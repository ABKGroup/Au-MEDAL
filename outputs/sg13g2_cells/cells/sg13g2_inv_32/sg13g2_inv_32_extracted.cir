* Extracted by KLayout with SG13G2 LVS runset on : 14/09/2026 22:06

.SUBCKT sg13g2_inv_32 VSS Y A VDD
M$1 VSS A Y VSS sg13_lv_nmos L=0.13u W=23.68u AS=6.4754p AD=4.6176p PS=52.08u
+ PD=36.16u
M$33 VDD A Y VDD sg13_lv_pmos L=0.13u W=35.84u AS=7.9652p AD=7.9652p PS=56.66u
+ PD=56.66u
.ENDS sg13g2_inv_32

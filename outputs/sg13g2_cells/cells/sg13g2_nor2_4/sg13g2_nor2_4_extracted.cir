* Extracted by KLayout with SG13G2 LVS runset on : 14/09/2026 22:09

.SUBCKT sg13g2_nor2_4 VSS Y A B VDD
M$1 VSS A Y VSS sg13_lv_nmos L=0.13u W=2.96u AS=0.9157p AD=0.5772p PS=7.56u
+ PD=4.52u
M$5 VSS B Y VSS sg13_lv_nmos L=0.13u W=2.96u AS=0.9157p AD=0.5772p PS=7.56u
+ PD=4.52u
M$9 \$4 A VDD VDD sg13_lv_pmos L=0.13u W=4.48u AS=1.1195p AD=0.972p PS=8.28u
+ PD=6.86u
M$13 \$4 B Y VDD sg13_lv_pmos L=0.13u W=4.48u AS=0.8736p AD=1.0211p PS=6.04u
+ PD=7.46u
.ENDS sg13g2_nor2_4

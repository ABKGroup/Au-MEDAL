* Extracted by KLayout with SG13G2 LVS runset on : 14/09/2026 22:07

.SUBCKT sg13g2_nand3_2 VSS Y A B C VDD
M$1 VSS C \$4 VSS sg13_lv_nmos L=0.13u W=1.48u AS=0.6704p AD=0.2886p PS=5.88u
+ PD=2.26u
M$3 \$2 A Y VSS sg13_lv_nmos L=0.13u W=1.48u AS=0.3886p AD=0.2886p PS=3.3u
+ PD=2.26u
M$5 \$2 B \$4 VSS sg13_lv_nmos L=0.13u W=1.48u AS=0.2886p AD=0.3886p PS=2.26u
+ PD=3.3u
M$7 VDD C Y VDD sg13_lv_pmos L=0.13u W=2.24u AS=0.6752p AD=0.6752p PS=5.21u
+ PD=5.21u
M$9 VDD A Y VDD sg13_lv_pmos L=0.13u W=2.24u AS=0.6752p AD=0.486p PS=5.21u
+ PD=3.43u
M$11 VDD B Y VDD sg13_lv_pmos L=0.13u W=2.24u AS=0.486p AD=0.6752p PS=3.43u
+ PD=5.21u
.ENDS sg13g2_nand3_2

.SUBCKT sg13g2_a22o_1 X A1 A2 B1 B2 VDD VSS
*.PININFO A1:I A2:I B1:I B2:I X:O VDD:B VSS:B
MN0 net1 A1 net2 VSS sg13_lv_nmos m=1 w=740.00n l=130.00n ng=1
MN1 net2 A2 VSS VSS sg13_lv_nmos m=1 w=740.00n l=130.00n ng=1
MN2 net1 B1 net3 VSS sg13_lv_nmos m=1 w=740.00n l=130.00n ng=1
MN3 net3 B2 VSS VSS sg13_lv_nmos m=1 w=740.00n l=130.00n ng=1
MP0 net1 A1 net4 VDD sg13_lv_pmos m=1 w=1.12u l=130.00n ng=1
MP1 net1 A2 net4 VDD sg13_lv_pmos m=1 w=1.12u l=130.00n ng=1
MP2 net4 B1 VDD VDD sg13_lv_pmos m=1 w=1.12u l=130.00n ng=1
MP3 net4 B2 VDD VDD sg13_lv_pmos m=1 w=1.12u l=130.00n ng=1
MN4 X net1 VSS VSS sg13_lv_nmos m=1 w=740.00n l=130.00n ng=1
MP4 X net1 VDD VDD sg13_lv_pmos m=1 w=1.12u l=130.00n ng=1
.ENDS

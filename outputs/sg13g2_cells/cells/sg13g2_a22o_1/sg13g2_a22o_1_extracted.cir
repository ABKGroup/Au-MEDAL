.SUBCKT sg13g2_a22o_1 VSS X A1 A2 B1 B2 VDD
M$1 \$3 B1 \$8 VSS sg13_lv_nmos L=0.13u W=0.74u AS=0.2443p AD=0.1443p PS=2.17u
+ PD=1.13u
M$2 VSS B2 \$8 VSS sg13_lv_nmos L=0.13u W=0.74u AS=0.3352p AD=0.1443p PS=2.94u
+ PD=1.13u
M$3 \$3 A1 \$9 VSS sg13_lv_nmos L=0.13u W=0.74u AS=0.2443p AD=0.1443p PS=2.17u
+ PD=1.13u
M$4 VSS A2 \$9 VSS sg13_lv_nmos L=0.13u W=0.74u AS=0.3352p AD=0.1443p PS=2.94u
+ PD=1.13u
M$5 VSS \$3 X VSS sg13_lv_nmos L=0.13u W=0.74u AS=0.3352p AD=0.2443p PS=2.94u
+ PD=2.17u
M$6 VDD B1 \$10 VDD sg13_lv_pmos L=0.13u W=1.12u AS=0.4568p AD=0.2184p PS=3.7u
+ PD=1.51u
M$7 \$10 B2 VDD VDD sg13_lv_pmos L=0.13u W=1.12u AS=0.2184p AD=0.4568p PS=1.51u
+ PD=3.7u
M$8 VDD \$3 X VDD sg13_lv_pmos L=0.13u W=1.12u AS=0.4568p AD=0.3659p PS=3.7u
+ PD=2.93u
M$9 \$3 A1 \$10 VDD sg13_lv_pmos L=0.13u W=1.12u AS=0.3659p AD=0.2184p PS=2.93u
+ PD=1.51u
M$10 \$10 A2 \$3 VDD sg13_lv_pmos L=0.13u W=1.12u AS=0.2184p AD=0.3659p
+ PS=1.51u PD=2.93u
.ENDS sg13g2_a22o_1

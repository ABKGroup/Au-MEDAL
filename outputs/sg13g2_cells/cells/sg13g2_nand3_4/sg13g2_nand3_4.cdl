.SUBCKT sg13g2_nand3_4 Y A B C VDD VSS
*.PININFO A:I B:I C:I Y:O VDD:B VSS:B
MP0 Y A VDD VDD sg13_lv_pmos w=4.48u l=130.00n ng=4
MP1 Y B VDD VDD sg13_lv_pmos w=4.48u l=130.00n ng=4
MP2 Y C VDD VDD sg13_lv_pmos w=4.48u l=130.00n ng=4
MN1 net2 B net3 VSS sg13_lv_nmos w=2.96u l=130.00n ng=4
MN2 net3 C VSS VSS sg13_lv_nmos w=2.96u l=130.00n ng=4
MN0 Y A net2 VSS sg13_lv_nmos w=2.96u l=130.00n ng=4
.ENDS

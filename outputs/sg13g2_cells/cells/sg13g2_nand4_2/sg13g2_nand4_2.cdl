.SUBCKT sg13g2_nand4_2 Y A B C D VDD VSS
*.PININFO A:I B:I C:I D:I Y:O VDD:B VSS:B
MP3 Y D VDD VDD sg13_lv_pmos w=2.24u l=130.00n ng=2
MP0 Y A VDD VDD sg13_lv_pmos w=2.24u l=130.00n ng=2
MP1 Y B VDD VDD sg13_lv_pmos w=2.24u l=130.00n ng=2
MP2 Y C VDD VDD sg13_lv_pmos w=2.24u l=130.00n ng=2
MN1 net2 B net3 VSS sg13_lv_nmos w=1.48u l=130.00n ng=2
MN2 net3 C net5 VSS sg13_lv_nmos w=1.48u l=130.00n ng=2
MN0 Y A net2 VSS sg13_lv_nmos w=1.48u l=130.00n ng=2
MN3 net5 D VSS VSS sg13_lv_nmos w=1.48u l=130.00n ng=2
.ENDS

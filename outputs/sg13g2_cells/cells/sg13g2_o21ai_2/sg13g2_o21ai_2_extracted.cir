.SUBCKT sg13g2_o21ai_2 VSS B1 Y A2 A1 VDD
M$1 VSS A2 \$2 VSS sg13_lv_nmos L=0.13u W=1.48u AS=0.5287p AD=0.2886p PS=4.48u
+ PD=2.26u
M$3 VSS A1 \$2 VSS sg13_lv_nmos L=0.13u W=1.48u AS=0.5287p AD=0.2886p PS=4.48u
+ PD=2.26u
M$5 Y B1 \$2 VSS sg13_lv_nmos L=0.13u W=1.48u AS=0.3886p AD=0.3886p PS=3.3u
+ PD=3.3u
M$7 \$7 A2 Y VDD sg13_lv_pmos L=0.13u W=2.24u AS=0.5843p AD=0.4368p PS=4.44u
+ PD=3.02u
M$9 \$7 A1 VDD VDD sg13_lv_pmos L=0.13u W=2.24u AS=0.486p AD=0.6335p PS=3.43u
+ PD=4.85u
M$11 VDD B1 Y VDD sg13_lv_pmos L=0.13u W=2.24u AS=0.6752p AD=0.6752p PS=5.21u
+ PD=5.21u
.ENDS sg13g2_o21ai_2

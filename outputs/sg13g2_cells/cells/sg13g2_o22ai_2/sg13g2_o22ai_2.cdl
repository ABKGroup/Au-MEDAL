.SUBCKT sg13g2_o22ai_2 Y A1 A2 B1 B2 VDD VSS
*.PININFO A1:I A2:I B1:I B2:I Y:O VDD:B VSS:B
MN0 Y A1 net1 VSS sg13_lv_nmos w=1.48u l=130.00n ng=2
MN1 Y A2 net1 VSS sg13_lv_nmos w=1.48u l=130.00n ng=2
MN2 net1 B1 VSS VSS sg13_lv_nmos w=1.48u l=130.00n ng=2
MN3 net1 B2 VSS VSS sg13_lv_nmos w=1.48u l=130.00n ng=2
MP0 Y A1 net2 VDD sg13_lv_pmos w=2.24u l=130.00n ng=2
MP1 net2 A2 VDD VDD sg13_lv_pmos w=2.24u l=130.00n ng=2
MP2 Y B1 net3 VDD sg13_lv_pmos w=2.24u l=130.00n ng=2
MP3 net3 B2 VDD VDD sg13_lv_pmos w=2.24u l=130.00n ng=2
.ENDS

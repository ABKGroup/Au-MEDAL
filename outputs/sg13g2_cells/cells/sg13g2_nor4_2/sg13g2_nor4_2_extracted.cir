* Extracted by KLayout with SG13G2 LVS runset on : 14/09/2026 22:11

.SUBCKT sg13g2_nor4_2 VSS Y A B C D VDD
M$1 VSS C Y VSS sg13_lv_nmos L=0.13u W=1.48u AS=0.5287p AD=0.2886p PS=4.48u
+ PD=2.26u
M$3 VSS D Y VSS sg13_lv_nmos L=0.13u W=1.48u AS=0.5287p AD=0.2886p PS=4.48u
+ PD=2.26u
M$5 VSS A Y VSS sg13_lv_nmos L=0.13u W=1.48u AS=0.5287p AD=0.2886p PS=4.48u
+ PD=2.26u
M$7 VSS B Y VSS sg13_lv_nmos L=0.13u W=1.48u AS=0.5287p AD=0.2886p PS=4.48u
+ PD=2.26u
M$9 \$9 C \$8 VDD sg13_lv_pmos L=0.13u W=2.24u AS=0.5843p AD=0.4368p PS=4.44u
+ PD=3.02u
M$11 \$9 D Y VDD sg13_lv_pmos L=0.13u W=2.24u AS=0.4368p AD=0.5843p PS=3.02u
+ PD=4.44u
M$13 \$7 A VDD VDD sg13_lv_pmos L=0.13u W=2.24u AS=0.6335p AD=0.486p PS=4.85u
+ PD=3.43u
M$15 \$7 B \$8 VDD sg13_lv_pmos L=0.13u W=2.24u AS=0.4368p AD=0.5843p PS=3.02u
+ PD=4.44u
.ENDS sg13g2_nor4_2

* Extracted by KLayout with SG13G2 LVS runset on : 14/09/2026 22:11

.SUBCKT sg13g2_a22oi_2 VSS Y B1 B2 A1 A2 VDD
M$1 \$6 A1 Y VSS sg13_lv_nmos L=0.13u W=1.48u AS=0.3886p AD=0.2886p PS=3.3u
+ PD=2.26u
M$3 VSS A2 \$6 VSS sg13_lv_nmos L=0.13u W=1.48u AS=0.387p AD=0.3886p PS=3.08u
+ PD=3.3u
M$5 \$3 B1 Y VSS sg13_lv_nmos L=0.13u W=1.48u AS=0.3886p AD=0.2886p PS=3.3u
+ PD=2.26u
M$7 VSS B2 \$3 VSS sg13_lv_nmos L=0.13u W=1.48u AS=0.387p AD=0.3886p PS=3.08u
+ PD=3.3u
M$9 VDD A1 \$9 VDD sg13_lv_pmos L=0.13u W=2.24u AS=0.6752p AD=0.486p PS=5.21u
+ PD=3.43u
M$11 VDD A2 \$9 VDD sg13_lv_pmos L=0.13u W=2.24u AS=0.486p AD=0.6752p PS=3.43u
+ PD=5.21u
M$13 \$9 B1 Y VDD sg13_lv_pmos L=0.13u W=2.24u AS=0.5843p AD=0.4368p PS=4.44u
+ PD=3.02u
M$15 \$9 B2 Y VDD sg13_lv_pmos L=0.13u W=2.24u AS=0.4368p AD=0.5843p PS=3.02u
+ PD=4.44u
.ENDS sg13g2_a22oi_2

.SUBCKT sg13g2_a22o_2 VSS X A2 A1 B1 B2 VDD
M$1 VSS A2 \$4 VSS sg13_lv_nmos L=0.13u W=0.74u AS=0.3352p AD=0.1443p PS=2.94u
+ PD=1.13u
M$2 \$4 A1 \$3 VSS sg13_lv_nmos L=0.13u W=0.74u AS=0.1443p AD=0.1443p PS=1.13u
+ PD=1.13u
M$3 \$3 B1 \$5 VSS sg13_lv_nmos L=0.13u W=0.74u AS=0.1443p AD=0.1443p PS=1.13u
+ PD=1.13u
M$4 VSS B2 \$5 VSS sg13_lv_nmos L=0.13u W=0.74u AS=0.3352p AD=0.1443p PS=2.94u
+ PD=1.13u
M$5 VSS \$3 X VSS sg13_lv_nmos L=0.13u W=1.48u AS=0.6704p AD=0.2886p PS=5.88u
+ PD=2.26u
M$7 \$6 A2 \$3 VDD sg13_lv_pmos L=0.13u W=1.12u AS=0.3659p AD=0.2184p PS=2.93u
+ PD=1.51u
M$8 \$3 A1 \$6 VDD sg13_lv_pmos L=0.13u W=1.12u AS=0.2184p AD=0.2184p PS=1.51u
+ PD=1.51u
M$9 \$6 B1 VDD VDD sg13_lv_pmos L=0.13u W=1.12u AS=0.2184p AD=0.2676p PS=1.51u
+ PD=1.92u
M$10 VDD B2 \$6 VDD sg13_lv_pmos L=0.13u W=1.12u AS=0.2676p AD=0.3659p PS=1.92u
+ PD=2.93u
M$11 VDD \$3 X VDD sg13_lv_pmos L=0.13u W=2.24u AS=0.6752p AD=0.6752p PS=5.21u
+ PD=5.21u
.ENDS sg13g2_a22o_2

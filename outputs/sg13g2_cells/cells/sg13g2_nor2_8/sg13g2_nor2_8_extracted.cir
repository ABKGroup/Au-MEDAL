.SUBCKT sg13g2_nor2_8 VSS B Y A VDD
M$1 VSS A Y VSS sg13_lv_nmos L=0.13u W=5.92u AS=1.6897p AD=1.1544p PS=13.72u
+ PD=9.04u
M$9 VSS B Y VSS sg13_lv_nmos L=0.13u W=5.92u AS=1.6897p AD=1.1544p PS=13.72u
+ PD=9.04u
M$17 \$5 A VDD VDD sg13_lv_pmos L=0.13u W=8.96u AS=2.0915p AD=1.944p PS=15.14u
+ PD=13.72u
M$25 \$5 B Y VDD sg13_lv_pmos L=0.13u W=8.96u AS=1.7472p AD=1.8947p PS=12.08u
+ PD=13.5u
.ENDS sg13g2_nor2_8

.SUBCKT sg13g2_nor2_8 Y A B VDD VSS
*.PININFO A:I B:I Y:O VDD:B VSS:B
MN0 Y A VSS VSS sg13_lv_nmos m=1 w=5.92u l=130.00n ng=8
MN1 Y B VSS VSS sg13_lv_nmos m=1 w=5.92u l=130.00n ng=8
MP0 net1 A VDD VDD sg13_lv_pmos m=1 w=8.96u l=130.00n ng=8
MP1 Y B net1 VDD sg13_lv_pmos m=1 w=8.96u l=130.00n ng=8
.ENDS

.SUBCKT sg13g2_nand2_4 VSS Y A B VDD
M$1 \$2 A Y VSS sg13_lv_nmos L=0.13u W=2.96u AS=0.6772p AD=0.5772p PS=5.56u
+ PD=4.52u
M$5 VSS B \$2 VSS sg13_lv_nmos L=0.13u W=2.96u AS=0.774p AD=0.6772p PS=6.16u
+ PD=5.56u
M$9 VDD A Y VDD sg13_lv_pmos L=0.13u W=4.48u AS=1.1612p AD=0.972p PS=8.64u
+ PD=6.86u
M$13 VDD B Y VDD sg13_lv_pmos L=0.13u W=4.48u AS=0.972p AD=1.1612p PS=6.86u
+ PD=8.64u
.ENDS sg13g2_nand2_4

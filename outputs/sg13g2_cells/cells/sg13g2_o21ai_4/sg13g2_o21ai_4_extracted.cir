.SUBCKT sg13g2_o21ai_4 VSS Y B1 A2 A1 VDD
M$1 Y B1 \$2 VSS sg13_lv_nmos L=0.13u W=2.96u AS=0.6772p AD=0.6772p PS=5.56u
+ PD=5.56u
M$5 VSS A2 \$2 VSS sg13_lv_nmos L=0.13u W=2.96u AS=0.9157p AD=0.5772p PS=7.56u
+ PD=4.52u
M$9 VSS A1 \$2 VSS sg13_lv_nmos L=0.13u W=2.96u AS=0.9157p AD=0.5772p PS=7.56u
+ PD=4.52u
M$13 VDD B1 Y VDD sg13_lv_pmos L=0.13u W=4.48u AS=1.1612p AD=1.1612p PS=8.64u
+ PD=8.64u
M$17 \$7 A2 Y VDD sg13_lv_pmos L=0.13u W=4.48u AS=1.0211p AD=0.8736p PS=7.46u
+ PD=6.04u
M$21 \$7 A1 VDD VDD sg13_lv_pmos L=0.13u W=4.48u AS=0.972p AD=1.1195p PS=6.86u
+ PD=8.28u
.ENDS sg13g2_o21ai_4

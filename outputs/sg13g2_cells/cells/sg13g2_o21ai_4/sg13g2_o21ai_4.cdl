.SUBCKT sg13g2_o21ai_4 Y A1 A2 B1 VDD VSS
*.PININFO A1:I A2:I B1:I Y:O VDD:B VSS:B
MP0 net14 A1 VDD VDD sg13_lv_pmos w=4.48u l=130.00n ng=4
MP1 Y A2 net14 VDD sg13_lv_pmos w=4.48u l=130.00n ng=4
MP2 Y B1 VDD VDD sg13_lv_pmos w=4.48u l=130.00n ng=4
MN0 net1 A2 VSS VSS sg13_lv_nmos w=2.96u l=130.00n ng=4
MN2 net1 A1 VSS VSS sg13_lv_nmos w=2.96u l=130.00n ng=4
MN1 Y B1 net1 VSS sg13_lv_nmos w=2.96u l=130.00n ng=4
.ENDS

.SUBCKT sg13g2_nand2_8 Y A B VDD VSS
*.PININFO A:I B:I Y:O VDD:B VSS:B
MP1 Y B VDD VDD sg13_lv_pmos w=8.96u l=130.00n ng=8
MP0 Y A VDD VDD sg13_lv_pmos w=8.96u l=130.00n ng=8
MN1 net1 B VSS VSS sg13_lv_nmos w=5.92u l=130.00n ng=8
MN0 Y A net1 VSS sg13_lv_nmos w=5.92u l=130.00n ng=8
.ENDS

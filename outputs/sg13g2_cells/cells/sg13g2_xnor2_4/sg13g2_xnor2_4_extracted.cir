* Extracted by KLayout with SG13G2 LVS runset on : 14/09/2026 22:10

.SUBCKT sg13g2_xnor2_4 VSS A Y B VDD
M$1 VSS B \$5 VSS sg13_lv_nmos L=0.13u W=2.96u AS=1.0574p AD=0.5772p PS=8.96u
+ PD=4.52u
M$5 \$6 B \$4 VSS sg13_lv_nmos L=0.13u W=0.64u AS=0.2123p AD=0.1248p PS=1.97u
+ PD=1.03u
M$6 VSS A \$4 VSS sg13_lv_nmos L=0.13u W=0.64u AS=0.19p AD=0.1248p PS=1.54u
+ PD=1.03u
M$7 VSS A \$5 VSS sg13_lv_nmos L=0.13u W=2.96u AS=0.9122p AD=0.5772p PS=7.56u
+ PD=4.52u
M$11 Y \$6 \$5 VSS sg13_lv_nmos L=0.13u W=2.96u AS=0.6772p AD=0.6772p PS=5.56u
+ PD=5.56u
M$15 VDD B \$6 VDD sg13_lv_pmos L=0.13u W=0.84u AS=0.3672p AD=0.1638p PS=3.14u
+ PD=1.23u
M$16 VDD A \$6 VDD sg13_lv_pmos L=0.13u W=0.84u AS=0.2578p AD=0.1638p PS=1.92u
+ PD=1.23u
M$17 VDD A \$8 VDD sg13_lv_pmos L=0.13u W=4.48u AS=0.9622p AD=1.1612p PS=6.86u
+ PD=8.64u
M$21 VDD \$6 Y VDD sg13_lv_pmos L=0.13u W=4.48u AS=1.1612p AD=1.1612p PS=8.64u
+ PD=8.64u
M$25 Y B \$8 VDD sg13_lv_pmos L=0.13u W=4.48u AS=1.0211p AD=1.0211p PS=7.46u
+ PD=7.46u
.ENDS sg13g2_xnor2_4

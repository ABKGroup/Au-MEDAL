.SUBCKT sg13g2_dlygate4sd_4 VSS X A VDD
M$1 VSS \$4 \$3 VSS sg13_lv_nmos L=0.13u W=0.42u AS=0.1823p AD=0.1419p PS=1.54u
+ PD=1.53u
M$2 VSS \$3 X VSS sg13_lv_nmos L=0.13u W=2.96u AS=0.9045p AD=0.5772p PS=7.56u
+ PD=4.52u
M$6 VSS \$5 \$4 VSS sg13_lv_nmos L=0.13u W=0.42u AS=0.1311p AD=0.1419p PS=1.22u
+ PD=1.53u
M$7 VSS A \$5 VSS sg13_lv_nmos L=0.13u W=0.42u AS=0.1311p AD=0.1419p PS=1.22u
+ PD=1.53u
M$8 \$4 \$5 VDD VDD sg13_lv_pmos L=0.13u W=1u AS=0.3275p AD=0.2239p PS=2.69u
+ PD=1.8u
M$9 VDD A \$5 VDD sg13_lv_pmos L=0.13u W=0.42u AS=0.2239p AD=0.1419p PS=1.8u
+ PD=1.53u
M$10 VDD \$3 X VDD sg13_lv_pmos L=0.13u W=4.48u AS=1.1612p AD=0.9678p PS=8.64u
+ PD=6.86u
M$14 VDD \$4 \$3 VDD sg13_lv_pmos L=0.13u W=1u AS=0.2634p AD=0.3275p PS=1.92u
+ PD=2.69u
.ENDS sg13g2_dlygate4sd_4

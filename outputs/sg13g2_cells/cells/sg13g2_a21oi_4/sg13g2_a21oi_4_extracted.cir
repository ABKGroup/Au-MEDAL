.SUBCKT sg13g2_a21oi_4 VSS Y B1 A1 A2 VDD
M$1 \$3 A1 Y VSS sg13_lv_nmos L=0.13u W=2.96u AS=0.6772p AD=0.5772p PS=5.56u
+ PD=4.52u
M$5 VSS A2 \$3 VSS sg13_lv_nmos L=0.13u W=2.96u AS=0.774p AD=0.6772p PS=6.16u
+ PD=5.56u
M$9 VSS B1 Y VSS sg13_lv_nmos L=0.13u W=2.96u AS=1.0574p AD=0.5772p PS=8.96u
+ PD=4.52u
M$13 Y B1 \$7 VDD sg13_lv_pmos L=0.13u W=4.48u AS=1.0211p AD=1.0211p PS=7.46u
+ PD=7.46u
M$17 VDD A1 \$7 VDD sg13_lv_pmos L=0.13u W=4.48u AS=1.1612p AD=0.972p PS=8.64u
+ PD=6.86u
M$21 VDD A2 \$7 VDD sg13_lv_pmos L=0.13u W=4.48u AS=0.972p AD=1.1612p PS=6.86u
+ PD=8.64u
.ENDS sg13g2_a21oi_4

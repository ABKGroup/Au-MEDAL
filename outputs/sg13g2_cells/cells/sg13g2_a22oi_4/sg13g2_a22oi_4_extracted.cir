* Extracted by KLayout with SG13G2 LVS runset on : 14/09/2026 22:13

.SUBCKT sg13g2_a22oi_4 VSS B1 B2 Y A1 A2 VDD
M$1 \$4 A1 Y VSS sg13_lv_nmos L=0.13u W=2.96u AS=0.6772p AD=0.5772p PS=5.56u
+ PD=4.52u
M$5 VSS A2 \$4 VSS sg13_lv_nmos L=0.13u W=2.96u AS=0.774p AD=0.6772p PS=6.16u
+ PD=5.56u
M$9 \$5 B1 Y VSS sg13_lv_nmos L=0.13u W=2.96u AS=0.6772p AD=0.5772p PS=5.56u
+ PD=4.52u
M$13 VSS B2 \$5 VSS sg13_lv_nmos L=0.13u W=2.96u AS=0.774p AD=0.6772p PS=6.16u
+ PD=5.56u
M$17 VDD A1 \$10 VDD sg13_lv_pmos L=0.13u W=4.48u AS=1.1612p AD=0.972p PS=8.64u
+ PD=6.86u
M$21 VDD A2 \$10 VDD sg13_lv_pmos L=0.13u W=4.48u AS=0.972p AD=1.1612p PS=6.86u
+ PD=8.64u
M$25 Y B1 \$10 VDD sg13_lv_pmos L=0.13u W=4.48u AS=1.0211p AD=0.8736p PS=7.46u
+ PD=6.04u
M$29 Y B2 \$10 VDD sg13_lv_pmos L=0.13u W=4.48u AS=0.8736p AD=1.0211p PS=6.04u
+ PD=7.46u
.ENDS sg13g2_a22oi_4

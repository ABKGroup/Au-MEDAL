.subckt PM_FAx1_ASAP7_75t_R%7 vss 11 23 24 7 1 8 9 2
c1 1 vss 0.0091558f $X=0.054 $Y=0.0675
c2 2 vss 0.00704942f $X=0.27 $Y=0.0675
c3 7 vss 0.0371386f $X=0.056 $Y=0.0675
c4 8 vss 0.00320058f $X=0.2555 $Y=0.0675
c5 9 vss 0.0215761f $X=0.0425 $Y=0.036
r1 24 22 0.0308642 $w=8.1e-08 $l=2.5e-09 $layer=N_src_drn $thickness=1e-09
+ $X=0.2873 $Y=0.0675 $X2=0.2845 $Y2=0.0675
r2 2 22 0.179012 $w=8.1e-08 $l=1.45e-08 $layer=N_src_drn $thickness=1e-09
+ $X=0.27 $Y=0.0675 $X2=0.2845 $Y2=0.0675
r3 8 2 0.179012 $w=8.1e-08 $l=1.45e-08 $layer=N_src_drn $thickness=1e-09
+ $X=0.2555 $Y=0.0675 $X2=0.27 $Y2=0.0675
r4 23 8 0.0308642 $w=8.1e-08 $l=2.5e-09 $layer=N_src_drn $thickness=1e-09
+ $X=0.2526 $Y=0.0675 $X2=0.2555 $Y2=0.0675
r5 2 18 19.3796 $a=3.24e-16 $layer=V0LISD $X=0.27 $Y=0.0675 $X2=0.27 $Y2=0.036
r6 17 18 18.0722 $w=1.3e-08 $l=7.75e-08 $layer=M1 $thickness=3.6e-08 $X=0.1925
+ $Y=0.036 $X2=0.27 $Y2=0.036
r7 16 17 19.9377 $w=1.3e-08 $l=8.55e-08 $layer=M1 $thickness=3.6e-08 $X=0.107
+ $Y=0.036 $X2=0.1925 $Y2=0.036
r8 15 16 6.06293 $w=1.3e-08 $l=2.6e-08 $layer=M1 $thickness=3.6e-08 $X=0.081
+ $Y=0.036 $X2=0.107 $Y2=0.036
r9 14 15 3.14806 $w=1.3e-08 $l=1.35e-08 $layer=M1 $thickness=3.6e-08 $X=0.0675
+ $Y=0.036 $X2=0.081 $Y2=0.036
r10 13 14 1.51573 $w=1.3e-08 $l=6.5e-09 $layer=M1 $thickness=3.6e-08 $X=0.061
+ $Y=0.036 $X2=0.0675 $Y2=0.036
r11 12 13 2.09871 $w=1.3e-08 $l=9e-09 $layer=M1 $thickness=3.6e-08 $X=0.052
+ $Y=0.036 $X2=0.061 $Y2=0.036
r12 9 12 2.2153 $w=1.3e-08 $l=9.5e-09 $layer=M1 $thickness=3.6e-08 $X=0.0425
+ $Y=0.036 $X2=0.052 $Y2=0.036
r13 1 12 19.3796 $a=3.24e-16 $layer=V0LISD $X=0.054 $Y=0.0675 $X2=0.052
+ $Y2=0.036
r14 11 10 0.0308642 $w=8.1e-08 $l=2.5e-09 $layer=N_src_drn $thickness=1e-09
+ $X=0.0713 $Y=0.0675 $X2=0.0685 $Y2=0.0675
r15 7 10 0.154321 $w=8.1e-08 $l=1.25e-08 $layer=N_src_drn $thickness=1e-09
+ $X=0.056 $Y=0.0675 $X2=0.0685 $Y2=0.0675
r16 1 7 1e-05 $l=2e-09 $X=0.054 $Y=0.0675 $X2=0.056 $Y2=0.0675
.ends

.subckt PM_FAx1_ASAP7_75t_R%13 vss 2 3 1
c1 1 vss 0.00426349f $X=0.378 $Y=0.0675
r1 2 1 0.209877 $w=8.1e-08 $l=1.7e-08 $layer=N_src_drn $thickness=1e-09
+ $X=0.3606 $Y=0.0675 $X2=0.378 $Y2=0.0675
r2 3 1 0.209877 $w=8.1e-08 $l=1.7e-08 $layer=N_src_drn $thickness=1e-09
+ $X=0.3953 $Y=0.0675 $X2=0.378 $Y2=0.0675
.ends

.subckt PM_FAx1_ASAP7_75t_R%14 vss 2 3 1
c1 1 vss 0.00414526f $X=0.432 $Y=0.0675
r1 2 1 0.209877 $w=8.1e-08 $l=1.7e-08 $layer=N_src_drn $thickness=1e-09
+ $X=0.4146 $Y=0.0675 $X2=0.432 $Y2=0.0675
r2 3 1 0.209877 $w=8.1e-08 $l=1.7e-08 $layer=N_src_drn $thickness=1e-09
+ $X=0.4493 $Y=0.0675 $X2=0.432 $Y2=0.0675
.ends

.subckt PM_FAx1_ASAP7_75t_R%15 vss 2 3 1
c1 1 vss 0.000760075f $X=0.162 $Y=0.2025
r1 2 1 0.209877 $w=8.1e-08 $l=1.7e-08 $layer=P_src_drn $thickness=1e-09
+ $X=0.1446 $Y=0.2025 $X2=0.162 $Y2=0.2025
r2 3 1 0.209877 $w=8.1e-08 $l=1.7e-08 $layer=P_src_drn $thickness=1e-09
+ $X=0.1793 $Y=0.2025 $X2=0.162 $Y2=0.2025
.ends

.subckt PM_FAx1_ASAP7_75t_R%16 vss 2 3 1
c1 1 vss 0.00413116f $X=0.378 $Y=0.2025
r1 2 1 0.209877 $w=8.1e-08 $l=1.7e-08 $layer=P_src_drn $thickness=1e-09
+ $X=0.3606 $Y=0.2025 $X2=0.378 $Y2=0.2025
r2 3 1 0.209877 $w=8.1e-08 $l=1.7e-08 $layer=P_src_drn $thickness=1e-09
+ $X=0.3953 $Y=0.2025 $X2=0.378 $Y2=0.2025
.ends

.subckt PM_FAx1_ASAP7_75t_R%10 vss 12 13 28 29 8 2 7 9 1
c1 1 vss 0.00620095f $X=0.54 $Y=0.0675
c2 2 vss 0.00907642f $X=0.648 $Y=0.0675
c3 7 vss 0.0031463f $X=0.5255 $Y=0.0675
c4 8 vss 0.00441848f $X=0.6335 $Y=0.0675
c5 9 vss 0.0125625f $X=0.6345 $Y=0.036
r1 29 27 0.0308642 $w=8.1e-08 $l=2.5e-09 $layer=N_src_drn $thickness=1e-09
+ $X=0.5573 $Y=0.0675 $X2=0.5545 $Y2=0.0675
r2 1 27 0.179012 $w=8.1e-08 $l=1.45e-08 $layer=N_src_drn $thickness=1e-09
+ $X=0.54 $Y=0.0675 $X2=0.5545 $Y2=0.0675
r3 7 1 0.179012 $w=8.1e-08 $l=1.45e-08 $layer=N_src_drn $thickness=1e-09
+ $X=0.5255 $Y=0.0675 $X2=0.54 $Y2=0.0675
r4 28 7 0.0308642 $w=8.1e-08 $l=2.5e-09 $layer=N_src_drn $thickness=1e-09
+ $X=0.5226 $Y=0.0675 $X2=0.5255 $Y2=0.0675
r5 1 23 19.3796 $a=3.24e-16 $layer=V0LISD $X=0.54 $Y=0.0675 $X2=0.538 $Y2=0.036
r6 21 22 1.74892 $w=1.3e-08 $l=7.5e-09 $layer=M1 $thickness=3.6e-08 $X=0.546
+ $Y=0.036 $X2=0.5535 $Y2=0.036
r7 21 23 1.86552 $w=1.3e-08 $l=8e-09 $layer=M1 $thickness=3.6e-08 $X=0.546
+ $Y=0.036 $X2=0.538 $Y2=0.036
r8 20 22 3.14806 $w=1.3e-08 $l=1.35e-08 $layer=M1 $thickness=3.6e-08 $X=0.567
+ $Y=0.036 $X2=0.5535 $Y2=0.036
r9 19 20 3.38125 $w=1.3e-08 $l=1.45e-08 $layer=M1 $thickness=3.6e-08 $X=0.5815
+ $Y=0.036 $X2=0.567 $Y2=0.036
r10 18 19 2.68168 $w=1.3e-08 $l=1.15e-08 $layer=M1 $thickness=3.6e-08 $X=0.593
+ $Y=0.036 $X2=0.5815 $Y2=0.036
r11 17 18 2.91487 $w=1.3e-08 $l=1.25e-08 $layer=M1 $thickness=3.6e-08 $X=0.6055
+ $Y=0.036 $X2=0.593 $Y2=0.036
r12 16 17 3.61444 $w=1.3e-08 $l=1.55e-08 $layer=M1 $thickness=3.6e-08 $X=0.621
+ $Y=0.036 $X2=0.6055 $Y2=0.036
r13 9 14 3.14806 $w=1.3e-08 $l=1.35e-08 $layer=M1 $thickness=3.6e-08 $X=0.6345
+ $Y=0.036 $X2=0.648 $Y2=0.036
r14 9 16 3.14806 $w=1.3e-08 $l=1.35e-08 $layer=M1 $thickness=3.6e-08 $X=0.6345
+ $Y=0.036 $X2=0.621 $Y2=0.036
r15 2 14 19.3796 $a=3.24e-16 $layer=V0LISD $X=0.648 $Y=0.0675 $X2=0.648
+ $Y2=0.036
r16 13 11 0.0308642 $w=8.1e-08 $l=2.5e-09 $layer=N_src_drn $thickness=1e-09
+ $X=0.6653 $Y=0.0675 $X2=0.6625 $Y2=0.0675
r17 2 11 0.179012 $w=8.1e-08 $l=1.45e-08 $layer=N_src_drn $thickness=1e-09
+ $X=0.648 $Y=0.0675 $X2=0.6625 $Y2=0.0675
r18 8 2 0.179012 $w=8.1e-08 $l=1.45e-08 $layer=N_src_drn $thickness=1e-09
+ $X=0.6335 $Y=0.0675 $X2=0.648 $Y2=0.0675
r19 12 8 0.0308642 $w=8.1e-08 $l=2.5e-09 $layer=N_src_drn $thickness=1e-09
+ $X=0.6306 $Y=0.0675 $X2=0.6335 $Y2=0.0675
.ends

.subckt PM_FAx1_ASAP7_75t_R%B vss 36 19 25 52 55 58 61 64 67 15 12 11 2 1 14 13
+ 3 10 7 9 8
c1 1 vss 0.00147513f $X=0.189 $Y=0.135
c2 2 vss 0.0105145f $X=0.2875 $Y=0.135
c3 3 vss 0.00539088f $X=0.675 $Y=0.135
c4 7 vss 0.00765821f $X=0.189 $Y=0.135
c5 8 vss 0.0813625f $X=0.297 $Y=0.135
c6 9 vss 0.088504f $X=0.351 $Y=0.135
c7 10 vss 0.091607f $X=0.675 $Y=0.0245
c8 11 vss 0.000333524f $X=0.1695 $Y=0.153
c9 12 vss 0.000589595f $X=0.189 $Y=0.1465
c10 13 vss 0.000543995f $X=0.297 $Y=0.1375
c11 14 vss 0.00641219f $X=0.675 $Y=0.1235
c12 15 vss 0.0225559f $X=0.6465 $Y=0.153
r1 67 66 16.4967 $w=2.1e-08 $l=4.85e-08 $layer=Gate_1 $thickness=5.6e-08
+ $X=0.189 $Y=0.2025 $X2=0.189 $Y2=0.154
r2 64 65 16.4967 $w=2.1e-08 $l=4.85e-08 $layer=Gate_1 $thickness=5.6e-08
+ $X=0.189 $Y=0.0675 $X2=0.189 $Y2=0.116
r3 7 65 6.6497 $w=2.04211e-08 $l=1.9e-08 $layer=Gate_1 $thickness=5.6e-08
+ $X=0.189 $Y=0.135 $X2=0.189 $Y2=0.116
r4 7 66 6.6497 $w=2.04211e-08 $l=1.9e-08 $layer=Gate_1 $thickness=5.6e-08
+ $X=0.189 $Y=0.135 $X2=0.189 $Y2=0.154
r5 61 60 16.4967 $w=2.1e-08 $l=4.85e-08 $layer=Gate_1 $thickness=5.6e-08
+ $X=0.351 $Y=0.2025 $X2=0.351 $Y2=0.154
r6 58 59 16.4967 $w=2.1e-08 $l=4.85e-08 $layer=Gate_1 $thickness=5.6e-08
+ $X=0.351 $Y=0.0675 $X2=0.351 $Y2=0.116
r7 9 49 6.54019 $w=2.09524e-08 $layer=Gate_1 $thickness=5.21905e-08 $X=0.351
+ $Y=0.135 $X2=0.351 $Y2=0.135
r8 9 59 6.6497 $w=2.04211e-08 $l=1.9e-08 $layer=Gate_1 $thickness=5.6e-08
+ $X=0.351 $Y=0.135 $X2=0.351 $Y2=0.116
r9 9 60 6.6497 $w=2.04211e-08 $l=1.9e-08 $layer=Gate_1 $thickness=5.6e-08
+ $X=0.351 $Y=0.135 $X2=0.351 $Y2=0.154
r10 55 54 16.4967 $w=2.1e-08 $l=4.85e-08 $layer=Gate_1 $thickness=5.6e-08
+ $X=0.297 $Y=0.2025 $X2=0.297 $Y2=0.154
r11 52 53 16.4967 $w=2.1e-08 $l=4.85e-08 $layer=Gate_1 $thickness=5.6e-08
+ $X=0.297 $Y=0.0675 $X2=0.297 $Y2=0.116
r12 8 45 6.27904 $w=2.09e-08 $layer=Gate_1 $thickness=5.24e-08 $X=0.297
+ $Y=0.135 $X2=0.297 $Y2=0.135
r13 8 53 6.6497 $w=2.04211e-08 $l=1.9e-08 $layer=Gate_1 $thickness=5.6e-08
+ $X=0.297 $Y=0.135 $X2=0.297 $Y2=0.116
r14 8 54 6.6497 $w=2.04211e-08 $l=1.9e-08 $layer=Gate_1 $thickness=5.6e-08
+ $X=0.297 $Y=0.135 $X2=0.297 $Y2=0.154
r15 1 42 19.3796 $a=3.24e-16 $layer=V0LIG $X=0.189 $Y=0.135 $X2=0.189 $Y2=0.135
r16 1 7 10.4265 $w=1.765e-08 $layer=LIG $thickness=5.2e-08 $X=0.189 $Y=0.135
+ $X2=0.189 $Y2=0.135
r17 48 49 12.6539 $w=1.77815e-08 $l=2.7e-08 $layer=LIG $thickness=4.8e-08
+ $X=0.324 $Y=0.135 $X2=0.351 $Y2=0.135
r18 46 48 10.1729 $w=1.54914e-08 $l=1.75e-08 $layer=LIG $thickness=4.8e-08
+ $X=0.3065 $Y=0.135 $X2=0.324 $Y2=0.135
r19 45 46 2.48102 $w=2.2e-08 $l=9.5e-09 $layer=LIG $thickness=4.8e-08 $X=0.297
+ $Y=0.135 $X2=0.3065 $Y2=0.135
r20 2 45 2.48102 $w=2.2e-08 $l=9.5e-09 $layer=LIG $thickness=4.8e-08 $X=0.2875
+ $Y=0.135 $X2=0.297 $Y2=0.135
r21 12 41 1.18787 $w=1.49231e-08 $l=1.45344e-08 $layer=M1 $thickness=3.6e-08
+ $X=0.189 $Y=0.1465 $X2=0.176 $Y2=0.153
r22 12 42 2.35382 $w=1.4087e-08 $l=1.15e-08 $layer=M1 $thickness=3.6e-08
+ $X=0.189 $Y=0.1465 $X2=0.189 $Y2=0.135
r23 12 44 0.9184 $w=1.8e-08 $l=9e-09 $layer=M1 $thickness=3.6e-08 $X=0.189
+ $Y=0.1465 $X2=0.189 $Y2=0.1555
r24 41 44 1.59605 $w=1.60952e-08 $l=1.32382e-08 $layer=M1 $thickness=3.6e-08
+ $X=0.176 $Y=0.153 $X2=0.189 $Y2=0.1555
r25 11 41 1.51573 $w=1.3e-08 $l=6.5e-09 $layer=M1 $thickness=3.6e-08 $X=0.1695
+ $Y=0.153 $X2=0.176 $Y2=0.153
r26 13 39 4.19742 $w=1.3e-08 $l=1.8e-08 $layer=M1 $thickness=3.6e-08 $X=0.297
+ $Y=0.1375 $X2=0.297 $Y2=0.1555
r27 13 45 19.3796 $a=3.24e-16 $layer=V0LIG $X=0.297 $Y=0.1375 $X2=0.297
+ $Y2=0.135
r28 36 37 6.64591 $w=1.3e-08 $l=2.85e-08 $layer=M2 $thickness=3.6e-08 $X=0.187
+ $Y=0.153 $X2=0.2095 $Y2=0.153
r29 36 41 43.953 $a=1.44e-16 $layer=V1 $X=0.187 $Y=0.153 $X2=0.176 $Y2=0.153
r30 36 44 35.1624 $a=1.8e-16 $layer=V1 $X=0.187 $Y=0.153 $X2=0.189 $Y2=0.1555
r31 33 34 34.8619 $w=1.3e-08 $l=1.495e-07 $layer=M2 $thickness=3.6e-08 $X=0.297
+ $Y=0.153 $X2=0.4465 $Y2=0.153
r32 33 39 19.5347 $a=3.24e-16 $layer=V1 $X=0.297 $Y=0.153 $X2=0.297 $Y2=0.1555
r33 32 33 8.97781 $w=1.3e-08 $l=3.85e-08 $layer=M2 $thickness=3.6e-08 $X=0.2585
+ $Y=0.153 $X2=0.297 $Y2=0.153
r34 32 37 11.4263 $w=1.3e-08 $l=4.9e-08 $layer=M2 $thickness=3.6e-08 $X=0.2585
+ $Y=0.153 $X2=0.2095 $Y2=0.153
r35 31 34 37.427 $w=1.3e-08 $l=1.605e-07 $layer=M2 $thickness=3.6e-08 $X=0.607
+ $Y=0.153 $X2=0.4465 $Y2=0.153
r36 15 29 6.64591 $w=1.3e-08 $l=2.85e-08 $layer=M2 $thickness=3.6e-08 $X=0.6465
+ $Y=0.153 $X2=0.675 $Y2=0.153
r37 15 31 9.211 $w=1.3e-08 $l=3.95e-08 $layer=M2 $thickness=3.6e-08 $X=0.6465
+ $Y=0.153 $X2=0.607 $Y2=0.153
r38 27 29 19.5347 $a=3.24e-16 $layer=V1 $X=0.675 $Y=0.144 $X2=0.675 $Y2=0.153
r39 14 27 4.78039 $w=1.3e-08 $l=2.05e-08 $layer=M1 $thickness=3.6e-08 $X=0.675
+ $Y=0.1235 $X2=0.675 $Y2=0.144
r40 3 22 10.4265 $w=1.765e-08 $layer=LIG $thickness=5.2e-08 $X=0.675 $Y=0.135
+ $X2=0.675 $Y2=0.135
r41 3 27 19.3796 $a=3.24e-16 $layer=V0LIG $X=0.675 $Y=0.135 $X2=0.675 $Y2=0.144
r42 25 24 14.6259 $w=2.1e-08 $l=4.3e-08 $layer=Gate_1 $thickness=5.6e-08
+ $X=0.675 $Y=0.2025 $X2=0.675 $Y2=0.1595
r43 23 24 2.7211 $w=2.1e-08 $l=8e-09 $layer=Gate_1 $thickness=5.6e-08 $X=0.675
+ $Y=0.1515 $X2=0.675 $Y2=0.1595
r44 22 23 5.79936 $w=2.03333e-08 $l=1.65e-08 $layer=Gate_1 $thickness=5.6e-08
+ $X=0.675 $Y=0.135 $X2=0.675 $Y2=0.1515
r45 21 22 5.79936 $w=2.03333e-08 $l=1.65e-08 $layer=Gate_1 $thickness=5.6e-08
+ $X=0.675 $Y=0.1185 $X2=0.675 $Y2=0.135
r46 20 21 2.7211 $w=2.1e-08 $l=8e-09 $layer=Gate_1 $thickness=5.6e-08 $X=0.675
+ $Y=0.1105 $X2=0.675 $Y2=0.1185
r47 19 20 14.6259 $w=2.1e-08 $l=4.3e-08 $layer=Gate_1 $thickness=5.6e-08
+ $X=0.675 $Y=0.0675 $X2=0.675 $Y2=0.1105
r48 19 10 14.6259 $w=2.1e-08 $l=4.3e-08 $layer=Gate_1 $thickness=5.6e-08
+ $X=0.675 $Y=0.0675 $X2=0.675 $Y2=0.0245
.ends

.subckt PM_FAx1_ASAP7_75t_R%CON vss 35 24 28 62 63 72 73 17 3 18 12 4 13 20 21
+ 19 10 11 14 1 16 15 9
c1 1 vss 0.000246775f $X=0.513 $Y=0.135
c2 3 vss 0.00363452f $X=0.216 $Y=0.0675
c3 4 vss 0.00388637f $X=0.216 $Y=0.2025
c4 9 vss 0.00550621f $X=0.513 $Y=0.0245
c5 10 vss 0.00559331f $X=0.2015 $Y=0.0675
c6 11 vss 0.00560123f $X=0.2015 $Y=0.2025
c7 12 vss 0.000952656f $X=0.133 $Y=0.081
c8 13 vss 0.000823568f $X=0.133 $Y=0.1935
c9 14 vss 5.33304e-20 $X=0.5095 $Y=0.1055
c10 15 vss 0.000701717f $X=0.524 $Y=0.099
c11 16 vss 0.000354042f $X=0.5355 $Y=0.081
c12 17 vss 0.00178102f $X=0.133 $Y=0.099
c13 18 vss 0.00189916f $X=0.1465 $Y=0.081
c14 19 vss 0.00153615f $X=0.1545 $Y=0.198
c15 20 vss 0.000133829f $X=0.513 $Y=0.117
c16 21 vss 0.0133993f $X=0.2592 $Y=0.081
r1 73 71 0.0308642 $w=8.1e-08 $l=2.5e-09 $layer=P_src_drn $thickness=1e-09
+ $X=0.2333 $Y=0.2025 $X2=0.2305 $Y2=0.2025
r2 4 71 0.179012 $w=8.1e-08 $l=1.45e-08 $layer=P_src_drn $thickness=1e-09
+ $X=0.216 $Y=0.2025 $X2=0.2305 $Y2=0.2025
r3 11 4 0.179012 $w=8.1e-08 $l=1.45e-08 $layer=P_src_drn $thickness=1e-09
+ $X=0.2015 $Y=0.2025 $X2=0.216 $Y2=0.2025
r4 72 11 0.0308642 $w=8.1e-08 $l=2.5e-09 $layer=P_src_drn $thickness=1e-09
+ $X=0.1986 $Y=0.2025 $X2=0.2015 $Y2=0.2025
r5 4 67 19.3796 $a=3.24e-16 $layer=V0LISD $X=0.216 $Y=0.2025 $X2=0.216 $Y2=0.198
r6 66 67 3.14806 $w=1.3e-08 $l=1.35e-08 $layer=M1 $thickness=3.6e-08 $X=0.2025
+ $Y=0.198 $X2=0.216 $Y2=0.198
r7 65 66 3.14806 $w=1.3e-08 $l=1.35e-08 $layer=M1 $thickness=3.6e-08 $X=0.189
+ $Y=0.198 $X2=0.2025 $Y2=0.198
r8 64 65 3.61444 $w=1.3e-08 $l=1.55e-08 $layer=M1 $thickness=3.6e-08 $X=0.1735
+ $Y=0.198 $X2=0.189 $Y2=0.198
r9 19 64 4.43061 $w=1.3e-08 $l=1.9e-08 $layer=M1 $thickness=3.6e-08 $X=0.1545
+ $Y=0.198 $X2=0.1735 $Y2=0.198
r10 63 61 0.0308642 $w=8.1e-08 $l=2.5e-09 $layer=N_src_drn $thickness=1e-09
+ $X=0.2333 $Y=0.0675 $X2=0.2305 $Y2=0.0675
r11 3 61 0.179012 $w=8.1e-08 $l=1.45e-08 $layer=N_src_drn $thickness=1e-09
+ $X=0.216 $Y=0.0675 $X2=0.2305 $Y2=0.0675
r12 10 3 0.179012 $w=8.1e-08 $l=1.45e-08 $layer=N_src_drn $thickness=1e-09
+ $X=0.2015 $Y=0.0675 $X2=0.216 $Y2=0.0675
r13 62 10 0.0308642 $w=8.1e-08 $l=2.5e-09 $layer=N_src_drn $thickness=1e-09
+ $X=0.1986 $Y=0.0675 $X2=0.2015 $Y2=0.0675
r14 13 58 1.50855 $w=1.55e-08 $l=9e-09 $layer=M1 $thickness=3.6e-08 $X=0.133
+ $Y=0.1935 $X2=0.133 $Y2=0.1845
r15 13 19 3.37407 $w=1.43235e-08 $l=2.19659e-08 $layer=M1 $thickness=3.6e-08
+ $X=0.133 $Y=0.1935 $X2=0.1545 $Y2=0.198
r16 3 47 19.3796 $a=3.24e-16 $layer=V0LISD $X=0.216 $Y=0.0675 $X2=0.216
+ $Y2=0.081
r17 57 58 2.56509 $w=1.3e-08 $l=1.1e-08 $layer=M1 $thickness=3.6e-08 $X=0.133
+ $Y=0.1735 $X2=0.133 $Y2=0.1845
r18 56 57 2.09871 $w=1.3e-08 $l=9e-09 $layer=M1 $thickness=3.6e-08 $X=0.133
+ $Y=0.1645 $X2=0.133 $Y2=0.1735
r19 55 56 2.68168 $w=1.3e-08 $l=1.15e-08 $layer=M1 $thickness=3.6e-08 $X=0.133
+ $Y=0.153 $X2=0.133 $Y2=0.1645
r20 54 55 4.78039 $w=1.3e-08 $l=2.05e-08 $layer=M1 $thickness=3.6e-08 $X=0.133
+ $Y=0.1325 $X2=0.133 $Y2=0.153
r21 53 54 4.19742 $w=1.3e-08 $l=1.8e-08 $layer=M1 $thickness=3.6e-08 $X=0.133
+ $Y=0.1145 $X2=0.133 $Y2=0.1325
r22 17 53 3.61444 $w=1.3e-08 $l=1.55e-08 $layer=M1 $thickness=3.6e-08 $X=0.133
+ $Y=0.099 $X2=0.133 $Y2=0.1145
r23 46 47 3.14806 $w=1.3e-08 $l=1.35e-08 $layer=M1 $thickness=3.6e-08 $X=0.2025
+ $Y=0.081 $X2=0.216 $Y2=0.081
r24 45 46 3.14806 $w=1.3e-08 $l=1.35e-08 $layer=M1 $thickness=3.6e-08 $X=0.189
+ $Y=0.081 $X2=0.2025 $Y2=0.081
r25 44 45 3.61444 $w=1.3e-08 $l=1.55e-08 $layer=M1 $thickness=3.6e-08 $X=0.1735
+ $Y=0.081 $X2=0.189 $Y2=0.081
r26 43 44 3.38125 $w=1.3e-08 $l=1.45e-08 $layer=M1 $thickness=3.6e-08 $X=0.159
+ $Y=0.081 $X2=0.1735 $Y2=0.081
r27 18 43 2.91487 $w=1.3e-08 $l=1.25e-08 $layer=M1 $thickness=3.6e-08 $X=0.1465
+ $Y=0.081 $X2=0.159 $Y2=0.081
r28 18 41 39.0693 $a=1.62e-16 $layer=V1 $X=0.1465 $Y=0.081 $X2=0.142 $Y2=0.081
r29 12 41 39.0693 $a=1.62e-16 $layer=V1 $X=0.133 $Y=0.081 $X2=0.142 $Y2=0.081
r30 12 18 1.96775 $w=1.63333e-08 $l=1.35e-08 $layer=M1 $thickness=3.6e-08
+ $X=0.133 $Y=0.081 $X2=0.1465 $Y2=0.081
r31 12 17 3.01711 $w=1.55e-08 $l=1.8e-08 $layer=M1 $thickness=3.6e-08 $X=0.133
+ $Y=0.081 $X2=0.133 $Y2=0.099
r32 41 42 3.96423 $w=1.3e-08 $l=1.7e-08 $layer=M2 $thickness=3.6e-08 $X=0.142
+ $Y=0.081 $X2=0.159 $Y2=0.081
r33 39 42 9.0944 $w=1.3e-08 $l=3.9e-08 $layer=M2 $thickness=3.6e-08 $X=0.198
+ $Y=0.081 $X2=0.159 $Y2=0.081
r34 36 37 28.8572 $w=1.3e-08 $l=1.238e-07 $layer=M2 $thickness=3.6e-08
+ $X=0.4052 $Y=0.081 $X2=0.529 $Y2=0.081
r35 35 36 26.8751 $w=1.3e-08 $l=1.152e-07 $layer=M2 $thickness=3.6e-08 $X=0.29
+ $Y=0.081 $X2=0.4052 $Y2=0.081
r36 35 21 7.17059 $w=1.3e-08 $l=3.08e-08 $layer=M2 $thickness=3.6e-08 $X=0.29
+ $Y=0.081 $X2=0.2592 $Y2=0.081
r37 21 39 14.2829 $w=1.3e-08 $l=6.12e-08 $layer=M2 $thickness=3.6e-08 $X=0.2592
+ $Y=0.081 $X2=0.198 $Y2=0.081
r38 16 33 1.50137 $w=1.6913e-08 $l=1.15e-08 $layer=M1 $thickness=3.6e-08
+ $X=0.5355 $Y=0.081 $X2=0.524 $Y2=0.081
r39 16 37 70.3248 $a=9e-17 $layer=V1 $X=0.5355 $Y=0.081 $X2=0.529 $Y2=0.081
r40 33 37 27.048 $a=2.34e-16 $layer=V1 $X=0.524 $Y=0.081 $X2=0.529 $Y2=0.081
r41 15 20 3.01711 $w=1.55e-08 $l=2.1095e-08 $layer=M1 $thickness=3.6e-08
+ $X=0.524 $Y=0.099 $X2=0.513 $Y2=0.117
r42 15 32 2.9921 $w=1.50645e-08 $l=1.47139e-08 $layer=M1 $thickness=3.6e-08
+ $X=0.524 $Y=0.099 $X2=0.5095 $Y2=0.0965
r43 15 33 1.8368 $w=1.8e-08 $l=1.8e-08 $layer=M1 $thickness=3.6e-08 $X=0.524
+ $Y=0.099 $X2=0.524 $Y2=0.081
r44 14 20 2.89628 $w=1.25652e-08 $l=1.20208e-08 $layer=M1 $thickness=3.6e-08
+ $X=0.5095 $Y=0.1055 $X2=0.513 $Y2=0.117
r45 14 32 2.87127 $w=1.1e-08 $l=9e-09 $layer=M1 $thickness=3.6e-08 $X=0.5095
+ $Y=0.1055 $X2=0.5095 $Y2=0.0965
r46 20 30 4.19742 $w=1.3e-08 $l=1.8e-08 $layer=M1 $thickness=3.6e-08 $X=0.513
+ $Y=0.117 $X2=0.513 $Y2=0.135
r47 1 26 10.4265 $w=1.765e-08 $layer=LIG $thickness=5.2e-08 $X=0.513 $Y=0.135
+ $X2=0.513 $Y2=0.135
r48 1 30 19.3796 $a=3.24e-16 $layer=V0LIG $X=0.513 $Y=0.135 $X2=0.513 $Y2=0.135
r49 28 27 16.4967 $w=2.1e-08 $l=4.85e-08 $layer=Gate_1 $thickness=5.6e-08
+ $X=0.513 $Y=0.2025 $X2=0.513 $Y2=0.154
r50 26 27 6.6497 $w=2.04211e-08 $l=1.9e-08 $layer=Gate_1 $thickness=5.6e-08
+ $X=0.513 $Y=0.135 $X2=0.513 $Y2=0.154
r51 25 26 6.6497 $w=2.04211e-08 $l=1.9e-08 $layer=Gate_1 $thickness=5.6e-08
+ $X=0.513 $Y=0.116 $X2=0.513 $Y2=0.135
r52 24 25 16.4967 $w=2.1e-08 $l=4.85e-08 $layer=Gate_1 $thickness=5.6e-08
+ $X=0.513 $Y=0.0675 $X2=0.513 $Y2=0.116
r53 24 9 14.6259 $w=2.1e-08 $l=4.3e-08 $layer=Gate_1 $thickness=5.6e-08
+ $X=0.513 $Y=0.0675 $X2=0.513 $Y2=0.0245
.ends

.subckt PM_FAx1_ASAP7_75t_R%SN vss 39 19 20 50 51 15 14 13 8 16 7 1 2 11 12
c1 1 vss 0.00316473f $X=0.486 $Y=0.0675
c2 2 vss 0.00340553f $X=0.486 $Y=0.2025
c3 7 vss 0.0021837f $X=0.4715 $Y=0.0675
c4 8 vss 0.00218515f $X=0.4715 $Y=0.2025
c5 9 vss 0.00342252f $X=0.333 $Y=0.036
c6 10 vss 0.00354882f $X=0.333 $Y=0.234
c7 11 vss 0.00233902f $X=0.486 $Y=0.054
c8 12 vss 0.00231331f $X=0.486 $Y=0.234
c9 13 vss 0.00525687f $X=0.333 $Y=0.0565
c10 14 vss 0.0111662f $X=0.4725 $Y=0.036
c11 15 vss 0.0109543f $X=0.3625 $Y=0.234
c12 16 vss 0.000470258f $X=0.486 $Y=0.2025
r1 51 49 0.0308642 $w=8.1e-08 $l=2.5e-09 $layer=P_src_drn $thickness=1e-09
+ $X=0.5033 $Y=0.2025 $X2=0.5005 $Y2=0.2025
r2 2 49 0.179012 $w=8.1e-08 $l=1.45e-08 $layer=P_src_drn $thickness=1e-09
+ $X=0.486 $Y=0.2025 $X2=0.5005 $Y2=0.2025
r3 8 2 0.179012 $w=8.1e-08 $l=1.45e-08 $layer=P_src_drn $thickness=1e-09
+ $X=0.4715 $Y=0.2025 $X2=0.486 $Y2=0.2025
r4 50 8 0.0308642 $w=8.1e-08 $l=2.5e-09 $layer=P_src_drn $thickness=1e-09
+ $X=0.4686 $Y=0.2025 $X2=0.4715 $Y2=0.2025
r5 2 47 19.3796 $a=3.24e-16 $layer=V0LISD $X=0.486 $Y=0.2025 $X2=0.486
+ $Y2=0.1935
r6 16 45 3.14806 $w=1.3e-08 $l=1.35e-08 $layer=M1 $thickness=3.6e-08 $X=0.486
+ $Y=0.2025 $X2=0.486 $Y2=0.216
r7 16 47 2.09871 $w=1.3e-08 $l=9e-09 $layer=M1 $thickness=3.6e-08 $X=0.486
+ $Y=0.2025 $X2=0.486 $Y2=0.1935
r8 12 44 1.49895 $w=1.63333e-08 $l=1.35e-08 $layer=M1 $thickness=3.6e-08
+ $X=0.486 $Y=0.234 $X2=0.4725 $Y2=0.234
r9 12 45 2.5483 $w=1.79e-08 $l=1.8e-08 $layer=M1 $thickness=3.6e-08 $X=0.486
+ $Y=0.234 $X2=0.486 $Y2=0.216
r10 43 44 3.14806 $w=1.3e-08 $l=1.35e-08 $layer=M1 $thickness=3.6e-08 $X=0.459
+ $Y=0.234 $X2=0.4725 $Y2=0.234
r11 42 43 6.29612 $w=1.3e-08 $l=2.7e-08 $layer=M1 $thickness=3.6e-08 $X=0.432
+ $Y=0.234 $X2=0.459 $Y2=0.234
r12 41 42 7.81186 $w=1.3e-08 $l=3.35e-08 $layer=M1 $thickness=3.6e-08 $X=0.3985
+ $Y=0.234 $X2=0.432 $Y2=0.234
r13 15 41 8.39483 $w=1.3e-08 $l=3.6e-08 $layer=M1 $thickness=3.6e-08 $X=0.3625
+ $Y=0.234 $X2=0.3985 $Y2=0.234
r14 10 40 1.55725 $w=1.94145e-08 $l=1.38e-08 $layer=M1 $thickness=3.6e-08
+ $X=0.333 $Y=0.234 $X2=0.333 $Y2=0.2202
r15 10 15 5.22999 $w=1.45254e-08 $l=2.95e-08 $layer=M1 $thickness=3.6e-08
+ $X=0.333 $Y=0.234 $X2=0.3625 $Y2=0.234
r16 39 40 1.22425 $w=1.3e-08 $l=5.2e-09 $layer=M1 $thickness=3.6e-08 $X=0.334
+ $Y=0.215 $X2=0.333 $Y2=0.2202
r17 39 38 0.991057 $w=1.3e-08 $l=4.3e-09 $layer=M1 $thickness=3.6e-08 $X=0.334
+ $Y=0.215 $X2=0.333 $Y2=0.2107
r18 37 38 1.92382 $w=1.3e-08 $l=8.2e-09 $layer=M1 $thickness=3.6e-08 $X=0.333
+ $Y=0.2025 $X2=0.333 $Y2=0.2107
r19 36 37 2.09871 $w=1.3e-08 $l=9e-09 $layer=M1 $thickness=3.6e-08 $X=0.333
+ $Y=0.1935 $X2=0.333 $Y2=0.2025
r20 35 36 2.09871 $w=1.3e-08 $l=9e-09 $layer=M1 $thickness=3.6e-08 $X=0.333
+ $Y=0.1845 $X2=0.333 $Y2=0.1935
r21 34 35 2.56509 $w=1.3e-08 $l=1.1e-08 $layer=M1 $thickness=3.6e-08 $X=0.333
+ $Y=0.1735 $X2=0.333 $Y2=0.1845
r22 33 34 6.8791 $w=1.3e-08 $l=2.95e-08 $layer=M1 $thickness=3.6e-08 $X=0.333
+ $Y=0.144 $X2=0.333 $Y2=0.1735
r23 32 33 6.8791 $w=1.3e-08 $l=2.95e-08 $layer=M1 $thickness=3.6e-08 $X=0.333
+ $Y=0.1145 $X2=0.333 $Y2=0.144
r24 31 32 2.09871 $w=1.3e-08 $l=9e-09 $layer=M1 $thickness=3.6e-08 $X=0.333
+ $Y=0.1055 $X2=0.333 $Y2=0.1145
r25 30 31 2.09871 $w=1.3e-08 $l=9e-09 $layer=M1 $thickness=3.6e-08 $X=0.333
+ $Y=0.0965 $X2=0.333 $Y2=0.1055
r26 29 30 3.61444 $w=1.3e-08 $l=1.55e-08 $layer=M1 $thickness=3.6e-08 $X=0.333
+ $Y=0.081 $X2=0.333 $Y2=0.0965
r27 28 29 2.56509 $w=1.3e-08 $l=1.1e-08 $layer=M1 $thickness=3.6e-08 $X=0.333
+ $Y=0.07 $X2=0.333 $Y2=0.081
r28 13 28 3.14806 $w=1.3e-08 $l=1.35e-08 $layer=M1 $thickness=3.6e-08 $X=0.333
+ $Y=0.0565 $X2=0.333 $Y2=0.07
r29 9 27 5.22999 $w=1.45254e-08 $l=2.95e-08 $layer=M1 $thickness=3.6e-08
+ $X=0.333 $Y=0.036 $X2=0.3625 $Y2=0.036
r30 9 13 3.13128 $w=1.73024e-08 $l=2.05e-08 $layer=M1 $thickness=3.6e-08
+ $X=0.333 $Y=0.036 $X2=0.333 $Y2=0.0565
r31 26 27 6.29612 $w=1.3e-08 $l=2.7e-08 $layer=M1 $thickness=3.6e-08 $X=0.3895
+ $Y=0.036 $X2=0.3625 $Y2=0.036
r32 25 26 3.61444 $w=1.3e-08 $l=1.55e-08 $layer=M1 $thickness=3.6e-08 $X=0.405
+ $Y=0.036 $X2=0.3895 $Y2=0.036
r33 24 25 6.29612 $w=1.3e-08 $l=2.7e-08 $layer=M1 $thickness=3.6e-08 $X=0.432
+ $Y=0.036 $X2=0.405 $Y2=0.036
r34 23 24 6.29612 $w=1.3e-08 $l=2.7e-08 $layer=M1 $thickness=3.6e-08 $X=0.459
+ $Y=0.036 $X2=0.432 $Y2=0.036
r35 14 22 1.96775 $w=1.63333e-08 $l=1.35e-08 $layer=M1 $thickness=3.6e-08
+ $X=0.4725 $Y=0.036 $X2=0.486 $Y2=0.036
r36 14 23 3.14806 $w=1.3e-08 $l=1.35e-08 $layer=M1 $thickness=3.6e-08 $X=0.4725
+ $Y=0.036 $X2=0.459 $Y2=0.036
r37 11 22 3.01711 $w=1.55e-08 $l=1.8e-08 $layer=M1 $thickness=3.6e-08 $X=0.486
+ $Y=0.054 $X2=0.486 $Y2=0.036
r38 1 11 19.3796 $a=3.24e-16 $layer=V0LISD $X=0.486 $Y=0.0675 $X2=0.486
+ $Y2=0.054
r39 20 18 0.0308642 $w=8.1e-08 $l=2.5e-09 $layer=N_src_drn $thickness=1e-09
+ $X=0.5033 $Y=0.0675 $X2=0.5005 $Y2=0.0675
r40 1 18 0.179012 $w=8.1e-08 $l=1.45e-08 $layer=N_src_drn $thickness=1e-09
+ $X=0.486 $Y=0.0675 $X2=0.5005 $Y2=0.0675
r41 7 1 0.179012 $w=8.1e-08 $l=1.45e-08 $layer=N_src_drn $thickness=1e-09
+ $X=0.4715 $Y=0.0675 $X2=0.486 $Y2=0.0675
r42 19 7 0.0308642 $w=8.1e-08 $l=2.5e-09 $layer=N_src_drn $thickness=1e-09
+ $X=0.4686 $Y=0.0675 $X2=0.4715 $Y2=0.0675
.ends

.subckt PM_FAx1_ASAP7_75t_R%11 vss 12 13 27 28 8 9 2 7 1
c1 1 vss 0.00623334f $X=0.54 $Y=0.2025
c2 2 vss 0.00890282f $X=0.648 $Y=0.2025
c3 7 vss 0.00314829f $X=0.5255 $Y=0.2025
c4 8 vss 0.00431361f $X=0.6335 $Y=0.2025
c5 9 vss 0.0119279f $X=0.538 $Y=0.234
r1 28 26 0.0308642 $w=8.1e-08 $l=2.5e-09 $layer=P_src_drn $thickness=1e-09
+ $X=0.6653 $Y=0.2025 $X2=0.6625 $Y2=0.2025
r2 2 26 0.179012 $w=8.1e-08 $l=1.45e-08 $layer=P_src_drn $thickness=1e-09
+ $X=0.648 $Y=0.2025 $X2=0.6625 $Y2=0.2025
r3 8 2 0.179012 $w=8.1e-08 $l=1.45e-08 $layer=P_src_drn $thickness=1e-09
+ $X=0.6335 $Y=0.2025 $X2=0.648 $Y2=0.2025
r4 27 8 0.0308642 $w=8.1e-08 $l=2.5e-09 $layer=P_src_drn $thickness=1e-09
+ $X=0.6306 $Y=0.2025 $X2=0.6335 $Y2=0.2025
r5 2 23 19.3796 $a=3.24e-16 $layer=V0LISD $X=0.648 $Y=0.2025 $X2=0.648 $Y2=0.234
r6 22 23 3.14806 $w=1.3e-08 $l=1.35e-08 $layer=M1 $thickness=3.6e-08 $X=0.6345
+ $Y=0.234 $X2=0.648 $Y2=0.234
r7 21 22 4.6638 $w=1.3e-08 $l=2e-08 $layer=M1 $thickness=3.6e-08 $X=0.6145
+ $Y=0.234 $X2=0.6345 $Y2=0.234
r8 20 21 5.01358 $w=1.3e-08 $l=2.15e-08 $layer=M1 $thickness=3.6e-08 $X=0.593
+ $Y=0.234 $X2=0.6145 $Y2=0.234
r9 19 20 2.68168 $w=1.3e-08 $l=1.15e-08 $layer=M1 $thickness=3.6e-08 $X=0.5815
+ $Y=0.234 $X2=0.593 $Y2=0.234
r10 18 19 3.38125 $w=1.3e-08 $l=1.45e-08 $layer=M1 $thickness=3.6e-08 $X=0.567
+ $Y=0.234 $X2=0.5815 $Y2=0.234
r11 17 18 3.14806 $w=1.3e-08 $l=1.35e-08 $layer=M1 $thickness=3.6e-08 $X=0.5535
+ $Y=0.234 $X2=0.567 $Y2=0.234
r12 16 17 1.74892 $w=1.3e-08 $l=7.5e-09 $layer=M1 $thickness=3.6e-08 $X=0.546
+ $Y=0.234 $X2=0.5535 $Y2=0.234
r13 9 16 1.86552 $w=1.3e-08 $l=8e-09 $layer=M1 $thickness=3.6e-08 $X=0.538
+ $Y=0.234 $X2=0.546 $Y2=0.234
r14 1 9 19.3796 $a=3.24e-16 $layer=V0LISD $X=0.54 $Y=0.2025 $X2=0.538 $Y2=0.234
r15 13 11 0.0308642 $w=8.1e-08 $l=2.5e-09 $layer=P_src_drn $thickness=1e-09
+ $X=0.5573 $Y=0.2025 $X2=0.5545 $Y2=0.2025
r16 1 11 0.179012 $w=8.1e-08 $l=1.45e-08 $layer=P_src_drn $thickness=1e-09
+ $X=0.54 $Y=0.2025 $X2=0.5545 $Y2=0.2025
r17 7 1 0.179012 $w=8.1e-08 $l=1.45e-08 $layer=P_src_drn $thickness=1e-09
+ $X=0.5255 $Y=0.2025 $X2=0.54 $Y2=0.2025
r18 12 7 0.0308642 $w=8.1e-08 $l=2.5e-09 $layer=P_src_drn $thickness=1e-09
+ $X=0.5226 $Y=0.2025 $X2=0.5255 $Y2=0.2025
.ends

.subckt PM_FAx1_ASAP7_75t_R%A vss 46 21 27 38 41 63 66 69 72 1 17 13 12 2 16 15
+ 3 10 8 9 11 14 7
c1 1 vss 0.010652f $X=0.0715 $Y=0.135
c2 2 vss 0.00174378f $X=0.405 $Y=0.135
c3 3 vss 0.00343654f $X=0.621 $Y=0.135
c4 7 vss 0.0866667f $X=0.081 $Y=0.0245
c5 8 vss 0.0869445f $X=0.135 $Y=0.135
c6 9 vss 0.0141132f $X=0.405 $Y=0.135
c7 10 vss 0.0816902f $X=0.621 $Y=0.135
c8 11 vss 0.00249507f $X=0.0745 $Y=0.189
c9 12 vss 0.00109282f $X=0.3985 $Y=0.182
c10 13 vss 0.00138652f $X=0.6145 $Y=0.182
c11 14 vss 0.00232408f $X=0.081 $Y=0.1235
c12 15 vss 0.000605191f $X=0.405 $Y=0.1645
c13 16 vss 0.000910615f $X=0.621 $Y=0.1735
c14 17 vss 0.0248899f $X=0.0615 $Y=0.189
r1 72 71 16.4967 $w=2.1e-08 $l=4.85e-08 $layer=Gate_1 $thickness=5.6e-08
+ $X=0.621 $Y=0.2025 $X2=0.621 $Y2=0.154
r2 69 70 16.4967 $w=2.1e-08 $l=4.85e-08 $layer=Gate_1 $thickness=5.6e-08
+ $X=0.621 $Y=0.0675 $X2=0.621 $Y2=0.116
r3 10 70 6.6497 $w=2.04211e-08 $l=1.9e-08 $layer=Gate_1 $thickness=5.6e-08
+ $X=0.621 $Y=0.135 $X2=0.621 $Y2=0.116
r4 10 71 6.6497 $w=2.04211e-08 $l=1.9e-08 $layer=Gate_1 $thickness=5.6e-08
+ $X=0.621 $Y=0.135 $X2=0.621 $Y2=0.154
r5 66 65 16.4967 $w=2.1e-08 $l=4.85e-08 $layer=Gate_1 $thickness=5.6e-08
+ $X=0.405 $Y=0.2025 $X2=0.405 $Y2=0.154
r6 63 64 16.4967 $w=2.1e-08 $l=4.85e-08 $layer=Gate_1 $thickness=5.6e-08
+ $X=0.405 $Y=0.0675 $X2=0.405 $Y2=0.116
r7 9 64 6.6497 $w=2.04211e-08 $l=1.9e-08 $layer=Gate_1 $thickness=5.6e-08
+ $X=0.405 $Y=0.135 $X2=0.405 $Y2=0.116
r8 9 65 6.6497 $w=2.04211e-08 $l=1.9e-08 $layer=Gate_1 $thickness=5.6e-08
+ $X=0.405 $Y=0.135 $X2=0.405 $Y2=0.154
r9 3 59 19.3796 $a=3.24e-16 $layer=V0LIG $X=0.621 $Y=0.135 $X2=0.621 $Y2=0.135
r10 3 10 10.4265 $w=1.765e-08 $layer=LIG $thickness=5.2e-08 $X=0.621 $Y=0.135
+ $X2=0.621 $Y2=0.135
r11 2 56 19.3796 $a=3.24e-16 $layer=V0LIG $X=0.405 $Y=0.135 $X2=0.405 $Y2=0.135
r12 2 9 10.4265 $w=1.765e-08 $layer=LIG $thickness=5.2e-08 $X=0.405 $Y=0.135
+ $X2=0.405 $Y2=0.135
r13 59 60 2.68168 $w=1.3e-08 $l=1.15e-08 $layer=M1 $thickness=3.6e-08 $X=0.621
+ $Y=0.135 $X2=0.621 $Y2=0.1465
r14 58 60 2.68168 $w=1.3e-08 $l=1.15e-08 $layer=M1 $thickness=3.6e-08 $X=0.621
+ $Y=0.158 $X2=0.621 $Y2=0.1465
r15 16 58 3.61444 $w=1.3e-08 $l=1.55e-08 $layer=M1 $thickness=3.6e-08 $X=0.621
+ $Y=0.1735 $X2=0.621 $Y2=0.158
r16 56 57 2.68168 $w=1.3e-08 $l=1.15e-08 $layer=M1 $thickness=3.6e-08 $X=0.405
+ $Y=0.135 $X2=0.405 $Y2=0.1465
r17 15 57 4.19742 $w=1.3e-08 $l=1.8e-08 $layer=M1 $thickness=3.6e-08 $X=0.405
+ $Y=0.1645 $X2=0.405 $Y2=0.1465
r18 13 54 0.507446 $w=2.6e-08 $l=9e-09 $layer=M1 $thickness=3.6e-08 $X=0.6145
+ $Y=0.182 $X2=0.6145 $Y2=0.191
r19 13 16 1.6285 $w=1.60588e-08 $l=1.07005e-08 $layer=M1 $thickness=3.6e-08
+ $X=0.6145 $Y=0.182 $X2=0.621 $Y2=0.1735
r20 12 53 0.507446 $w=2.6e-08 $l=9e-09 $layer=M1 $thickness=3.6e-08 $X=0.3985
+ $Y=0.182 $X2=0.3985 $Y2=0.191
r21 12 15 3.72721 $w=1.44857e-08 $l=1.86682e-08 $layer=M1 $thickness=3.6e-08
+ $X=0.3985 $Y=0.182 $X2=0.405 $Y2=0.1645
r22 51 54 19.5347 $a=3.24e-16 $layer=V1 $X=0.613 $Y=0.189 $X2=0.6145 $Y2=0.191
r23 50 51 25.1845 $w=1.3e-08 $l=1.08e-07 $layer=M2 $thickness=3.6e-08 $X=0.505
+ $Y=0.189 $X2=0.613 $Y2=0.189
r24 49 50 25.1845 $w=1.3e-08 $l=1.08e-07 $layer=M2 $thickness=3.6e-08 $X=0.397
+ $Y=0.189 $X2=0.505 $Y2=0.189
r25 49 53 19.5347 $a=3.24e-16 $layer=V1 $X=0.397 $Y=0.189 $X2=0.3985 $Y2=0.191
r26 48 49 27.8662 $w=1.3e-08 $l=1.195e-07 $layer=M2 $thickness=3.6e-08
+ $X=0.2775 $Y=0.189 $X2=0.397 $Y2=0.189
r27 47 48 28.7406 $w=1.3e-08 $l=1.233e-07 $layer=M2 $thickness=3.6e-08
+ $X=0.1542 $Y=0.189 $X2=0.2775 $Y2=0.189
r28 46 47 3.08976 $w=1.3e-08 $l=1.32e-08 $layer=M2 $thickness=3.6e-08 $X=0.141
+ $Y=0.191 $X2=0.1542 $Y2=0.189
r29 46 45 1.57403 $w=1.3e-08 $l=6.8e-09 $layer=M2 $thickness=3.6e-08 $X=0.141
+ $Y=0.191 $X2=0.1342 $Y2=0.189
r30 44 45 6.8208 $w=1.3e-08 $l=2.92e-08 $layer=M2 $thickness=3.6e-08 $X=0.105
+ $Y=0.189 $X2=0.1342 $Y2=0.189
r31 43 44 7.46207 $w=1.3e-08 $l=3.2e-08 $layer=M2 $thickness=3.6e-08 $X=0.073
+ $Y=0.189 $X2=0.105 $Y2=0.189
r32 17 43 2.68168 $w=1.3e-08 $l=1.15e-08 $layer=M2 $thickness=3.6e-08 $X=0.0615
+ $Y=0.189 $X2=0.073 $Y2=0.189
r33 11 36 4.70486 $w=1.73333e-08 $l=2.77714e-08 $layer=M1 $thickness=3.6e-08
+ $X=0.0745 $Y=0.189 $X2=0.081 $Y2=0.162
r34 11 43 19.5347 $a=3.24e-16 $layer=V1 $X=0.0745 $Y=0.189 $X2=0.073 $Y2=0.189
r35 41 40 16.4967 $w=2.1e-08 $l=4.85e-08 $layer=Gate_1 $thickness=5.6e-08
+ $X=0.135 $Y=0.2025 $X2=0.135 $Y2=0.154
r36 38 39 16.4967 $w=2.1e-08 $l=4.85e-08 $layer=Gate_1 $thickness=5.6e-08
+ $X=0.135 $Y=0.0675 $X2=0.135 $Y2=0.116
r37 8 33 6.54019 $w=2.09524e-08 $layer=Gate_1 $thickness=5.21905e-08 $X=0.135
+ $Y=0.135 $X2=0.135 $Y2=0.135
r38 8 39 6.6497 $w=2.04211e-08 $l=1.9e-08 $layer=Gate_1 $thickness=5.6e-08
+ $X=0.135 $Y=0.135 $X2=0.135 $Y2=0.116
r39 8 40 6.6497 $w=2.04211e-08 $l=1.9e-08 $layer=Gate_1 $thickness=5.6e-08
+ $X=0.135 $Y=0.135 $X2=0.135 $Y2=0.154
r40 35 36 6.29612 $w=1.3e-08 $l=2.7e-08 $layer=M1 $thickness=3.6e-08 $X=0.081
+ $Y=0.135 $X2=0.081 $Y2=0.162
r41 14 35 2.68168 $w=1.3e-08 $l=1.15e-08 $layer=M1 $thickness=3.6e-08 $X=0.081
+ $Y=0.1235 $X2=0.081 $Y2=0.135
r42 32 33 12.6539 $w=1.77815e-08 $l=2.7e-08 $layer=LIG $thickness=4.8e-08
+ $X=0.108 $Y=0.135 $X2=0.135 $Y2=0.135
r43 30 32 10.1729 $w=1.54914e-08 $l=1.75e-08 $layer=LIG $thickness=4.8e-08
+ $X=0.0905 $Y=0.135 $X2=0.108 $Y2=0.135
r44 29 30 2.48102 $w=2.2e-08 $l=9.5e-09 $layer=LIG $thickness=4.8e-08 $X=0.081
+ $Y=0.135 $X2=0.0905 $Y2=0.135
r45 29 35 19.3796 $a=3.24e-16 $layer=V0LIG $X=0.081 $Y=0.135 $X2=0.081 $Y2=0.135
r46 1 29 2.48102 $w=2.2e-08 $l=9.5e-09 $layer=LIG $thickness=4.8e-08 $X=0.0715
+ $Y=0.135 $X2=0.081 $Y2=0.135
r47 27 26 14.6259 $w=2.1e-08 $l=4.3e-08 $layer=Gate_1 $thickness=5.6e-08
+ $X=0.081 $Y=0.2025 $X2=0.081 $Y2=0.1595
r48 25 26 2.7211 $w=2.1e-08 $l=8e-09 $layer=Gate_1 $thickness=5.6e-08 $X=0.081
+ $Y=0.1515 $X2=0.081 $Y2=0.1595
r49 24 25 5.79936 $w=2.03333e-08 $l=1.65e-08 $layer=Gate_1 $thickness=5.6e-08
+ $X=0.081 $Y=0.135 $X2=0.081 $Y2=0.1515
r50 24 30 4.05918 $w=2.0087e-08 $l=9.5e-09 $layer=Gate_1 $thickness=5.56522e-08
+ $X=0.081 $Y=0.135 $X2=0.0905 $Y2=0.135
r51 24 29 6.27904 $w=2.09e-08 $layer=Gate_1 $thickness=5.24e-08 $X=0.081
+ $Y=0.135 $X2=0.081 $Y2=0.135
r52 23 24 5.79936 $w=2.03333e-08 $l=1.65e-08 $layer=Gate_1 $thickness=5.6e-08
+ $X=0.081 $Y=0.1185 $X2=0.081 $Y2=0.135
r53 22 23 2.7211 $w=2.1e-08 $l=8e-09 $layer=Gate_1 $thickness=5.6e-08 $X=0.081
+ $Y=0.1105 $X2=0.081 $Y2=0.1185
r54 21 22 14.6259 $w=2.1e-08 $l=4.3e-08 $layer=Gate_1 $thickness=5.6e-08
+ $X=0.081 $Y=0.0675 $X2=0.081 $Y2=0.1105
r55 21 7 14.6259 $w=2.1e-08 $l=4.3e-08 $layer=Gate_1 $thickness=5.6e-08
+ $X=0.081 $Y=0.0675 $X2=0.081 $Y2=0.0245
.ends

.subckt PM_FAx1_ASAP7_75t_R%CI vss 29 20 24 43 46 49 52 8 13 15 3 14 2 16 9 11
+ 12 10 1 7
c1 1 vss 0.00520356f $X=0.243 $Y=0.135
c2 2 vss 0.0055601f $X=0.459 $Y=0.135
c3 3 vss 0.00852069f $X=0.567 $Y=0.135
c4 7 vss 0.00731003f $X=0.243 $Y=0.0245
c5 8 vss 0.0110123f $X=0.459 $Y=0.135
c6 9 vss 0.0832243f $X=0.567 $Y=0.135
c7 10 vss 0.00263736f $X=0.232 $Y=0.117
c8 11 vss 0.00523865f $X=0.243 $Y=0.117
c9 12 vss 0.00271402f $X=0.2575 $Y=0.117
c10 13 vss 0.00575634f $X=0.567 $Y=0.117
c11 14 vss 0.0030077f $X=0.579 $Y=0.117
c12 15 vss 0.00520356f $X=0.459 $Y=0.1145
c13 16 vss 0.00348342f $X=0.2315 $Y=0.117
r1 52 51 16.4967 $w=2.1e-08 $l=4.85e-08 $layer=Gate_1 $thickness=5.6e-08
+ $X=0.567 $Y=0.2025 $X2=0.567 $Y2=0.154
r2 49 50 16.4967 $w=2.1e-08 $l=4.85e-08 $layer=Gate_1 $thickness=5.6e-08
+ $X=0.567 $Y=0.0675 $X2=0.567 $Y2=0.116
r3 9 50 6.6497 $w=2.04211e-08 $l=1.9e-08 $layer=Gate_1 $thickness=5.6e-08
+ $X=0.567 $Y=0.135 $X2=0.567 $Y2=0.116
r4 9 51 6.6497 $w=2.04211e-08 $l=1.9e-08 $layer=Gate_1 $thickness=5.6e-08
+ $X=0.567 $Y=0.135 $X2=0.567 $Y2=0.154
r5 46 45 16.4967 $w=2.1e-08 $l=4.85e-08 $layer=Gate_1 $thickness=5.6e-08
+ $X=0.459 $Y=0.2025 $X2=0.459 $Y2=0.154
r6 43 44 16.4967 $w=2.1e-08 $l=4.85e-08 $layer=Gate_1 $thickness=5.6e-08
+ $X=0.459 $Y=0.0675 $X2=0.459 $Y2=0.116
r7 8 44 6.6497 $w=2.04211e-08 $l=1.9e-08 $layer=Gate_1 $thickness=5.6e-08
+ $X=0.459 $Y=0.135 $X2=0.459 $Y2=0.116
r8 8 45 6.6497 $w=2.04211e-08 $l=1.9e-08 $layer=Gate_1 $thickness=5.6e-08
+ $X=0.459 $Y=0.135 $X2=0.459 $Y2=0.154
r9 3 39 19.3796 $a=3.24e-16 $layer=V0LIG $X=0.567 $Y=0.135 $X2=0.567 $Y2=0.135
r10 3 9 10.4265 $w=1.765e-08 $layer=LIG $thickness=5.2e-08 $X=0.567 $Y=0.135
+ $X2=0.567 $Y2=0.135
r11 2 37 19.3796 $a=3.24e-16 $layer=V0LIG $X=0.459 $Y=0.135 $X2=0.459 $Y2=0.1325
r12 2 8 10.4265 $w=1.765e-08 $layer=LIG $thickness=5.2e-08 $X=0.459 $Y=0.135
+ $X2=0.459 $Y2=0.135
r13 14 34 58.604 $a=1.08e-16 $layer=V1 $X=0.579 $Y=0.117 $X2=0.573 $Y2=0.117
r14 13 34 29.302 $a=2.16e-16 $layer=V1 $X=0.567 $Y=0.117 $X2=0.573 $Y2=0.117
r15 13 39 3.01711 $w=1.55e-08 $l=1.8e-08 $layer=M1 $thickness=3.6e-08 $X=0.567
+ $Y=0.117 $X2=0.567 $Y2=0.135
r16 13 14 1.61797 $w=1.675e-08 $l=1.2e-08 $layer=M1 $thickness=3.6e-08 $X=0.567
+ $Y=0.117 $X2=0.579 $Y2=0.117
r17 15 31 19.5347 $a=3.24e-16 $layer=V1 $X=0.459 $Y=0.1145 $X2=0.459 $Y2=0.117
r18 15 37 4.19742 $w=1.3e-08 $l=1.8e-08 $layer=M1 $thickness=3.6e-08 $X=0.459
+ $Y=0.1145 $X2=0.459 $Y2=0.1325
r19 33 34 4.5472 $w=1.3e-08 $l=1.95e-08 $layer=M2 $thickness=3.6e-08 $X=0.5535
+ $Y=0.117 $X2=0.573 $Y2=0.117
r20 32 33 11.1931 $w=1.3e-08 $l=4.8e-08 $layer=M2 $thickness=3.6e-08 $X=0.5055
+ $Y=0.117 $X2=0.5535 $Y2=0.117
r21 31 32 10.8433 $w=1.3e-08 $l=4.65e-08 $layer=M2 $thickness=3.6e-08 $X=0.459
+ $Y=0.117 $X2=0.5055 $Y2=0.117
r22 30 31 25.1845 $w=1.3e-08 $l=1.08e-07 $layer=M2 $thickness=3.6e-08 $X=0.351
+ $Y=0.117 $X2=0.459 $Y2=0.117
r23 29 30 25.1845 $w=1.3e-08 $l=1.08e-07 $layer=M2 $thickness=3.6e-08 $X=0.249
+ $Y=0.117 $X2=0.351 $Y2=0.117
r24 29 16 2.68168 $w=1.3e-08 $l=1.15e-08 $layer=M2 $thickness=3.6e-08 $X=0.249
+ $Y=0.117 $X2=0.2315 $Y2=0.117
r25 10 11 1.38478 $w=1.70909e-08 $l=1.1e-08 $layer=M1 $thickness=3.6e-08
+ $X=0.232 $Y=0.117 $X2=0.243 $Y2=0.117
r26 11 26 3.01711 $w=1.55e-08 $l=1.8e-08 $layer=M1 $thickness=3.6e-08 $X=0.243
+ $Y=0.117 $X2=0.243 $Y2=0.135
r27 11 12 2.20094 $w=1.61034e-08 $l=1.45e-08 $layer=M1 $thickness=3.6e-08
+ $X=0.243 $Y=0.117 $X2=0.2575 $Y2=0.117
r28 29 11 19.5347 $a=3.24e-16 $layer=V1 $X=0.249 $Y=0.117 $X2=0.243 $Y2=0.117
r29 1 22 10.4265 $w=1.765e-08 $layer=LIG $thickness=5.2e-08 $X=0.243 $Y=0.135
+ $X2=0.243 $Y2=0.135
r30 1 26 19.3796 $a=3.24e-16 $layer=V0LIG $X=0.243 $Y=0.135 $X2=0.243 $Y2=0.135
r31 24 23 16.4967 $w=2.1e-08 $l=4.85e-08 $layer=Gate_1 $thickness=5.6e-08
+ $X=0.243 $Y=0.2025 $X2=0.243 $Y2=0.154
r32 22 23 6.6497 $w=2.04211e-08 $l=1.9e-08 $layer=Gate_1 $thickness=5.6e-08
+ $X=0.243 $Y=0.135 $X2=0.243 $Y2=0.154
r33 21 22 6.6497 $w=2.04211e-08 $l=1.9e-08 $layer=Gate_1 $thickness=5.6e-08
+ $X=0.243 $Y=0.116 $X2=0.243 $Y2=0.135
r34 20 21 16.4967 $w=2.1e-08 $l=4.85e-08 $layer=Gate_1 $thickness=5.6e-08
+ $X=0.243 $Y=0.0675 $X2=0.243 $Y2=0.116
r35 20 7 14.6259 $w=2.1e-08 $l=4.3e-08 $layer=Gate_1 $thickness=5.6e-08
+ $X=0.243 $Y=0.0675 $X2=0.243 $Y2=0.0245
.ends

.subckt PM_FAx1_ASAP7_75t_R%17 vss 2 3 1
c1 1 vss 0.00419764f $X=0.432 $Y=0.2025
r1 2 1 0.209877 $w=8.1e-08 $l=1.7e-08 $layer=P_src_drn $thickness=1e-09
+ $X=0.4146 $Y=0.2025 $X2=0.432 $Y2=0.2025
r2 3 1 0.209877 $w=8.1e-08 $l=1.7e-08 $layer=P_src_drn $thickness=1e-09
+ $X=0.4493 $Y=0.2025 $X2=0.432 $Y2=0.2025
.ends

.subckt PM_FAx1_ASAP7_75t_R%12 vss 2 3 1
c1 1 vss 0.000880988f $X=0.162 $Y=0.0675
r1 2 1 0.209877 $w=8.1e-08 $l=1.7e-08 $layer=N_src_drn $thickness=1e-09
+ $X=0.1446 $Y=0.0675 $X2=0.162 $Y2=0.0675
r2 3 1 0.209877 $w=8.1e-08 $l=1.7e-08 $layer=N_src_drn $thickness=1e-09
+ $X=0.1793 $Y=0.0675 $X2=0.162 $Y2=0.0675
.ends

.subckt PM_FAx1_ASAP7_75t_R%8 vss 11 26 27 7 9 1 8 2
c1 1 vss 0.00888218f $X=0.054 $Y=0.2025
c2 2 vss 0.00732069f $X=0.27 $Y=0.2025
c3 7 vss 0.0370586f $X=0.056 $Y=0.2025
c4 8 vss 0.00319443f $X=0.2555 $Y=0.2025
c5 9 vss 0.0211952f $X=0.0425 $Y=0.234
r1 27 25 0.0308642 $w=8.1e-08 $l=2.5e-09 $layer=P_src_drn $thickness=1e-09
+ $X=0.2873 $Y=0.2025 $X2=0.2845 $Y2=0.2025
r2 2 25 0.179012 $w=8.1e-08 $l=1.45e-08 $layer=P_src_drn $thickness=1e-09
+ $X=0.27 $Y=0.2025 $X2=0.2845 $Y2=0.2025
r3 8 2 0.179012 $w=8.1e-08 $l=1.45e-08 $layer=P_src_drn $thickness=1e-09
+ $X=0.2555 $Y=0.2025 $X2=0.27 $Y2=0.2025
r4 26 8 0.0308642 $w=8.1e-08 $l=2.5e-09 $layer=P_src_drn $thickness=1e-09
+ $X=0.2526 $Y=0.2025 $X2=0.2555 $Y2=0.2025
r5 2 21 19.3796 $a=3.24e-16 $layer=V0LISD $X=0.27 $Y=0.2025 $X2=0.271 $Y2=0.234
r6 20 21 2.09871 $w=1.3e-08 $l=9e-09 $layer=M1 $thickness=3.6e-08 $X=0.262
+ $Y=0.234 $X2=0.271 $Y2=0.234
r7 19 20 1.28254 $w=1.3e-08 $l=5.5e-09 $layer=M1 $thickness=3.6e-08 $X=0.2565
+ $Y=0.234 $X2=0.262 $Y2=0.234
r8 18 19 3.14806 $w=1.3e-08 $l=1.35e-08 $layer=M1 $thickness=3.6e-08 $X=0.243
+ $Y=0.234 $X2=0.2565 $Y2=0.234
r9 17 18 2.56509 $w=1.3e-08 $l=1.1e-08 $layer=M1 $thickness=3.6e-08 $X=0.232
+ $Y=0.234 $X2=0.243 $Y2=0.234
r10 16 17 12.8254 $w=1.3e-08 $l=5.5e-08 $layer=M1 $thickness=3.6e-08 $X=0.177
+ $Y=0.234 $X2=0.232 $Y2=0.234
r11 15 16 16.3233 $w=1.3e-08 $l=7e-08 $layer=M1 $thickness=3.6e-08 $X=0.107
+ $Y=0.234 $X2=0.177 $Y2=0.234
r12 14 15 7.11229 $w=1.3e-08 $l=3.05e-08 $layer=M1 $thickness=3.6e-08 $X=0.0765
+ $Y=0.234 $X2=0.107 $Y2=0.234
r13 13 14 3.61444 $w=1.3e-08 $l=1.55e-08 $layer=M1 $thickness=3.6e-08 $X=0.061
+ $Y=0.234 $X2=0.0765 $Y2=0.234
r14 12 13 2.09871 $w=1.3e-08 $l=9e-09 $layer=M1 $thickness=3.6e-08 $X=0.052
+ $Y=0.234 $X2=0.061 $Y2=0.234
r15 9 12 2.2153 $w=1.3e-08 $l=9.5e-09 $layer=M1 $thickness=3.6e-08 $X=0.0425
+ $Y=0.234 $X2=0.052 $Y2=0.234
r16 1 12 19.3796 $a=3.24e-16 $layer=V0LISD $X=0.054 $Y=0.2025 $X2=0.052
+ $Y2=0.234
r17 11 10 0.0308642 $w=8.1e-08 $l=2.5e-09 $layer=P_src_drn $thickness=1e-09
+ $X=0.0713 $Y=0.2025 $X2=0.0685 $Y2=0.2025
r18 7 10 0.154321 $w=8.1e-08 $l=1.25e-08 $layer=P_src_drn $thickness=1e-09
+ $X=0.056 $Y=0.2025 $X2=0.0685 $Y2=0.2025
r19 1 7 1e-05 $l=2e-09 $X=0.054 $Y=0.2025 $X2=0.056 $Y2=0.2025
.ends

* End of included file FAx1_ASAP7_75t_R.pex.sp.pex

*
.subckt FAx1_ASAP7_75t_CUSTOM_4_25_0_7 VSS VDD A B CI CON SN
*
* VSS VSS
* VDD VDD
* A A
* B B
* CI CI
* CON CON
* SN SN
*
*

M0 VSS N_M0_g N_M0_s VSS nmos_rvt L=2e-08 W=8.1e-08 nfin=3 $X=0.071 $Y=0.027
M1 N_M1_d N_M1_g VSS VSS nmos_rvt L=2e-08 W=8.1e-08 nfin=3 $X=0.125 $Y=0.027
M2 N_M2_d N_M2_g N_M2_s VSS nmos_rvt L=2e-08 W=8.1e-08 nfin=3 $X=0.179 $Y=0.027
M3 N_M3_d N_M3_g N_M3_s VSS nmos_rvt L=2e-08 W=8.1e-08 nfin=3 $X=0.233 $Y=0.027
M4 VSS N_M4_g N_M4_s VSS nmos_rvt L=2e-08 W=8.1e-08 nfin=3 $X=0.287 $Y=0.027
M5 N_M5_d N_M5_g VSS VSS nmos_rvt L=2e-08 W=8.1e-08 nfin=3 $X=0.341 $Y=0.027
M6 N_M6_d N_M6_g N_M6_s VSS nmos_rvt L=2e-08 W=8.1e-08 nfin=3 $X=0.395 $Y=0.027
M7 N_M7_d N_M7_g N_M7_s VSS nmos_rvt L=2e-08 W=8.1e-08 nfin=3 $X=0.449 $Y=0.027
M8 N_M8_d N_M8_g N_M8_s VSS nmos_rvt L=2e-08 W=8.1e-08 nfin=3 $X=0.503 $Y=0.027
M9 VSS N_M9_g N_M9_s VSS nmos_rvt L=2e-08 W=8.1e-08 nfin=3 $X=0.557 $Y=0.027
M10 N_M10_d N_M10_g VSS VSS nmos_rvt L=2e-08 W=8.1e-08 nfin=3 $X=0.611 $Y=0.027
M11 VSS N_M11_g N_M11_s VSS nmos_rvt L=2e-08 W=8.1e-08 nfin=3 $X=0.665 $Y=0.027
M12 VDD N_M12_g N_M12_s VDD pmos_rvt L=2e-08 W=8.1e-08 nfin=3 $X=0.071 $Y=0.162
M13 N_M13_d N_M13_g VDD VDD pmos_rvt L=2e-08 W=8.1e-08 nfin=3 $X=0.125 $Y=0.162
M14 N_M14_d N_M14_g N_M14_s VDD pmos_rvt L=2e-08 W=8.1e-08 nfin=3 $X=0.179
+ $Y=0.162
M15 N_M15_d N_M15_g N_M15_s VDD pmos_rvt L=2e-08 W=8.1e-08 nfin=3 $X=0.233
+ $Y=0.162
M16 VDD N_M16_g N_M16_s VDD pmos_rvt L=2e-08 W=8.1e-08 nfin=3 $X=0.287 $Y=0.162
M17 N_M17_d N_M17_g VDD VDD pmos_rvt L=2e-08 W=8.1e-08 nfin=3 $X=0.341 $Y=0.162
M18 N_M18_d N_M18_g N_M18_s VDD pmos_rvt L=2e-08 W=8.1e-08 nfin=3 $X=0.395
+ $Y=0.162
M19 N_M19_d N_M19_g N_M19_s VDD pmos_rvt L=2e-08 W=8.1e-08 nfin=3 $X=0.449
+ $Y=0.162
M20 N_M20_d N_M20_g N_M20_s VDD pmos_rvt L=2e-08 W=8.1e-08 nfin=3 $X=0.503
+ $Y=0.162
M21 VDD N_M21_g N_M21_s VDD pmos_rvt L=2e-08 W=8.1e-08 nfin=3 $X=0.557 $Y=0.162
M22 N_M22_d N_M22_g VDD VDD pmos_rvt L=2e-08 W=8.1e-08 nfin=3 $X=0.611 $Y=0.162
M23 VDD N_M23_g N_M23_s VDD pmos_rvt L=2e-08 W=8.1e-08 nfin=3 $X=0.665 $Y=0.162

* .include "FAx1_ASAP7_75t_R.pex.sp.pxi"

* Start of included file FAx1_ASAP7_75t_R.pex.sp.pxi
x_PM_FAx1_ASAP7_75t_R%7 vss N_M0_s N_M3_d N_M4_s N_7_7 N_7_1 N_7_8 N_7_9 N_7_2
+ PM_FAx1_ASAP7_75t_R%7
cc_1 N_7_7 N_A_1 0.00127994f $X=0.056 $Y=0.0675
cc_2 N_7_7 N_A_14 0.000413485f $X=0.056 $Y=0.0675
cc_3 N_7_7 N_A_8 0.000490685f $X=0.056 $Y=0.0675
cc_4 N_7_1 N_A_7 0.00110978f $X=0.054 $Y=0.0675
cc_5 N_7_7 N_A_7 0.0339325f $X=0.056 $Y=0.0675
cc_6 N_7_8 N_B_13 0.000144657f $X=0.2555 $Y=0.0675
cc_7 N_7_8 N_B_2 0.000946289f $X=0.2555 $Y=0.0675
cc_8 N_7_8 N_B_8 0.0341626f $X=0.2555 $Y=0.0675
cc_9 N_7_8 N_CI_1 0.000791771f $X=0.2555 $Y=0.0675
cc_10 N_7_8 N_CI_7 0.0343857f $X=0.2555 $Y=0.0675
cc_11 N_7_9 N_CON_12 0.00115467f $X=0.0425 $Y=0.036
cc_12 N_7_9 N_CON_17 0.000399188f $X=0.0425 $Y=0.036
cc_13 N_7_9 N_CON_3 0.00041565f $X=0.0425 $Y=0.036
cc_14 N_7_8 N_CON_10 0.00122233f $X=0.2555 $Y=0.0675
cc_15 N_7_9 N_CON_21 0.00106948f $X=0.0425 $Y=0.036
cc_16 N_7_2 N_CON_3 0.00331175f $X=0.27 $Y=0.0675
cc_17 N_7_9 N_CON_18 0.00980669f $X=0.0425 $Y=0.036
x_PM_FAx1_ASAP7_75t_R%13 vss N_M5_d N_M6_s N_13_1 PM_FAx1_ASAP7_75t_R%13
cc_18 N_13_1 N_A_9 0.0127884f $X=0.378 $Y=0.0675
cc_19 N_13_1 N_B_9 0.0174237f $X=0.378 $Y=0.0675
x_PM_FAx1_ASAP7_75t_R%14 vss N_M6_d N_M7_s N_14_1 PM_FAx1_ASAP7_75t_R%14
cc_20 N_14_1 N_A_9 0.0127411f $X=0.432 $Y=0.0675
cc_21 N_14_1 N_CI_8 0.017393f $X=0.432 $Y=0.0675
x_PM_FAx1_ASAP7_75t_R%15 vss N_M13_d N_M14_s N_15_1 PM_FAx1_ASAP7_75t_R%15
cc_22 N_15_1 N_A_8 0.0168739f $X=0.162 $Y=0.2025
cc_23 N_15_1 N_B_7 0.0167634f $X=0.162 $Y=0.2025
x_PM_FAx1_ASAP7_75t_R%16 vss N_M17_d N_M18_s N_16_1 PM_FAx1_ASAP7_75t_R%16
cc_24 N_16_1 N_A_9 0.0127619f $X=0.378 $Y=0.2025
cc_25 N_16_1 N_B_9 0.0173871f $X=0.378 $Y=0.2025
x_PM_FAx1_ASAP7_75t_R%10 vss N_M10_d N_M11_s N_M8_d N_M9_s N_10_8 N_10_2 N_10_7
+ N_10_9 N_10_1 PM_FAx1_ASAP7_75t_R%10
cc_26 N_10_8 N_A_16 0.000527903f $X=0.6335 $Y=0.0675
cc_27 N_10_8 N_A_3 0.000945671f $X=0.6335 $Y=0.0675
cc_28 N_10_2 N_A_10 0.000758572f $X=0.648 $Y=0.0675
cc_29 N_10_8 N_A_10 0.0326107f $X=0.6335 $Y=0.0675
cc_30 N_10_8 N_B_14 0.000620015f $X=0.6335 $Y=0.0675
cc_31 N_10_8 N_B_3 0.000917282f $X=0.6335 $Y=0.0675
cc_32 N_10_2 N_B_10 0.000815768f $X=0.648 $Y=0.0675
cc_33 N_10_8 N_B_10 0.0326624f $X=0.6335 $Y=0.0675
cc_34 N_10_7 N_CI_3 0.000859202f $X=0.5255 $Y=0.0675
cc_35 N_10_7 N_CI_14 0.000229934f $X=0.5255 $Y=0.0675
cc_36 N_10_7 N_CI_13 0.000294671f $X=0.5255 $Y=0.0675
cc_37 N_10_9 N_CI_14 0.000589114f $X=0.6345 $Y=0.036
cc_38 N_10_1 N_CI_9 0.000789782f $X=0.54 $Y=0.0675
cc_39 N_10_7 N_CI_9 0.0324105f $X=0.5255 $Y=0.0675
cc_40 N_10_7 N_CON_1 0.000773852f $X=0.5255 $Y=0.0675
cc_41 N_10_7 N_CON_15 0.000243213f $X=0.5255 $Y=0.0675
cc_42 N_10_7 N_CON_21 0.000268526f $X=0.5255 $Y=0.0675
cc_43 N_10_7 N_CON_16 0.000290783f $X=0.5255 $Y=0.0675
cc_44 N_10_9 N_CON_15 0.000460713f $X=0.6345 $Y=0.036
cc_45 N_10_1 N_CON_9 0.00120029f $X=0.54 $Y=0.0675
cc_46 N_10_9 N_CON_16 0.00180489f $X=0.6345 $Y=0.036
cc_47 N_10_7 N_CON_9 0.0326143f $X=0.5255 $Y=0.0675
cc_48 N_10_9 N_SN_11 0.00102645f $X=0.6345 $Y=0.036
cc_49 N_10_1 N_SN_1 0.00401052f $X=0.54 $Y=0.0675
x_PM_FAx1_ASAP7_75t_R%B vss B N_M11_g N_M23_g N_M4_g N_M16_g N_M5_g N_M17_g
+ N_M2_g N_M14_g N_B_15 N_B_12 N_B_11 N_B_2 N_B_1 N_B_14 N_B_13 N_B_3 N_B_10
+ N_B_7 N_B_9 N_B_8 PM_FAx1_ASAP7_75t_R%B
cc_50 N_B_15 N_A_1 7.26442e-20 $X=0.6465 $Y=0.153
cc_51 N_B_12 N_A_17 8.66183e-20 $X=0.189 $Y=0.1465
cc_52 N_B_15 N_A_13 0.000661313f $X=0.6465 $Y=0.153
cc_53 N_B_11 N_A_17 0.000653468f $X=0.1695 $Y=0.153
cc_54 N_B_15 N_A_12 0.000523766f $X=0.6465 $Y=0.153
cc_55 N_B_2 N_A_2 0.00226207f $X=0.2875 $Y=0.135
cc_56 N_B_1 N_A_1 0.00212021f $X=0.189 $Y=0.135
cc_57 N_B_14 N_A_16 0.00278432f $X=0.675 $Y=0.1235
cc_58 N_B_13 N_A_17 0.000717379f $X=0.297 $Y=0.1375
cc_59 N_B_14 N_A_13 0.000310063f $X=0.675 $Y=0.1235
cc_60 N_B_15 N_A_15 0.000637562f $X=0.6465 $Y=0.153
cc_61 N_B_3 N_A_3 0.0018451f $X=0.675 $Y=0.135
cc_62 N_B_10 N_A_10 0.00333185f $X=0.675 $Y=0.0245
cc_63 N_B_7 N_A_8 0.00646047f $X=0.189 $Y=0.135
cc_64 N_B_9 N_A_9 0.00915503f $X=0.351 $Y=0.135
cc_65 N_B_15 N_A_17 0.0339544f $X=0.6465 $Y=0.153
x_PM_FAx1_ASAP7_75t_R%CON vss CON N_M8_g N_M20_g N_M2_d N_M3_s N_M14_d N_M15_s
+ N_CON_17 N_CON_3 N_CON_18 N_CON_12 N_CON_4 N_CON_13 N_CON_20 N_CON_21
+ N_CON_19 N_CON_10 N_CON_11 N_CON_14 N_CON_1 N_CON_16 N_CON_15 N_CON_9
+ PM_FAx1_ASAP7_75t_R%CON
cc_66 N_CON_17 N_A_2 7.75492e-20 $X=0.133 $Y=0.099
cc_67 N_CON_17 N_A_3 0.000111716f $X=0.133 $Y=0.099
cc_68 N_CON_17 N_A_11 0.000550459f $X=0.133 $Y=0.099
cc_69 N_CON_3 N_A_8 0.00013963f $X=0.216 $Y=0.0675
cc_70 N_CON_18 N_A_1 0.000155396f $X=0.1465 $Y=0.081
cc_71 N_CON_12 N_A_14 0.000431926f $X=0.133 $Y=0.081
cc_72 N_CON_4 N_A_8 0.000197188f $X=0.216 $Y=0.2025
cc_73 N_CON_17 N_A_1 0.00129819f $X=0.133 $Y=0.099
cc_74 N_CON_13 N_A_11 0.000608153f $X=0.133 $Y=0.1935
cc_75 N_CON_20 N_A_17 0.000644736f $X=0.513 $Y=0.117
cc_76 N_CON_21 N_A_15 0.00149683f $X=0.2592 $Y=0.081
cc_77 N_CON_19 N_A_17 0.00314874f $X=0.1545 $Y=0.198
cc_78 N_CON_17 N_A_14 0.00409157f $X=0.133 $Y=0.099
cc_79 N_CON_10 N_B_15 9.07649e-20 $X=0.2015 $Y=0.0675
cc_80 N_CON_10 N_B_13 9.25974e-20 $X=0.2015 $Y=0.0675
cc_81 N_CON_10 N_B_12 9.41605e-20 $X=0.2015 $Y=0.0675
cc_82 N_CON_18 N_B_2 0.000140063f $X=0.1465 $Y=0.081
cc_83 N_CON_3 N_B_12 0.000182517f $X=0.216 $Y=0.0675
cc_84 N_CON_4 N_B_12 0.000230098f $X=0.216 $Y=0.2025
cc_85 N_CON_18 N_B_13 0.000313462f $X=0.1465 $Y=0.081
cc_86 N_CON_20 N_B_15 0.000354057f $X=0.513 $Y=0.117
cc_87 N_CON_11 N_B_7 0.0154476f $X=0.2015 $Y=0.2025
cc_88 N_CON_19 N_B_11 0.000540878f $X=0.1545 $Y=0.198
cc_89 N_CON_3 N_B_1 0.000933783f $X=0.216 $Y=0.0675
cc_90 N_CON_3 N_B_7 0.000979862f $X=0.216 $Y=0.0675
cc_91 N_CON_4 N_B_7 0.00109344f $X=0.216 $Y=0.2025
cc_92 N_CON_11 N_B_1 0.00184297f $X=0.2015 $Y=0.2025
cc_93 N_CON_19 N_B_12 0.00231604f $X=0.1545 $Y=0.198
cc_94 N_CON_18 N_B_12 0.00237115f $X=0.1465 $Y=0.081
cc_95 N_CON_17 N_B_11 0.00276151f $X=0.133 $Y=0.099
cc_96 N_CON_21 N_B_15 0.00384339f $X=0.2592 $Y=0.081
cc_97 N_CON_10 N_B_7 0.0546969f $X=0.2015 $Y=0.0675
cc_98 N_CON_11 N_CI_14 0.000190001f $X=0.2015 $Y=0.2025
cc_99 N_CON_3 N_CI_10 0.000262186f $X=0.216 $Y=0.0675
cc_100 N_CON_19 N_CI_11 0.000296813f $X=0.1545 $Y=0.198
cc_101 N_CON_14 N_CI_15 0.00031887f $X=0.5095 $Y=0.1055
cc_102 N_CON_1 N_CI_3 0.000917194f $X=0.513 $Y=0.135
cc_103 N_CON_21 N_CI_13 0.000395644f $X=0.2592 $Y=0.081
cc_104 N_CON_10 N_CI_7 0.0152098f $X=0.2015 $Y=0.0675
cc_105 N_CON_16 N_CI_13 0.000471154f $X=0.5355 $Y=0.081
cc_106 N_CON_21 N_CI_15 0.000517133f $X=0.2592 $Y=0.081
cc_107 N_CON_15 N_CI_16 0.000585316f $X=0.524 $Y=0.099
cc_108 N_CON_3 N_CI_1 0.000648519f $X=0.216 $Y=0.0675
cc_109 N_CON_18 N_CI_11 0.00383807f $X=0.1465 $Y=0.081
cc_110 N_CON_3 N_CI_7 0.000738327f $X=0.216 $Y=0.0675
cc_111 N_CON_4 N_CI_7 0.00073876f $X=0.216 $Y=0.2025
cc_112 N_CON_18 N_CI_10 0.00077263f $X=0.1465 $Y=0.081
cc_113 N_CON_18 N_CI_12 0.000773274f $X=0.1465 $Y=0.081
cc_114 N_CON_1 N_CI_2 0.00247519f $X=0.513 $Y=0.135
cc_115 N_CON_10 N_CI_1 0.00137535f $X=0.2015 $Y=0.0675
cc_116 N_CON_9 N_CI_9 0.00166538f $X=0.513 $Y=0.0245
cc_117 N_CON_15 N_CI_13 0.00169598f $X=0.524 $Y=0.099
cc_118 N_CON_20 N_CI_15 0.00253314f $X=0.513 $Y=0.117
cc_119 N_CON_9 N_CI_8 0.00489461f $X=0.513 $Y=0.0245
cc_120 N_CON_21 N_CI_16 0.0230761f $X=0.2592 $Y=0.081
cc_121 N_CON_11 N_CI_7 0.0535725f $X=0.2015 $Y=0.2025
x_PM_FAx1_ASAP7_75t_R%SN vss SN N_M7_d N_M8_s N_M19_d N_M20_s N_SN_15 N_SN_14
+ N_SN_13 N_SN_8 N_SN_16 N_SN_7 N_SN_1 N_SN_2 N_SN_11 N_SN_12
+ PM_FAx1_ASAP7_75t_R%SN
cc_122 N_SN_15 N_A_17 0.000214892f $X=0.3625 $Y=0.234
cc_123 N_SN_15 N_A_9 0.000594552f $X=0.3625 $Y=0.234
cc_124 N_SN_15 N_A_2 0.00028454f $X=0.3625 $Y=0.234
cc_125 N_SN_14 N_A_15 0.000456464f $X=0.4725 $Y=0.036
cc_126 N_SN_13 N_A_2 0.000471332f $X=0.333 $Y=0.0565
cc_127 N_SN_13 N_A_17 0.000596347f $X=0.333 $Y=0.0565
cc_128 N_SN_8 N_A_9 0.0021532f $X=0.4715 $Y=0.2025
cc_129 N_SN_16 N_A_17 0.00235373f $X=0.486 $Y=0.2025
cc_130 N_SN_13 N_A_15 0.00294034f $X=0.333 $Y=0.0565
cc_131 N_SN_15 N_A_12 0.00506641f $X=0.3625 $Y=0.234
cc_132 N_SN_13 N_B_9 0.000149668f $X=0.333 $Y=0.0565
cc_133 N_SN_13 N_B_15 0.000168802f $X=0.333 $Y=0.0565
cc_134 N_SN_13 N_B_2 0.00131405f $X=0.333 $Y=0.0565
cc_135 N_SN_16 N_B_15 0.000928892f $X=0.486 $Y=0.2025
cc_136 N_SN_13 N_B_13 0.00569387f $X=0.333 $Y=0.0565
cc_137 N_SN_7 N_CI_15 0.00129594f $X=0.4715 $Y=0.0675
cc_138 N_SN_8 N_CI_8 0.0147945f $X=0.4715 $Y=0.2025
cc_139 N_SN_16 N_CI_15 0.000434915f $X=0.486 $Y=0.2025
cc_140 N_SN_14 N_CI_15 0.000467171f $X=0.4725 $Y=0.036
cc_141 N_SN_1 N_CI_2 0.000680453f $X=0.486 $Y=0.0675
cc_142 N_SN_2 N_CI_8 0.00108284f $X=0.486 $Y=0.2025
cc_143 N_SN_1 N_CI_8 0.00122825f $X=0.486 $Y=0.0675
cc_144 N_SN_1 N_CI_15 0.00139199f $X=0.486 $Y=0.0675
cc_145 N_SN_8 N_CI_2 0.00175776f $X=0.4715 $Y=0.2025
cc_146 N_SN_13 N_CI_16 0.00199116f $X=0.333 $Y=0.0565
cc_147 N_SN_7 N_CI_8 0.0533262f $X=0.4715 $Y=0.0675
cc_148 N_SN_7 N_CON_20 0.000459291f $X=0.4715 $Y=0.0675
cc_149 N_SN_7 N_CON_19 0.000214732f $X=0.4715 $Y=0.0675
cc_150 N_SN_7 N_CON_18 0.000229207f $X=0.4715 $Y=0.0675
cc_151 N_SN_7 N_CON_15 0.000291197f $X=0.4715 $Y=0.0675
cc_152 N_SN_8 N_CON_9 0.0145642f $X=0.4715 $Y=0.2025
cc_153 N_SN_11 N_CON_14 0.000402749f $X=0.486 $Y=0.054
cc_154 N_SN_1 N_CON_20 0.000487285f $X=0.486 $Y=0.0675
cc_155 N_SN_1 N_CON_1 0.000487503f $X=0.486 $Y=0.0675
cc_156 N_SN_2 N_CON_9 0.000773872f $X=0.486 $Y=0.2025
cc_157 N_SN_1 N_CON_9 0.0010277f $X=0.486 $Y=0.0675
cc_158 N_SN_14 N_CON_21 0.00113526f $X=0.4725 $Y=0.036
cc_159 N_SN_7 N_CON_1 0.00131176f $X=0.4715 $Y=0.0675
cc_160 N_SN_11 N_CON_15 0.0017583f $X=0.486 $Y=0.054
cc_161 N_SN_13 N_CON_18 0.0019777f $X=0.333 $Y=0.0565
cc_162 N_SN_13 N_CON_21 0.00217242f $X=0.333 $Y=0.0565
cc_163 N_SN_7 N_CON_9 0.0512528f $X=0.4715 $Y=0.0675
x_PM_FAx1_ASAP7_75t_R%11 vss N_M20_d N_M21_s N_M22_d N_M23_s N_11_8 N_11_9
+ N_11_2 N_11_7 N_11_1 PM_FAx1_ASAP7_75t_R%11
cc_164 N_11_8 N_A_13 0.00051796f $X=0.6335 $Y=0.2025
cc_165 N_11_8 N_A_3 0.000839106f $X=0.6335 $Y=0.2025
cc_166 N_11_8 N_A_16 0.000362754f $X=0.6335 $Y=0.2025
cc_167 N_11_9 N_A_17 0.000791691f $X=0.538 $Y=0.234
cc_168 N_11_2 N_A_10 0.00106619f $X=0.648 $Y=0.2025
cc_169 N_11_9 N_A_13 0.00365286f $X=0.538 $Y=0.234
cc_170 N_11_8 N_A_10 0.0327792f $X=0.6335 $Y=0.2025
cc_171 N_11_8 N_B_3 0.000853631f $X=0.6335 $Y=0.2025
cc_172 N_11_8 N_B_14 0.000355455f $X=0.6335 $Y=0.2025
cc_173 N_11_8 N_B_15 0.000443667f $X=0.6335 $Y=0.2025
cc_174 N_11_2 N_B_10 0.000856193f $X=0.648 $Y=0.2025
cc_175 N_11_8 N_B_10 0.0326508f $X=0.6335 $Y=0.2025
cc_176 N_11_7 N_CI_13 0.000492253f $X=0.5255 $Y=0.2025
cc_177 N_11_7 N_CI_3 0.000921685f $X=0.5255 $Y=0.2025
cc_178 N_11_1 N_CI_9 0.000768367f $X=0.54 $Y=0.2025
cc_179 N_11_7 N_CI_9 0.0325408f $X=0.5255 $Y=0.2025
cc_180 N_11_7 N_CON_1 0.000847306f $X=0.5255 $Y=0.2025
cc_181 N_11_1 N_CON_9 0.000737872f $X=0.54 $Y=0.2025
cc_182 N_11_7 N_CON_9 0.0326007f $X=0.5255 $Y=0.2025
cc_183 N_11_7 N_SN_8 0.000566497f $X=0.5255 $Y=0.2025
cc_184 N_11_9 N_SN_12 0.00107531f $X=0.538 $Y=0.234
cc_185 N_11_1 N_SN_2 0.00411627f $X=0.54 $Y=0.2025
x_PM_FAx1_ASAP7_75t_R%A vss A N_M0_g N_M12_g N_M1_g N_M13_g N_M6_g N_M18_g
+ N_M10_g N_M22_g N_A_1 N_A_17 N_A_13 N_A_12 N_A_2 N_A_16 N_A_15 N_A_3 N_A_10
+ N_A_8 N_A_9 N_A_11 N_A_14 N_A_7 PM_FAx1_ASAP7_75t_R%A
x_PM_FAx1_ASAP7_75t_R%CI vss CI N_M3_g N_M15_g N_M7_g N_M19_g N_M9_g N_M21_g
+ N_CI_8 N_CI_13 N_CI_15 N_CI_3 N_CI_14 N_CI_2 N_CI_16 N_CI_9 N_CI_11 N_CI_12
+ N_CI_10 N_CI_1 N_CI_7 PM_FAx1_ASAP7_75t_R%CI
cc_186 N_CI_8 N_A_12 0.000109774f $X=0.459 $Y=0.135
cc_187 N_CI_13 N_A_13 0.000405603f $X=0.567 $Y=0.117
cc_188 N_CI_15 N_A_12 0.000150293f $X=0.459 $Y=0.1145
cc_189 N_CI_15 N_A_15 0.00207314f $X=0.459 $Y=0.1145
cc_190 N_CI_13 N_A_16 0.00120539f $X=0.567 $Y=0.117
cc_191 N_CI_3 N_A_3 0.00144537f $X=0.567 $Y=0.135
cc_192 N_CI_14 N_A_3 0.000391848f $X=0.579 $Y=0.117
cc_193 N_CI_2 N_A_2 0.00238529f $X=0.459 $Y=0.135
cc_194 N_CI_16 N_A_17 0.00117122f $X=0.2315 $Y=0.117
cc_195 N_CI_16 N_A_15 0.00134479f $X=0.2315 $Y=0.117
cc_196 N_CI_14 N_A_16 0.00153413f $X=0.579 $Y=0.117
cc_197 N_CI_9 N_A_10 0.00316377f $X=0.567 $Y=0.135
cc_198 N_CI_8 N_A_9 0.00950716f $X=0.459 $Y=0.135
cc_199 N_CI_16 N_B_14 7.17679e-20 $X=0.2315 $Y=0.117
cc_200 N_CI_14 N_B_15 0.000130246f $X=0.579 $Y=0.117
cc_201 N_CI_11 N_B_11 0.000134839f $X=0.243 $Y=0.117
cc_202 N_CI_15 N_B_15 0.000641096f $X=0.459 $Y=0.1145
cc_203 N_CI_13 N_B_15 0.000754615f $X=0.567 $Y=0.117
cc_204 N_CI_12 N_B_2 0.000353854f $X=0.2575 $Y=0.117
cc_205 N_CI_11 N_B_12 0.000365829f $X=0.243 $Y=0.117
cc_206 N_CI_10 N_B_1 0.000397981f $X=0.232 $Y=0.117
cc_207 N_CI_16 N_B_13 0.000443413f $X=0.2315 $Y=0.117
cc_208 N_CI_1 N_B_2 0.00045482f $X=0.243 $Y=0.135
cc_209 N_CI_11 N_B_15 0.000549729f $X=0.243 $Y=0.117
cc_210 N_CI_1 N_B_1 0.00210738f $X=0.243 $Y=0.135
cc_211 N_CI_10 N_B_12 0.000965957f $X=0.232 $Y=0.117
cc_212 N_CI_11 N_B_13 0.00138069f $X=0.243 $Y=0.117
cc_213 N_CI_12 N_B_13 0.00142156f $X=0.2575 $Y=0.117
cc_214 N_CI_7 N_B_8 0.0016681f $X=0.243 $Y=0.0245
cc_215 N_CI_7 N_B_7 0.00494292f $X=0.243 $Y=0.0245
cc_216 N_CI_16 N_B_15 0.025639f $X=0.2315 $Y=0.117
x_PM_FAx1_ASAP7_75t_R%17 vss N_M18_d N_M19_s N_17_1 PM_FAx1_ASAP7_75t_R%17
cc_217 N_17_1 N_A_9 0.0127911f $X=0.432 $Y=0.2025
cc_218 N_17_1 N_CI_8 0.0174085f $X=0.432 $Y=0.2025
x_PM_FAx1_ASAP7_75t_R%12 vss N_M1_d N_M2_s N_12_1 PM_FAx1_ASAP7_75t_R%12
cc_219 N_12_1 N_A_8 0.0168451f $X=0.162 $Y=0.0675
cc_220 N_12_1 N_B_7 0.0167498f $X=0.162 $Y=0.0675
x_PM_FAx1_ASAP7_75t_R%8 vss N_M12_s N_M15_d N_M16_s N_8_7 N_8_9 N_8_1 N_8_8
+ N_8_2 PM_FAx1_ASAP7_75t_R%8
cc_221 N_8_7 N_A_1 0.00114321f $X=0.056 $Y=0.2025
cc_222 N_8_7 N_A_11 0.000632968f $X=0.056 $Y=0.2025
cc_223 N_8_7 N_A_14 0.000366171f $X=0.056 $Y=0.2025
cc_224 N_8_9 N_A_11 0.00153005f $X=0.0425 $Y=0.234
cc_225 N_8_1 N_A_7 0.00163435f $X=0.054 $Y=0.2025
cc_226 N_8_9 N_A_17 0.00418678f $X=0.0425 $Y=0.234
cc_227 N_8_7 N_A_7 0.033878f $X=0.056 $Y=0.2025
cc_228 N_8_8 N_B_13 0.000518234f $X=0.2555 $Y=0.2025
cc_229 N_8_8 N_B_2 0.000952425f $X=0.2555 $Y=0.2025
cc_230 N_8_8 N_B_12 0.000390846f $X=0.2555 $Y=0.2025
cc_231 N_8_2 N_B_8 0.00090503f $X=0.27 $Y=0.2025
cc_232 N_8_8 N_B_8 0.0334453f $X=0.2555 $Y=0.2025
cc_233 N_8_8 N_CI_1 0.000862831f $X=0.2555 $Y=0.2025
cc_234 N_8_8 N_CI_7 0.0343396f $X=0.2555 $Y=0.2025
cc_235 N_8_9 N_CON_4 0.000892989f $X=0.0425 $Y=0.234
cc_236 N_8_9 N_CON_11 0.00119074f $X=0.0425 $Y=0.234
cc_237 N_8_9 N_CON_13 0.000989322f $X=0.0425 $Y=0.234
cc_238 N_8_2 N_CON_4 0.0028663f $X=0.27 $Y=0.2025
cc_239 N_8_9 N_CON_19 0.00792357f $X=0.0425 $Y=0.234

* End of included file FAx1_ASAP7_75t_R.pex.sp.pxi
.ends

.subckt PM_HAxp5_ASAP7_75t_R%8 vss 2 3 1
c1 1 vss 0.000789803f $X=0.108 $Y=0.0675
r1 2 1 0.209877 $w=8.1e-08 $l=1.7e-08 $layer=N_src_drn $thickness=1e-09
+ $X=0.0906 $Y=0.0675 $X2=0.108 $Y2=0.0675
r2 3 1 0.209877 $w=8.1e-08 $l=1.7e-08 $layer=N_src_drn $thickness=1e-09
+ $X=0.1253 $Y=0.0675 $X2=0.108 $Y2=0.0675
.ends

.subckt PM_HAxp5_ASAP7_75t_R%B vss 22 8 14 28 32 5 1 6 7 4 3
c1 1 vss 0.0184144f $X=0.1255 $Y=0.135
c2 3 vss 0.0435422f $X=0.135 $Y=0.0245
c3 4 vss 0.110014f $X=0.297 $Y=0.135
c4 5 vss 0.00191356f $X=0.135 $Y=0.072
c5 6 vss 0.00178791f $X=0.135 $Y=0.198
c6 7 vss 0.00345752f $X=0.135 $Y=0.1265
r1 6 25 6.16517 $w=1.44286e-08 $l=3.15e-08 $layer=M1 $thickness=3.6e-08
+ $X=0.135 $Y=0.198 $X2=0.135 $Y2=0.1665
r2 5 24 6.16517 $w=1.44286e-08 $l=3.15e-08 $layer=M1 $thickness=3.6e-08
+ $X=0.135 $Y=0.072 $X2=0.135 $Y2=0.1035
r3 32 31 14.6259 $w=2.1e-08 $l=4.3e-08 $layer=Gate_1 $thickness=5.6e-08
+ $X=0.297 $Y=0.2025 $X2=0.297 $Y2=0.1595
r4 30 31 3.23131 $w=2.1e-08 $l=9.5e-09 $layer=Gate_1 $thickness=5.6e-08
+ $X=0.297 $Y=0.15 $X2=0.297 $Y2=0.1595
r5 28 29 14.6259 $w=2.1e-08 $l=4.3e-08 $layer=Gate_1 $thickness=5.6e-08
+ $X=0.297 $Y=0.0675 $X2=0.297 $Y2=0.1105
r6 26 29 3.23131 $w=2.1e-08 $l=9.5e-09 $layer=Gate_1 $thickness=5.6e-08
+ $X=0.297 $Y=0.12 $X2=0.297 $Y2=0.1105
r7 4 20 7.58422 $w=1.77778e-08 $layer=LIG $thickness=5.15556e-08 $X=0.297
+ $Y=0.135 $X2=0.297 $Y2=0.135
r8 4 26 5.23813 $w=2.04667e-08 $l=1.5e-08 $layer=Gate_1 $thickness=5.6e-08
+ $X=0.297 $Y=0.135 $X2=0.297 $Y2=0.12
r9 4 30 5.23813 $w=2.04667e-08 $l=1.5e-08 $layer=Gate_1 $thickness=5.6e-08
+ $X=0.297 $Y=0.135 $X2=0.297 $Y2=0.15
r10 23 25 5.36336 $w=1.3e-08 $l=2.3e-08 $layer=M1 $thickness=3.6e-08 $X=0.135
+ $Y=0.1435 $X2=0.135 $Y2=0.1665
r11 22 23 1.98211 $w=1.3e-08 $l=8.5e-09 $layer=M1 $thickness=3.6e-08 $X=0.136
+ $Y=0.135 $X2=0.135 $Y2=0.1435
r12 22 7 1.98211 $w=1.3e-08 $l=8.5e-09 $layer=M1 $thickness=3.6e-08 $X=0.136
+ $Y=0.135 $X2=0.135 $Y2=0.1265
r13 7 24 5.36336 $w=1.3e-08 $l=2.3e-08 $layer=M1 $thickness=3.6e-08 $X=0.135
+ $Y=0.1265 $X2=0.135 $Y2=0.1035
r14 19 20 170.233 $w=1.01272e-08 $l=8.1e-08 $layer=LIG $thickness=4.8e-08
+ $X=0.216 $Y=0.135 $X2=0.297 $Y2=0.135
r15 17 19 165.742 $w=9.34685e-09 $l=7.15e-08 $layer=LIG $thickness=4.8e-08
+ $X=0.1445 $Y=0.135 $X2=0.216 $Y2=0.135
r16 16 17 4.49071 $w=1.6e-08 $l=9.5e-09 $layer=LIG $thickness=4.8e-08 $X=0.135
+ $Y=0.135 $X2=0.1445 $Y2=0.135
r17 22 16 28.9687 $a=2.88e-16 $layer=V0LIG $X=0.136 $Y=0.135 $X2=0.135 $Y2=0.135
r18 1 16 4.49071 $w=1.6e-08 $l=9.5e-09 $layer=LIG $thickness=4.8e-08 $X=0.1255
+ $Y=0.135 $X2=0.135 $Y2=0.135
r19 14 13 14.6259 $w=2.1e-08 $l=4.3e-08 $layer=Gate_1 $thickness=5.6e-08
+ $X=0.135 $Y=0.216 $X2=0.135 $Y2=0.173
r20 12 13 7.82318 $w=2.1e-08 $l=2.3e-08 $layer=Gate_1 $thickness=5.6e-08
+ $X=0.135 $Y=0.15 $X2=0.135 $Y2=0.173
r21 11 12 5.23813 $w=2.04667e-08 $l=1.5e-08 $layer=Gate_1 $thickness=5.6e-08
+ $X=0.135 $Y=0.135 $X2=0.135 $Y2=0.15
r22 11 17 3.09351 $w=1.97647e-08 $l=9.5e-09 $layer=Gate_1
+ $thickness=5.55294e-08 $X=0.135 $Y=0.135 $X2=0.1445 $Y2=0.135
r23 11 16 7.11151 $w=1.78824e-08 $layer=LIG $thickness=5.17647e-08 $X=0.135
+ $Y=0.135 $X2=0.135 $Y2=0.135
r24 10 11 5.23813 $w=2.04667e-08 $l=1.5e-08 $layer=Gate_1 $thickness=5.6e-08
+ $X=0.135 $Y=0.12 $X2=0.135 $Y2=0.135
r25 9 10 3.23131 $w=2.1e-08 $l=9.5e-09 $layer=Gate_1 $thickness=5.6e-08
+ $X=0.135 $Y=0.1105 $X2=0.135 $Y2=0.12
r26 8 9 14.6259 $w=2.1e-08 $l=4.3e-08 $layer=Gate_1 $thickness=5.6e-08 $X=0.135
+ $Y=0.0675 $X2=0.135 $Y2=0.1105
r27 8 3 14.6259 $w=2.1e-08 $l=4.3e-08 $layer=Gate_1 $thickness=5.6e-08 $X=0.135
+ $Y=0.0675 $X2=0.135 $Y2=0.0245
.ends

.subckt PM_HAxp5_ASAP7_75t_R%CON vss 34 20 26 42 50 51 11 3 4 15 1 16 18 19 9
+ 10 12 14
c1 1 vss 0.00379969f $X=0.405 $Y=0.135
c2 3 vss 0.00776972f $X=0.108 $Y=0.216
c3 4 vss 0.0104558f $X=0.1745 $Y=0.0675
c4 9 vss 0.0826156f $X=0.405 $Y=0.0245
c5 10 vss 0.0374804f $X=0.1475 $Y=0.0675
c6 11 vss 0.00474809f $X=0.0935 $Y=0.216
c7 12 vss 0.000443039f $X=0.171 $Y=0.198
c8 13 vss 0.003126f $X=0.171 $Y=0.234
c9 14 vss 0.000585334f $X=0.405 $Y=0.198
c10 15 vss 0.00707263f $X=0.153 $Y=0.234
c11 16 vss 0.00185189f $X=0.171 $Y=0.1695
c12 17 vss 0.00073201f $X=0.171 $Y=0.216
c13 18 vss 0.00672191f $X=0.3915 $Y=0.198
c14 19 vss 0.00183312f $X=0.405 $Y=0.1235
r1 51 49 0.0462963 $w=5.4e-08 $l=2.5e-09 $layer=P_src_drn $thickness=1e-09
+ $X=0.1253 $Y=0.216 $X2=0.1225 $Y2=0.216
r2 3 49 0.268519 $w=5.4e-08 $l=1.45e-08 $layer=P_src_drn $thickness=1e-09
+ $X=0.108 $Y=0.216 $X2=0.1225 $Y2=0.216
r3 11 3 0.268519 $w=5.4e-08 $l=1.45e-08 $layer=P_src_drn $thickness=1e-09
+ $X=0.0935 $Y=0.216 $X2=0.108 $Y2=0.216
r4 50 11 0.0462963 $w=5.4e-08 $l=2.5e-09 $layer=P_src_drn $thickness=1e-09
+ $X=0.0906 $Y=0.216 $X2=0.0935 $Y2=0.216
r5 3 43 19.3796 $a=3.24e-16 $layer=V0LISD $X=0.108 $Y=0.216 $X2=0.112 $Y2=0.234
r6 43 44 4.31401 $w=1.3e-08 $l=1.85e-08 $layer=M1 $thickness=3.6e-08 $X=0.112
+ $Y=0.234 $X2=0.1305 $Y2=0.234
r7 15 44 5.24677 $w=1.3e-08 $l=2.25e-08 $layer=M1 $thickness=3.6e-08 $X=0.153
+ $Y=0.234 $X2=0.1305 $Y2=0.234
r8 10 4 0.154321 $w=8.1e-08 $l=1.25e-08 $layer=N_src_drn $thickness=1e-09
+ $X=0.1475 $Y=0.0675 $X2=0.1745 $Y2=0.0675
r9 42 10 0.0308642 $w=8.1e-08 $l=2.5e-09 $layer=N_src_drn $thickness=1e-09
+ $X=0.1446 $Y=0.0675 $X2=0.1475 $Y2=0.0675
r10 13 17 2.5483 $w=1.79e-08 $l=1.8e-08 $layer=M1 $thickness=3.6e-08 $X=0.171
+ $Y=0.234 $X2=0.171 $Y2=0.216
r11 13 15 2.5483 $w=1.55e-08 $l=1.8e-08 $layer=M1 $thickness=3.6e-08 $X=0.171
+ $Y=0.234 $X2=0.153 $Y2=0.234
r12 4 38 19.3796 $a=3.24e-16 $layer=V0LISD $X=0.1745 $Y=0.0675 $X2=0.171
+ $Y2=0.09
r13 38 39 8.04505 $w=1.3e-08 $l=3.45e-08 $layer=M1 $thickness=3.6e-08 $X=0.171
+ $Y=0.09 $X2=0.171 $Y2=0.1245
r14 16 39 10.4935 $w=1.3e-08 $l=4.5e-08 $layer=M1 $thickness=3.6e-08 $X=0.171
+ $Y=0.1695 $X2=0.171 $Y2=0.1245
r15 12 37 4.06646 $w=1.5e-08 $l=2.25e-08 $layer=M1 $thickness=3.6e-08 $X=0.171
+ $Y=0.198 $X2=0.1935 $Y2=0.198
r16 12 16 5.4656 $w=1.45789e-08 $l=2.85e-08 $layer=M1 $thickness=3.6e-08
+ $X=0.171 $Y=0.198 $X2=0.171 $Y2=0.1695
r17 12 17 3.01711 $w=1.55e-08 $l=1.8e-08 $layer=M1 $thickness=3.6e-08 $X=0.171
+ $Y=0.198 $X2=0.171 $Y2=0.216
r18 36 37 8.86121 $w=1.3e-08 $l=3.8e-08 $layer=M1 $thickness=3.6e-08 $X=0.2315
+ $Y=0.198 $X2=0.1935 $Y2=0.198
r19 34 35 9.96886 $w=1.3e-08 $l=4.27e-08 $layer=M1 $thickness=3.6e-08 $X=0.257
+ $Y=0.198 $X2=0.2997 $Y2=0.198
r20 34 33 0.174892 $w=1.3e-08 $l=8e-10 $layer=M1 $thickness=3.6e-08 $X=0.257
+ $Y=0.198 $X2=0.2562 $Y2=0.198
r21 33 36 5.77145 $w=1.3e-08 $l=2.47e-08 $layer=M1 $thickness=3.6e-08 $X=0.2562
+ $Y=0.198 $X2=0.2315 $Y2=0.198
r22 32 35 11.951 $w=1.3e-08 $l=5.13e-08 $layer=M1 $thickness=3.6e-08 $X=0.351
+ $Y=0.198 $X2=0.2997 $Y2=0.198
r23 31 32 5.24677 $w=1.3e-08 $l=2.25e-08 $layer=M1 $thickness=3.6e-08 $X=0.3735
+ $Y=0.198 $X2=0.351 $Y2=0.198
r24 18 31 4.19742 $w=1.3e-08 $l=1.8e-08 $layer=M1 $thickness=3.6e-08 $X=0.3915
+ $Y=0.198 $X2=0.3735 $Y2=0.198
r25 14 30 4.9968 $w=1.60947e-08 $l=2.85e-08 $layer=M1 $thickness=3.6e-08
+ $X=0.405 $Y=0.198 $X2=0.405 $Y2=0.1695
r26 14 18 1.49895 $w=1.63333e-08 $l=1.35e-08 $layer=M1 $thickness=3.6e-08
+ $X=0.405 $Y=0.198 $X2=0.3915 $Y2=0.198
r27 29 30 5.24677 $w=1.3e-08 $l=2.25e-08 $layer=M1 $thickness=3.6e-08 $X=0.405
+ $Y=0.147 $X2=0.405 $Y2=0.1695
r28 28 29 2.79828 $w=1.3e-08 $l=1.2e-08 $layer=M1 $thickness=3.6e-08 $X=0.405
+ $Y=0.135 $X2=0.405 $Y2=0.147
r29 19 28 2.68168 $w=1.3e-08 $l=1.15e-08 $layer=M1 $thickness=3.6e-08 $X=0.405
+ $Y=0.1235 $X2=0.405 $Y2=0.135
r30 1 23 10.4265 $w=1.765e-08 $layer=LIG $thickness=5.2e-08 $X=0.405 $Y=0.135
+ $X2=0.405 $Y2=0.135
r31 1 28 19.3796 $a=3.24e-16 $layer=V0LIG $X=0.405 $Y=0.135 $X2=0.405 $Y2=0.135
r32 26 25 14.6259 $w=2.1e-08 $l=4.3e-08 $layer=Gate_1 $thickness=5.6e-08
+ $X=0.405 $Y=0.2025 $X2=0.405 $Y2=0.1595
r33 24 25 2.7211 $w=2.1e-08 $l=8e-09 $layer=Gate_1 $thickness=5.6e-08 $X=0.405
+ $Y=0.1515 $X2=0.405 $Y2=0.1595
r34 23 24 5.79936 $w=2.03333e-08 $l=1.65e-08 $layer=Gate_1 $thickness=5.6e-08
+ $X=0.405 $Y=0.135 $X2=0.405 $Y2=0.1515
r35 22 23 5.79936 $w=2.03333e-08 $l=1.65e-08 $layer=Gate_1 $thickness=5.6e-08
+ $X=0.405 $Y=0.1185 $X2=0.405 $Y2=0.135
r36 21 22 2.7211 $w=2.1e-08 $l=8e-09 $layer=Gate_1 $thickness=5.6e-08 $X=0.405
+ $Y=0.1105 $X2=0.405 $Y2=0.1185
r37 20 21 14.6259 $w=2.1e-08 $l=4.3e-08 $layer=Gate_1 $thickness=5.6e-08
+ $X=0.405 $Y=0.0675 $X2=0.405 $Y2=0.1105
r38 20 9 14.6259 $w=2.1e-08 $l=4.3e-08 $layer=Gate_1 $thickness=5.6e-08
+ $X=0.405 $Y=0.0675 $X2=0.405 $Y2=0.0245
.ends

.subckt PM_HAxp5_ASAP7_75t_R%A vss 31 19 25 52 55 5 17 1 2 15 10 14 6 13 18
c1 1 vss 0.00726072f $X=0.072 $Y=0.135
c2 2 vss 0.0062025f $X=0.351 $Y=0.135
c3 5 vss 0.0776153f $X=0.081 $Y=0.0245
c4 6 vss 0.141092f $X=0.351 $Y=0.135
c5 7 vss 0.00375912f $X=0.027 $Y=0.036
c6 8 vss 0.00116578f $X=0.027 $Y=0.135
c7 9 vss 0.00344383f $X=0.216 $Y=0.036
c8 10 vss 0.00076134f $X=0.216 $Y=0.069
c9 11 vss 0.00357487f $X=0.351 $Y=0.072
c10 12 vss 0.00653784f $X=0.027 $Y=0.1035
c11 13 vss 0.00998203f $X=0.027 $Y=0.1665
c12 14 vss 0.0173617f $X=0.057 $Y=0.036
c13 15 vss 0.00150168f $X=0.0455 $Y=0.135
c14 16 vss 0.000880947f $X=0.216 $Y=0.054
c15 17 vss 0.0120099f $X=0.2405 $Y=0.072
c16 18 vss 0.00434538f $X=0.351 $Y=0.101
r1 55 54 16.4967 $w=2.1e-08 $l=4.85e-08 $layer=Gate_1 $thickness=5.6e-08
+ $X=0.351 $Y=0.2025 $X2=0.351 $Y2=0.154
r2 52 53 16.4967 $w=2.1e-08 $l=4.85e-08 $layer=Gate_1 $thickness=5.6e-08
+ $X=0.351 $Y=0.0675 $X2=0.351 $Y2=0.116
r3 6 53 6.6497 $w=2.04211e-08 $l=1.9e-08 $layer=Gate_1 $thickness=5.6e-08
+ $X=0.351 $Y=0.135 $X2=0.351 $Y2=0.116
r4 6 54 6.6497 $w=2.04211e-08 $l=1.9e-08 $layer=Gate_1 $thickness=5.6e-08
+ $X=0.351 $Y=0.135 $X2=0.351 $Y2=0.154
r5 2 47 19.3796 $a=3.24e-16 $layer=V0LIG $X=0.351 $Y=0.135 $X2=0.351 $Y2=0.135
r6 2 6 8.65438 $w=1.80211e-08 $layer=LIG $thickness=5.26316e-08 $X=0.351
+ $Y=0.135 $X2=0.351 $Y2=0.135
r7 46 47 2.68168 $w=1.3e-08 $l=1.15e-08 $layer=M1 $thickness=3.6e-08 $X=0.351
+ $Y=0.1235 $X2=0.351 $Y2=0.135
r8 18 46 5.24677 $w=1.3e-08 $l=2.25e-08 $layer=M1 $thickness=3.6e-08 $X=0.351
+ $Y=0.101 $X2=0.351 $Y2=0.1235
r9 11 45 10.4768 $w=1.38654e-08 $l=5.2e-08 $layer=M1 $thickness=3.6e-08
+ $X=0.351 $Y=0.072 $X2=0.299 $Y2=0.072
r10 11 18 5.11339 $w=1.60414e-08 $l=2.9e-08 $layer=M1 $thickness=3.6e-08
+ $X=0.351 $Y=0.072 $X2=0.351 $Y2=0.101
r11 17 45 13.6416 $w=1.3e-08 $l=5.85e-08 $layer=M1 $thickness=3.6e-08 $X=0.2405
+ $Y=0.072 $X2=0.299 $Y2=0.072
r12 10 16 2.71097 $w=1.5e-08 $l=1.5e-08 $layer=M1 $thickness=3.6e-08 $X=0.216
+ $Y=0.069 $X2=0.216 $Y2=0.054
r13 10 17 4.22671 $w=1.43953e-08 $l=2.4683e-08 $layer=M1 $thickness=3.6e-08
+ $X=0.216 $Y=0.069 $X2=0.2405 $Y2=0.072
r14 9 43 3.59766 $w=1.5e-08 $l=2.25e-08 $layer=M1 $thickness=3.6e-08 $X=0.216
+ $Y=0.036 $X2=0.1935 $Y2=0.036
r15 9 16 2.5483 $w=1.79e-08 $l=1.8e-08 $layer=M1 $thickness=3.6e-08 $X=0.216
+ $Y=0.036 $X2=0.216 $Y2=0.054
r16 42 43 5.24677 $w=1.3e-08 $l=2.25e-08 $layer=M1 $thickness=3.6e-08 $X=0.171
+ $Y=0.036 $X2=0.1935 $Y2=0.036
r17 41 42 4.19742 $w=1.3e-08 $l=1.8e-08 $layer=M1 $thickness=3.6e-08 $X=0.153
+ $Y=0.036 $X2=0.171 $Y2=0.036
r18 40 41 6.52931 $w=1.3e-08 $l=2.8e-08 $layer=M1 $thickness=3.6e-08 $X=0.125
+ $Y=0.036 $X2=0.153 $Y2=0.036
r19 39 40 5.82974 $w=1.3e-08 $l=2.5e-08 $layer=M1 $thickness=3.6e-08 $X=0.1
+ $Y=0.036 $X2=0.125 $Y2=0.036
r20 38 39 3.26466 $w=1.3e-08 $l=1.4e-08 $layer=M1 $thickness=3.6e-08 $X=0.086
+ $Y=0.036 $X2=0.1 $Y2=0.036
r21 14 38 6.7625 $w=1.3e-08 $l=2.9e-08 $layer=M1 $thickness=3.6e-08 $X=0.057
+ $Y=0.036 $X2=0.086 $Y2=0.036
r22 7 34 2.5483 $w=1.79e-08 $l=1.8e-08 $layer=M1 $thickness=3.6e-08 $X=0.027
+ $Y=0.036 $X2=0.027 $Y2=0.054
r23 7 14 5.34658 $w=1.45e-08 $l=3e-08 $layer=M1 $thickness=3.6e-08 $X=0.027
+ $Y=0.036 $X2=0.057 $Y2=0.036
r24 33 34 4.19742 $w=1.3e-08 $l=1.8e-08 $layer=M1 $thickness=3.6e-08 $X=0.027
+ $Y=0.072 $X2=0.027 $Y2=0.054
r25 12 33 7.34548 $w=1.3e-08 $l=3.15e-08 $layer=M1 $thickness=3.6e-08 $X=0.027
+ $Y=0.1035 $X2=0.027 $Y2=0.072
r26 8 15 3.1337 $w=1.54324e-08 $l=1.85e-08 $layer=M1 $thickness=3.6e-08
+ $X=0.027 $Y=0.135 $X2=0.0455 $Y2=0.135
r27 8 12 6.16517 $w=1.44286e-08 $l=3.15e-08 $layer=M1 $thickness=3.6e-08
+ $X=0.027 $Y=0.135 $X2=0.027 $Y2=0.1035
r28 8 13 6.16517 $w=1.44286e-08 $l=3.15e-08 $layer=M1 $thickness=3.6e-08
+ $X=0.027 $Y=0.135 $X2=0.027 $Y2=0.1665
r29 31 15 4.31401 $w=1.3e-08 $l=1.85e-08 $layer=M1 $thickness=3.6e-08 $X=0.06
+ $Y=0.136 $X2=0.0455 $Y2=0.135
r30 31 29 19.3796 $a=3.24e-16 $layer=V0LIG $X=0.06 $Y=0.136 $X2=0.063 $Y2=0.135
r31 1 27 2.6116 $w=2.2e-08 $l=1e-08 $layer=LIG $thickness=4.8e-08 $X=0.072
+ $Y=0.135 $X2=0.082 $Y2=0.135
r32 1 29 4.98695 $w=1.60444e-08 $l=9e-09 $layer=LIG $thickness=4.8e-08 $X=0.072
+ $Y=0.135 $X2=0.063 $Y2=0.135
r33 25 24 14.6259 $w=2.1e-08 $l=4.3e-08 $layer=Gate_1 $thickness=5.6e-08
+ $X=0.081 $Y=0.216 $X2=0.081 $Y2=0.173
r34 23 24 7.31297 $w=2.1e-08 $l=2.15e-08 $layer=Gate_1 $thickness=5.6e-08
+ $X=0.081 $Y=0.1515 $X2=0.081 $Y2=0.173
r35 22 23 5.79936 $w=2.03333e-08 $l=1.65e-08 $layer=Gate_1 $thickness=5.6e-08
+ $X=0.081 $Y=0.135 $X2=0.081 $Y2=0.1515
r36 22 27 6.27904 $w=2.09e-08 $l=1e-09 $layer=Gate_1 $thickness=5.24e-08
+ $X=0.081 $Y=0.135 $X2=0.082 $Y2=0.135
r37 21 22 5.79936 $w=2.03333e-08 $l=1.65e-08 $layer=Gate_1 $thickness=5.6e-08
+ $X=0.081 $Y=0.1185 $X2=0.081 $Y2=0.135
r38 20 21 2.7211 $w=2.1e-08 $l=8e-09 $layer=Gate_1 $thickness=5.6e-08 $X=0.081
+ $Y=0.1105 $X2=0.081 $Y2=0.1185
r39 19 20 14.6259 $w=2.1e-08 $l=4.3e-08 $layer=Gate_1 $thickness=5.6e-08
+ $X=0.081 $Y=0.0675 $X2=0.081 $Y2=0.1105
r40 19 5 14.6259 $w=2.1e-08 $l=4.3e-08 $layer=Gate_1 $thickness=5.6e-08
+ $X=0.081 $Y=0.0675 $X2=0.081 $Y2=0.0245
.ends

.subckt PM_HAxp5_ASAP7_75t_R%SN vss 22 18 31 33 11 12 3 15 16 10
c1 2 vss 0.00981206f $X=0.432 $Y=0.0675
c2 3 vss 0.00844735f $X=0.432 $Y=0.2025
c3 10 vss 0.0383554f $X=0.4175 $Y=0.0675
c4 11 vss 0.0442299f $X=0.272 $Y=0.2025
c5 12 vss 0.0382404f $X=0.4175 $Y=0.2025
c6 13 vss 0.00610142f $X=0.432 $Y=0.036
c7 14 vss 0.00276312f $X=0.459 $Y=0.234
c8 15 vss 0.0168424f $X=0.432 $Y=0.234
c9 16 vss 0.00549876f $X=0.459 $Y=0.054
r1 33 32 0.0308642 $w=8.1e-08 $l=2.5e-09 $layer=P_src_drn $thickness=1e-09
+ $X=0.2873 $Y=0.2025 $X2=0.2845 $Y2=0.2025
r2 11 32 0.154321 $w=8.1e-08 $l=1.25e-08 $layer=P_src_drn $thickness=1e-09
+ $X=0.272 $Y=0.2025 $X2=0.2845 $Y2=0.2025
r3 12 3 0.154321 $w=8.1e-08 $l=1.25e-08 $layer=P_src_drn $thickness=1e-09
+ $X=0.4175 $Y=0.2025 $X2=0.432 $Y2=0.2025
r4 31 12 0.0308642 $w=8.1e-08 $l=2.5e-09 $layer=P_src_drn $thickness=1e-09
+ $X=0.4146 $Y=0.2025 $X2=0.4175 $Y2=0.2025
r5 11 27 19.3796 $a=3.24e-16 $layer=V0LISD $X=0.272 $Y=0.2025 $X2=0.27 $Y2=0.234
r6 3 15 19.3796 $a=3.24e-16 $layer=V0LISD $X=0.432 $Y=0.2025 $X2=0.432 $Y2=0.234
r7 27 28 17.839 $w=1.3e-08 $l=7.65e-08 $layer=M1 $thickness=3.6e-08 $X=0.27
+ $Y=0.234 $X2=0.3465 $Y2=0.234
r8 25 28 16.7897 $w=1.3e-08 $l=7.2e-08 $layer=M1 $thickness=3.6e-08 $X=0.4185
+ $Y=0.234 $X2=0.3465 $Y2=0.234
r9 15 24 3.14806 $w=1.3e-08 $l=1.35e-08 $layer=M1 $thickness=3.6e-08 $X=0.432
+ $Y=0.234 $X2=0.4455 $Y2=0.234
r10 15 25 3.14806 $w=1.3e-08 $l=1.35e-08 $layer=M1 $thickness=3.6e-08 $X=0.432
+ $Y=0.234 $X2=0.4185 $Y2=0.234
r11 14 23 2.5483 $w=1.79e-08 $l=1.8e-08 $layer=M1 $thickness=3.6e-08 $X=0.459
+ $Y=0.234 $X2=0.459 $Y2=0.216
r12 14 24 1.49895 $w=1.63333e-08 $l=1.35e-08 $layer=M1 $thickness=3.6e-08
+ $X=0.459 $Y=0.234 $X2=0.4455 $Y2=0.234
r13 22 23 12.1259 $w=1.3e-08 $l=5.2e-08 $layer=M1 $thickness=3.6e-08 $X=0.457
+ $Y=0.135 $X2=0.459 $Y2=0.216
r14 22 21 16.7897 $w=1.3e-08 $l=7.2e-08 $layer=M1 $thickness=3.6e-08 $X=0.457
+ $Y=0.135 $X2=0.459 $Y2=0.092
r15 16 20 3.01711 $w=1.55e-08 $l=1.8e-08 $layer=M1 $thickness=3.6e-08 $X=0.459
+ $Y=0.054 $X2=0.459 $Y2=0.036
r16 16 21 8.86121 $w=1.3e-08 $l=3.8e-08 $layer=M1 $thickness=3.6e-08 $X=0.459
+ $Y=0.054 $X2=0.459 $Y2=0.092
r17 19 20 1.96775 $w=1.63333e-08 $l=1.35e-08 $layer=M1 $thickness=3.6e-08
+ $X=0.4455 $Y=0.036 $X2=0.459 $Y2=0.036
r18 13 19 3.14806 $w=1.3e-08 $l=1.35e-08 $layer=M1 $thickness=3.6e-08 $X=0.432
+ $Y=0.036 $X2=0.4455 $Y2=0.036
r19 2 13 19.3796 $a=3.24e-16 $layer=V0LISD $X=0.432 $Y=0.0675 $X2=0.432
+ $Y2=0.036
r20 10 2 0.154321 $w=8.1e-08 $l=1.25e-08 $layer=N_src_drn $thickness=1e-09
+ $X=0.4175 $Y=0.0675 $X2=0.432 $Y2=0.0675
r21 18 10 0.0308642 $w=8.1e-08 $l=2.5e-09 $layer=N_src_drn $thickness=1e-09
+ $X=0.4146 $Y=0.0675 $X2=0.4175 $Y2=0.0675
.ends

* End of included file HAxp5_ASAP7_75t_R.pex.sp.pex

*
.subckt HAxp5_ASAP7_75t_CUSTOM_4_25_0_7 VSS VDD A B CON SN
*
* VSS VSS
* VDD VDD
* A A
* B B
* CON CON
* SN SN
*
*

M0 N_M0_d N_M0_g VSS VSS nmos_rvt L=2e-08 W=8.1e-08 nfin=3 $X=0.071 $Y=0.027
M1 N_M1_d N_M1_g N_M1_s VSS nmos_rvt L=2e-08 W=8.1e-08 nfin=3 $X=0.125 $Y=0.027
M2 VSS N_M2_g noxref_6 VSS nmos_rvt L=2e-08 W=8.1e-08 nfin=3 $X=0.287 $Y=0.027
M3 noxref_6 N_M3_g VSS VSS nmos_rvt L=2e-08 W=8.1e-08 nfin=3 $X=0.341 $Y=0.027
M4 N_M4_d N_M4_g noxref_6 VSS nmos_rvt L=2e-08 W=8.1e-08 nfin=3 $X=0.395
+ $Y=0.027
M5 N_M5_d N_M5_g VDD VDD pmos_rvt L=2e-08 W=5.4e-08 nfin=2 $X=0.071 $Y=0.189
M6 VDD N_M6_g N_M6_s VDD pmos_rvt L=2e-08 W=5.4e-08 nfin=2 $X=0.125 $Y=0.189
M7 noxref_9 N_M7_g N_M7_s VDD pmos_rvt L=2e-08 W=8.1e-08 nfin=3 $X=0.287
+ $Y=0.162
M8 VDD N_M8_g noxref_9 VDD pmos_rvt L=2e-08 W=8.1e-08 nfin=3 $X=0.341 $Y=0.162
M9 N_M9_d N_M9_g VDD VDD pmos_rvt L=2e-08 W=8.1e-08 nfin=3 $X=0.395 $Y=0.162

* .include "HAxp5_ASAP7_75t_R.pex.sp.pxi"

* Start of included file HAxp5_ASAP7_75t_R.pex.sp.pxi
x_PM_HAxp5_ASAP7_75t_R%8 vss N_M0_d N_M1_s N_8_1 PM_HAxp5_ASAP7_75t_R%8
cc_1 N_8_1 N_A_5 0.0168341f $X=0.108 $Y=0.0675
cc_2 N_8_1 N_B_3 0.0168883f $X=0.108 $Y=0.0675
x_PM_HAxp5_ASAP7_75t_R%B vss B N_M1_g N_M6_g N_M2_g N_M7_g N_B_5 N_B_1 N_B_6
+ N_B_7 N_B_4 N_B_3 PM_HAxp5_ASAP7_75t_R%B
cc_3 N_B_5 N_A_5 0.000223375f $X=0.135 $Y=0.072
cc_4 N_B_1 N_A_5 0.000297746f $X=0.1255 $Y=0.135
cc_5 N_B_6 N_A_5 0.000303556f $X=0.135 $Y=0.198
cc_6 N_B_1 N_A_17 0.000404232f $X=0.1255 $Y=0.135
cc_7 N_B_1 N_A_1 0.0017349f $X=0.1255 $Y=0.135
cc_8 N_B_1 N_A_2 0.000522319f $X=0.1255 $Y=0.135
cc_9 N_B_6 N_A_15 0.000535999f $X=0.135 $Y=0.198
cc_10 N_B_1 N_A_10 0.00187269f $X=0.1255 $Y=0.135
cc_11 N_B_7 N_A_15 0.00196774f $X=0.135 $Y=0.1265
cc_12 N_B_5 N_A_14 0.00485213f $X=0.135 $Y=0.072
cc_13 N_B_4 N_A_6 0.00489475f $X=0.297 $Y=0.135
cc_14 N_B_3 N_A_5 0.00771698f $X=0.135 $Y=0.0245
x_PM_HAxp5_ASAP7_75t_R%CON vss CON N_M4_g N_M9_g N_M1_d N_M5_d N_M6_s N_CON_11
+ N_CON_3 N_CON_4 N_CON_15 N_CON_1 N_CON_16 N_CON_18 N_CON_19 N_CON_9 N_CON_10
+ N_CON_12 N_CON_14 PM_HAxp5_ASAP7_75t_R%CON
cc_15 N_CON_11 N_A_10 0.000374031f $X=0.0935 $Y=0.216
cc_16 N_CON_11 N_A_1 0.000472447f $X=0.0935 $Y=0.216
cc_17 N_CON_3 N_A_5 0.000586306f $X=0.108 $Y=0.216
cc_18 N_CON_4 N_A_17 0.000724497f $X=0.1745 $Y=0.0675
cc_19 N_CON_15 N_A_13 0.000857996f $X=0.153 $Y=0.234
cc_20 N_CON_1 N_A_2 0.0021814f $X=0.405 $Y=0.135
cc_21 N_CON_16 N_A_14 0.00162061f $X=0.171 $Y=0.1695
cc_22 N_CON_4 N_A_14 0.00162595f $X=0.1745 $Y=0.0675
cc_23 N_CON_18 N_A_18 0.00167172f $X=0.3915 $Y=0.198
cc_24 N_CON_16 N_A_10 0.00242734f $X=0.171 $Y=0.1695
cc_25 N_CON_19 N_A_18 0.00273159f $X=0.405 $Y=0.1235
cc_26 N_CON_9 N_A_6 0.00334667f $X=0.405 $Y=0.0245
cc_27 N_CON_11 N_A_5 0.0262323f $X=0.0935 $Y=0.216
cc_28 N_CON_10 N_B_6 0.000359851f $X=0.1475 $Y=0.0675
cc_29 N_CON_10 N_B_7 0.000703734f $X=0.1475 $Y=0.0675
cc_30 N_CON_18 N_B_1 0.000764556f $X=0.3915 $Y=0.198
cc_31 N_CON_16 N_B_1 0.000830229f $X=0.171 $Y=0.1695
cc_32 N_CON_16 N_B_5 0.000857002f $X=0.171 $Y=0.1695
cc_33 N_CON_3 N_B_3 0.000864739f $X=0.108 $Y=0.216
cc_34 N_CON_12 N_B_6 0.0023283f $X=0.171 $Y=0.198
cc_35 N_CON_4 N_B_3 0.00292801f $X=0.1745 $Y=0.0675
cc_36 N_CON_15 N_B_6 0.0029527f $X=0.153 $Y=0.234
cc_37 N_CON_11 N_B_3 0.0105439f $X=0.0935 $Y=0.216
cc_38 N_CON_4 N_B_1 0.00508032f $X=0.1745 $Y=0.0675
cc_39 N_CON_16 N_B_7 0.00879352f $X=0.171 $Y=0.1695
cc_40 N_CON_10 N_B_3 0.0503118f $X=0.1475 $Y=0.0675
x_PM_HAxp5_ASAP7_75t_R%A vss A N_M0_g N_M5_g N_M3_g N_M8_g N_A_5 N_A_17 N_A_1
+ N_A_2 N_A_15 N_A_10 N_A_14 N_A_6 N_A_13 N_A_18 PM_HAxp5_ASAP7_75t_R%A
x_PM_HAxp5_ASAP7_75t_R%SN vss SN N_M4_d N_M9_d N_M7_s N_SN_11 N_SN_12 N_SN_3
+ N_SN_15 N_SN_16 N_SN_10 PM_HAxp5_ASAP7_75t_R%SN
cc_41 N_SN_11 N_B_1 0.00288612f $X=0.272 $Y=0.2025
cc_42 N_SN_11 N_B_4 0.0373015f $X=0.272 $Y=0.2025
cc_43 N_SN_12 N_CON_1 0.00248751f $X=0.4175 $Y=0.2025
cc_44 N_SN_12 N_CON_18 0.00120369f $X=0.4175 $Y=0.2025
cc_45 N_SN_3 N_CON_9 0.00128776f $X=0.432 $Y=0.2025
cc_46 N_SN_15 N_CON_14 0.00165158f $X=0.432 $Y=0.234
cc_47 N_SN_16 N_CON_19 0.00431613f $X=0.459 $Y=0.054
cc_48 N_SN_10 N_CON_9 0.0148234f $X=0.4175 $Y=0.0675
cc_49 N_SN_15 N_CON_18 0.0124138f $X=0.432 $Y=0.234
cc_50 N_SN_12 N_CON_9 0.0562186f $X=0.4175 $Y=0.2025

* End of included file HAxp5_ASAP7_75t_R.pex.sp.pxi
.ends

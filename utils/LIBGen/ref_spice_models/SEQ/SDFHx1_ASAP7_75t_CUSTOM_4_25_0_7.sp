.subckt PM_SDFHx1_ASAP7_75t_R%CLK vss 21 9 15 3 6 1 4 7 8 5
c1 1 vss 0.00381006f $X=0.081 $Y=0.135
c2 3 vss 0.0693837f $X=0.081 $Y=0.0245
c3 4 vss 0.00197191f $X=0.081 $Y=0.09
c4 5 vss 0.00172447f $X=0.081 $Y=0.194
c5 6 vss 0.00436141f $X=0.108 $Y=0.194
c6 7 vss 0.00156669f $X=0.081 $Y=0.11
c7 8 vss 0.00459789f $X=0.108 $Y=0.063
r1 6 25 1.96775 $w=1.63333e-08 $l=1.35e-08 $layer=M1 $thickness=3.6e-08
+ $X=0.108 $Y=0.194 $X2=0.0945 $Y2=0.194
r2 8 24 5.11582 $w=1.46667e-08 $l=2.7e-08 $layer=M1 $thickness=3.6e-08 $X=0.108
+ $Y=0.063 $X2=0.108 $Y2=0.09
r3 5 22 1.44308 $w=1.7e-08 $l=1.13e-08 $layer=M1 $thickness=3.6e-08 $X=0.081
+ $Y=0.194 $X2=0.081 $Y2=0.1827
r4 5 25 1.96775 $w=1.63333e-08 $l=1.35e-08 $layer=M1 $thickness=3.6e-08
+ $X=0.081 $Y=0.194 $X2=0.0945 $Y2=0.194
r5 23 24 1.96775 $w=1.63333e-08 $l=1.35e-08 $layer=M1 $thickness=3.6e-08
+ $X=0.0945 $Y=0.09 $X2=0.108 $Y2=0.09
r6 4 7 3.48349 $w=1.525e-08 $l=2e-08 $layer=M1 $thickness=3.6e-08 $X=0.081
+ $Y=0.09 $X2=0.081 $Y2=0.11
r7 4 23 1.96775 $w=1.63333e-08 $l=1.35e-08 $layer=M1 $thickness=3.6e-08
+ $X=0.081 $Y=0.09 $X2=0.0945 $Y2=0.09
r8 21 22 0.641272 $w=1.3e-08 $l=2.7e-09 $layer=M1 $thickness=3.6e-08 $X=0.078
+ $Y=0.18 $X2=0.081 $Y2=0.1827
r9 21 20 1.57403 $w=1.3e-08 $l=6.8e-09 $layer=M1 $thickness=3.6e-08 $X=0.078
+ $Y=0.18 $X2=0.081 $Y2=0.1732
r10 19 20 4.13912 $w=1.3e-08 $l=1.77e-08 $layer=M1 $thickness=3.6e-08 $X=0.081
+ $Y=0.1555 $X2=0.081 $Y2=0.1732
r11 18 19 4.78039 $w=1.3e-08 $l=2.05e-08 $layer=M1 $thickness=3.6e-08 $X=0.081
+ $Y=0.135 $X2=0.081 $Y2=0.1555
r12 17 18 2.68168 $w=1.3e-08 $l=1.15e-08 $layer=M1 $thickness=3.6e-08 $X=0.081
+ $Y=0.1235 $X2=0.081 $Y2=0.135
r13 7 17 3.14806 $w=1.3e-08 $l=1.35e-08 $layer=M1 $thickness=3.6e-08 $X=0.081
+ $Y=0.11 $X2=0.081 $Y2=0.1235
r14 1 12 10.4265 $w=1.765e-08 $layer=LIG $thickness=5.2e-08 $X=0.081 $Y=0.135
+ $X2=0.081 $Y2=0.135
r15 1 18 19.3796 $a=3.24e-16 $layer=V0LIG $X=0.081 $Y=0.135 $X2=0.081 $Y2=0.135
r16 15 14 14.6259 $w=2.1e-08 $l=4.3e-08 $layer=Gate_1 $thickness=5.6e-08
+ $X=0.081 $Y=0.216 $X2=0.081 $Y2=0.173
r17 13 14 7.31297 $w=2.1e-08 $l=2.15e-08 $layer=Gate_1 $thickness=5.6e-08
+ $X=0.081 $Y=0.1515 $X2=0.081 $Y2=0.173
r18 12 13 5.79936 $w=2.03333e-08 $l=1.65e-08 $layer=Gate_1 $thickness=5.6e-08
+ $X=0.081 $Y=0.135 $X2=0.081 $Y2=0.1515
r19 11 12 5.79936 $w=2.03333e-08 $l=1.65e-08 $layer=Gate_1 $thickness=5.6e-08
+ $X=0.081 $Y=0.1185 $X2=0.081 $Y2=0.135
r20 10 11 7.31297 $w=2.1e-08 $l=2.15e-08 $layer=Gate_1 $thickness=5.6e-08
+ $X=0.081 $Y=0.097 $X2=0.081 $Y2=0.1185
r21 9 10 14.6259 $w=2.1e-08 $l=4.3e-08 $layer=Gate_1 $thickness=5.6e-08
+ $X=0.081 $Y=0.054 $X2=0.081 $Y2=0.097
r22 9 3 10.0341 $w=2.1e-08 $l=2.95e-08 $layer=Gate_1 $thickness=5.6e-08
+ $X=0.081 $Y=0.054 $X2=0.081 $Y2=0.0245
.ends

.subckt PM_SDFHx1_ASAP7_75t_R%14 vss 13 24 26 8 1 9 11 2 10
c1 1 vss 0.00617057f $X=0.27 $Y=0.1755
c2 2 vss 0.0102087f $X=0.513 $Y=0.2025
c3 8 vss 0.0365628f $X=0.272 $Y=0.2025
c4 9 vss 0.0358316f $X=0.4715 $Y=0.2025
c5 10 vss 0.035779f $X=0.542 $Y=0.2025
c6 11 vss 0.0203889f $X=0.258 $Y=0.234
r1 26 25 0.0308642 $w=8.1e-08 $l=2.5e-09 $layer=P_src_drn $thickness=1e-09
+ $X=0.5573 $Y=0.2025 $X2=0.5545 $Y2=0.2025
r2 10 25 0.154321 $w=8.1e-08 $l=1.25e-08 $layer=P_src_drn $thickness=1e-09
+ $X=0.542 $Y=0.2025 $X2=0.5545 $Y2=0.2025
r3 9 2 0.154321 $w=8.1e-08 $l=1.25e-08 $layer=P_src_drn $thickness=1e-09
+ $X=0.4715 $Y=0.2025 $X2=0.513 $Y2=0.2025
r4 24 9 0.0308642 $w=8.1e-08 $l=2.5e-09 $layer=P_src_drn $thickness=1e-09
+ $X=0.4686 $Y=0.2025 $X2=0.4715 $Y2=0.2025
r5 2 21 19.3796 $a=3.24e-16 $layer=V0LISD $X=0.513 $Y=0.2025 $X2=0.49 $Y2=0.234
r6 20 21 2.09871 $w=1.3e-08 $l=9e-09 $layer=M1 $thickness=3.6e-08 $X=0.481
+ $Y=0.234 $X2=0.49 $Y2=0.234
r7 19 20 2.79828 $w=1.3e-08 $l=1.2e-08 $layer=M1 $thickness=3.6e-08 $X=0.469
+ $Y=0.234 $X2=0.481 $Y2=0.234
r8 18 19 3.49785 $w=1.3e-08 $l=1.5e-08 $layer=M1 $thickness=3.6e-08 $X=0.454
+ $Y=0.234 $X2=0.469 $Y2=0.234
r9 17 18 17.7224 $w=1.3e-08 $l=7.6e-08 $layer=M1 $thickness=3.6e-08 $X=0.378
+ $Y=0.234 $X2=0.454 $Y2=0.234
r10 16 17 19.5879 $w=1.3e-08 $l=8.4e-08 $layer=M1 $thickness=3.6e-08 $X=0.294
+ $Y=0.234 $X2=0.378 $Y2=0.234
r11 15 16 5.59655 $w=1.3e-08 $l=2.4e-08 $layer=M1 $thickness=3.6e-08 $X=0.27
+ $Y=0.234 $X2=0.294 $Y2=0.234
r12 11 15 2.79828 $w=1.3e-08 $l=1.2e-08 $layer=M1 $thickness=3.6e-08 $X=0.258
+ $Y=0.234 $X2=0.27 $Y2=0.234
r13 8 15 19.3796 $a=3.24e-16 $layer=V0LISD $X=0.272 $Y=0.2025 $X2=0.27 $Y2=0.234
r14 1 8 23.8708 $w=2.02e-08 $l=4.05e-08 $layer=LISD $thickness=2.7e-08 $X=0.27
+ $Y=0.1755 $X2=0.272 $Y2=0.2025
r15 13 12 0.0308642 $w=8.1e-08 $l=2.5e-09 $layer=P_src_drn $thickness=1e-09
+ $X=0.2873 $Y=0.2025 $X2=0.2845 $Y2=0.2025
r16 8 12 0.154321 $w=8.1e-08 $l=1.25e-08 $layer=P_src_drn $thickness=1e-09
+ $X=0.272 $Y=0.2025 $X2=0.2845 $Y2=0.2025
r17 2 10 1e-05 $l=2.9e-08 $X=0.513 $Y=0.2025 $X2=0.542 $Y2=0.2025
.ends

.subckt PM_SDFHx1_ASAP7_75t_R%16 vss 12 13 27 28 7 1 9 2 8
c1 1 vss 0.00451647f $X=0.324 $Y=0.2025
c2 2 vss 0.00451163f $X=0.432 $Y=0.2025
c3 7 vss 0.00311539f $X=0.3095 $Y=0.2025
c4 8 vss 0.00310315f $X=0.4175 $Y=0.2025
c5 9 vss 0.00337342f $X=0.31 $Y=0.198
r1 28 26 0.0308642 $w=8.1e-08 $l=2.5e-09 $layer=P_src_drn $thickness=1e-09
+ $X=0.4493 $Y=0.2025 $X2=0.4465 $Y2=0.2025
r2 2 26 0.179012 $w=8.1e-08 $l=1.45e-08 $layer=P_src_drn $thickness=1e-09
+ $X=0.432 $Y=0.2025 $X2=0.4465 $Y2=0.2025
r3 8 2 0.179012 $w=8.1e-08 $l=1.45e-08 $layer=P_src_drn $thickness=1e-09
+ $X=0.4175 $Y=0.2025 $X2=0.432 $Y2=0.2025
r4 27 8 0.0308642 $w=8.1e-08 $l=2.5e-09 $layer=P_src_drn $thickness=1e-09
+ $X=0.4146 $Y=0.2025 $X2=0.4175 $Y2=0.2025
r5 2 23 19.3796 $a=3.24e-16 $layer=V0LISD $X=0.432 $Y=0.2025 $X2=0.432 $Y2=0.198
r6 22 23 2.68168 $w=1.3e-08 $l=1.15e-08 $layer=M1 $thickness=3.6e-08 $X=0.4205
+ $Y=0.198 $X2=0.432 $Y2=0.198
r7 21 22 1.04935 $w=1.3e-08 $l=4.5e-09 $layer=M1 $thickness=3.6e-08 $X=0.416
+ $Y=0.198 $X2=0.4205 $Y2=0.198
r8 20 21 2.56509 $w=1.3e-08 $l=1.1e-08 $layer=M1 $thickness=3.6e-08 $X=0.405
+ $Y=0.198 $X2=0.416 $Y2=0.198
r9 19 20 4.08082 $w=1.3e-08 $l=1.75e-08 $layer=M1 $thickness=3.6e-08 $X=0.3875
+ $Y=0.198 $X2=0.405 $Y2=0.198
r10 18 19 4.19742 $w=1.3e-08 $l=1.8e-08 $layer=M1 $thickness=3.6e-08 $X=0.3695
+ $Y=0.198 $X2=0.3875 $Y2=0.198
r11 17 18 4.31401 $w=1.3e-08 $l=1.85e-08 $layer=M1 $thickness=3.6e-08 $X=0.351
+ $Y=0.198 $X2=0.3695 $Y2=0.198
r12 16 17 3.14806 $w=1.3e-08 $l=1.35e-08 $layer=M1 $thickness=3.6e-08 $X=0.3375
+ $Y=0.198 $X2=0.351 $Y2=0.198
r13 15 16 3.14806 $w=1.3e-08 $l=1.35e-08 $layer=M1 $thickness=3.6e-08 $X=0.324
+ $Y=0.198 $X2=0.3375 $Y2=0.198
r14 14 15 2.56509 $w=1.3e-08 $l=1.1e-08 $layer=M1 $thickness=3.6e-08 $X=0.313
+ $Y=0.198 $X2=0.324 $Y2=0.198
r15 9 14 0.699569 $w=1.3e-08 $l=3e-09 $layer=M1 $thickness=3.6e-08 $X=0.31
+ $Y=0.198 $X2=0.313 $Y2=0.198
r16 1 15 19.3796 $a=3.24e-16 $layer=V0LISD $X=0.324 $Y=0.2025 $X2=0.324
+ $Y2=0.198
r17 13 11 0.0308642 $w=8.1e-08 $l=2.5e-09 $layer=P_src_drn $thickness=1e-09
+ $X=0.3413 $Y=0.2025 $X2=0.3385 $Y2=0.2025
r18 1 11 0.179012 $w=8.1e-08 $l=1.45e-08 $layer=P_src_drn $thickness=1e-09
+ $X=0.324 $Y=0.2025 $X2=0.3385 $Y2=0.2025
r19 7 1 0.179012 $w=8.1e-08 $l=1.45e-08 $layer=P_src_drn $thickness=1e-09
+ $X=0.3095 $Y=0.2025 $X2=0.324 $Y2=0.2025
r20 12 7 0.0308642 $w=8.1e-08 $l=2.5e-09 $layer=P_src_drn $thickness=1e-09
+ $X=0.3066 $Y=0.2025 $X2=0.3095 $Y2=0.2025
.ends

.subckt PM_SDFHx1_ASAP7_75t_R%19 vss 7 12 4 1 5
c1 1 vss 0.0059335f $X=0.648 $Y=0.2295
c2 4 vss 0.00168595f $X=0.6335 $Y=0.2295
c3 5 vss 0.00204854f $X=0.704 $Y=0.2295
r1 12 11 0.0925926 $w=2.7e-08 $l=2.5e-09 $layer=P_src_drn $thickness=1e-09
+ $X=0.7193 $Y=0.2295 $X2=0.7165 $Y2=0.2295
r2 5 11 0.462963 $w=2.7e-08 $l=1.25e-08 $layer=P_src_drn $thickness=1e-09
+ $X=0.704 $Y=0.2295 $X2=0.7165 $Y2=0.2295
r3 9 5 11.9937 $w=2.32e-08 $l=2.55e-08 $layer=LISD $thickness=2.7e-08 $X=0.6765
+ $Y=0.2295 $X2=0.704 $Y2=0.2295
r4 8 9 7.05511 $w=2.32e-08 $l=1.5e-08 $layer=LISD $thickness=2.7e-08 $X=0.6615
+ $Y=0.2295 $X2=0.6765 $Y2=0.2295
r5 1 8 6.3496 $w=2.32e-08 $l=1.35e-08 $layer=LISD $thickness=2.7e-08 $X=0.648
+ $Y=0.2295 $X2=0.6615 $Y2=0.2295
r6 4 1 0.462963 $w=2.7e-08 $l=1.25e-08 $layer=P_src_drn $thickness=1e-09
+ $X=0.6335 $Y=0.2295 $X2=0.648 $Y2=0.2295
r7 7 4 0.0925926 $w=2.7e-08 $l=2.5e-09 $layer=P_src_drn $thickness=1e-09
+ $X=0.6306 $Y=0.2295 $X2=0.6335 $Y2=0.2295
.ends

.subckt PM_SDFHx1_ASAP7_75t_R%11 vss 22 26 60 63 66 69 11 3 13 15 17 19 4 21 20
+ 10 12 16 1 9 14
c1 1 vss 0.00028627f $X=0.783 $Y=0.131
c2 3 vss 0.00420687f $X=0.594 $Y=0.2295
c3 4 vss 0.00777028f $X=0.648 $Y=0.0405
c4 9 vss 0.0385807f $X=0.783 $Y=0.0245
c5 10 vss 0.0031238f $X=0.6335 $Y=0.0405
c6 11 vss 0.000356791f $X=0.6335 $Y=0.081
c7 12 vss 0.00175685f $X=0.5795 $Y=0.2295
c8 13 vss 0.000297149f $X=0.5795 $Y=0.189
c9 14 vss 0.00296432f $X=0.693 $Y=0.036
c10 15 vss 9.78464e-20 $X=0.693 $Y=0.131
c11 16 vss 0.00264647f $X=0.693 $Y=0.234
c12 17 vss 0.00821472f $X=0.6665 $Y=0.234
c13 18 vss 0.00801163f $X=0.653 $Y=0.036
c14 19 vss 0.00167607f $X=0.693 $Y=0.114
c15 20 vss 0.000494544f $X=0.693 $Y=0.1465
c16 21 vss 0.000810708f $X=0.756 $Y=0.131
r1 13 3 0.231482 $w=5.4e-08 $l=1.25e-08 $layer=P_src_drn $thickness=1e-09
+ $X=0.5795 $Y=0.189 $X2=0.594 $Y2=0.2295
r2 69 68 0.0925926 $w=2.7e-08 $l=2.5e-09 $layer=P_src_drn $thickness=1e-09
+ $X=0.6113 $Y=0.2295 $X2=0.6085 $Y2=0.2295
r3 67 68 0.166667 $w=2.7e-08 $l=4.5e-09 $layer=P_src_drn $thickness=1e-09
+ $X=0.604 $Y=0.2295 $X2=0.6085 $Y2=0.2295
r4 3 67 0.444445 $w=2.7e-08 $l=1.2e-08 $layer=P_src_drn $thickness=1e-09
+ $X=0.594 $Y=0.2295 $X2=0.604 $Y2=0.2295
r5 12 3 0.462963 $w=2.7e-08 $l=1.25e-08 $layer=P_src_drn $thickness=1e-09
+ $X=0.5795 $Y=0.2295 $X2=0.594 $Y2=0.2295
r6 66 12 0.0925926 $w=2.7e-08 $l=2.5e-09 $layer=P_src_drn $thickness=1e-09
+ $X=0.5766 $Y=0.2025 $X2=0.5795 $Y2=0.2295
r7 11 53 0.231482 $w=5.4e-08 $l=1.25e-08 $layer=N_src_drn $thickness=1e-09
+ $X=0.6335 $Y=0.081 $X2=0.648 $Y2=0.0685
r8 63 62 0.0925926 $w=2.7e-08 $l=2.5e-09 $layer=N_src_drn $thickness=1e-09
+ $X=0.6653 $Y=0.0405 $X2=0.6625 $Y2=0.0405
r9 61 62 0.166667 $w=2.7e-08 $l=4.5e-09 $layer=N_src_drn $thickness=1e-09
+ $X=0.658 $Y=0.0405 $X2=0.6625 $Y2=0.0405
r10 53 61 0.444445 $w=2.7e-08 $l=1.2e-08 $layer=N_src_drn $thickness=1e-09
+ $X=0.648 $Y=0.0685 $X2=0.658 $Y2=0.0405
r11 10 53 0.462963 $w=2.7e-08 $l=1.25e-08 $layer=N_src_drn $thickness=1e-09
+ $X=0.6335 $Y=0.0405 $X2=0.648 $Y2=0.0685
r12 60 10 0.0925926 $w=2.7e-08 $l=2.5e-09 $layer=N_src_drn $thickness=1e-09
+ $X=0.6306 $Y=0.0675 $X2=0.6335 $Y2=0.0405
r13 3 52 19.3796 $a=3.24e-16 $layer=V0LISD $X=0.594 $Y=0.2295 $X2=0.59 $Y2=0.234
r14 4 46 19.3796 $a=3.24e-16 $layer=V0LISD $X=0.648 $Y=0.0405 $X2=0.644
+ $Y2=0.036
r15 4 53 16.5033 $w=2.02e-08 $l=2.8e-08 $layer=LISD $thickness=2.7e-08 $X=0.648
+ $Y=0.0405 $X2=0.648 $Y2=0.0685
r16 49 50 1.63233 $w=1.3e-08 $l=7e-09 $layer=M1 $thickness=3.6e-08 $X=0.599
+ $Y=0.234 $X2=0.606 $Y2=0.234
r17 49 52 2.09871 $w=1.3e-08 $l=9e-09 $layer=M1 $thickness=3.6e-08 $X=0.599
+ $Y=0.234 $X2=0.59 $Y2=0.234
r18 48 50 1.04935 $w=1.3e-08 $l=4.5e-09 $layer=M1 $thickness=3.6e-08 $X=0.6105
+ $Y=0.234 $X2=0.606 $Y2=0.234
r19 47 48 4.6638 $w=1.3e-08 $l=2e-08 $layer=M1 $thickness=3.6e-08 $X=0.6305
+ $Y=0.234 $X2=0.6105 $Y2=0.234
r20 17 47 8.39483 $w=1.3e-08 $l=3.6e-08 $layer=M1 $thickness=3.6e-08 $X=0.6665
+ $Y=0.234 $X2=0.6305 $Y2=0.234
r21 18 44 4.08082 $w=1.3e-08 $l=1.75e-08 $layer=M1 $thickness=3.6e-08 $X=0.653
+ $Y=0.036 $X2=0.6705 $Y2=0.036
r22 18 46 2.09871 $w=1.3e-08 $l=9e-09 $layer=M1 $thickness=3.6e-08 $X=0.653
+ $Y=0.036 $X2=0.644 $Y2=0.036
r23 16 43 2.5483 $w=1.79e-08 $l=1.8e-08 $layer=M1 $thickness=3.6e-08 $X=0.693
+ $Y=0.234 $X2=0.693 $Y2=0.216
r24 16 17 4.53042 $w=1.46981e-08 $l=2.65e-08 $layer=M1 $thickness=3.6e-08
+ $X=0.693 $Y=0.234 $X2=0.6665 $Y2=0.234
r25 14 38 2.43171 $w=1.804e-08 $l=1.75e-08 $layer=M1 $thickness=3.6e-08
+ $X=0.693 $Y=0.036 $X2=0.693 $Y2=0.0535
r26 14 44 3.59766 $w=1.5e-08 $l=2.25e-08 $layer=M1 $thickness=3.6e-08 $X=0.693
+ $Y=0.036 $X2=0.6705 $Y2=0.036
r27 42 43 4.19742 $w=1.3e-08 $l=1.8e-08 $layer=M1 $thickness=3.6e-08 $X=0.693
+ $Y=0.198 $X2=0.693 $Y2=0.216
r28 41 42 4.19742 $w=1.3e-08 $l=1.8e-08 $layer=M1 $thickness=3.6e-08 $X=0.693
+ $Y=0.18 $X2=0.693 $Y2=0.198
r29 40 41 2.79828 $w=1.3e-08 $l=1.2e-08 $layer=M1 $thickness=3.6e-08 $X=0.693
+ $Y=0.168 $X2=0.693 $Y2=0.18
r30 39 40 2.09871 $w=1.3e-08 $l=9e-09 $layer=M1 $thickness=3.6e-08 $X=0.693
+ $Y=0.159 $X2=0.693 $Y2=0.168
r31 20 39 2.91487 $w=1.3e-08 $l=1.25e-08 $layer=M1 $thickness=3.6e-08 $X=0.693
+ $Y=0.1465 $X2=0.693 $Y2=0.159
r32 37 38 2.09871 $w=1.3e-08 $l=9e-09 $layer=M1 $thickness=3.6e-08 $X=0.693
+ $Y=0.0625 $X2=0.693 $Y2=0.0535
r33 36 37 2.2153 $w=1.3e-08 $l=9.5e-09 $layer=M1 $thickness=3.6e-08 $X=0.693
+ $Y=0.072 $X2=0.693 $Y2=0.0625
r34 35 36 4.19742 $w=1.3e-08 $l=1.8e-08 $layer=M1 $thickness=3.6e-08 $X=0.693
+ $Y=0.09 $X2=0.693 $Y2=0.072
r35 34 35 2.91487 $w=1.3e-08 $l=1.25e-08 $layer=M1 $thickness=3.6e-08 $X=0.693
+ $Y=0.1025 $X2=0.693 $Y2=0.09
r36 19 34 2.68168 $w=1.3e-08 $l=1.15e-08 $layer=M1 $thickness=3.6e-08 $X=0.693
+ $Y=0.114 $X2=0.693 $Y2=0.1025
r37 15 32 3.01711 $w=1.55e-08 $l=1.8e-08 $layer=M1 $thickness=3.6e-08 $X=0.693
+ $Y=0.131 $X2=0.711 $Y2=0.131
r38 15 19 2.78392 $w=1.56471e-08 $l=1.7e-08 $layer=M1 $thickness=3.6e-08
+ $X=0.693 $Y=0.131 $X2=0.693 $Y2=0.114
r39 15 20 2.43413 $w=1.59032e-08 $l=1.55e-08 $layer=M1 $thickness=3.6e-08
+ $X=0.693 $Y=0.131 $X2=0.693 $Y2=0.1465
r40 31 32 4.19742 $w=1.3e-08 $l=1.8e-08 $layer=M1 $thickness=3.6e-08 $X=0.729
+ $Y=0.131 $X2=0.711 $Y2=0.131
r41 21 30 6.29612 $w=1.3e-08 $l=2.7e-08 $layer=M1 $thickness=3.6e-08 $X=0.756
+ $Y=0.131 $X2=0.783 $Y2=0.131
r42 21 31 6.29612 $w=1.3e-08 $l=2.7e-08 $layer=M1 $thickness=3.6e-08 $X=0.756
+ $Y=0.131 $X2=0.729 $Y2=0.131
r43 1 24 6.54019 $w=2.09524e-08 $layer=Gate_1 $thickness=5.21905e-08 $X=0.783
+ $Y=0.131 $X2=0.783 $Y2=0.131
r44 1 30 19.3796 $a=3.24e-16 $layer=V0LIG $X=0.783 $Y=0.131 $X2=0.783 $Y2=0.131
r45 26 25 17.177 $w=2.1e-08 $l=5.05e-08 $layer=Gate_1 $thickness=5.6e-08
+ $X=0.783 $Y=0.2295 $X2=0.783 $Y2=0.179
r46 24 25 16.5137 $w=2.07708e-08 $l=4.8e-08 $layer=Gate_1 $thickness=5.6e-08
+ $X=0.783 $Y=0.131 $X2=0.783 $Y2=0.179
r47 23 24 15.1532 $w=2.075e-08 $l=4.4e-08 $layer=Gate_1 $thickness=5.6e-08
+ $X=0.783 $Y=0.087 $X2=0.783 $Y2=0.131
r48 22 23 15.8164 $w=2.1e-08 $l=4.65e-08 $layer=Gate_1 $thickness=5.6e-08
+ $X=0.783 $Y=0.0405 $X2=0.783 $Y2=0.087
r49 22 9 5.44221 $w=2.1e-08 $l=1.6e-08 $layer=Gate_1 $thickness=5.6e-08
+ $X=0.783 $Y=0.0405 $X2=0.783 $Y2=0.0245
.ends

.subckt PM_SDFHx1_ASAP7_75t_R%22 vss 2 3 1
c1 1 vss 0.000563126f $X=0.702 $Y=0.0405
r1 2 1 0.62963 $w=2.7e-08 $l=1.7e-08 $layer=N_src_drn $thickness=1e-09
+ $X=0.6846 $Y=0.0405 $X2=0.702 $Y2=0.0405
r2 3 1 0.62963 $w=2.7e-08 $l=1.7e-08 $layer=N_src_drn $thickness=1e-09
+ $X=0.7193 $Y=0.0405 $X2=0.702 $Y2=0.0405
.ends

.subckt PM_SDFHx1_ASAP7_75t_R%23 vss 2 3 1
c1 1 vss 0.000554328f $X=0.972 $Y=0.2295
r1 2 1 0.62963 $w=2.7e-08 $l=1.7e-08 $layer=P_src_drn $thickness=1e-09
+ $X=0.9546 $Y=0.2295 $X2=0.972 $Y2=0.2295
r2 3 1 0.62963 $w=2.7e-08 $l=1.7e-08 $layer=P_src_drn $thickness=1e-09
+ $X=0.9893 $Y=0.2295 $X2=0.972 $Y2=0.2295
.ends

.subckt PM_SDFHx1_ASAP7_75t_R%4 vss 30 34 74 77 81 85 88 90 21 7 22 16 17 8 1
+ 19 25 18 13 24 23 15 3 14 20 2
c1 1 vss 0.00230663f $X=0.135 $Y=0.135
c2 2 vss 0.00237346f $X=0.621 $Y=0.135
c3 3 vss 0.000377767f $X=0.891 $Y=0.135
c4 7 vss 0.00805504f $X=0.054 $Y=0.054
c5 8 vss 0.00785792f $X=0.054 $Y=0.216
c6 13 vss 0.0699761f $X=0.135 $Y=0.135
c7 14 vss 0.0461967f $X=0.621 $Y=0.135
c8 15 vss 0.00706633f $X=0.891 $Y=0.0245
c9 16 vss 0.0309404f $X=0.056 $Y=0.054
c10 17 vss 0.0308844f $X=0.056 $Y=0.216
c11 18 vss 0.00616525f $X=0.03 $Y=0.036
c12 19 vss 0.00612992f $X=0.03 $Y=0.234
c13 20 vss 0.000411192f $X=0.621 $Y=0.162
c14 21 vss 0.0107168f $X=0.03 $Y=0.1215
c15 22 vss 0.000584491f $X=0.135 $Y=0.1235
c16 23 vss 0.0014868f $X=0.621 $Y=0.116
c17 24 vss 0.000767571f $X=0.891 $Y=0.1135
c18 25 vss 0.0219457f $X=0.8125 $Y=0.153
r1 90 89 0.0462963 $w=5.4e-08 $l=2.5e-09 $layer=P_src_drn $thickness=1e-09
+ $X=0.0713 $Y=0.216 $X2=0.0685 $Y2=0.216
r2 17 89 0.231482 $w=5.4e-08 $l=1.25e-08 $layer=P_src_drn $thickness=1e-09
+ $X=0.056 $Y=0.216 $X2=0.0685 $Y2=0.216
r3 88 87 0.0462963 $w=5.4e-08 $l=2.5e-09 $layer=N_src_drn $thickness=1e-09
+ $X=0.0713 $Y=0.054 $X2=0.0685 $Y2=0.054
r4 16 87 0.231482 $w=5.4e-08 $l=1.25e-08 $layer=N_src_drn $thickness=1e-09
+ $X=0.056 $Y=0.054 $X2=0.0685 $Y2=0.054
r5 85 84 14.6259 $w=2.1e-08 $l=4.3e-08 $layer=Gate_1 $thickness=5.6e-08
+ $X=0.135 $Y=0.216 $X2=0.135 $Y2=0.173
r6 83 84 7.31297 $w=2.1e-08 $l=2.15e-08 $layer=Gate_1 $thickness=5.6e-08
+ $X=0.135 $Y=0.1515 $X2=0.135 $Y2=0.173
r7 81 82 14.6259 $w=2.1e-08 $l=4.3e-08 $layer=Gate_1 $thickness=5.6e-08
+ $X=0.135 $Y=0.054 $X2=0.135 $Y2=0.097
r8 79 82 7.31297 $w=2.1e-08 $l=2.15e-08 $layer=Gate_1 $thickness=5.6e-08
+ $X=0.135 $Y=0.1185 $X2=0.135 $Y2=0.097
r9 13 79 5.79936 $w=2.03333e-08 $l=1.65e-08 $layer=Gate_1 $thickness=5.6e-08
+ $X=0.135 $Y=0.135 $X2=0.135 $Y2=0.1185
r10 13 83 5.79936 $w=2.03333e-08 $l=1.65e-08 $layer=Gate_1 $thickness=5.6e-08
+ $X=0.135 $Y=0.135 $X2=0.135 $Y2=0.1515
r11 8 71 19.3796 $a=3.24e-16 $layer=V0LISD $X=0.054 $Y=0.216 $X2=0.054 $Y2=0.234
r12 7 68 19.3796 $a=3.24e-16 $layer=V0LISD $X=0.054 $Y=0.054 $X2=0.054 $Y2=0.036
r13 77 76 16.4967 $w=2.1e-08 $l=4.85e-08 $layer=Gate_1 $thickness=5.6e-08
+ $X=0.621 $Y=0.2295 $X2=0.621 $Y2=0.181
r14 74 75 16.4967 $w=2.1e-08 $l=4.85e-08 $layer=Gate_1 $thickness=5.6e-08
+ $X=0.621 $Y=0.0675 $X2=0.621 $Y2=0.116
r15 14 75 6.6497 $w=2.04211e-08 $l=1.9e-08 $layer=Gate_1 $thickness=5.6e-08
+ $X=0.621 $Y=0.135 $X2=0.621 $Y2=0.116
r16 14 76 15.8334 $w=2.07609e-08 $l=4.6e-08 $layer=Gate_1 $thickness=5.6e-08
+ $X=0.621 $Y=0.135 $X2=0.621 $Y2=0.181
r17 1 63 19.3796 $a=3.24e-16 $layer=V0LIG $X=0.135 $Y=0.135 $X2=0.135 $Y2=0.144
r18 1 13 10.4265 $w=1.765e-08 $layer=LIG $thickness=5.2e-08 $X=0.135 $Y=0.135
+ $X2=0.135 $Y2=0.135
r19 70 71 2.79828 $w=1.3e-08 $l=1.2e-08 $layer=M1 $thickness=3.6e-08 $X=0.042
+ $Y=0.234 $X2=0.054 $Y2=0.234
r20 19 62 3.48349 $w=1.525e-08 $l=2e-08 $layer=M1 $thickness=3.6e-08 $X=0.03
+ $Y=0.234 $X2=0.03 $Y2=0.214
r21 19 70 1.61797 $w=1.675e-08 $l=1.2e-08 $layer=M1 $thickness=3.6e-08 $X=0.03
+ $Y=0.234 $X2=0.042 $Y2=0.234
r22 67 68 2.79828 $w=1.3e-08 $l=1.2e-08 $layer=M1 $thickness=3.6e-08 $X=0.042
+ $Y=0.036 $X2=0.054 $Y2=0.036
r23 18 60 5.11582 $w=1.46667e-08 $l=2.7e-08 $layer=M1 $thickness=3.6e-08
+ $X=0.03 $Y=0.036 $X2=0.03 $Y2=0.063
r24 18 67 1.61797 $w=1.675e-08 $l=1.2e-08 $layer=M1 $thickness=3.6e-08 $X=0.03
+ $Y=0.036 $X2=0.042 $Y2=0.036
r25 2 56 19.3796 $a=3.24e-16 $layer=V0LIG $X=0.621 $Y=0.135 $X2=0.621 $Y2=0.1395
r26 2 14 6.54019 $w=2.09524e-08 $layer=Gate_1 $thickness=5.21905e-08 $X=0.621
+ $Y=0.135 $X2=0.621 $Y2=0.135
r27 22 63 4.78039 $w=1.3e-08 $l=2.05e-08 $layer=M1 $thickness=3.6e-08 $X=0.135
+ $Y=0.1235 $X2=0.135 $Y2=0.144
r28 61 62 4.6638 $w=1.3e-08 $l=2e-08 $layer=M1 $thickness=3.6e-08 $X=0.03
+ $Y=0.194 $X2=0.03 $Y2=0.214
r29 59 60 6.29612 $w=1.3e-08 $l=2.7e-08 $layer=M1 $thickness=3.6e-08 $X=0.03
+ $Y=0.09 $X2=0.03 $Y2=0.063
r30 58 61 4.78039 $w=1.3e-08 $l=2.05e-08 $layer=M1 $thickness=3.6e-08 $X=0.03
+ $Y=0.1735 $X2=0.03 $Y2=0.194
r31 57 58 4.78039 $w=1.3e-08 $l=2.05e-08 $layer=M1 $thickness=3.6e-08 $X=0.03
+ $Y=0.153 $X2=0.03 $Y2=0.1735
r32 21 57 7.34548 $w=1.3e-08 $l=3.15e-08 $layer=M1 $thickness=3.6e-08 $X=0.03
+ $Y=0.1215 $X2=0.03 $Y2=0.153
r33 21 59 7.34548 $w=1.3e-08 $l=3.15e-08 $layer=M1 $thickness=3.6e-08 $X=0.03
+ $Y=0.1215 $X2=0.03 $Y2=0.09
r34 23 56 5.47996 $w=1.3e-08 $l=2.35e-08 $layer=M1 $thickness=3.6e-08 $X=0.621
+ $Y=0.116 $X2=0.621 $Y2=0.1395
r35 20 42 39.0693 $a=1.62e-16 $layer=V1 $X=0.621 $Y=0.162 $X2=0.621 $Y2=0.153
r36 20 56 4.06646 $w=1.5e-08 $l=2.25e-08 $layer=M1 $thickness=3.6e-08 $X=0.621
+ $Y=0.162 $X2=0.621 $Y2=0.1395
r37 52 53 5.71315 $w=1.3e-08 $l=2.45e-08 $layer=M2 $thickness=3.6e-08 $X=0.135
+ $Y=0.153 $X2=0.1595 $Y2=0.153
r38 52 63 19.5347 $a=3.24e-16 $layer=V1 $X=0.135 $Y=0.153 $X2=0.135 $Y2=0.144
r39 51 52 12.2425 $w=1.3e-08 $l=5.25e-08 $layer=M2 $thickness=3.6e-08 $X=0.0825
+ $Y=0.153 $X2=0.135 $Y2=0.153
r40 50 51 12.2425 $w=1.3e-08 $l=5.25e-08 $layer=M2 $thickness=3.6e-08 $X=0.03
+ $Y=0.153 $X2=0.0825 $Y2=0.153
r41 50 57 19.5347 $a=3.24e-16 $layer=V1 $X=0.03 $Y=0.153 $X2=0.03 $Y2=0.153
r42 48 53 7.81186 $w=1.3e-08 $l=3.35e-08 $layer=M2 $thickness=3.6e-08 $X=0.193
+ $Y=0.153 $X2=0.1595 $Y2=0.153
r43 47 48 12.7088 $w=1.3e-08 $l=5.45e-08 $layer=M2 $thickness=3.6e-08 $X=0.2475
+ $Y=0.153 $X2=0.193 $Y2=0.153
r44 46 47 26.2338 $w=1.3e-08 $l=1.125e-07 $layer=M2 $thickness=3.6e-08 $X=0.36
+ $Y=0.153 $X2=0.2475 $Y2=0.153
r45 45 46 21.3369 $w=1.3e-08 $l=9.15e-08 $layer=M2 $thickness=3.6e-08 $X=0.4515
+ $Y=0.153 $X2=0.36 $Y2=0.153
r46 44 45 17.9556 $w=1.3e-08 $l=7.7e-08 $layer=M2 $thickness=3.6e-08 $X=0.5285
+ $Y=0.153 $X2=0.4515 $Y2=0.153
r47 42 43 15.2739 $w=1.3e-08 $l=6.55e-08 $layer=M2 $thickness=3.6e-08 $X=0.621
+ $Y=0.153 $X2=0.6865 $Y2=0.153
r48 42 56 39.0693 $a=1.62e-16 $layer=V1 $X=0.621 $Y=0.153 $X2=0.621 $Y2=0.1395
r49 41 42 4.6638 $w=1.3e-08 $l=2e-08 $layer=M2 $thickness=3.6e-08 $X=0.601
+ $Y=0.153 $X2=0.621 $Y2=0.153
r50 41 44 16.9063 $w=1.3e-08 $l=7.25e-08 $layer=M2 $thickness=3.6e-08 $X=0.601
+ $Y=0.153 $X2=0.5285 $Y2=0.153
r51 25 40 18.3054 $w=1.3e-08 $l=7.85e-08 $layer=M2 $thickness=3.6e-08 $X=0.8125
+ $Y=0.153 $X2=0.891 $Y2=0.153
r52 25 43 29.3819 $w=1.3e-08 $l=1.26e-07 $layer=M2 $thickness=3.6e-08 $X=0.8125
+ $Y=0.153 $X2=0.6865 $Y2=0.153
r53 38 40 19.5347 $a=3.24e-16 $layer=V1 $X=0.891 $Y=0.144 $X2=0.891 $Y2=0.153
r54 24 38 7.11229 $w=1.3e-08 $l=3.05e-08 $layer=M1 $thickness=3.6e-08 $X=0.891
+ $Y=0.1135 $X2=0.891 $Y2=0.144
r55 3 32 6.54019 $w=2.09524e-08 $layer=Gate_1 $thickness=5.21905e-08 $X=0.891
+ $Y=0.135 $X2=0.891 $Y2=0.135
r56 3 38 19.3796 $a=3.24e-16 $layer=V0LIG $X=0.891 $Y=0.135 $X2=0.891 $Y2=0.144
r57 34 33 16.4967 $w=2.1e-08 $l=4.85e-08 $layer=Gate_1 $thickness=5.6e-08
+ $X=0.891 $Y=0.2295 $X2=0.891 $Y2=0.181
r58 32 33 15.8334 $w=2.07609e-08 $l=4.6e-08 $layer=Gate_1 $thickness=5.6e-08
+ $X=0.891 $Y=0.135 $X2=0.891 $Y2=0.181
r59 31 32 15.8334 $w=2.07609e-08 $l=4.6e-08 $layer=Gate_1 $thickness=5.6e-08
+ $X=0.891 $Y=0.089 $X2=0.891 $Y2=0.135
r60 30 31 16.4967 $w=2.1e-08 $l=4.85e-08 $layer=Gate_1 $thickness=5.6e-08
+ $X=0.891 $Y=0.0405 $X2=0.891 $Y2=0.089
r61 30 15 5.44221 $w=2.1e-08 $l=1.6e-08 $layer=Gate_1 $thickness=5.6e-08
+ $X=0.891 $Y=0.0405 $X2=0.891 $Y2=0.0245
r62 8 17 1e-05 $l=2e-09 $X=0.054 $Y=0.216 $X2=0.056 $Y2=0.216
r63 7 16 1e-05 $l=2e-09 $X=0.054 $Y=0.054 $X2=0.056 $Y2=0.054
.ends

.subckt PM_SDFHx1_ASAP7_75t_R%SE vss 36 16 22 50 54 11 7 8 10 13 6 9 12 1 2 5
c1 1 vss 0.00483828f $X=0.297 $Y=0.135
c2 2 vss 0.00489023f $X=1.215 $Y=0.136
c3 5 vss 0.0855718f $X=0.297 $Y=0.135
c4 6 vss 0.0981301f $X=1.215 $Y=0.0245
c5 7 vss 0.00774846f $X=0.225 $Y=0.036
c6 8 vss 0.000503238f $X=0.225 $Y=0.135
c7 9 vss 0.00650815f $X=1.215 $Y=0.036
c8 10 vss 0.0043336f $X=0.225 $Y=0.0495
c9 11 vss 0.00331155f $X=0.2445 $Y=0.135
c10 12 vss 0.00402499f $X=1.215 $Y=0.0495
c11 13 vss 0.0538622f $X=1.1905 $Y=0.045
r1 54 53 14.6259 $w=2.1e-08 $l=4.3e-08 $layer=Gate_1 $thickness=5.6e-08
+ $X=0.297 $Y=0.2025 $X2=0.297 $Y2=0.1595
r2 52 53 2.7211 $w=2.1e-08 $l=8e-09 $layer=Gate_1 $thickness=5.6e-08 $X=0.297
+ $Y=0.1515 $X2=0.297 $Y2=0.1595
r3 50 51 14.6259 $w=2.1e-08 $l=4.3e-08 $layer=Gate_1 $thickness=5.6e-08
+ $X=0.297 $Y=0.0675 $X2=0.297 $Y2=0.1105
r4 48 51 2.7211 $w=2.1e-08 $l=8e-09 $layer=Gate_1 $thickness=5.6e-08 $X=0.297
+ $Y=0.1185 $X2=0.297 $Y2=0.1105
r5 5 48 5.79936 $w=2.03333e-08 $l=1.65e-08 $layer=Gate_1 $thickness=5.6e-08
+ $X=0.297 $Y=0.135 $X2=0.297 $Y2=0.1185
r6 5 52 5.79936 $w=2.03333e-08 $l=1.65e-08 $layer=Gate_1 $thickness=5.6e-08
+ $X=0.297 $Y=0.135 $X2=0.297 $Y2=0.1515
r7 1 45 19.3796 $a=3.24e-16 $layer=V0LIG $X=0.297 $Y=0.135 $X2=0.297 $Y2=0.135
r8 1 5 10.4265 $w=1.765e-08 $layer=LIG $thickness=5.2e-08 $X=0.297 $Y=0.135
+ $X2=0.297 $Y2=0.135
r9 44 45 5.24677 $w=1.3e-08 $l=2.25e-08 $layer=M1 $thickness=3.6e-08 $X=0.2745
+ $Y=0.135 $X2=0.297 $Y2=0.135
r10 43 44 3.49785 $w=1.3e-08 $l=1.5e-08 $layer=M1 $thickness=3.6e-08 $X=0.2595
+ $Y=0.135 $X2=0.2745 $Y2=0.135
r11 42 43 0.699569 $w=1.3e-08 $l=3e-09 $layer=M1 $thickness=3.6e-08 $X=0.2565
+ $Y=0.135 $X2=0.2595 $Y2=0.135
r12 11 42 2.79828 $w=1.3e-08 $l=1.2e-08 $layer=M1 $thickness=3.6e-08 $X=0.2445
+ $Y=0.135 $X2=0.2565 $Y2=0.135
r13 8 41 3.59766 $w=1.692e-08 $l=2.25e-08 $layer=M1 $thickness=3.6e-08 $X=0.225
+ $Y=0.135 $X2=0.225 $Y2=0.1125
r14 8 11 2.89809 $w=1.53077e-08 $l=1.95e-08 $layer=M1 $thickness=3.6e-08
+ $X=0.225 $Y=0.135 $X2=0.2445 $Y2=0.135
r15 40 41 5.24677 $w=1.3e-08 $l=2.25e-08 $layer=M1 $thickness=3.6e-08 $X=0.225
+ $Y=0.09 $X2=0.225 $Y2=0.1125
r16 39 40 5.24677 $w=1.3e-08 $l=2.25e-08 $layer=M1 $thickness=3.6e-08 $X=0.225
+ $Y=0.0675 $X2=0.225 $Y2=0.09
r17 10 39 4.19742 $w=1.3e-08 $l=1.8e-08 $layer=M1 $thickness=3.6e-08 $X=0.225
+ $Y=0.0495 $X2=0.225 $Y2=0.0675
r18 36 10 39.0693 $a=1.62e-16 $layer=V1 $X=0.227 $Y=0.046 $X2=0.225 $Y2=0.0495
r19 36 7 39.0693 $a=1.62e-16 $layer=V1 $X=0.227 $Y=0.046 $X2=0.225 $Y2=0.036
r20 7 10 1.96775 $w=1.63333e-08 $l=1.35e-08 $layer=M1 $thickness=3.6e-08
+ $X=0.225 $Y=0.036 $X2=0.225 $Y2=0.0495
r21 36 37 7.92845 $w=1.3e-08 $l=3.4e-08 $layer=M2 $thickness=3.6e-08 $X=0.227
+ $Y=0.046 $X2=0.259 $Y2=0.045
r22 34 37 12.0093 $w=1.3e-08 $l=5.15e-08 $layer=M2 $thickness=3.6e-08 $X=0.3105
+ $Y=0.045 $X2=0.259 $Y2=0.045
r23 33 34 103.886 $w=1.3e-08 $l=4.455e-07 $layer=M2 $thickness=3.6e-08 $X=0.756
+ $Y=0.045 $X2=0.3105 $Y2=0.045
r24 13 31 5.71315 $w=1.3e-08 $l=2.45e-08 $layer=M2 $thickness=3.6e-08 $X=1.1905
+ $Y=0.045 $X2=1.215 $Y2=0.045
r25 13 33 101.321 $w=1.3e-08 $l=4.345e-07 $layer=M2 $thickness=3.6e-08
+ $X=1.1905 $Y=0.045 $X2=0.756 $Y2=0.045
r26 9 12 1.96775 $w=1.63333e-08 $l=1.35e-08 $layer=M1 $thickness=3.6e-08
+ $X=1.215 $Y=0.036 $X2=1.215 $Y2=0.0495
r27 9 31 39.0693 $a=1.62e-16 $layer=V1 $X=1.215 $Y=0.036 $X2=1.215 $Y2=0.045
r28 27 28 6.41272 $w=1.3e-08 $l=2.75e-08 $layer=M1 $thickness=3.6e-08 $X=1.215
+ $Y=0.1085 $X2=1.215 $Y2=0.136
r29 26 27 8.51143 $w=1.3e-08 $l=3.65e-08 $layer=M1 $thickness=3.6e-08 $X=1.215
+ $Y=0.072 $X2=1.215 $Y2=0.1085
r30 12 26 5.24677 $w=1.3e-08 $l=2.25e-08 $layer=M1 $thickness=3.6e-08 $X=1.215
+ $Y=0.0495 $X2=1.215 $Y2=0.072
r31 12 31 39.0693 $a=1.62e-16 $layer=V1 $X=1.215 $Y=0.0495 $X2=1.215 $Y2=0.045
r32 2 19 6.54019 $w=2.09524e-08 $layer=Gate_1 $thickness=5.21905e-08 $X=1.215
+ $Y=0.136 $X2=1.215 $Y2=0.136
r33 2 28 19.3796 $a=3.24e-16 $layer=V0LIG $X=1.215 $Y=0.136 $X2=1.215 $Y2=0.136
r34 22 21 14.6259 $w=2.1e-08 $l=4.3e-08 $layer=Gate_1 $thickness=5.6e-08
+ $X=1.215 $Y=0.2295 $X2=1.215 $Y2=0.1865
r35 20 21 11.7348 $w=2.1e-08 $l=3.45e-08 $layer=Gate_1 $thickness=5.6e-08
+ $X=1.215 $Y=0.152 $X2=1.215 $Y2=0.1865
r36 19 20 5.62929 $w=2.03125e-08 $l=1.6e-08 $layer=Gate_1 $thickness=5.6e-08
+ $X=1.215 $Y=0.136 $X2=1.215 $Y2=0.152
r37 18 19 5.96942 $w=2.03529e-08 $l=1.7e-08 $layer=Gate_1 $thickness=5.6e-08
+ $X=1.215 $Y=0.119 $X2=1.215 $Y2=0.136
r38 17 18 12.0749 $w=2.1e-08 $l=3.55e-08 $layer=Gate_1 $thickness=5.6e-08
+ $X=1.215 $Y=0.0835 $X2=1.215 $Y2=0.119
r39 16 17 14.6259 $w=2.1e-08 $l=4.3e-08 $layer=Gate_1 $thickness=5.6e-08
+ $X=1.215 $Y=0.0405 $X2=1.215 $Y2=0.0835
r40 16 6 5.44221 $w=2.1e-08 $l=1.6e-08 $layer=Gate_1 $thickness=5.6e-08
+ $X=1.215 $Y=0.0405 $X2=1.215 $Y2=0.0245
.ends

.subckt PM_SDFHx1_ASAP7_75t_R%6 vss 19 23 53 55 16 14 10 11 15 4 3 1 12 13 9
c1 1 vss 0.00456352f $X=0.351 $Y=0.135
c2 3 vss 0.011312f $X=1.1485 $Y=0.0455
c3 4 vss 0.00657298f $X=1.188 $Y=0.2295
c4 9 vss 0.102099f $X=0.351 $Y=0.0245
c5 10 vss 0.0183841f $X=1.19 $Y=0.0405
c6 11 vss 0.0194078f $X=1.19 $Y=0.2295
c7 12 vss 0.00706377f $X=0.351 $Y=0.072
c8 13 vss 0.00630514f $X=1.161 $Y=0.234
c9 14 vss 0.00330592f $X=0.351 $Y=0.135
c10 15 vss 0.00508602f $X=1.161 $Y=0.037
c11 16 vss 0.01725f $X=0.3395 $Y=0.081
r1 55 54 0.0925926 $w=2.7e-08 $l=2.5e-09 $layer=P_src_drn $thickness=1e-09
+ $X=1.2053 $Y=0.2295 $X2=1.2025 $Y2=0.2295
r2 11 54 0.462963 $w=2.7e-08 $l=1.25e-08 $layer=P_src_drn $thickness=1e-09
+ $X=1.19 $Y=0.2295 $X2=1.2025 $Y2=0.2295
r3 4 50 19.3796 $a=3.24e-16 $layer=V0LISD $X=1.188 $Y=0.2295 $X2=1.188 $Y2=0.234
r4 53 52 0.0925926 $w=2.7e-08 $l=2.5e-09 $layer=N_src_drn $thickness=1e-09
+ $X=1.2053 $Y=0.0405 $X2=1.2025 $Y2=0.0405
r5 10 52 0.462963 $w=2.7e-08 $l=1.25e-08 $layer=N_src_drn $thickness=1e-09
+ $X=1.19 $Y=0.0405 $X2=1.2025 $Y2=0.0405
r6 49 50 3.14806 $w=1.3e-08 $l=1.35e-08 $layer=M1 $thickness=3.6e-08 $X=1.1745
+ $Y=0.234 $X2=1.188 $Y2=0.234
r7 13 45 3.83327 $w=1.5093e-08 $l=2.15e-08 $layer=M1 $thickness=3.6e-08
+ $X=1.161 $Y=0.234 $X2=1.161 $Y2=0.2125
r8 13 49 1.96775 $w=1.63333e-08 $l=1.35e-08 $layer=M1 $thickness=3.6e-08
+ $X=1.161 $Y=0.234 $X2=1.1745 $Y2=0.234
r9 47 10 3.98201 $w=3.32e-08 $l=1.5e-08 $layer=LISD $thickness=2.7e-08 $X=1.173
+ $Y=0.0455 $X2=1.19 $Y2=0.0405
r10 46 47 3.18561 $w=3.32e-08 $l=1.2e-08 $layer=LISD $thickness=2.7e-08
+ $X=1.161 $Y=0.0455 $X2=1.173 $Y2=0.0455
r11 3 46 3.31834 $w=3.32e-08 $l=1.25e-08 $layer=LISD $thickness=2.7e-08
+ $X=1.1485 $Y=0.0455 $X2=1.161 $Y2=0.0455
r12 44 45 15.7403 $w=1.3e-08 $l=6.75e-08 $layer=M1 $thickness=3.6e-08 $X=1.161
+ $Y=0.145 $X2=1.161 $Y2=0.2125
r13 43 44 14.9241 $w=1.3e-08 $l=6.4e-08 $layer=M1 $thickness=3.6e-08 $X=1.161
+ $Y=0.081 $X2=1.161 $Y2=0.145
r14 42 43 3.73104 $w=1.3e-08 $l=1.6e-08 $layer=M1 $thickness=3.6e-08 $X=1.161
+ $Y=0.065 $X2=1.161 $Y2=0.081
r15 41 42 3.14806 $w=1.3e-08 $l=1.35e-08 $layer=M1 $thickness=3.6e-08 $X=1.161
+ $Y=0.0515 $X2=1.161 $Y2=0.065
r16 41 46 19.3796 $a=3.24e-16 $layer=V0LISD $X=1.161 $Y=0.0515 $X2=1.161
+ $Y2=0.0455
r17 40 41 2.09871 $w=1.3e-08 $l=9e-09 $layer=M1 $thickness=3.6e-08 $X=1.161
+ $Y=0.0425 $X2=1.161 $Y2=0.0515
r18 15 40 1.28254 $w=1.3e-08 $l=5.5e-09 $layer=M1 $thickness=3.6e-08 $X=1.161
+ $Y=0.037 $X2=1.161 $Y2=0.0425
r19 38 43 19.5347 $a=3.24e-16 $layer=V1 $X=1.161 $Y=0.081 $X2=1.161 $Y2=0.081
r20 37 38 27.2832 $w=1.3e-08 $l=1.17e-07 $layer=M2 $thickness=3.6e-08 $X=1.044
+ $Y=0.081 $X2=1.161 $Y2=0.081
r21 36 37 29.3819 $w=1.3e-08 $l=1.26e-07 $layer=M2 $thickness=3.6e-08 $X=0.918
+ $Y=0.081 $X2=1.044 $Y2=0.081
r22 35 36 40.3418 $w=1.3e-08 $l=1.73e-07 $layer=M2 $thickness=3.6e-08 $X=0.745
+ $Y=0.081 $X2=0.918 $Y2=0.081
r23 34 35 50.4856 $w=1.3e-08 $l=2.165e-07 $layer=M2 $thickness=3.6e-08
+ $X=0.5285 $Y=0.081 $X2=0.745 $Y2=0.081
r24 33 34 17.9556 $w=1.3e-08 $l=7.7e-08 $layer=M2 $thickness=3.6e-08 $X=0.4515
+ $Y=0.081 $X2=0.5285 $Y2=0.081
r25 32 33 12.4757 $w=1.3e-08 $l=5.35e-08 $layer=M2 $thickness=3.6e-08 $X=0.398
+ $Y=0.081 $X2=0.4515 $Y2=0.081
r26 31 32 10.9599 $w=1.3e-08 $l=4.7e-08 $layer=M2 $thickness=3.6e-08 $X=0.351
+ $Y=0.081 $X2=0.398 $Y2=0.081
r27 16 31 2.68168 $w=1.3e-08 $l=1.15e-08 $layer=M2 $thickness=3.6e-08 $X=0.3395
+ $Y=0.081 $X2=0.351 $Y2=0.081
r28 12 27 1.96775 $w=1.63333e-08 $l=1.35e-08 $layer=M1 $thickness=3.6e-08
+ $X=0.351 $Y=0.072 $X2=0.351 $Y2=0.0855
r29 12 31 39.0693 $a=1.62e-16 $layer=V1 $X=0.351 $Y=0.072 $X2=0.351 $Y2=0.081
r30 27 28 2.09871 $w=1.3e-08 $l=9e-09 $layer=M1 $thickness=3.6e-08 $X=0.351
+ $Y=0.0855 $X2=0.351 $Y2=0.0945
r31 27 31 39.0693 $a=1.62e-16 $layer=V1 $X=0.351 $Y=0.0855 $X2=0.351 $Y2=0.081
r32 26 28 1.86552 $w=1.3e-08 $l=8e-09 $layer=M1 $thickness=3.6e-08 $X=0.351
+ $Y=0.1025 $X2=0.351 $Y2=0.0945
r33 25 26 3.14806 $w=1.3e-08 $l=1.35e-08 $layer=M1 $thickness=3.6e-08 $X=0.351
+ $Y=0.116 $X2=0.351 $Y2=0.1025
r34 14 25 4.43061 $w=1.3e-08 $l=1.9e-08 $layer=M1 $thickness=3.6e-08 $X=0.351
+ $Y=0.135 $X2=0.351 $Y2=0.116
r35 1 21 10.4265 $w=1.765e-08 $layer=LIG $thickness=5.2e-08 $X=0.351 $Y=0.135
+ $X2=0.351 $Y2=0.135
r36 1 14 19.3796 $a=3.24e-16 $layer=V0LIG $X=0.351 $Y=0.135 $X2=0.351 $Y2=0.135
r37 23 22 16.4967 $w=2.1e-08 $l=4.85e-08 $layer=Gate_1 $thickness=5.6e-08
+ $X=0.351 $Y=0.2025 $X2=0.351 $Y2=0.154
r38 21 22 6.6497 $w=2.04211e-08 $l=1.9e-08 $layer=Gate_1 $thickness=5.6e-08
+ $X=0.351 $Y=0.135 $X2=0.351 $Y2=0.154
r39 20 21 6.6497 $w=2.04211e-08 $l=1.9e-08 $layer=Gate_1 $thickness=5.6e-08
+ $X=0.351 $Y=0.116 $X2=0.351 $Y2=0.135
r40 19 20 16.4967 $w=2.1e-08 $l=4.85e-08 $layer=Gate_1 $thickness=5.6e-08
+ $X=0.351 $Y=0.0675 $X2=0.351 $Y2=0.116
r41 19 9 14.6259 $w=2.1e-08 $l=4.3e-08 $layer=Gate_1 $thickness=5.6e-08
+ $X=0.351 $Y=0.0675 $X2=0.351 $Y2=0.0245
r42 4 11 1e-05 $l=2e-09 $X=1.188 $Y=0.2295 $X2=1.19 $Y2=0.2295
.ends

.subckt PM_SDFHx1_ASAP7_75t_R%9 vss 30 56 61 91 94 96 23 7 6 20 21 18 19 3 4 25
+ 22 8 2 26 1 14 24 16 15 17
c1 1 vss 0.00354317f $X=0.567 $Y=0.1355
c2 2 vss 0.000100108f $X=0.675 $Y=0.178
c3 3 vss 4.41908e-20 $X=0.837 $Y=0.178
c4 4 vss 0.000790435f $X=0.945 $Y=0.178
c5 6 vss 0.00773517f $X=0.162 $Y=0.054
c6 7 vss 0.00744558f $X=0.162 $Y=0.216
c7 8 vss 0.00560059f $X=0.837 $Y=0.178
c8 14 vss 0.0596277f $X=0.567 $Y=0.1355
c9 15 vss 0.00667859f $X=0.675 $Y=0.178
c10 16 vss 0.00620026f $X=0.837 $Y=0.0245
c11 17 vss 0.00746686f $X=0.945 $Y=0.178
c12 18 vss 0.0346375f $X=0.1475 $Y=0.054
c13 19 vss 0.0344167f $X=0.1475 $Y=0.216
c14 20 vss 0.00566087f $X=0.189 $Y=0.036
c15 21 vss 0.00610798f $X=0.189 $Y=0.234
c16 22 vss 0.00122995f $X=0.567 $Y=0.198
c17 23 vss 0.00499307f $X=0.189 $Y=0.187
c18 24 vss 0.00370305f $X=0.567 $Y=0.1755
c19 25 vss 0.00143054f $X=0.729 $Y=0.168
c20 26 vss 0.0332004f $X=0.1775 $Y=0.189
r1 19 7 0.231482 $w=5.4e-08 $l=1.25e-08 $layer=P_src_drn $thickness=1e-09
+ $X=0.1475 $Y=0.216 $X2=0.162 $Y2=0.216
r2 96 19 0.0462963 $w=5.4e-08 $l=2.5e-09 $layer=P_src_drn $thickness=1e-09
+ $X=0.1446 $Y=0.216 $X2=0.1475 $Y2=0.216
r3 18 6 0.231482 $w=5.4e-08 $l=1.25e-08 $layer=N_src_drn $thickness=1e-09
+ $X=0.1475 $Y=0.054 $X2=0.162 $Y2=0.054
r4 94 18 0.0462963 $w=5.4e-08 $l=2.5e-09 $layer=N_src_drn $thickness=1e-09
+ $X=0.1446 $Y=0.054 $X2=0.1475 $Y2=0.054
r5 91 90 16.4967 $w=2.1e-08 $l=4.85e-08 $layer=Gate_1 $thickness=5.6e-08
+ $X=0.567 $Y=0.2025 $X2=0.567 $Y2=0.154
r6 14 90 6.47113 $w=2.04324e-08 $l=1.85e-08 $layer=Gate_1 $thickness=5.6e-08
+ $X=0.567 $Y=0.1355 $X2=0.567 $Y2=0.154
r7 7 85 19.3796 $a=3.24e-16 $layer=V0LISD $X=0.162 $Y=0.216 $X2=0.162 $Y2=0.234
r8 6 82 19.3796 $a=3.24e-16 $layer=V0LISD $X=0.162 $Y=0.054 $X2=0.162 $Y2=0.036
r9 1 79 19.3796 $a=3.24e-16 $layer=V0LIG $X=0.567 $Y=0.1355 $X2=0.567 $Y2=0.135
r10 1 14 6.63025 $w=2.04878e-08 $layer=Gate_1 $thickness=5.20976e-08 $X=0.567
+ $Y=0.1355 $X2=0.567 $Y2=0.1355
r11 85 86 3.14806 $w=1.3e-08 $l=1.35e-08 $layer=M1 $thickness=3.6e-08 $X=0.162
+ $Y=0.234 $X2=0.1755 $Y2=0.234
r12 21 73 3.01711 $w=1.55e-08 $l=1.8e-08 $layer=M1 $thickness=3.6e-08 $X=0.189
+ $Y=0.234 $X2=0.189 $Y2=0.216
r13 21 86 1.96775 $w=1.63333e-08 $l=1.35e-08 $layer=M1 $thickness=3.6e-08
+ $X=0.189 $Y=0.234 $X2=0.1755 $Y2=0.234
r14 82 83 3.14806 $w=1.3e-08 $l=1.35e-08 $layer=M1 $thickness=3.6e-08 $X=0.162
+ $Y=0.036 $X2=0.1755 $Y2=0.036
r15 20 70 5.11582 $w=1.46667e-08 $l=2.7e-08 $layer=M1 $thickness=3.6e-08
+ $X=0.189 $Y=0.036 $X2=0.189 $Y2=0.063
r16 20 83 1.96775 $w=1.63333e-08 $l=1.35e-08 $layer=M1 $thickness=3.6e-08
+ $X=0.189 $Y=0.036 $X2=0.1755 $Y2=0.036
r17 79 80 3.14806 $w=1.3e-08 $l=1.35e-08 $layer=M1 $thickness=3.6e-08 $X=0.567
+ $Y=0.135 $X2=0.567 $Y2=0.1485
r18 77 80 3.14806 $w=1.3e-08 $l=1.35e-08 $layer=M1 $thickness=3.6e-08 $X=0.567
+ $Y=0.162 $X2=0.567 $Y2=0.1485
r19 24 76 2.09871 $w=1.3e-08 $l=9e-09 $layer=M1 $thickness=3.6e-08 $X=0.567
+ $Y=0.1755 $X2=0.567 $Y2=0.1845
r20 24 77 3.14806 $w=1.3e-08 $l=1.35e-08 $layer=M1 $thickness=3.6e-08 $X=0.567
+ $Y=0.1755 $X2=0.567 $Y2=0.162
r21 22 51 39.0693 $a=1.62e-16 $layer=V1 $X=0.567 $Y=0.198 $X2=0.567 $Y2=0.189
r22 22 76 1.96775 $w=1.63333e-08 $l=1.35e-08 $layer=M1 $thickness=3.6e-08
+ $X=0.567 $Y=0.198 $X2=0.567 $Y2=0.1845
r23 72 73 3.14806 $w=1.3e-08 $l=1.35e-08 $layer=M1 $thickness=3.6e-08 $X=0.189
+ $Y=0.2025 $X2=0.189 $Y2=0.216
r24 71 72 2.09871 $w=1.3e-08 $l=9e-09 $layer=M1 $thickness=3.6e-08 $X=0.189
+ $Y=0.1935 $X2=0.189 $Y2=0.2025
r25 69 70 6.29612 $w=1.3e-08 $l=2.7e-08 $layer=M1 $thickness=3.6e-08 $X=0.189
+ $Y=0.09 $X2=0.189 $Y2=0.063
r26 68 69 4.6638 $w=1.3e-08 $l=2e-08 $layer=M1 $thickness=3.6e-08 $X=0.189
+ $Y=0.11 $X2=0.189 $Y2=0.09
r27 67 68 5.24677 $w=1.3e-08 $l=2.25e-08 $layer=M1 $thickness=3.6e-08 $X=0.189
+ $Y=0.1325 $X2=0.189 $Y2=0.11
r28 66 67 5.01358 $w=1.3e-08 $l=2.15e-08 $layer=M1 $thickness=3.6e-08 $X=0.189
+ $Y=0.154 $X2=0.189 $Y2=0.1325
r29 65 66 2.68168 $w=1.3e-08 $l=1.15e-08 $layer=M1 $thickness=3.6e-08 $X=0.189
+ $Y=0.1655 $X2=0.189 $Y2=0.154
r30 63 64 2.09871 $w=1.3e-08 $l=9e-09 $layer=M1 $thickness=3.6e-08 $X=0.189
+ $Y=0.1735 $X2=0.189 $Y2=0.1825
r31 63 65 1.86552 $w=1.3e-08 $l=8e-09 $layer=M1 $thickness=3.6e-08 $X=0.189
+ $Y=0.1735 $X2=0.189 $Y2=0.1655
r32 23 64 1.04935 $w=1.3e-08 $l=4.5e-09 $layer=M1 $thickness=3.6e-08 $X=0.189
+ $Y=0.187 $X2=0.189 $Y2=0.1825
r33 23 71 1.51573 $w=1.3e-08 $l=6.5e-09 $layer=M1 $thickness=3.6e-08 $X=0.189
+ $Y=0.187 $X2=0.189 $Y2=0.1935
r34 61 60 8.84359 $w=2.1e-08 $l=2.6e-08 $layer=Gate_1 $thickness=5.6e-08
+ $X=0.945 $Y=0.2295 $X2=0.945 $Y2=0.2035
r35 17 60 8.89461 $w=2.04902e-08 $l=2.55e-08 $layer=Gate_1 $thickness=5.6e-08
+ $X=0.945 $Y=0.178 $X2=0.945 $Y2=0.2035
r36 56 57 23.4695 $w=2.1e-08 $l=6.9e-08 $layer=Gate_1 $thickness=5.6e-08
+ $X=0.675 $Y=0.0405 $X2=0.675 $Y2=0.1095
r37 15 57 23.5205 $w=2.08102e-08 $l=6.85e-08 $layer=Gate_1 $thickness=5.6e-08
+ $X=0.675 $Y=0.178 $X2=0.675 $Y2=0.1095
r38 52 53 18.8884 $w=1.3e-08 $l=8.1e-08 $layer=M2 $thickness=3.6e-08 $X=0.648
+ $Y=0.189 $X2=0.729 $Y2=0.189
r39 51 52 18.8884 $w=1.3e-08 $l=8.1e-08 $layer=M2 $thickness=3.6e-08 $X=0.567
+ $Y=0.189 $X2=0.648 $Y2=0.189
r40 51 76 39.0693 $a=1.62e-16 $layer=V1 $X=0.567 $Y=0.189 $X2=0.567 $Y2=0.1845
r41 50 51 44.0729 $w=1.3e-08 $l=1.89e-07 $layer=M2 $thickness=3.6e-08 $X=0.378
+ $Y=0.189 $X2=0.567 $Y2=0.189
r42 49 50 44.0729 $w=1.3e-08 $l=1.89e-07 $layer=M2 $thickness=3.6e-08 $X=0.189
+ $Y=0.189 $X2=0.378 $Y2=0.189
r43 49 71 19.5347 $a=3.24e-16 $layer=V1 $X=0.189 $Y=0.189 $X2=0.189 $Y2=0.1935
r44 26 49 2.68168 $w=1.3e-08 $l=1.15e-08 $layer=M2 $thickness=3.6e-08 $X=0.1775
+ $Y=0.189 $X2=0.189 $Y2=0.189
r45 4 46 2.78395 $w=2.4e-08 $layer=LIG $thickness=4.8e-08 $X=0.945 $Y=0.178
+ $X2=0.945 $Y2=0.178
r46 4 17 7.42683 $w=2.2e-08 $layer=Gate_1 $thickness=5.2e-08 $X=0.945 $Y=0.178
+ $X2=0.945 $Y2=0.178
r47 2 41 2.78395 $w=2.4e-08 $layer=LIG $thickness=4.8e-08 $X=0.675 $Y=0.178
+ $X2=0.675 $Y2=0.178
r48 2 15 7.42683 $w=2.2e-08 $layer=Gate_1 $thickness=5.2e-08 $X=0.675 $Y=0.178
+ $X2=0.675 $Y2=0.178
r49 47 53 19.5347 $a=3.24e-16 $layer=V1 $X=0.729 $Y=0.1845 $X2=0.729 $Y2=0.189
r50 25 47 3.84763 $w=1.3e-08 $l=1.65e-08 $layer=M1 $thickness=3.6e-08 $X=0.729
+ $Y=0.168 $X2=0.729 $Y2=0.1845
r51 45 46 6.83711 $w=2.22e-08 $l=1.5e-09 $layer=LISD $thickness=2.7e-08
+ $X=0.9435 $Y=0.178 $X2=0.945 $Y2=0.178
r52 44 45 12.9145 $w=2.22e-08 $l=2.55e-08 $layer=LISD $thickness=2.7e-08
+ $X=0.918 $Y=0.178 $X2=0.9435 $Y2=0.178
r53 43 44 13.6742 $w=2.22e-08 $l=2.7e-08 $layer=LISD $thickness=2.7e-08
+ $X=0.891 $Y=0.178 $X2=0.918 $Y2=0.178
r54 42 43 13.6742 $w=2.22e-08 $l=2.7e-08 $layer=LISD $thickness=2.7e-08
+ $X=0.864 $Y=0.178 $X2=0.891 $Y2=0.178
r55 40 41 12.9145 $w=2.22e-08 $l=1.35e-08 $layer=LISD $thickness=2.7e-08
+ $X=0.6885 $Y=0.178 $X2=0.675 $Y2=0.178
r56 38 39 6.07743 $w=2.22e-08 $l=1.2e-08 $layer=LISD $thickness=2.7e-08
+ $X=0.729 $Y=0.178 $X2=0.741 $Y2=0.178
r57 38 47 19.3796 $a=3.24e-16 $layer=V0LISD $X=0.729 $Y=0.178 $X2=0.729
+ $Y2=0.1845
r58 37 38 6.07743 $w=2.22e-08 $l=1.2e-08 $layer=LISD $thickness=2.7e-08
+ $X=0.717 $Y=0.178 $X2=0.729 $Y2=0.178
r59 37 40 14.4339 $w=2.22e-08 $l=2.85e-08 $layer=LISD $thickness=2.7e-08
+ $X=0.717 $Y=0.178 $X2=0.6885 $Y2=0.178
r60 36 39 7.59679 $w=2.22e-08 $l=1.5e-08 $layer=LISD $thickness=2.7e-08
+ $X=0.756 $Y=0.178 $X2=0.741 $Y2=0.178
r61 35 36 13.6742 $w=2.22e-08 $l=2.7e-08 $layer=LISD $thickness=2.7e-08
+ $X=0.783 $Y=0.178 $X2=0.756 $Y2=0.178
r62 34 35 13.6742 $w=2.22e-08 $l=2.7e-08 $layer=LISD $thickness=2.7e-08 $X=0.81
+ $Y=0.178 $X2=0.783 $Y2=0.178
r63 8 34 13.6742 $w=2.22e-08 $l=2.7e-08 $layer=LISD $thickness=2.7e-08 $X=0.837
+ $Y=0.178 $X2=0.81 $Y2=0.178
r64 8 42 13.6742 $w=2.22e-08 $l=2.7e-08 $layer=LISD $thickness=2.7e-08 $X=0.837
+ $Y=0.178 $X2=0.864 $Y2=0.178
r65 3 32 7.42683 $w=2.2e-08 $layer=Gate_1 $thickness=5.2e-08 $X=0.837 $Y=0.178
+ $X2=0.837 $Y2=0.178
r66 3 8 10.3807 $w=2.30357e-08 $layer=LISD $thickness=3.675e-08 $X=0.837
+ $Y=0.178 $X2=0.837 $Y2=0.178
r67 31 32 23.5205 $w=2.08102e-08 $l=6.85e-08 $layer=Gate_1 $thickness=5.6e-08
+ $X=0.837 $Y=0.1095 $X2=0.837 $Y2=0.178
r68 30 31 23.4695 $w=2.1e-08 $l=6.9e-08 $layer=Gate_1 $thickness=5.6e-08
+ $X=0.837 $Y=0.0405 $X2=0.837 $Y2=0.1095
r69 30 16 5.44221 $w=2.1e-08 $l=1.6e-08 $layer=Gate_1 $thickness=5.6e-08
+ $X=0.837 $Y=0.0405 $X2=0.837 $Y2=0.0245
.ends

.subckt PM_SDFHx1_ASAP7_75t_R%10 vss 21 25 47 48 53 55 13 18 20 15 14 17 3 1 11
+ 12 4 10 16 19
c1 1 vss 0.00320269f $X=0.7285 $Y=0.09
c2 3 vss 0.00518826f $X=0.81 $Y=0.0405
c3 4 vss 0.00826565f $X=0.81 $Y=0.2295
c4 10 vss 0.0489671f $X=0.729 $Y=0.0245
c5 11 vss 0.00378018f $X=0.7955 $Y=0.0405
c6 12 vss 0.00355787f $X=0.7955 $Y=0.2295
c7 13 vss 0.00316824f $X=0.866 $Y=0.2295
c8 14 vss 0.00132027f $X=0.729 $Y=0.09
c9 15 vss 0.0012214f $X=0.81 $Y=0.09
c10 16 vss 0.00262769f $X=0.837 $Y=0.234
c11 17 vss 0.00100131f $X=0.747 $Y=0.09
c12 18 vss 0.00375933f $X=0.8125 $Y=0.234
c13 19 vss 0.00182545f $X=0.81 $Y=0.0625
c14 20 vss 0.00117062f $X=0.837 $Y=0.1
r1 55 54 0.0925926 $w=2.7e-08 $l=2.5e-09 $layer=P_src_drn $thickness=1e-09
+ $X=0.8813 $Y=0.2295 $X2=0.8785 $Y2=0.2295
r2 13 54 0.462963 $w=2.7e-08 $l=1.25e-08 $layer=P_src_drn $thickness=1e-09
+ $X=0.866 $Y=0.2295 $X2=0.8785 $Y2=0.2295
r3 12 4 0.462963 $w=2.7e-08 $l=1.25e-08 $layer=P_src_drn $thickness=1e-09
+ $X=0.7955 $Y=0.2295 $X2=0.81 $Y2=0.2295
r4 53 12 0.0925926 $w=2.7e-08 $l=2.5e-09 $layer=P_src_drn $thickness=1e-09
+ $X=0.7926 $Y=0.2295 $X2=0.7955 $Y2=0.2295
r5 50 13 12.6992 $w=2.32e-08 $l=2.7e-08 $layer=LISD $thickness=2.7e-08 $X=0.837
+ $Y=0.2295 $X2=0.866 $Y2=0.2295
r6 4 50 12.6992 $w=2.32e-08 $l=2.7e-08 $layer=LISD $thickness=2.7e-08 $X=0.81
+ $Y=0.2295 $X2=0.837 $Y2=0.2295
r7 4 18 19.3796 $a=3.24e-16 $layer=V0LISD $X=0.81 $Y=0.2295 $X2=0.8125 $Y2=0.234
r8 47 46 0.0925926 $w=2.7e-08 $l=2.5e-09 $layer=N_src_drn $thickness=1e-09
+ $X=0.8273 $Y=0.0405 $X2=0.8245 $Y2=0.0405
r9 3 46 0.537037 $w=2.7e-08 $l=1.45e-08 $layer=N_src_drn $thickness=1e-09
+ $X=0.81 $Y=0.0405 $X2=0.8245 $Y2=0.0405
r10 11 3 0.537037 $w=2.7e-08 $l=1.45e-08 $layer=N_src_drn $thickness=1e-09
+ $X=0.7955 $Y=0.0405 $X2=0.81 $Y2=0.0405
r11 48 11 0.0925926 $w=2.7e-08 $l=2.5e-09 $layer=N_src_drn $thickness=1e-09
+ $X=0.7926 $Y=0.0405 $X2=0.7955 $Y2=0.0405
r12 16 42 2.5483 $w=1.79e-08 $l=1.8e-08 $layer=M1 $thickness=3.6e-08 $X=0.837
+ $Y=0.234 $X2=0.837 $Y2=0.216
r13 16 18 4.06404 $w=1.48367e-08 $l=2.45e-08 $layer=M1 $thickness=3.6e-08
+ $X=0.837 $Y=0.234 $X2=0.8125 $Y2=0.234
r14 3 36 19.3796 $a=3.24e-16 $layer=V0LISD $X=0.81 $Y=0.0405 $X2=0.81 $Y2=0.0535
r15 41 42 6.7625 $w=1.3e-08 $l=2.9e-08 $layer=M1 $thickness=3.6e-08 $X=0.837
+ $Y=0.187 $X2=0.837 $Y2=0.216
r16 40 41 4.89699 $w=1.3e-08 $l=2.1e-08 $layer=M1 $thickness=3.6e-08 $X=0.837
+ $Y=0.166 $X2=0.837 $Y2=0.187
r17 39 40 3.14806 $w=1.3e-08 $l=1.35e-08 $layer=M1 $thickness=3.6e-08 $X=0.837
+ $Y=0.1525 $X2=0.837 $Y2=0.166
r18 38 39 5.01358 $w=1.3e-08 $l=2.15e-08 $layer=M1 $thickness=3.6e-08 $X=0.837
+ $Y=0.131 $X2=0.837 $Y2=0.1525
r19 37 38 4.5472 $w=1.3e-08 $l=1.95e-08 $layer=M1 $thickness=3.6e-08 $X=0.837
+ $Y=0.1115 $X2=0.837 $Y2=0.131
r20 20 34 1.15159 $w=1.75e-08 $l=1e-08 $layer=M1 $thickness=3.6e-08 $X=0.837
+ $Y=0.1 $X2=0.837 $Y2=0.09
r21 20 37 2.68168 $w=1.3e-08 $l=1.15e-08 $layer=M1 $thickness=3.6e-08 $X=0.837
+ $Y=0.1 $X2=0.837 $Y2=0.1115
r22 19 35 2.2153 $w=1.3e-08 $l=9.5e-09 $layer=M1 $thickness=3.6e-08 $X=0.81
+ $Y=0.0625 $X2=0.81 $Y2=0.072
r23 19 36 2.09871 $w=1.3e-08 $l=9e-09 $layer=M1 $thickness=3.6e-08 $X=0.81
+ $Y=0.0625 $X2=0.81 $Y2=0.0535
r24 33 34 1.96775 $w=1.63333e-08 $l=1.35e-08 $layer=M1 $thickness=3.6e-08
+ $X=0.8235 $Y=0.09 $X2=0.837 $Y2=0.09
r25 15 31 1.38478 $w=1.70909e-08 $l=1.1e-08 $layer=M1 $thickness=3.6e-08
+ $X=0.81 $Y=0.09 $X2=0.799 $Y2=0.09
r26 15 33 1.96775 $w=1.63333e-08 $l=1.35e-08 $layer=M1 $thickness=3.6e-08
+ $X=0.81 $Y=0.09 $X2=0.8235 $Y2=0.09
r27 15 35 3.01711 $w=1.55e-08 $l=1.8e-08 $layer=M1 $thickness=3.6e-08 $X=0.81
+ $Y=0.09 $X2=0.81 $Y2=0.072
r28 14 17 3.01711 $w=1.55e-08 $l=1.8e-08 $layer=M1 $thickness=3.6e-08 $X=0.729
+ $Y=0.09 $X2=0.747 $Y2=0.09
r29 30 31 5.24677 $w=1.3e-08 $l=2.25e-08 $layer=M1 $thickness=3.6e-08 $X=0.7765
+ $Y=0.09 $X2=0.799 $Y2=0.09
r30 17 30 6.8791 $w=1.3e-08 $l=2.95e-08 $layer=M1 $thickness=3.6e-08 $X=0.747
+ $Y=0.09 $X2=0.7765 $Y2=0.09
r31 17 29 19.3796 $a=3.24e-16 $layer=V0LIG $X=0.747 $Y=0.09 $X2=0.7475 $Y2=0.09
r32 27 29 5.15173 $w=1.56722e-08 $l=9e-09 $layer=LIG $thickness=4.8e-08
+ $X=0.7385 $Y=0.09 $X2=0.7475 $Y2=0.09
r33 1 27 2.6116 $w=2.2e-08 $l=1e-08 $layer=LIG $thickness=4.8e-08 $X=0.7285
+ $Y=0.09 $X2=0.7385 $Y2=0.09
r34 1 23 6.40962 $w=2.09268e-08 $l=5e-10 $layer=Gate_1 $thickness=5.22927e-08
+ $X=0.7285 $Y=0.09 $X2=0.729 $Y2=0.09
r35 25 24 24.1498 $w=2.1e-08 $l=7.1e-08 $layer=Gate_1 $thickness=5.6e-08
+ $X=0.729 $Y=0.2295 $X2=0.729 $Y2=0.1585
r36 23 24 23.4865 $w=2.08394e-08 $l=6.85e-08 $layer=Gate_1 $thickness=5.6e-08
+ $X=0.729 $Y=0.09 $X2=0.729 $Y2=0.1585
r37 23 27 4.05918 $w=2.0087e-08 $l=9.5e-09 $layer=Gate_1 $thickness=5.56522e-08
+ $X=0.729 $Y=0.09 $X2=0.7385 $Y2=0.09
r38 22 23 8.18032 $w=2.05319e-08 $l=2.35e-08 $layer=Gate_1 $thickness=5.6e-08
+ $X=0.729 $Y=0.0665 $X2=0.729 $Y2=0.09
r39 21 22 8.84359 $w=2.1e-08 $l=2.6e-08 $layer=Gate_1 $thickness=5.6e-08
+ $X=0.729 $Y=0.0405 $X2=0.729 $Y2=0.0665
r40 21 10 5.44221 $w=2.1e-08 $l=1.6e-08 $layer=Gate_1 $thickness=5.6e-08
+ $X=0.729 $Y=0.0405 $X2=0.729 $Y2=0.0245
.ends

.subckt PM_SDFHx1_ASAP7_75t_R%12 vss 18 22 38 43 16 15 17 14 13 9 1 3 4 12 10 11
c1 1 vss 0.00188917f $X=0.999 $Y=0.1055
c2 3 vss 0.00590302f $X=1.08 $Y=0.0405
c3 4 vss 0.00636079f $X=1.08 $Y=0.2295
c4 9 vss 0.0412676f $X=0.999 $Y=0.0245
c5 10 vss 0.0186752f $X=1.0655 $Y=0.0405
c6 11 vss 0.0188243f $X=1.0655 $Y=0.2295
c7 12 vss 0.00254558f $X=0.999 $Y=0.036
c8 13 vss 0.00605054f $X=1.107 $Y=0.234
c9 14 vss 0.00251785f $X=1.107 $Y=0.0305
c10 15 vss 0.00100969f $X=0.999 $Y=0.0705
c11 16 vss 0.00726974f $X=1.026 $Y=0.036
c12 17 vss 0.00378991f $X=1.107 $Y=0.081
r1 11 4 0.462963 $w=2.7e-08 $l=1.25e-08 $layer=P_src_drn $thickness=1e-09
+ $X=1.0655 $Y=0.2295 $X2=1.08 $Y2=0.2295
r2 43 11 0.0925926 $w=2.7e-08 $l=2.5e-09 $layer=P_src_drn $thickness=1e-09
+ $X=1.0626 $Y=0.2295 $X2=1.0655 $Y2=0.2295
r3 4 40 19.3796 $a=3.24e-16 $layer=V0LISD $X=1.08 $Y=0.2295 $X2=1.08 $Y2=0.234
r4 40 41 3.14806 $w=1.3e-08 $l=1.35e-08 $layer=M1 $thickness=3.6e-08 $X=1.08
+ $Y=0.234 $X2=1.0935 $Y2=0.234
r5 13 36 7.21452 $w=1.425e-08 $l=3.6e-08 $layer=M1 $thickness=3.6e-08 $X=1.107
+ $Y=0.234 $X2=1.107 $Y2=0.198
r6 13 41 1.96775 $w=1.63333e-08 $l=1.35e-08 $layer=M1 $thickness=3.6e-08
+ $X=1.107 $Y=0.234 $X2=1.0935 $Y2=0.234
r7 10 3 0.462963 $w=2.7e-08 $l=1.25e-08 $layer=N_src_drn $thickness=1e-09
+ $X=1.0655 $Y=0.0405 $X2=1.08 $Y2=0.0405
r8 38 10 0.0925926 $w=2.7e-08 $l=2.5e-09 $layer=N_src_drn $thickness=1e-09
+ $X=1.0626 $Y=0.0405 $X2=1.0655 $Y2=0.0405
r9 35 36 12.5922 $w=1.3e-08 $l=5.4e-08 $layer=M1 $thickness=3.6e-08 $X=1.107
+ $Y=0.144 $X2=1.107 $Y2=0.198
r10 17 34 8.95608 $w=1.36627e-08 $l=4.15e-08 $layer=M1 $thickness=3.6e-08
+ $X=1.107 $Y=0.081 $X2=1.107 $Y2=0.0395
r11 17 35 14.691 $w=1.3e-08 $l=6.3e-08 $layer=M1 $thickness=3.6e-08 $X=1.107
+ $Y=0.081 $X2=1.107 $Y2=0.144
r12 3 32 19.3796 $a=3.24e-16 $layer=V0LISD $X=1.08 $Y=0.0405 $X2=1.08 $Y2=0.036
r13 14 33 1.40651 $w=1.51875e-08 $l=1.45774e-08 $layer=M1 $thickness=3.6e-08
+ $X=1.107 $Y=0.0305 $X2=1.0935 $Y2=0.036
r14 14 34 0.9184 $w=1.8e-08 $l=9e-09 $layer=M1 $thickness=3.6e-08 $X=1.107
+ $Y=0.0305 $X2=1.107 $Y2=0.0395
r15 32 33 3.14806 $w=1.3e-08 $l=1.35e-08 $layer=M1 $thickness=3.6e-08 $X=1.08
+ $Y=0.036 $X2=1.0935 $Y2=0.036
r16 31 32 2.68168 $w=1.3e-08 $l=1.15e-08 $layer=M1 $thickness=3.6e-08 $X=1.0685
+ $Y=0.036 $X2=1.08 $Y2=0.036
r17 30 31 1.04935 $w=1.3e-08 $l=4.5e-09 $layer=M1 $thickness=3.6e-08 $X=1.064
+ $Y=0.036 $X2=1.0685 $Y2=0.036
r18 29 30 2.56509 $w=1.3e-08 $l=1.1e-08 $layer=M1 $thickness=3.6e-08 $X=1.053
+ $Y=0.036 $X2=1.064 $Y2=0.036
r19 16 29 6.29612 $w=1.3e-08 $l=2.7e-08 $layer=M1 $thickness=3.6e-08 $X=1.026
+ $Y=0.036 $X2=1.053 $Y2=0.036
r20 12 15 6.39593 $w=1.55565e-08 $l=3.45e-08 $layer=M1 $thickness=3.6e-08
+ $X=0.999 $Y=0.036 $X2=0.999 $Y2=0.0705
r21 12 16 4.64701 $w=1.46667e-08 $l=2.7e-08 $layer=M1 $thickness=3.6e-08
+ $X=0.999 $Y=0.036 $X2=1.026 $Y2=0.036
r22 15 26 8.04505 $w=1.3e-08 $l=3.45e-08 $layer=M1 $thickness=3.6e-08 $X=0.999
+ $Y=0.0705 $X2=0.999 $Y2=0.105
r23 1 20 6.4735 $w=2.13953e-08 $layer=Gate_1 $thickness=5.22791e-08 $X=0.999
+ $Y=0.1055 $X2=0.999 $Y2=0.1055
r24 1 26 19.3796 $a=3.24e-16 $layer=V0LIG $X=0.999 $Y=0.1055 $X2=0.999 $Y2=0.105
r25 22 21 21.4287 $w=2.1e-08 $l=6.3e-08 $layer=Gate_1 $thickness=5.6e-08
+ $X=0.999 $Y=0.2295 $X2=0.999 $Y2=0.1665
r26 20 21 20.944 $w=2.08115e-08 $l=6.1e-08 $layer=Gate_1 $thickness=5.6e-08
+ $X=0.999 $Y=0.1055 $X2=0.999 $Y2=0.1665
r27 19 20 10.9099 $w=2.06349e-08 $l=3.15e-08 $layer=Gate_1 $thickness=5.6e-08
+ $X=0.999 $Y=0.074 $X2=0.999 $Y2=0.1055
r28 18 19 11.3946 $w=2.1e-08 $l=3.35e-08 $layer=Gate_1 $thickness=5.6e-08
+ $X=0.999 $Y=0.0405 $X2=0.999 $Y2=0.074
r29 18 9 5.44221 $w=2.1e-08 $l=1.6e-08 $layer=Gate_1 $thickness=5.6e-08
+ $X=0.999 $Y=0.0405 $X2=0.999 $Y2=0.0245
.ends

.subckt PM_SDFHx1_ASAP7_75t_R%QN vss 19 13 25 9 8 1 2 7 11
c1 1 vss 0.00845809f $X=1.296 $Y=0.0675
c2 2 vss 0.00849145f $X=1.296 $Y=0.2025
c3 7 vss 0.0382758f $X=1.2815 $Y=0.0675
c4 8 vss 0.0382749f $X=1.2815 $Y=0.2025
c5 9 vss 0.00564423f $X=1.2845 $Y=0.036
c6 10 vss 0.0059706f $X=1.323 $Y=0.234
c7 11 vss 0.00469416f $X=1.323 $Y=0.0675
r1 8 2 0.154321 $w=8.1e-08 $l=1.25e-08 $layer=P_src_drn $thickness=1e-09
+ $X=1.2815 $Y=0.2025 $X2=1.296 $Y2=0.2025
r2 25 8 0.0308642 $w=8.1e-08 $l=2.5e-09 $layer=P_src_drn $thickness=1e-09
+ $X=1.2786 $Y=0.2025 $X2=1.2815 $Y2=0.2025
r3 2 22 19.3796 $a=3.24e-16 $layer=V0LISD $X=1.296 $Y=0.2025 $X2=1.296 $Y2=0.234
r4 22 23 3.14806 $w=1.3e-08 $l=1.35e-08 $layer=M1 $thickness=3.6e-08 $X=1.296
+ $Y=0.234 $X2=1.3095 $Y2=0.234
r5 10 20 1.09329 $w=1.76154e-08 $l=9.8e-09 $layer=M1 $thickness=3.6e-08
+ $X=1.323 $Y=0.234 $X2=1.323 $Y2=0.2242
r6 10 23 1.96775 $w=1.63333e-08 $l=1.35e-08 $layer=M1 $thickness=3.6e-08
+ $X=1.323 $Y=0.234 $X2=1.3095 $Y2=0.234
r7 19 20 0.291487 $w=1.3e-08 $l=1.2e-09 $layer=M1 $thickness=3.6e-08 $X=1.32
+ $Y=0.223 $X2=1.323 $Y2=0.2242
r8 19 18 2.73998 $w=1.3e-08 $l=1.18e-08 $layer=M1 $thickness=3.6e-08 $X=1.32
+ $Y=0.223 $X2=1.323 $Y2=0.2112
r9 17 18 15.4488 $w=1.3e-08 $l=6.62e-08 $layer=M1 $thickness=3.6e-08 $X=1.323
+ $Y=0.145 $X2=1.323 $Y2=0.2112
r10 11 16 6.16517 $w=1.44286e-08 $l=3.15e-08 $layer=M1 $thickness=3.6e-08
+ $X=1.323 $Y=0.0675 $X2=1.323 $Y2=0.036
r11 11 17 18.0722 $w=1.3e-08 $l=7.75e-08 $layer=M1 $thickness=3.6e-08 $X=1.323
+ $Y=0.0675 $X2=1.323 $Y2=0.145
r12 15 16 1.96775 $w=1.63333e-08 $l=1.35e-08 $layer=M1 $thickness=3.6e-08
+ $X=1.3095 $Y=0.036 $X2=1.323 $Y2=0.036
r13 14 15 3.14806 $w=1.3e-08 $l=1.35e-08 $layer=M1 $thickness=3.6e-08 $X=1.296
+ $Y=0.036 $X2=1.3095 $Y2=0.036
r14 9 14 2.68168 $w=1.3e-08 $l=1.15e-08 $layer=M1 $thickness=3.6e-08 $X=1.2845
+ $Y=0.036 $X2=1.296 $Y2=0.036
r15 1 14 19.3796 $a=3.24e-16 $layer=V0LISD $X=1.296 $Y=0.0675 $X2=1.296
+ $Y2=0.036
r16 7 1 0.154321 $w=8.1e-08 $l=1.25e-08 $layer=N_src_drn $thickness=1e-09
+ $X=1.2815 $Y=0.0675 $X2=1.296 $Y2=0.0675
r17 13 7 0.0308642 $w=8.1e-08 $l=2.5e-09 $layer=N_src_drn $thickness=1e-09
+ $X=1.2786 $Y=0.0675 $X2=1.2815 $Y2=0.0675
.ends

.subckt PM_SDFHx1_ASAP7_75t_R%20 vss 7 12 4 1 5
c1 1 vss 0.00627859f $X=0.918 $Y=0.0405
c2 4 vss 0.00176428f $X=0.9035 $Y=0.0405
c3 5 vss 0.00219009f $X=0.974 $Y=0.0405
r1 12 11 0.0925926 $w=2.7e-08 $l=2.5e-09 $layer=N_src_drn $thickness=1e-09
+ $X=0.9893 $Y=0.0405 $X2=0.9865 $Y2=0.0405
r2 5 11 0.462963 $w=2.7e-08 $l=1.25e-08 $layer=N_src_drn $thickness=1e-09
+ $X=0.974 $Y=0.0405 $X2=0.9865 $Y2=0.0405
r3 9 5 6.3496 $w=2.32e-08 $l=1.35e-08 $layer=LISD $thickness=2.7e-08 $X=0.9585
+ $Y=0.0405 $X2=0.974 $Y2=0.0405
r4 8 9 7.05511 $w=2.32e-08 $l=1.5e-08 $layer=LISD $thickness=2.7e-08 $X=0.9435
+ $Y=0.0405 $X2=0.9585 $Y2=0.0405
r5 1 8 11.9937 $w=2.32e-08 $l=2.55e-08 $layer=LISD $thickness=2.7e-08 $X=0.918
+ $Y=0.0405 $X2=0.9435 $Y2=0.0405
r6 4 1 0.462963 $w=2.7e-08 $l=1.25e-08 $layer=N_src_drn $thickness=1e-09
+ $X=0.9035 $Y=0.0405 $X2=0.918 $Y2=0.0405
r7 7 4 0.0925926 $w=2.7e-08 $l=2.5e-09 $layer=N_src_drn $thickness=1e-09
+ $X=0.9006 $Y=0.0405 $X2=0.9035 $Y2=0.0405
.ends

.subckt PM_SDFHx1_ASAP7_75t_R%13 vss 28 34 72 76 80 81 84 85 22 13 14 15 17 19
+ 21 5 20 25 24 16 2 12 1 23 6 11 18
c1 1 vss 0.00169051f $X=1.053 $Y=0.14
c2 2 vss 0.00359753f $X=1.269 $Y=0.136
c3 5 vss 0.00477957f $X=0.864 $Y=0.0405
c4 6 vss 0.00457047f $X=0.918 $Y=0.2295
c5 11 vss 0.0535359f $X=1.053 $Y=0.0245
c6 12 vss 0.10906f $X=1.269 $Y=0.136
c7 13 vss 0.00321188f $X=0.8495 $Y=0.0405
c8 14 vss 0.00344149f $X=0.9035 $Y=0.2295
c9 15 vss 0.00606878f $X=0.945 $Y=0.234
c10 16 vss 0.00232904f $X=0.945 $Y=0.036
c11 17 vss 0.000200828f $X=0.945 $Y=0.1575
c12 18 vss 0.000369508f $X=1.053 $Y=0.162
c13 19 vss 0.00700993f $X=0.92 $Y=0.036
c14 20 vss 0.000573681f $X=0.945 $Y=0.1315
c15 21 vss 0.00129335f $X=0.945 $Y=0.198
c16 22 vss 0.00137619f $X=1.026 $Y=0.162
c17 23 vss 0.000296847f $X=1.053 $Y=0.125
c18 24 vss 0.00334358f $X=1.269 $Y=0.1085
c19 25 vss 0.00998917f $X=0.945 $Y=0.153
r1 85 83 0.0925926 $w=2.7e-08 $l=2.5e-09 $layer=N_src_drn $thickness=1e-09
+ $X=0.8813 $Y=0.0405 $X2=0.8785 $Y2=0.0405
r2 5 83 0.537037 $w=2.7e-08 $l=1.45e-08 $layer=N_src_drn $thickness=1e-09
+ $X=0.864 $Y=0.0405 $X2=0.8785 $Y2=0.0405
r3 13 5 0.537037 $w=2.7e-08 $l=1.45e-08 $layer=N_src_drn $thickness=1e-09
+ $X=0.8495 $Y=0.0405 $X2=0.864 $Y2=0.0405
r4 84 13 0.0925926 $w=2.7e-08 $l=2.5e-09 $layer=N_src_drn $thickness=1e-09
+ $X=0.8466 $Y=0.0405 $X2=0.8495 $Y2=0.0405
r5 81 79 0.0925926 $w=2.7e-08 $l=2.5e-09 $layer=P_src_drn $thickness=1e-09
+ $X=0.9353 $Y=0.2295 $X2=0.9325 $Y2=0.2295
r6 6 79 0.537037 $w=2.7e-08 $l=1.45e-08 $layer=P_src_drn $thickness=1e-09
+ $X=0.918 $Y=0.2295 $X2=0.9325 $Y2=0.2295
r7 14 6 0.537037 $w=2.7e-08 $l=1.45e-08 $layer=P_src_drn $thickness=1e-09
+ $X=0.9035 $Y=0.2295 $X2=0.918 $Y2=0.2295
r8 80 14 0.0925926 $w=2.7e-08 $l=2.5e-09 $layer=P_src_drn $thickness=1e-09
+ $X=0.9006 $Y=0.2295 $X2=0.9035 $Y2=0.2295
r9 76 75 14.6259 $w=2.1e-08 $l=4.3e-08 $layer=Gate_1 $thickness=5.6e-08
+ $X=1.269 $Y=0.2025 $X2=1.269 $Y2=0.1595
r10 74 75 2.55104 $w=2.1e-08 $l=7.5e-09 $layer=Gate_1 $thickness=5.6e-08
+ $X=1.269 $Y=0.152 $X2=1.269 $Y2=0.1595
r11 72 73 14.6259 $w=2.1e-08 $l=4.3e-08 $layer=Gate_1 $thickness=5.6e-08
+ $X=1.269 $Y=0.0675 $X2=1.269 $Y2=0.1105
r12 70 73 2.89117 $w=2.1e-08 $l=8.5e-09 $layer=Gate_1 $thickness=5.6e-08
+ $X=1.269 $Y=0.119 $X2=1.269 $Y2=0.1105
r13 12 70 5.96942 $w=2.03529e-08 $l=1.7e-08 $layer=Gate_1 $thickness=5.6e-08
+ $X=1.269 $Y=0.136 $X2=1.269 $Y2=0.119
r14 12 74 5.62929 $w=2.03125e-08 $l=1.6e-08 $layer=Gate_1 $thickness=5.6e-08
+ $X=1.269 $Y=0.136 $X2=1.269 $Y2=0.152
r15 5 63 19.3796 $a=3.24e-16 $layer=V0LISD $X=0.864 $Y=0.0405 $X2=0.864
+ $Y2=0.036
r16 6 58 19.3796 $a=3.24e-16 $layer=V0LISD $X=0.918 $Y=0.2295 $X2=0.918
+ $Y2=0.234
r17 2 55 19.3796 $a=3.24e-16 $layer=V0LIG $X=1.269 $Y=0.136 $X2=1.269 $Y2=0.1445
r18 2 12 6.54019 $w=2.09524e-08 $layer=Gate_1 $thickness=5.21905e-08 $X=1.269
+ $Y=0.136 $X2=1.269 $Y2=0.136
r19 63 64 3.14806 $w=1.3e-08 $l=1.35e-08 $layer=M1 $thickness=3.6e-08 $X=0.864
+ $Y=0.036 $X2=0.8775 $Y2=0.036
r20 61 64 3.14806 $w=1.3e-08 $l=1.35e-08 $layer=M1 $thickness=3.6e-08 $X=0.891
+ $Y=0.036 $X2=0.8775 $Y2=0.036
r21 60 61 2.56509 $w=1.3e-08 $l=1.1e-08 $layer=M1 $thickness=3.6e-08 $X=0.902
+ $Y=0.036 $X2=0.891 $Y2=0.036
r22 19 60 4.19742 $w=1.3e-08 $l=1.8e-08 $layer=M1 $thickness=3.6e-08 $X=0.92
+ $Y=0.036 $X2=0.902 $Y2=0.036
r23 58 59 3.14806 $w=1.3e-08 $l=1.35e-08 $layer=M1 $thickness=3.6e-08 $X=0.918
+ $Y=0.234 $X2=0.9315 $Y2=0.234
r24 15 21 7.21452 $w=1.425e-08 $l=3.6e-08 $layer=M1 $thickness=3.6e-08 $X=0.945
+ $Y=0.234 $X2=0.945 $Y2=0.198
r25 15 59 1.96775 $w=1.63333e-08 $l=1.35e-08 $layer=M1 $thickness=3.6e-08
+ $X=0.945 $Y=0.234 $X2=0.9315 $Y2=0.234
r26 24 55 8.39483 $w=1.3e-08 $l=3.6e-08 $layer=M1 $thickness=3.6e-08 $X=1.269
+ $Y=0.1085 $X2=1.269 $Y2=0.1445
r27 16 49 4.64701 $w=1.62667e-08 $l=2.7e-08 $layer=M1 $thickness=3.6e-08
+ $X=0.945 $Y=0.036 $X2=0.945 $Y2=0.063
r28 16 19 4.18063 $w=1.48e-08 $l=2.5e-08 $layer=M1 $thickness=3.6e-08 $X=0.945
+ $Y=0.036 $X2=0.92 $Y2=0.036
r29 21 44 6.50021 $w=1.33448e-08 $l=2.9e-08 $layer=M1 $thickness=3.6e-08
+ $X=0.945 $Y=0.198 $X2=0.945 $Y2=0.169
r30 53 55 19.5347 $a=3.24e-16 $layer=V1 $X=1.269 $Y=0.153 $X2=1.269 $Y2=0.1445
r31 52 53 5.71315 $w=1.3e-08 $l=2.45e-08 $layer=M2 $thickness=3.6e-08 $X=1.2445
+ $Y=0.153 $X2=1.269 $Y2=0.153
r32 51 52 9.91056 $w=1.3e-08 $l=4.25e-08 $layer=M2 $thickness=3.6e-08 $X=1.202
+ $Y=0.153 $X2=1.2445 $Y2=0.153
r33 50 51 32.0636 $w=1.3e-08 $l=1.375e-07 $layer=M2 $thickness=3.6e-08
+ $X=1.0645 $Y=0.153 $X2=1.202 $Y2=0.153
r34 25 50 27.8662 $w=1.3e-08 $l=1.195e-07 $layer=M2 $thickness=3.6e-08 $X=0.945
+ $Y=0.153 $X2=1.0645 $Y2=0.153
r35 25 45 39.0693 $a=1.62e-16 $layer=V1 $X=0.945 $Y=0.153 $X2=0.945 $Y2=0.1485
r36 48 49 6.29612 $w=1.3e-08 $l=2.7e-08 $layer=M1 $thickness=3.6e-08 $X=0.945
+ $Y=0.09 $X2=0.945 $Y2=0.063
r37 47 48 2.3319 $w=1.3e-08 $l=1e-08 $layer=M1 $thickness=3.6e-08 $X=0.945
+ $Y=0.1 $X2=0.945 $Y2=0.09
r38 46 47 2.3319 $w=1.3e-08 $l=1e-08 $layer=M1 $thickness=3.6e-08 $X=0.945
+ $Y=0.11 $X2=0.945 $Y2=0.1
r39 20 45 3.96423 $w=1.3e-08 $l=1.7e-08 $layer=M1 $thickness=3.6e-08 $X=0.945
+ $Y=0.1315 $X2=0.945 $Y2=0.1485
r40 20 46 5.01358 $w=1.3e-08 $l=2.15e-08 $layer=M1 $thickness=3.6e-08 $X=0.945
+ $Y=0.1315 $X2=0.945 $Y2=0.11
r41 43 44 0.4592 $w=1.8e-08 $l=4.5e-09 $layer=M1 $thickness=3.6e-08 $X=0.945
+ $Y=0.1645 $X2=0.945 $Y2=0.169
r42 17 43 0.714311 $w=1.8e-08 $l=7e-09 $layer=M1 $thickness=3.6e-08 $X=0.945
+ $Y=0.1575 $X2=0.945 $Y2=0.1645
r43 17 45 1.50855 $w=1.55e-08 $l=9e-09 $layer=M1 $thickness=3.6e-08 $X=0.945
+ $Y=0.1575 $X2=0.945 $Y2=0.1485
r44 17 25 39.0693 $a=1.62e-16 $layer=V1 $X=0.945 $Y=0.1575 $X2=0.945 $Y2=0.153
r45 42 44 4.4015 $w=1.35e-08 $l=2.78927e-08 $layer=M1 $thickness=3.6e-08
+ $X=0.972 $Y=0.162 $X2=0.945 $Y2=0.169
r46 41 42 6.29612 $w=1.3e-08 $l=2.7e-08 $layer=M1 $thickness=3.6e-08 $X=0.999
+ $Y=0.162 $X2=0.972 $Y2=0.162
r47 22 41 6.29612 $w=1.3e-08 $l=2.7e-08 $layer=M1 $thickness=3.6e-08 $X=1.026
+ $Y=0.162 $X2=0.999 $Y2=0.162
r48 18 39 0.915974 $w=2.10182e-08 $l=1.1e-08 $layer=M1 $thickness=3.6e-08
+ $X=1.053 $Y=0.162 $X2=1.053 $Y2=0.151
r49 18 22 4.64701 $w=1.46667e-08 $l=2.7e-08 $layer=M1 $thickness=3.6e-08
+ $X=1.053 $Y=0.162 $X2=1.026 $Y2=0.162
r50 38 39 2.56509 $w=1.3e-08 $l=1.1e-08 $layer=M1 $thickness=3.6e-08 $X=1.053
+ $Y=0.14 $X2=1.053 $Y2=0.151
r51 23 38 3.49785 $w=1.3e-08 $l=1.5e-08 $layer=M1 $thickness=3.6e-08 $X=1.053
+ $Y=0.125 $X2=1.053 $Y2=0.14
r52 1 31 6.54019 $w=2.09524e-08 $layer=Gate_1 $thickness=5.21905e-08 $X=1.053
+ $Y=0.14 $X2=1.053 $Y2=0.14
r53 1 38 19.3796 $a=3.24e-16 $layer=V0LIG $X=1.053 $Y=0.14 $X2=1.053 $Y2=0.14
r54 34 33 14.6259 $w=2.1e-08 $l=4.3e-08 $layer=Gate_1 $thickness=5.6e-08
+ $X=1.053 $Y=0.2295 $X2=1.053 $Y2=0.1865
r55 32 33 11.0545 $w=2.1e-08 $l=3.25e-08 $layer=Gate_1 $thickness=5.6e-08
+ $X=1.053 $Y=0.154 $X2=1.053 $Y2=0.1865
r56 31 32 4.94901 $w=2.02143e-08 $l=1.4e-08 $layer=Gate_1 $thickness=5.6e-08
+ $X=1.053 $Y=0.14 $X2=1.053 $Y2=0.154
r57 30 31 6.6497 $w=2.04211e-08 $l=1.9e-08 $layer=Gate_1 $thickness=5.6e-08
+ $X=1.053 $Y=0.121 $X2=1.053 $Y2=0.14
r58 29 30 12.7552 $w=2.1e-08 $l=3.75e-08 $layer=Gate_1 $thickness=5.6e-08
+ $X=1.053 $Y=0.0835 $X2=1.053 $Y2=0.121
r59 28 29 14.6259 $w=2.1e-08 $l=4.3e-08 $layer=Gate_1 $thickness=5.6e-08
+ $X=1.053 $Y=0.0405 $X2=1.053 $Y2=0.0835
r60 28 11 5.44221 $w=2.1e-08 $l=1.6e-08 $layer=Gate_1 $thickness=5.6e-08
+ $X=1.053 $Y=0.0405 $X2=1.053 $Y2=0.0245
.ends

.subckt PM_SDFHx1_ASAP7_75t_R%D vss 16 7 11 5 1 4 3
c1 1 vss 0.00500946f $X=0.405 $Y=0.135
c2 3 vss 0.10375f $X=0.405 $Y=0.0245
c3 4 vss 0.00275476f $X=0.405 $Y=0.135
c4 5 vss 0.00696598f $X=0.3665 $Y=0.117
r1 16 5 8.97781 $w=1.3e-08 $l=3.85e-08 $layer=M2 $thickness=3.6e-08 $X=0.405
+ $Y=0.117 $X2=0.3665 $Y2=0.117
r2 16 14 19.5347 $a=3.24e-16 $layer=V1 $X=0.405 $Y=0.117 $X2=0.405 $Y2=0.117
r3 4 14 4.19742 $w=1.3e-08 $l=1.8e-08 $layer=M1 $thickness=3.6e-08 $X=0.405
+ $Y=0.135 $X2=0.405 $Y2=0.117
r4 1 9 10.4265 $w=1.765e-08 $layer=LIG $thickness=5.2e-08 $X=0.405 $Y=0.135
+ $X2=0.405 $Y2=0.135
r5 1 4 19.3796 $a=3.24e-16 $layer=V0LIG $X=0.405 $Y=0.135 $X2=0.405 $Y2=0.135
r6 11 10 16.4967 $w=2.1e-08 $l=4.85e-08 $layer=Gate_1 $thickness=5.6e-08
+ $X=0.405 $Y=0.2025 $X2=0.405 $Y2=0.154
r7 9 10 6.6497 $w=2.04211e-08 $l=1.9e-08 $layer=Gate_1 $thickness=5.6e-08
+ $X=0.405 $Y=0.135 $X2=0.405 $Y2=0.154
r8 8 9 6.6497 $w=2.04211e-08 $l=1.9e-08 $layer=Gate_1 $thickness=5.6e-08
+ $X=0.405 $Y=0.116 $X2=0.405 $Y2=0.135
r9 7 8 16.4967 $w=2.1e-08 $l=4.85e-08 $layer=Gate_1 $thickness=5.6e-08 $X=0.405
+ $Y=0.0675 $X2=0.405 $Y2=0.116
r10 7 3 14.6259 $w=2.1e-08 $l=4.3e-08 $layer=Gate_1 $thickness=5.6e-08 $X=0.405
+ $Y=0.0675 $X2=0.405 $Y2=0.0245
.ends

.subckt PM_SDFHx1_ASAP7_75t_R%SI vss 26 10 14 8 6 1 3 7 5 4
c1 1 vss 0.00969841f $X=0.4575 $Y=0.135
c2 3 vss 0.0844727f $X=0.459 $Y=0.0245
c3 4 vss 0.00227797f $X=0.513 $Y=0.198
c4 5 vss 0.0056144f $X=0.513 $Y=0.135
c5 6 vss 0.00238363f $X=0.4635 $Y=0.135
c6 7 vss 0.00184147f $X=0.513 $Y=0.154
c7 8 vss 0.00240807f $X=0.4697 $Y=0.117
r1 4 25 3.83327 $w=1.5093e-08 $l=2.15e-08 $layer=M1 $thickness=3.6e-08 $X=0.513
+ $Y=0.198 $X2=0.513 $Y2=0.1765
r2 27 28 5.65485 $w=1.3e-08 $l=2.43e-08 $layer=M2 $thickness=3.6e-08 $X=0.4887
+ $Y=0.117 $X2=0.513 $Y2=0.117
r3 26 27 3.67274 $w=1.3e-08 $l=1.57e-08 $layer=M2 $thickness=3.6e-08 $X=0.473
+ $Y=0.12 $X2=0.4887 $Y2=0.117
r4 26 8 0.757867 $w=1.3e-08 $l=3.3e-09 $layer=M2 $thickness=3.6e-08 $X=0.473
+ $Y=0.12 $X2=0.4697 $Y2=0.117
r5 7 25 5.24677 $w=1.3e-08 $l=2.25e-08 $layer=M1 $thickness=3.6e-08 $X=0.513
+ $Y=0.154 $X2=0.513 $Y2=0.1765
r6 24 28 19.5347 $a=3.24e-16 $layer=V1 $X=0.513 $Y=0.117 $X2=0.513 $Y2=0.117
r7 5 22 3.1337 $w=1.54324e-08 $l=1.85e-08 $layer=M1 $thickness=3.6e-08 $X=0.513
+ $Y=0.135 $X2=0.4945 $Y2=0.135
r8 5 24 3.01711 $w=1.55e-08 $l=1.8e-08 $layer=M1 $thickness=3.6e-08 $X=0.513
+ $Y=0.135 $X2=0.513 $Y2=0.117
r9 5 7 3.2503 $w=1.53684e-08 $l=1.9e-08 $layer=M1 $thickness=3.6e-08 $X=0.513
+ $Y=0.135 $X2=0.513 $Y2=0.154
r10 21 22 2.3319 $w=1.3e-08 $l=1e-08 $layer=M1 $thickness=3.6e-08 $X=0.4845
+ $Y=0.135 $X2=0.4945 $Y2=0.135
r11 20 21 2.2153 $w=1.3e-08 $l=9.5e-09 $layer=M1 $thickness=3.6e-08 $X=0.475
+ $Y=0.135 $X2=0.4845 $Y2=0.135
r12 6 20 2.68168 $w=1.3e-08 $l=1.15e-08 $layer=M1 $thickness=3.6e-08 $X=0.4635
+ $Y=0.135 $X2=0.475 $Y2=0.135
r13 18 20 19.3796 $a=3.24e-16 $layer=V0LIG $X=0.4765 $Y=0.135 $X2=0.475
+ $Y2=0.135
r14 16 18 4.82216 $w=1.64167e-08 $l=9e-09 $layer=LIG $thickness=4.8e-08
+ $X=0.4675 $Y=0.135 $X2=0.4765 $Y2=0.135
r15 1 16 2.6116 $w=2.2e-08 $l=1e-08 $layer=LIG $thickness=4.8e-08 $X=0.4575
+ $Y=0.135 $X2=0.4675 $Y2=0.135
r16 1 12 6.14846 $w=2.08718e-08 $l=1.5e-09 $layer=Gate_1 $thickness=5.25128e-08
+ $X=0.4575 $Y=0.135 $X2=0.459 $Y2=0.135
r17 14 13 16.4967 $w=2.1e-08 $l=4.85e-08 $layer=Gate_1 $thickness=5.6e-08
+ $X=0.459 $Y=0.2025 $X2=0.459 $Y2=0.154
r18 12 13 6.6497 $w=2.04211e-08 $l=1.9e-08 $layer=Gate_1 $thickness=5.6e-08
+ $X=0.459 $Y=0.135 $X2=0.459 $Y2=0.154
r19 12 16 4.32033 $w=2.024e-08 $l=8.5e-09 $layer=Gate_1 $thickness=5.504e-08
+ $X=0.459 $Y=0.135 $X2=0.4675 $Y2=0.135
r20 11 12 6.6497 $w=2.04211e-08 $l=1.9e-08 $layer=Gate_1 $thickness=5.6e-08
+ $X=0.459 $Y=0.116 $X2=0.459 $Y2=0.135
r21 10 11 16.4967 $w=2.1e-08 $l=4.85e-08 $layer=Gate_1 $thickness=5.6e-08
+ $X=0.459 $Y=0.0675 $X2=0.459 $Y2=0.116
r22 10 3 14.6259 $w=2.1e-08 $l=4.3e-08 $layer=Gate_1 $thickness=5.6e-08
+ $X=0.459 $Y=0.0675 $X2=0.459 $Y2=0.0245
.ends

* End of included file SDFHx1_ASAP7_75t_R.pex.sp.pex

*
.subckt SDFHx1_ASAP7_75t_CUSTOM_4_25_0_7 VSS VDD CLK SE D SI QN
*
* VSS VSS
* VDD VDD
* CLK CLK
* SE SE
* D D
* SI SI
* QN QN
*
*

M0 VSS N_M0_g N_M0_s VSS nmos_rvt L=2e-08 W=5.4e-08 nfin=2 $X=0.071 $Y=0.027
M1 N_M1_d N_M1_g VSS VSS nmos_rvt L=2e-08 W=5.4e-08 nfin=2 $X=0.125 $Y=0.027
M2 VSS N_M2_g noxref_15 VSS nmos_rvt L=2e-08 W=8.1e-08 nfin=3 $X=0.287 $Y=0.027
M3 noxref_21 N_M3_g VSS VSS nmos_rvt L=2e-08 W=8.1e-08 nfin=3 $X=0.341 $Y=0.027
M4 noxref_17 N_M4_g noxref_21 VSS nmos_rvt L=2e-08 W=8.1e-08 nfin=3 $X=0.395
+ $Y=0.027
M5 noxref_15 N_M5_g noxref_17 VSS nmos_rvt L=2e-08 W=8.1e-08 nfin=3 $X=0.449
+ $Y=0.027
M6 N_M6_d N_M6_g noxref_17 VSS nmos_rvt L=2e-08 W=8.1e-08 nfin=3 $X=0.611
+ $Y=0.027
M7 N_M7_d N_M7_g N_M7_s VSS nmos_rvt L=2e-08 W=2.7e-08 nfin=1 $X=0.665 $Y=0.027
M8 VSS N_M8_g N_M8_s VSS nmos_rvt L=2e-08 W=2.7e-08 nfin=1 $X=0.719 $Y=0.027
M9 N_M9_d N_M9_g VSS VSS nmos_rvt L=2e-08 W=2.7e-08 nfin=1 $X=0.773 $Y=0.027
M10 N_M10_d N_M10_g N_M10_s VSS nmos_rvt L=2e-08 W=2.7e-08 nfin=1 $X=0.827
+ $Y=0.027
M11 N_M11_d N_M11_g N_M11_s VSS nmos_rvt L=2e-08 W=2.7e-08 nfin=1 $X=0.881
+ $Y=0.027
M12 VSS N_M12_g N_M12_s VSS nmos_rvt L=2e-08 W=2.7e-08 nfin=1 $X=0.989 $Y=0.027
M13 N_M13_d N_M13_g VSS VSS nmos_rvt L=2e-08 W=2.7e-08 nfin=1 $X=1.043 $Y=0.027
M14 VSS N_M14_g N_M14_s VSS nmos_rvt L=2e-08 W=2.7e-08 nfin=1 $X=1.205 $Y=0.027
M15 N_M15_d N_M15_g VSS VSS nmos_rvt L=2e-08 W=8.1e-08 nfin=3 $X=1.259 $Y=0.027
M16 VDD N_M16_g N_M16_s VDD pmos_rvt L=2e-08 W=5.4e-08 nfin=2 $X=0.071 $Y=0.189
M17 N_M17_d N_M17_g VDD VDD pmos_rvt L=2e-08 W=5.4e-08 nfin=2 $X=0.125 $Y=0.189
M18 N_M18_d N_M18_g N_M18_s VDD pmos_rvt L=2e-08 W=8.1e-08 nfin=3 $X=0.287
+ $Y=0.162
M19 VDD N_M19_g N_M19_s VDD pmos_rvt L=2e-08 W=8.1e-08 nfin=3 $X=0.341 $Y=0.162
M20 N_M20_d N_M20_g VDD VDD pmos_rvt L=2e-08 W=8.1e-08 nfin=3 $X=0.395 $Y=0.162
M21 N_M21_d N_M21_g N_M21_s VDD pmos_rvt L=2e-08 W=8.1e-08 nfin=3 $X=0.449
+ $Y=0.162
M22 N_M22_d N_M22_g N_M22_s VDD pmos_rvt L=2e-08 W=8.1e-08 nfin=3 $X=0.557
+ $Y=0.162
M23 N_M23_d N_M23_g N_M23_s VDD pmos_rvt L=2e-08 W=2.7e-08 nfin=1 $X=0.611
+ $Y=0.216
M24 VDD N_M24_g N_M24_s VDD pmos_rvt L=2e-08 W=2.7e-08 nfin=1 $X=0.719 $Y=0.216
M25 N_M25_d N_M25_g VDD VDD pmos_rvt L=2e-08 W=2.7e-08 nfin=1 $X=0.773 $Y=0.216
M26 N_M26_d N_M26_g N_M26_s VDD pmos_rvt L=2e-08 W=2.7e-08 nfin=1 $X=0.881
+ $Y=0.216
M27 N_M27_d N_M27_g N_M27_s VDD pmos_rvt L=2e-08 W=2.7e-08 nfin=1 $X=0.935
+ $Y=0.216
M28 VDD N_M28_g N_M28_s VDD pmos_rvt L=2e-08 W=2.7e-08 nfin=1 $X=0.989 $Y=0.216
M29 N_M29_d N_M29_g VDD VDD pmos_rvt L=2e-08 W=2.7e-08 nfin=1 $X=1.043 $Y=0.216
M30 VDD N_M30_g N_M30_s VDD pmos_rvt L=2e-08 W=2.7e-08 nfin=1 $X=1.205 $Y=0.216
M31 N_M31_d N_M31_g VDD VDD pmos_rvt L=2e-08 W=8.1e-08 nfin=3 $X=1.259 $Y=0.162

* .include "SDFHx1_ASAP7_75t_R.pex.sp.pxi"

* Start of included file SDFHx1_ASAP7_75t_R.pex.sp.pxi
x_PM_SDFHx1_ASAP7_75t_R%CLK vss CLK N_M0_g N_M16_g N_CLK_3 N_CLK_6 N_CLK_1
+ N_CLK_4 N_CLK_7 N_CLK_8 N_CLK_5 PM_SDFHx1_ASAP7_75t_R%CLK
x_PM_SDFHx1_ASAP7_75t_R%14 vss N_M18_s N_M21_d N_M22_s N_14_8 N_14_1 N_14_9
+ N_14_11 N_14_2 N_14_10 PM_SDFHx1_ASAP7_75t_R%14
cc_1 N_14_8 N_SE_1 0.00105351f $X=0.272 $Y=0.2025
cc_2 N_14_8 N_SE_11 0.000887243f $X=0.272 $Y=0.2025
cc_3 N_14_1 N_SE_5 0.00125506f $X=0.27 $Y=0.1755
cc_4 N_14_8 N_SE_5 0.0342494f $X=0.272 $Y=0.2025
cc_5 N_14_9 N_SI_7 0.000638167f $X=0.4715 $Y=0.2025
cc_6 N_14_9 N_SI_1 0.00166009f $X=0.4715 $Y=0.2025
cc_7 N_14_11 N_SI_4 0.00287212f $X=0.258 $Y=0.234
cc_8 N_14_2 N_SI_4 0.00317398f $X=0.513 $Y=0.2025
cc_9 N_14_9 N_SI_3 0.0350735f $X=0.4715 $Y=0.2025
cc_10 N_14_10 N_9_7 0.000227052f $X=0.542 $Y=0.2025
cc_11 N_14_10 N_9_21 0.000378414f $X=0.542 $Y=0.2025
cc_12 N_14_10 N_9_1 0.00100038f $X=0.542 $Y=0.2025
cc_13 N_14_10 N_9_24 0.000284059f $X=0.542 $Y=0.2025
cc_14 N_14_10 N_9_22 0.00034597f $X=0.542 $Y=0.2025
cc_15 N_14_1 N_9_23 0.000924197f $X=0.27 $Y=0.1755
cc_16 N_14_2 N_9_14 0.00162885f $X=0.513 $Y=0.2025
cc_17 N_14_11 N_9_26 0.00375814f $X=0.258 $Y=0.234
cc_18 N_14_10 N_9_14 0.0343915f $X=0.542 $Y=0.2025
cc_19 N_14_2 N_11_13 0.000573477f $X=0.513 $Y=0.2025
cc_20 N_14_2 N_11_3 0.00104269f $X=0.513 $Y=0.2025
cc_21 N_14_2 N_11_12 0.00220175f $X=0.513 $Y=0.2025
x_PM_SDFHx1_ASAP7_75t_R%16 vss N_M18_d N_M19_s N_M20_d N_M21_s N_16_7 N_16_1
+ N_16_9 N_16_2 N_16_8 PM_SDFHx1_ASAP7_75t_R%16
cc_22 N_16_7 N_SE_1 0.00127433f $X=0.3095 $Y=0.2025
cc_23 N_16_1 N_SE_5 0.000744572f $X=0.324 $Y=0.2025
cc_24 N_16_9 N_SE_11 0.000754367f $X=0.31 $Y=0.198
cc_25 N_16_7 N_SE_5 0.0322549f $X=0.3095 $Y=0.2025
cc_26 N_16_7 N_6_1 0.0010266f $X=0.3095 $Y=0.2025
cc_27 N_16_1 N_6_9 0.000794862f $X=0.324 $Y=0.2025
cc_28 N_16_9 N_6_14 0.00195782f $X=0.31 $Y=0.198
cc_29 N_16_7 N_6_9 0.0326406f $X=0.3095 $Y=0.2025
cc_30 N_16_2 N_D_3 0.000807639f $X=0.432 $Y=0.2025
cc_31 N_16_9 N_D_4 0.00203642f $X=0.31 $Y=0.198
cc_32 N_16_8 N_D_3 0.0337265f $X=0.4175 $Y=0.2025
cc_33 N_16_8 N_SI_1 0.000730984f $X=0.4175 $Y=0.2025
cc_34 N_16_9 N_SI_6 0.000746969f $X=0.31 $Y=0.198
cc_35 N_16_2 N_SI_3 0.000793392f $X=0.432 $Y=0.2025
cc_36 N_16_8 N_SI_3 0.0331446f $X=0.4175 $Y=0.2025
cc_37 N_16_9 N_9_26 0.00292273f $X=0.31 $Y=0.198
cc_38 N_16_7 N_14_11 0.00114283f $X=0.3095 $Y=0.2025
cc_39 N_16_8 N_14_11 0.000591748f $X=0.4175 $Y=0.2025
cc_40 N_16_2 N_14_11 0.000642985f $X=0.432 $Y=0.2025
cc_41 N_16_1 N_14_11 0.000662148f $X=0.324 $Y=0.2025
cc_42 N_16_8 N_14_2 0.0010547f $X=0.4175 $Y=0.2025
cc_43 N_16_2 N_14_2 0.00154422f $X=0.432 $Y=0.2025
cc_44 N_16_1 N_14_1 0.00277365f $X=0.324 $Y=0.2025
cc_45 N_16_9 N_14_11 0.0113527f $X=0.31 $Y=0.198
x_PM_SDFHx1_ASAP7_75t_R%19 vss N_M23_d N_M24_s N_19_4 N_19_1 N_19_5
+ PM_SDFHx1_ASAP7_75t_R%19
cc_46 N_19_4 N_4_14 0.014195f $X=0.6335 $Y=0.2295
cc_47 N_19_4 N_9_8 8.52833e-20 $X=0.6335 $Y=0.2295
cc_48 N_19_1 N_9_2 0.000721155f $X=0.648 $Y=0.2295
cc_49 N_19_5 N_9_8 0.00143529f $X=0.704 $Y=0.2295
cc_50 N_19_1 N_9_15 0.00176944f $X=0.648 $Y=0.2295
cc_51 N_19_5 N_9_15 0.00661032f $X=0.704 $Y=0.2295
cc_52 N_19_4 N_9_15 0.0229505f $X=0.6335 $Y=0.2295
cc_53 N_19_5 N_10_10 0.0175468f $X=0.704 $Y=0.2295
cc_54 N_19_4 N_11_3 0.000497965f $X=0.6335 $Y=0.2295
cc_55 N_19_1 N_11_17 0.00361422f $X=0.648 $Y=0.2295
x_PM_SDFHx1_ASAP7_75t_R%11 vss N_M9_g N_M25_g N_M6_d N_M7_s N_M22_d N_M23_s
+ N_11_11 N_11_3 N_11_13 N_11_15 N_11_17 N_11_19 N_11_4 N_11_21 N_11_20 N_11_10
+ N_11_12 N_11_16 N_11_1 N_11_9 N_11_14 PM_SDFHx1_ASAP7_75t_R%11
cc_56 N_11_11 N_4_3 0.000104143f $X=0.6335 $Y=0.081
cc_57 N_11_11 N_4_23 0.000104416f $X=0.6335 $Y=0.081
cc_58 N_11_11 N_4_20 0.000195338f $X=0.6335 $Y=0.081
cc_59 N_11_3 N_4_20 0.000389144f $X=0.594 $Y=0.2295
cc_60 N_11_13 N_4_14 0.00543281f $X=0.5795 $Y=0.189
cc_61 N_11_15 N_4_20 0.000438265f $X=0.693 $Y=0.131
cc_62 N_11_17 N_4_20 0.000449285f $X=0.6665 $Y=0.234
cc_63 N_11_19 N_4_23 0.000574406f $X=0.693 $Y=0.114
cc_64 N_11_4 N_4_2 0.000755306f $X=0.648 $Y=0.0405
cc_65 N_11_4 N_4_23 0.000891541f $X=0.648 $Y=0.0405
cc_66 N_11_4 N_4_14 0.00100031f $X=0.648 $Y=0.0405
cc_67 N_11_21 N_4_25 0.00102256f $X=0.756 $Y=0.131
cc_68 N_11_3 N_4_14 0.00118051f $X=0.594 $Y=0.2295
cc_69 N_11_20 N_4_25 0.00161996f $X=0.693 $Y=0.1465
cc_70 N_11_10 N_4_2 0.00162378f $X=0.6335 $Y=0.0405
cc_71 N_11_20 N_4_20 0.00207151f $X=0.693 $Y=0.1465
cc_72 N_11_10 N_4_14 0.0094026f $X=0.6335 $Y=0.0405
cc_73 N_11_12 N_4_14 0.0104949f $X=0.5795 $Y=0.2295
cc_74 N_11_11 N_4_14 0.0443579f $X=0.6335 $Y=0.081
cc_75 N_11_10 N_9_14 0.000137728f $X=0.6335 $Y=0.0405
cc_76 N_11_10 N_9_25 0.000315512f $X=0.6335 $Y=0.0405
cc_77 N_11_10 N_9_3 0.000168274f $X=0.6335 $Y=0.0405
cc_78 N_11_10 N_9_1 0.000185986f $X=0.6335 $Y=0.0405
cc_79 N_11_13 N_9_14 0.0234474f $X=0.5795 $Y=0.189
cc_80 N_11_3 N_9_24 0.000293271f $X=0.594 $Y=0.2295
cc_81 N_11_3 N_9_22 0.000370255f $X=0.594 $Y=0.2295
cc_82 N_11_11 N_9_15 0.0054493f $X=0.6335 $Y=0.081
cc_83 N_11_16 N_9_25 0.000440845f $X=0.693 $Y=0.234
cc_84 N_11_20 N_9_25 0.00606252f $X=0.693 $Y=0.1465
cc_85 N_11_1 N_9_8 0.00199086f $X=0.783 $Y=0.131
cc_86 N_11_4 N_9_15 0.000651499f $X=0.648 $Y=0.0405
cc_87 N_11_12 N_9_1 0.000652102f $X=0.5795 $Y=0.2295
cc_88 N_11_20 N_9_2 0.000755759f $X=0.693 $Y=0.1465
cc_89 N_11_20 N_9_8 0.000761596f $X=0.693 $Y=0.1465
cc_90 N_11_17 N_9_26 0.00134227f $X=0.6665 $Y=0.234
cc_91 N_11_21 N_9_25 0.00139948f $X=0.756 $Y=0.131
cc_92 N_11_3 N_9_14 0.00157156f $X=0.594 $Y=0.2295
cc_93 N_11_17 N_9_22 0.00360979f $X=0.6665 $Y=0.234
cc_94 N_11_9 N_9_8 0.00497935f $X=0.783 $Y=0.0245
cc_95 N_11_12 N_9_14 0.00939434f $X=0.5795 $Y=0.2295
cc_96 N_11_9 N_9_16 0.0117773f $X=0.783 $Y=0.0245
cc_97 N_11_10 N_9_15 0.0309312f $X=0.6335 $Y=0.0405
cc_98 N_11_9 N_10_12 0.00644907f $X=0.783 $Y=0.0245
cc_99 N_11_9 N_10_11 0.00634672f $X=0.783 $Y=0.0245
cc_100 N_11_14 N_10_14 0.000285511f $X=0.693 $Y=0.036
cc_101 N_11_4 N_10_1 0.000322213f $X=0.648 $Y=0.0405
cc_102 N_11_20 N_10_14 0.000397204f $X=0.693 $Y=0.1465
cc_103 N_11_21 N_10_15 0.000453035f $X=0.756 $Y=0.131
cc_104 N_11_21 N_10_1 0.000615862f $X=0.756 $Y=0.131
cc_105 N_11_1 N_10_17 0.000981656f $X=0.783 $Y=0.131
cc_106 N_11_9 N_10_3 0.000993529f $X=0.783 $Y=0.0245
cc_107 N_11_21 N_10_20 0.00105827f $X=0.756 $Y=0.131
cc_108 N_11_1 N_10_1 0.00121755f $X=0.783 $Y=0.131
cc_109 N_11_9 N_10_1 0.00183283f $X=0.783 $Y=0.0245
cc_110 N_11_19 N_10_14 0.00441274f $X=0.693 $Y=0.114
cc_111 N_11_21 N_10_17 0.00472686f $X=0.756 $Y=0.131
cc_112 N_11_9 N_10_10 0.0288006f $X=0.783 $Y=0.0245
x_PM_SDFHx1_ASAP7_75t_R%22 vss N_M7_d N_M8_s N_22_1 PM_SDFHx1_ASAP7_75t_R%22
cc_113 N_22_1 N_9_15 0.00754445f $X=0.702 $Y=0.0405
cc_114 N_22_1 N_10_10 0.00762774f $X=0.702 $Y=0.0405
x_PM_SDFHx1_ASAP7_75t_R%23 vss N_M27_d N_M28_s N_23_1 PM_SDFHx1_ASAP7_75t_R%23
cc_115 N_23_1 N_9_17 0.00757089f $X=0.972 $Y=0.2295
cc_116 N_23_1 N_12_9 0.00763942f $X=0.972 $Y=0.2295
x_PM_SDFHx1_ASAP7_75t_R%4 vss N_M11_g N_M26_g N_M6_g N_M23_g N_M1_g N_M17_g
+ N_M0_s N_M16_s N_4_21 N_4_7 N_4_22 N_4_16 N_4_17 N_4_8 N_4_1 N_4_19 N_4_25
+ N_4_18 N_4_13 N_4_24 N_4_23 N_4_15 N_4_3 N_4_14 N_4_20 N_4_2
+ PM_SDFHx1_ASAP7_75t_R%4
cc_117 N_4_21 N_CLK_3 0.000247304f $X=0.03 $Y=0.1215
cc_118 N_4_7 N_CLK_3 0.000963868f $X=0.054 $Y=0.054
cc_119 N_4_22 N_CLK_3 0.000310871f $X=0.135 $Y=0.1235
cc_120 N_4_16 N_CLK_3 0.0110896f $X=0.056 $Y=0.054
cc_121 N_4_17 N_CLK_3 0.0110272f $X=0.056 $Y=0.216
cc_122 N_4_8 N_CLK_3 0.00111854f $X=0.054 $Y=0.216
cc_123 N_4_1 N_CLK_3 0.000622923f $X=0.135 $Y=0.135
cc_124 N_4_22 N_CLK_6 0.000845917f $X=0.135 $Y=0.1235
cc_125 N_4_19 N_CLK_6 0.000913071f $X=0.03 $Y=0.234
cc_126 N_4_1 N_CLK_1 0.00418441f $X=0.135 $Y=0.135
cc_127 N_4_22 N_CLK_4 0.00108075f $X=0.135 $Y=0.1235
cc_128 N_4_21 N_CLK_4 0.0010827f $X=0.03 $Y=0.1215
cc_129 N_4_25 N_CLK_6 0.00144822f $X=0.8125 $Y=0.153
cc_130 N_4_22 N_CLK_7 0.0015548f $X=0.135 $Y=0.1235
cc_131 N_4_18 N_CLK_8 0.00170315f $X=0.03 $Y=0.036
cc_132 N_4_19 N_CLK_5 0.0021542f $X=0.03 $Y=0.234
cc_133 N_4_21 N_CLK_7 0.00653409f $X=0.03 $Y=0.1215
cc_134 N_4_13 N_CLK_3 0.0353637f $X=0.135 $Y=0.135
x_PM_SDFHx1_ASAP7_75t_R%SE vss SE N_M14_g N_M30_g N_M2_g N_M18_g N_SE_11 N_SE_7
+ N_SE_8 N_SE_10 N_SE_13 N_SE_6 N_SE_9 N_SE_12 N_SE_1 N_SE_2 N_SE_5
+ PM_SDFHx1_ASAP7_75t_R%SE
cc_135 N_SE_11 N_4_22 6.65987e-20 $X=0.2445 $Y=0.135
cc_136 N_SE_7 N_4_25 9.78279e-20 $X=0.225 $Y=0.036
cc_137 N_SE_8 N_4_22 0.000105207f $X=0.225 $Y=0.135
cc_138 N_SE_10 N_4_25 0.000374106f $X=0.225 $Y=0.0495
cc_139 N_SE_8 N_4_25 0.000394136f $X=0.225 $Y=0.135
cc_140 N_SE_13 N_4_24 0.000510371f $X=1.1905 $Y=0.045
cc_141 N_SE_13 N_4_25 0.0018364f $X=1.1905 $Y=0.045
cc_142 N_SE_11 N_4_25 0.00291732f $X=0.2445 $Y=0.135
x_PM_SDFHx1_ASAP7_75t_R%6 vss N_M3_g N_M19_g N_M14_s N_M30_s N_6_16 N_6_14
+ N_6_10 N_6_11 N_6_15 N_6_4 N_6_3 N_6_1 N_6_12 N_6_13 N_6_9
+ PM_SDFHx1_ASAP7_75t_R%6
cc_143 N_6_16 N_4_24 0.0028171f $X=0.3395 $Y=0.081
cc_144 N_6_16 N_4_23 0.000268274f $X=0.3395 $Y=0.081
cc_145 N_6_14 N_4_25 0.00127059f $X=0.351 $Y=0.135
cc_146 N_6_16 N_4_25 0.0064069f $X=0.3395 $Y=0.081
cc_147 N_6_10 N_SE_6 0.0238595f $X=1.19 $Y=0.0405
cc_148 N_6_11 N_SE_6 0.0067177f $X=1.19 $Y=0.2295
cc_149 N_6_15 N_SE_9 0.000592677f $X=1.161 $Y=0.037
cc_150 N_6_4 N_SE_12 0.000237698f $X=1.188 $Y=0.2295
cc_151 N_6_3 N_SE_12 0.000260677f $X=1.1485 $Y=0.0455
cc_152 N_6_1 N_SE_11 0.000282148f $X=0.351 $Y=0.135
cc_153 N_6_1 N_SE_1 0.00128719f $X=0.351 $Y=0.135
cc_154 N_6_4 N_SE_6 0.000390182f $X=1.188 $Y=0.2295
cc_155 N_6_3 N_SE_2 0.000453201f $X=1.1485 $Y=0.0455
cc_156 N_6_12 N_SE_13 0.000457902f $X=0.351 $Y=0.072
cc_157 N_6_15 N_SE_2 0.000490431f $X=1.161 $Y=0.037
cc_158 N_6_13 N_SE_12 0.000493475f $X=1.161 $Y=0.234
cc_159 N_6_15 N_SE_13 0.000641588f $X=1.161 $Y=0.037
cc_160 N_6_3 N_SE_6 0.00108827f $X=1.1485 $Y=0.0455
cc_161 N_6_14 N_SE_11 0.00141773f $X=0.351 $Y=0.135
cc_162 N_6_9 N_SE_5 0.00323523f $X=0.351 $Y=0.0245
cc_163 N_6_15 N_SE_12 0.0072711f $X=1.161 $Y=0.037
cc_164 N_6_16 N_SE_13 0.0573616f $X=0.3395 $Y=0.081
x_PM_SDFHx1_ASAP7_75t_R%9 vss N_M10_g N_M7_g N_M27_g N_M22_g N_M1_d N_M17_d
+ N_9_23 N_9_7 N_9_6 N_9_20 N_9_21 N_9_18 N_9_19 N_9_3 N_9_4 N_9_25 N_9_22
+ N_9_8 N_9_2 N_9_26 N_9_1 N_9_14 N_9_24 N_9_16 N_9_15 N_9_17
+ PM_SDFHx1_ASAP7_75t_R%9
cc_165 N_9_23 N_CLK_6 0.001161f $X=0.189 $Y=0.187
cc_166 N_9_7 N_CLK_6 0.000320422f $X=0.162 $Y=0.216
cc_167 N_9_6 N_CLK_6 0.000388767f $X=0.162 $Y=0.054
cc_168 N_9_20 N_CLK_6 0.00178477f $X=0.189 $Y=0.036
cc_169 N_9_21 N_CLK_6 0.00187322f $X=0.189 $Y=0.234
cc_170 N_9_20 N_4_25 3.74383e-20 $X=0.189 $Y=0.036
cc_171 N_9_18 N_4_7 5.24868e-20 $X=0.1475 $Y=0.054
cc_172 N_9_19 N_4_8 5.71255e-20 $X=0.1475 $Y=0.216
cc_173 N_9_21 N_4_19 6.91684e-20 $X=0.189 $Y=0.234
cc_174 N_9_18 N_4_1 7.24779e-20 $X=0.1475 $Y=0.054
cc_175 N_9_6 N_4_13 0.000644911f $X=0.162 $Y=0.054
cc_176 N_9_7 N_4_13 0.00079429f $X=0.162 $Y=0.216
cc_177 N_9_3 N_4_15 0.000190356f $X=0.837 $Y=0.178
cc_178 N_9_6 N_4_21 0.000213521f $X=0.162 $Y=0.054
cc_179 N_9_4 N_4_15 0.000216191f $X=0.945 $Y=0.178
cc_180 N_9_20 N_4_22 0.000289285f $X=0.189 $Y=0.036
cc_181 N_9_21 N_4_22 0.000309703f $X=0.189 $Y=0.234
cc_182 N_9_25 N_4_25 0.000835318f $X=0.729 $Y=0.168
cc_183 N_9_19 N_4_13 0.010985f $X=0.1475 $Y=0.216
cc_184 N_9_18 N_4_13 0.0388782f $X=0.1475 $Y=0.054
cc_185 N_9_23 N_4_22 0.00447991f $X=0.189 $Y=0.187
cc_186 N_9_22 N_4_25 0.000409621f $X=0.567 $Y=0.198
cc_187 N_9_8 N_4_24 0.000442756f $X=0.837 $Y=0.178
cc_188 N_9_8 N_4_3 0.00241447f $X=0.837 $Y=0.178
cc_189 N_9_2 N_4_14 0.000540737f $X=0.675 $Y=0.178
cc_190 N_9_26 N_4_20 0.00055467f $X=0.1775 $Y=0.189
cc_191 N_9_23 N_4_25 0.000573725f $X=0.189 $Y=0.187
cc_192 N_9_23 N_4_1 0.000671974f $X=0.189 $Y=0.187
cc_193 N_9_1 N_4_2 0.00237872f $X=0.567 $Y=0.1355
cc_194 N_9_14 N_4_14 0.00158946f $X=0.567 $Y=0.1355
cc_195 N_9_22 N_4_20 0.00175437f $X=0.567 $Y=0.198
cc_196 N_9_24 N_4_23 0.00268845f $X=0.567 $Y=0.1755
cc_197 N_9_8 N_4_15 0.00476961f $X=0.837 $Y=0.178
cc_198 N_9_16 N_4_15 0.00545732f $X=0.837 $Y=0.0245
cc_199 N_9_15 N_4_14 0.00851917f $X=0.675 $Y=0.178
cc_200 N_9_17 N_4_15 0.0172122f $X=0.945 $Y=0.178
cc_201 N_9_26 N_4_25 0.0417483f $X=0.1775 $Y=0.189
cc_202 N_9_6 N_SE_10 0.000214818f $X=0.162 $Y=0.054
cc_203 N_9_26 N_SE_13 0.000251386f $X=0.1775 $Y=0.189
cc_204 N_9_20 N_SE_7 0.0019833f $X=0.189 $Y=0.036
cc_205 N_9_24 N_SE_13 0.000751965f $X=0.567 $Y=0.1755
cc_206 N_9_26 N_SE_11 0.00111147f $X=0.1775 $Y=0.189
cc_207 N_9_23 N_SE_10 0.00261546f $X=0.189 $Y=0.187
cc_208 N_9_23 N_SE_8 0.00552876f $X=0.189 $Y=0.187
cc_209 N_9_1 N_SI_7 0.000448525f $X=0.567 $Y=0.1355
cc_210 N_9_22 N_SI_7 0.000206437f $X=0.567 $Y=0.198
cc_211 N_9_26 N_SI_7 0.000681848f $X=0.1775 $Y=0.189
cc_212 N_9_24 N_SI_8 0.000664487f $X=0.567 $Y=0.1755
cc_213 N_9_24 N_SI_5 0.000843524f $X=0.567 $Y=0.1755
cc_214 N_9_26 N_SI_8 0.00096424f $X=0.1775 $Y=0.189
cc_215 N_9_22 N_SI_4 0.00111059f $X=0.567 $Y=0.198
cc_216 N_9_24 N_SI_7 0.0032563f $X=0.567 $Y=0.1755
x_PM_SDFHx1_ASAP7_75t_R%10 vss N_M8_g N_M24_g N_M10_s N_M9_d N_M25_d N_M26_s
+ N_10_13 N_10_18 N_10_20 N_10_15 N_10_14 N_10_17 N_10_3 N_10_1 N_10_11 N_10_12
+ N_10_4 N_10_10 N_10_16 N_10_19 PM_SDFHx1_ASAP7_75t_R%10
cc_217 N_10_13 N_4_24 0.000144296f $X=0.866 $Y=0.2295
cc_218 N_10_13 N_4_25 0.000180505f $X=0.866 $Y=0.2295
cc_219 N_10_13 N_4_14 0.00018201f $X=0.866 $Y=0.2295
cc_220 N_10_13 N_4_3 0.000194575f $X=0.866 $Y=0.2295
cc_221 N_10_18 N_4_25 0.000247978f $X=0.8125 $Y=0.234
cc_222 N_10_20 N_4_24 0.00410898f $X=0.837 $Y=0.1
cc_223 N_10_20 N_4_3 0.000353515f $X=0.837 $Y=0.1
cc_224 N_10_15 N_4_24 0.000527136f $X=0.81 $Y=0.09
cc_225 N_10_14 N_4_25 0.0016307f $X=0.729 $Y=0.09
cc_226 N_10_13 N_4_15 0.0154038f $X=0.866 $Y=0.2295
cc_227 N_10_17 N_6_16 0.000564622f $X=0.747 $Y=0.09
cc_228 N_10_14 N_6_16 0.00087101f $X=0.729 $Y=0.09
cc_229 N_10_15 N_6_16 0.00235704f $X=0.81 $Y=0.09
cc_230 N_10_3 N_9_8 0.000583464f $X=0.81 $Y=0.0405
cc_231 N_10_3 N_9_25 0.000114255f $X=0.81 $Y=0.0405
cc_232 N_10_1 N_9_8 0.00020591f $X=0.7285 $Y=0.09
cc_233 N_10_11 N_9_16 0.00651162f $X=0.7955 $Y=0.0405
cc_234 N_10_12 N_9_16 0.00763077f $X=0.7955 $Y=0.2295
cc_235 N_10_13 N_9_16 0.00767083f $X=0.866 $Y=0.2295
cc_236 N_10_18 N_9_25 0.000325205f $X=0.8125 $Y=0.234
cc_237 N_10_18 N_9_8 0.000370584f $X=0.8125 $Y=0.234
cc_238 N_10_1 N_9_15 0.000729702f $X=0.7285 $Y=0.09
cc_239 N_10_4 N_9_3 0.000871193f $X=0.81 $Y=0.2295
cc_240 N_10_20 N_9_8 0.00156515f $X=0.837 $Y=0.1
cc_241 N_10_4 N_9_16 0.00227824f $X=0.81 $Y=0.2295
cc_242 N_10_4 N_9_8 0.00635814f $X=0.81 $Y=0.2295
cc_243 N_10_10 N_9_15 0.0136698f $X=0.729 $Y=0.0245
cc_244 N_10_3 N_9_16 0.0289276f $X=0.81 $Y=0.0405
x_PM_SDFHx1_ASAP7_75t_R%12 vss N_M12_g N_M28_g N_M13_d N_M29_d N_12_16 N_12_15
+ N_12_17 N_12_14 N_12_13 N_12_9 N_12_1 N_12_3 N_12_4 N_12_12 N_12_10 N_12_11
+ PM_SDFHx1_ASAP7_75t_R%12
cc_245 N_12_16 N_SE_13 0.000897973f $X=1.026 $Y=0.036
cc_246 N_12_15 N_SE_13 0.00324801f $X=0.999 $Y=0.0705
cc_247 N_12_17 N_6_13 0.000131983f $X=1.107 $Y=0.081
cc_248 N_12_17 N_6_3 0.00118364f $X=1.107 $Y=0.081
cc_249 N_12_16 N_6_16 0.000337041f $X=1.026 $Y=0.036
cc_250 N_12_14 N_6_15 0.000399389f $X=1.107 $Y=0.0305
cc_251 N_12_13 N_6_13 0.000733452f $X=1.107 $Y=0.234
cc_252 N_12_15 N_6_16 0.00260171f $X=0.999 $Y=0.0705
cc_253 N_12_17 N_6_15 0.00804191f $X=1.107 $Y=0.081
cc_254 N_12_9 N_9_8 0.000579802f $X=0.999 $Y=0.0245
cc_255 N_12_9 N_9_4 0.000346979f $X=0.999 $Y=0.0245
cc_256 N_12_1 N_9_17 0.000500085f $X=0.999 $Y=0.1055
cc_257 N_12_9 N_9_17 0.0122628f $X=0.999 $Y=0.0245
x_PM_SDFHx1_ASAP7_75t_R%QN vss QN N_M15_d N_M31_d N_QN_9 N_QN_8 N_QN_1 N_QN_2
+ N_QN_7 N_QN_11 PM_SDFHx1_ASAP7_75t_R%QN
cc_258 N_QN_9 N_SE_12 0.000628857f $X=1.2845 $Y=0.036
cc_259 N_QN_9 N_SE_9 0.00184849f $X=1.2845 $Y=0.036
cc_260 N_QN_8 N_13_24 0.00129774f $X=1.2815 $Y=0.2025
cc_261 N_QN_8 N_13_25 0.000670633f $X=1.2815 $Y=0.2025
cc_262 N_QN_8 N_13_2 0.00247266f $X=1.2815 $Y=0.2025
cc_263 N_QN_1 N_13_12 0.00110501f $X=1.296 $Y=0.0675
cc_264 N_QN_2 N_13_12 0.00126382f $X=1.296 $Y=0.2025
cc_265 N_QN_7 N_13_12 0.0148708f $X=1.2815 $Y=0.0675
cc_266 N_QN_11 N_13_24 0.00638266f $X=1.323 $Y=0.0675
cc_267 N_QN_8 N_13_12 0.055235f $X=1.2815 $Y=0.2025
x_PM_SDFHx1_ASAP7_75t_R%20 vss N_M11_d N_M12_s N_20_4 N_20_1 N_20_5
+ PM_SDFHx1_ASAP7_75t_R%20
cc_268 N_20_4 N_4_3 0.000238689f $X=0.9035 $Y=0.0405
cc_269 N_20_4 N_4_15 0.0147519f $X=0.9035 $Y=0.0405
cc_270 N_20_1 N_9_17 0.000691149f $X=0.918 $Y=0.0405
cc_271 N_20_5 N_9_17 0.00666939f $X=0.974 $Y=0.0405
cc_272 N_20_4 N_9_17 0.0257715f $X=0.9035 $Y=0.0405
cc_273 N_20_1 N_12_9 0.000851296f $X=0.918 $Y=0.0405
cc_274 N_20_5 N_12_9 0.0149832f $X=0.974 $Y=0.0405
cc_275 N_20_1 N_13_13 0.000318964f $X=0.918 $Y=0.0405
cc_276 N_20_1 N_13_19 0.000406769f $X=0.918 $Y=0.0405
cc_277 N_20_1 N_13_20 0.000465887f $X=0.918 $Y=0.0405
cc_278 N_20_4 N_13_5 0.000557578f $X=0.9035 $Y=0.0405
cc_279 N_20_1 N_13_16 0.00232284f $X=0.918 $Y=0.0405
x_PM_SDFHx1_ASAP7_75t_R%13 vss N_M13_g N_M29_g N_M15_g N_M31_g N_M26_d N_M27_s
+ N_M10_d N_M11_s N_13_22 N_13_13 N_13_14 N_13_15 N_13_17 N_13_19 N_13_21
+ N_13_5 N_13_20 N_13_25 N_13_24 N_13_16 N_13_2 N_13_12 N_13_1 N_13_23 N_13_6
+ N_13_11 N_13_18 PM_SDFHx1_ASAP7_75t_R%13
cc_280 N_13_22 N_4_24 0.000163867f $X=1.026 $Y=0.162
cc_281 N_13_13 N_4_15 0.00653501f $X=0.8495 $Y=0.0405
cc_282 N_13_14 N_4_15 0.00650474f $X=0.9035 $Y=0.2295
cc_283 N_13_15 N_4_24 0.000317452f $X=0.945 $Y=0.234
cc_284 N_13_17 N_4_24 0.00138724f $X=0.945 $Y=0.1575
cc_285 N_13_19 N_4_24 0.000412848f $X=0.92 $Y=0.036
cc_286 N_13_21 N_4_24 0.000424241f $X=0.945 $Y=0.198
cc_287 N_13_5 N_4_3 0.0005001f $X=0.864 $Y=0.0405
cc_288 N_13_20 N_4_3 0.000513079f $X=0.945 $Y=0.1315
cc_289 N_13_25 N_4_25 0.000732895f $X=0.945 $Y=0.153
cc_290 N_13_19 N_4_25 0.000951516f $X=0.92 $Y=0.036
cc_291 N_13_20 N_4_24 0.0044001f $X=0.945 $Y=0.1315
cc_292 N_13_5 N_4_15 0.0187414f $X=0.864 $Y=0.0405
cc_293 N_13_24 N_SE_9 0.00022303f $X=1.269 $Y=0.1085
cc_294 N_13_16 N_SE_13 0.000257859f $X=0.945 $Y=0.036
cc_295 N_13_2 N_SE_2 0.00189516f $X=1.269 $Y=0.136
cc_296 N_13_19 N_SE_13 0.000975098f $X=0.92 $Y=0.036
cc_297 N_13_25 N_SE_13 0.00197662f $X=0.945 $Y=0.153
cc_298 N_13_20 N_SE_13 0.00276935f $X=0.945 $Y=0.1315
cc_299 N_13_12 N_SE_6 0.00325687f $X=1.269 $Y=0.136
cc_300 N_13_24 N_SE_12 0.0058484f $X=1.269 $Y=0.1085
cc_301 N_13_25 N_6_16 0.00465919f $X=0.945 $Y=0.153
cc_302 N_13_17 N_6_16 0.000160704f $X=0.945 $Y=0.1575
cc_303 N_13_12 N_6_3 0.000162363f $X=1.269 $Y=0.136
cc_304 N_13_24 N_6_15 0.000183079f $X=1.269 $Y=0.1085
cc_305 N_13_25 N_6_15 0.00174324f $X=0.945 $Y=0.153
cc_306 N_13_1 N_6_15 0.000215713f $X=1.053 $Y=0.14
cc_307 N_13_22 N_6_16 0.000219276f $X=1.026 $Y=0.162
cc_308 N_13_19 N_6_16 0.000293579f $X=0.92 $Y=0.036
cc_309 N_13_24 N_6_13 0.000310306f $X=1.269 $Y=0.1085
cc_310 N_13_23 N_6_16 0.000376706f $X=1.053 $Y=0.125
cc_311 N_13_20 N_6_16 0.00584271f $X=0.945 $Y=0.1315
cc_312 N_13_14 N_9_8 0.000166367f $X=0.9035 $Y=0.2295
cc_313 N_13_17 N_9_8 0.000191687f $X=0.945 $Y=0.1575
cc_314 N_13_6 N_9_8 0.000219326f $X=0.918 $Y=0.2295
cc_315 N_13_13 N_9_16 0.00656824f $X=0.8495 $Y=0.0405
cc_316 N_13_22 N_9_8 0.000356948f $X=1.026 $Y=0.162
cc_317 N_13_20 N_9_8 0.000518101f $X=0.945 $Y=0.1315
cc_318 N_13_21 N_9_8 0.000569503f $X=0.945 $Y=0.198
cc_319 N_13_6 N_9_17 0.000928804f $X=0.918 $Y=0.2295
cc_320 N_13_14 N_9_4 0.00116078f $X=0.9035 $Y=0.2295
cc_321 N_13_5 N_9_8 0.00278448f $X=0.864 $Y=0.0405
cc_322 N_13_5 N_9_16 0.00946347f $X=0.864 $Y=0.0405
cc_323 N_13_14 N_9_17 0.0167351f $X=0.9035 $Y=0.2295
cc_324 N_13_14 N_10_3 0.000439214f $X=0.9035 $Y=0.2295
cc_325 N_13_15 N_10_16 0.00023682f $X=0.945 $Y=0.234
cc_326 N_13_13 N_10_11 0.000478204f $X=0.8495 $Y=0.0405
cc_327 N_13_15 N_10_4 0.000280175f $X=0.945 $Y=0.234
cc_328 N_13_6 N_10_4 0.000720649f $X=0.918 $Y=0.2295
cc_329 N_13_19 N_10_19 0.000391414f $X=0.92 $Y=0.036
cc_330 N_13_15 N_10_20 0.000580833f $X=0.945 $Y=0.234
cc_331 N_13_14 N_10_4 0.000581349f $X=0.9035 $Y=0.2295
cc_332 N_13_19 N_10_15 0.00136498f $X=0.92 $Y=0.036
cc_333 N_13_5 N_10_3 0.00354988f $X=0.864 $Y=0.0405
cc_334 N_13_21 N_12_9 0.000210555f $X=0.945 $Y=0.198
cc_335 N_13_23 N_12_16 0.00033165f $X=1.053 $Y=0.125
cc_336 N_13_11 N_12_3 0.000350057f $X=1.053 $Y=0.0245
cc_337 N_13_11 N_12_4 0.000484593f $X=1.053 $Y=0.0245
cc_338 N_13_18 N_12_13 0.000738141f $X=1.053 $Y=0.162
cc_339 N_13_18 N_12_17 0.000772014f $X=1.053 $Y=0.162
cc_340 N_13_16 N_12_12 0.000860689f $X=0.945 $Y=0.036
cc_341 N_13_1 N_12_17 0.000873129f $X=1.053 $Y=0.14
cc_342 N_13_20 N_12_1 0.000937725f $X=0.945 $Y=0.1315
cc_343 N_13_11 N_12_1 0.0010674f $X=1.053 $Y=0.0245
cc_344 N_13_1 N_12_9 0.00117175f $X=1.053 $Y=0.14
cc_345 N_13_22 N_12_15 0.00148777f $X=1.026 $Y=0.162
cc_346 N_13_25 N_12_17 0.0016235f $X=0.945 $Y=0.153
cc_347 N_13_11 N_12_10 0.00645578f $X=1.053 $Y=0.0245
cc_348 N_13_11 N_12_11 0.00654642f $X=1.053 $Y=0.0245
cc_349 N_13_20 N_12_15 0.00398801f $X=0.945 $Y=0.1315
cc_350 N_13_23 N_12_17 0.0048435f $X=1.053 $Y=0.125
cc_351 N_13_11 N_12_9 0.0307875f $X=1.053 $Y=0.0245
x_PM_SDFHx1_ASAP7_75t_R%D vss D N_M4_g N_M20_g N_D_5 N_D_1 N_D_4 N_D_3
+ PM_SDFHx1_ASAP7_75t_R%D
cc_352 N_D_5 N_4_25 0.0121035f $X=0.3665 $Y=0.117
cc_353 N_D_5 N_SE_11 0.000448913f $X=0.3665 $Y=0.117
cc_354 N_D_5 N_SE_13 0.0023377f $X=0.3665 $Y=0.117
cc_355 N_D_5 N_6_12 0.000452826f $X=0.3665 $Y=0.117
cc_356 N_D_1 N_6_1 0.00198865f $X=0.405 $Y=0.135
cc_357 N_D_4 N_6_14 0.00267463f $X=0.405 $Y=0.135
cc_358 N_D_3 N_6_9 0.0050023f $X=0.405 $Y=0.0245
cc_359 N_D_5 N_6_16 0.00903124f $X=0.3665 $Y=0.117
x_PM_SDFHx1_ASAP7_75t_R%SI vss SI N_M5_g N_M21_g N_SI_8 N_SI_6 N_SI_1 N_SI_3
+ N_SI_7 N_SI_5 N_SI_4 PM_SDFHx1_ASAP7_75t_R%SI
cc_360 N_SI_8 N_4_23 0.000167815f $X=0.4697 $Y=0.117
cc_361 N_SI_6 N_4_25 0.000848403f $X=0.4635 $Y=0.135
cc_362 N_SI_8 N_4_25 0.0105778f $X=0.4697 $Y=0.117
cc_363 N_SI_8 N_6_16 0.00982589f $X=0.4697 $Y=0.117
cc_364 N_SI_6 N_D_4 0.00103757f $X=0.4635 $Y=0.135
cc_365 N_SI_1 N_D_1 0.00112723f $X=0.4575 $Y=0.135
cc_366 N_SI_3 N_D_3 0.00482672f $X=0.459 $Y=0.0245

* End of included file SDFHx1_ASAP7_75t_R.pex.sp.pxi
.ends

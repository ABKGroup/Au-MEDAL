.subckt PM_DLLx1_ASAP7_75t_R%CLK vss 18 9 15 3 1 4 5 7 8 6
c1 1 vss 0.00378038f $X=0.081 $Y=0.135
c2 3 vss 0.0687615f $X=0.081 $Y=0.0245
c3 4 vss 0.00208829f $X=0.081 $Y=0.099
c4 5 vss 0.00174948f $X=0.081 $Y=0.171
c5 6 vss 0.00100139f $X=0.081 $Y=0.135
c6 7 vss 0.00437411f $X=0.108 $Y=0.063
c7 8 vss 0.00441195f $X=0.108 $Y=0.198
r1 8 24 2.40741 $w=2.45e-08 $l=2.7e-08 $layer=M1 $thickness=3.6e-08 $X=0.108
+ $Y=0.198 $X2=0.108 $Y2=0.171
r2 7 22 4.50612 $w=2.06667e-08 $l=3.6e-08 $layer=M1 $thickness=3.6e-08 $X=0.108
+ $Y=0.063 $X2=0.108 $Y2=0.099
r3 23 24 0.502848 $w=3.43333e-08 $l=1.35e-08 $layer=M1 $thickness=3.6e-08
+ $X=0.0945 $Y=0.171 $X2=0.108 $Y2=0.171
r4 5 20 1.35805 $w=2.83333e-08 $l=2.25e-08 $layer=M1 $thickness=3.6e-08
+ $X=0.081 $Y=0.171 $X2=0.081 $Y2=0.1485
r5 5 23 0.502848 $w=3.43333e-08 $l=1.35e-08 $layer=M1 $thickness=3.6e-08
+ $X=0.081 $Y=0.171 $X2=0.0945 $Y2=0.171
r6 21 22 0.502848 $w=3.43333e-08 $l=1.35e-08 $layer=M1 $thickness=3.6e-08
+ $X=0.0945 $Y=0.099 $X2=0.108 $Y2=0.099
r7 4 17 0.483592 $w=3.42308e-08 $l=1.87e-08 $layer=M1 $thickness=3.6e-08
+ $X=0.081 $Y=0.099 $X2=0.081 $Y2=0.1177
r8 4 21 0.502848 $w=3.43333e-08 $l=1.35e-08 $layer=M1 $thickness=3.6e-08
+ $X=0.081 $Y=0.099 $X2=0.0945 $Y2=0.099
r9 18 19 0.874462 $w=1.3e-08 $l=3.7e-09 $layer=M1 $thickness=3.6e-08 $X=0.082
+ $Y=0.119 $X2=0.081 $Y2=0.1227
r10 18 17 0.291487 $w=1.3e-08 $l=1.3e-09 $layer=M1 $thickness=3.6e-08 $X=0.082
+ $Y=0.119 $X2=0.081 $Y2=0.1177
r11 6 19 2.85657 $w=1.3e-08 $l=1.23e-08 $layer=M1 $thickness=3.6e-08 $X=0.081
+ $Y=0.135 $X2=0.081 $Y2=0.1227
r12 6 20 3.14806 $w=1.3e-08 $l=1.35e-08 $layer=M1 $thickness=3.6e-08 $X=0.081
+ $Y=0.135 $X2=0.081 $Y2=0.1485
r13 1 12 10.4265 $w=1.765e-08 $layer=LIG $thickness=5.2e-08 $X=0.081 $Y=0.135
+ $X2=0.081 $Y2=0.135
r14 1 6 19.3796 $a=3.24e-16 $layer=V0LIG $X=0.081 $Y=0.135 $X2=0.081 $Y2=0.135
r15 15 14 14.6259 $w=2.1e-08 $l=4.3e-08 $layer=Gate_1 $thickness=5.6e-08
+ $X=0.081 $Y=0.216 $X2=0.081 $Y2=0.173
r16 13 14 7.31297 $w=2.1e-08 $l=2.15e-08 $layer=Gate_1 $thickness=5.6e-08
+ $X=0.081 $Y=0.1515 $X2=0.081 $Y2=0.173
r17 12 13 5.79936 $w=2.03333e-08 $l=1.65e-08 $layer=Gate_1 $thickness=5.6e-08
+ $X=0.081 $Y=0.135 $X2=0.081 $Y2=0.1515
r18 11 12 5.79936 $w=2.03333e-08 $l=1.65e-08 $layer=Gate_1 $thickness=5.6e-08
+ $X=0.081 $Y=0.1185 $X2=0.081 $Y2=0.135
r19 10 11 7.31297 $w=2.1e-08 $l=2.15e-08 $layer=Gate_1 $thickness=5.6e-08
+ $X=0.081 $Y=0.097 $X2=0.081 $Y2=0.1185
r20 9 10 14.6259 $w=2.1e-08 $l=4.3e-08 $layer=Gate_1 $thickness=5.6e-08
+ $X=0.081 $Y=0.054 $X2=0.081 $Y2=0.097
r21 9 3 10.0341 $w=2.1e-08 $l=2.95e-08 $layer=Gate_1 $thickness=5.6e-08
+ $X=0.081 $Y=0.054 $X2=0.081 $Y2=0.0245
.ends

.subckt PM_DLLx1_ASAP7_75t_R%13 vss 2 3 1
c1 1 vss 0.000752697f $X=0.324 $Y=0.2025
r1 2 1 0.209877 $w=8.1e-08 $l=1.7e-08 $layer=P_src_drn $thickness=1e-09
+ $X=0.3066 $Y=0.2025 $X2=0.324 $Y2=0.2025
r2 3 1 0.209877 $w=8.1e-08 $l=1.7e-08 $layer=P_src_drn $thickness=1e-09
+ $X=0.3413 $Y=0.2025 $X2=0.324 $Y2=0.2025
.ends

.subckt PM_DLLx1_ASAP7_75t_R%4 vss 31 35 71 75 78 80 6 5 16 13 14 21 25 1 23 24
+ 27 22 18 20 11 26 19 12 2
c1 1 vss 0.00339531f $X=0.153 $Y=0.135
c2 2 vss 0.000278843f $X=0.405 $Y=0.133
c3 5 vss 0.00786942f $X=0.054 $Y=0.054
c4 6 vss 0.00790241f $X=0.054 $Y=0.216
c5 11 vss 0.0685463f $X=0.135 $Y=0.135
c6 12 vss 0.00712059f $X=0.405 $Y=0.0245
c7 13 vss 0.0308787f $X=0.056 $Y=0.054
c8 14 vss 0.0309255f $X=0.056 $Y=0.216
c9 15 vss 0.00358488f $X=0.018 $Y=0.036
c10 16 vss 0.00213156f $X=0.0165 $Y=0.153
c11 17 vss 0.00355774f $X=0.018 $Y=0.234
c12 18 vss 0.00137189f $X=0.189 $Y=0.198
c13 19 vss 0.00061489f $X=0.189 $Y=0.135
c14 20 vss 0.00638539f $X=0.018 $Y=0.1305
c15 21 vss 0.00408784f $X=0.018 $Y=0.1755
c16 22 vss 0.00460702f $X=0.036 $Y=0.036
c17 23 vss 0.00436397f $X=0.036 $Y=0.234
c18 24 vss 0.000624824f $X=0.1545 $Y=0.135
c19 25 vss 0.000791289f $X=0.189 $Y=0.1485
c20 26 vss 0.00122075f $X=0.405 $Y=0.116
c21 27 vss 0.0156221f $X=0.3125 $Y=0.153
r1 80 79 0.0462963 $w=5.4e-08 $l=2.5e-09 $layer=P_src_drn $thickness=1e-09
+ $X=0.0713 $Y=0.216 $X2=0.0685 $Y2=0.216
r2 14 79 0.231482 $w=5.4e-08 $l=1.25e-08 $layer=P_src_drn $thickness=1e-09
+ $X=0.056 $Y=0.216 $X2=0.0685 $Y2=0.216
r3 78 77 0.0462963 $w=5.4e-08 $l=2.5e-09 $layer=N_src_drn $thickness=1e-09
+ $X=0.0713 $Y=0.054 $X2=0.0685 $Y2=0.054
r4 13 77 0.231482 $w=5.4e-08 $l=1.25e-08 $layer=N_src_drn $thickness=1e-09
+ $X=0.056 $Y=0.054 $X2=0.0685 $Y2=0.054
r5 75 74 14.6259 $w=2.1e-08 $l=4.3e-08 $layer=Gate_1 $thickness=5.6e-08
+ $X=0.135 $Y=0.216 $X2=0.135 $Y2=0.173
r6 73 74 7.31297 $w=2.1e-08 $l=2.15e-08 $layer=Gate_1 $thickness=5.6e-08
+ $X=0.135 $Y=0.1515 $X2=0.135 $Y2=0.173
r7 71 72 14.6259 $w=2.1e-08 $l=4.3e-08 $layer=Gate_1 $thickness=5.6e-08
+ $X=0.135 $Y=0.054 $X2=0.135 $Y2=0.097
r8 69 72 7.31297 $w=2.1e-08 $l=2.15e-08 $layer=Gate_1 $thickness=5.6e-08
+ $X=0.135 $Y=0.1185 $X2=0.135 $Y2=0.097
r9 11 67 3.9286 $w=2e-08 $layer=Gate_1 $thickness=5.6e-08 $X=0.135 $Y=0.135
+ $X2=0.135 $Y2=0.135
r10 11 69 5.79936 $w=2.03333e-08 $l=1.65e-08 $layer=Gate_1 $thickness=5.6e-08
+ $X=0.135 $Y=0.135 $X2=0.135 $Y2=0.1185
r11 11 73 5.79936 $w=2.03333e-08 $l=1.65e-08 $layer=Gate_1 $thickness=5.6e-08
+ $X=0.135 $Y=0.135 $X2=0.135 $Y2=0.1515
r12 6 62 19.3796 $a=3.24e-16 $layer=V0LISD $X=0.054 $Y=0.216 $X2=0.055 $Y2=0.234
r13 5 59 19.3796 $a=3.24e-16 $layer=V0LISD $X=0.054 $Y=0.054 $X2=0.055 $Y2=0.036
r14 65 66 2.6116 $w=2.2e-08 $l=1e-08 $layer=LIG $thickness=4.8e-08 $X=0.134
+ $Y=0.135 $X2=0.144 $Y2=0.135
r15 65 67 2.35044 $w=2.2e-08 $l=1e-09 $layer=LIG $thickness=4.8e-08 $X=0.134
+ $Y=0.135 $X2=0.135 $Y2=0.135
r16 1 24 19.3796 $a=3.24e-16 $layer=V0LIG $X=0.153 $Y=0.135 $X2=0.1545 $Y2=0.135
r17 1 66 4.98695 $w=1.60444e-08 $l=9e-09 $layer=LIG $thickness=4.8e-08 $X=0.153
+ $Y=0.135 $X2=0.144 $Y2=0.135
r18 61 62 2.09871 $w=1.3e-08 $l=9e-09 $layer=M1 $thickness=3.6e-08 $X=0.046
+ $Y=0.234 $X2=0.055 $Y2=0.234
r19 23 61 2.3319 $w=1.3e-08 $l=1e-08 $layer=M1 $thickness=3.6e-08 $X=0.036
+ $Y=0.234 $X2=0.046 $Y2=0.234
r20 58 59 2.09871 $w=1.3e-08 $l=9e-09 $layer=M1 $thickness=3.6e-08 $X=0.046
+ $Y=0.036 $X2=0.055 $Y2=0.036
r21 22 58 2.3319 $w=1.3e-08 $l=1e-08 $layer=M1 $thickness=3.6e-08 $X=0.036
+ $Y=0.036 $X2=0.046 $Y2=0.036
r22 24 55 3.73104 $w=1.3e-08 $l=1.6e-08 $layer=M1 $thickness=3.6e-08 $X=0.1545
+ $Y=0.135 $X2=0.1705 $Y2=0.135
r23 17 53 4.64701 $w=1.62667e-08 $l=2.7e-08 $layer=M1 $thickness=3.6e-08
+ $X=0.018 $Y=0.234 $X2=0.018 $Y2=0.207
r24 17 23 2.5483 $w=1.55e-08 $l=1.8e-08 $layer=M1 $thickness=3.6e-08 $X=0.018
+ $Y=0.234 $X2=0.036 $Y2=0.234
r25 15 52 4.64701 $w=1.62667e-08 $l=2.7e-08 $layer=M1 $thickness=3.6e-08
+ $X=0.018 $Y=0.036 $X2=0.018 $Y2=0.063
r26 15 22 2.5483 $w=1.55e-08 $l=1.8e-08 $layer=M1 $thickness=3.6e-08 $X=0.018
+ $Y=0.036 $X2=0.036 $Y2=0.036
r27 18 50 4.06646 $w=1.5e-08 $l=2.25e-08 $layer=M1 $thickness=3.6e-08 $X=0.189
+ $Y=0.198 $X2=0.189 $Y2=0.1755
r28 19 25 1.49895 $w=1.95333e-08 $l=1.35e-08 $layer=M1 $thickness=3.6e-08
+ $X=0.189 $Y=0.135 $X2=0.189 $Y2=0.1485
r29 19 55 2.6649 $w=1.54324e-08 $l=1.85e-08 $layer=M1 $thickness=3.6e-08
+ $X=0.189 $Y=0.135 $X2=0.1705 $Y2=0.135
r30 21 53 7.34548 $w=1.3e-08 $l=3.15e-08 $layer=M1 $thickness=3.6e-08 $X=0.018
+ $Y=0.1755 $X2=0.018 $Y2=0.207
r31 51 52 8.39483 $w=1.3e-08 $l=3.6e-08 $layer=M1 $thickness=3.6e-08 $X=0.018
+ $Y=0.099 $X2=0.018 $Y2=0.063
r32 20 51 7.34548 $w=1.3e-08 $l=3.15e-08 $layer=M1 $thickness=3.6e-08 $X=0.018
+ $Y=0.1305 $X2=0.018 $Y2=0.099
r33 49 50 4.19742 $w=1.3e-08 $l=1.8e-08 $layer=M1 $thickness=3.6e-08 $X=0.189
+ $Y=0.1575 $X2=0.189 $Y2=0.1755
r34 25 44 19.5347 $a=3.24e-16 $layer=V1 $X=0.189 $Y=0.1485 $X2=0.189 $Y2=0.153
r35 25 49 2.09871 $w=1.3e-08 $l=9e-09 $layer=M1 $thickness=3.6e-08 $X=0.189
+ $Y=0.1485 $X2=0.189 $Y2=0.1575
r36 46 47 1.90199 $w=1.38333e-08 $l=9e-09 $layer=M1 $thickness=3.6e-08
+ $X=0.0255 $Y=0.153 $X2=0.0345 $Y2=0.153
r37 16 46 0.9184 $w=1.8e-08 $l=9e-09 $layer=M1 $thickness=3.6e-08 $X=0.0165
+ $Y=0.153 $X2=0.0255 $Y2=0.153
r38 16 20 3.9134 $w=1.47857e-08 $l=2.25499e-08 $layer=M1 $thickness=3.6e-08
+ $X=0.0165 $Y=0.153 $X2=0.018 $Y2=0.1305
r39 16 21 3.9134 $w=1.47857e-08 $l=2.25499e-08 $layer=M1 $thickness=3.6e-08
+ $X=0.0165 $Y=0.153 $X2=0.018 $Y2=0.1755
r40 44 45 5.71315 $w=1.3e-08 $l=2.45e-08 $layer=M2 $thickness=3.6e-08 $X=0.189
+ $Y=0.153 $X2=0.2135 $Y2=0.153
r41 43 44 18.1888 $w=1.3e-08 $l=7.8e-08 $layer=M2 $thickness=3.6e-08 $X=0.111
+ $Y=0.153 $X2=0.189 $Y2=0.153
r42 42 43 18.1888 $w=1.3e-08 $l=7.8e-08 $layer=M2 $thickness=3.6e-08 $X=0.033
+ $Y=0.153 $X2=0.111 $Y2=0.153
r43 42 47 19.5347 $a=3.24e-16 $layer=V1 $X=0.033 $Y=0.153 $X2=0.0345 $Y2=0.153
r44 27 40 21.5701 $w=1.3e-08 $l=9.25e-08 $layer=M2 $thickness=3.6e-08 $X=0.3125
+ $Y=0.153 $X2=0.405 $Y2=0.153
r45 27 45 23.0858 $w=1.3e-08 $l=9.9e-08 $layer=M2 $thickness=3.6e-08 $X=0.3125
+ $Y=0.153 $X2=0.2135 $Y2=0.153
r46 38 40 19.5347 $a=3.24e-16 $layer=V1 $X=0.405 $Y=0.144 $X2=0.405 $Y2=0.153
r47 26 38 6.52931 $w=1.3e-08 $l=2.8e-08 $layer=M1 $thickness=3.6e-08 $X=0.405
+ $Y=0.116 $X2=0.405 $Y2=0.144
r48 2 33 9.2451 $w=1.7885e-08 $l=2e-09 $layer=LIG $thickness=5.24e-08 $X=0.405
+ $Y=0.133 $X2=0.405 $Y2=0.135
r49 2 38 19.3796 $a=3.24e-16 $layer=V0LIG $X=0.405 $Y=0.133 $X2=0.405 $Y2=0.144
r50 35 34 16.4967 $w=2.1e-08 $l=4.85e-08 $layer=Gate_1 $thickness=5.6e-08
+ $X=0.405 $Y=0.2295 $X2=0.405 $Y2=0.181
r51 33 34 15.8334 $w=2.07609e-08 $l=4.6e-08 $layer=Gate_1 $thickness=5.6e-08
+ $X=0.405 $Y=0.135 $X2=0.405 $Y2=0.181
r52 32 33 6.6497 $w=2.04211e-08 $l=1.9e-08 $layer=Gate_1 $thickness=5.6e-08
+ $X=0.405 $Y=0.116 $X2=0.405 $Y2=0.135
r53 31 32 16.4967 $w=2.1e-08 $l=4.85e-08 $layer=Gate_1 $thickness=5.6e-08
+ $X=0.405 $Y=0.0675 $X2=0.405 $Y2=0.116
r54 31 12 14.6259 $w=2.1e-08 $l=4.3e-08 $layer=Gate_1 $thickness=5.6e-08
+ $X=0.405 $Y=0.0675 $X2=0.405 $Y2=0.0245
r55 6 14 1e-05 $l=2e-09 $X=0.054 $Y=0.216 $X2=0.056 $Y2=0.216
r56 5 13 1e-05 $l=2e-09 $X=0.054 $Y=0.054 $X2=0.056 $Y2=0.054
.ends

.subckt PM_DLLx1_ASAP7_75t_R%7 vss 18 22 39 44 9 1 13 4 17 3 16 12 11 10 15
c1 1 vss 0.00269891f $X=0.513 $Y=0.082
c2 3 vss 0.0062853f $X=0.594 $Y=0.0405
c3 4 vss 0.00613381f $X=0.594 $Y=0.2295
c4 9 vss 0.0407349f $X=0.513 $Y=0.0245
c5 10 vss 0.0190009f $X=0.5795 $Y=0.0405
c6 11 vss 0.0186302f $X=0.5795 $Y=0.2295
c7 12 vss 0.00291627f $X=0.513 $Y=0.036
c8 13 vss 0.00644662f $X=0.621 $Y=0.234
c9 14 vss 0.00325043f $X=0.621 $Y=0.036
c10 15 vss 0.00151494f $X=0.513 $Y=0.059
c11 16 vss 0.00846934f $X=0.551 $Y=0.036
c12 17 vss 0.00636258f $X=0.621 $Y=0.071
r1 11 4 0.462963 $w=2.7e-08 $l=1.25e-08 $layer=P_src_drn $thickness=1e-09
+ $X=0.5795 $Y=0.2295 $X2=0.594 $Y2=0.2295
r2 44 11 0.0925926 $w=2.7e-08 $l=2.5e-09 $layer=P_src_drn $thickness=1e-09
+ $X=0.5766 $Y=0.2295 $X2=0.5795 $Y2=0.2295
r3 4 41 19.3796 $a=3.24e-16 $layer=V0LISD $X=0.594 $Y=0.2295 $X2=0.594 $Y2=0.234
r4 41 42 3.14806 $w=1.3e-08 $l=1.35e-08 $layer=M1 $thickness=3.6e-08 $X=0.594
+ $Y=0.234 $X2=0.6075 $Y2=0.234
r5 13 37 3.48349 $w=1.525e-08 $l=2e-08 $layer=M1 $thickness=3.6e-08 $X=0.621
+ $Y=0.234 $X2=0.621 $Y2=0.214
r6 13 42 1.96775 $w=1.63333e-08 $l=1.35e-08 $layer=M1 $thickness=3.6e-08
+ $X=0.621 $Y=0.234 $X2=0.6075 $Y2=0.234
r7 10 3 0.462963 $w=2.7e-08 $l=1.25e-08 $layer=N_src_drn $thickness=1e-09
+ $X=0.5795 $Y=0.0405 $X2=0.594 $Y2=0.0405
r8 39 10 0.0925926 $w=2.7e-08 $l=2.5e-09 $layer=N_src_drn $thickness=1e-09
+ $X=0.5766 $Y=0.0405 $X2=0.5795 $Y2=0.0405
r9 36 37 2.91487 $w=1.3e-08 $l=1.25e-08 $layer=M1 $thickness=3.6e-08 $X=0.621
+ $Y=0.2015 $X2=0.621 $Y2=0.214
r10 35 36 4.43061 $w=1.3e-08 $l=1.9e-08 $layer=M1 $thickness=3.6e-08 $X=0.621
+ $Y=0.1825 $X2=0.621 $Y2=0.2015
r11 34 35 6.99569 $w=1.3e-08 $l=3e-08 $layer=M1 $thickness=3.6e-08 $X=0.621
+ $Y=0.1525 $X2=0.621 $Y2=0.1825
r12 33 34 5.01358 $w=1.3e-08 $l=2.15e-08 $layer=M1 $thickness=3.6e-08 $X=0.621
+ $Y=0.131 $X2=0.621 $Y2=0.1525
r13 32 33 3.96423 $w=1.3e-08 $l=1.7e-08 $layer=M1 $thickness=3.6e-08 $X=0.621
+ $Y=0.114 $X2=0.621 $Y2=0.131
r14 31 32 2.91487 $w=1.3e-08 $l=1.25e-08 $layer=M1 $thickness=3.6e-08 $X=0.621
+ $Y=0.1015 $X2=0.621 $Y2=0.114
r15 17 31 7.11229 $w=1.3e-08 $l=3.05e-08 $layer=M1 $thickness=3.6e-08 $X=0.621
+ $Y=0.071 $X2=0.621 $Y2=0.1015
r16 3 29 19.3796 $a=3.24e-16 $layer=V0LISD $X=0.594 $Y=0.0405 $X2=0.594
+ $Y2=0.036
r17 14 30 1.49895 $w=1.63333e-08 $l=1.35e-08 $layer=M1 $thickness=3.6e-08
+ $X=0.621 $Y=0.036 $X2=0.6075 $Y2=0.036
r18 14 17 6.51253 $w=1.552e-08 $l=3.5e-08 $layer=M1 $thickness=3.6e-08 $X=0.621
+ $Y=0.036 $X2=0.621 $Y2=0.071
r19 29 30 3.14806 $w=1.3e-08 $l=1.35e-08 $layer=M1 $thickness=3.6e-08 $X=0.594
+ $Y=0.036 $X2=0.6075 $Y2=0.036
r20 28 29 2.68168 $w=1.3e-08 $l=1.15e-08 $layer=M1 $thickness=3.6e-08 $X=0.5825
+ $Y=0.036 $X2=0.594 $Y2=0.036
r21 16 28 7.34548 $w=1.3e-08 $l=3.15e-08 $layer=M1 $thickness=3.6e-08 $X=0.551
+ $Y=0.036 $X2=0.5825 $Y2=0.036
r22 12 15 3.71425 $w=1.68348e-08 $l=2.3e-08 $layer=M1 $thickness=3.6e-08
+ $X=0.513 $Y=0.036 $X2=0.513 $Y2=0.059
r23 12 16 7.2121 $w=1.41842e-08 $l=3.8e-08 $layer=M1 $thickness=3.6e-08
+ $X=0.513 $Y=0.036 $X2=0.551 $Y2=0.036
r24 15 26 5.36336 $w=1.3e-08 $l=2.3e-08 $layer=M1 $thickness=3.6e-08 $X=0.513
+ $Y=0.059 $X2=0.513 $Y2=0.082
r25 1 20 6.54019 $w=2.09524e-08 $layer=Gate_1 $thickness=5.21905e-08 $X=0.513
+ $Y=0.082 $X2=0.513 $Y2=0.082
r26 1 26 19.3796 $a=3.24e-16 $layer=V0LIG $X=0.513 $Y=0.082 $X2=0.513 $Y2=0.082
r27 22 21 25.5104 $w=2.1e-08 $l=7.5e-08 $layer=Gate_1 $thickness=5.6e-08
+ $X=0.513 $Y=0.2295 $X2=0.513 $Y2=0.1545
r28 20 21 24.8471 $w=2.08483e-08 $l=7.25e-08 $layer=Gate_1 $thickness=5.6e-08
+ $X=0.513 $Y=0.082 $X2=0.513 $Y2=0.1545
r29 19 20 6.81977 $w=2.04359e-08 $l=1.95e-08 $layer=Gate_1 $thickness=5.6e-08
+ $X=0.513 $Y=0.0625 $X2=0.513 $Y2=0.082
r30 18 19 7.48304 $w=2.1e-08 $l=2.2e-08 $layer=Gate_1 $thickness=5.6e-08
+ $X=0.513 $Y=0.0405 $X2=0.513 $Y2=0.0625
r31 18 9 5.44221 $w=2.1e-08 $l=1.6e-08 $layer=Gate_1 $thickness=5.6e-08
+ $X=0.513 $Y=0.0405 $X2=0.513 $Y2=0.0245
.ends

.subckt PM_DLLx1_ASAP7_75t_R%Q vss 19 14 27 8 7 12
c1 1 vss 0.00899515f $X=0.756 $Y=0.0675
c2 2 vss 0.00867582f $X=0.756 $Y=0.2025
c3 7 vss 0.0385218f $X=0.7415 $Y=0.0675
c4 8 vss 0.0384649f $X=0.7415 $Y=0.2025
c5 9 vss 0.00609579f $X=0.783 $Y=0.234
c6 10 vss 0.00276863f $X=0.783 $Y=0.036
c7 11 vss 0.00455513f $X=0.74 $Y=0.036
c8 12 vss 0.00546574f $X=0.783 $Y=0.0627
r1 8 2 0.154321 $w=8.1e-08 $l=1.25e-08 $layer=P_src_drn $thickness=1e-09
+ $X=0.7415 $Y=0.2025 $X2=0.756 $Y2=0.2025
r2 27 8 0.0308642 $w=8.1e-08 $l=2.5e-09 $layer=P_src_drn $thickness=1e-09
+ $X=0.7386 $Y=0.2025 $X2=0.7415 $Y2=0.2025
r3 2 24 19.3796 $a=3.24e-16 $layer=V0LISD $X=0.756 $Y=0.2025 $X2=0.756 $Y2=0.234
r4 24 25 3.14806 $w=1.3e-08 $l=1.35e-08 $layer=M1 $thickness=3.6e-08 $X=0.756
+ $Y=0.234 $X2=0.7695 $Y2=0.234
r5 9 22 3.83327 $w=1.5093e-08 $l=2.15e-08 $layer=M1 $thickness=3.6e-08 $X=0.783
+ $Y=0.234 $X2=0.783 $Y2=0.2125
r6 9 25 1.96775 $w=1.63333e-08 $l=1.35e-08 $layer=M1 $thickness=3.6e-08
+ $X=0.783 $Y=0.234 $X2=0.7695 $Y2=0.234
r7 21 22 13.8748 $w=1.3e-08 $l=5.95e-08 $layer=M1 $thickness=3.6e-08 $X=0.783
+ $Y=0.153 $X2=0.783 $Y2=0.2125
r8 20 21 13.8165 $w=1.3e-08 $l=5.93e-08 $layer=M1 $thickness=3.6e-08 $X=0.783
+ $Y=0.0937 $X2=0.783 $Y2=0.153
r9 19 20 2.97317 $w=1.3e-08 $l=1.27e-08 $layer=M1 $thickness=3.6e-08 $X=0.783
+ $Y=0.081 $X2=0.783 $Y2=0.0937
r10 19 12 4.25571 $w=1.3e-08 $l=1.83e-08 $layer=M1 $thickness=3.6e-08 $X=0.783
+ $Y=0.081 $X2=0.783 $Y2=0.0627
r11 10 18 1.49895 $w=1.63333e-08 $l=1.35e-08 $layer=M1 $thickness=3.6e-08
+ $X=0.783 $Y=0.036 $X2=0.7695 $Y2=0.036
r12 10 12 4.58871 $w=1.62972e-08 $l=2.67e-08 $layer=M1 $thickness=3.6e-08
+ $X=0.783 $Y=0.036 $X2=0.783 $Y2=0.0627
r13 17 18 3.14806 $w=1.3e-08 $l=1.35e-08 $layer=M1 $thickness=3.6e-08 $X=0.756
+ $Y=0.036 $X2=0.7695 $Y2=0.036
r14 16 17 2.68168 $w=1.3e-08 $l=1.15e-08 $layer=M1 $thickness=3.6e-08 $X=0.7445
+ $Y=0.036 $X2=0.756 $Y2=0.036
r15 11 16 1.04935 $w=1.3e-08 $l=4.5e-09 $layer=M1 $thickness=3.6e-08 $X=0.74
+ $Y=0.036 $X2=0.7445 $Y2=0.036
r16 1 17 19.3796 $a=3.24e-16 $layer=V0LISD $X=0.756 $Y=0.0675 $X2=0.756
+ $Y2=0.036
r17 7 1 0.154321 $w=8.1e-08 $l=1.25e-08 $layer=N_src_drn $thickness=1e-09
+ $X=0.7415 $Y=0.0675 $X2=0.756 $Y2=0.0675
r18 14 7 0.0308642 $w=8.1e-08 $l=2.5e-09 $layer=N_src_drn $thickness=1e-09
+ $X=0.7386 $Y=0.0675 $X2=0.7415 $Y2=0.0675
.ends

.subckt PM_DLLx1_ASAP7_75t_R%6 vss 29 70 74 76 4 5 20 19 18 16 14 21 2 23 1 15
+ 12 13 17 6 22
c1 1 vss 0.000413579f $X=0.351 $Y=0.135
c2 2 vss 0.000146503f $X=0.459 $Y=0.179
c3 4 vss 0.00759679f $X=0.162 $Y=0.054
c4 5 vss 0.00748515f $X=0.162 $Y=0.216
c5 6 vss 0.00963964f $X=0.501 $Y=0.179
c6 12 vss 0.00788225f $X=0.351 $Y=0.073
c7 13 vss 0.00643065f $X=0.459 $Y=0.179
c8 14 vss 0.0322252f $X=0.1475 $Y=0.054
c9 15 vss 0.0321923f $X=0.1475 $Y=0.216
c10 16 vss 0.00308326f $X=0.243 $Y=0.036
c11 17 vss 0.00284865f $X=0.243 $Y=0.234
c12 18 vss 0.00965548f $X=0.216 $Y=0.036
c13 19 vss 0.00875066f $X=0.216 $Y=0.234
c14 20 vss 0.00795256f $X=0.243 $Y=0.153
c15 21 vss 0.00173951f $X=0.351 $Y=0.116
c16 22 vss 0.00144656f $X=0.513 $Y=0.168
c17 23 vss 0.0131282f $X=0.2315 $Y=0.189
r1 15 5 0.231482 $w=5.4e-08 $l=1.25e-08 $layer=P_src_drn $thickness=1e-09
+ $X=0.1475 $Y=0.216 $X2=0.162 $Y2=0.216
r2 76 15 0.0462963 $w=5.4e-08 $l=2.5e-09 $layer=P_src_drn $thickness=1e-09
+ $X=0.1446 $Y=0.216 $X2=0.1475 $Y2=0.216
r3 14 4 0.231482 $w=5.4e-08 $l=1.25e-08 $layer=N_src_drn $thickness=1e-09
+ $X=0.1475 $Y=0.054 $X2=0.162 $Y2=0.054
r4 74 14 0.0462963 $w=5.4e-08 $l=2.5e-09 $layer=N_src_drn $thickness=1e-09
+ $X=0.1446 $Y=0.054 $X2=0.1475 $Y2=0.054
r5 70 71 23.4695 $w=2.1e-08 $l=6.9e-08 $layer=Gate_1 $thickness=5.6e-08
+ $X=0.459 $Y=0.0405 $X2=0.459 $Y2=0.1095
r6 13 71 23.8777 $w=2.07986e-08 $l=6.95e-08 $layer=Gate_1 $thickness=5.6e-08
+ $X=0.459 $Y=0.179 $X2=0.459 $Y2=0.1095
r7 5 65 19.3796 $a=3.24e-16 $layer=V0LISD $X=0.162 $Y=0.216 $X2=0.162 $Y2=0.234
r8 4 62 19.3796 $a=3.24e-16 $layer=V0LISD $X=0.162 $Y=0.054 $X2=0.162 $Y2=0.036
r9 2 56 5.67512 $w=2.4e-08 $l=5e-09 $layer=LISD $thickness=4.02632e-08 $X=0.459
+ $Y=0.179 $X2=0.464 $Y2=0.179
r10 2 13 7.56983 $w=2.18462e-08 $layer=Gate_1 $thickness=5.23077e-08 $X=0.459
+ $Y=0.179 $X2=0.459 $Y2=0.179
r11 65 66 5.24677 $w=1.3e-08 $l=2.25e-08 $layer=M1 $thickness=3.6e-08 $X=0.162
+ $Y=0.234 $X2=0.1845 $Y2=0.234
r12 19 66 7.34548 $w=1.3e-08 $l=3.15e-08 $layer=M1 $thickness=3.6e-08 $X=0.216
+ $Y=0.234 $X2=0.1845 $Y2=0.234
r13 62 63 5.24677 $w=1.3e-08 $l=2.25e-08 $layer=M1 $thickness=3.6e-08 $X=0.162
+ $Y=0.036 $X2=0.1845 $Y2=0.036
r14 18 63 7.34548 $w=1.3e-08 $l=3.15e-08 $layer=M1 $thickness=3.6e-08 $X=0.216
+ $Y=0.036 $X2=0.1845 $Y2=0.036
r15 55 56 11.0623 $w=2.14976e-08 $l=2.05e-08 $layer=LISD $thickness=2.7e-08
+ $X=0.4845 $Y=0.179 $X2=0.464 $Y2=0.179
r16 6 53 7.07284 $w=2.02e-08 $l=1.2e-08 $layer=LISD $thickness=2.7e-08 $X=0.501
+ $Y=0.179 $X2=0.513 $Y2=0.179
r17 6 55 9.72516 $w=2.02e-08 $l=1.65e-08 $layer=LISD $thickness=2.7e-08
+ $X=0.501 $Y=0.179 $X2=0.4845 $Y2=0.179
r18 17 50 2.5483 $w=1.79e-08 $l=1.8e-08 $layer=M1 $thickness=3.6e-08 $X=0.243
+ $Y=0.234 $X2=0.243 $Y2=0.216
r19 17 19 4.64701 $w=1.46667e-08 $l=2.7e-08 $layer=M1 $thickness=3.6e-08
+ $X=0.243 $Y=0.234 $X2=0.216 $Y2=0.234
r20 16 47 4.64701 $w=1.62667e-08 $l=2.7e-08 $layer=M1 $thickness=3.6e-08
+ $X=0.243 $Y=0.036 $X2=0.243 $Y2=0.063
r21 16 18 4.64701 $w=1.46667e-08 $l=2.7e-08 $layer=M1 $thickness=3.6e-08
+ $X=0.243 $Y=0.036 $X2=0.216 $Y2=0.036
r22 51 53 19.3796 $a=3.24e-16 $layer=V0LISD $X=0.513 $Y=0.1845 $X2=0.513
+ $Y2=0.179
r23 22 51 3.84763 $w=1.3e-08 $l=1.65e-08 $layer=M1 $thickness=3.6e-08 $X=0.513
+ $Y=0.168 $X2=0.513 $Y2=0.1845
r24 49 50 3.14806 $w=1.3e-08 $l=1.35e-08 $layer=M1 $thickness=3.6e-08 $X=0.243
+ $Y=0.2025 $X2=0.243 $Y2=0.216
r25 48 49 2.09871 $w=1.3e-08 $l=9e-09 $layer=M1 $thickness=3.6e-08 $X=0.243
+ $Y=0.1935 $X2=0.243 $Y2=0.2025
r26 46 47 8.39483 $w=1.3e-08 $l=3.6e-08 $layer=M1 $thickness=3.6e-08 $X=0.243
+ $Y=0.099 $X2=0.243 $Y2=0.063
r27 45 46 5.24677 $w=1.3e-08 $l=2.25e-08 $layer=M1 $thickness=3.6e-08 $X=0.243
+ $Y=0.1215 $X2=0.243 $Y2=0.099
r28 44 48 2.09871 $w=1.3e-08 $l=9e-09 $layer=M1 $thickness=3.6e-08 $X=0.243
+ $Y=0.1845 $X2=0.243 $Y2=0.1935
r29 20 44 7.34548 $w=1.3e-08 $l=3.15e-08 $layer=M1 $thickness=3.6e-08 $X=0.243
+ $Y=0.153 $X2=0.243 $Y2=0.1845
r30 20 45 7.34548 $w=1.3e-08 $l=3.15e-08 $layer=M1 $thickness=3.6e-08 $X=0.243
+ $Y=0.153 $X2=0.243 $Y2=0.1215
r31 42 51 19.5347 $a=3.24e-16 $layer=V1 $X=0.513 $Y=0.189 $X2=0.513 $Y2=0.1845
r32 41 42 8.39483 $w=1.3e-08 $l=3.6e-08 $layer=M2 $thickness=3.6e-08 $X=0.477
+ $Y=0.189 $X2=0.513 $Y2=0.189
r33 40 41 10.4935 $w=1.3e-08 $l=4.5e-08 $layer=M2 $thickness=3.6e-08 $X=0.432
+ $Y=0.189 $X2=0.477 $Y2=0.189
r34 39 40 10.4935 $w=1.3e-08 $l=4.5e-08 $layer=M2 $thickness=3.6e-08 $X=0.387
+ $Y=0.189 $X2=0.432 $Y2=0.189
r35 38 39 8.39483 $w=1.3e-08 $l=3.6e-08 $layer=M2 $thickness=3.6e-08 $X=0.351
+ $Y=0.189 $X2=0.387 $Y2=0.189
r36 37 38 12.5922 $w=1.3e-08 $l=5.4e-08 $layer=M2 $thickness=3.6e-08 $X=0.297
+ $Y=0.189 $X2=0.351 $Y2=0.189
r37 36 37 12.5922 $w=1.3e-08 $l=5.4e-08 $layer=M2 $thickness=3.6e-08 $X=0.243
+ $Y=0.189 $X2=0.297 $Y2=0.189
r38 36 44 19.5347 $a=3.24e-16 $layer=V1 $X=0.243 $Y=0.189 $X2=0.243 $Y2=0.1845
r39 23 36 2.68168 $w=1.3e-08 $l=1.15e-08 $layer=M2 $thickness=3.6e-08 $X=0.2315
+ $Y=0.189 $X2=0.243 $Y2=0.189
r40 33 38 19.5347 $a=3.24e-16 $layer=V1 $X=0.351 $Y=0.189 $X2=0.351 $Y2=0.189
r41 32 33 6.29612 $w=1.3e-08 $l=2.7e-08 $layer=M1 $thickness=3.6e-08 $X=0.351
+ $Y=0.162 $X2=0.351 $Y2=0.189
r42 31 32 6.29612 $w=1.3e-08 $l=2.7e-08 $layer=M1 $thickness=3.6e-08 $X=0.351
+ $Y=0.135 $X2=0.351 $Y2=0.162
r43 21 31 4.4306 $w=1.3e-08 $l=1.9e-08 $layer=M1 $thickness=3.6e-08 $X=0.351
+ $Y=0.116 $X2=0.351 $Y2=0.135
r44 1 27 10.4265 $w=1.765e-08 $layer=LIG $thickness=5.2e-08 $X=0.351 $Y=0.135
+ $X2=0.351 $Y2=0.135
r45 1 31 19.3796 $a=3.24e-16 $layer=V0LIG $X=0.351 $Y=0.135 $X2=0.351 $Y2=0.135
r46 29 28 16.4967 $w=2.1e-08 $l=4.85e-08 $layer=Gate_1 $thickness=5.6e-08
+ $X=0.351 $Y=0.2025 $X2=0.351 $Y2=0.154
r47 27 28 6.6497 $w=2.04211e-08 $l=1.9e-08 $layer=Gate_1 $thickness=5.6e-08
+ $X=0.351 $Y=0.135 $X2=0.351 $Y2=0.154
r48 12 27 21.2756 $w=2.08226e-08 $l=6.2e-08 $layer=Gate_1 $thickness=5.6e-08
+ $X=0.351 $Y=0.073 $X2=0.351 $Y2=0.135
.ends

.subckt PM_DLLx1_ASAP7_75t_R%10 vss 7 9 5 4 1
c1 1 vss 0.00825519f $X=0.351 $Y=0.0675
c2 4 vss 0.00286626f $X=0.3095 $Y=0.0675
c3 5 vss 0.00175859f $X=0.38 $Y=0.0675
r1 9 8 0.0308642 $w=8.1e-08 $l=2.5e-09 $layer=N_src_drn $thickness=1e-09
+ $X=0.3953 $Y=0.0675 $X2=0.3925 $Y2=0.0675
r2 5 8 0.154321 $w=8.1e-08 $l=1.25e-08 $layer=N_src_drn $thickness=1e-09
+ $X=0.38 $Y=0.0675 $X2=0.3925 $Y2=0.0675
r3 4 1 0.154321 $w=8.1e-08 $l=1.25e-08 $layer=N_src_drn $thickness=1e-09
+ $X=0.3095 $Y=0.0675 $X2=0.351 $Y2=0.0675
r4 7 4 0.0308642 $w=8.1e-08 $l=2.5e-09 $layer=N_src_drn $thickness=1e-09
+ $X=0.3066 $Y=0.0675 $X2=0.3095 $Y2=0.0675
r5 1 5 1e-05 $l=2.9e-08 $X=0.351 $Y=0.0675 $X2=0.38 $Y2=0.0675
.ends

.subckt PM_DLLx1_ASAP7_75t_R%11 vss 7 12 4 1 5
c1 1 vss 0.00627674f $X=0.432 $Y=0.2295
c2 4 vss 0.00175543f $X=0.4175 $Y=0.2295
c3 5 vss 0.00215977f $X=0.488 $Y=0.2295
r1 12 11 0.0925926 $w=2.7e-08 $l=2.5e-09 $layer=P_src_drn $thickness=1e-09
+ $X=0.5033 $Y=0.2295 $X2=0.5005 $Y2=0.2295
r2 5 11 0.462963 $w=2.7e-08 $l=1.25e-08 $layer=P_src_drn $thickness=1e-09
+ $X=0.488 $Y=0.2295 $X2=0.5005 $Y2=0.2295
r3 9 5 9.64198 $w=2.32e-08 $l=2.05e-08 $layer=LISD $thickness=2.7e-08 $X=0.4655
+ $Y=0.2295 $X2=0.488 $Y2=0.2295
r4 8 9 7.05511 $w=2.32e-08 $l=1.5e-08 $layer=LISD $thickness=2.7e-08 $X=0.4505
+ $Y=0.2295 $X2=0.4655 $Y2=0.2295
r5 1 8 8.7013 $w=2.32e-08 $l=1.85e-08 $layer=LISD $thickness=2.7e-08 $X=0.432
+ $Y=0.2295 $X2=0.4505 $Y2=0.2295
r6 4 1 0.462963 $w=2.7e-08 $l=1.25e-08 $layer=P_src_drn $thickness=1e-09
+ $X=0.4175 $Y=0.2295 $X2=0.432 $Y2=0.2295
r7 7 4 0.0925926 $w=2.7e-08 $l=2.5e-09 $layer=P_src_drn $thickness=1e-09
+ $X=0.4146 $Y=0.2295 $X2=0.4175 $Y2=0.2295
.ends

.subckt PM_DLLx1_ASAP7_75t_R%8 vss 29 35 67 70 74 78 81 84 24 5 21 16 18 26 22
+ 20 23 6 13 15 14 19 1 11 2 25 17 12
c1 1 vss 0.00107647f $X=0.567 $Y=0.131
c2 2 vss 0.00472416f $X=0.729 $Y=0.136
c3 5 vss 0.00471627f $X=0.378 $Y=0.2295
c4 6 vss 0.00468394f $X=0.432 $Y=0.0405
c5 11 vss 0.0504228f $X=0.567 $Y=0.0245
c6 12 vss 0.0837497f $X=0.729 $Y=0.136
c7 13 vss 0.00247024f $X=0.4175 $Y=0.0405
c8 14 vss 0.000932979f $X=0.4175 $Y=0.081
c9 15 vss 0.00265642f $X=0.3635 $Y=0.2295
c10 16 vss 0.000991345f $X=0.3635 $Y=0.189
c11 17 vss 0.00266f $X=0.459 $Y=0.036
c12 18 vss 2.07858e-20 $X=0.459 $Y=0.131
c13 19 vss 0.00270708f $X=0.459 $Y=0.234
c14 20 vss 0.0071173f $X=0.432 $Y=0.234
c15 21 vss 0.00371938f $X=0.432 $Y=0.036
c16 22 vss 0.0010259f $X=0.459 $Y=0.114
c17 23 vss 0.000696711f $X=0.459 $Y=0.142
c18 24 vss 0.00102332f $X=0.5395 $Y=0.131
c19 25 vss 0.00397483f $X=0.729 $Y=0.1165
c20 26 vss 0.00704505f $X=0.459 $Y=0.153
r1 16 5 0.231482 $w=5.4e-08 $l=1.25e-08 $layer=P_src_drn $thickness=1e-09
+ $X=0.3635 $Y=0.189 $X2=0.378 $Y2=0.2295
r2 84 83 0.0925926 $w=2.7e-08 $l=2.5e-09 $layer=P_src_drn $thickness=1e-09
+ $X=0.3953 $Y=0.2295 $X2=0.3925 $Y2=0.2295
r3 82 83 0.166667 $w=2.7e-08 $l=4.5e-09 $layer=P_src_drn $thickness=1e-09
+ $X=0.388 $Y=0.2295 $X2=0.3925 $Y2=0.2295
r4 5 82 0.444445 $w=2.7e-08 $l=1.2e-08 $layer=P_src_drn $thickness=1e-09
+ $X=0.378 $Y=0.2295 $X2=0.388 $Y2=0.2295
r5 15 5 0.462963 $w=2.7e-08 $l=1.25e-08 $layer=P_src_drn $thickness=1e-09
+ $X=0.3635 $Y=0.2295 $X2=0.378 $Y2=0.2295
r6 81 15 0.0925926 $w=2.7e-08 $l=2.5e-09 $layer=P_src_drn $thickness=1e-09
+ $X=0.3606 $Y=0.2025 $X2=0.3635 $Y2=0.2295
r7 78 77 14.6259 $w=2.1e-08 $l=4.3e-08 $layer=Gate_1 $thickness=5.6e-08
+ $X=0.729 $Y=0.2025 $X2=0.729 $Y2=0.1595
r8 76 77 2.55104 $w=2.1e-08 $l=7.5e-09 $layer=Gate_1 $thickness=5.6e-08
+ $X=0.729 $Y=0.152 $X2=0.729 $Y2=0.1595
r9 74 75 14.6259 $w=2.1e-08 $l=4.3e-08 $layer=Gate_1 $thickness=5.6e-08
+ $X=0.729 $Y=0.0675 $X2=0.729 $Y2=0.1105
r10 72 75 2.89117 $w=2.1e-08 $l=8.5e-09 $layer=Gate_1 $thickness=5.6e-08
+ $X=0.729 $Y=0.119 $X2=0.729 $Y2=0.1105
r11 12 72 5.96942 $w=2.03529e-08 $l=1.7e-08 $layer=Gate_1 $thickness=5.6e-08
+ $X=0.729 $Y=0.136 $X2=0.729 $Y2=0.119
r12 12 76 5.62929 $w=2.03125e-08 $l=1.6e-08 $layer=Gate_1 $thickness=5.6e-08
+ $X=0.729 $Y=0.136 $X2=0.729 $Y2=0.152
r13 14 60 0.231482 $w=5.4e-08 $l=1.25e-08 $layer=N_src_drn $thickness=1e-09
+ $X=0.4175 $Y=0.081 $X2=0.432 $Y2=0.081
r14 70 69 0.0925926 $w=2.7e-08 $l=2.5e-09 $layer=N_src_drn $thickness=1e-09
+ $X=0.4493 $Y=0.0405 $X2=0.4465 $Y2=0.0405
r15 68 69 0.166667 $w=2.7e-08 $l=4.5e-09 $layer=N_src_drn $thickness=1e-09
+ $X=0.442 $Y=0.0405 $X2=0.4465 $Y2=0.0405
r16 60 68 0.444445 $w=2.7e-08 $l=1.2e-08 $layer=N_src_drn $thickness=1e-09
+ $X=0.432 $Y=0.081 $X2=0.442 $Y2=0.0405
r17 13 60 0.462963 $w=2.7e-08 $l=1.25e-08 $layer=N_src_drn $thickness=1e-09
+ $X=0.4175 $Y=0.0405 $X2=0.432 $Y2=0.081
r18 67 13 0.0925926 $w=2.7e-08 $l=2.5e-09 $layer=N_src_drn $thickness=1e-09
+ $X=0.4146 $Y=0.0675 $X2=0.4175 $Y2=0.0405
r19 5 58 19.3796 $a=3.24e-16 $layer=V0LISD $X=0.378 $Y=0.2295 $X2=0.378
+ $Y2=0.234
r20 2 54 19.3796 $a=3.24e-16 $layer=V0LIG $X=0.729 $Y=0.136 $X2=0.729 $Y2=0.1445
r21 2 12 6.54019 $w=2.09524e-08 $layer=Gate_1 $thickness=5.21905e-08 $X=0.729
+ $Y=0.136 $X2=0.729 $Y2=0.136
r22 6 21 19.3796 $a=3.24e-16 $layer=V0LISD $X=0.432 $Y=0.0405 $X2=0.432
+ $Y2=0.036
r23 6 60 23.8708 $w=2.02e-08 $l=4.05e-08 $layer=LISD $thickness=2.7e-08
+ $X=0.432 $Y=0.0405 $X2=0.432 $Y2=0.081
r24 58 59 3.14806 $w=1.3e-08 $l=1.35e-08 $layer=M1 $thickness=3.6e-08 $X=0.378
+ $Y=0.234 $X2=0.3915 $Y2=0.234
r25 56 59 3.14806 $w=1.3e-08 $l=1.35e-08 $layer=M1 $thickness=3.6e-08 $X=0.405
+ $Y=0.234 $X2=0.3915 $Y2=0.234
r26 20 56 6.29612 $w=1.3e-08 $l=2.7e-08 $layer=M1 $thickness=3.6e-08 $X=0.432
+ $Y=0.234 $X2=0.405 $Y2=0.234
r27 25 54 6.52931 $w=1.3e-08 $l=2.8e-08 $layer=M1 $thickness=3.6e-08 $X=0.729
+ $Y=0.1165 $X2=0.729 $Y2=0.1445
r28 19 49 3.01468 $w=1.741e-08 $l=2e-08 $layer=M1 $thickness=3.6e-08 $X=0.459
+ $Y=0.234 $X2=0.459 $Y2=0.214
r29 19 20 4.64701 $w=1.46667e-08 $l=2.7e-08 $layer=M1 $thickness=3.6e-08
+ $X=0.459 $Y=0.234 $X2=0.432 $Y2=0.234
r30 52 54 19.5347 $a=3.24e-16 $layer=V1 $X=0.729 $Y=0.153 $X2=0.729 $Y2=0.1445
r31 51 52 24.6015 $w=1.3e-08 $l=1.055e-07 $layer=M2 $thickness=3.6e-08
+ $X=0.6235 $Y=0.153 $X2=0.729 $Y2=0.153
r32 50 51 29.3819 $w=1.3e-08 $l=1.26e-07 $layer=M2 $thickness=3.6e-08 $X=0.4975
+ $Y=0.153 $X2=0.6235 $Y2=0.153
r33 26 50 8.97781 $w=1.3e-08 $l=3.85e-08 $layer=M2 $thickness=3.6e-08 $X=0.459
+ $Y=0.153 $X2=0.4975 $Y2=0.153
r34 26 45 19.5347 $a=3.24e-16 $layer=V1 $X=0.459 $Y=0.153 $X2=0.459 $Y2=0.153
r35 17 44 6.51253 $w=1.552e-08 $l=3.5e-08 $layer=M1 $thickness=3.6e-08 $X=0.459
+ $Y=0.036 $X2=0.459 $Y2=0.071
r36 17 21 4.64701 $w=1.46667e-08 $l=2.7e-08 $layer=M1 $thickness=3.6e-08
+ $X=0.459 $Y=0.036 $X2=0.432 $Y2=0.036
r37 48 49 2.91487 $w=1.3e-08 $l=1.25e-08 $layer=M1 $thickness=3.6e-08 $X=0.459
+ $Y=0.2015 $X2=0.459 $Y2=0.214
r38 47 48 4.43061 $w=1.3e-08 $l=1.9e-08 $layer=M1 $thickness=3.6e-08 $X=0.459
+ $Y=0.1825 $X2=0.459 $Y2=0.2015
r39 46 47 4.43061 $w=1.3e-08 $l=1.9e-08 $layer=M1 $thickness=3.6e-08 $X=0.459
+ $Y=0.1635 $X2=0.459 $Y2=0.1825
r40 45 46 2.44849 $w=1.3e-08 $l=1.05e-08 $layer=M1 $thickness=3.6e-08 $X=0.459
+ $Y=0.153 $X2=0.459 $Y2=0.1635
r41 23 45 2.56509 $w=1.3e-08 $l=1.1e-08 $layer=M1 $thickness=3.6e-08 $X=0.459
+ $Y=0.142 $X2=0.459 $Y2=0.153
r42 43 44 7.11229 $w=1.3e-08 $l=3.05e-08 $layer=M1 $thickness=3.6e-08 $X=0.459
+ $Y=0.1015 $X2=0.459 $Y2=0.071
r43 22 43 2.91487 $w=1.3e-08 $l=1.25e-08 $layer=M1 $thickness=3.6e-08 $X=0.459
+ $Y=0.114 $X2=0.459 $Y2=0.1015
r44 18 42 5.11582 $w=1.46667e-08 $l=2.7e-08 $layer=M1 $thickness=3.6e-08
+ $X=0.459 $Y=0.131 $X2=0.486 $Y2=0.131
r45 18 22 2.78392 $w=1.56471e-08 $l=1.7e-08 $layer=M1 $thickness=3.6e-08
+ $X=0.459 $Y=0.131 $X2=0.459 $Y2=0.114
r46 18 23 1.38478 $w=1.70909e-08 $l=1.1e-08 $layer=M1 $thickness=3.6e-08
+ $X=0.459 $Y=0.131 $X2=0.459 $Y2=0.142
r47 41 42 6.29612 $w=1.3e-08 $l=2.7e-08 $layer=M1 $thickness=3.6e-08 $X=0.513
+ $Y=0.131 $X2=0.486 $Y2=0.131
r48 24 39 6.17953 $w=1.3e-08 $l=2.65e-08 $layer=M1 $thickness=3.6e-08 $X=0.5395
+ $Y=0.131 $X2=0.566 $Y2=0.131
r49 24 41 6.17953 $w=1.3e-08 $l=2.65e-08 $layer=M1 $thickness=3.6e-08 $X=0.5395
+ $Y=0.131 $X2=0.513 $Y2=0.131
r50 1 32 6.54019 $w=2.09524e-08 $layer=Gate_1 $thickness=5.21905e-08 $X=0.567
+ $Y=0.131 $X2=0.567 $Y2=0.131
r51 1 39 19.3796 $a=3.24e-16 $layer=V0LIG $X=0.567 $Y=0.131 $X2=0.566 $Y2=0.131
r52 35 34 14.6259 $w=2.1e-08 $l=4.3e-08 $layer=Gate_1 $thickness=5.6e-08
+ $X=0.567 $Y=0.2295 $X2=0.567 $Y2=0.1865
r53 33 34 12.5851 $w=2.1e-08 $l=3.7e-08 $layer=Gate_1 $thickness=5.6e-08
+ $X=0.567 $Y=0.1495 $X2=0.567 $Y2=0.1865
r54 32 33 6.47963 $w=2.04054e-08 $l=1.85e-08 $layer=Gate_1 $thickness=5.6e-08
+ $X=0.567 $Y=0.131 $X2=0.567 $Y2=0.1495
r55 31 32 5.11908 $w=2.02414e-08 $l=1.45e-08 $layer=Gate_1 $thickness=5.6e-08
+ $X=0.567 $Y=0.1165 $X2=0.567 $Y2=0.131
r56 30 31 11.2246 $w=2.1e-08 $l=3.3e-08 $layer=Gate_1 $thickness=5.6e-08
+ $X=0.567 $Y=0.0835 $X2=0.567 $Y2=0.1165
r57 29 30 14.6259 $w=2.1e-08 $l=4.3e-08 $layer=Gate_1 $thickness=5.6e-08
+ $X=0.567 $Y=0.0405 $X2=0.567 $Y2=0.0835
r58 29 11 5.44221 $w=2.1e-08 $l=1.6e-08 $layer=Gate_1 $thickness=5.6e-08
+ $X=0.567 $Y=0.0405 $X2=0.567 $Y2=0.0245
.ends

.subckt PM_DLLx1_ASAP7_75t_R%12 vss 2 3 1
c1 1 vss 0.000562145f $X=0.486 $Y=0.0405
r1 2 1 0.62963 $w=2.7e-08 $l=1.7e-08 $layer=N_src_drn $thickness=1e-09
+ $X=0.4686 $Y=0.0405 $X2=0.486 $Y2=0.0405
r2 3 1 0.62963 $w=2.7e-08 $l=1.7e-08 $layer=N_src_drn $thickness=1e-09
+ $X=0.5033 $Y=0.0405 $X2=0.486 $Y2=0.0405
.ends

.subckt PM_DLLx1_ASAP7_75t_R%D vss 16 7 13 6 5 4 1 3
c1 1 vss 0.00500801f $X=0.297 $Y=0.135
c2 3 vss 0.0918138f $X=0.297 $Y=0.0245
c3 4 vss 0.00541899f $X=0.297 $Y=0.036
c4 5 vss 0.00519674f $X=0.297 $Y=0.234
c5 6 vss 0.00566662f $X=0.297 $Y=0.0755
r1 5 20 3.48349 $w=1.525e-08 $l=2e-08 $layer=M1 $thickness=3.6e-08 $X=0.297
+ $Y=0.234 $X2=0.297 $Y2=0.214
r2 4 6 8.03069 $w=1.41392e-08 $l=3.95e-08 $layer=M1 $thickness=3.6e-08 $X=0.297
+ $Y=0.036 $X2=0.297 $Y2=0.0755
r3 19 20 9.44419 $w=1.3e-08 $l=4.05e-08 $layer=M1 $thickness=3.6e-08 $X=0.297
+ $Y=0.1735 $X2=0.297 $Y2=0.214
r4 18 19 8.97781 $w=1.3e-08 $l=3.85e-08 $layer=M1 $thickness=3.6e-08 $X=0.297
+ $Y=0.135 $X2=0.297 $Y2=0.1735
r5 17 18 3.14806 $w=1.3e-08 $l=1.35e-08 $layer=M1 $thickness=3.6e-08 $X=0.297
+ $Y=0.1215 $X2=0.297 $Y2=0.135
r6 16 17 1.16595 $w=1.3e-08 $l=5e-09 $layer=M1 $thickness=3.6e-08 $X=0.297
+ $Y=0.1165 $X2=0.297 $Y2=0.1215
r7 16 15 1.28254 $w=1.3e-08 $l=5.5e-09 $layer=M1 $thickness=3.6e-08 $X=0.297
+ $Y=0.1165 $X2=0.297 $Y2=0.111
r8 6 15 8.27824 $w=1.3e-08 $l=3.55e-08 $layer=M1 $thickness=3.6e-08 $X=0.297
+ $Y=0.0755 $X2=0.297 $Y2=0.111
r9 1 10 10.4265 $w=1.765e-08 $layer=LIG $thickness=5.2e-08 $X=0.297 $Y=0.135
+ $X2=0.297 $Y2=0.135
r10 1 18 19.3796 $a=3.24e-16 $layer=V0LIG $X=0.297 $Y=0.135 $X2=0.297 $Y2=0.135
r11 13 12 14.6259 $w=2.1e-08 $l=4.3e-08 $layer=Gate_1 $thickness=5.6e-08
+ $X=0.297 $Y=0.2025 $X2=0.297 $Y2=0.1595
r12 11 12 2.7211 $w=2.1e-08 $l=8e-09 $layer=Gate_1 $thickness=5.6e-08 $X=0.297
+ $Y=0.1515 $X2=0.297 $Y2=0.1595
r13 10 11 5.79936 $w=2.03333e-08 $l=1.65e-08 $layer=Gate_1 $thickness=5.6e-08
+ $X=0.297 $Y=0.135 $X2=0.297 $Y2=0.1515
r14 9 10 5.79936 $w=2.03333e-08 $l=1.65e-08 $layer=Gate_1 $thickness=5.6e-08
+ $X=0.297 $Y=0.1185 $X2=0.297 $Y2=0.135
r15 8 9 2.7211 $w=2.1e-08 $l=8e-09 $layer=Gate_1 $thickness=5.6e-08 $X=0.297
+ $Y=0.1105 $X2=0.297 $Y2=0.1185
r16 7 8 14.6259 $w=2.1e-08 $l=4.3e-08 $layer=Gate_1 $thickness=5.6e-08 $X=0.297
+ $Y=0.0675 $X2=0.297 $Y2=0.1105
r17 7 3 14.6259 $w=2.1e-08 $l=4.3e-08 $layer=Gate_1 $thickness=5.6e-08 $X=0.297
+ $Y=0.0675 $X2=0.297 $Y2=0.0245
.ends

* End of included file DLLx1_ASAP7_75t_R.pex.sp.pex

*
.subckt DLLx1_ASAP7_75t_CUSTOM_4_25_0_7 VSS VDD CLK D Q
*
* VSS VSS
* VDD VDD
* CLK CLK
* D D
* Q Q
*
*

M0 VSS N_M0_g N_M0_s VSS nmos_rvt L=2e-08 W=5.4e-08 nfin=2 $X=0.071 $Y=0.027
M1 N_M1_d N_M1_g VSS VSS nmos_rvt L=2e-08 W=5.4e-08 nfin=2 $X=0.125 $Y=0.027
M2 N_M2_d N_M2_g VSS VSS nmos_rvt L=2e-08 W=8.1e-08 nfin=3 $X=0.287 $Y=0.027
M3 N_M3_d N_M3_g N_M3_s VSS nmos_rvt L=2e-08 W=8.1e-08 nfin=3 $X=0.395 $Y=0.027
M4 N_M4_d N_M4_g N_M4_s VSS nmos_rvt L=2e-08 W=2.7e-08 nfin=1 $X=0.449 $Y=0.027
M5 VSS N_M5_g N_M5_s VSS nmos_rvt L=2e-08 W=2.7e-08 nfin=1 $X=0.503 $Y=0.027
M6 N_M6_d N_M6_g VSS VSS nmos_rvt L=2e-08 W=2.7e-08 nfin=1 $X=0.557 $Y=0.027
M7 N_M7_d N_M7_g VSS VSS nmos_rvt L=2e-08 W=8.1e-08 nfin=3 $X=0.719 $Y=0.027
M8 VDD N_M8_g N_M8_s VDD pmos_rvt L=2e-08 W=5.4e-08 nfin=2 $X=0.071 $Y=0.189
M9 N_M9_d N_M9_g VDD VDD pmos_rvt L=2e-08 W=5.4e-08 nfin=2 $X=0.125 $Y=0.189
M10 N_M10_d N_M10_g VDD VDD pmos_rvt L=2e-08 W=8.1e-08 nfin=3 $X=0.287 $Y=0.162
M11 N_M11_d N_M11_g N_M11_s VDD pmos_rvt L=2e-08 W=8.1e-08 nfin=3 $X=0.341
+ $Y=0.162
M12 N_M12_d N_M12_g N_M12_s VDD pmos_rvt L=2e-08 W=2.7e-08 nfin=1 $X=0.395
+ $Y=0.216
M13 VDD N_M13_g N_M13_s VDD pmos_rvt L=2e-08 W=2.7e-08 nfin=1 $X=0.503 $Y=0.216
M14 N_M14_d N_M14_g VDD VDD pmos_rvt L=2e-08 W=2.7e-08 nfin=1 $X=0.557 $Y=0.216
M15 N_M15_d N_M15_g VDD VDD pmos_rvt L=2e-08 W=8.1e-08 nfin=3 $X=0.719 $Y=0.162

* .include "DLLx1_ASAP7_75t_R.pex.sp.pxi"

* Start of included file DLLx1_ASAP7_75t_R.pex.sp.pxi
x_PM_DLLx1_ASAP7_75t_R%CLK vss CLK N_M0_g N_M8_g N_CLK_3 N_CLK_1 N_CLK_4
+ N_CLK_5 N_CLK_7 N_CLK_8 N_CLK_6 PM_DLLx1_ASAP7_75t_R%CLK
x_PM_DLLx1_ASAP7_75t_R%13 vss N_M10_d N_M11_s N_13_1 PM_DLLx1_ASAP7_75t_R%13
cc_1 N_13_1 N_D_3 0.0167014f $X=0.324 $Y=0.2025
cc_2 N_13_1 N_6_12 0.0169056f $X=0.324 $Y=0.2025
x_PM_DLLx1_ASAP7_75t_R%4 vss N_M3_g N_M12_g N_M1_g N_M9_g N_M0_s N_M8_s N_4_6
+ N_4_5 N_4_16 N_4_13 N_4_14 N_4_21 N_4_25 N_4_1 N_4_23 N_4_24 N_4_27 N_4_22
+ N_4_18 N_4_20 N_4_11 N_4_26 N_4_19 N_4_12 N_4_2 PM_DLLx1_ASAP7_75t_R%4
cc_3 N_4_6 N_CLK_3 0.0010252f $X=0.054 $Y=0.216
cc_4 N_4_5 N_CLK_3 0.0010409f $X=0.054 $Y=0.054
cc_5 N_4_16 N_CLK_3 0.000282529f $X=0.0165 $Y=0.153
cc_6 N_4_13 N_CLK_3 0.0110335f $X=0.056 $Y=0.054
cc_7 N_4_14 N_CLK_3 0.0110328f $X=0.056 $Y=0.216
cc_8 N_4_21 N_CLK_3 0.00043457f $X=0.018 $Y=0.1755
cc_9 N_4_25 N_CLK_3 0.000533805f $X=0.189 $Y=0.1485
cc_10 N_4_1 N_CLK_3 0.000554411f $X=0.153 $Y=0.135
cc_11 N_4_23 N_CLK_3 0.000630339f $X=0.036 $Y=0.234
cc_12 N_4_16 N_CLK_1 0.000829348f $X=0.0165 $Y=0.153
cc_13 N_4_24 N_CLK_4 0.00159838f $X=0.1545 $Y=0.135
cc_14 N_4_27 N_CLK_5 0.00184733f $X=0.3125 $Y=0.153
cc_15 N_4_22 N_CLK_7 0.00186748f $X=0.036 $Y=0.036
cc_16 N_4_18 N_CLK_8 0.002238f $X=0.189 $Y=0.198
cc_17 N_4_16 N_CLK_6 0.00226042f $X=0.0165 $Y=0.153
cc_18 N_4_16 N_CLK_5 0.00226681f $X=0.0165 $Y=0.153
cc_19 N_4_20 N_CLK_4 0.00256095f $X=0.018 $Y=0.1305
cc_20 N_4_24 N_CLK_5 0.00262667f $X=0.1545 $Y=0.135
cc_21 N_4_1 N_CLK_1 0.00285772f $X=0.153 $Y=0.135
cc_22 N_4_11 N_CLK_3 0.0360266f $X=0.135 $Y=0.135
x_PM_DLLx1_ASAP7_75t_R%7 vss N_M5_g N_M13_g N_M6_d N_M14_d N_7_9 N_7_1 N_7_13
+ N_7_4 N_7_17 N_7_3 N_7_16 N_7_12 N_7_11 N_7_10 N_7_15 PM_DLLx1_ASAP7_75t_R%7
cc_23 N_7_9 N_6_2 0.000171714f $X=0.513 $Y=0.0245
cc_24 N_7_9 N_6_6 0.0055121f $X=0.513 $Y=0.0245
cc_25 N_7_9 N_6_23 0.000259967f $X=0.513 $Y=0.0245
cc_26 N_7_9 N_6_22 0.000315459f $X=0.513 $Y=0.0245
cc_27 N_7_1 N_6_13 0.000446633f $X=0.513 $Y=0.082
cc_28 N_7_13 N_6_6 0.000496058f $X=0.621 $Y=0.234
cc_29 N_7_4 N_6_6 0.000782221f $X=0.594 $Y=0.2295
cc_30 N_7_17 N_6_6 0.00140747f $X=0.621 $Y=0.071
cc_31 N_7_9 N_6_13 0.0138162f $X=0.513 $Y=0.0245
x_PM_DLLx1_ASAP7_75t_R%Q vss Q N_M7_d N_M15_d N_Q_8 N_Q_7 N_Q_12
+ PM_DLLx1_ASAP7_75t_R%Q
cc_32 N_Q_8 N_8_25 0.0013119f $X=0.7415 $Y=0.2025
cc_33 N_Q_8 N_8_2 0.00248175f $X=0.7415 $Y=0.2025
cc_34 N_Q_8 N_8_26 0.000803308f $X=0.7415 $Y=0.2025
cc_35 N_Q_7 N_8_12 0.0148725f $X=0.7415 $Y=0.0675
cc_36 N_Q_12 N_8_25 0.00599353f $X=0.783 $Y=0.0627
cc_37 N_Q_8 N_8_12 0.0566306f $X=0.7415 $Y=0.2025
x_PM_DLLx1_ASAP7_75t_R%6 vss N_M11_g N_M4_g N_M1_d N_M9_d N_6_4 N_6_5 N_6_20
+ N_6_19 N_6_18 N_6_16 N_6_14 N_6_21 N_6_2 N_6_23 N_6_1 N_6_15 N_6_12 N_6_13
+ N_6_17 N_6_6 N_6_22 PM_DLLx1_ASAP7_75t_R%6
cc_38 N_6_4 N_CLK_7 0.000442777f $X=0.162 $Y=0.054
cc_39 N_6_5 N_CLK_7 0.000214592f $X=0.162 $Y=0.216
cc_40 N_6_20 N_CLK_7 0.000233429f $X=0.243 $Y=0.153
cc_41 N_6_19 N_CLK_7 0.00108464f $X=0.216 $Y=0.234
cc_42 N_6_18 N_CLK_7 0.00219567f $X=0.216 $Y=0.036
cc_43 N_6_18 N_4_11 0.000230315f $X=0.216 $Y=0.036
cc_44 N_6_4 N_4_11 0.000921416f $X=0.162 $Y=0.054
cc_45 N_6_19 N_4_23 0.00012276f $X=0.216 $Y=0.234
cc_46 N_6_16 N_4_19 0.000136389f $X=0.243 $Y=0.036
cc_47 N_6_14 N_4_11 0.011029f $X=0.1475 $Y=0.054
cc_48 N_6_20 N_4_25 0.00145075f $X=0.243 $Y=0.153
cc_49 N_6_4 N_4_1 0.000430771f $X=0.162 $Y=0.054
cc_50 N_6_20 N_4_24 0.000442854f $X=0.243 $Y=0.153
cc_51 N_6_21 N_4_27 0.000509824f $X=0.351 $Y=0.116
cc_52 N_6_2 N_4_12 0.000547782f $X=0.459 $Y=0.179
cc_53 N_6_5 N_4_18 0.000564686f $X=0.162 $Y=0.216
cc_54 N_6_18 N_4_19 0.000596597f $X=0.216 $Y=0.036
cc_55 N_6_23 N_4_26 0.000657843f $X=0.2315 $Y=0.189
cc_56 N_6_20 N_4_27 0.00067201f $X=0.243 $Y=0.153
cc_57 N_6_1 N_4_2 0.00237846f $X=0.351 $Y=0.135
cc_58 N_6_15 N_4_1 0.000932299f $X=0.1475 $Y=0.216
cc_59 N_6_5 N_4_11 0.00111626f $X=0.162 $Y=0.216
cc_60 N_6_12 N_4_12 0.00160546f $X=0.351 $Y=0.073
cc_61 N_6_20 N_4_19 0.00362943f $X=0.243 $Y=0.153
cc_62 N_6_21 N_4_26 0.0043763f $X=0.351 $Y=0.116
cc_63 N_6_19 N_4_18 0.00511368f $X=0.216 $Y=0.234
cc_64 N_6_13 N_4_12 0.00851797f $X=0.459 $Y=0.179
cc_65 N_6_23 N_4_27 0.0170815f $X=0.2315 $Y=0.189
cc_66 N_6_15 N_4_11 0.0389961f $X=0.1475 $Y=0.216
cc_67 N_6_21 N_D_6 0.00269428f $X=0.351 $Y=0.116
cc_68 N_6_23 N_D_5 0.000891765f $X=0.2315 $Y=0.189
cc_69 N_6_16 N_D_4 0.0010363f $X=0.243 $Y=0.036
cc_70 N_6_17 N_D_5 0.00109665f $X=0.243 $Y=0.234
cc_71 N_6_1 N_D_1 0.00258063f $X=0.351 $Y=0.135
cc_72 N_6_12 N_D_3 0.00494026f $X=0.351 $Y=0.073
cc_73 N_6_20 N_D_6 0.00876452f $X=0.243 $Y=0.153
x_PM_DLLx1_ASAP7_75t_R%10 vss N_M2_d N_M3_s N_10_5 N_10_4 N_10_1
+ PM_DLLx1_ASAP7_75t_R%10
cc_74 N_10_5 N_4_2 0.000625723f $X=0.38 $Y=0.0675
cc_75 N_10_5 N_4_12 0.0345477f $X=0.38 $Y=0.0675
cc_76 N_10_4 N_D_6 0.000686505f $X=0.3095 $Y=0.0675
cc_77 N_10_4 N_D_3 0.0357143f $X=0.3095 $Y=0.0675
cc_78 N_10_4 N_6_1 0.00185017f $X=0.3095 $Y=0.0675
cc_79 N_10_4 N_6_12 0.0730663f $X=0.3095 $Y=0.0675
cc_80 N_10_1 N_8_6 0.00123965f $X=0.351 $Y=0.0675
cc_81 N_10_1 N_8_14 0.000583508f $X=0.351 $Y=0.0675
cc_82 N_10_1 N_8_13 0.00254315f $X=0.351 $Y=0.0675
x_PM_DLLx1_ASAP7_75t_R%11 vss N_M12_d N_M13_s N_11_4 N_11_1 N_11_5
+ PM_DLLx1_ASAP7_75t_R%11
cc_83 N_11_4 N_4_12 0.0150736f $X=0.4175 $Y=0.2295
cc_84 N_11_1 N_6_2 0.00100676f $X=0.432 $Y=0.2295
cc_85 N_11_5 N_6_6 0.0010776f $X=0.488 $Y=0.2295
cc_86 N_11_1 N_6_13 0.00201878f $X=0.432 $Y=0.2295
cc_87 N_11_5 N_6_13 0.0069665f $X=0.488 $Y=0.2295
cc_88 N_11_4 N_6_13 0.0242727f $X=0.4175 $Y=0.2295
cc_89 N_11_5 N_7_9 0.0145055f $X=0.488 $Y=0.2295
cc_90 N_11_1 N_8_16 0.00029258f $X=0.432 $Y=0.2295
cc_91 N_11_1 N_8_20 0.000368891f $X=0.432 $Y=0.2295
cc_92 N_11_1 N_8_23 0.000385775f $X=0.432 $Y=0.2295
cc_93 N_11_4 N_8_5 0.000497213f $X=0.4175 $Y=0.2295
cc_94 N_11_1 N_8_19 0.00203492f $X=0.432 $Y=0.2295
x_PM_DLLx1_ASAP7_75t_R%8 vss N_M6_g N_M14_g N_M3_d N_M4_s N_M7_g N_M15_g
+ N_M11_d N_M12_s N_8_24 N_8_5 N_8_21 N_8_16 N_8_18 N_8_26 N_8_22 N_8_20 N_8_23
+ N_8_6 N_8_13 N_8_15 N_8_14 N_8_19 N_8_1 N_8_11 N_8_2 N_8_25 N_8_17 N_8_12
+ PM_DLLx1_ASAP7_75t_R%8
cc_95 N_8_24 N_4_12 0.000154776f $X=0.5395 $Y=0.131
cc_96 N_8_5 N_4_26 0.000166699f $X=0.378 $Y=0.2295
cc_97 N_8_21 N_4_26 0.000278852f $X=0.432 $Y=0.036
cc_98 N_8_16 N_4_12 0.00556731f $X=0.3635 $Y=0.189
cc_99 N_8_18 N_4_26 0.000461951f $X=0.459 $Y=0.131
cc_100 N_8_26 N_4_27 0.000649604f $X=0.459 $Y=0.153
cc_101 N_8_22 N_4_26 0.000733894f $X=0.459 $Y=0.114
cc_102 N_8_5 N_4_2 0.000759675f $X=0.378 $Y=0.2295
cc_103 N_8_20 N_4_27 0.000811139f $X=0.432 $Y=0.234
cc_104 N_8_23 N_4_26 0.00527203f $X=0.459 $Y=0.142
cc_105 N_8_20 N_4_26 0.000939972f $X=0.432 $Y=0.234
cc_106 N_8_6 N_4_12 0.00103362f $X=0.432 $Y=0.0405
cc_107 N_8_5 N_4_12 0.00123216f $X=0.378 $Y=0.2295
cc_108 N_8_13 N_4_2 0.00165255f $X=0.4175 $Y=0.0405
cc_109 N_8_13 N_4_12 0.009616f $X=0.4175 $Y=0.0405
cc_110 N_8_15 N_4_12 0.0108384f $X=0.3635 $Y=0.2295
cc_111 N_8_14 N_4_12 0.0454772f $X=0.4175 $Y=0.081
cc_112 N_8_5 N_D_5 0.000821426f $X=0.378 $Y=0.2295
cc_113 N_8_20 N_D_5 0.00128191f $X=0.432 $Y=0.234
cc_114 N_8_13 N_6_12 0.000147816f $X=0.4175 $Y=0.0405
cc_115 N_8_18 N_6_22 0.000153597f $X=0.459 $Y=0.131
cc_116 N_8_20 N_6_21 0.00144671f $X=0.432 $Y=0.234
cc_117 N_8_16 N_6_12 0.02446f $X=0.3635 $Y=0.189
cc_118 N_8_5 N_6_21 0.00151444f $X=0.378 $Y=0.2295
cc_119 N_8_5 N_6_1 0.000280336f $X=0.378 $Y=0.2295
cc_120 N_8_22 N_6_22 0.000321027f $X=0.459 $Y=0.114
cc_121 N_8_19 N_6_22 0.00042481f $X=0.459 $Y=0.234
cc_122 N_8_14 N_6_13 0.00558805f $X=0.4175 $Y=0.081
cc_123 N_8_1 N_6_6 0.00171463f $X=0.567 $Y=0.131
cc_124 N_8_23 N_6_23 0.000589203f $X=0.459 $Y=0.142
cc_125 N_8_24 N_6_6 0.000641913f $X=0.5395 $Y=0.131
cc_126 N_8_6 N_6_13 0.000645309f $X=0.432 $Y=0.0405
cc_127 N_8_15 N_6_1 0.000754747f $X=0.3635 $Y=0.2295
cc_128 N_8_26 N_6_22 0.000919733f $X=0.459 $Y=0.153
cc_129 N_8_23 N_6_2 0.00101556f $X=0.459 $Y=0.142
cc_130 N_8_5 N_6_12 0.00162985f $X=0.378 $Y=0.2295
cc_131 N_8_23 N_6_22 0.002461f $X=0.459 $Y=0.142
cc_132 N_8_24 N_6_22 0.00359772f $X=0.5395 $Y=0.131
cc_133 N_8_26 N_6_23 0.0040433f $X=0.459 $Y=0.153
cc_134 N_8_20 N_6_23 0.00496875f $X=0.432 $Y=0.234
cc_135 N_8_11 N_6_6 0.00626822f $X=0.567 $Y=0.0245
cc_136 N_8_15 N_6_12 0.00991118f $X=0.3635 $Y=0.2295
cc_137 N_8_13 N_6_13 0.0319242f $X=0.4175 $Y=0.0405
cc_138 N_8_2 N_7_9 8.84088e-20 $X=0.729 $Y=0.136
cc_139 N_8_24 N_7_9 0.000225686f $X=0.5395 $Y=0.131
cc_140 N_8_6 N_7_9 0.000394068f $X=0.432 $Y=0.0405
cc_141 N_8_11 N_7_3 0.000420721f $X=0.567 $Y=0.0245
cc_142 N_8_25 N_7_17 0.000443143f $X=0.729 $Y=0.1165
cc_143 N_8_26 N_7_13 0.000491063f $X=0.459 $Y=0.153
cc_144 N_8_24 N_7_16 0.000610514f $X=0.5395 $Y=0.131
cc_145 N_8_1 N_7_17 0.000736335f $X=0.567 $Y=0.131
cc_146 N_8_17 N_7_12 0.000861116f $X=0.459 $Y=0.036
cc_147 N_8_1 N_7_9 0.000935748f $X=0.567 $Y=0.131
cc_148 N_8_24 N_7_1 0.000938115f $X=0.5395 $Y=0.131
cc_149 N_8_11 N_7_1 0.000988172f $X=0.567 $Y=0.0245
cc_150 N_8_11 N_7_11 0.00633621f $X=0.567 $Y=0.0245
cc_151 N_8_11 N_7_10 0.00655217f $X=0.567 $Y=0.0245
cc_152 N_8_26 N_7_17 0.00251309f $X=0.459 $Y=0.153
cc_153 N_8_24 N_7_15 0.00273701f $X=0.5395 $Y=0.131
cc_154 N_8_22 N_7_15 0.00343188f $X=0.459 $Y=0.114
cc_155 N_8_24 N_7_17 0.00373254f $X=0.5395 $Y=0.131
cc_156 N_8_11 N_7_9 0.0307731f $X=0.567 $Y=0.0245
x_PM_DLLx1_ASAP7_75t_R%12 vss N_M4_d N_M5_s N_12_1 PM_DLLx1_ASAP7_75t_R%12
cc_157 N_12_1 N_6_13 0.00757355f $X=0.486 $Y=0.0405
cc_158 N_12_1 N_7_9 0.00767407f $X=0.486 $Y=0.0405
x_PM_DLLx1_ASAP7_75t_R%D vss D N_M2_g N_M10_g N_D_6 N_D_5 N_D_4 N_D_1 N_D_3
+ PM_DLLx1_ASAP7_75t_R%D
cc_159 N_D_6 N_4_26 0.000182948f $X=0.297 $Y=0.0755
cc_160 N_D_6 N_4_27 0.00293758f $X=0.297 $Y=0.0755

* End of included file DLLx1_ASAP7_75t_R.pex.sp.pxi
.ends

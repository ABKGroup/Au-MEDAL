.subckt PM_DFFHQNx2_ASAP7_75t_R%12 vss 7 9 5 4 1
c1 1 vss 0.00905618f $X=0.351 $Y=0.0675
c2 4 vss 0.00287982f $X=0.3095 $Y=0.0675
c3 5 vss 0.00175787f $X=0.38 $Y=0.0675
r1 9 8 0.0308642 $w=8.1e-08 $l=2.5e-09 $layer=N_src_drn $thickness=1e-09
+ $X=0.3953 $Y=0.0675 $X2=0.3925 $Y2=0.0675
r2 5 8 0.154321 $w=8.1e-08 $l=1.25e-08 $layer=N_src_drn $thickness=1e-09
+ $X=0.38 $Y=0.0675 $X2=0.3925 $Y2=0.0675
r3 4 1 0.154321 $w=8.1e-08 $l=1.25e-08 $layer=N_src_drn $thickness=1e-09
+ $X=0.3095 $Y=0.0675 $X2=0.351 $Y2=0.0675
r4 7 4 0.0308642 $w=8.1e-08 $l=2.5e-09 $layer=N_src_drn $thickness=1e-09
+ $X=0.3066 $Y=0.0675 $X2=0.3095 $Y2=0.0675
r5 1 5 1e-05 $l=2.9e-08 $X=0.351 $Y=0.0675 $X2=0.38 $Y2=0.0675
.ends

.subckt PM_DFFHQNx2_ASAP7_75t_R%15 vss 2 3 1
c1 1 vss 0.000540513f $X=0.486 $Y=0.0405
r1 2 1 0.62963 $w=2.7e-08 $l=1.7e-08 $layer=N_src_drn $thickness=1e-09
+ $X=0.4686 $Y=0.0405 $X2=0.486 $Y2=0.0405
r2 3 1 0.62963 $w=2.7e-08 $l=1.7e-08 $layer=N_src_drn $thickness=1e-09
+ $X=0.5033 $Y=0.0405 $X2=0.486 $Y2=0.0405
.ends

.subckt PM_DFFHQNx2_ASAP7_75t_R%CLK vss 17 9 15 3 1 7 8 4 5 6
c1 1 vss 0.0041521f $X=0.081 $Y=0.135
c2 3 vss 0.0689334f $X=0.081 $Y=0.0245
c3 4 vss 0.0026397f $X=0.081 $Y=0.088
c4 5 vss 0.00254462f $X=0.081 $Y=0.182
c5 6 vss 0.00128444f $X=0.081 $Y=0.1122
c6 7 vss 0.0042108f $X=0.108 $Y=0.0575
c7 8 vss 0.00407343f $X=0.108 $Y=0.2125
r1 8 25 3.22357 $w=2.26279e-08 $l=3.05e-08 $layer=M1 $thickness=3.6e-08
+ $X=0.108 $Y=0.2125 $X2=0.108 $Y2=0.182
r2 7 23 3.22357 $w=2.26279e-08 $l=3.05e-08 $layer=M1 $thickness=3.6e-08
+ $X=0.108 $Y=0.0575 $X2=0.108 $Y2=0.088
r3 24 25 0.502848 $w=3.43333e-08 $l=1.35e-08 $layer=M1 $thickness=3.6e-08
+ $X=0.0945 $Y=0.182 $X2=0.108 $Y2=0.182
r4 5 21 0.54189 $w=3.37e-08 $l=1.9e-08 $layer=M1 $thickness=3.6e-08 $X=0.081
+ $Y=0.182 $X2=0.081 $Y2=0.163
r5 5 24 0.502848 $w=3.43333e-08 $l=1.35e-08 $layer=M1 $thickness=3.6e-08
+ $X=0.081 $Y=0.182 $X2=0.0945 $Y2=0.182
r6 22 23 0.502848 $w=3.43333e-08 $l=1.35e-08 $layer=M1 $thickness=3.6e-08
+ $X=0.0945 $Y=0.088 $X2=0.108 $Y2=0.088
r7 4 6 1.76614 $w=2.65738e-08 $l=2.42e-08 $layer=M1 $thickness=3.6e-08 $X=0.081
+ $Y=0.088 $X2=0.081 $Y2=0.1122
r8 4 22 0.502848 $w=3.43333e-08 $l=1.35e-08 $layer=M1 $thickness=3.6e-08
+ $X=0.081 $Y=0.088 $X2=0.0945 $Y2=0.088
r9 20 21 2.3319 $w=1.3e-08 $l=1e-08 $layer=M1 $thickness=3.6e-08 $X=0.081
+ $Y=0.153 $X2=0.081 $Y2=0.163
r10 19 20 4.19742 $w=1.3e-08 $l=1.8e-08 $layer=M1 $thickness=3.6e-08 $X=0.081
+ $Y=0.135 $X2=0.081 $Y2=0.153
r11 18 19 2.85657 $w=1.3e-08 $l=1.23e-08 $layer=M1 $thickness=3.6e-08 $X=0.081
+ $Y=0.1227 $X2=0.081 $Y2=0.135
r12 17 18 0.874462 $w=1.3e-08 $l=3.7e-09 $layer=M1 $thickness=3.6e-08 $X=0.082
+ $Y=0.119 $X2=0.081 $Y2=0.1227
r13 17 6 1.57403 $w=1.3e-08 $l=6.8e-09 $layer=M1 $thickness=3.6e-08 $X=0.082
+ $Y=0.119 $X2=0.081 $Y2=0.1122
r14 1 12 10.4265 $w=1.765e-08 $layer=LIG $thickness=5.2e-08 $X=0.081 $Y=0.135
+ $X2=0.081 $Y2=0.135
r15 1 19 19.3796 $a=3.24e-16 $layer=V0LIG $X=0.081 $Y=0.135 $X2=0.081 $Y2=0.135
r16 15 14 14.6259 $w=2.1e-08 $l=4.3e-08 $layer=Gate_1 $thickness=5.6e-08
+ $X=0.081 $Y=0.216 $X2=0.081 $Y2=0.173
r17 13 14 7.31297 $w=2.1e-08 $l=2.15e-08 $layer=Gate_1 $thickness=5.6e-08
+ $X=0.081 $Y=0.1515 $X2=0.081 $Y2=0.173
r18 12 13 5.79936 $w=2.03333e-08 $l=1.65e-08 $layer=Gate_1 $thickness=5.6e-08
+ $X=0.081 $Y=0.135 $X2=0.081 $Y2=0.1515
r19 11 12 5.79936 $w=2.03333e-08 $l=1.65e-08 $layer=Gate_1 $thickness=5.6e-08
+ $X=0.081 $Y=0.1185 $X2=0.081 $Y2=0.135
r20 10 11 7.31297 $w=2.1e-08 $l=2.15e-08 $layer=Gate_1 $thickness=5.6e-08
+ $X=0.081 $Y=0.097 $X2=0.081 $Y2=0.1185
r21 9 10 14.6259 $w=2.1e-08 $l=4.3e-08 $layer=Gate_1 $thickness=5.6e-08
+ $X=0.081 $Y=0.054 $X2=0.081 $Y2=0.097
r22 9 3 10.0341 $w=2.1e-08 $l=2.95e-08 $layer=Gate_1 $thickness=5.6e-08
+ $X=0.081 $Y=0.054 $X2=0.081 $Y2=0.0245
.ends

.subckt PM_DFFHQNx2_ASAP7_75t_R%8 vss 21 25 52 55 61 64 11 19 13 14 3 4 18 10
+ 15 20 12 16 1 17 9
c1 1 vss 0.000445103f $X=0.567 $Y=0.1305
c2 3 vss 0.0051338f $X=0.378 $Y=0.2295
c3 4 vss 0.00478172f $X=0.432 $Y=0.0405
c4 9 vss 0.0387218f $X=0.567 $Y=0.0245
c5 10 vss 0.00195189f $X=0.4175 $Y=0.0405
c6 11 vss 0.000314953f $X=0.4175 $Y=0.081
c7 12 vss 0.00223934f $X=0.3635 $Y=0.2295
c8 13 vss 0.000392214f $X=0.3635 $Y=0.189
c9 14 vss 0.00602224f $X=0.459 $Y=0.036
c10 15 vss 1.31698e-20 $X=0.459 $Y=0.131
c11 16 vss 0.00260054f $X=0.459 $Y=0.234
c12 17 vss 0.00707202f $X=0.434 $Y=0.234
c13 18 vss 0.00127872f $X=0.459 $Y=0.114
c14 19 vss 0.000588222f $X=0.459 $Y=0.1525
c15 20 vss 0.000777111f $X=0.54 $Y=0.131
r1 13 3 0.231482 $w=5.4e-08 $l=1.25e-08 $layer=P_src_drn $thickness=1e-09
+ $X=0.3635 $Y=0.189 $X2=0.378 $Y2=0.2295
r2 64 63 0.0925926 $w=2.7e-08 $l=2.5e-09 $layer=P_src_drn $thickness=1e-09
+ $X=0.3953 $Y=0.2295 $X2=0.3925 $Y2=0.2295
r3 62 63 0.166667 $w=2.7e-08 $l=4.5e-09 $layer=P_src_drn $thickness=1e-09
+ $X=0.388 $Y=0.2295 $X2=0.3925 $Y2=0.2295
r4 3 62 0.444445 $w=2.7e-08 $l=1.2e-08 $layer=P_src_drn $thickness=1e-09
+ $X=0.378 $Y=0.2295 $X2=0.388 $Y2=0.2295
r5 12 3 0.462963 $w=2.7e-08 $l=1.25e-08 $layer=P_src_drn $thickness=1e-09
+ $X=0.3635 $Y=0.2295 $X2=0.378 $Y2=0.2295
r6 61 12 0.0925926 $w=2.7e-08 $l=2.5e-09 $layer=P_src_drn $thickness=1e-09
+ $X=0.3606 $Y=0.2025 $X2=0.3635 $Y2=0.2295
r7 3 48 19.3796 $a=3.24e-16 $layer=V0LISD $X=0.378 $Y=0.2295 $X2=0.378 $Y2=0.234
r8 11 4 0.231482 $w=5.4e-08 $l=1.25e-08 $layer=N_src_drn $thickness=1e-09
+ $X=0.4175 $Y=0.081 $X2=0.432 $Y2=0.0405
r9 55 54 0.0925926 $w=2.7e-08 $l=2.5e-09 $layer=N_src_drn $thickness=1e-09
+ $X=0.4493 $Y=0.0405 $X2=0.4465 $Y2=0.0405
r10 53 54 0.166667 $w=2.7e-08 $l=4.5e-09 $layer=N_src_drn $thickness=1e-09
+ $X=0.442 $Y=0.0405 $X2=0.4465 $Y2=0.0405
r11 4 53 0.444445 $w=2.7e-08 $l=1.2e-08 $layer=N_src_drn $thickness=1e-09
+ $X=0.432 $Y=0.0405 $X2=0.442 $Y2=0.0405
r12 10 4 0.462963 $w=2.7e-08 $l=1.25e-08 $layer=N_src_drn $thickness=1e-09
+ $X=0.4175 $Y=0.0405 $X2=0.432 $Y2=0.0405
r13 52 10 0.0925926 $w=2.7e-08 $l=2.5e-09 $layer=N_src_drn $thickness=1e-09
+ $X=0.4146 $Y=0.0675 $X2=0.4175 $Y2=0.0405
r14 48 49 3.14806 $w=1.3e-08 $l=1.35e-08 $layer=M1 $thickness=3.6e-08 $X=0.378
+ $Y=0.234 $X2=0.3915 $Y2=0.234
r15 46 49 3.14806 $w=1.3e-08 $l=1.35e-08 $layer=M1 $thickness=3.6e-08 $X=0.405
+ $Y=0.234 $X2=0.3915 $Y2=0.234
r16 45 46 2.56509 $w=1.3e-08 $l=1.1e-08 $layer=M1 $thickness=3.6e-08 $X=0.416
+ $Y=0.234 $X2=0.405 $Y2=0.234
r17 17 45 4.19742 $w=1.3e-08 $l=1.8e-08 $layer=M1 $thickness=3.6e-08 $X=0.434
+ $Y=0.234 $X2=0.416 $Y2=0.234
r18 4 40 19.3796 $a=3.24e-16 $layer=V0LISD $X=0.432 $Y=0.0405 $X2=0.432
+ $Y2=0.036
r19 16 38 3.01468 $w=1.741e-08 $l=2e-08 $layer=M1 $thickness=3.6e-08 $X=0.459
+ $Y=0.234 $X2=0.459 $Y2=0.214
r20 16 17 4.18063 $w=1.48e-08 $l=2.5e-08 $layer=M1 $thickness=3.6e-08 $X=0.459
+ $Y=0.234 $X2=0.434 $Y2=0.234
r21 40 41 3.14806 $w=1.3e-08 $l=1.35e-08 $layer=M1 $thickness=3.6e-08 $X=0.432
+ $Y=0.036 $X2=0.4455 $Y2=0.036
r22 14 35 5.11582 $w=1.46667e-08 $l=2.7e-08 $layer=M1 $thickness=3.6e-08
+ $X=0.459 $Y=0.036 $X2=0.459 $Y2=0.063
r23 14 41 1.96775 $w=1.63333e-08 $l=1.35e-08 $layer=M1 $thickness=3.6e-08
+ $X=0.459 $Y=0.036 $X2=0.4455 $Y2=0.036
r24 37 38 6.7625 $w=1.3e-08 $l=2.9e-08 $layer=M1 $thickness=3.6e-08 $X=0.459
+ $Y=0.185 $X2=0.459 $Y2=0.214
r25 36 37 4.43061 $w=1.3e-08 $l=1.9e-08 $layer=M1 $thickness=3.6e-08 $X=0.459
+ $Y=0.166 $X2=0.459 $Y2=0.185
r26 19 36 3.14806 $w=1.3e-08 $l=1.35e-08 $layer=M1 $thickness=3.6e-08 $X=0.459
+ $Y=0.1525 $X2=0.459 $Y2=0.166
r27 34 35 6.29612 $w=1.3e-08 $l=2.7e-08 $layer=M1 $thickness=3.6e-08 $X=0.459
+ $Y=0.09 $X2=0.459 $Y2=0.063
r28 33 34 2.91487 $w=1.3e-08 $l=1.25e-08 $layer=M1 $thickness=3.6e-08 $X=0.459
+ $Y=0.1025 $X2=0.459 $Y2=0.09
r29 18 33 2.68168 $w=1.3e-08 $l=1.15e-08 $layer=M1 $thickness=3.6e-08 $X=0.459
+ $Y=0.114 $X2=0.459 $Y2=0.1025
r30 15 32 4.18306 $w=1.49565e-08 $l=2.3e-08 $layer=M1 $thickness=3.6e-08
+ $X=0.459 $Y=0.131 $X2=0.482 $Y2=0.131
r31 15 18 2.78392 $w=1.56471e-08 $l=1.7e-08 $layer=M1 $thickness=3.6e-08
+ $X=0.459 $Y=0.131 $X2=0.459 $Y2=0.114
r32 15 19 3.83327 $w=1.5093e-08 $l=2.15e-08 $layer=M1 $thickness=3.6e-08
+ $X=0.459 $Y=0.131 $X2=0.459 $Y2=0.1525
r33 31 32 4.19742 $w=1.3e-08 $l=1.8e-08 $layer=M1 $thickness=3.6e-08 $X=0.5
+ $Y=0.131 $X2=0.482 $Y2=0.131
r34 30 31 3.03147 $w=1.3e-08 $l=1.3e-08 $layer=M1 $thickness=3.6e-08 $X=0.513
+ $Y=0.131 $X2=0.5 $Y2=0.131
r35 20 29 6.29612 $w=1.3e-08 $l=2.7e-08 $layer=M1 $thickness=3.6e-08 $X=0.54
+ $Y=0.131 $X2=0.567 $Y2=0.131
r36 20 30 6.29612 $w=1.3e-08 $l=2.7e-08 $layer=M1 $thickness=3.6e-08 $X=0.54
+ $Y=0.131 $X2=0.513 $Y2=0.131
r37 1 23 6.4735 $w=2.13953e-08 $layer=Gate_1 $thickness=5.22791e-08 $X=0.567
+ $Y=0.1305 $X2=0.567 $Y2=0.1305
r38 1 29 19.3796 $a=3.24e-16 $layer=V0LIG $X=0.567 $Y=0.1305 $X2=0.567 $Y2=0.131
r39 25 24 17.177 $w=2.1e-08 $l=5.05e-08 $layer=Gate_1 $thickness=5.6e-08
+ $X=0.567 $Y=0.2295 $X2=0.567 $Y2=0.179
r40 23 24 16.6923 $w=2.07629e-08 $l=4.85e-08 $layer=Gate_1 $thickness=5.6e-08
+ $X=0.567 $Y=0.1305 $X2=0.567 $Y2=0.179
r41 22 23 15.1617 $w=2.07386e-08 $l=4.4e-08 $layer=Gate_1 $thickness=5.6e-08
+ $X=0.567 $Y=0.0865 $X2=0.567 $Y2=0.1305
r42 21 22 15.6464 $w=2.1e-08 $l=4.6e-08 $layer=Gate_1 $thickness=5.6e-08
+ $X=0.567 $Y=0.0405 $X2=0.567 $Y2=0.0865
r43 21 9 5.44221 $w=2.1e-08 $l=1.6e-08 $layer=Gate_1 $thickness=5.6e-08
+ $X=0.567 $Y=0.0405 $X2=0.567 $Y2=0.0245
.ends

.subckt PM_DFFHQNx2_ASAP7_75t_R%16 vss 2 3 1
c1 1 vss 0.000765319f $X=0.324 $Y=0.2025
r1 2 1 0.209877 $w=8.1e-08 $l=1.7e-08 $layer=P_src_drn $thickness=1e-09
+ $X=0.3066 $Y=0.2025 $X2=0.324 $Y2=0.2025
r2 3 1 0.209877 $w=8.1e-08 $l=1.7e-08 $layer=P_src_drn $thickness=1e-09
+ $X=0.3413 $Y=0.2025 $X2=0.324 $Y2=0.2025
.ends

.subckt PM_DFFHQNx2_ASAP7_75t_R%17 vss 2 3 1
c1 1 vss 0.000559422f $X=0.756 $Y=0.2295
r1 2 1 0.62963 $w=2.7e-08 $l=1.7e-08 $layer=P_src_drn $thickness=1e-09
+ $X=0.7386 $Y=0.2295 $X2=0.756 $Y2=0.2295
r2 3 1 0.62963 $w=2.7e-08 $l=1.7e-08 $layer=P_src_drn $thickness=1e-09
+ $X=0.7733 $Y=0.2295 $X2=0.756 $Y2=0.2295
.ends

.subckt PM_DFFHQNx2_ASAP7_75t_R%4 vss 33 39 75 78 81 84 93 95 8 7 25 19 16 17 1
+ 22 24 23 21 28 13 14 26 15 2 3 27
c1 1 vss 0.00343853f $X=0.1335 $Y=0.135
c2 2 vss 0.000116463f $X=0.405 $Y=0.135
c3 3 vss 0.000502161f $X=0.675 $Y=0.135
c4 7 vss 0.00795233f $X=0.054 $Y=0.054
c5 8 vss 0.00789595f $X=0.054 $Y=0.216
c6 13 vss 0.0686574f $X=0.135 $Y=0.0245
c7 14 vss 0.0071451f $X=0.405 $Y=0.135
c8 15 vss 0.00730557f $X=0.675 $Y=0.135
c9 16 vss 0.0311097f $X=0.056 $Y=0.054
c10 17 vss 0.0311611f $X=0.056 $Y=0.216
c11 18 vss 0.00367253f $X=0.018 $Y=0.036
c12 19 vss 0.00214887f $X=0.0165 $Y=0.153
c13 20 vss 0.00364042f $X=0.018 $Y=0.234
c14 21 vss 0.00667284f $X=0.018 $Y=0.125
c15 22 vss 0.00426713f $X=0.018 $Y=0.163
c16 23 vss 0.00461369f $X=0.036 $Y=0.036
c17 24 vss 0.00421284f $X=0.036 $Y=0.234
c18 25 vss 0.00104171f $X=0.151 $Y=0.116
c19 26 vss 0.000762029f $X=0.405 $Y=0.135
c20 27 vss 0.00179039f $X=0.675 $Y=0.1135
c21 28 vss 0.0271348f $X=0.0215 $Y=0.153
r1 95 94 0.0462963 $w=5.4e-08 $l=2.5e-09 $layer=P_src_drn $thickness=1e-09
+ $X=0.0713 $Y=0.216 $X2=0.0685 $Y2=0.216
r2 17 94 0.231482 $w=5.4e-08 $l=1.25e-08 $layer=P_src_drn $thickness=1e-09
+ $X=0.056 $Y=0.216 $X2=0.0685 $Y2=0.216
r3 93 92 0.0462963 $w=5.4e-08 $l=2.5e-09 $layer=N_src_drn $thickness=1e-09
+ $X=0.0713 $Y=0.054 $X2=0.0685 $Y2=0.054
r4 16 92 0.231482 $w=5.4e-08 $l=1.25e-08 $layer=N_src_drn $thickness=1e-09
+ $X=0.056 $Y=0.054 $X2=0.0685 $Y2=0.054
r5 8 90 19.3796 $a=3.24e-16 $layer=V0LISD $X=0.054 $Y=0.216 $X2=0.055 $Y2=0.234
r6 7 87 19.3796 $a=3.24e-16 $layer=V0LISD $X=0.054 $Y=0.054 $X2=0.055 $Y2=0.036
r7 89 90 2.09871 $w=1.3e-08 $l=9e-09 $layer=M1 $thickness=3.6e-08 $X=0.046
+ $Y=0.234 $X2=0.055 $Y2=0.234
r8 24 89 2.3319 $w=1.3e-08 $l=1e-08 $layer=M1 $thickness=3.6e-08 $X=0.036
+ $Y=0.234 $X2=0.046 $Y2=0.234
r9 86 87 2.09871 $w=1.3e-08 $l=9e-09 $layer=M1 $thickness=3.6e-08 $X=0.046
+ $Y=0.036 $X2=0.055 $Y2=0.036
r10 23 86 2.3319 $w=1.3e-08 $l=1e-08 $layer=M1 $thickness=3.6e-08 $X=0.036
+ $Y=0.036 $X2=0.046 $Y2=0.036
r11 84 83 16.4967 $w=2.1e-08 $l=4.85e-08 $layer=Gate_1 $thickness=5.6e-08
+ $X=0.675 $Y=0.2295 $X2=0.675 $Y2=0.181
r12 81 82 16.4967 $w=2.1e-08 $l=4.85e-08 $layer=Gate_1 $thickness=5.6e-08
+ $X=0.675 $Y=0.0405 $X2=0.675 $Y2=0.089
r13 15 82 15.8334 $w=2.07609e-08 $l=4.6e-08 $layer=Gate_1 $thickness=5.6e-08
+ $X=0.675 $Y=0.135 $X2=0.675 $Y2=0.089
r14 15 83 15.8334 $w=2.07609e-08 $l=4.6e-08 $layer=Gate_1 $thickness=5.6e-08
+ $X=0.675 $Y=0.135 $X2=0.675 $Y2=0.181
r15 78 77 16.4967 $w=2.1e-08 $l=4.85e-08 $layer=Gate_1 $thickness=5.6e-08
+ $X=0.405 $Y=0.2295 $X2=0.405 $Y2=0.181
r16 75 76 16.4967 $w=2.1e-08 $l=4.85e-08 $layer=Gate_1 $thickness=5.6e-08
+ $X=0.405 $Y=0.0675 $X2=0.405 $Y2=0.116
r17 14 76 6.6497 $w=2.04211e-08 $l=1.9e-08 $layer=Gate_1 $thickness=5.6e-08
+ $X=0.405 $Y=0.135 $X2=0.405 $Y2=0.116
r18 14 77 15.8334 $w=2.07609e-08 $l=4.6e-08 $layer=Gate_1 $thickness=5.6e-08
+ $X=0.405 $Y=0.135 $X2=0.405 $Y2=0.181
r19 20 69 3.36447 $w=1.71023e-08 $l=2.15e-08 $layer=M1 $thickness=3.6e-08
+ $X=0.018 $Y=0.234 $X2=0.018 $Y2=0.2125
r20 20 24 2.5483 $w=1.55e-08 $l=1.8e-08 $layer=M1 $thickness=3.6e-08 $X=0.018
+ $Y=0.234 $X2=0.036 $Y2=0.234
r21 18 67 3.36447 $w=1.71023e-08 $l=2.15e-08 $layer=M1 $thickness=3.6e-08
+ $X=0.018 $Y=0.036 $X2=0.018 $Y2=0.0575
r22 18 23 2.5483 $w=1.55e-08 $l=1.8e-08 $layer=M1 $thickness=3.6e-08 $X=0.018
+ $Y=0.036 $X2=0.036 $Y2=0.036
r23 3 64 19.3796 $a=3.24e-16 $layer=V0LIG $X=0.675 $Y=0.135 $X2=0.675 $Y2=0.144
r24 3 15 6.54019 $w=2.09524e-08 $layer=Gate_1 $thickness=5.21905e-08 $X=0.675
+ $Y=0.135 $X2=0.675 $Y2=0.135
r25 2 26 19.3796 $a=3.24e-16 $layer=V0LIG $X=0.405 $Y=0.135 $X2=0.405 $Y2=0.135
r26 2 14 6.54019 $w=2.09524e-08 $layer=Gate_1 $thickness=5.21905e-08 $X=0.405
+ $Y=0.135 $X2=0.405 $Y2=0.135
r27 68 69 7.11229 $w=1.3e-08 $l=3.05e-08 $layer=M1 $thickness=3.6e-08 $X=0.018
+ $Y=0.182 $X2=0.018 $Y2=0.2125
r28 22 68 4.43061 $w=1.3e-08 $l=1.9e-08 $layer=M1 $thickness=3.6e-08 $X=0.018
+ $Y=0.163 $X2=0.018 $Y2=0.182
r29 66 67 7.11229 $w=1.3e-08 $l=3.05e-08 $layer=M1 $thickness=3.6e-08 $X=0.018
+ $Y=0.088 $X2=0.018 $Y2=0.0575
r30 21 66 8.62802 $w=1.3e-08 $l=3.7e-08 $layer=M1 $thickness=3.6e-08 $X=0.018
+ $Y=0.125 $X2=0.018 $Y2=0.088
r31 27 64 7.11229 $w=1.3e-08 $l=3.05e-08 $layer=M1 $thickness=3.6e-08 $X=0.675
+ $Y=0.1135 $X2=0.675 $Y2=0.144
r32 26 62 4.19742 $w=1.3e-08 $l=1.8e-08 $layer=M1 $thickness=3.6e-08 $X=0.405
+ $Y=0.135 $X2=0.405 $Y2=0.153
r33 58 59 1.90199 $w=1.38333e-08 $l=9e-09 $layer=M1 $thickness=3.6e-08
+ $X=0.0255 $Y=0.153 $X2=0.0345 $Y2=0.153
r34 19 58 0.9184 $w=1.8e-08 $l=9e-09 $layer=M1 $thickness=3.6e-08 $X=0.0165
+ $Y=0.153 $X2=0.0255 $Y2=0.153
r35 19 21 5.19594 $w=1.44151e-08 $l=2.80401e-08 $layer=M1 $thickness=3.6e-08
+ $X=0.0165 $Y=0.153 $X2=0.018 $Y2=0.125
r36 19 22 0.998523 $w=1.74118e-08 $l=1.01119e-08 $layer=M1 $thickness=3.6e-08
+ $X=0.0165 $Y=0.153 $X2=0.018 $Y2=0.163
r37 56 64 19.5347 $a=3.24e-16 $layer=V1 $X=0.675 $Y=0.153 $X2=0.675 $Y2=0.144
r38 55 56 18.3054 $w=1.3e-08 $l=7.85e-08 $layer=M2 $thickness=3.6e-08 $X=0.5965
+ $Y=0.153 $X2=0.675 $Y2=0.153
r39 54 55 29.3819 $w=1.3e-08 $l=1.26e-07 $layer=M2 $thickness=3.6e-08 $X=0.4705
+ $Y=0.153 $X2=0.5965 $Y2=0.153
r40 53 54 15.2739 $w=1.3e-08 $l=6.55e-08 $layer=M2 $thickness=3.6e-08 $X=0.405
+ $Y=0.153 $X2=0.4705 $Y2=0.153
r41 53 62 19.5347 $a=3.24e-16 $layer=V1 $X=0.405 $Y=0.153 $X2=0.405 $Y2=0.153
r42 52 53 27.8662 $w=1.3e-08 $l=1.195e-07 $layer=M2 $thickness=3.6e-08
+ $X=0.2855 $Y=0.153 $X2=0.405 $Y2=0.153
r43 51 52 27.5164 $w=1.3e-08 $l=1.18e-07 $layer=M2 $thickness=3.6e-08 $X=0.1675
+ $Y=0.153 $X2=0.2855 $Y2=0.153
r44 50 51 3.84763 $w=1.3e-08 $l=1.65e-08 $layer=M2 $thickness=3.6e-08 $X=0.151
+ $Y=0.153 $X2=0.1675 $Y2=0.153
r45 49 50 13.7582 $w=1.3e-08 $l=5.9e-08 $layer=M2 $thickness=3.6e-08 $X=0.092
+ $Y=0.153 $X2=0.151 $Y2=0.153
r46 48 49 13.7582 $w=1.3e-08 $l=5.9e-08 $layer=M2 $thickness=3.6e-08 $X=0.033
+ $Y=0.153 $X2=0.092 $Y2=0.153
r47 48 59 19.5347 $a=3.24e-16 $layer=V1 $X=0.033 $Y=0.153 $X2=0.0345 $Y2=0.153
r48 28 48 2.68168 $w=1.3e-08 $l=1.15e-08 $layer=M2 $thickness=3.6e-08 $X=0.0215
+ $Y=0.153 $X2=0.033 $Y2=0.153
r49 45 50 19.5347 $a=3.24e-16 $layer=V1 $X=0.151 $Y=0.144 $X2=0.151 $Y2=0.153
r50 25 45 6.52931 $w=1.3e-08 $l=2.8e-08 $layer=M1 $thickness=3.6e-08 $X=0.151
+ $Y=0.116 $X2=0.151 $Y2=0.144
r51 43 45 19.3796 $a=3.24e-16 $layer=V0LIG $X=0.1525 $Y=0.135 $X2=0.151
+ $Y2=0.144
r52 41 43 4.82216 $w=1.64167e-08 $l=9e-09 $layer=LIG $thickness=4.8e-08
+ $X=0.1435 $Y=0.135 $X2=0.1525 $Y2=0.135
r53 1 41 2.6116 $w=2.2e-08 $l=1e-08 $layer=LIG $thickness=4.8e-08 $X=0.1335
+ $Y=0.135 $X2=0.1435 $Y2=0.135
r54 1 36 6.14846 $w=2.08718e-08 $l=1.5e-09 $layer=Gate_1 $thickness=5.25128e-08
+ $X=0.1335 $Y=0.135 $X2=0.135 $Y2=0.135
r55 39 38 14.6259 $w=2.1e-08 $l=4.3e-08 $layer=Gate_1 $thickness=5.6e-08
+ $X=0.135 $Y=0.216 $X2=0.135 $Y2=0.173
r56 37 38 7.31297 $w=2.1e-08 $l=2.15e-08 $layer=Gate_1 $thickness=5.6e-08
+ $X=0.135 $Y=0.1515 $X2=0.135 $Y2=0.173
r57 36 37 5.79936 $w=2.03333e-08 $l=1.65e-08 $layer=Gate_1 $thickness=5.6e-08
+ $X=0.135 $Y=0.135 $X2=0.135 $Y2=0.1515
r58 36 41 4.32033 $w=2.024e-08 $l=8.5e-09 $layer=Gate_1 $thickness=5.504e-08
+ $X=0.135 $Y=0.135 $X2=0.1435 $Y2=0.135
r59 35 36 5.79936 $w=2.03333e-08 $l=1.65e-08 $layer=Gate_1 $thickness=5.6e-08
+ $X=0.135 $Y=0.1185 $X2=0.135 $Y2=0.135
r60 34 35 7.31297 $w=2.1e-08 $l=2.15e-08 $layer=Gate_1 $thickness=5.6e-08
+ $X=0.135 $Y=0.097 $X2=0.135 $Y2=0.1185
r61 33 34 14.6259 $w=2.1e-08 $l=4.3e-08 $layer=Gate_1 $thickness=5.6e-08
+ $X=0.135 $Y=0.054 $X2=0.135 $Y2=0.097
r62 33 13 10.0341 $w=2.1e-08 $l=2.95e-08 $layer=Gate_1 $thickness=5.6e-08
+ $X=0.135 $Y=0.054 $X2=0.135 $Y2=0.0245
r63 8 17 1e-05 $l=2e-09 $X=0.054 $Y=0.216 $X2=0.056 $Y2=0.216
r64 7 16 1e-05 $l=2e-09 $X=0.054 $Y=0.054 $X2=0.056 $Y2=0.054
.ends

.subckt PM_DFFHQNx2_ASAP7_75t_R%6 vss 32 79 81 83 87 92 7 6 23 21 20 18 19 3 4
+ 22 25 1 8 2 24 26 14 17 15 16
c1 1 vss 0.000929366f $X=0.351 $Y=0.135
c2 2 vss 7.68157e-20 $X=0.459 $Y=0.178
c3 3 vss 4.3834e-20 $X=0.621 $Y=0.178
c4 4 vss 0.000976702f $X=0.729 $Y=0.178
c5 6 vss 0.00762212f $X=0.162 $Y=0.054
c6 7 vss 0.00762129f $X=0.162 $Y=0.216
c7 8 vss 0.00485675f $X=0.501 $Y=0.178
c8 14 vss 0.00835366f $X=0.351 $Y=0.073
c9 15 vss 0.00696584f $X=0.459 $Y=0.178
c10 16 vss 0.00640149f $X=0.621 $Y=0.178
c11 17 vss 0.00786028f $X=0.729 $Y=0.178
c12 18 vss 0.036511f $X=0.1475 $Y=0.054
c13 19 vss 0.0360659f $X=0.1475 $Y=0.216
c14 20 vss 0.00626121f $X=0.189 $Y=0.036
c15 21 vss 0.00600321f $X=0.189 $Y=0.234
c16 22 vss 0.00116367f $X=0.3375 $Y=0.135
c17 23 vss 0.00627352f $X=0.189 $Y=0.1735
c18 24 vss 0.00242744f $X=0.324 $Y=0.1555
c19 25 vss 0.00150749f $X=0.513 $Y=0.168
c20 26 vss 0.0264636f $X=0.1775 $Y=0.189
r1 92 91 8.84359 $w=2.1e-08 $l=2.6e-08 $layer=Gate_1 $thickness=5.6e-08
+ $X=0.729 $Y=0.2295 $X2=0.729 $Y2=0.2035
r2 17 91 8.89461 $w=2.04902e-08 $l=2.55e-08 $layer=Gate_1 $thickness=5.6e-08
+ $X=0.729 $Y=0.178 $X2=0.729 $Y2=0.2035
r3 87 88 23.4695 $w=2.1e-08 $l=6.9e-08 $layer=Gate_1 $thickness=5.6e-08
+ $X=0.621 $Y=0.0405 $X2=0.621 $Y2=0.1095
r4 16 88 23.5205 $w=2.08102e-08 $l=6.85e-08 $layer=Gate_1 $thickness=5.6e-08
+ $X=0.621 $Y=0.178 $X2=0.621 $Y2=0.1095
r5 83 84 23.4695 $w=2.1e-08 $l=6.9e-08 $layer=Gate_1 $thickness=5.6e-08
+ $X=0.459 $Y=0.0405 $X2=0.459 $Y2=0.1095
r6 15 84 23.5205 $w=2.08102e-08 $l=6.85e-08 $layer=Gate_1 $thickness=5.6e-08
+ $X=0.459 $Y=0.178 $X2=0.459 $Y2=0.1095
r7 19 7 0.231482 $w=5.4e-08 $l=1.25e-08 $layer=P_src_drn $thickness=1e-09
+ $X=0.1475 $Y=0.216 $X2=0.162 $Y2=0.216
r8 81 19 0.0462963 $w=5.4e-08 $l=2.5e-09 $layer=P_src_drn $thickness=1e-09
+ $X=0.1446 $Y=0.216 $X2=0.1475 $Y2=0.216
r9 18 6 0.231482 $w=5.4e-08 $l=1.25e-08 $layer=N_src_drn $thickness=1e-09
+ $X=0.1475 $Y=0.054 $X2=0.162 $Y2=0.054
r10 79 18 0.0462963 $w=5.4e-08 $l=2.5e-09 $layer=N_src_drn $thickness=1e-09
+ $X=0.1446 $Y=0.054 $X2=0.1475 $Y2=0.054
r11 4 77 2.78395 $w=2.4e-08 $l=4e-09 $layer=LIG $thickness=4.8e-08 $X=0.729
+ $Y=0.178 $X2=0.725 $Y2=0.178
r12 4 17 7.42683 $w=2.2e-08 $layer=Gate_1 $thickness=5.2e-08 $X=0.729 $Y=0.178
+ $X2=0.729 $Y2=0.178
r13 3 72 10.3807 $w=2.30357e-08 $layer=LISD $thickness=3.675e-08 $X=0.621
+ $Y=0.178 $X2=0.621 $Y2=0.178
r14 3 16 7.42683 $w=2.2e-08 $layer=Gate_1 $thickness=5.2e-08 $X=0.621 $Y=0.178
+ $X2=0.621 $Y2=0.178
r15 2 68 2.78395 $w=2.4e-08 $l=5e-09 $layer=LIG $thickness=4.8e-08 $X=0.459
+ $Y=0.178 $X2=0.464 $Y2=0.178
r16 2 15 7.42683 $w=2.2e-08 $layer=Gate_1 $thickness=5.2e-08 $X=0.459 $Y=0.178
+ $X2=0.459 $Y2=0.178
r17 7 61 19.3796 $a=3.24e-16 $layer=V0LISD $X=0.162 $Y=0.216 $X2=0.1655
+ $Y2=0.234
r18 6 57 19.3796 $a=3.24e-16 $layer=V0LISD $X=0.162 $Y=0.054 $X2=0.1655
+ $Y2=0.036
r19 76 77 4.8113 $w=2.22e-08 $l=1.5e-09 $layer=LISD $thickness=2.7e-08
+ $X=0.7235 $Y=0.178 $X2=0.725 $Y2=0.178
r20 75 76 10.8887 $w=2.22e-08 $l=2.15e-08 $layer=LISD $thickness=2.7e-08
+ $X=0.702 $Y=0.178 $X2=0.7235 $Y2=0.178
r21 74 75 13.6742 $w=2.22e-08 $l=2.7e-08 $layer=LISD $thickness=2.7e-08
+ $X=0.675 $Y=0.178 $X2=0.702 $Y2=0.178
r22 73 74 13.6742 $w=2.22e-08 $l=2.7e-08 $layer=LISD $thickness=2.7e-08
+ $X=0.648 $Y=0.178 $X2=0.675 $Y2=0.178
r23 72 73 13.6742 $w=2.22e-08 $l=2.7e-08 $layer=LISD $thickness=2.7e-08
+ $X=0.621 $Y=0.178 $X2=0.648 $Y2=0.178
r24 71 72 13.6742 $w=2.22e-08 $l=2.7e-08 $layer=LISD $thickness=2.7e-08
+ $X=0.594 $Y=0.178 $X2=0.621 $Y2=0.178
r25 70 71 13.6742 $w=2.22e-08 $l=2.7e-08 $layer=LISD $thickness=2.7e-08
+ $X=0.567 $Y=0.178 $X2=0.594 $Y2=0.178
r26 69 70 13.6742 $w=2.22e-08 $l=2.7e-08 $layer=LISD $thickness=2.7e-08 $X=0.54
+ $Y=0.178 $X2=0.567 $Y2=0.178
r27 67 68 10.3823 $w=2.22e-08 $l=1.35e-08 $layer=LISD $thickness=2.7e-08
+ $X=0.4775 $Y=0.178 $X2=0.464 $Y2=0.178
r28 66 69 7.59679 $w=2.22e-08 $l=1.5e-08 $layer=LISD $thickness=2.7e-08
+ $X=0.525 $Y=0.178 $X2=0.54 $Y2=0.178
r29 65 66 6.07743 $w=2.22e-08 $l=1.2e-08 $layer=LISD $thickness=2.7e-08
+ $X=0.513 $Y=0.178 $X2=0.525 $Y2=0.178
r30 8 65 6.07743 $w=2.22e-08 $l=1.2e-08 $layer=LISD $thickness=2.7e-08 $X=0.501
+ $Y=0.178 $X2=0.513 $Y2=0.178
r31 8 67 11.9016 $w=2.22e-08 $l=2.35e-08 $layer=LISD $thickness=2.7e-08
+ $X=0.501 $Y=0.178 $X2=0.4775 $Y2=0.178
r32 61 62 2.3319 $w=1.3e-08 $l=1e-08 $layer=M1 $thickness=3.6e-08 $X=0.1655
+ $Y=0.234 $X2=0.1755 $Y2=0.234
r33 21 54 3.83327 $w=1.5093e-08 $l=2.15e-08 $layer=M1 $thickness=3.6e-08
+ $X=0.189 $Y=0.234 $X2=0.189 $Y2=0.2125
r34 21 62 1.96775 $w=1.63333e-08 $l=1.35e-08 $layer=M1 $thickness=3.6e-08
+ $X=0.189 $Y=0.234 $X2=0.1755 $Y2=0.234
r35 57 58 2.3319 $w=1.3e-08 $l=1e-08 $layer=M1 $thickness=3.6e-08 $X=0.1655
+ $Y=0.036 $X2=0.1755 $Y2=0.036
r36 20 53 3.83327 $w=1.5093e-08 $l=2.15e-08 $layer=M1 $thickness=3.6e-08
+ $X=0.189 $Y=0.036 $X2=0.189 $Y2=0.0575
r37 20 58 1.96775 $w=1.63333e-08 $l=1.35e-08 $layer=M1 $thickness=3.6e-08
+ $X=0.189 $Y=0.036 $X2=0.1755 $Y2=0.036
r38 55 65 19.3796 $a=3.24e-16 $layer=V0LISD $X=0.513 $Y=0.1845 $X2=0.513
+ $Y2=0.178
r39 25 55 3.84763 $w=1.3e-08 $l=1.65e-08 $layer=M1 $thickness=3.6e-08 $X=0.513
+ $Y=0.168 $X2=0.513 $Y2=0.1845
r40 52 53 7.11229 $w=1.3e-08 $l=3.05e-08 $layer=M1 $thickness=3.6e-08 $X=0.189
+ $Y=0.088 $X2=0.189 $Y2=0.0575
r41 51 52 11.3097 $w=1.3e-08 $l=4.85e-08 $layer=M1 $thickness=3.6e-08 $X=0.189
+ $Y=0.1365 $X2=0.189 $Y2=0.088
r42 50 54 3.14806 $w=1.3e-08 $l=1.35e-08 $layer=M1 $thickness=3.6e-08 $X=0.189
+ $Y=0.199 $X2=0.189 $Y2=0.2125
r43 49 50 2.3319 $w=1.3e-08 $l=1e-08 $layer=M1 $thickness=3.6e-08 $X=0.189
+ $Y=0.189 $X2=0.189 $Y2=0.199
r44 23 49 3.61444 $w=1.3e-08 $l=1.55e-08 $layer=M1 $thickness=3.6e-08 $X=0.189
+ $Y=0.1735 $X2=0.189 $Y2=0.189
r45 23 51 8.62802 $w=1.3e-08 $l=3.7e-08 $layer=M1 $thickness=3.6e-08 $X=0.189
+ $Y=0.1735 $X2=0.189 $Y2=0.1365
r46 47 55 19.5347 $a=3.24e-16 $layer=V1 $X=0.513 $Y=0.189 $X2=0.513 $Y2=0.1845
r47 46 47 22.0364 $w=1.3e-08 $l=9.45e-08 $layer=M2 $thickness=3.6e-08 $X=0.4185
+ $Y=0.189 $X2=0.513 $Y2=0.189
r48 45 46 22.0364 $w=1.3e-08 $l=9.45e-08 $layer=M2 $thickness=3.6e-08 $X=0.324
+ $Y=0.189 $X2=0.4185 $Y2=0.189
r49 44 45 15.7403 $w=1.3e-08 $l=6.75e-08 $layer=M2 $thickness=3.6e-08 $X=0.2565
+ $Y=0.189 $X2=0.324 $Y2=0.189
r50 43 44 15.7403 $w=1.3e-08 $l=6.75e-08 $layer=M2 $thickness=3.6e-08 $X=0.189
+ $Y=0.189 $X2=0.2565 $Y2=0.189
r51 43 49 19.5347 $a=3.24e-16 $layer=V1 $X=0.189 $Y=0.189 $X2=0.189 $Y2=0.189
r52 26 43 2.68168 $w=1.3e-08 $l=1.15e-08 $layer=M2 $thickness=3.6e-08 $X=0.1775
+ $Y=0.189 $X2=0.189 $Y2=0.189
r53 41 45 19.5347 $a=3.24e-16 $layer=V1 $X=0.324 $Y=0.189 $X2=0.324 $Y2=0.189
r54 40 41 3.61444 $w=1.3e-08 $l=1.55e-08 $layer=M1 $thickness=3.6e-08 $X=0.324
+ $Y=0.1735 $X2=0.324 $Y2=0.189
r55 24 38 3.60008 $w=1.51951e-08 $l=2.05e-08 $layer=M1 $thickness=3.6e-08
+ $X=0.324 $Y=0.1555 $X2=0.324 $Y2=0.135
r56 24 40 4.19742 $w=1.3e-08 $l=1.8e-08 $layer=M1 $thickness=3.6e-08 $X=0.324
+ $Y=0.1555 $X2=0.324 $Y2=0.1735
r57 22 36 3.14806 $w=1.3e-08 $l=1.35e-08 $layer=M1 $thickness=3.6e-08 $X=0.3375
+ $Y=0.135 $X2=0.351 $Y2=0.135
r58 22 38 1.96775 $w=1.63333e-08 $l=1.35e-08 $layer=M1 $thickness=3.6e-08
+ $X=0.3375 $Y=0.135 $X2=0.324 $Y2=0.135
r59 1 30 6.54019 $w=2.09524e-08 $layer=Gate_1 $thickness=5.21905e-08 $X=0.351
+ $Y=0.135 $X2=0.351 $Y2=0.135
r60 1 36 19.3796 $a=3.24e-16 $layer=V0LIG $X=0.351 $Y=0.135 $X2=0.351 $Y2=0.135
r61 32 31 16.4967 $w=2.1e-08 $l=4.85e-08 $layer=Gate_1 $thickness=5.6e-08
+ $X=0.351 $Y=0.2025 $X2=0.351 $Y2=0.154
r62 30 31 6.6497 $w=2.04211e-08 $l=1.9e-08 $layer=Gate_1 $thickness=5.6e-08
+ $X=0.351 $Y=0.135 $X2=0.351 $Y2=0.154
r63 14 30 21.2756 $w=2.08226e-08 $l=6.2e-08 $layer=Gate_1 $thickness=5.6e-08
+ $X=0.351 $Y=0.073 $X2=0.351 $Y2=0.135
.ends

.subckt PM_DFFHQNx2_ASAP7_75t_R%7 vss 20 24 46 47 51 53 13 17 19 14 16 3 4 1 12
+ 11 10 18
c1 1 vss 0.00225842f $X=0.513 $Y=0.09
c2 3 vss 0.00487439f $X=0.594 $Y=0.0405
c3 4 vss 0.00839322f $X=0.594 $Y=0.2295
c4 10 vss 0.0523423f $X=0.513 $Y=0.0245
c5 11 vss 0.0038443f $X=0.5795 $Y=0.0405
c6 12 vss 0.00363768f $X=0.5795 $Y=0.2295
c7 13 vss 0.0032639f $X=0.65 $Y=0.2295
c8 14 vss 0.000570577f $X=0.594 $Y=0.09
c9 15 vss 0.00263896f $X=0.621 $Y=0.2335
c10 16 vss 0.00237224f $X=0.5 $Y=0.09
c11 17 vss 0.00395464f $X=0.594 $Y=0.234
c12 18 vss 0.00193079f $X=0.594 $Y=0.054
c13 19 vss 0.00142241f $X=0.621 $Y=0.1
r1 53 52 0.0925926 $w=2.7e-08 $l=2.5e-09 $layer=P_src_drn $thickness=1e-09
+ $X=0.6653 $Y=0.2295 $X2=0.6625 $Y2=0.2295
r2 13 52 0.462963 $w=2.7e-08 $l=1.25e-08 $layer=P_src_drn $thickness=1e-09
+ $X=0.65 $Y=0.2295 $X2=0.6625 $Y2=0.2295
r3 12 4 0.462963 $w=2.7e-08 $l=1.25e-08 $layer=P_src_drn $thickness=1e-09
+ $X=0.5795 $Y=0.2295 $X2=0.594 $Y2=0.2295
r4 51 12 0.0925926 $w=2.7e-08 $l=2.5e-09 $layer=P_src_drn $thickness=1e-09
+ $X=0.5766 $Y=0.2295 $X2=0.5795 $Y2=0.2295
r5 48 13 12.6992 $w=2.32e-08 $l=2.7e-08 $layer=LISD $thickness=2.7e-08 $X=0.621
+ $Y=0.2295 $X2=0.65 $Y2=0.2295
r6 4 48 12.6992 $w=2.32e-08 $l=2.7e-08 $layer=LISD $thickness=2.7e-08 $X=0.594
+ $Y=0.2295 $X2=0.621 $Y2=0.2295
r7 4 17 19.3796 $a=3.24e-16 $layer=V0LISD $X=0.594 $Y=0.2295 $X2=0.594 $Y2=0.234
r8 47 45 0.0925926 $w=2.7e-08 $l=2.5e-09 $layer=N_src_drn $thickness=1e-09
+ $X=0.6113 $Y=0.0405 $X2=0.6085 $Y2=0.0405
r9 3 45 0.537037 $w=2.7e-08 $l=1.45e-08 $layer=N_src_drn $thickness=1e-09
+ $X=0.594 $Y=0.0405 $X2=0.6085 $Y2=0.0405
r10 11 3 0.537037 $w=2.7e-08 $l=1.45e-08 $layer=N_src_drn $thickness=1e-09
+ $X=0.5795 $Y=0.0405 $X2=0.594 $Y2=0.0405
r11 46 11 0.0925926 $w=2.7e-08 $l=2.5e-09 $layer=N_src_drn $thickness=1e-09
+ $X=0.5766 $Y=0.0405 $X2=0.5795 $Y2=0.0405
r12 15 40 0.983973 $w=1.77222e-08 $l=9e-09 $layer=M1 $thickness=3.6e-08
+ $X=0.621 $Y=0.2335 $X2=0.621 $Y2=0.2245
r13 15 17 5.06479 $w=1.46038e-08 $l=2.70046e-08 $layer=M1 $thickness=3.6e-08
+ $X=0.621 $Y=0.2335 $X2=0.594 $Y2=0.234
r14 3 18 19.3796 $a=3.24e-16 $layer=V0LISD $X=0.594 $Y=0.0405 $X2=0.594
+ $Y2=0.054
r15 39 40 2.56509 $w=1.3e-08 $l=1.1e-08 $layer=M1 $thickness=3.6e-08 $X=0.621
+ $Y=0.2135 $X2=0.621 $Y2=0.2245
r16 38 39 6.64591 $w=1.3e-08 $l=2.85e-08 $layer=M1 $thickness=3.6e-08 $X=0.621
+ $Y=0.185 $X2=0.621 $Y2=0.2135
r17 37 38 4.43061 $w=1.3e-08 $l=1.9e-08 $layer=M1 $thickness=3.6e-08 $X=0.621
+ $Y=0.166 $X2=0.621 $Y2=0.185
r18 36 37 3.14806 $w=1.3e-08 $l=1.35e-08 $layer=M1 $thickness=3.6e-08 $X=0.621
+ $Y=0.1525 $X2=0.621 $Y2=0.166
r19 35 36 5.01358 $w=1.3e-08 $l=2.15e-08 $layer=M1 $thickness=3.6e-08 $X=0.621
+ $Y=0.131 $X2=0.621 $Y2=0.1525
r20 34 35 4.5472 $w=1.3e-08 $l=1.95e-08 $layer=M1 $thickness=3.6e-08 $X=0.621
+ $Y=0.1115 $X2=0.621 $Y2=0.131
r21 19 32 1.15159 $w=1.75e-08 $l=1e-08 $layer=M1 $thickness=3.6e-08 $X=0.621
+ $Y=0.1 $X2=0.621 $Y2=0.09
r22 19 34 2.68168 $w=1.3e-08 $l=1.15e-08 $layer=M1 $thickness=3.6e-08 $X=0.621
+ $Y=0.1 $X2=0.621 $Y2=0.1115
r23 18 33 4.19742 $w=1.3e-08 $l=1.8e-08 $layer=M1 $thickness=3.6e-08 $X=0.594
+ $Y=0.054 $X2=0.594 $Y2=0.072
r24 31 32 1.96775 $w=1.63333e-08 $l=1.35e-08 $layer=M1 $thickness=3.6e-08
+ $X=0.6075 $Y=0.09 $X2=0.621 $Y2=0.09
r25 14 30 1.96775 $w=1.63333e-08 $l=1.35e-08 $layer=M1 $thickness=3.6e-08
+ $X=0.594 $Y=0.09 $X2=0.5805 $Y2=0.09
r26 14 31 1.96775 $w=1.63333e-08 $l=1.35e-08 $layer=M1 $thickness=3.6e-08
+ $X=0.594 $Y=0.09 $X2=0.6075 $Y2=0.09
r27 14 33 3.01711 $w=1.55e-08 $l=1.8e-08 $layer=M1 $thickness=3.6e-08 $X=0.594
+ $Y=0.09 $X2=0.594 $Y2=0.072
r28 29 30 7.34548 $w=1.3e-08 $l=3.15e-08 $layer=M1 $thickness=3.6e-08 $X=0.549
+ $Y=0.09 $X2=0.5805 $Y2=0.09
r29 28 29 8.39483 $w=1.3e-08 $l=3.6e-08 $layer=M1 $thickness=3.6e-08 $X=0.513
+ $Y=0.09 $X2=0.549 $Y2=0.09
r30 16 28 3.03147 $w=1.3e-08 $l=1.3e-08 $layer=M1 $thickness=3.6e-08 $X=0.5
+ $Y=0.09 $X2=0.513 $Y2=0.09
r31 1 22 6.54019 $w=2.09524e-08 $layer=Gate_1 $thickness=5.21905e-08 $X=0.513
+ $Y=0.09 $X2=0.513 $Y2=0.09
r32 1 28 19.3796 $a=3.24e-16 $layer=V0LIG $X=0.513 $Y=0.09 $X2=0.513 $Y2=0.09
r33 24 23 24.1498 $w=2.1e-08 $l=7.1e-08 $layer=Gate_1 $thickness=5.6e-08
+ $X=0.513 $Y=0.2295 $X2=0.513 $Y2=0.1585
r34 22 23 23.4865 $w=2.08394e-08 $l=6.85e-08 $layer=Gate_1 $thickness=5.6e-08
+ $X=0.513 $Y=0.09 $X2=0.513 $Y2=0.1585
r35 21 22 8.18032 $w=2.05319e-08 $l=2.35e-08 $layer=Gate_1 $thickness=5.6e-08
+ $X=0.513 $Y=0.0665 $X2=0.513 $Y2=0.09
r36 20 21 8.84359 $w=2.1e-08 $l=2.6e-08 $layer=Gate_1 $thickness=5.6e-08
+ $X=0.513 $Y=0.0405 $X2=0.513 $Y2=0.0665
r37 20 10 5.44221 $w=2.1e-08 $l=1.6e-08 $layer=Gate_1 $thickness=5.6e-08
+ $X=0.513 $Y=0.0405 $X2=0.513 $Y2=0.0245
.ends

.subckt PM_DFFHQNx2_ASAP7_75t_R%9 vss 19 23 36 49 9 11 14 18 3 4 1 17 12 15 16
+ 10
c1 1 vss 0.00162205f $X=0.783 $Y=0.1055
c2 3 vss 0.00645413f $X=0.864 $Y=0.0405
c3 4 vss 0.00665606f $X=0.864 $Y=0.2295
c4 9 vss 0.0413459f $X=0.783 $Y=0.0245
c5 10 vss 0.0187887f $X=0.8495 $Y=0.0405
c6 11 vss 0.0187568f $X=0.8495 $Y=0.2295
c7 12 vss 0.00283131f $X=0.783 $Y=0.036
c8 13 vss 0.00319845f $X=0.945 $Y=0.0315
c9 14 vss 0.00318487f $X=0.945 $Y=0.2295
c10 15 vss 0.00228123f $X=0.783 $Y=0.0705
c11 16 vss 0.0138047f $X=0.81 $Y=0.036
c12 17 vss 0.00911087f $X=0.918 $Y=0.234
c13 18 vss 0.00728272f $X=0.945 $Y=0.0495
r1 11 4 0.462963 $w=2.7e-08 $l=1.25e-08 $layer=P_src_drn $thickness=1e-09
+ $X=0.8495 $Y=0.2295 $X2=0.864 $Y2=0.2295
r2 49 11 0.0925926 $w=2.7e-08 $l=2.5e-09 $layer=P_src_drn $thickness=1e-09
+ $X=0.8466 $Y=0.2295 $X2=0.8495 $Y2=0.2295
r3 4 46 19.3796 $a=3.24e-16 $layer=V0LISD $X=0.864 $Y=0.2295 $X2=0.864 $Y2=0.234
r4 46 47 5.24677 $w=1.3e-08 $l=2.25e-08 $layer=M1 $thickness=3.6e-08 $X=0.864
+ $Y=0.234 $X2=0.8865 $Y2=0.234
r5 17 47 7.34548 $w=1.3e-08 $l=3.15e-08 $layer=M1 $thickness=3.6e-08 $X=0.918
+ $Y=0.234 $X2=0.8865 $Y2=0.234
r6 14 43 0.575795 $w=1.75e-08 $l=5e-09 $layer=M1 $thickness=3.6e-08 $X=0.945
+ $Y=0.2295 $X2=0.945 $Y2=0.2245
r7 14 17 4.65662 $w=1.4e-08 $l=2.73724e-08 $layer=M1 $thickness=3.6e-08
+ $X=0.945 $Y=0.2295 $X2=0.918 $Y2=0.234
r8 42 43 1.04935 $w=1.3e-08 $l=4.5e-09 $layer=M1 $thickness=3.6e-08 $X=0.945
+ $Y=0.22 $X2=0.945 $Y2=0.2245
r9 41 42 6.17953 $w=1.3e-08 $l=2.65e-08 $layer=M1 $thickness=3.6e-08 $X=0.945
+ $Y=0.1935 $X2=0.945 $Y2=0.22
r10 40 41 5.71315 $w=1.3e-08 $l=2.45e-08 $layer=M1 $thickness=3.6e-08 $X=0.945
+ $Y=0.169 $X2=0.945 $Y2=0.1935
r11 39 40 6.29612 $w=1.3e-08 $l=2.7e-08 $layer=M1 $thickness=3.6e-08 $X=0.945
+ $Y=0.142 $X2=0.945 $Y2=0.169
r12 38 39 8.97781 $w=1.3e-08 $l=3.85e-08 $layer=M1 $thickness=3.6e-08 $X=0.945
+ $Y=0.1035 $X2=0.945 $Y2=0.142
r13 37 38 7.34548 $w=1.3e-08 $l=3.15e-08 $layer=M1 $thickness=3.6e-08 $X=0.945
+ $Y=0.072 $X2=0.945 $Y2=0.1035
r14 18 34 1.50855 $w=1.55e-08 $l=9e-09 $layer=M1 $thickness=3.6e-08 $X=0.945
+ $Y=0.0495 $X2=0.945 $Y2=0.0405
r15 18 37 5.24677 $w=1.3e-08 $l=2.25e-08 $layer=M1 $thickness=3.6e-08 $X=0.945
+ $Y=0.0495 $X2=0.945 $Y2=0.072
r16 10 3 0.462963 $w=2.7e-08 $l=1.25e-08 $layer=N_src_drn $thickness=1e-09
+ $X=0.8495 $Y=0.0405 $X2=0.864 $Y2=0.0405
r17 36 10 0.0925926 $w=2.7e-08 $l=2.5e-09 $layer=N_src_drn $thickness=1e-09
+ $X=0.8466 $Y=0.0405 $X2=0.8495 $Y2=0.0405
r18 13 33 4.65662 $w=1.4e-08 $l=2.73724e-08 $layer=M1 $thickness=3.6e-08
+ $X=0.945 $Y=0.0315 $X2=0.918 $Y2=0.036
r19 13 34 0.9184 $w=1.8e-08 $l=9e-09 $layer=M1 $thickness=3.6e-08 $X=0.945
+ $Y=0.0315 $X2=0.945 $Y2=0.0405
r20 3 31 19.3796 $a=3.24e-16 $layer=V0LISD $X=0.864 $Y=0.0405 $X2=0.864
+ $Y2=0.036
r21 32 33 6.29612 $w=1.3e-08 $l=2.7e-08 $layer=M1 $thickness=3.6e-08 $X=0.891
+ $Y=0.036 $X2=0.918 $Y2=0.036
r22 31 32 6.29612 $w=1.3e-08 $l=2.7e-08 $layer=M1 $thickness=3.6e-08 $X=0.864
+ $Y=0.036 $X2=0.891 $Y2=0.036
r23 30 31 6.29612 $w=1.3e-08 $l=2.7e-08 $layer=M1 $thickness=3.6e-08 $X=0.837
+ $Y=0.036 $X2=0.864 $Y2=0.036
r24 16 30 6.29612 $w=1.3e-08 $l=2.7e-08 $layer=M1 $thickness=3.6e-08 $X=0.81
+ $Y=0.036 $X2=0.837 $Y2=0.036
r25 12 15 6.39593 $w=1.55565e-08 $l=3.45e-08 $layer=M1 $thickness=3.6e-08
+ $X=0.783 $Y=0.036 $X2=0.783 $Y2=0.0705
r26 12 16 4.64701 $w=1.46667e-08 $l=2.7e-08 $layer=M1 $thickness=3.6e-08
+ $X=0.783 $Y=0.036 $X2=0.81 $Y2=0.036
r27 15 27 8.04505 $w=1.3e-08 $l=3.45e-08 $layer=M1 $thickness=3.6e-08 $X=0.783
+ $Y=0.0705 $X2=0.783 $Y2=0.105
r28 1 21 6.4735 $w=2.13953e-08 $layer=Gate_1 $thickness=5.22791e-08 $X=0.783
+ $Y=0.1055 $X2=0.783 $Y2=0.1055
r29 1 27 19.3796 $a=3.24e-16 $layer=V0LIG $X=0.783 $Y=0.1055 $X2=0.783 $Y2=0.105
r30 23 22 21.4287 $w=2.1e-08 $l=6.3e-08 $layer=Gate_1 $thickness=5.6e-08
+ $X=0.783 $Y=0.2295 $X2=0.783 $Y2=0.1665
r31 21 22 20.944 $w=2.08115e-08 $l=6.1e-08 $layer=Gate_1 $thickness=5.6e-08
+ $X=0.783 $Y=0.1055 $X2=0.783 $Y2=0.1665
r32 20 21 10.9099 $w=2.06349e-08 $l=3.15e-08 $layer=Gate_1 $thickness=5.6e-08
+ $X=0.783 $Y=0.074 $X2=0.783 $Y2=0.1055
r33 19 20 11.3946 $w=2.1e-08 $l=3.35e-08 $layer=Gate_1 $thickness=5.6e-08
+ $X=0.783 $Y=0.0405 $X2=0.783 $Y2=0.074
r34 19 9 5.44221 $w=2.1e-08 $l=1.6e-08 $layer=Gate_1 $thickness=5.6e-08
+ $X=0.783 $Y=0.0405 $X2=0.783 $Y2=0.0245
.ends

.subckt PM_DFFHQNx2_ASAP7_75t_R%QN vss 24 16 17 28 29 2 8 13 1 7
c1 1 vss 0.00853045f $X=1.026 $Y=0.0675
c2 2 vss 0.00840862f $X=1.026 $Y=0.2025
c3 7 vss 0.00454027f $X=1.0115 $Y=0.0675
c4 8 vss 0.0044743f $X=1.0115 $Y=0.2025
c5 9 vss 0.00241665f $X=1.108 $Y=0.045
c6 10 vss 0.00241069f $X=1.108 $Y=0.225
c7 11 vss 0.00689861f $X=1.0145 $Y=0.045
c8 12 vss 0.00708512f $X=1.0145 $Y=0.225
c9 13 vss 0.00748001f $X=1.108 $Y=0.072
r1 29 27 0.0308642 $w=8.1e-08 $l=2.5e-09 $layer=P_src_drn $thickness=1e-09
+ $X=1.0433 $Y=0.2025 $X2=1.0405 $Y2=0.2025
r2 2 27 0.179012 $w=8.1e-08 $l=1.45e-08 $layer=P_src_drn $thickness=1e-09
+ $X=1.026 $Y=0.2025 $X2=1.0405 $Y2=0.2025
r3 8 2 0.179012 $w=8.1e-08 $l=1.45e-08 $layer=P_src_drn $thickness=1e-09
+ $X=1.0115 $Y=0.2025 $X2=1.026 $Y2=0.2025
r4 28 8 0.0308642 $w=8.1e-08 $l=2.5e-09 $layer=P_src_drn $thickness=1e-09
+ $X=1.0086 $Y=0.2025 $X2=1.0115 $Y2=0.2025
r5 2 22 19.3796 $a=3.24e-16 $layer=V0LISD $X=1.026 $Y=0.2025 $X2=1.026 $Y2=0.225
r6 24 25 1.69063 $w=1.3e-08 $l=7.2e-09 $layer=M1 $thickness=3.6e-08 $X=1.085
+ $Y=0.225 $X2=1.0922 $Y2=0.225
r7 24 23 5.88804 $w=1.3e-08 $l=2.53e-08 $layer=M1 $thickness=3.6e-08 $X=1.085
+ $Y=0.225 $X2=1.0597 $Y2=0.225
r8 22 23 7.87015 $w=1.3e-08 $l=3.37e-08 $layer=M1 $thickness=3.6e-08 $X=1.026
+ $Y=0.225 $X2=1.0597 $Y2=0.225
r9 12 22 2.68168 $w=1.3e-08 $l=1.15e-08 $layer=M1 $thickness=3.6e-08 $X=1.0145
+ $Y=0.225 $X2=1.026 $Y2=0.225
r10 10 21 6.16274 $w=1.56328e-08 $l=3.35e-08 $layer=M1 $thickness=3.6e-08
+ $X=1.108 $Y=0.225 $X2=1.108 $Y2=0.1915
r11 10 25 2.02363 $w=1.58571e-08 $l=1.58e-08 $layer=M1 $thickness=3.6e-08
+ $X=1.108 $Y=0.225 $X2=1.0922 $Y2=0.225
r12 20 21 14.691 $w=1.3e-08 $l=6.3e-08 $layer=M1 $thickness=3.6e-08 $X=1.108
+ $Y=0.1285 $X2=1.108 $Y2=0.1915
r13 13 20 13.1752 $w=1.3e-08 $l=5.65e-08 $layer=M1 $thickness=3.6e-08 $X=1.108
+ $Y=0.072 $X2=1.108 $Y2=0.1285
r14 9 19 7.91167 $w=1.40976e-08 $l=4.1e-08 $layer=M1 $thickness=3.6e-08
+ $X=1.108 $Y=0.045 $X2=1.067 $Y2=0.045
r15 9 13 4.64701 $w=1.62667e-08 $l=2.7e-08 $layer=M1 $thickness=3.6e-08
+ $X=1.108 $Y=0.045 $X2=1.108 $Y2=0.072
r16 18 19 9.56078 $w=1.3e-08 $l=4.1e-08 $layer=M1 $thickness=3.6e-08 $X=1.026
+ $Y=0.045 $X2=1.067 $Y2=0.045
r17 11 18 2.68168 $w=1.3e-08 $l=1.15e-08 $layer=M1 $thickness=3.6e-08 $X=1.0145
+ $Y=0.045 $X2=1.026 $Y2=0.045
r18 1 18 19.3796 $a=3.24e-16 $layer=V0LISD $X=1.026 $Y=0.0675 $X2=1.026
+ $Y2=0.045
r19 17 15 0.0308642 $w=8.1e-08 $l=2.5e-09 $layer=N_src_drn $thickness=1e-09
+ $X=1.0433 $Y=0.0675 $X2=1.0405 $Y2=0.0675
r20 1 15 0.179012 $w=8.1e-08 $l=1.45e-08 $layer=N_src_drn $thickness=1e-09
+ $X=1.026 $Y=0.0675 $X2=1.0405 $Y2=0.0675
r21 7 1 0.179012 $w=8.1e-08 $l=1.45e-08 $layer=N_src_drn $thickness=1e-09
+ $X=1.0115 $Y=0.0675 $X2=1.026 $Y2=0.0675
r22 16 7 0.0308642 $w=8.1e-08 $l=2.5e-09 $layer=N_src_drn $thickness=1e-09
+ $X=1.0086 $Y=0.0675 $X2=1.0115 $Y2=0.0675
.ends

.subckt PM_DFFHQNx2_ASAP7_75t_R%14 vss 7 12 4 1 5
c1 1 vss 0.00632302f $X=0.702 $Y=0.0405
c2 4 vss 0.00175236f $X=0.6875 $Y=0.0405
c3 5 vss 0.00217527f $X=0.758 $Y=0.0405
r1 12 11 0.0925926 $w=2.7e-08 $l=2.5e-09 $layer=N_src_drn $thickness=1e-09
+ $X=0.7733 $Y=0.0405 $X2=0.7705 $Y2=0.0405
r2 5 11 0.462963 $w=2.7e-08 $l=1.25e-08 $layer=N_src_drn $thickness=1e-09
+ $X=0.758 $Y=0.0405 $X2=0.7705 $Y2=0.0405
r3 9 5 8.23096 $w=2.32e-08 $l=1.75e-08 $layer=LISD $thickness=2.7e-08 $X=0.7385
+ $Y=0.0405 $X2=0.758 $Y2=0.0405
r4 8 9 7.05511 $w=2.32e-08 $l=1.5e-08 $layer=LISD $thickness=2.7e-08 $X=0.7235
+ $Y=0.0405 $X2=0.7385 $Y2=0.0405
r5 1 8 10.1123 $w=2.32e-08 $l=2.15e-08 $layer=LISD $thickness=2.7e-08 $X=0.702
+ $Y=0.0405 $X2=0.7235 $Y2=0.0405
r6 4 1 0.462963 $w=2.7e-08 $l=1.25e-08 $layer=N_src_drn $thickness=1e-09
+ $X=0.6875 $Y=0.0405 $X2=0.702 $Y2=0.0405
r7 7 4 0.0925926 $w=2.7e-08 $l=2.5e-09 $layer=N_src_drn $thickness=1e-09
+ $X=0.6846 $Y=0.0405 $X2=0.6875 $Y2=0.0405
.ends

.subckt PM_DFFHQNx2_ASAP7_75t_R%10 vss 32 38 77 78 81 85 89 93 97 98 5 24 6 15
+ 14 16 18 22 23 21 2 19 28 11 20 26 1 17 25 27 29 12 13
c1 1 vss 0.00173128f $X=0.837 $Y=0.135
c2 2 vss 0.00911205f $X=0.9895 $Y=0.136
c3 5 vss 0.00469763f $X=0.648 $Y=0.0405
c4 6 vss 0.00451694f $X=0.702 $Y=0.2295
c5 11 vss 0.053354f $X=0.837 $Y=0.0245
c6 12 vss 0.0868614f $X=0.999 $Y=0.136
c7 13 vss 0.0863679f $X=1.053 $Y=0.136
c8 14 vss 0.00395849f $X=0.6335 $Y=0.0405
c9 15 vss 0.00413631f $X=0.6875 $Y=0.2295
c10 16 vss 0.00605949f $X=0.729 $Y=0.233
c11 17 vss 0.00265073f $X=0.729 $Y=0.036
c12 18 vss 0.000172309f $X=0.729 $Y=0.16
c13 19 vss 0.000304292f $X=0.837 $Y=0.162
c14 20 vss 0.00116254f $X=0.891 $Y=0.1575
c15 21 vss 0.00842546f $X=0.704 $Y=0.036
c16 22 vss 0.0018361f $X=0.729 $Y=0.136
c17 23 vss 0.00166004f $X=0.729 $Y=0.1975
c18 24 vss 0.00235005f $X=0.81 $Y=0.162
c19 25 vss 0.000797827f $X=0.837 $Y=0.118
c20 26 vss 0.000749807f $X=0.848 $Y=0.162
c21 27 vss 0.00114399f $X=0.891 $Y=0.1305
c22 28 vss 0.00363354f $X=0.999 $Y=0.1085
c23 29 vss 0.00889696f $X=0.8795 $Y=0.153
r1 98 96 0.0925926 $w=2.7e-08 $l=2.5e-09 $layer=N_src_drn $thickness=1e-09
+ $X=0.6653 $Y=0.0405 $X2=0.6625 $Y2=0.0405
r2 5 96 0.537037 $w=2.7e-08 $l=1.45e-08 $layer=N_src_drn $thickness=1e-09
+ $X=0.648 $Y=0.0405 $X2=0.6625 $Y2=0.0405
r3 14 5 0.537037 $w=2.7e-08 $l=1.45e-08 $layer=N_src_drn $thickness=1e-09
+ $X=0.6335 $Y=0.0405 $X2=0.648 $Y2=0.0405
r4 97 14 0.0925926 $w=2.7e-08 $l=2.5e-09 $layer=N_src_drn $thickness=1e-09
+ $X=0.6306 $Y=0.0405 $X2=0.6335 $Y2=0.0405
r5 93 92 14.6259 $w=2.1e-08 $l=4.3e-08 $layer=Gate_1 $thickness=5.6e-08
+ $X=1.053 $Y=0.2025 $X2=1.053 $Y2=0.1595
r6 91 92 2.55104 $w=2.1e-08 $l=7.5e-09 $layer=Gate_1 $thickness=5.6e-08
+ $X=1.053 $Y=0.152 $X2=1.053 $Y2=0.1595
r7 89 90 14.6259 $w=2.1e-08 $l=4.3e-08 $layer=Gate_1 $thickness=5.6e-08
+ $X=1.053 $Y=0.0675 $X2=1.053 $Y2=0.1105
r8 87 90 2.89117 $w=2.1e-08 $l=8.5e-09 $layer=Gate_1 $thickness=5.6e-08
+ $X=1.053 $Y=0.119 $X2=1.053 $Y2=0.1105
r9 13 71 6.54019 $w=2.09524e-08 $layer=Gate_1 $thickness=5.21905e-08 $X=1.053
+ $Y=0.136 $X2=1.053 $Y2=0.136
r10 13 87 5.96942 $w=2.03529e-08 $l=1.7e-08 $layer=Gate_1 $thickness=5.6e-08
+ $X=1.053 $Y=0.136 $X2=1.053 $Y2=0.119
r11 13 91 5.62929 $w=2.03125e-08 $l=1.6e-08 $layer=Gate_1 $thickness=5.6e-08
+ $X=1.053 $Y=0.136 $X2=1.053 $Y2=0.152
r12 85 84 14.6259 $w=2.1e-08 $l=4.3e-08 $layer=Gate_1 $thickness=5.6e-08
+ $X=0.999 $Y=0.2025 $X2=0.999 $Y2=0.1595
r13 83 84 2.55104 $w=2.1e-08 $l=7.5e-09 $layer=Gate_1 $thickness=5.6e-08
+ $X=0.999 $Y=0.152 $X2=0.999 $Y2=0.1595
r14 81 82 14.6259 $w=2.1e-08 $l=4.3e-08 $layer=Gate_1 $thickness=5.6e-08
+ $X=0.999 $Y=0.0675 $X2=0.999 $Y2=0.1105
r15 79 82 2.89117 $w=2.1e-08 $l=8.5e-09 $layer=Gate_1 $thickness=5.6e-08
+ $X=0.999 $Y=0.119 $X2=0.999 $Y2=0.1105
r16 12 67 6.27904 $w=2.09e-08 $layer=Gate_1 $thickness=5.24e-08 $X=0.999
+ $Y=0.136 $X2=0.999 $Y2=0.136
r17 12 79 5.96942 $w=2.03529e-08 $l=1.7e-08 $layer=Gate_1 $thickness=5.6e-08
+ $X=0.999 $Y=0.136 $X2=0.999 $Y2=0.119
r18 12 83 5.62929 $w=2.03125e-08 $l=1.6e-08 $layer=Gate_1 $thickness=5.6e-08
+ $X=0.999 $Y=0.136 $X2=0.999 $Y2=0.152
r19 78 76 0.0925926 $w=2.7e-08 $l=2.5e-09 $layer=P_src_drn $thickness=1e-09
+ $X=0.7193 $Y=0.2295 $X2=0.7165 $Y2=0.2295
r20 6 76 0.537037 $w=2.7e-08 $l=1.45e-08 $layer=P_src_drn $thickness=1e-09
+ $X=0.702 $Y=0.2295 $X2=0.7165 $Y2=0.2295
r21 15 6 0.537037 $w=2.7e-08 $l=1.45e-08 $layer=P_src_drn $thickness=1e-09
+ $X=0.6875 $Y=0.2295 $X2=0.702 $Y2=0.2295
r22 77 15 0.0925926 $w=2.7e-08 $l=2.5e-09 $layer=P_src_drn $thickness=1e-09
+ $X=0.6846 $Y=0.2295 $X2=0.6875 $Y2=0.2295
r23 5 65 19.3796 $a=3.24e-16 $layer=V0LISD $X=0.648 $Y=0.0405 $X2=0.648
+ $Y2=0.036
r24 70 71 12.6539 $w=1.77815e-08 $l=2.7e-08 $layer=LIG $thickness=4.8e-08
+ $X=1.026 $Y=0.136 $X2=1.053 $Y2=0.136
r25 68 70 10.1729 $w=1.54914e-08 $l=1.75e-08 $layer=LIG $thickness=4.8e-08
+ $X=1.0085 $Y=0.136 $X2=1.026 $Y2=0.136
r26 67 68 2.48102 $w=2.2e-08 $l=9.5e-09 $layer=LIG $thickness=4.8e-08 $X=0.999
+ $Y=0.136 $X2=1.0085 $Y2=0.136
r27 2 67 2.48102 $w=2.2e-08 $l=9.5e-09 $layer=LIG $thickness=4.8e-08 $X=0.9895
+ $Y=0.136 $X2=0.999 $Y2=0.136
r28 6 58 19.3796 $a=3.24e-16 $layer=V0LISD $X=0.702 $Y=0.2295 $X2=0.702
+ $Y2=0.233
r29 65 66 3.14806 $w=1.3e-08 $l=1.35e-08 $layer=M1 $thickness=3.6e-08 $X=0.648
+ $Y=0.036 $X2=0.6615 $Y2=0.036
r30 63 66 3.14806 $w=1.3e-08 $l=1.35e-08 $layer=M1 $thickness=3.6e-08 $X=0.675
+ $Y=0.036 $X2=0.6615 $Y2=0.036
r31 62 63 2.56509 $w=1.3e-08 $l=1.1e-08 $layer=M1 $thickness=3.6e-08 $X=0.686
+ $Y=0.036 $X2=0.675 $Y2=0.036
r32 21 62 4.19742 $w=1.3e-08 $l=1.8e-08 $layer=M1 $thickness=3.6e-08 $X=0.704
+ $Y=0.036 $X2=0.686 $Y2=0.036
r33 60 67 19.3796 $a=3.24e-16 $layer=V0LIG $X=0.999 $Y=0.1445 $X2=0.999
+ $Y2=0.136
r34 28 60 8.39483 $w=1.3e-08 $l=3.6e-08 $layer=M1 $thickness=3.6e-08 $X=0.999
+ $Y=0.1085 $X2=0.999 $Y2=0.1445
r35 58 59 3.14806 $w=1.3e-08 $l=1.35e-08 $layer=M1 $thickness=3.6e-08 $X=0.702
+ $Y=0.233 $X2=0.7155 $Y2=0.233
r36 16 23 7.09793 $w=1.42676e-08 $l=3.55e-08 $layer=M1 $thickness=3.6e-08
+ $X=0.729 $Y=0.233 $X2=0.729 $Y2=0.1975
r37 16 59 1.96775 $w=1.63333e-08 $l=1.35e-08 $layer=M1 $thickness=3.6e-08
+ $X=0.729 $Y=0.233 $X2=0.7155 $Y2=0.233
r38 17 51 4.64701 $w=1.62667e-08 $l=2.7e-08 $layer=M1 $thickness=3.6e-08
+ $X=0.729 $Y=0.036 $X2=0.729 $Y2=0.063
r39 17 21 4.18063 $w=1.48e-08 $l=2.5e-08 $layer=M1 $thickness=3.6e-08 $X=0.729
+ $Y=0.036 $X2=0.704 $Y2=0.036
r40 55 60 19.5347 $a=3.24e-16 $layer=V1 $X=0.999 $Y=0.153 $X2=0.999 $Y2=0.1445
r41 54 55 12.5922 $w=1.3e-08 $l=5.4e-08 $layer=M2 $thickness=3.6e-08 $X=0.945
+ $Y=0.153 $X2=0.999 $Y2=0.153
r42 53 54 12.5922 $w=1.3e-08 $l=5.4e-08 $layer=M2 $thickness=3.6e-08 $X=0.891
+ $Y=0.153 $X2=0.945 $Y2=0.153
r43 29 53 2.68168 $w=1.3e-08 $l=1.15e-08 $layer=M2 $thickness=3.6e-08 $X=0.8795
+ $Y=0.153 $X2=0.891 $Y2=0.153
r44 52 53 39.0693 $a=1.62e-16 $layer=V1 $X=0.891 $Y=0.1485 $X2=0.891 $Y2=0.153
r45 27 52 4.19742 $w=1.3e-08 $l=1.8e-08 $layer=M1 $thickness=3.6e-08 $X=0.891
+ $Y=0.1305 $X2=0.891 $Y2=0.1485
r46 23 46 6.38362 $w=1.33509e-08 $l=2.85e-08 $layer=M1 $thickness=3.6e-08
+ $X=0.729 $Y=0.1975 $X2=0.729 $Y2=0.169
r47 50 51 6.29612 $w=1.3e-08 $l=2.7e-08 $layer=M1 $thickness=3.6e-08 $X=0.729
+ $Y=0.09 $X2=0.729 $Y2=0.063
r48 49 50 2.3319 $w=1.3e-08 $l=1e-08 $layer=M1 $thickness=3.6e-08 $X=0.729
+ $Y=0.1 $X2=0.729 $Y2=0.09
r49 48 49 2.3319 $w=1.3e-08 $l=1e-08 $layer=M1 $thickness=3.6e-08 $X=0.729
+ $Y=0.11 $X2=0.729 $Y2=0.1
r50 22 48 6.06293 $w=1.3e-08 $l=2.6e-08 $layer=M1 $thickness=3.6e-08 $X=0.729
+ $Y=0.136 $X2=0.729 $Y2=0.11
r51 20 47 0.9184 $w=1.8e-08 $l=9e-09 $layer=M1 $thickness=3.6e-08 $X=0.891
+ $Y=0.1575 $X2=0.891 $Y2=0.1665
r52 20 52 1.50855 $w=1.55e-08 $l=9e-09 $layer=M1 $thickness=3.6e-08 $X=0.891
+ $Y=0.1575 $X2=0.891 $Y2=0.1485
r53 20 53 39.0693 $a=1.62e-16 $layer=V1 $X=0.891 $Y=0.1575 $X2=0.891 $Y2=0.153
r54 18 46 0.9184 $w=1.8e-08 $l=9e-09 $layer=M1 $thickness=3.6e-08 $X=0.729
+ $Y=0.16 $X2=0.729 $Y2=0.169
r55 18 22 4.67854 $w=1.44583e-08 $l=2.4e-08 $layer=M1 $thickness=3.6e-08
+ $X=0.729 $Y=0.16 $X2=0.729 $Y2=0.136
r56 45 47 4.19024 $w=1.156e-08 $l=2.54018e-08 $layer=M1 $thickness=3.6e-08
+ $X=0.866 $Y=0.162 $X2=0.891 $Y2=0.1665
r57 26 45 4.19742 $w=1.3e-08 $l=1.8e-08 $layer=M1 $thickness=3.6e-08 $X=0.848
+ $Y=0.162 $X2=0.866 $Y2=0.162
r58 44 46 4.4015 $w=1.35e-08 $l=2.78927e-08 $layer=M1 $thickness=3.6e-08
+ $X=0.756 $Y=0.162 $X2=0.729 $Y2=0.169
r59 43 44 6.29612 $w=1.3e-08 $l=2.7e-08 $layer=M1 $thickness=3.6e-08 $X=0.783
+ $Y=0.162 $X2=0.756 $Y2=0.162
r60 24 43 6.29612 $w=1.3e-08 $l=2.7e-08 $layer=M1 $thickness=3.6e-08 $X=0.81
+ $Y=0.162 $X2=0.783 $Y2=0.162
r61 19 42 4.88263 $w=1.47308e-08 $l=2.6e-08 $layer=M1 $thickness=3.6e-08
+ $X=0.837 $Y=0.162 $X2=0.837 $Y2=0.136
r62 19 24 5.11582 $w=1.46667e-08 $l=2.7e-08 $layer=M1 $thickness=3.6e-08
+ $X=0.837 $Y=0.162 $X2=0.81 $Y2=0.162
r63 19 26 1.38478 $w=1.70909e-08 $l=1.1e-08 $layer=M1 $thickness=3.6e-08
+ $X=0.837 $Y=0.162 $X2=0.848 $Y2=0.162
r64 25 42 4.19742 $w=1.3e-08 $l=1.8e-08 $layer=M1 $thickness=3.6e-08 $X=0.837
+ $Y=0.118 $X2=0.837 $Y2=0.136
r65 1 35 6.54019 $w=2.09524e-08 $layer=Gate_1 $thickness=5.21905e-08 $X=0.837
+ $Y=0.135 $X2=0.837 $Y2=0.135
r66 1 42 19.3796 $a=3.24e-16 $layer=V0LIG $X=0.837 $Y=0.135 $X2=0.837 $Y2=0.136
r67 38 37 14.6259 $w=2.1e-08 $l=4.3e-08 $layer=Gate_1 $thickness=5.6e-08
+ $X=0.837 $Y=0.2295 $X2=0.837 $Y2=0.1865
r68 36 37 11.9048 $w=2.1e-08 $l=3.5e-08 $layer=Gate_1 $thickness=5.6e-08
+ $X=0.837 $Y=0.1515 $X2=0.837 $Y2=0.1865
r69 35 36 5.79936 $w=2.03333e-08 $l=1.65e-08 $layer=Gate_1 $thickness=5.6e-08
+ $X=0.837 $Y=0.135 $X2=0.837 $Y2=0.1515
r70 34 35 5.79936 $w=2.03333e-08 $l=1.65e-08 $layer=Gate_1 $thickness=5.6e-08
+ $X=0.837 $Y=0.1185 $X2=0.837 $Y2=0.135
r71 33 34 11.9048 $w=2.1e-08 $l=3.5e-08 $layer=Gate_1 $thickness=5.6e-08
+ $X=0.837 $Y=0.0835 $X2=0.837 $Y2=0.1185
r72 32 33 14.6259 $w=2.1e-08 $l=4.3e-08 $layer=Gate_1 $thickness=5.6e-08
+ $X=0.837 $Y=0.0405 $X2=0.837 $Y2=0.0835
r73 32 11 5.44221 $w=2.1e-08 $l=1.6e-08 $layer=Gate_1 $thickness=5.6e-08
+ $X=0.837 $Y=0.0405 $X2=0.837 $Y2=0.0245
.ends

.subckt PM_DFFHQNx2_ASAP7_75t_R%13 vss 7 12 4 1 5
c1 1 vss 0.00582471f $X=0.432 $Y=0.2295
c2 4 vss 0.00166157f $X=0.4175 $Y=0.2295
c3 5 vss 0.00204761f $X=0.488 $Y=0.2295
r1 12 11 0.0925926 $w=2.7e-08 $l=2.5e-09 $layer=P_src_drn $thickness=1e-09
+ $X=0.5033 $Y=0.2295 $X2=0.5005 $Y2=0.2295
r2 5 11 0.462963 $w=2.7e-08 $l=1.25e-08 $layer=P_src_drn $thickness=1e-09
+ $X=0.488 $Y=0.2295 $X2=0.5005 $Y2=0.2295
r3 9 5 9.64198 $w=2.32e-08 $l=2.05e-08 $layer=LISD $thickness=2.7e-08 $X=0.4655
+ $Y=0.2295 $X2=0.488 $Y2=0.2295
r4 8 9 7.05511 $w=2.32e-08 $l=1.5e-08 $layer=LISD $thickness=2.7e-08 $X=0.4505
+ $Y=0.2295 $X2=0.4655 $Y2=0.2295
r5 1 8 8.7013 $w=2.32e-08 $l=1.85e-08 $layer=LISD $thickness=2.7e-08 $X=0.432
+ $Y=0.2295 $X2=0.4505 $Y2=0.2295
r6 4 1 0.462963 $w=2.7e-08 $l=1.25e-08 $layer=P_src_drn $thickness=1e-09
+ $X=0.4175 $Y=0.2295 $X2=0.432 $Y2=0.2295
r7 7 4 0.0925926 $w=2.7e-08 $l=2.5e-09 $layer=P_src_drn $thickness=1e-09
+ $X=0.4146 $Y=0.2295 $X2=0.4175 $Y2=0.2295
.ends

.subckt PM_DFFHQNx2_ASAP7_75t_R%D vss 25 10 16 8 3 9 6 1 7 5
c1 1 vss 0.00929323f $X=0.2885 $Y=0.135
c2 3 vss 0.0907477f $X=0.297 $Y=0.0245
c3 4 vss 0.00669016f $X=0.243 $Y=0.036
c4 5 vss 0.000459865f $X=0.243 $Y=0.135
c5 6 vss 0.00644942f $X=0.243 $Y=0.234
c6 7 vss 0.00404821f $X=0.243 $Y=0.116
c7 8 vss 0.00298378f $X=0.243 $Y=0.1735
c8 9 vss 0.000927362f $X=0.2615 $Y=0.135
r1 6 27 3.48349 $w=1.525e-08 $l=2e-08 $layer=M1 $thickness=3.6e-08 $X=0.243
+ $Y=0.234 $X2=0.243 $Y2=0.214
r2 4 24 5.17411 $w=1.46514e-08 $l=2.72e-08 $layer=M1 $thickness=3.6e-08
+ $X=0.243 $Y=0.036 $X2=0.243 $Y2=0.0632
r3 8 27 9.44419 $w=1.3e-08 $l=4.05e-08 $layer=M1 $thickness=3.6e-08 $X=0.243
+ $Y=0.1735 $X2=0.243 $Y2=0.214
r4 25 26 2.85657 $w=1.3e-08 $l=1.22e-08 $layer=M1 $thickness=3.6e-08 $X=0.244
+ $Y=0.082 $X2=0.243 $Y2=0.0942
r5 25 24 4.37231 $w=1.3e-08 $l=1.88e-08 $layer=M1 $thickness=3.6e-08 $X=0.244
+ $Y=0.082 $X2=0.243 $Y2=0.0632
r6 7 26 5.07188 $w=1.3e-08 $l=2.18e-08 $layer=M1 $thickness=3.6e-08 $X=0.243
+ $Y=0.116 $X2=0.243 $Y2=0.0942
r7 5 9 3.1337 $w=1.54324e-08 $l=1.85e-08 $layer=M1 $thickness=3.6e-08 $X=0.243
+ $Y=0.135 $X2=0.2615 $Y2=0.135
r8 5 7 3.2503 $w=1.53684e-08 $l=1.9e-08 $layer=M1 $thickness=3.6e-08 $X=0.243
+ $Y=0.135 $X2=0.243 $Y2=0.116
r9 5 8 7.7975 $w=1.41688e-08 $l=3.85e-08 $layer=M1 $thickness=3.6e-08 $X=0.243
+ $Y=0.135 $X2=0.243 $Y2=0.1735
r10 22 23 2.2153 $w=1.3e-08 $l=9.5e-09 $layer=M1 $thickness=3.6e-08 $X=0.2715
+ $Y=0.135 $X2=0.281 $Y2=0.135
r11 9 22 2.3319 $w=1.3e-08 $l=1e-08 $layer=M1 $thickness=3.6e-08 $X=0.2615
+ $Y=0.135 $X2=0.2715 $Y2=0.135
r12 20 23 19.3796 $a=3.24e-16 $layer=V0LIG $X=0.2795 $Y=0.135 $X2=0.281
+ $Y2=0.135
r13 1 18 2.6116 $w=2.2e-08 $l=1e-08 $layer=LIG $thickness=4.8e-08 $X=0.2885
+ $Y=0.135 $X2=0.2985 $Y2=0.135
r14 1 20 4.82216 $w=1.64167e-08 $l=9e-09 $layer=LIG $thickness=4.8e-08
+ $X=0.2885 $Y=0.135 $X2=0.2795 $Y2=0.135
r15 16 15 14.6259 $w=2.1e-08 $l=4.3e-08 $layer=Gate_1 $thickness=5.6e-08
+ $X=0.297 $Y=0.2025 $X2=0.297 $Y2=0.1595
r16 14 15 2.7211 $w=2.1e-08 $l=8e-09 $layer=Gate_1 $thickness=5.6e-08 $X=0.297
+ $Y=0.1515 $X2=0.297 $Y2=0.1595
r17 13 14 5.79936 $w=2.03333e-08 $l=1.65e-08 $layer=Gate_1 $thickness=5.6e-08
+ $X=0.297 $Y=0.135 $X2=0.297 $Y2=0.1515
r18 13 18 6.14846 $w=2.08718e-08 $l=1.5e-09 $layer=Gate_1
+ $thickness=5.25128e-08 $X=0.297 $Y=0.135 $X2=0.2985 $Y2=0.135
r19 12 13 5.79936 $w=2.03333e-08 $l=1.65e-08 $layer=Gate_1 $thickness=5.6e-08
+ $X=0.297 $Y=0.1185 $X2=0.297 $Y2=0.135
r20 11 12 2.7211 $w=2.1e-08 $l=8e-09 $layer=Gate_1 $thickness=5.6e-08 $X=0.297
+ $Y=0.1105 $X2=0.297 $Y2=0.1185
r21 10 11 14.6259 $w=2.1e-08 $l=4.3e-08 $layer=Gate_1 $thickness=5.6e-08
+ $X=0.297 $Y=0.0675 $X2=0.297 $Y2=0.1105
r22 10 3 14.6259 $w=2.1e-08 $l=4.3e-08 $layer=Gate_1 $thickness=5.6e-08
+ $X=0.297 $Y=0.0675 $X2=0.297 $Y2=0.0245
.ends

* End of included file DFFHQNx2_ASAP7_75t_R.pex.sp.pex

*
.subckt DFFHQNx2_ASAP7_75t_CUSTOM_4_25_0_7 VSS VDD CLK D QN
*
* VSS VSS
* VDD VDD
* CLK CLK
* D D
* QN QN
*
*

M0 VSS N_M0_g N_M0_s VSS nmos_rvt L=2e-08 W=5.4e-08 nfin=2 $X=0.071 $Y=0.027
M1 N_M1_d N_M1_g VSS VSS nmos_rvt L=2e-08 W=5.4e-08 nfin=2 $X=0.125 $Y=0.027
M2 N_M2_d N_M2_g VSS VSS nmos_rvt L=2e-08 W=8.1e-08 nfin=3 $X=0.287 $Y=0.027
M3 N_M3_d N_M3_g N_M3_s VSS nmos_rvt L=2e-08 W=8.1e-08 nfin=3 $X=0.395 $Y=0.027
M4 N_M4_d N_M4_g N_M4_s VSS nmos_rvt L=2e-08 W=2.7e-08 nfin=1 $X=0.449 $Y=0.027
M5 VSS N_M5_g N_M5_s VSS nmos_rvt L=2e-08 W=2.7e-08 nfin=1 $X=0.503 $Y=0.027
M6 N_M6_d N_M6_g VSS VSS nmos_rvt L=2e-08 W=2.7e-08 nfin=1 $X=0.557 $Y=0.027
M7 N_M7_d N_M7_g N_M7_s VSS nmos_rvt L=2e-08 W=2.7e-08 nfin=1 $X=0.611 $Y=0.027
M8 N_M8_d N_M8_g N_M8_s VSS nmos_rvt L=2e-08 W=2.7e-08 nfin=1 $X=0.665 $Y=0.027
M9 VSS N_M9_g N_M9_s VSS nmos_rvt L=2e-08 W=2.7e-08 nfin=1 $X=0.773 $Y=0.027
M10 N_M10_d N_M10_g VSS VSS nmos_rvt L=2e-08 W=2.7e-08 nfin=1 $X=0.827 $Y=0.027
M11 N_M11_d N_M11_g VSS VSS nmos_rvt L=2e-08 W=8.1e-08 nfin=3 $X=0.989 $Y=0.027
M12 N_M12_d N_M12_g VSS VSS nmos_rvt L=2e-08 W=8.1e-08 nfin=3 $X=1.043 $Y=0.027
M13 VDD N_M13_g N_M13_s VDD pmos_rvt L=2e-08 W=5.4e-08 nfin=2 $X=0.071 $Y=0.189
M14 N_M14_d N_M14_g VDD VDD pmos_rvt L=2e-08 W=5.4e-08 nfin=2 $X=0.125 $Y=0.189
M15 N_M15_d N_M15_g VDD VDD pmos_rvt L=2e-08 W=8.1e-08 nfin=3 $X=0.287 $Y=0.162
M16 N_M16_d N_M16_g N_M16_s VDD pmos_rvt L=2e-08 W=8.1e-08 nfin=3 $X=0.341
+ $Y=0.162
M17 N_M17_d N_M17_g N_M17_s VDD pmos_rvt L=2e-08 W=2.7e-08 nfin=1 $X=0.395
+ $Y=0.216
M18 VDD N_M18_g N_M18_s VDD pmos_rvt L=2e-08 W=2.7e-08 nfin=1 $X=0.503 $Y=0.216
M19 N_M19_d N_M19_g VDD VDD pmos_rvt L=2e-08 W=2.7e-08 nfin=1 $X=0.557 $Y=0.216
M20 N_M20_d N_M20_g N_M20_s VDD pmos_rvt L=2e-08 W=2.7e-08 nfin=1 $X=0.665
+ $Y=0.216
M21 N_M21_d N_M21_g N_M21_s VDD pmos_rvt L=2e-08 W=2.7e-08 nfin=1 $X=0.719
+ $Y=0.216
M22 VDD N_M22_g N_M22_s VDD pmos_rvt L=2e-08 W=2.7e-08 nfin=1 $X=0.773 $Y=0.216
M23 N_M23_d N_M23_g VDD VDD pmos_rvt L=2e-08 W=2.7e-08 nfin=1 $X=0.827 $Y=0.216
M24 N_M24_d N_M24_g VDD VDD pmos_rvt L=2e-08 W=8.1e-08 nfin=3 $X=0.989 $Y=0.162
M25 N_M25_d N_M25_g VDD VDD pmos_rvt L=2e-08 W=8.1e-08 nfin=3 $X=1.043 $Y=0.162

* .include "DFFHQNx2_ASAP7_75t_R.pex.sp.pxi"

* Start of included file DFFHQNx2_ASAP7_75t_R.pex.sp.pxi
x_PM_DFFHQNx2_ASAP7_75t_R%12 vss N_M2_d N_M3_s N_12_5 N_12_4 N_12_1
+ PM_DFFHQNx2_ASAP7_75t_R%12
cc_1 N_12_5 N_4_26 0.000268718f $X=0.38 $Y=0.0675
cc_2 N_12_5 N_4_2 0.000663959f $X=0.38 $Y=0.0675
cc_3 N_12_5 N_4_14 0.0343108f $X=0.38 $Y=0.0675
cc_4 N_12_4 N_D_3 0.0346448f $X=0.3095 $Y=0.0675
cc_5 N_12_4 N_6_22 0.000355756f $X=0.3095 $Y=0.0675
cc_6 N_12_4 N_6_1 0.00191679f $X=0.3095 $Y=0.0675
cc_7 N_12_4 N_6_14 0.0727034f $X=0.3095 $Y=0.0675
cc_8 N_12_1 N_8_11 0.000581865f $X=0.351 $Y=0.0675
cc_9 N_12_1 N_8_4 0.00106878f $X=0.351 $Y=0.0675
cc_10 N_12_1 N_8_10 0.00268053f $X=0.351 $Y=0.0675
x_PM_DFFHQNx2_ASAP7_75t_R%15 vss N_M4_d N_M5_s N_15_1 PM_DFFHQNx2_ASAP7_75t_R%15
cc_11 N_15_1 N_6_15 0.00756208f $X=0.486 $Y=0.0405
cc_12 N_15_1 N_7_10 0.00766116f $X=0.486 $Y=0.0405
x_PM_DFFHQNx2_ASAP7_75t_R%CLK vss CLK N_M0_g N_M13_g N_CLK_3 N_CLK_1 N_CLK_7
+ N_CLK_8 N_CLK_4 N_CLK_5 N_CLK_6 PM_DFFHQNx2_ASAP7_75t_R%CLK
x_PM_DFFHQNx2_ASAP7_75t_R%8 vss N_M6_g N_M19_g N_M3_d N_M4_s N_M16_d N_M17_s
+ N_8_11 N_8_19 N_8_13 N_8_14 N_8_3 N_8_4 N_8_18 N_8_10 N_8_15 N_8_20 N_8_12
+ N_8_16 N_8_1 N_8_17 N_8_9 PM_DFFHQNx2_ASAP7_75t_R%8
cc_13 N_8_11 N_4_3 0.000149809f $X=0.4175 $Y=0.081
cc_14 N_8_11 N_4_26 0.000266023f $X=0.4175 $Y=0.081
cc_15 N_8_19 N_4_26 0.0016012f $X=0.459 $Y=0.1525
cc_16 N_8_13 N_4_14 0.00543342f $X=0.3635 $Y=0.189
cc_17 N_8_14 N_4_26 0.000466163f $X=0.459 $Y=0.036
cc_18 N_8_3 N_4_2 0.000817894f $X=0.378 $Y=0.2295
cc_19 N_8_4 N_4_14 0.00104449f $X=0.432 $Y=0.0405
cc_20 N_8_18 N_4_26 0.00105727f $X=0.459 $Y=0.114
cc_21 N_8_3 N_4_14 0.0010605f $X=0.378 $Y=0.2295
cc_22 N_8_10 N_4_2 0.0016958f $X=0.4175 $Y=0.0405
cc_23 N_8_15 N_4_26 0.00273759f $X=0.459 $Y=0.131
cc_24 N_8_20 N_4_28 0.00344625f $X=0.54 $Y=0.131
cc_25 N_8_10 N_4_14 0.00935404f $X=0.4175 $Y=0.0405
cc_26 N_8_12 N_4_14 0.0105112f $X=0.3635 $Y=0.2295
cc_27 N_8_11 N_4_14 0.0443738f $X=0.4175 $Y=0.081
cc_28 N_8_10 N_6_24 9.89496e-20 $X=0.4175 $Y=0.0405
cc_29 N_8_10 N_6_25 0.000358997f $X=0.4175 $Y=0.0405
cc_30 N_8_10 N_6_14 0.00014368f $X=0.4175 $Y=0.0405
cc_31 N_8_10 N_6_3 0.000168777f $X=0.4175 $Y=0.0405
cc_32 N_8_13 N_6_14 0.0237887f $X=0.3635 $Y=0.189
cc_33 N_8_3 N_6_24 0.000955347f $X=0.378 $Y=0.2295
cc_34 N_8_3 N_6_1 0.00032655f $X=0.378 $Y=0.2295
cc_35 N_8_3 N_6_22 0.000346994f $X=0.378 $Y=0.2295
cc_36 N_8_19 N_6_25 0.00273504f $X=0.459 $Y=0.1525
cc_37 N_8_16 N_6_25 0.000388109f $X=0.459 $Y=0.234
cc_38 N_8_11 N_6_15 0.00543166f $X=0.4175 $Y=0.081
cc_39 N_8_1 N_6_8 0.00208723f $X=0.567 $Y=0.1305
cc_40 N_8_20 N_6_8 0.000590235f $X=0.54 $Y=0.131
cc_41 N_8_4 N_6_15 0.000620208f $X=0.432 $Y=0.0405
cc_42 N_8_12 N_6_1 0.000766412f $X=0.3635 $Y=0.2295
cc_43 N_8_19 N_6_2 0.00100696f $X=0.459 $Y=0.1525
cc_44 N_8_3 N_6_14 0.00160761f $X=0.378 $Y=0.2295
cc_45 N_8_17 N_6_26 0.00289551f $X=0.434 $Y=0.234
cc_46 N_8_20 N_6_25 0.0031639f $X=0.54 $Y=0.131
cc_47 N_8_9 N_6_8 0.00421716f $X=0.567 $Y=0.0245
cc_48 N_8_12 N_6_14 0.00964452f $X=0.3635 $Y=0.2295
cc_49 N_8_9 N_6_16 0.0117153f $X=0.567 $Y=0.0245
cc_50 N_8_10 N_6_15 0.0309403f $X=0.4175 $Y=0.0405
cc_51 N_8_9 N_7_12 0.00646832f $X=0.567 $Y=0.0245
cc_52 N_8_4 N_7_1 0.00032925f $X=0.432 $Y=0.0405
cc_53 N_8_20 N_7_14 0.000422918f $X=0.54 $Y=0.131
cc_54 N_8_20 N_7_1 0.000848262f $X=0.54 $Y=0.131
cc_55 N_8_20 N_7_19 0.00088332f $X=0.54 $Y=0.131
cc_56 N_8_9 N_7_3 0.0010357f $X=0.567 $Y=0.0245
cc_57 N_8_1 N_7_10 0.00109055f $X=0.567 $Y=0.1305
cc_58 N_8_1 N_7_16 0.00109113f $X=0.567 $Y=0.1305
cc_59 N_8_18 N_7_16 0.0011104f $X=0.459 $Y=0.114
cc_60 N_8_9 N_7_1 0.00116088f $X=0.567 $Y=0.0245
cc_61 N_8_9 N_7_11 0.0061722f $X=0.567 $Y=0.0245
cc_62 N_8_20 N_7_16 0.00659592f $X=0.54 $Y=0.131
cc_63 N_8_9 N_7_10 0.029082f $X=0.567 $Y=0.0245
x_PM_DFFHQNx2_ASAP7_75t_R%16 vss N_M15_d N_M16_s N_16_1
+ PM_DFFHQNx2_ASAP7_75t_R%16
cc_64 N_16_1 N_D_3 0.016654f $X=0.324 $Y=0.2025
cc_65 N_16_1 N_6_14 0.0167643f $X=0.324 $Y=0.2025
x_PM_DFFHQNx2_ASAP7_75t_R%17 vss N_M21_d N_M22_s N_17_1
+ PM_DFFHQNx2_ASAP7_75t_R%17
cc_66 N_17_1 N_6_17 0.00757727f $X=0.756 $Y=0.2295
cc_67 N_17_1 N_9_9 0.00762795f $X=0.756 $Y=0.2295
x_PM_DFFHQNx2_ASAP7_75t_R%4 vss N_M1_g N_M14_g N_M3_g N_M17_g N_M8_g N_M20_g
+ N_M0_s N_M13_s N_4_8 N_4_7 N_4_25 N_4_19 N_4_16 N_4_17 N_4_1 N_4_22 N_4_24
+ N_4_23 N_4_21 N_4_28 N_4_13 N_4_14 N_4_26 N_4_15 N_4_2 N_4_3 N_4_27
+ PM_DFFHQNx2_ASAP7_75t_R%4
cc_68 N_4_8 N_CLK_3 0.00109281f $X=0.054 $Y=0.216
cc_69 N_4_7 N_CLK_3 0.00111041f $X=0.054 $Y=0.054
cc_70 N_4_25 N_CLK_3 0.000287433f $X=0.151 $Y=0.116
cc_71 N_4_19 N_CLK_3 0.000289949f $X=0.0165 $Y=0.153
cc_72 N_4_16 N_CLK_3 0.011035f $X=0.056 $Y=0.054
cc_73 N_4_17 N_CLK_3 0.0110356f $X=0.056 $Y=0.216
cc_74 N_4_1 N_CLK_3 0.000379929f $X=0.1335 $Y=0.135
cc_75 N_4_22 N_CLK_3 0.000490682f $X=0.018 $Y=0.163
cc_76 N_4_24 N_CLK_3 0.000661339f $X=0.036 $Y=0.234
cc_77 N_4_19 N_CLK_1 0.000964211f $X=0.0165 $Y=0.153
cc_78 N_4_23 N_CLK_7 0.000981669f $X=0.036 $Y=0.036
cc_79 N_4_24 N_CLK_8 0.0010457f $X=0.036 $Y=0.234
cc_80 N_4_25 N_CLK_4 0.00107739f $X=0.151 $Y=0.116
cc_81 N_4_21 N_CLK_4 0.00111575f $X=0.018 $Y=0.125
cc_82 N_4_19 N_CLK_5 0.00162596f $X=0.0165 $Y=0.153
cc_83 N_4_28 N_CLK_5 0.00169831f $X=0.0215 $Y=0.153
cc_84 N_4_23 N_CLK_4 0.00269035f $X=0.036 $Y=0.036
cc_85 N_4_1 N_CLK_1 0.00275583f $X=0.1335 $Y=0.135
cc_86 N_4_19 N_CLK_6 0.00319132f $X=0.0165 $Y=0.153
cc_87 N_4_25 N_CLK_5 0.00325707f $X=0.151 $Y=0.116
cc_88 N_4_13 N_CLK_3 0.0355723f $X=0.135 $Y=0.0245
x_PM_DFFHQNx2_ASAP7_75t_R%6 vss N_M16_g N_M1_d N_M14_d N_M4_g N_M7_g N_M21_g
+ N_6_7 N_6_6 N_6_23 N_6_21 N_6_20 N_6_18 N_6_19 N_6_3 N_6_4 N_6_22 N_6_25
+ N_6_1 N_6_8 N_6_2 N_6_24 N_6_26 N_6_14 N_6_17 N_6_15 N_6_16
+ PM_DFFHQNx2_ASAP7_75t_R%6
cc_89 N_6_7 N_CLK_7 0.000349039f $X=0.162 $Y=0.216
cc_90 N_6_6 N_CLK_7 0.000349152f $X=0.162 $Y=0.054
cc_91 N_6_23 N_CLK_7 0.000663096f $X=0.189 $Y=0.1735
cc_92 N_6_21 N_CLK_7 0.00181431f $X=0.189 $Y=0.234
cc_93 N_6_20 N_CLK_7 0.00195343f $X=0.189 $Y=0.036
cc_94 N_6_20 N_4_13 5.47525e-20 $X=0.189 $Y=0.036
cc_95 N_6_18 N_4_13 0.0110179f $X=0.1475 $Y=0.054
cc_96 N_6_19 N_4_8 5.53013e-20 $X=0.1475 $Y=0.216
cc_97 N_6_21 N_4_24 0.000123689f $X=0.189 $Y=0.234
cc_98 N_6_20 N_4_21 0.00012527f $X=0.189 $Y=0.036
cc_99 N_6_3 N_4_15 0.000190373f $X=0.621 $Y=0.178
cc_100 N_6_6 N_4_13 0.000945008f $X=0.162 $Y=0.054
cc_101 N_6_7 N_4_13 0.000945519f $X=0.162 $Y=0.216
cc_102 N_6_4 N_4_15 0.000244847f $X=0.729 $Y=0.178
cc_103 N_6_21 N_4_25 0.000318618f $X=0.189 $Y=0.234
cc_104 N_6_22 N_4_28 0.000327986f $X=0.3375 $Y=0.135
cc_105 N_6_25 N_4_28 0.000897778f $X=0.513 $Y=0.168
cc_106 N_6_1 N_4_2 0.00192117f $X=0.351 $Y=0.135
cc_107 N_6_20 N_4_25 0.000414282f $X=0.189 $Y=0.036
cc_108 N_6_22 N_4_2 0.000440665f $X=0.3375 $Y=0.135
cc_109 N_6_8 N_4_3 0.0024285f $X=0.501 $Y=0.178
cc_110 N_6_2 N_4_14 0.000469482f $X=0.459 $Y=0.178
cc_111 N_6_24 N_4_28 0.00114908f $X=0.324 $Y=0.1555
cc_112 N_6_8 N_4_27 0.000537411f $X=0.501 $Y=0.178
cc_113 N_6_23 N_4_25 0.00726511f $X=0.189 $Y=0.1735
cc_114 N_6_23 N_4_28 0.000580985f $X=0.189 $Y=0.1735
cc_115 N_6_26 N_4_26 0.000645288f $X=0.1775 $Y=0.189
cc_116 N_6_23 N_4_1 0.000678953f $X=0.189 $Y=0.1735
cc_117 N_6_19 N_4_1 0.00106824f $X=0.1475 $Y=0.216
cc_118 N_6_14 N_4_14 0.0015971f $X=0.351 $Y=0.073
cc_119 N_6_22 N_4_26 0.00255217f $X=0.3375 $Y=0.135
cc_120 N_6_8 N_4_15 0.00374533f $X=0.501 $Y=0.178
cc_121 N_6_17 N_4_15 0.00553253f $X=0.729 $Y=0.178
cc_122 N_6_15 N_4_14 0.00849006f $X=0.459 $Y=0.178
cc_123 N_6_16 N_4_15 0.017189f $X=0.621 $Y=0.178
cc_124 N_6_26 N_4_28 0.0287619f $X=0.1775 $Y=0.189
cc_125 N_6_19 N_4_13 0.0388325f $X=0.1475 $Y=0.216
cc_126 N_6_7 N_D_3 0.000120711f $X=0.162 $Y=0.216
cc_127 N_6_24 N_D_3 0.00015154f $X=0.324 $Y=0.1555
cc_128 N_6_23 N_D_3 0.000178992f $X=0.189 $Y=0.1735
cc_129 N_6_1 N_D_3 0.000348418f $X=0.351 $Y=0.135
cc_130 N_6_22 N_D_3 0.000633271f $X=0.3375 $Y=0.135
cc_131 N_6_20 N_D_3 0.000864419f $X=0.189 $Y=0.036
cc_132 N_6_24 N_D_9 0.000997692f $X=0.324 $Y=0.1555
cc_133 N_6_26 N_D_9 0.00108401f $X=0.1775 $Y=0.189
cc_134 N_6_21 N_D_6 0.00133071f $X=0.189 $Y=0.234
cc_135 N_6_1 N_D_1 0.00170124f $X=0.351 $Y=0.135
cc_136 N_6_23 N_D_7 0.00177956f $X=0.189 $Y=0.1735
cc_137 N_6_22 N_D_9 0.00189954f $X=0.3375 $Y=0.135
cc_138 N_6_23 N_D_8 0.00260289f $X=0.189 $Y=0.1735
cc_139 N_6_23 N_D_5 0.00369039f $X=0.189 $Y=0.1735
cc_140 N_6_14 N_D_3 0.00501281f $X=0.351 $Y=0.073
x_PM_DFFHQNx2_ASAP7_75t_R%7 vss N_M5_g N_M18_g N_M6_d N_M7_s N_M19_d N_M20_s
+ N_7_13 N_7_17 N_7_19 N_7_14 N_7_16 N_7_3 N_7_4 N_7_1 N_7_12 N_7_11 N_7_10
+ N_7_18 PM_DFFHQNx2_ASAP7_75t_R%7
cc_141 N_7_13 N_4_14 0.000114926f $X=0.65 $Y=0.2295
cc_142 N_7_13 N_4_27 0.000367426f $X=0.65 $Y=0.2295
cc_143 N_7_13 N_4_3 0.000222687f $X=0.65 $Y=0.2295
cc_144 N_7_17 N_4_28 0.000237652f $X=0.594 $Y=0.234
cc_145 N_7_19 N_4_27 0.0044981f $X=0.621 $Y=0.1
cc_146 N_7_19 N_4_3 0.000355934f $X=0.621 $Y=0.1
cc_147 N_7_14 N_4_27 0.000760578f $X=0.594 $Y=0.09
cc_148 N_7_16 N_4_28 0.00268324f $X=0.5 $Y=0.09
cc_149 N_7_13 N_4_15 0.0155852f $X=0.65 $Y=0.2295
cc_150 N_7_3 N_6_25 0.000203618f $X=0.594 $Y=0.0405
cc_151 N_7_3 N_6_2 0.00010497f $X=0.594 $Y=0.0405
cc_152 N_7_3 N_6_8 0.000355643f $X=0.594 $Y=0.0405
cc_153 N_7_3 N_6_26 0.000212361f $X=0.594 $Y=0.0405
cc_154 N_7_4 N_6_8 0.00650714f $X=0.594 $Y=0.2295
cc_155 N_7_1 N_6_15 0.000731365f $X=0.513 $Y=0.09
cc_156 N_7_12 N_6_16 0.00764222f $X=0.5795 $Y=0.2295
cc_157 N_7_13 N_6_16 0.00767505f $X=0.65 $Y=0.2295
cc_158 N_7_17 N_6_25 0.000372747f $X=0.594 $Y=0.234
cc_159 N_7_17 N_6_8 0.000376396f $X=0.594 $Y=0.234
cc_160 N_7_4 N_6_3 0.000871281f $X=0.594 $Y=0.2295
cc_161 N_7_19 N_6_8 0.00154873f $X=0.621 $Y=0.1
cc_162 N_7_4 N_6_16 0.00228899f $X=0.594 $Y=0.2295
cc_163 N_7_11 N_6_16 0.00633096f $X=0.5795 $Y=0.0405
cc_164 N_7_10 N_6_15 0.0136854f $X=0.513 $Y=0.0245
cc_165 N_7_3 N_6_16 0.0290666f $X=0.594 $Y=0.0405
x_PM_DFFHQNx2_ASAP7_75t_R%9 vss N_M9_g N_M22_g N_M10_d N_M23_d N_9_9 N_9_11
+ N_9_14 N_9_18 N_9_3 N_9_4 N_9_1 N_9_17 N_9_12 N_9_15 N_9_16 N_9_10
+ PM_DFFHQNx2_ASAP7_75t_R%9
cc_166 N_9_9 N_6_8 0.000207124f $X=0.783 $Y=0.0245
cc_167 N_9_9 N_6_4 0.000410434f $X=0.783 $Y=0.0245
cc_168 N_9_9 N_6_17 0.012848f $X=0.783 $Y=0.0245
x_PM_DFFHQNx2_ASAP7_75t_R%QN vss QN N_M11_d N_M12_d N_M24_d N_M25_d N_QN_2
+ N_QN_8 N_QN_13 N_QN_1 N_QN_7 PM_DFFHQNx2_ASAP7_75t_R%QN
cc_169 N_QN_2 N_9_18 0.00220322f $X=1.026 $Y=0.2025
cc_170 N_QN_8 N_10_28 0.00183486f $X=1.0115 $Y=0.2025
cc_171 N_QN_8 N_10_2 0.00538009f $X=1.0115 $Y=0.2025
cc_172 N_QN_8 N_10_29 0.000686367f $X=1.0115 $Y=0.2025
cc_173 N_QN_8 N_10_12 0.055895f $X=1.0115 $Y=0.2025
cc_174 N_QN_13 N_10_2 0.000909647f $X=1.108 $Y=0.072
cc_175 N_QN_1 N_10_28 0.0017231f $X=1.026 $Y=0.0675
cc_176 N_QN_1 N_10_13 0.00180743f $X=1.026 $Y=0.0675
cc_177 N_QN_2 N_10_13 0.00183301f $X=1.026 $Y=0.2025
cc_178 N_QN_7 N_10_12 0.0285733f $X=1.0115 $Y=0.0675
cc_179 N_QN_8 N_10_13 0.0480995f $X=1.0115 $Y=0.2025
x_PM_DFFHQNx2_ASAP7_75t_R%14 vss N_M8_d N_M9_s N_14_4 N_14_1 N_14_5
+ PM_DFFHQNx2_ASAP7_75t_R%14
cc_180 N_14_4 N_4_15 0.014782f $X=0.6875 $Y=0.0405
cc_181 N_14_1 N_6_17 0.000699363f $X=0.702 $Y=0.0405
cc_182 N_14_5 N_6_17 0.00666858f $X=0.758 $Y=0.0405
cc_183 N_14_4 N_6_17 0.0257597f $X=0.6875 $Y=0.0405
cc_184 N_14_1 N_9_9 0.00088528f $X=0.702 $Y=0.0405
cc_185 N_14_5 N_9_9 0.0150119f $X=0.758 $Y=0.0405
cc_186 N_14_1 N_10_14 0.000289745f $X=0.702 $Y=0.0405
cc_187 N_14_1 N_10_21 0.000416778f $X=0.702 $Y=0.0405
cc_188 N_14_1 N_10_22 0.000530762f $X=0.702 $Y=0.0405
cc_189 N_14_4 N_10_5 0.000557961f $X=0.6875 $Y=0.0405
cc_190 N_14_1 N_10_17 0.002383f $X=0.702 $Y=0.0405
x_PM_DFFHQNx2_ASAP7_75t_R%10 vss N_M10_g N_M23_g N_M20_d N_M21_s N_M11_g
+ N_M24_g N_M12_g N_M25_g N_M7_d N_M8_s N_10_5 N_10_24 N_10_6 N_10_15 N_10_14
+ N_10_16 N_10_18 N_10_22 N_10_23 N_10_21 N_10_2 N_10_19 N_10_28 N_10_11
+ N_10_20 N_10_26 N_10_1 N_10_17 N_10_25 N_10_27 N_10_29 N_10_12 N_10_13
+ PM_DFFHQNx2_ASAP7_75t_R%10
cc_191 N_10_5 N_4_28 0.000125439f $X=0.648 $Y=0.0405
cc_192 N_10_24 N_4_27 0.000128331f $X=0.81 $Y=0.162
cc_193 N_10_6 N_4_15 0.000132721f $X=0.702 $Y=0.2295
cc_194 N_10_15 N_4_15 0.00641314f $X=0.6875 $Y=0.2295
cc_195 N_10_14 N_4_15 0.00655149f $X=0.6335 $Y=0.0405
cc_196 N_10_16 N_4_27 0.000388772f $X=0.729 $Y=0.233
cc_197 N_10_18 N_4_27 0.000944377f $X=0.729 $Y=0.16
cc_198 N_10_22 N_4_3 0.000505057f $X=0.729 $Y=0.136
cc_199 N_10_5 N_4_3 0.000506715f $X=0.648 $Y=0.0405
cc_200 N_10_23 N_4_27 0.000540971f $X=0.729 $Y=0.1975
cc_201 N_10_21 N_4_27 0.00056496f $X=0.704 $Y=0.036
cc_202 N_10_21 N_4_28 0.000942261f $X=0.704 $Y=0.036
cc_203 N_10_22 N_4_27 0.00365606f $X=0.729 $Y=0.136
cc_204 N_10_5 N_4_15 0.018767f $X=0.648 $Y=0.0405
cc_205 N_10_18 N_6_8 0.000159558f $X=0.729 $Y=0.16
cc_206 N_10_16 N_6_8 0.000194312f $X=0.729 $Y=0.233
cc_207 N_10_6 N_6_8 0.000228311f $X=0.702 $Y=0.2295
cc_208 N_10_14 N_6_16 0.0065955f $X=0.6335 $Y=0.0405
cc_209 N_10_24 N_6_4 0.000357767f $X=0.81 $Y=0.162
cc_210 N_10_22 N_6_8 0.000483063f $X=0.729 $Y=0.136
cc_211 N_10_23 N_6_8 0.000571106f $X=0.729 $Y=0.1975
cc_212 N_10_6 N_6_17 0.000929593f $X=0.702 $Y=0.2295
cc_213 N_10_15 N_6_4 0.0013197f $X=0.6875 $Y=0.2295
cc_214 N_10_15 N_6_8 0.00219996f $X=0.6875 $Y=0.2295
cc_215 N_10_5 N_6_16 0.00947472f $X=0.648 $Y=0.0405
cc_216 N_10_15 N_6_17 0.0167127f $X=0.6875 $Y=0.2295
cc_217 N_10_16 N_7_3 0.000185186f $X=0.729 $Y=0.233
cc_218 N_10_15 N_7_3 0.00043371f $X=0.6875 $Y=0.2295
cc_219 N_10_14 N_7_11 0.000474321f $X=0.6335 $Y=0.0405
cc_220 N_10_16 N_7_4 0.000284656f $X=0.729 $Y=0.233
cc_221 N_10_6 N_7_4 0.000748088f $X=0.702 $Y=0.2295
cc_222 N_10_21 N_7_18 0.000476766f $X=0.704 $Y=0.036
cc_223 N_10_15 N_7_4 0.0005675f $X=0.6875 $Y=0.2295
cc_224 N_10_16 N_7_19 0.000678209f $X=0.729 $Y=0.233
cc_225 N_10_21 N_7_14 0.00144666f $X=0.704 $Y=0.036
cc_226 N_10_5 N_7_3 0.00349651f $X=0.648 $Y=0.0405
cc_227 N_10_2 N_9_9 0.000153489f $X=0.9895 $Y=0.136
cc_228 N_10_19 N_9_9 0.000212839f $X=0.837 $Y=0.162
cc_229 N_10_28 N_9_9 0.00021714f $X=0.999 $Y=0.1085
cc_230 N_10_11 N_9_11 0.00680629f $X=0.837 $Y=0.0245
cc_231 N_10_20 N_9_14 0.000225372f $X=0.891 $Y=0.1575
cc_232 N_10_28 N_9_18 0.00189631f $X=0.999 $Y=0.1085
cc_233 N_10_2 N_9_18 0.000310572f $X=0.9895 $Y=0.136
cc_234 N_10_11 N_9_3 0.000359581f $X=0.837 $Y=0.0245
cc_235 N_10_26 N_9_4 0.000373446f $X=0.848 $Y=0.162
cc_236 N_10_20 N_9_18 0.00126247f $X=0.891 $Y=0.1575
cc_237 N_10_11 N_9_4 0.000540838f $X=0.837 $Y=0.0245
cc_238 N_10_1 N_9_1 0.000606623f $X=0.837 $Y=0.135
cc_239 N_10_26 N_9_17 0.000685099f $X=0.848 $Y=0.162
cc_240 N_10_17 N_9_12 0.000791702f $X=0.729 $Y=0.036
cc_241 N_10_25 N_9_15 0.000835953f $X=0.837 $Y=0.118
cc_242 N_10_22 N_9_1 0.000978201f $X=0.729 $Y=0.136
cc_243 N_10_27 N_9_16 0.00113524f $X=0.891 $Y=0.1305
cc_244 N_10_1 N_9_9 0.00116628f $X=0.837 $Y=0.135
cc_245 N_10_20 N_9_17 0.0012023f $X=0.891 $Y=0.1575
cc_246 N_10_11 N_9_1 0.00121761f $X=0.837 $Y=0.0245
cc_247 N_10_24 N_9_15 0.00140646f $X=0.81 $Y=0.162
cc_248 N_10_29 N_9_18 0.00184558f $X=0.8795 $Y=0.153
cc_249 N_10_11 N_9_10 0.00654689f $X=0.837 $Y=0.0245
cc_250 N_10_22 N_9_15 0.00453711f $X=0.729 $Y=0.136
cc_251 N_10_27 N_9_18 0.00657255f $X=0.891 $Y=0.1305
cc_252 N_10_11 N_9_9 0.0304987f $X=0.837 $Y=0.0245
x_PM_DFFHQNx2_ASAP7_75t_R%13 vss N_M17_d N_M18_s N_13_4 N_13_1 N_13_5
+ PM_DFFHQNx2_ASAP7_75t_R%13
cc_253 N_13_4 N_4_14 0.014054f $X=0.4175 $Y=0.2295
cc_254 N_13_1 N_6_2 0.000798758f $X=0.432 $Y=0.2295
cc_255 N_13_5 N_6_8 0.00102117f $X=0.488 $Y=0.2295
cc_256 N_13_1 N_6_15 0.00185714f $X=0.432 $Y=0.2295
cc_257 N_13_5 N_6_15 0.00654217f $X=0.488 $Y=0.2295
cc_258 N_13_4 N_6_15 0.0227819f $X=0.4175 $Y=0.2295
cc_259 N_13_5 N_7_10 0.018515f $X=0.488 $Y=0.2295
cc_260 N_13_1 N_8_17 0.000405587f $X=0.432 $Y=0.2295
cc_261 N_13_4 N_8_3 0.000500404f $X=0.4175 $Y=0.2295
cc_262 N_13_1 N_8_16 0.00281296f $X=0.432 $Y=0.2295
x_PM_DFFHQNx2_ASAP7_75t_R%D vss D N_M2_g N_M15_g N_D_8 N_D_3 N_D_9 N_D_6 N_D_1
+ N_D_7 N_D_5 PM_DFFHQNx2_ASAP7_75t_R%D
cc_263 N_D_8 N_4_14 9.69334e-20 $X=0.243 $Y=0.1735
cc_264 N_D_8 N_4_1 0.000357586f $X=0.243 $Y=0.1735
cc_265 N_D_8 N_4_26 0.000160189f $X=0.243 $Y=0.1735
cc_266 N_D_8 N_4_28 0.00387671f $X=0.243 $Y=0.1735

* End of included file DFFHQNx2_ASAP7_75t_R.pex.sp.pxi
.ends

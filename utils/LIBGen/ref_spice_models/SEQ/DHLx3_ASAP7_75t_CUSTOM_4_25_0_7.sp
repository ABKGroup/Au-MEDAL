.subckt PM_DHLx3_ASAP7_75t_R%CLK vss 18 9 15 3 1 6 5 4 8 7
c1 1 vss 0.00388997f $X=0.081 $Y=0.135
c2 3 vss 0.0695926f $X=0.081 $Y=0.0245
c3 4 vss 0.00203744f $X=0.081 $Y=0.099
c4 5 vss 0.00191144f $X=0.081 $Y=0.171
c5 6 vss 0.00104297f $X=0.081 $Y=0.135
c6 7 vss 0.00439529f $X=0.108 $Y=0.063
c7 8 vss 0.00427792f $X=0.108 $Y=0.1935
r1 8 24 1.35805 $w=2.83333e-08 $l=2.25e-08 $layer=M1 $thickness=3.6e-08
+ $X=0.108 $Y=0.1935 $X2=0.108 $Y2=0.171
r2 7 22 4.50612 $w=2.06667e-08 $l=3.6e-08 $layer=M1 $thickness=3.6e-08 $X=0.108
+ $Y=0.063 $X2=0.108 $Y2=0.099
r3 23 24 0.502848 $w=3.43333e-08 $l=1.35e-08 $layer=M1 $thickness=3.6e-08
+ $X=0.0945 $Y=0.171 $X2=0.108 $Y2=0.171
r4 5 20 1.35805 $w=2.83333e-08 $l=2.25e-08 $layer=M1 $thickness=3.6e-08
+ $X=0.081 $Y=0.171 $X2=0.081 $Y2=0.1485
r5 5 23 0.502848 $w=3.43333e-08 $l=1.35e-08 $layer=M1 $thickness=3.6e-08
+ $X=0.081 $Y=0.171 $X2=0.0945 $Y2=0.171
r6 21 22 0.502848 $w=3.43333e-08 $l=1.35e-08 $layer=M1 $thickness=3.6e-08
+ $X=0.0945 $Y=0.099 $X2=0.108 $Y2=0.099
r7 4 17 0.483592 $w=3.42308e-08 $l=1.87e-08 $layer=M1 $thickness=3.6e-08
+ $X=0.081 $Y=0.099 $X2=0.081 $Y2=0.1177
r8 4 21 0.502848 $w=3.43333e-08 $l=1.35e-08 $layer=M1 $thickness=3.6e-08
+ $X=0.081 $Y=0.099 $X2=0.0945 $Y2=0.099
r9 18 19 0.874462 $w=1.3e-08 $l=3.7e-09 $layer=M1 $thickness=3.6e-08 $X=0.08
+ $Y=0.119 $X2=0.081 $Y2=0.1227
r10 18 17 0.291487 $w=1.3e-08 $l=1.3e-09 $layer=M1 $thickness=3.6e-08 $X=0.08
+ $Y=0.119 $X2=0.081 $Y2=0.1177
r11 6 19 2.85657 $w=1.3e-08 $l=1.23e-08 $layer=M1 $thickness=3.6e-08 $X=0.081
+ $Y=0.135 $X2=0.081 $Y2=0.1227
r12 6 20 3.14806 $w=1.3e-08 $l=1.35e-08 $layer=M1 $thickness=3.6e-08 $X=0.081
+ $Y=0.135 $X2=0.081 $Y2=0.1485
r13 1 12 10.4265 $w=1.765e-08 $layer=LIG $thickness=5.2e-08 $X=0.081 $Y=0.135
+ $X2=0.081 $Y2=0.135
r14 1 6 19.3796 $a=3.24e-16 $layer=V0LIG $X=0.081 $Y=0.135 $X2=0.081 $Y2=0.135
r15 15 14 14.6259 $w=2.1e-08 $l=4.3e-08 $layer=Gate_1 $thickness=5.6e-08
+ $X=0.081 $Y=0.216 $X2=0.081 $Y2=0.173
r16 13 14 7.31297 $w=2.1e-08 $l=2.15e-08 $layer=Gate_1 $thickness=5.6e-08
+ $X=0.081 $Y=0.1515 $X2=0.081 $Y2=0.173
r17 12 13 5.79936 $w=2.03333e-08 $l=1.65e-08 $layer=Gate_1 $thickness=5.6e-08
+ $X=0.081 $Y=0.135 $X2=0.081 $Y2=0.1515
r18 11 12 5.79936 $w=2.03333e-08 $l=1.65e-08 $layer=Gate_1 $thickness=5.6e-08
+ $X=0.081 $Y=0.1185 $X2=0.081 $Y2=0.135
r19 10 11 7.31297 $w=2.1e-08 $l=2.15e-08 $layer=Gate_1 $thickness=5.6e-08
+ $X=0.081 $Y=0.097 $X2=0.081 $Y2=0.1185
r20 9 10 14.6259 $w=2.1e-08 $l=4.3e-08 $layer=Gate_1 $thickness=5.6e-08
+ $X=0.081 $Y=0.054 $X2=0.081 $Y2=0.097
r21 9 3 10.0341 $w=2.1e-08 $l=2.95e-08 $layer=Gate_1 $thickness=5.6e-08
+ $X=0.081 $Y=0.054 $X2=0.081 $Y2=0.0245
.ends

.subckt PM_DHLx3_ASAP7_75t_R%D vss 16 6 12 5 1 3 4
c1 1 vss 0.00509676f $X=0.297 $Y=0.1345
c2 3 vss 0.0917962f $X=0.297 $Y=0.0245
c3 4 vss 0.00569133f $X=0.297 $Y=0.036
c4 5 vss 0.00890003f $X=0.297 $Y=0.0755
r1 4 5 8.03069 $w=1.41392e-08 $l=3.95e-08 $layer=M1 $thickness=3.6e-08 $X=0.297
+ $Y=0.036 $X2=0.297 $Y2=0.0755
r2 17 18 3.14806 $w=1.3e-08 $l=1.35e-08 $layer=M1 $thickness=3.6e-08 $X=0.297
+ $Y=0.1215 $X2=0.297 $Y2=0.135
r3 16 17 1.16595 $w=1.3e-08 $l=5e-09 $layer=M1 $thickness=3.6e-08 $X=0.297
+ $Y=0.1165 $X2=0.297 $Y2=0.1215
r4 16 15 1.28254 $w=1.3e-08 $l=5.5e-09 $layer=M1 $thickness=3.6e-08 $X=0.297
+ $Y=0.1165 $X2=0.297 $Y2=0.111
r5 5 15 8.27824 $w=1.3e-08 $l=3.55e-08 $layer=M1 $thickness=3.6e-08 $X=0.297
+ $Y=0.0755 $X2=0.297 $Y2=0.111
r6 1 9 10.1312 $w=1.77047e-08 $l=5e-10 $layer=LIG $thickness=5.2093e-08
+ $X=0.297 $Y=0.1345 $X2=0.297 $Y2=0.135
r7 1 18 19.3796 $a=3.24e-16 $layer=V0LIG $X=0.297 $Y=0.1345 $X2=0.297 $Y2=0.135
r8 12 11 14.6259 $w=2.1e-08 $l=4.3e-08 $layer=Gate_1 $thickness=5.6e-08
+ $X=0.297 $Y=0.2025 $X2=0.297 $Y2=0.1595
r9 10 11 2.7211 $w=2.1e-08 $l=8e-09 $layer=Gate_1 $thickness=5.6e-08 $X=0.297
+ $Y=0.1515 $X2=0.297 $Y2=0.1595
r10 9 10 5.79936 $w=2.03333e-08 $l=1.65e-08 $layer=Gate_1 $thickness=5.6e-08
+ $X=0.297 $Y=0.135 $X2=0.297 $Y2=0.1515
r11 8 9 5.79936 $w=2.03333e-08 $l=1.65e-08 $layer=Gate_1 $thickness=5.6e-08
+ $X=0.297 $Y=0.1185 $X2=0.297 $Y2=0.135
r12 7 8 2.7211 $w=2.1e-08 $l=8e-09 $layer=Gate_1 $thickness=5.6e-08 $X=0.297
+ $Y=0.1105 $X2=0.297 $Y2=0.1185
r13 6 7 14.6259 $w=2.1e-08 $l=4.3e-08 $layer=Gate_1 $thickness=5.6e-08 $X=0.297
+ $Y=0.0675 $X2=0.297 $Y2=0.1105
r14 6 3 14.6259 $w=2.1e-08 $l=4.3e-08 $layer=Gate_1 $thickness=5.6e-08 $X=0.297
+ $Y=0.0675 $X2=0.297 $Y2=0.0245
.ends

.subckt PM_DHLx3_ASAP7_75t_R%13 vss 2 3 1
c1 1 vss 0.000776028f $X=0.324 $Y=0.2025
r1 2 1 0.209877 $w=8.1e-08 $l=1.7e-08 $layer=P_src_drn $thickness=1e-09
+ $X=0.3066 $Y=0.2025 $X2=0.324 $Y2=0.2025
r2 3 1 0.209877 $w=8.1e-08 $l=1.7e-08 $layer=P_src_drn $thickness=1e-09
+ $X=0.3413 $Y=0.2025 $X2=0.324 $Y2=0.2025
.ends

.subckt PM_DHLx3_ASAP7_75t_R%6 vss 21 25 50 52 3 15 14 10 11 4 9 18 17 16 1 13
+ 12
c1 1 vss 0.000398656f $X=0.405 $Y=0.132
c2 3 vss 0.00759102f $X=0.162 $Y=0.054
c3 4 vss 0.00741095f $X=0.162 $Y=0.216
c4 9 vss 0.00738359f $X=0.405 $Y=0.0245
c5 10 vss 0.0321499f $X=0.1475 $Y=0.054
c6 11 vss 0.0319338f $X=0.1475 $Y=0.216
c7 12 vss 0.00307187f $X=0.243 $Y=0.036
c8 13 vss 0.00302335f $X=0.243 $Y=0.2305
c9 14 vss 0.00938152f $X=0.216 $Y=0.036
c10 15 vss 0.00843044f $X=0.216 $Y=0.234
c11 16 vss 0.00743959f $X=0.243 $Y=0.135
c12 17 vss 0.000898956f $X=0.405 $Y=0.1155
c13 18 vss 0.00645585f $X=0.2315 $Y=0.153
r1 11 4 0.231482 $w=5.4e-08 $l=1.25e-08 $layer=P_src_drn $thickness=1e-09
+ $X=0.1475 $Y=0.216 $X2=0.162 $Y2=0.216
r2 52 11 0.0462963 $w=5.4e-08 $l=2.5e-09 $layer=P_src_drn $thickness=1e-09
+ $X=0.1446 $Y=0.216 $X2=0.1475 $Y2=0.216
r3 10 3 0.231482 $w=5.4e-08 $l=1.25e-08 $layer=N_src_drn $thickness=1e-09
+ $X=0.1475 $Y=0.054 $X2=0.162 $Y2=0.054
r4 50 10 0.0462963 $w=5.4e-08 $l=2.5e-09 $layer=N_src_drn $thickness=1e-09
+ $X=0.1446 $Y=0.054 $X2=0.1475 $Y2=0.054
r5 4 47 19.3796 $a=3.24e-16 $layer=V0LISD $X=0.162 $Y=0.216 $X2=0.162 $Y2=0.234
r6 3 44 19.3796 $a=3.24e-16 $layer=V0LISD $X=0.162 $Y=0.054 $X2=0.162 $Y2=0.036
r7 47 48 5.24677 $w=1.3e-08 $l=2.25e-08 $layer=M1 $thickness=3.6e-08 $X=0.162
+ $Y=0.234 $X2=0.1845 $Y2=0.234
r8 15 48 7.34548 $w=1.3e-08 $l=3.15e-08 $layer=M1 $thickness=3.6e-08 $X=0.216
+ $Y=0.234 $X2=0.1845 $Y2=0.234
r9 44 45 5.24677 $w=1.3e-08 $l=2.25e-08 $layer=M1 $thickness=3.6e-08 $X=0.162
+ $Y=0.036 $X2=0.1845 $Y2=0.036
r10 14 45 7.34548 $w=1.3e-08 $l=3.15e-08 $layer=M1 $thickness=3.6e-08 $X=0.216
+ $Y=0.036 $X2=0.1845 $Y2=0.036
r11 13 41 3.70931 $w=1.44474e-08 $l=1.9e-08 $layer=M1 $thickness=3.6e-08
+ $X=0.243 $Y=0.2305 $X2=0.243 $Y2=0.2115
r12 13 15 4.75866 $w=1.41702e-08 $l=2.72259e-08 $layer=M1 $thickness=3.6e-08
+ $X=0.243 $Y=0.2305 $X2=0.216 $Y2=0.234
r13 12 39 4.64701 $w=1.62667e-08 $l=2.7e-08 $layer=M1 $thickness=3.6e-08
+ $X=0.243 $Y=0.036 $X2=0.243 $Y2=0.063
r14 12 14 4.64701 $w=1.46667e-08 $l=2.7e-08 $layer=M1 $thickness=3.6e-08
+ $X=0.243 $Y=0.036 $X2=0.216 $Y2=0.036
r15 40 41 5.24677 $w=1.3e-08 $l=2.25e-08 $layer=M1 $thickness=3.6e-08 $X=0.243
+ $Y=0.189 $X2=0.243 $Y2=0.2115
r16 38 39 8.39483 $w=1.3e-08 $l=3.6e-08 $layer=M1 $thickness=3.6e-08 $X=0.243
+ $Y=0.099 $X2=0.243 $Y2=0.063
r17 37 38 5.24677 $w=1.3e-08 $l=2.25e-08 $layer=M1 $thickness=3.6e-08 $X=0.243
+ $Y=0.1215 $X2=0.243 $Y2=0.099
r18 36 40 4.19742 $w=1.3e-08 $l=1.8e-08 $layer=M1 $thickness=3.6e-08 $X=0.243
+ $Y=0.171 $X2=0.243 $Y2=0.189
r19 35 36 4.19742 $w=1.3e-08 $l=1.8e-08 $layer=M1 $thickness=3.6e-08 $X=0.243
+ $Y=0.153 $X2=0.243 $Y2=0.171
r20 16 35 4.19742 $w=1.3e-08 $l=1.8e-08 $layer=M1 $thickness=3.6e-08 $X=0.243
+ $Y=0.135 $X2=0.243 $Y2=0.153
r21 16 37 3.14806 $w=1.3e-08 $l=1.35e-08 $layer=M1 $thickness=3.6e-08 $X=0.243
+ $Y=0.135 $X2=0.243 $Y2=0.1215
r22 33 34 18.8884 $w=1.3e-08 $l=8.1e-08 $layer=M2 $thickness=3.6e-08 $X=0.324
+ $Y=0.153 $X2=0.405 $Y2=0.153
r23 32 33 18.8884 $w=1.3e-08 $l=8.1e-08 $layer=M2 $thickness=3.6e-08 $X=0.243
+ $Y=0.153 $X2=0.324 $Y2=0.153
r24 32 35 19.5347 $a=3.24e-16 $layer=V1 $X=0.243 $Y=0.153 $X2=0.243 $Y2=0.153
r25 18 32 2.68168 $w=1.3e-08 $l=1.15e-08 $layer=M2 $thickness=3.6e-08 $X=0.2315
+ $Y=0.153 $X2=0.243 $Y2=0.153
r26 30 34 19.5347 $a=3.24e-16 $layer=V1 $X=0.405 $Y=0.153 $X2=0.405 $Y2=0.153
r27 29 30 2.2153 $w=1.3e-08 $l=9.5e-09 $layer=M1 $thickness=3.6e-08 $X=0.405
+ $Y=0.1435 $X2=0.405 $Y2=0.153
r28 28 29 2.2153 $w=1.3e-08 $l=9.5e-09 $layer=M1 $thickness=3.6e-08 $X=0.405
+ $Y=0.134 $X2=0.405 $Y2=0.1435
r29 17 28 4.31401 $w=1.3e-08 $l=1.85e-08 $layer=M1 $thickness=3.6e-08 $X=0.405
+ $Y=0.1155 $X2=0.405 $Y2=0.134
r30 1 23 9.2451 $w=1.7885e-08 $l=2e-09 $layer=LIG $thickness=5.24e-08 $X=0.405
+ $Y=0.132 $X2=0.405 $Y2=0.134
r31 1 28 19.3796 $a=3.24e-16 $layer=V0LIG $X=0.405 $Y=0.132 $X2=0.405 $Y2=0.134
r32 25 24 16.6668 $w=2.1e-08 $l=4.9e-08 $layer=Gate_1 $thickness=5.6e-08
+ $X=0.405 $Y=0.2295 $X2=0.405 $Y2=0.1805
r33 23 24 16.0035 $w=2.07634e-08 $l=4.65e-08 $layer=Gate_1 $thickness=5.6e-08
+ $X=0.405 $Y=0.134 $X2=0.405 $Y2=0.1805
r34 22 23 6.47963 $w=2.04054e-08 $l=1.85e-08 $layer=Gate_1 $thickness=5.6e-08
+ $X=0.405 $Y=0.1155 $X2=0.405 $Y2=0.134
r35 21 22 16.3266 $w=2.1e-08 $l=4.8e-08 $layer=Gate_1 $thickness=5.6e-08
+ $X=0.405 $Y=0.0675 $X2=0.405 $Y2=0.1155
r36 21 9 14.6259 $w=2.1e-08 $l=4.3e-08 $layer=Gate_1 $thickness=5.6e-08
+ $X=0.405 $Y=0.0675 $X2=0.405 $Y2=0.0245
.ends

.subckt PM_DHLx3_ASAP7_75t_R%7 vss 18 22 39 45 9 13 1 4 17 3 16 12 11 10 15 14
c1 1 vss 0.0026324f $X=0.513 $Y=0.082
c2 3 vss 0.00597511f $X=0.594 $Y=0.0405
c3 4 vss 0.00596952f $X=0.594 $Y=0.2295
c4 9 vss 0.0407619f $X=0.513 $Y=0.0245
c5 10 vss 0.018989f $X=0.5795 $Y=0.0405
c6 11 vss 0.018716f $X=0.5795 $Y=0.2295
c7 12 vss 0.00292301f $X=0.513 $Y=0.036
c8 13 vss 0.00607681f $X=0.621 $Y=0.234
c9 14 vss 0.00284856f $X=0.621 $Y=0.036
c10 15 vss 0.00141576f $X=0.513 $Y=0.059
c11 16 vss 0.00831925f $X=0.5515 $Y=0.036
c12 17 vss 0.00429491f $X=0.621 $Y=0.0675
r1 11 4 0.462963 $w=2.7e-08 $l=1.25e-08 $layer=P_src_drn $thickness=1e-09
+ $X=0.5795 $Y=0.2295 $X2=0.594 $Y2=0.2295
r2 45 11 0.0925926 $w=2.7e-08 $l=2.5e-09 $layer=P_src_drn $thickness=1e-09
+ $X=0.5766 $Y=0.2295 $X2=0.5795 $Y2=0.2295
r3 4 41 19.3796 $a=3.24e-16 $layer=V0LISD $X=0.594 $Y=0.2295 $X2=0.594 $Y2=0.234
r4 41 42 3.14806 $w=1.3e-08 $l=1.35e-08 $layer=M1 $thickness=3.6e-08 $X=0.594
+ $Y=0.234 $X2=0.6075 $Y2=0.234
r5 13 37 3.01711 $w=1.55e-08 $l=1.8e-08 $layer=M1 $thickness=3.6e-08 $X=0.621
+ $Y=0.234 $X2=0.621 $Y2=0.216
r6 13 42 1.96775 $w=1.63333e-08 $l=1.35e-08 $layer=M1 $thickness=3.6e-08
+ $X=0.621 $Y=0.234 $X2=0.6075 $Y2=0.234
r7 10 3 0.462963 $w=2.7e-08 $l=1.25e-08 $layer=N_src_drn $thickness=1e-09
+ $X=0.5795 $Y=0.0405 $X2=0.594 $Y2=0.0405
r8 39 10 0.0925926 $w=2.7e-08 $l=2.5e-09 $layer=N_src_drn $thickness=1e-09
+ $X=0.5766 $Y=0.0405 $X2=0.5795 $Y2=0.0405
r9 36 37 6.7625 $w=1.3e-08 $l=2.9e-08 $layer=M1 $thickness=3.6e-08 $X=0.621
+ $Y=0.187 $X2=0.621 $Y2=0.216
r10 35 36 5.01358 $w=1.3e-08 $l=2.15e-08 $layer=M1 $thickness=3.6e-08 $X=0.621
+ $Y=0.1655 $X2=0.621 $Y2=0.187
r11 34 35 3.26466 $w=1.3e-08 $l=1.4e-08 $layer=M1 $thickness=3.6e-08 $X=0.621
+ $Y=0.1515 $X2=0.621 $Y2=0.1655
r12 33 34 5.01358 $w=1.3e-08 $l=2.15e-08 $layer=M1 $thickness=3.6e-08 $X=0.621
+ $Y=0.13 $X2=0.621 $Y2=0.1515
r13 32 33 5.01358 $w=1.3e-08 $l=2.15e-08 $layer=M1 $thickness=3.6e-08 $X=0.621
+ $Y=0.1085 $X2=0.621 $Y2=0.13
r14 31 32 3.61444 $w=1.3e-08 $l=1.55e-08 $layer=M1 $thickness=3.6e-08 $X=0.621
+ $Y=0.093 $X2=0.621 $Y2=0.1085
r15 17 31 5.94634 $w=1.3e-08 $l=2.55e-08 $layer=M1 $thickness=3.6e-08 $X=0.621
+ $Y=0.0675 $X2=0.621 $Y2=0.093
r16 3 29 19.3796 $a=3.24e-16 $layer=V0LISD $X=0.594 $Y=0.0405 $X2=0.594
+ $Y2=0.036
r17 14 30 1.49895 $w=1.63333e-08 $l=1.35e-08 $layer=M1 $thickness=3.6e-08
+ $X=0.621 $Y=0.036 $X2=0.6075 $Y2=0.036
r18 14 17 5.69636 $w=1.58e-08 $l=3.15e-08 $layer=M1 $thickness=3.6e-08 $X=0.621
+ $Y=0.036 $X2=0.621 $Y2=0.0675
r19 29 30 3.14806 $w=1.3e-08 $l=1.35e-08 $layer=M1 $thickness=3.6e-08 $X=0.594
+ $Y=0.036 $X2=0.6075 $Y2=0.036
r20 28 29 2.56509 $w=1.3e-08 $l=1.1e-08 $layer=M1 $thickness=3.6e-08 $X=0.583
+ $Y=0.036 $X2=0.594 $Y2=0.036
r21 16 28 7.34548 $w=1.3e-08 $l=3.15e-08 $layer=M1 $thickness=3.6e-08 $X=0.5515
+ $Y=0.036 $X2=0.583 $Y2=0.036
r22 12 15 3.71425 $w=1.68348e-08 $l=2.3e-08 $layer=M1 $thickness=3.6e-08
+ $X=0.513 $Y=0.036 $X2=0.513 $Y2=0.059
r23 12 16 7.32869 $w=1.41688e-08 $l=3.85e-08 $layer=M1 $thickness=3.6e-08
+ $X=0.513 $Y=0.036 $X2=0.5515 $Y2=0.036
r24 15 26 5.36336 $w=1.3e-08 $l=2.3e-08 $layer=M1 $thickness=3.6e-08 $X=0.513
+ $Y=0.059 $X2=0.513 $Y2=0.082
r25 1 20 6.54019 $w=2.09524e-08 $layer=Gate_1 $thickness=5.21905e-08 $X=0.513
+ $Y=0.082 $X2=0.513 $Y2=0.082
r26 1 26 19.3796 $a=3.24e-16 $layer=V0LIG $X=0.513 $Y=0.082 $X2=0.513 $Y2=0.082
r27 22 21 25.5104 $w=2.1e-08 $l=7.5e-08 $layer=Gate_1 $thickness=5.6e-08
+ $X=0.513 $Y=0.2295 $X2=0.513 $Y2=0.1545
r28 20 21 24.8471 $w=2.08483e-08 $l=7.25e-08 $layer=Gate_1 $thickness=5.6e-08
+ $X=0.513 $Y=0.082 $X2=0.513 $Y2=0.1545
r29 19 20 6.81977 $w=2.04359e-08 $l=1.95e-08 $layer=Gate_1 $thickness=5.6e-08
+ $X=0.513 $Y=0.0625 $X2=0.513 $Y2=0.082
r30 18 19 7.48304 $w=2.1e-08 $l=2.2e-08 $layer=Gate_1 $thickness=5.6e-08
+ $X=0.513 $Y=0.0405 $X2=0.513 $Y2=0.0625
r31 18 9 5.44221 $w=2.1e-08 $l=1.6e-08 $layer=Gate_1 $thickness=5.6e-08
+ $X=0.513 $Y=0.0405 $X2=0.513 $Y2=0.0245
.ends

.subckt PM_DHLx3_ASAP7_75t_R%Q vss 40 23 37 38 58 59 61 1 14 4 2 16 15 3 20 19
+ 13 21
c1 1 vss 0.00805541f $X=0.702 $Y=0.0405
c2 2 vss 0.00824458f $X=0.702 $Y=0.2295
c3 3 vss 0.00862261f $X=0.81 $Y=0.0675
c4 4 vss 0.00849836f $X=0.81 $Y=0.2025
c5 13 vss 0.037196f $X=0.704 $Y=0.0675
c6 14 vss 0.00441016f $X=0.7955 $Y=0.0675
c7 15 vss 0.0380207f $X=0.704 $Y=0.2025
c8 16 vss 0.00449201f $X=0.7955 $Y=0.2025
c9 17 vss 0.00291271f $X=0.891 $Y=0.036
c10 18 vss 0.00290318f $X=0.891 $Y=0.234
c11 19 vss 0.017284f $X=0.6905 $Y=0.036
c12 20 vss 0.0174578f $X=0.864 $Y=0.234
c13 21 vss 0.00772051f $X=0.891 $Y=0.0675
r1 61 60 0.0308642 $w=8.1e-08 $l=2.5e-09 $layer=P_src_drn $thickness=1e-09
+ $X=0.7193 $Y=0.2025 $X2=0.7165 $Y2=0.2025
r2 15 60 0.154321 $w=8.1e-08 $l=1.25e-08 $layer=P_src_drn $thickness=1e-09
+ $X=0.704 $Y=0.2025 $X2=0.7165 $Y2=0.2025
r3 59 57 0.0308642 $w=8.1e-08 $l=2.5e-09 $layer=P_src_drn $thickness=1e-09
+ $X=0.8273 $Y=0.2025 $X2=0.8245 $Y2=0.2025
r4 4 57 0.179012 $w=8.1e-08 $l=1.45e-08 $layer=P_src_drn $thickness=1e-09
+ $X=0.81 $Y=0.2025 $X2=0.8245 $Y2=0.2025
r5 16 4 0.179012 $w=8.1e-08 $l=1.45e-08 $layer=P_src_drn $thickness=1e-09
+ $X=0.7955 $Y=0.2025 $X2=0.81 $Y2=0.2025
r6 58 16 0.0308642 $w=8.1e-08 $l=2.5e-09 $layer=P_src_drn $thickness=1e-09
+ $X=0.7926 $Y=0.2025 $X2=0.7955 $Y2=0.2025
r7 2 51 19.3796 $a=3.24e-16 $layer=V0LISD $X=0.702 $Y=0.2295 $X2=0.702 $Y2=0.234
r8 4 45 19.3796 $a=3.24e-16 $layer=V0LISD $X=0.81 $Y=0.2025 $X2=0.81 $Y2=0.234
r9 51 52 3.14806 $w=1.3e-08 $l=1.35e-08 $layer=M1 $thickness=3.6e-08 $X=0.702
+ $Y=0.234 $X2=0.7155 $Y2=0.234
r10 49 52 3.14806 $w=1.3e-08 $l=1.35e-08 $layer=M1 $thickness=3.6e-08 $X=0.729
+ $Y=0.234 $X2=0.7155 $Y2=0.234
r11 48 49 6.29612 $w=1.3e-08 $l=2.7e-08 $layer=M1 $thickness=3.6e-08 $X=0.756
+ $Y=0.234 $X2=0.729 $Y2=0.234
r12 47 48 6.29612 $w=1.3e-08 $l=2.7e-08 $layer=M1 $thickness=3.6e-08 $X=0.783
+ $Y=0.234 $X2=0.756 $Y2=0.234
r13 45 46 3.14806 $w=1.3e-08 $l=1.35e-08 $layer=M1 $thickness=3.6e-08 $X=0.81
+ $Y=0.234 $X2=0.8235 $Y2=0.234
r14 44 45 3.14806 $w=1.3e-08 $l=1.35e-08 $layer=M1 $thickness=3.6e-08 $X=0.7965
+ $Y=0.234 $X2=0.81 $Y2=0.234
r15 44 47 3.14806 $w=1.3e-08 $l=1.35e-08 $layer=M1 $thickness=3.6e-08 $X=0.7965
+ $Y=0.234 $X2=0.783 $Y2=0.234
r16 43 46 3.14806 $w=1.3e-08 $l=1.35e-08 $layer=M1 $thickness=3.6e-08 $X=0.837
+ $Y=0.234 $X2=0.8235 $Y2=0.234
r17 20 43 6.29612 $w=1.3e-08 $l=2.7e-08 $layer=M1 $thickness=3.6e-08 $X=0.864
+ $Y=0.234 $X2=0.837 $Y2=0.234
r18 18 42 7.2121 $w=1.53211e-08 $l=3.8e-08 $layer=M1 $thickness=3.6e-08
+ $X=0.891 $Y=0.234 $X2=0.891 $Y2=0.196
r19 18 20 4.64701 $w=1.46667e-08 $l=2.7e-08 $layer=M1 $thickness=3.6e-08
+ $X=0.891 $Y=0.234 $X2=0.864 $Y2=0.234
r20 41 42 8.33653 $w=1.3e-08 $l=3.58e-08 $layer=M1 $thickness=3.6e-08 $X=0.891
+ $Y=0.1602 $X2=0.891 $Y2=0.196
r21 40 41 1.69063 $w=1.3e-08 $l=7.2e-09 $layer=M1 $thickness=3.6e-08 $X=0.893
+ $Y=0.153 $X2=0.891 $Y2=0.1602
r22 40 39 7.40378 $w=1.3e-08 $l=3.18e-08 $layer=M1 $thickness=3.6e-08 $X=0.893
+ $Y=0.153 $X2=0.891 $Y2=0.1212
r23 21 39 12.5339 $w=1.3e-08 $l=5.37e-08 $layer=M1 $thickness=3.6e-08 $X=0.891
+ $Y=0.0675 $X2=0.891 $Y2=0.1212
r24 38 36 0.0308642 $w=8.1e-08 $l=2.5e-09 $layer=N_src_drn $thickness=1e-09
+ $X=0.8273 $Y=0.0675 $X2=0.8245 $Y2=0.0675
r25 3 36 0.179012 $w=8.1e-08 $l=1.45e-08 $layer=N_src_drn $thickness=1e-09
+ $X=0.81 $Y=0.0675 $X2=0.8245 $Y2=0.0675
r26 14 3 0.179012 $w=8.1e-08 $l=1.45e-08 $layer=N_src_drn $thickness=1e-09
+ $X=0.7955 $Y=0.0675 $X2=0.81 $Y2=0.0675
r27 37 14 0.0308642 $w=8.1e-08 $l=2.5e-09 $layer=N_src_drn $thickness=1e-09
+ $X=0.7926 $Y=0.0675 $X2=0.7955 $Y2=0.0675
r28 17 34 4.64701 $w=1.46667e-08 $l=2.7e-08 $layer=M1 $thickness=3.6e-08
+ $X=0.891 $Y=0.036 $X2=0.864 $Y2=0.036
r29 17 21 5.69636 $w=1.58e-08 $l=3.15e-08 $layer=M1 $thickness=3.6e-08 $X=0.891
+ $Y=0.036 $X2=0.891 $Y2=0.0675
r30 3 31 19.3796 $a=3.24e-16 $layer=V0LISD $X=0.81 $Y=0.0675 $X2=0.81 $Y2=0.036
r31 33 34 6.29612 $w=1.3e-08 $l=2.7e-08 $layer=M1 $thickness=3.6e-08 $X=0.837
+ $Y=0.036 $X2=0.864 $Y2=0.036
r32 32 33 3.14806 $w=1.3e-08 $l=1.35e-08 $layer=M1 $thickness=3.6e-08 $X=0.8235
+ $Y=0.036 $X2=0.837 $Y2=0.036
r33 31 32 3.14806 $w=1.3e-08 $l=1.35e-08 $layer=M1 $thickness=3.6e-08 $X=0.81
+ $Y=0.036 $X2=0.8235 $Y2=0.036
r34 30 31 3.14806 $w=1.3e-08 $l=1.35e-08 $layer=M1 $thickness=3.6e-08 $X=0.7965
+ $Y=0.036 $X2=0.81 $Y2=0.036
r35 29 30 3.14806 $w=1.3e-08 $l=1.35e-08 $layer=M1 $thickness=3.6e-08 $X=0.783
+ $Y=0.036 $X2=0.7965 $Y2=0.036
r36 28 29 6.29612 $w=1.3e-08 $l=2.7e-08 $layer=M1 $thickness=3.6e-08 $X=0.756
+ $Y=0.036 $X2=0.783 $Y2=0.036
r37 27 28 6.29612 $w=1.3e-08 $l=2.7e-08 $layer=M1 $thickness=3.6e-08 $X=0.729
+ $Y=0.036 $X2=0.756 $Y2=0.036
r38 26 27 3.14806 $w=1.3e-08 $l=1.35e-08 $layer=M1 $thickness=3.6e-08 $X=0.7155
+ $Y=0.036 $X2=0.729 $Y2=0.036
r39 25 26 3.14806 $w=1.3e-08 $l=1.35e-08 $layer=M1 $thickness=3.6e-08 $X=0.702
+ $Y=0.036 $X2=0.7155 $Y2=0.036
r40 19 25 2.68168 $w=1.3e-08 $l=1.15e-08 $layer=M1 $thickness=3.6e-08 $X=0.6905
+ $Y=0.036 $X2=0.702 $Y2=0.036
r41 1 13 23.8708 $w=2.02e-08 $l=4.05e-08 $layer=LISD $thickness=2.7e-08
+ $X=0.702 $Y=0.0405 $X2=0.704 $Y2=0.0675
r42 1 25 19.3796 $a=3.24e-16 $layer=V0LISD $X=0.702 $Y=0.0405 $X2=0.702
+ $Y2=0.036
r43 23 22 0.0308642 $w=8.1e-08 $l=2.5e-09 $layer=N_src_drn $thickness=1e-09
+ $X=0.7193 $Y=0.0675 $X2=0.7165 $Y2=0.0675
r44 13 22 0.154321 $w=8.1e-08 $l=1.25e-08 $layer=N_src_drn $thickness=1e-09
+ $X=0.704 $Y=0.0675 $X2=0.7165 $Y2=0.0675
r45 2 15 1e-05 $l=2.7074e-08 $X=0.702 $Y=0.2295 $X2=0.704 $Y2=0.2025
.ends

.subckt PM_DHLx3_ASAP7_75t_R%10 vss 7 9 4 5 1
c1 1 vss 0.00821559f $X=0.351 $Y=0.0675
c2 4 vss 0.00291538f $X=0.3095 $Y=0.0675
c3 5 vss 0.00175915f $X=0.38 $Y=0.0675
r1 9 8 0.0308642 $w=8.1e-08 $l=2.5e-09 $layer=N_src_drn $thickness=1e-09
+ $X=0.3953 $Y=0.0675 $X2=0.3925 $Y2=0.0675
r2 5 8 0.154321 $w=8.1e-08 $l=1.25e-08 $layer=N_src_drn $thickness=1e-09
+ $X=0.38 $Y=0.0675 $X2=0.3925 $Y2=0.0675
r3 4 1 0.154321 $w=8.1e-08 $l=1.25e-08 $layer=N_src_drn $thickness=1e-09
+ $X=0.3095 $Y=0.0675 $X2=0.351 $Y2=0.0675
r4 7 4 0.0308642 $w=8.1e-08 $l=2.5e-09 $layer=N_src_drn $thickness=1e-09
+ $X=0.3066 $Y=0.0675 $X2=0.3095 $Y2=0.0675
r5 1 5 1e-05 $l=2.9e-08 $X=0.351 $Y=0.0675 $X2=0.38 $Y2=0.0675
.ends

.subckt PM_DHLx3_ASAP7_75t_R%11 vss 7 12 4 1 5
c1 1 vss 0.00625836f $X=0.432 $Y=0.2295
c2 4 vss 0.00175205f $X=0.4175 $Y=0.2295
c3 5 vss 0.00216732f $X=0.488 $Y=0.2295
r1 12 11 0.0925926 $w=2.7e-08 $l=2.5e-09 $layer=P_src_drn $thickness=1e-09
+ $X=0.5033 $Y=0.2295 $X2=0.5005 $Y2=0.2295
r2 5 11 0.462963 $w=2.7e-08 $l=1.25e-08 $layer=P_src_drn $thickness=1e-09
+ $X=0.488 $Y=0.2295 $X2=0.5005 $Y2=0.2295
r3 9 5 9.64198 $w=2.32e-08 $l=2.05e-08 $layer=LISD $thickness=2.7e-08 $X=0.4655
+ $Y=0.2295 $X2=0.488 $Y2=0.2295
r4 8 9 7.05511 $w=2.32e-08 $l=1.5e-08 $layer=LISD $thickness=2.7e-08 $X=0.4505
+ $Y=0.2295 $X2=0.4655 $Y2=0.2295
r5 1 8 8.7013 $w=2.32e-08 $l=1.85e-08 $layer=LISD $thickness=2.7e-08 $X=0.432
+ $Y=0.2295 $X2=0.4505 $Y2=0.2295
r6 4 1 0.462963 $w=2.7e-08 $l=1.25e-08 $layer=P_src_drn $thickness=1e-09
+ $X=0.4175 $Y=0.2295 $X2=0.432 $Y2=0.2295
r7 7 4 0.0925926 $w=2.7e-08 $l=2.5e-09 $layer=P_src_drn $thickness=1e-09
+ $X=0.4146 $Y=0.2295 $X2=0.4175 $Y2=0.2295
.ends

.subckt PM_DHLx3_ASAP7_75t_R%8 vss 39 45 92 95 99 103 106 109 113 117 120 123
+ 19 26 21 9 22 28 25 20 1 29 30 10 34 15 27 24 31 32 23 16 33 3 4 2 18 17
c1 1 vss 0.00108801f $X=0.567 $Y=0.124
c2 2 vss 0.00357804f $X=0.729 $Y=0.136
c3 3 vss 0.00323532f $X=0.783 $Y=0.136
c4 4 vss 0.00441691f $X=0.837 $Y=0.136
c5 9 vss 0.00587441f $X=0.378 $Y=0.2295
c6 10 vss 0.00482635f $X=0.432 $Y=0.0405
c7 15 vss 0.0509975f $X=0.567 $Y=0.0245
c8 16 vss 0.0846561f $X=0.729 $Y=0.136
c9 17 vss 0.0804392f $X=0.783 $Y=0.136
c10 18 vss 0.0848748f $X=0.837 $Y=0.136
c11 19 vss 0.00338145f $X=0.4175 $Y=0.0405
c12 20 vss 0.00205108f $X=0.4175 $Y=0.081
c13 21 vss 0.00349429f $X=0.3635 $Y=0.2295
c14 22 vss 0.00208842f $X=0.3635 $Y=0.189
c15 23 vss 0.00272729f $X=0.459 $Y=0.036
c16 24 vss 5.72287e-20 $X=0.459 $Y=0.13
c17 25 vss 0.00276989f $X=0.459 $Y=0.234
c18 26 vss 0.00753078f $X=0.432 $Y=0.234
c19 27 vss 0.00411517f $X=0.432 $Y=0.036
c20 28 vss 0.0012474f $X=0.459 $Y=0.1135
c21 29 vss 0.000691095f $X=0.459 $Y=0.1415
c22 30 vss 0.0010489f $X=0.54 $Y=0.13
c23 31 vss 0.00230884f $X=0.729 $Y=0.1085
c24 32 vss 0.00185219f $X=0.783 $Y=0.1085
c25 33 vss 0.00286244f $X=0.837 $Y=0.1085
c26 34 vss 0.0144777f $X=0.459 $Y=0.153
r1 22 9 0.231482 $w=5.4e-08 $l=1.25e-08 $layer=P_src_drn $thickness=1e-09
+ $X=0.3635 $Y=0.189 $X2=0.378 $Y2=0.2295
r2 123 122 0.0925926 $w=2.7e-08 $l=2.5e-09 $layer=P_src_drn $thickness=1e-09
+ $X=0.3953 $Y=0.2295 $X2=0.3925 $Y2=0.2295
r3 121 122 0.166667 $w=2.7e-08 $l=4.5e-09 $layer=P_src_drn $thickness=1e-09
+ $X=0.388 $Y=0.2295 $X2=0.3925 $Y2=0.2295
r4 9 121 0.444445 $w=2.7e-08 $l=1.2e-08 $layer=P_src_drn $thickness=1e-09
+ $X=0.378 $Y=0.2295 $X2=0.388 $Y2=0.2295
r5 21 9 0.462963 $w=2.7e-08 $l=1.25e-08 $layer=P_src_drn $thickness=1e-09
+ $X=0.3635 $Y=0.2295 $X2=0.378 $Y2=0.2295
r6 120 21 0.0925926 $w=2.7e-08 $l=2.5e-09 $layer=P_src_drn $thickness=1e-09
+ $X=0.3606 $Y=0.2025 $X2=0.3635 $Y2=0.2295
r7 117 116 14.6259 $w=2.1e-08 $l=4.3e-08 $layer=Gate_1 $thickness=5.6e-08
+ $X=0.837 $Y=0.2025 $X2=0.837 $Y2=0.1595
r8 115 116 2.55104 $w=2.1e-08 $l=7.5e-09 $layer=Gate_1 $thickness=5.6e-08
+ $X=0.837 $Y=0.152 $X2=0.837 $Y2=0.1595
r9 113 114 14.6259 $w=2.1e-08 $l=4.3e-08 $layer=Gate_1 $thickness=5.6e-08
+ $X=0.837 $Y=0.0675 $X2=0.837 $Y2=0.1105
r10 111 114 2.89117 $w=2.1e-08 $l=8.5e-09 $layer=Gate_1 $thickness=5.6e-08
+ $X=0.837 $Y=0.119 $X2=0.837 $Y2=0.1105
r11 18 111 5.96942 $w=2.03529e-08 $l=1.7e-08 $layer=Gate_1 $thickness=5.6e-08
+ $X=0.837 $Y=0.136 $X2=0.837 $Y2=0.119
r12 18 115 5.62929 $w=2.03125e-08 $l=1.6e-08 $layer=Gate_1 $thickness=5.6e-08
+ $X=0.837 $Y=0.136 $X2=0.837 $Y2=0.152
r13 109 108 16.3266 $w=2.1e-08 $l=4.8e-08 $layer=Gate_1 $thickness=5.6e-08
+ $X=0.783 $Y=0.2025 $X2=0.783 $Y2=0.1545
r14 106 107 16.6668 $w=2.1e-08 $l=4.9e-08 $layer=Gate_1 $thickness=5.6e-08
+ $X=0.783 $Y=0.0675 $X2=0.783 $Y2=0.1165
r15 17 107 6.81977 $w=2.04359e-08 $l=1.95e-08 $layer=Gate_1 $thickness=5.6e-08
+ $X=0.783 $Y=0.136 $X2=0.783 $Y2=0.1165
r16 17 108 6.47963 $w=2.04054e-08 $l=1.85e-08 $layer=Gate_1 $thickness=5.6e-08
+ $X=0.783 $Y=0.136 $X2=0.783 $Y2=0.1545
r17 103 102 14.6259 $w=2.1e-08 $l=4.3e-08 $layer=Gate_1 $thickness=5.6e-08
+ $X=0.729 $Y=0.2025 $X2=0.729 $Y2=0.1595
r18 101 102 2.55104 $w=2.1e-08 $l=7.5e-09 $layer=Gate_1 $thickness=5.6e-08
+ $X=0.729 $Y=0.152 $X2=0.729 $Y2=0.1595
r19 99 100 14.6259 $w=2.1e-08 $l=4.3e-08 $layer=Gate_1 $thickness=5.6e-08
+ $X=0.729 $Y=0.0675 $X2=0.729 $Y2=0.1105
r20 97 100 2.89117 $w=2.1e-08 $l=8.5e-09 $layer=Gate_1 $thickness=5.6e-08
+ $X=0.729 $Y=0.119 $X2=0.729 $Y2=0.1105
r21 16 97 5.96942 $w=2.03529e-08 $l=1.7e-08 $layer=Gate_1 $thickness=5.6e-08
+ $X=0.729 $Y=0.136 $X2=0.729 $Y2=0.119
r22 16 101 5.62929 $w=2.03125e-08 $l=1.6e-08 $layer=Gate_1 $thickness=5.6e-08
+ $X=0.729 $Y=0.136 $X2=0.729 $Y2=0.152
r23 20 81 0.231482 $w=5.4e-08 $l=1.25e-08 $layer=N_src_drn $thickness=1e-09
+ $X=0.4175 $Y=0.081 $X2=0.432 $Y2=0.081
r24 95 94 0.0925926 $w=2.7e-08 $l=2.5e-09 $layer=N_src_drn $thickness=1e-09
+ $X=0.4493 $Y=0.0405 $X2=0.4465 $Y2=0.0405
r25 93 94 0.166667 $w=2.7e-08 $l=4.5e-09 $layer=N_src_drn $thickness=1e-09
+ $X=0.442 $Y=0.0405 $X2=0.4465 $Y2=0.0405
r26 81 93 0.444445 $w=2.7e-08 $l=1.2e-08 $layer=N_src_drn $thickness=1e-09
+ $X=0.432 $Y=0.081 $X2=0.442 $Y2=0.0405
r27 19 81 0.462963 $w=2.7e-08 $l=1.25e-08 $layer=N_src_drn $thickness=1e-09
+ $X=0.4175 $Y=0.0405 $X2=0.432 $Y2=0.081
r28 92 19 0.0925926 $w=2.7e-08 $l=2.5e-09 $layer=N_src_drn $thickness=1e-09
+ $X=0.4146 $Y=0.0675 $X2=0.4175 $Y2=0.0405
r29 9 80 19.3796 $a=3.24e-16 $layer=V0LISD $X=0.378 $Y=0.2295 $X2=0.374
+ $Y2=0.234
r30 4 74 19.3796 $a=3.24e-16 $layer=V0LIG $X=0.837 $Y=0.136 $X2=0.837 $Y2=0.1445
r31 4 18 6.54019 $w=2.09524e-08 $layer=Gate_1 $thickness=5.21905e-08 $X=0.837
+ $Y=0.136 $X2=0.837 $Y2=0.136
r32 3 72 19.3796 $a=3.24e-16 $layer=V0LIG $X=0.783 $Y=0.136 $X2=0.783 $Y2=0.1445
r33 3 17 6.54019 $w=2.09524e-08 $layer=Gate_1 $thickness=5.21905e-08 $X=0.783
+ $Y=0.136 $X2=0.783 $Y2=0.136
r34 2 70 19.3796 $a=3.24e-16 $layer=V0LIG $X=0.729 $Y=0.136 $X2=0.729 $Y2=0.1445
r35 2 16 6.54019 $w=2.09524e-08 $layer=Gate_1 $thickness=5.21905e-08 $X=0.729
+ $Y=0.136 $X2=0.729 $Y2=0.136
r36 10 27 19.3796 $a=3.24e-16 $layer=V0LISD $X=0.432 $Y=0.0405 $X2=0.432
+ $Y2=0.036
r37 10 81 23.8708 $w=2.02e-08 $l=4.05e-08 $layer=LISD $thickness=2.7e-08
+ $X=0.432 $Y=0.0405 $X2=0.432 $Y2=0.081
r38 77 78 1.98211 $w=1.3e-08 $l=8.5e-09 $layer=M1 $thickness=3.6e-08 $X=0.383
+ $Y=0.234 $X2=0.3915 $Y2=0.234
r39 77 80 2.09871 $w=1.3e-08 $l=9e-09 $layer=M1 $thickness=3.6e-08 $X=0.383
+ $Y=0.234 $X2=0.374 $Y2=0.234
r40 76 78 3.14806 $w=1.3e-08 $l=1.35e-08 $layer=M1 $thickness=3.6e-08 $X=0.405
+ $Y=0.234 $X2=0.3915 $Y2=0.234
r41 26 76 6.29612 $w=1.3e-08 $l=2.7e-08 $layer=M1 $thickness=3.6e-08 $X=0.432
+ $Y=0.234 $X2=0.405 $Y2=0.234
r42 33 74 8.39483 $w=1.3e-08 $l=3.6e-08 $layer=M1 $thickness=3.6e-08 $X=0.837
+ $Y=0.1085 $X2=0.837 $Y2=0.1445
r43 32 72 8.39483 $w=1.3e-08 $l=3.6e-08 $layer=M1 $thickness=3.6e-08 $X=0.783
+ $Y=0.1085 $X2=0.783 $Y2=0.1445
r44 31 70 8.39483 $w=1.3e-08 $l=3.6e-08 $layer=M1 $thickness=3.6e-08 $X=0.729
+ $Y=0.1085 $X2=0.729 $Y2=0.1445
r45 25 61 2.5483 $w=1.79e-08 $l=1.8e-08 $layer=M1 $thickness=3.6e-08 $X=0.459
+ $Y=0.234 $X2=0.459 $Y2=0.216
r46 25 26 4.64701 $w=1.46667e-08 $l=2.7e-08 $layer=M1 $thickness=3.6e-08
+ $X=0.459 $Y=0.234 $X2=0.432 $Y2=0.234
r47 68 74 19.5347 $a=3.24e-16 $layer=V1 $X=0.837 $Y=0.153 $X2=0.837 $Y2=0.1445
r48 67 68 6.29612 $w=1.3e-08 $l=2.7e-08 $layer=M2 $thickness=3.6e-08 $X=0.81
+ $Y=0.153 $X2=0.837 $Y2=0.153
r49 66 67 6.29612 $w=1.3e-08 $l=2.7e-08 $layer=M2 $thickness=3.6e-08 $X=0.783
+ $Y=0.153 $X2=0.81 $Y2=0.153
r50 66 72 19.5347 $a=3.24e-16 $layer=V1 $X=0.783 $Y=0.153 $X2=0.783 $Y2=0.1445
r51 65 66 6.29612 $w=1.3e-08 $l=2.7e-08 $layer=M2 $thickness=3.6e-08 $X=0.756
+ $Y=0.153 $X2=0.783 $Y2=0.153
r52 64 65 6.29612 $w=1.3e-08 $l=2.7e-08 $layer=M2 $thickness=3.6e-08 $X=0.729
+ $Y=0.153 $X2=0.756 $Y2=0.153
r53 64 70 19.5347 $a=3.24e-16 $layer=V1 $X=0.729 $Y=0.153 $X2=0.729 $Y2=0.1445
r54 63 64 24.6015 $w=1.3e-08 $l=1.055e-07 $layer=M2 $thickness=3.6e-08
+ $X=0.6235 $Y=0.153 $X2=0.729 $Y2=0.153
r55 62 63 29.3819 $w=1.3e-08 $l=1.26e-07 $layer=M2 $thickness=3.6e-08 $X=0.4975
+ $Y=0.153 $X2=0.6235 $Y2=0.153
r56 34 62 8.97781 $w=1.3e-08 $l=3.85e-08 $layer=M2 $thickness=3.6e-08 $X=0.459
+ $Y=0.153 $X2=0.4975 $Y2=0.153
r57 34 56 19.5347 $a=3.24e-16 $layer=V1 $X=0.459 $Y=0.153 $X2=0.459 $Y2=0.153
r58 23 55 6.39593 $w=1.55565e-08 $l=3.45e-08 $layer=M1 $thickness=3.6e-08
+ $X=0.459 $Y=0.036 $X2=0.459 $Y2=0.0705
r59 23 27 4.64701 $w=1.46667e-08 $l=2.7e-08 $layer=M1 $thickness=3.6e-08
+ $X=0.459 $Y=0.036 $X2=0.432 $Y2=0.036
r60 60 61 4.19742 $w=1.3e-08 $l=1.8e-08 $layer=M1 $thickness=3.6e-08 $X=0.459
+ $Y=0.198 $X2=0.459 $Y2=0.216
r61 59 60 4.19742 $w=1.3e-08 $l=1.8e-08 $layer=M1 $thickness=3.6e-08 $X=0.459
+ $Y=0.18 $X2=0.459 $Y2=0.198
r62 58 59 2.91487 $w=1.3e-08 $l=1.25e-08 $layer=M1 $thickness=3.6e-08 $X=0.459
+ $Y=0.1675 $X2=0.459 $Y2=0.18
r63 57 58 1.04935 $w=1.3e-08 $l=4.5e-09 $layer=M1 $thickness=3.6e-08 $X=0.459
+ $Y=0.163 $X2=0.459 $Y2=0.1675
r64 56 57 2.3319 $w=1.3e-08 $l=1e-08 $layer=M1 $thickness=3.6e-08 $X=0.459
+ $Y=0.153 $X2=0.459 $Y2=0.163
r65 29 56 2.68168 $w=1.3e-08 $l=1.15e-08 $layer=M1 $thickness=3.6e-08 $X=0.459
+ $Y=0.1415 $X2=0.459 $Y2=0.153
r66 54 55 7.11229 $w=1.3e-08 $l=3.05e-08 $layer=M1 $thickness=3.6e-08 $X=0.459
+ $Y=0.101 $X2=0.459 $Y2=0.0705
r67 28 54 2.91487 $w=1.3e-08 $l=1.25e-08 $layer=M1 $thickness=3.6e-08 $X=0.459
+ $Y=0.1135 $X2=0.459 $Y2=0.101
r68 24 52 5.11582 $w=1.46667e-08 $l=2.7e-08 $layer=M1 $thickness=3.6e-08
+ $X=0.459 $Y=0.13 $X2=0.486 $Y2=0.13
r69 24 28 2.66732 $w=1.57273e-08 $l=1.65e-08 $layer=M1 $thickness=3.6e-08
+ $X=0.459 $Y=0.13 $X2=0.459 $Y2=0.1135
r70 24 29 1.50137 $w=1.6913e-08 $l=1.15e-08 $layer=M1 $thickness=3.6e-08
+ $X=0.459 $Y=0.13 $X2=0.459 $Y2=0.1415
r71 51 52 6.29612 $w=1.3e-08 $l=2.7e-08 $layer=M1 $thickness=3.6e-08 $X=0.513
+ $Y=0.13 $X2=0.486 $Y2=0.13
r72 30 49 6.29612 $w=1.3e-08 $l=2.7e-08 $layer=M1 $thickness=3.6e-08 $X=0.54
+ $Y=0.13 $X2=0.567 $Y2=0.13
r73 30 51 6.29612 $w=1.3e-08 $l=2.7e-08 $layer=M1 $thickness=3.6e-08 $X=0.54
+ $Y=0.13 $X2=0.513 $Y2=0.13
r74 48 49 19.3796 $a=3.24e-16 $layer=V0LIG $X=0.567 $Y=0.133 $X2=0.567 $Y2=0.13
r75 1 42 4.51932 $w=1.96083e-08 $l=6e-09 $layer=Gate_1 $thickness=5.53333e-08
+ $X=0.567 $Y=0.124 $X2=0.567 $Y2=0.13
r76 1 47 1.77217 $w=1.53e-08 $l=3e-09 $layer=LIG $thickness=4.8e-08 $X=0.567
+ $Y=0.124 $X2=0.567 $Y2=0.121
r77 1 48 5.31651 $w=1.53e-08 $l=9e-09 $layer=LIG $thickness=4.8e-08 $X=0.567
+ $Y=0.124 $X2=0.567 $Y2=0.133
r78 45 44 14.6259 $w=2.1e-08 $l=4.3e-08 $layer=Gate_1 $thickness=5.6e-08
+ $X=0.567 $Y=0.2295 $X2=0.567 $Y2=0.1865
r79 43 44 12.7552 $w=2.1e-08 $l=3.75e-08 $layer=Gate_1 $thickness=5.6e-08
+ $X=0.567 $Y=0.149 $X2=0.567 $Y2=0.1865
r80 42 43 6.6497 $w=2.04211e-08 $l=1.9e-08 $layer=Gate_1 $thickness=5.6e-08
+ $X=0.567 $Y=0.13 $X2=0.567 $Y2=0.149
r81 42 47 5.11004 $w=1.92769e-08 $l=9e-09 $layer=Gate_1 $thickness=5.47692e-08
+ $X=0.567 $Y=0.13 $X2=0.567 $Y2=0.121
r82 41 42 4.94901 $w=2.02143e-08 $l=1.4e-08 $layer=Gate_1 $thickness=5.6e-08
+ $X=0.567 $Y=0.116 $X2=0.567 $Y2=0.13
r83 40 41 11.0545 $w=2.1e-08 $l=3.25e-08 $layer=Gate_1 $thickness=5.6e-08
+ $X=0.567 $Y=0.0835 $X2=0.567 $Y2=0.116
r84 39 40 14.6259 $w=2.1e-08 $l=4.3e-08 $layer=Gate_1 $thickness=5.6e-08
+ $X=0.567 $Y=0.0405 $X2=0.567 $Y2=0.0835
r85 39 15 5.44221 $w=2.1e-08 $l=1.6e-08 $layer=Gate_1 $thickness=5.6e-08
+ $X=0.567 $Y=0.0405 $X2=0.567 $Y2=0.0245
.ends

.subckt PM_DHLx3_ASAP7_75t_R%12 vss 2 3 1
c1 1 vss 0.000538977f $X=0.486 $Y=0.0405
r1 2 1 0.62963 $w=2.7e-08 $l=1.7e-08 $layer=N_src_drn $thickness=1e-09
+ $X=0.4686 $Y=0.0405 $X2=0.486 $Y2=0.0405
r2 3 1 0.62963 $w=2.7e-08 $l=1.7e-08 $layer=N_src_drn $thickness=1e-09
+ $X=0.5033 $Y=0.0405 $X2=0.486 $Y2=0.0405
.ends

.subckt PM_DHLx3_ASAP7_75t_R%4 vss 38 44 93 104 108 110 20 22 23 7 6 17 18 30 1
+ 28 25 29 33 27 14 24 2 15 31 3 16 8 32
c1 1 vss 0.00340432f $X=0.134 $Y=0.135
c2 2 vss 0.000360722f $X=0.351 $Y=0.1235
c3 3 vss 0.000124513f $X=0.459 $Y=0.179
c4 6 vss 0.00798282f $X=0.054 $Y=0.054
c5 7 vss 0.00789097f $X=0.054 $Y=0.216
c6 8 vss 0.00896993f $X=0.501 $Y=0.179
c7 14 vss 0.0686719f $X=0.135 $Y=0.0245
c8 15 vss 0.00789733f $X=0.351 $Y=0.0725
c9 16 vss 0.00658654f $X=0.459 $Y=0.179
c10 17 vss 0.0311904f $X=0.056 $Y=0.054
c11 18 vss 0.031137f $X=0.056 $Y=0.216
c12 19 vss 0.00366635f $X=0.018 $Y=0.036
c13 20 vss 0.00257083f $X=0.0165 $Y=0.189
c14 21 vss 0.00353266f $X=0.018 $Y=0.234
c15 22 vss 0.0012407f $X=0.189 $Y=0.189
c16 23 vss 0.000604855f $X=0.189 $Y=0.135
c17 24 vss 0.00126434f $X=0.351 $Y=0.198
c18 25 vss 0.00900444f $X=0.018 $Y=0.1665
c19 26 vss 0.00201536f $X=0.018 $Y=0.2115
c20 27 vss 0.00469589f $X=0.036 $Y=0.036
c21 28 vss 0.00383278f $X=0.036 $Y=0.234
c22 29 vss 0.000788994f $X=0.1405 $Y=0.135
c23 30 vss 0.000501949f $X=0.189 $Y=0.1485
c24 31 vss 0.00114394f $X=0.351 $Y=0.1755
c25 32 vss 0.00178777f $X=0.513 $Y=0.1675
c26 33 vss 0.0234648f $X=0.0215 $Y=0.189
r1 110 109 0.0462963 $w=5.4e-08 $l=2.5e-09 $layer=P_src_drn $thickness=1e-09
+ $X=0.0713 $Y=0.216 $X2=0.0685 $Y2=0.216
r2 18 109 0.231482 $w=5.4e-08 $l=1.25e-08 $layer=P_src_drn $thickness=1e-09
+ $X=0.056 $Y=0.216 $X2=0.0685 $Y2=0.216
r3 108 107 0.0462963 $w=5.4e-08 $l=2.5e-09 $layer=N_src_drn $thickness=1e-09
+ $X=0.0713 $Y=0.054 $X2=0.0685 $Y2=0.054
r4 17 107 0.231482 $w=5.4e-08 $l=1.25e-08 $layer=N_src_drn $thickness=1e-09
+ $X=0.056 $Y=0.054 $X2=0.0685 $Y2=0.054
r5 7 101 19.3796 $a=3.24e-16 $layer=V0LISD $X=0.054 $Y=0.216 $X2=0.055 $Y2=0.234
r6 6 98 19.3796 $a=3.24e-16 $layer=V0LISD $X=0.054 $Y=0.054 $X2=0.055 $Y2=0.036
r7 104 105 23.4695 $w=2.1e-08 $l=6.9e-08 $layer=Gate_1 $thickness=5.6e-08
+ $X=0.459 $Y=0.0405 $X2=0.459 $Y2=0.1095
r8 16 105 23.8777 $w=2.07986e-08 $l=6.95e-08 $layer=Gate_1 $thickness=5.6e-08
+ $X=0.459 $Y=0.179 $X2=0.459 $Y2=0.1095
r9 100 101 2.09871 $w=1.3e-08 $l=9e-09 $layer=M1 $thickness=3.6e-08 $X=0.046
+ $Y=0.234 $X2=0.055 $Y2=0.234
r10 28 100 2.3319 $w=1.3e-08 $l=1e-08 $layer=M1 $thickness=3.6e-08 $X=0.036
+ $Y=0.234 $X2=0.046 $Y2=0.234
r11 97 98 2.09871 $w=1.3e-08 $l=9e-09 $layer=M1 $thickness=3.6e-08 $X=0.046
+ $Y=0.036 $X2=0.055 $Y2=0.036
r12 27 97 2.3319 $w=1.3e-08 $l=1e-08 $layer=M1 $thickness=3.6e-08 $X=0.036
+ $Y=0.036 $X2=0.046 $Y2=0.036
r13 3 86 5.67512 $w=2.4e-08 $l=5e-09 $layer=LISD $thickness=4.02632e-08
+ $X=0.459 $Y=0.179 $X2=0.464 $Y2=0.179
r14 3 16 7.56983 $w=2.18462e-08 $layer=Gate_1 $thickness=5.23077e-08 $X=0.459
+ $Y=0.179 $X2=0.459 $Y2=0.179
r15 93 92 16.6668 $w=2.1e-08 $l=4.9e-08 $layer=Gate_1 $thickness=5.6e-08
+ $X=0.351 $Y=0.2025 $X2=0.351 $Y2=0.1535
r16 91 92 6.81977 $w=2.04359e-08 $l=1.95e-08 $layer=Gate_1 $thickness=5.6e-08
+ $X=0.351 $Y=0.134 $X2=0.351 $Y2=0.1535
r17 15 91 21.1056 $w=2.08211e-08 $l=6.15e-08 $layer=Gate_1 $thickness=5.6e-08
+ $X=0.351 $Y=0.0725 $X2=0.351 $Y2=0.134
r18 21 26 3.59766 $w=1.692e-08 $l=2.25e-08 $layer=M1 $thickness=3.6e-08
+ $X=0.018 $Y=0.234 $X2=0.018 $Y2=0.2115
r19 21 28 2.5483 $w=1.55e-08 $l=1.8e-08 $layer=M1 $thickness=3.6e-08 $X=0.018
+ $Y=0.234 $X2=0.036 $Y2=0.234
r20 19 81 4.64701 $w=1.62667e-08 $l=2.7e-08 $layer=M1 $thickness=3.6e-08
+ $X=0.018 $Y=0.036 $X2=0.018 $Y2=0.063
r21 19 27 2.5483 $w=1.55e-08 $l=1.8e-08 $layer=M1 $thickness=3.6e-08 $X=0.018
+ $Y=0.036 $X2=0.036 $Y2=0.036
r22 85 86 11.0623 $w=2.14976e-08 $l=2.05e-08 $layer=LISD $thickness=2.7e-08
+ $X=0.4845 $Y=0.179 $X2=0.464 $Y2=0.179
r23 8 83 7.07284 $w=2.02e-08 $l=1.2e-08 $layer=LISD $thickness=2.7e-08 $X=0.501
+ $Y=0.179 $X2=0.513 $Y2=0.179
r24 8 85 9.72516 $w=2.02e-08 $l=1.65e-08 $layer=LISD $thickness=2.7e-08
+ $X=0.501 $Y=0.179 $X2=0.4845 $Y2=0.179
r25 82 91 10.1312 $w=1.77047e-08 $l=5e-10 $layer=LIG $thickness=5.2093e-08
+ $X=0.351 $Y=0.1345 $X2=0.351 $Y2=0.134
r26 2 82 6.49795 $w=1.53e-08 $l=1.1e-08 $layer=LIG $thickness=4.8e-08 $X=0.351
+ $Y=0.1235 $X2=0.351 $Y2=0.1345
r27 2 15 17.4723 $w=2.09441e-08 $l=5.1e-08 $layer=Gate_1 $thickness=5.59216e-08
+ $X=0.351 $Y=0.1235 $X2=0.351 $Y2=0.0725
r28 80 81 8.39483 $w=1.3e-08 $l=3.6e-08 $layer=M1 $thickness=3.6e-08 $X=0.018
+ $Y=0.099 $X2=0.018 $Y2=0.063
r29 79 80 8.39483 $w=1.3e-08 $l=3.6e-08 $layer=M1 $thickness=3.6e-08 $X=0.018
+ $Y=0.135 $X2=0.018 $Y2=0.099
r30 25 79 7.34548 $w=1.3e-08 $l=3.15e-08 $layer=M1 $thickness=3.6e-08 $X=0.018
+ $Y=0.1665 $X2=0.018 $Y2=0.135
r31 77 83 19.3796 $a=3.24e-16 $layer=V0LISD $X=0.513 $Y=0.1845 $X2=0.513
+ $Y2=0.179
r32 32 77 3.96423 $w=1.3e-08 $l=1.7e-08 $layer=M1 $thickness=3.6e-08 $X=0.513
+ $Y=0.1675 $X2=0.513 $Y2=0.1845
r33 75 76 5.36336 $w=1.3e-08 $l=2.3e-08 $layer=M1 $thickness=3.6e-08 $X=0.351
+ $Y=0.134 $X2=0.351 $Y2=0.157
r34 75 82 19.3796 $a=3.24e-16 $layer=V0LIG $X=0.351 $Y=0.134 $X2=0.351
+ $Y2=0.1345
r35 31 73 2.09871 $w=1.3e-08 $l=9e-09 $layer=M1 $thickness=3.6e-08 $X=0.351
+ $Y=0.1755 $X2=0.351 $Y2=0.1845
r36 31 76 4.31401 $w=1.3e-08 $l=1.85e-08 $layer=M1 $thickness=3.6e-08 $X=0.351
+ $Y=0.1755 $X2=0.351 $Y2=0.157
r37 24 62 39.0693 $a=1.62e-16 $layer=V1 $X=0.351 $Y=0.198 $X2=0.351 $Y2=0.189
r38 24 73 1.96775 $w=1.63333e-08 $l=1.35e-08 $layer=M1 $thickness=3.6e-08
+ $X=0.351 $Y=0.198 $X2=0.351 $Y2=0.1845
r39 68 69 1.90199 $w=1.38333e-08 $l=9e-09 $layer=M1 $thickness=3.6e-08
+ $X=0.0255 $Y=0.189 $X2=0.0345 $Y2=0.189
r40 20 68 0.9184 $w=1.8e-08 $l=9e-09 $layer=M1 $thickness=3.6e-08 $X=0.0165
+ $Y=0.189 $X2=0.0255 $Y2=0.189
r41 20 25 3.9134 $w=1.47857e-08 $l=2.25499e-08 $layer=M1 $thickness=3.6e-08
+ $X=0.0165 $Y=0.189 $X2=0.018 $Y2=0.1665
r42 20 26 3.9134 $w=1.47857e-08 $l=2.25499e-08 $layer=M1 $thickness=3.6e-08
+ $X=0.0165 $Y=0.189 $X2=0.018 $Y2=0.2115
r43 66 77 19.5347 $a=3.24e-16 $layer=V1 $X=0.513 $Y=0.189 $X2=0.513 $Y2=0.1845
r44 65 66 8.39483 $w=1.3e-08 $l=3.6e-08 $layer=M2 $thickness=3.6e-08 $X=0.477
+ $Y=0.189 $X2=0.513 $Y2=0.189
r45 64 65 10.4935 $w=1.3e-08 $l=4.5e-08 $layer=M2 $thickness=3.6e-08 $X=0.432
+ $Y=0.189 $X2=0.477 $Y2=0.189
r46 63 64 10.4935 $w=1.3e-08 $l=4.5e-08 $layer=M2 $thickness=3.6e-08 $X=0.387
+ $Y=0.189 $X2=0.432 $Y2=0.189
r47 62 63 8.39483 $w=1.3e-08 $l=3.6e-08 $layer=M2 $thickness=3.6e-08 $X=0.351
+ $Y=0.189 $X2=0.387 $Y2=0.189
r48 62 73 39.0693 $a=1.62e-16 $layer=V1 $X=0.351 $Y=0.189 $X2=0.351 $Y2=0.1845
r49 61 62 15.2739 $w=1.3e-08 $l=6.55e-08 $layer=M2 $thickness=3.6e-08 $X=0.2855
+ $Y=0.189 $X2=0.351 $Y2=0.189
r50 60 61 19.9377 $w=1.3e-08 $l=8.55e-08 $layer=M2 $thickness=3.6e-08 $X=0.2
+ $Y=0.189 $X2=0.2855 $Y2=0.189
r51 59 60 8.86121 $w=1.3e-08 $l=3.8e-08 $layer=M2 $thickness=3.6e-08 $X=0.162
+ $Y=0.189 $X2=0.2 $Y2=0.189
r52 58 59 15.0407 $w=1.3e-08 $l=6.45e-08 $layer=M2 $thickness=3.6e-08 $X=0.0975
+ $Y=0.189 $X2=0.162 $Y2=0.189
r53 57 58 15.0407 $w=1.3e-08 $l=6.45e-08 $layer=M2 $thickness=3.6e-08 $X=0.033
+ $Y=0.189 $X2=0.0975 $Y2=0.189
r54 57 69 19.5347 $a=3.24e-16 $layer=V1 $X=0.033 $Y=0.189 $X2=0.0345 $Y2=0.189
r55 33 57 2.68168 $w=1.3e-08 $l=1.15e-08 $layer=M2 $thickness=3.6e-08 $X=0.0215
+ $Y=0.189 $X2=0.033 $Y2=0.189
r56 55 56 3.14806 $w=1.3e-08 $l=1.35e-08 $layer=M1 $thickness=3.6e-08 $X=0.162
+ $Y=0.189 $X2=0.1755 $Y2=0.189
r57 55 59 19.5347 $a=3.24e-16 $layer=V1 $X=0.162 $Y=0.189 $X2=0.162 $Y2=0.189
r58 22 53 4.06646 $w=1.5e-08 $l=2.25e-08 $layer=M1 $thickness=3.6e-08 $X=0.189
+ $Y=0.189 $X2=0.189 $Y2=0.1665
r59 22 56 1.96775 $w=1.63333e-08 $l=1.35e-08 $layer=M1 $thickness=3.6e-08
+ $X=0.189 $Y=0.189 $X2=0.1755 $Y2=0.189
r60 30 53 4.19742 $w=1.3e-08 $l=1.8e-08 $layer=M1 $thickness=3.6e-08 $X=0.189
+ $Y=0.1485 $X2=0.189 $Y2=0.1665
r61 23 52 2.6649 $w=1.54324e-08 $l=1.85e-08 $layer=M1 $thickness=3.6e-08
+ $X=0.189 $Y=0.135 $X2=0.1705 $Y2=0.135
r62 23 30 1.49895 $w=1.95333e-08 $l=1.35e-08 $layer=M1 $thickness=3.6e-08
+ $X=0.189 $Y=0.135 $X2=0.189 $Y2=0.1485
r63 51 52 3.73104 $w=1.3e-08 $l=1.6e-08 $layer=M1 $thickness=3.6e-08 $X=0.1545
+ $Y=0.135 $X2=0.1705 $Y2=0.135
r64 50 51 2.09871 $w=1.3e-08 $l=9e-09 $layer=M1 $thickness=3.6e-08 $X=0.1455
+ $Y=0.135 $X2=0.1545 $Y2=0.135
r65 29 50 1.16595 $w=1.3e-08 $l=5e-09 $layer=M1 $thickness=3.6e-08 $X=0.1405
+ $Y=0.135 $X2=0.1455 $Y2=0.135
r66 48 51 19.3796 $a=3.24e-16 $layer=V0LIG $X=0.153 $Y=0.135 $X2=0.1545
+ $Y2=0.135
r67 46 48 4.98695 $w=1.60444e-08 $l=9e-09 $layer=LIG $thickness=4.8e-08
+ $X=0.144 $Y=0.135 $X2=0.153 $Y2=0.135
r68 1 46 2.6116 $w=2.2e-08 $l=1e-08 $layer=LIG $thickness=4.8e-08 $X=0.134
+ $Y=0.135 $X2=0.144 $Y2=0.135
r69 1 41 6.27904 $w=2.09e-08 $l=1e-09 $layer=Gate_1 $thickness=5.24e-08
+ $X=0.134 $Y=0.135 $X2=0.135 $Y2=0.135
r70 44 43 14.6259 $w=2.1e-08 $l=4.3e-08 $layer=Gate_1 $thickness=5.6e-08
+ $X=0.135 $Y=0.216 $X2=0.135 $Y2=0.173
r71 42 43 7.31297 $w=2.1e-08 $l=2.15e-08 $layer=Gate_1 $thickness=5.6e-08
+ $X=0.135 $Y=0.1515 $X2=0.135 $Y2=0.173
r72 41 42 5.79936 $w=2.03333e-08 $l=1.65e-08 $layer=Gate_1 $thickness=5.6e-08
+ $X=0.135 $Y=0.135 $X2=0.135 $Y2=0.1515
r73 41 46 4.18976 $w=2.01667e-08 $l=9e-09 $layer=Gate_1 $thickness=5.53333e-08
+ $X=0.135 $Y=0.135 $X2=0.144 $Y2=0.135
r74 40 41 5.79936 $w=2.03333e-08 $l=1.65e-08 $layer=Gate_1 $thickness=5.6e-08
+ $X=0.135 $Y=0.1185 $X2=0.135 $Y2=0.135
r75 39 40 7.31297 $w=2.1e-08 $l=2.15e-08 $layer=Gate_1 $thickness=5.6e-08
+ $X=0.135 $Y=0.097 $X2=0.135 $Y2=0.1185
r76 38 39 14.6259 $w=2.1e-08 $l=4.3e-08 $layer=Gate_1 $thickness=5.6e-08
+ $X=0.135 $Y=0.054 $X2=0.135 $Y2=0.097
r77 38 14 10.0341 $w=2.1e-08 $l=2.95e-08 $layer=Gate_1 $thickness=5.6e-08
+ $X=0.135 $Y=0.054 $X2=0.135 $Y2=0.0245
r78 7 18 1e-05 $l=2e-09 $X=0.054 $Y=0.216 $X2=0.056 $Y2=0.216
r79 6 17 1e-05 $l=2e-09 $X=0.054 $Y=0.054 $X2=0.056 $Y2=0.054
.ends

* End of included file DHLx3_ASAP7_75t_R.pex.sp.pex

*
.subckt DHLx3_ASAP7_75t_CUSTOM_4_25_0_7 VSS VDD CLK D Q
*
* VSS VSS
* VDD VDD
* CLK CLK
* D D
* Q Q
*
*

M0 VSS N_M0_g N_M0_s VSS nmos_rvt L=2e-08 W=5.4e-08 nfin=2 $X=0.071 $Y=0.027
M1 N_M1_d N_M1_g VSS VSS nmos_rvt L=2e-08 W=5.4e-08 nfin=2 $X=0.125 $Y=0.027
M2 N_M2_d N_M2_g VSS VSS nmos_rvt L=2e-08 W=8.1e-08 nfin=3 $X=0.287 $Y=0.027
M3 N_M3_d N_M3_g N_M3_s VSS nmos_rvt L=2e-08 W=8.1e-08 nfin=3 $X=0.395 $Y=0.027
M4 N_M4_d N_M4_g N_M4_s VSS nmos_rvt L=2e-08 W=2.7e-08 nfin=1 $X=0.449 $Y=0.027
M5 VSS N_M5_g N_M5_s VSS nmos_rvt L=2e-08 W=2.7e-08 nfin=1 $X=0.503 $Y=0.027
M6 N_M6_d N_M6_g VSS VSS nmos_rvt L=2e-08 W=2.7e-08 nfin=1 $X=0.557 $Y=0.027
M7 VSS N_M7_g N_M7_s VSS nmos_rvt L=2e-08 W=8.1e-08 nfin=3 $X=0.719 $Y=0.027
M8 VSS N_M8_g N_M8_s VSS nmos_rvt L=2e-08 W=8.1e-08 nfin=3 $X=0.773 $Y=0.027
M9 VSS N_M9_g N_M9_s VSS nmos_rvt L=2e-08 W=8.1e-08 nfin=3 $X=0.827 $Y=0.027
M10 VDD N_M10_g N_M10_s VDD pmos_rvt L=2e-08 W=5.4e-08 nfin=2 $X=0.071 $Y=0.189
M11 N_M11_d N_M11_g VDD VDD pmos_rvt L=2e-08 W=5.4e-08 nfin=2 $X=0.125 $Y=0.189
M12 N_M12_d N_M12_g VDD VDD pmos_rvt L=2e-08 W=8.1e-08 nfin=3 $X=0.287 $Y=0.162
M13 N_M13_d N_M13_g N_M13_s VDD pmos_rvt L=2e-08 W=8.1e-08 nfin=3 $X=0.341
+ $Y=0.162
M14 N_M14_d N_M14_g N_M14_s VDD pmos_rvt L=2e-08 W=2.7e-08 nfin=1 $X=0.395
+ $Y=0.216
M15 VDD N_M15_g N_M15_s VDD pmos_rvt L=2e-08 W=2.7e-08 nfin=1 $X=0.503 $Y=0.216
M16 N_M16_d N_M16_g VDD VDD pmos_rvt L=2e-08 W=2.7e-08 nfin=1 $X=0.557 $Y=0.216
M17 VDD N_M17_g N_M17_s VDD pmos_rvt L=2e-08 W=8.1e-08 nfin=3 $X=0.719 $Y=0.162
M18 VDD N_M18_g N_M18_s VDD pmos_rvt L=2e-08 W=8.1e-08 nfin=3 $X=0.773 $Y=0.162
M19 VDD N_M19_g N_M19_s VDD pmos_rvt L=2e-08 W=8.1e-08 nfin=3 $X=0.827 $Y=0.162

* .include "DHLx3_ASAP7_75t_R.pex.sp.pxi"

* Start of included file DHLx3_ASAP7_75t_R.pex.sp.pxi
x_PM_DHLx3_ASAP7_75t_R%CLK vss CLK N_M0_g N_M10_g N_CLK_3 N_CLK_1 N_CLK_6
+ N_CLK_5 N_CLK_4 N_CLK_8 N_CLK_7 PM_DHLx3_ASAP7_75t_R%CLK
x_PM_DHLx3_ASAP7_75t_R%D vss D N_M2_g N_M12_g N_D_5 N_D_1 N_D_3 N_D_4
+ PM_DHLx3_ASAP7_75t_R%D
cc_1 N_D_5 N_4_23 9.51075e-20 $X=0.297 $Y=0.0755
cc_2 N_D_5 N_4_30 9.58174e-20 $X=0.297 $Y=0.0755
cc_3 N_D_5 N_4_24 0.00060689f $X=0.297 $Y=0.0755
cc_4 N_D_5 N_4_2 0.000857764f $X=0.297 $Y=0.0755
cc_5 N_D_5 N_4_33 0.000866394f $X=0.297 $Y=0.0755
cc_6 N_D_1 N_4_2 0.00134692f $X=0.297 $Y=0.1345
cc_7 N_D_3 N_4_15 0.00496441f $X=0.297 $Y=0.0245
cc_8 N_D_5 N_4_31 0.00516699f $X=0.297 $Y=0.0755
x_PM_DHLx3_ASAP7_75t_R%13 vss N_M12_d N_M13_s N_13_1 PM_DHLx3_ASAP7_75t_R%13
cc_9 N_13_1 N_4_15 0.0167922f $X=0.324 $Y=0.2025
cc_10 N_13_1 N_D_3 0.0166405f $X=0.324 $Y=0.2025
x_PM_DHLx3_ASAP7_75t_R%6 vss N_M3_g N_M14_g N_M1_d N_M11_d N_6_3 N_6_15 N_6_14
+ N_6_10 N_6_11 N_6_4 N_6_9 N_6_18 N_6_17 N_6_16 N_6_1 N_6_13 N_6_12
+ PM_DHLx3_ASAP7_75t_R%6
cc_11 N_6_3 N_CLK_7 0.000264136f $X=0.162 $Y=0.054
cc_12 N_6_15 N_CLK_7 0.00101641f $X=0.216 $Y=0.234
cc_13 N_6_14 N_CLK_7 0.00284848f $X=0.216 $Y=0.036
cc_14 N_6_10 N_4_6 5.76331e-20 $X=0.1475 $Y=0.054
cc_15 N_6_10 N_4_25 0.000181123f $X=0.1475 $Y=0.054
cc_16 N_6_10 N_4_22 0.000254221f $X=0.1475 $Y=0.054
cc_17 N_6_15 N_4_22 0.00451091f $X=0.216 $Y=0.234
cc_18 N_6_11 N_4_14 0.0110435f $X=0.1475 $Y=0.216
cc_19 N_6_4 N_4_22 0.000401416f $X=0.162 $Y=0.216
cc_20 N_6_3 N_4_1 0.000408302f $X=0.162 $Y=0.054
cc_21 N_6_9 N_4_3 0.000495184f $X=0.405 $Y=0.0245
cc_22 N_6_18 N_4_24 0.000511988f $X=0.2315 $Y=0.153
cc_23 N_6_17 N_4_24 0.000533798f $X=0.405 $Y=0.1155
cc_24 N_6_16 N_4_29 0.000538152f $X=0.243 $Y=0.135
cc_25 N_6_14 N_4_23 0.000608314f $X=0.216 $Y=0.036
cc_26 N_6_17 N_4_33 0.000682488f $X=0.405 $Y=0.1155
cc_27 N_6_16 N_4_33 0.000730015f $X=0.243 $Y=0.135
cc_28 N_6_3 N_4_14 0.000796591f $X=0.162 $Y=0.054
cc_29 N_6_1 N_4_2 0.00240236f $X=0.405 $Y=0.132
cc_30 N_6_10 N_4_1 0.000932415f $X=0.1475 $Y=0.054
cc_31 N_6_16 N_4_30 0.000969148f $X=0.243 $Y=0.135
cc_32 N_6_4 N_4_14 0.0012124f $X=0.162 $Y=0.216
cc_33 N_6_9 N_4_15 0.00163858f $X=0.405 $Y=0.0245
cc_34 N_6_16 N_4_23 0.00350624f $X=0.243 $Y=0.135
cc_35 N_6_17 N_4_31 0.00365526f $X=0.405 $Y=0.1155
cc_36 N_6_9 N_4_16 0.008578f $X=0.405 $Y=0.0245
cc_37 N_6_18 N_4_33 0.016958f $X=0.2315 $Y=0.153
cc_38 N_6_10 N_4_14 0.0390434f $X=0.1475 $Y=0.054
cc_39 N_6_13 N_D_5 0.000303312f $X=0.243 $Y=0.2305
cc_40 N_6_18 N_D_5 0.00100185f $X=0.2315 $Y=0.153
cc_41 N_6_12 N_D_4 0.00126279f $X=0.243 $Y=0.036
cc_42 N_6_16 N_D_5 0.00794244f $X=0.243 $Y=0.135
x_PM_DHLx3_ASAP7_75t_R%7 vss N_M5_g N_M15_g N_M6_d N_M16_d N_7_9 N_7_13 N_7_1
+ N_7_4 N_7_17 N_7_3 N_7_16 N_7_12 N_7_11 N_7_10 N_7_15 N_7_14
+ PM_DHLx3_ASAP7_75t_R%7
cc_43 N_7_9 N_4_3 0.000171813f $X=0.513 $Y=0.0245
cc_44 N_7_9 N_4_8 0.00543529f $X=0.513 $Y=0.0245
cc_45 N_7_9 N_4_32 0.000335165f $X=0.513 $Y=0.0245
cc_46 N_7_13 N_4_8 0.00043624f $X=0.621 $Y=0.234
cc_47 N_7_1 N_4_16 0.000438716f $X=0.513 $Y=0.082
cc_48 N_7_4 N_4_8 0.000784214f $X=0.594 $Y=0.2295
cc_49 N_7_17 N_4_8 0.00131717f $X=0.621 $Y=0.0675
cc_50 N_7_9 N_4_16 0.0138268f $X=0.513 $Y=0.0245
x_PM_DHLx3_ASAP7_75t_R%Q vss Q N_M7_s N_M8_s N_M9_s N_M18_s N_M19_s N_M17_s
+ N_Q_1 N_Q_14 N_Q_4 N_Q_2 N_Q_16 N_Q_15 N_Q_3 N_Q_20 N_Q_19 N_Q_13 N_Q_21
+ PM_DHLx3_ASAP7_75t_R%Q
cc_51 N_Q_1 N_7_14 0.000550085f $X=0.702 $Y=0.0405
cc_52 N_Q_1 N_7_17 0.00335745f $X=0.702 $Y=0.0405
cc_53 N_Q_14 N_8_16 0.000991026f $X=0.7955 $Y=0.0675
cc_54 N_Q_14 N_8_32 0.000182397f $X=0.7955 $Y=0.0675
cc_55 N_Q_14 N_8_33 0.000682062f $X=0.7955 $Y=0.0675
cc_56 N_Q_14 N_8_31 0.000398695f $X=0.7955 $Y=0.0675
cc_57 N_Q_14 N_8_3 0.000388125f $X=0.7955 $Y=0.0675
cc_58 N_Q_4 N_8_4 0.000612113f $X=0.81 $Y=0.2025
cc_59 N_Q_2 N_8_2 0.000662435f $X=0.702 $Y=0.2295
cc_60 N_Q_16 N_8_18 0.0300891f $X=0.7955 $Y=0.2025
cc_61 N_Q_14 N_8_17 0.0568486f $X=0.7955 $Y=0.0675
cc_62 N_Q_2 N_8_16 0.00136132f $X=0.702 $Y=0.2295
cc_63 N_Q_16 N_8_3 0.00136669f $X=0.7955 $Y=0.2025
cc_64 N_Q_16 N_8_4 0.00144578f $X=0.7955 $Y=0.2025
cc_65 N_Q_1 N_8_16 0.00147555f $X=0.702 $Y=0.0405
cc_66 N_Q_15 N_8_2 0.00162166f $X=0.704 $Y=0.2025
cc_67 N_Q_3 N_8_32 0.00163658f $X=0.81 $Y=0.0675
cc_68 N_Q_1 N_8_31 0.00183792f $X=0.702 $Y=0.0405
cc_69 N_Q_20 N_8_34 0.00184699f $X=0.864 $Y=0.234
cc_70 N_Q_3 N_8_17 0.00191088f $X=0.81 $Y=0.0675
cc_71 N_Q_4 N_8_17 0.00207068f $X=0.81 $Y=0.2025
cc_72 N_Q_20 N_8_32 0.00211441f $X=0.864 $Y=0.234
cc_73 N_Q_19 N_8_32 0.00235444f $X=0.6905 $Y=0.036
cc_74 N_Q_13 N_8_16 0.0146604f $X=0.704 $Y=0.0675
cc_75 N_Q_21 N_8_33 0.00564804f $X=0.891 $Y=0.0675
cc_76 N_Q_15 N_8_16 0.0521105f $X=0.704 $Y=0.2025
cc_77 N_Q_14 N_8_18 0.0481816f $X=0.7955 $Y=0.0675
x_PM_DHLx3_ASAP7_75t_R%10 vss N_M2_d N_M3_s N_10_4 N_10_5 N_10_1
+ PM_DHLx3_ASAP7_75t_R%10
cc_78 N_10_4 N_4_2 0.0019517f $X=0.3095 $Y=0.0675
cc_79 N_10_4 N_4_31 0.000459311f $X=0.3095 $Y=0.0675
cc_80 N_10_4 N_4_15 0.0732063f $X=0.3095 $Y=0.0675
cc_81 N_10_4 N_D_3 0.0365338f $X=0.3095 $Y=0.0675
cc_82 N_10_5 N_6_1 0.000658463f $X=0.38 $Y=0.0675
cc_83 N_10_5 N_6_9 0.0347572f $X=0.38 $Y=0.0675
cc_84 N_10_1 N_8_10 0.00124757f $X=0.351 $Y=0.0675
cc_85 N_10_1 N_8_20 0.000610082f $X=0.351 $Y=0.0675
cc_86 N_10_1 N_8_19 0.00249649f $X=0.351 $Y=0.0675
x_PM_DHLx3_ASAP7_75t_R%11 vss N_M14_d N_M15_s N_11_4 N_11_1 N_11_5
+ PM_DHLx3_ASAP7_75t_R%11
cc_87 N_11_4 N_4_32 0.00013717f $X=0.4175 $Y=0.2295
cc_88 N_11_1 N_4_3 0.00100679f $X=0.432 $Y=0.2295
cc_89 N_11_5 N_4_8 0.00107323f $X=0.488 $Y=0.2295
cc_90 N_11_1 N_4_16 0.00204934f $X=0.432 $Y=0.2295
cc_91 N_11_5 N_4_16 0.00694476f $X=0.488 $Y=0.2295
cc_92 N_11_4 N_4_16 0.0241332f $X=0.4175 $Y=0.2295
cc_93 N_11_4 N_6_9 0.0150182f $X=0.4175 $Y=0.2295
cc_94 N_11_5 N_7_9 0.0144806f $X=0.488 $Y=0.2295
cc_95 N_11_1 N_8_21 0.000283607f $X=0.432 $Y=0.2295
cc_96 N_11_1 N_8_22 0.000295203f $X=0.432 $Y=0.2295
cc_97 N_11_1 N_8_29 0.000399008f $X=0.432 $Y=0.2295
cc_98 N_11_1 N_8_26 0.000423188f $X=0.432 $Y=0.2295
cc_99 N_11_4 N_8_9 0.000524317f $X=0.4175 $Y=0.2295
cc_100 N_11_1 N_8_25 0.00181083f $X=0.432 $Y=0.2295
x_PM_DHLx3_ASAP7_75t_R%8 vss N_M6_g N_M16_g N_M3_d N_M4_s N_M7_g N_M17_g N_M8_g
+ N_M18_g N_M9_g N_M19_g N_M13_d N_M14_s N_8_19 N_8_26 N_8_21 N_8_9 N_8_22
+ N_8_28 N_8_25 N_8_20 N_8_1 N_8_29 N_8_30 N_8_10 N_8_34 N_8_15 N_8_27 N_8_24
+ N_8_31 N_8_32 N_8_23 N_8_16 N_8_33 N_8_3 N_8_4 N_8_2 N_8_18 N_8_17
+ PM_DHLx3_ASAP7_75t_R%8
cc_101 N_8_19 N_4_32 0.000121465f $X=0.4175 $Y=0.0405
cc_102 N_8_26 N_4_24 0.00380194f $X=0.432 $Y=0.234
cc_103 N_8_21 N_4_15 0.0100761f $X=0.3635 $Y=0.2295
cc_104 N_8_9 N_4_2 0.000235424f $X=0.378 $Y=0.2295
cc_105 N_8_22 N_4_15 0.0245214f $X=0.3635 $Y=0.189
cc_106 N_8_28 N_4_32 0.00026997f $X=0.459 $Y=0.1135
cc_107 N_8_9 N_4_24 0.000423778f $X=0.378 $Y=0.2295
cc_108 N_8_25 N_4_32 0.000433448f $X=0.459 $Y=0.234
cc_109 N_8_20 N_4_16 0.00558672f $X=0.4175 $Y=0.081
cc_110 N_8_9 N_4_31 0.000506141f $X=0.378 $Y=0.2295
cc_111 N_8_1 N_4_8 0.00164317f $X=0.567 $Y=0.124
cc_112 N_8_29 N_4_33 0.00060303f $X=0.459 $Y=0.1415
cc_113 N_8_30 N_4_8 0.000637305f $X=0.54 $Y=0.13
cc_114 N_8_10 N_4_16 0.000657113f $X=0.432 $Y=0.0405
cc_115 N_8_21 N_4_2 0.000707316f $X=0.3635 $Y=0.2295
cc_116 N_8_34 N_4_32 0.000899026f $X=0.459 $Y=0.153
cc_117 N_8_29 N_4_3 0.00103353f $X=0.459 $Y=0.1415
cc_118 N_8_30 N_4_32 0.00160663f $X=0.54 $Y=0.13
cc_119 N_8_9 N_4_15 0.0018312f $X=0.378 $Y=0.2295
cc_120 N_8_34 N_4_8 0.00412737f $X=0.459 $Y=0.153
cc_121 N_8_29 N_4_32 0.00467591f $X=0.459 $Y=0.1415
cc_122 N_8_26 N_4_33 0.00516516f $X=0.432 $Y=0.234
cc_123 N_8_15 N_4_8 0.00630253f $X=0.567 $Y=0.0245
cc_124 N_8_19 N_4_16 0.031919f $X=0.4175 $Y=0.0405
cc_125 N_8_19 N_6_9 0.00975961f $X=0.4175 $Y=0.0405
cc_126 N_8_21 N_6_9 0.0109658f $X=0.3635 $Y=0.2295
cc_127 N_8_26 N_6_9 0.000242601f $X=0.432 $Y=0.234
cc_128 N_8_27 N_6_17 0.000272848f $X=0.432 $Y=0.036
cc_129 N_8_24 N_6_17 0.000423306f $X=0.459 $Y=0.13
cc_130 N_8_22 N_6_9 0.00556711f $X=0.3635 $Y=0.189
cc_131 N_8_34 N_6_18 0.000621498f $X=0.459 $Y=0.153
cc_132 N_8_28 N_6_17 0.000745563f $X=0.459 $Y=0.1135
cc_133 N_8_26 N_6_18 0.000762652f $X=0.432 $Y=0.234
cc_134 N_8_10 N_6_1 0.000838673f $X=0.432 $Y=0.0405
cc_135 N_8_29 N_6_17 0.00448768f $X=0.459 $Y=0.1415
cc_136 N_8_10 N_6_9 0.00105085f $X=0.432 $Y=0.0405
cc_137 N_8_9 N_6_9 0.00105248f $X=0.378 $Y=0.2295
cc_138 N_8_19 N_6_1 0.00166363f $X=0.4175 $Y=0.0405
cc_139 N_8_20 N_6_9 0.045432f $X=0.4175 $Y=0.081
cc_140 N_8_31 N_7_9 7.55812e-20 $X=0.729 $Y=0.1085
cc_141 N_8_27 N_7_9 8.29584e-20 $X=0.432 $Y=0.036
cc_142 N_8_32 N_7_9 9.3728e-20 $X=0.783 $Y=0.1085
cc_143 N_8_30 N_7_9 0.000200542f $X=0.54 $Y=0.13
cc_144 N_8_31 N_7_17 0.000348681f $X=0.729 $Y=0.1085
cc_145 N_8_10 N_7_1 0.0003892f $X=0.432 $Y=0.0405
cc_146 N_8_15 N_7_3 0.0004187f $X=0.567 $Y=0.0245
cc_147 N_8_34 N_7_13 0.000546608f $X=0.459 $Y=0.153
cc_148 N_8_30 N_7_16 0.0006395f $X=0.54 $Y=0.13
cc_149 N_8_1 N_7_17 0.000757727f $X=0.567 $Y=0.124
cc_150 N_8_23 N_7_12 0.000859827f $X=0.459 $Y=0.036
cc_151 N_8_1 N_7_9 0.000942389f $X=0.567 $Y=0.124
cc_152 N_8_30 N_7_1 0.00098709f $X=0.54 $Y=0.13
cc_153 N_8_15 N_7_1 0.00106117f $X=0.567 $Y=0.0245
cc_154 N_8_15 N_7_11 0.00633552f $X=0.567 $Y=0.0245
cc_155 N_8_15 N_7_10 0.0065061f $X=0.567 $Y=0.0245
cc_156 N_8_34 N_7_17 0.00248608f $X=0.459 $Y=0.153
cc_157 N_8_30 N_7_15 0.00291897f $X=0.54 $Y=0.13
cc_158 N_8_28 N_7_15 0.00344943f $X=0.459 $Y=0.1135
cc_159 N_8_30 N_7_17 0.00394273f $X=0.54 $Y=0.13
cc_160 N_8_15 N_7_9 0.0306707f $X=0.567 $Y=0.0245
x_PM_DHLx3_ASAP7_75t_R%12 vss N_M4_d N_M5_s N_12_1 PM_DHLx3_ASAP7_75t_R%12
cc_161 N_12_1 N_4_16 0.00755795f $X=0.486 $Y=0.0405
cc_162 N_12_1 N_7_9 0.00766767f $X=0.486 $Y=0.0405
x_PM_DHLx3_ASAP7_75t_R%4 vss N_M1_g N_M11_g N_M13_g N_M4_g N_M0_s N_M10_s
+ N_4_20 N_4_22 N_4_23 N_4_7 N_4_6 N_4_17 N_4_18 N_4_30 N_4_1 N_4_28 N_4_25
+ N_4_29 N_4_33 N_4_27 N_4_14 N_4_24 N_4_2 N_4_15 N_4_31 N_4_3 N_4_16 N_4_8
+ N_4_32 PM_DHLx3_ASAP7_75t_R%4
cc_163 N_4_20 N_CLK_3 0.000198395f $X=0.0165 $Y=0.189
cc_164 N_4_22 N_CLK_3 0.000212357f $X=0.189 $Y=0.189
cc_165 N_4_23 N_CLK_3 0.000256091f $X=0.189 $Y=0.135
cc_166 N_4_7 N_CLK_3 0.00102882f $X=0.054 $Y=0.216
cc_167 N_4_6 N_CLK_3 0.00107591f $X=0.054 $Y=0.054
cc_168 N_4_17 N_CLK_3 0.0110998f $X=0.056 $Y=0.054
cc_169 N_4_18 N_CLK_3 0.0110308f $X=0.056 $Y=0.216
cc_170 N_4_30 N_CLK_3 0.000364442f $X=0.189 $Y=0.1485
cc_171 N_4_1 N_CLK_3 0.000553759f $X=0.134 $Y=0.135
cc_172 N_4_28 N_CLK_3 0.00058956f $X=0.036 $Y=0.234
cc_173 N_4_1 N_CLK_1 0.00360171f $X=0.134 $Y=0.135
cc_174 N_4_25 N_CLK_6 0.00109883f $X=0.018 $Y=0.1665
cc_175 N_4_29 N_CLK_5 0.00116479f $X=0.1405 $Y=0.135
cc_176 N_4_29 N_CLK_4 0.00150979f $X=0.1405 $Y=0.135
cc_177 N_4_22 N_CLK_5 0.00156702f $X=0.189 $Y=0.189
cc_178 N_4_33 N_CLK_8 0.00162605f $X=0.0215 $Y=0.189
cc_179 N_4_27 N_CLK_7 0.00185163f $X=0.036 $Y=0.036
cc_180 N_4_22 N_CLK_8 0.00225047f $X=0.189 $Y=0.189
cc_181 N_4_20 N_CLK_5 0.00282908f $X=0.0165 $Y=0.189
cc_182 N_4_25 N_CLK_4 0.00293194f $X=0.018 $Y=0.1665
cc_183 N_4_14 N_CLK_3 0.0355451f $X=0.135 $Y=0.0245

* End of included file DHLx3_ASAP7_75t_R.pex.sp.pxi
.ends

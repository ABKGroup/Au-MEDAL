.subckt PM_ICGx4DC_ASAP7_75t_R%7 vss 19 23 33 36 48 49 52 53 15 11 17 9 3 1 13
+ 10
c1 1 vss 0.0066075f $X=0.513 $Y=0.135
c2 3 vss 0.00844779f $X=0.432 $Y=0.2025
c3 4 vss 0.00828125f $X=0.54 $Y=0.2025
c4 9 vss 0.0817745f $X=0.513 $Y=0.0245
c5 10 vss 0.11821f $X=0.567 $Y=0.135
c6 11 vss 0.00469829f $X=0.4175 $Y=0.2025
c7 12 vss 0.00430764f $X=0.5255 $Y=0.2025
c8 13 vss 0.00127138f $X=0.513 $Y=0.135
c9 14 vss 0.00065521f $X=0.513 $Y=0.171
c10 15 vss 0.00365344f $X=0.486 $Y=0.171
c11 16 vss 0.000231607f $X=0.513 $Y=0.1455
c12 17 vss 0.00142125f $X=0.5265 $Y=0.135
c13 18 vss 0.00362303f $X=0.5265 $Y=0.171
r1 53 51 0.0308642 $w=8.1e-08 $l=2.5e-09 $layer=P_src_drn $thickness=1e-09
+ $X=0.5573 $Y=0.2025 $X2=0.5545 $Y2=0.2025
r2 4 51 0.179012 $w=8.1e-08 $l=1.45e-08 $layer=P_src_drn $thickness=1e-09
+ $X=0.54 $Y=0.2025 $X2=0.5545 $Y2=0.2025
r3 12 4 0.179012 $w=8.1e-08 $l=1.45e-08 $layer=P_src_drn $thickness=1e-09
+ $X=0.5255 $Y=0.2025 $X2=0.54 $Y2=0.2025
r4 52 12 0.0308642 $w=8.1e-08 $l=2.5e-09 $layer=P_src_drn $thickness=1e-09
+ $X=0.5226 $Y=0.2025 $X2=0.5255 $Y2=0.2025
r5 49 47 0.0308642 $w=8.1e-08 $l=2.5e-09 $layer=P_src_drn $thickness=1e-09
+ $X=0.4493 $Y=0.2025 $X2=0.4465 $Y2=0.2025
r6 3 47 0.179012 $w=8.1e-08 $l=1.45e-08 $layer=P_src_drn $thickness=1e-09
+ $X=0.432 $Y=0.2025 $X2=0.4465 $Y2=0.2025
r7 11 3 0.179012 $w=8.1e-08 $l=1.45e-08 $layer=P_src_drn $thickness=1e-09
+ $X=0.4175 $Y=0.2025 $X2=0.432 $Y2=0.2025
r8 48 11 0.0308642 $w=8.1e-08 $l=2.5e-09 $layer=P_src_drn $thickness=1e-09
+ $X=0.4146 $Y=0.2025 $X2=0.4175 $Y2=0.2025
r9 4 43 19.3796 $a=3.24e-16 $layer=V0LISD $X=0.54 $Y=0.2025 $X2=0.54 $Y2=0.171
r10 3 41 19.3796 $a=3.24e-16 $layer=V0LISD $X=0.432 $Y=0.2025 $X2=0.432
+ $Y2=0.171
r11 18 43 3.14806 $w=1.3e-08 $l=1.35e-08 $layer=M1 $thickness=3.6e-08 $X=0.5265
+ $Y=0.171 $X2=0.54 $Y2=0.171
r12 41 42 5.24677 $w=1.3e-08 $l=2.25e-08 $layer=M1 $thickness=3.6e-08 $X=0.432
+ $Y=0.171 $X2=0.4545 $Y2=0.171
r13 15 42 7.34548 $w=1.3e-08 $l=3.15e-08 $layer=M1 $thickness=3.6e-08 $X=0.486
+ $Y=0.171 $X2=0.4545 $Y2=0.171
r14 14 39 1.96775 $w=1.63333e-08 $l=1.35e-08 $layer=M1 $thickness=3.6e-08
+ $X=0.513 $Y=0.171 $X2=0.513 $Y2=0.1575
r15 14 15 5.11582 $w=1.46667e-08 $l=2.7e-08 $layer=M1 $thickness=3.6e-08
+ $X=0.513 $Y=0.171 $X2=0.486 $Y2=0.171
r16 14 18 1.96775 $w=1.63333e-08 $l=1.35e-08 $layer=M1 $thickness=3.6e-08
+ $X=0.513 $Y=0.171 $X2=0.5265 $Y2=0.171
r17 38 39 1.74892 $w=1.3e-08 $l=7.5e-09 $layer=M1 $thickness=3.6e-08 $X=0.513
+ $Y=0.15 $X2=0.513 $Y2=0.1575
r18 16 38 1.04935 $w=1.3e-08 $l=4.5e-09 $layer=M1 $thickness=3.6e-08 $X=0.513
+ $Y=0.1455 $X2=0.513 $Y2=0.15
r19 13 17 1.49895 $w=1.63333e-08 $l=1.35e-08 $layer=M1 $thickness=3.6e-08
+ $X=0.513 $Y=0.135 $X2=0.5265 $Y2=0.135
r20 13 16 0.79938 $w=2.14e-08 $l=1.05e-08 $layer=M1 $thickness=3.6e-08 $X=0.513
+ $Y=0.135 $X2=0.513 $Y2=0.1455
r21 36 35 16.4967 $w=2.1e-08 $l=4.85e-08 $layer=Gate_1 $thickness=5.6e-08
+ $X=0.567 $Y=0.2025 $X2=0.567 $Y2=0.154
r22 33 34 16.4967 $w=2.1e-08 $l=4.85e-08 $layer=Gate_1 $thickness=5.6e-08
+ $X=0.567 $Y=0.0675 $X2=0.567 $Y2=0.116
r23 10 27 6.54019 $w=2.09524e-08 $layer=Gate_1 $thickness=5.21905e-08 $X=0.567
+ $Y=0.135 $X2=0.567 $Y2=0.135
r24 10 34 6.6497 $w=2.04211e-08 $l=1.9e-08 $layer=Gate_1 $thickness=5.6e-08
+ $X=0.567 $Y=0.135 $X2=0.567 $Y2=0.116
r25 10 35 6.6497 $w=2.04211e-08 $l=1.9e-08 $layer=Gate_1 $thickness=5.6e-08
+ $X=0.567 $Y=0.135 $X2=0.567 $Y2=0.154
r26 17 29 3.14806 $w=1.3e-08 $l=1.35e-08 $layer=M1 $thickness=3.6e-08 $X=0.5265
+ $Y=0.135 $X2=0.54 $Y2=0.135
r27 26 27 12.6539 $w=1.77815e-08 $l=2.7e-08 $layer=LIG $thickness=4.8e-08
+ $X=0.54 $Y=0.135 $X2=0.567 $Y2=0.135
r28 26 29 19.3796 $a=3.24e-16 $layer=V0LIG $X=0.54 $Y=0.135 $X2=0.54 $Y2=0.135
r29 1 21 6.54019 $w=2.09524e-08 $layer=Gate_1 $thickness=5.21905e-08 $X=0.513
+ $Y=0.135 $X2=0.513 $Y2=0.135
r30 1 26 12.6539 $w=1.77815e-08 $l=2.7e-08 $layer=LIG $thickness=4.8e-08
+ $X=0.513 $Y=0.135 $X2=0.54 $Y2=0.135
r31 23 22 16.4967 $w=2.1e-08 $l=4.85e-08 $layer=Gate_1 $thickness=5.6e-08
+ $X=0.513 $Y=0.2025 $X2=0.513 $Y2=0.154
r32 21 22 6.6497 $w=2.04211e-08 $l=1.9e-08 $layer=Gate_1 $thickness=5.6e-08
+ $X=0.513 $Y=0.135 $X2=0.513 $Y2=0.154
r33 20 21 6.6497 $w=2.04211e-08 $l=1.9e-08 $layer=Gate_1 $thickness=5.6e-08
+ $X=0.513 $Y=0.116 $X2=0.513 $Y2=0.135
r34 19 20 16.4967 $w=2.1e-08 $l=4.85e-08 $layer=Gate_1 $thickness=5.6e-08
+ $X=0.513 $Y=0.0675 $X2=0.513 $Y2=0.116
r35 19 9 14.6259 $w=2.1e-08 $l=4.3e-08 $layer=Gate_1 $thickness=5.6e-08
+ $X=0.513 $Y=0.0675 $X2=0.513 $Y2=0.0245
.ends

.subckt PM_ICGx4DC_ASAP7_75t_R%20 vss 6 7 1 3
c1 1 vss 0.00455544f $X=1.242 $Y=0.2025
c2 3 vss 0.00309573f $X=1.2275 $Y=0.2025
r1 7 5 0.0308642 $w=8.1e-08 $l=2.5e-09 $layer=P_src_drn $thickness=1e-09
+ $X=1.2593 $Y=0.2025 $X2=1.2565 $Y2=0.2025
r2 1 5 0.179012 $w=8.1e-08 $l=1.45e-08 $layer=P_src_drn $thickness=1e-09
+ $X=1.242 $Y=0.2025 $X2=1.2565 $Y2=0.2025
r3 3 1 0.179012 $w=8.1e-08 $l=1.45e-08 $layer=P_src_drn $thickness=1e-09
+ $X=1.2275 $Y=0.2025 $X2=1.242 $Y2=0.2025
r4 6 3 0.0308642 $w=8.1e-08 $l=2.5e-09 $layer=P_src_drn $thickness=1e-09
+ $X=1.2246 $Y=0.2025 $X2=1.2275 $Y2=0.2025
.ends

.subckt PM_ICGx4DC_ASAP7_75t_R%21 vss 7 12 1 4 5
c1 1 vss 0.00606099f $X=1.35 $Y=0.2295
c2 4 vss 0.00167468f $X=1.3355 $Y=0.2295
c3 5 vss 0.00208017f $X=1.406 $Y=0.2295
r1 12 11 0.0925926 $w=2.7e-08 $l=2.5e-09 $layer=P_src_drn $thickness=1e-09
+ $X=1.4213 $Y=0.2295 $X2=1.4185 $Y2=0.2295
r2 5 11 0.462963 $w=2.7e-08 $l=1.25e-08 $layer=P_src_drn $thickness=1e-09
+ $X=1.406 $Y=0.2295 $X2=1.4185 $Y2=0.2295
r3 9 5 9.87715 $w=2.32e-08 $l=2.1e-08 $layer=LISD $thickness=2.7e-08 $X=1.383
+ $Y=0.2295 $X2=1.406 $Y2=0.2295
r4 8 9 7.05511 $w=2.32e-08 $l=1.5e-08 $layer=LISD $thickness=2.7e-08 $X=1.368
+ $Y=0.2295 $X2=1.383 $Y2=0.2295
r5 1 8 8.46613 $w=2.32e-08 $l=1.8e-08 $layer=LISD $thickness=2.7e-08 $X=1.35
+ $Y=0.2295 $X2=1.368 $Y2=0.2295
r6 4 1 0.462963 $w=2.7e-08 $l=1.25e-08 $layer=P_src_drn $thickness=1e-09
+ $X=1.3355 $Y=0.2295 $X2=1.35 $Y2=0.2295
r7 7 4 0.0925926 $w=2.7e-08 $l=2.5e-09 $layer=P_src_drn $thickness=1e-09
+ $X=1.3326 $Y=0.2295 $X2=1.3355 $Y2=0.2295
.ends

.subckt PM_ICGx4DC_ASAP7_75t_R%13 vss 16 20 44 50 9 1 4 11 14 3 15 12 10 13
c1 1 vss 0.00270323f $X=1.422 $Y=0.082
c2 3 vss 0.00756763f $X=1.512 $Y=0.0635
c3 4 vss 0.00604749f $X=1.512 $Y=0.2295
c4 9 vss 0.0591524f $X=1.431 $Y=0.0245
c5 10 vss 0.0218779f $X=1.4975 $Y=0.0405
c6 11 vss 0.0224198f $X=1.4975 $Y=0.2295
c7 12 vss 0.00647646f $X=1.5385 $Y=0.233
c8 13 vss 0.000683287f $X=1.5385 $Y=0.082
c9 14 vss 0.00331702f $X=1.4225 $Y=0.082
c10 15 vss 0.00222263f $X=1.5385 $Y=0.093
r1 11 4 0.462963 $w=2.7e-08 $l=1.25e-08 $layer=P_src_drn $thickness=1e-09
+ $X=1.4975 $Y=0.2295 $X2=1.512 $Y2=0.2295
r2 50 11 0.0925926 $w=2.7e-08 $l=2.5e-09 $layer=P_src_drn $thickness=1e-09
+ $X=1.4946 $Y=0.2295 $X2=1.4975 $Y2=0.2295
r3 4 46 19.3796 $a=3.24e-16 $layer=V0LISD $X=1.512 $Y=0.2295 $X2=1.512 $Y2=0.233
r4 46 47 3.03147 $w=1.3e-08 $l=1.3e-08 $layer=M1 $thickness=3.6e-08 $X=1.512
+ $Y=0.233 $X2=1.525 $Y2=0.233
r5 12 42 1.06916 $w=1.78e-08 $l=9.5e-09 $layer=M1 $thickness=3.6e-08 $X=1.5385
+ $Y=0.233 $X2=1.5385 $Y2=0.2235
r6 12 47 1.90218 $w=1.65185e-08 $l=1.35e-08 $layer=M1 $thickness=3.6e-08
+ $X=1.5385 $Y=0.233 $X2=1.525 $Y2=0.233
r7 10 35 0.462963 $w=2.7e-08 $l=1.25e-08 $layer=N_src_drn $thickness=1e-09
+ $X=1.4975 $Y=0.0405 $X2=1.512 $Y2=0.0405
r8 44 10 0.0925926 $w=2.7e-08 $l=2.5e-09 $layer=N_src_drn $thickness=1e-09
+ $X=1.4946 $Y=0.0405 $X2=1.4975 $Y2=0.0405
r9 41 42 2.49333 $w=1.4e-08 $l=1.25e-08 $layer=M1 $thickness=3.6e-08 $X=1.5385
+ $Y=0.211 $X2=1.5385 $Y2=0.2235
r10 40 41 4.1888 $w=1.4e-08 $l=2.1e-08 $layer=M1 $thickness=3.6e-08 $X=1.5385
+ $Y=0.19 $X2=1.5385 $Y2=0.211
r11 39 40 3.69013 $w=1.4e-08 $l=1.85e-08 $layer=M1 $thickness=3.6e-08 $X=1.5385
+ $Y=0.1715 $X2=1.5385 $Y2=0.19
r12 38 39 3.69013 $w=1.4e-08 $l=1.85e-08 $layer=M1 $thickness=3.6e-08 $X=1.5385
+ $Y=0.153 $X2=1.5385 $Y2=0.1715
r13 37 38 4.1888 $w=1.4e-08 $l=2.1e-08 $layer=M1 $thickness=3.6e-08 $X=1.5385
+ $Y=0.132 $X2=1.5385 $Y2=0.153
r14 36 37 4.88693 $w=1.4e-08 $l=2.45e-08 $layer=M1 $thickness=3.6e-08 $X=1.5385
+ $Y=0.1075 $X2=1.5385 $Y2=0.132
r15 15 36 2.89227 $w=1.4e-08 $l=1.45e-08 $layer=M1 $thickness=3.6e-08 $X=1.5385
+ $Y=0.093 $X2=1.5385 $Y2=0.1075
r16 3 33 10.904 $w=2.02e-08 $l=1.85e-08 $layer=LISD $thickness=2.7e-08 $X=1.512
+ $Y=0.0635 $X2=1.512 $Y2=0.082
r17 3 35 13.5563 $w=2.02e-08 $l=2.3e-08 $layer=LISD $thickness=2.7e-08 $X=1.512
+ $Y=0.0635 $X2=1.512 $Y2=0.0405
r18 13 32 1.37684 $w=2.03185e-08 $l=1.35e-08 $layer=M1 $thickness=3.6e-08
+ $X=1.5385 $Y=0.082 $X2=1.525 $Y2=0.082
r19 13 15 0.843012 $w=1.80909e-08 $l=1.1e-08 $layer=M1 $thickness=3.6e-08
+ $X=1.5385 $Y=0.082 $X2=1.5385 $Y2=0.093
r20 31 32 3.03147 $w=1.3e-08 $l=1.3e-08 $layer=M1 $thickness=3.6e-08 $X=1.512
+ $Y=0.082 $X2=1.525 $Y2=0.082
r21 31 33 19.3796 $a=3.24e-16 $layer=V0LISD $X=1.512 $Y=0.082 $X2=1.512
+ $Y2=0.082
r22 30 31 2.56509 $w=1.3e-08 $l=1.1e-08 $layer=M1 $thickness=3.6e-08 $X=1.501
+ $Y=0.082 $X2=1.512 $Y2=0.082
r23 29 30 3.49785 $w=1.3e-08 $l=1.5e-08 $layer=M1 $thickness=3.6e-08 $X=1.486
+ $Y=0.082 $X2=1.501 $Y2=0.082
r24 28 29 6.7625 $w=1.3e-08 $l=2.9e-08 $layer=M1 $thickness=3.6e-08 $X=1.457
+ $Y=0.082 $X2=1.486 $Y2=0.082
r25 27 28 3.84763 $w=1.3e-08 $l=1.65e-08 $layer=M1 $thickness=3.6e-08 $X=1.4405
+ $Y=0.082 $X2=1.457 $Y2=0.082
r26 25 27 2.09871 $w=1.3e-08 $l=9e-09 $layer=M1 $thickness=3.6e-08 $X=1.4315
+ $Y=0.082 $X2=1.4405 $Y2=0.082
r27 14 25 2.09871 $w=1.3e-08 $l=9e-09 $layer=M1 $thickness=3.6e-08 $X=1.4225
+ $Y=0.082 $X2=1.4315 $Y2=0.082
r28 22 25 19.3796 $a=3.24e-16 $layer=V0LIG $X=1.432 $Y=0.082 $X2=1.4315
+ $Y2=0.082
r29 1 22 2.6116 $w=2.2e-08 $l=1e-08 $layer=LIG $thickness=4.8e-08 $X=1.422
+ $Y=0.082 $X2=1.432 $Y2=0.082
r30 20 19 25.5104 $w=2.1e-08 $l=7.5e-08 $layer=Gate_1 $thickness=5.6e-08
+ $X=1.431 $Y=0.2295 $X2=1.431 $Y2=0.1545
r31 18 19 24.8471 $w=2.08483e-08 $l=7.25e-08 $layer=Gate_1 $thickness=5.6e-08
+ $X=1.431 $Y=0.082 $X2=1.431 $Y2=0.1545
r32 18 22 6.27904 $w=2.09e-08 $l=1e-09 $layer=Gate_1 $thickness=5.24e-08
+ $X=1.431 $Y=0.082 $X2=1.432 $Y2=0.082
r33 17 18 6.81977 $w=2.04359e-08 $l=1.95e-08 $layer=Gate_1 $thickness=5.6e-08
+ $X=1.431 $Y=0.0625 $X2=1.431 $Y2=0.082
r34 16 17 7.48304 $w=2.1e-08 $l=2.2e-08 $layer=Gate_1 $thickness=5.6e-08
+ $X=1.431 $Y=0.0405 $X2=1.431 $Y2=0.0625
r35 16 9 5.44221 $w=2.1e-08 $l=1.6e-08 $layer=Gate_1 $thickness=5.6e-08
+ $X=1.431 $Y=0.0405 $X2=1.431 $Y2=0.0245
.ends

.subckt PM_ICGx4DC_ASAP7_75t_R%22 vss 6 7 1 3
c1 1 vss 0.00266377f $X=1.404 $Y=0.0405
c2 3 vss 0.00214608f $X=1.3895 $Y=0.0405
r1 7 5 0.0925926 $w=2.7e-08 $l=2.5e-09 $layer=N_src_drn $thickness=1e-09
+ $X=1.4213 $Y=0.0405 $X2=1.4185 $Y2=0.0405
r2 1 5 0.537037 $w=2.7e-08 $l=1.45e-08 $layer=N_src_drn $thickness=1e-09
+ $X=1.404 $Y=0.0405 $X2=1.4185 $Y2=0.0405
r3 3 1 0.537037 $w=2.7e-08 $l=1.45e-08 $layer=N_src_drn $thickness=1e-09
+ $X=1.3895 $Y=0.0405 $X2=1.404 $Y2=0.0405
r4 6 3 0.0925926 $w=2.7e-08 $l=2.5e-09 $layer=N_src_drn $thickness=1e-09
+ $X=1.3866 $Y=0.0405 $X2=1.3895 $Y2=0.0405
.ends

.subckt PM_ICGx4DC_ASAP7_75t_R%12 vss 33 37 86 88 90 92 15 3 28 29 20 24 23 22
+ 5 26 1 27 4 6 18 16 17 19 21 25
c1 1 vss 0.000320348f $X=1.323 $Y=0.1335
c2 3 vss 0.00892387f $X=0.972 $Y=0.054
c3 4 vss 0.00866117f $X=0.972 $Y=0.216
c4 5 vss 0.00699152f $X=1.62 $Y=0.0605
c5 6 vss 0.00834687f $X=1.62 $Y=0.2295
c6 15 vss 0.00747156f $X=1.323 $Y=0.0245
c7 16 vss 0.0433467f $X=0.9575 $Y=0.0675
c8 17 vss 0.0443739f $X=1.622 $Y=0.0675
c9 18 vss 0.0438006f $X=0.9575 $Y=0.2025
c10 19 vss 0.0439922f $X=1.622 $Y=0.2025
c11 20 vss 0.00401303f $X=0.998 $Y=0.086
c12 21 vss 0.005612f $X=0.998 $Y=0.232
c13 22 vss 0.00187385f $X=1.323 $Y=0.081
c14 23 vss 0.000797458f $X=1.3205 $Y=0.189
c15 24 vss 0.00240366f $X=1.594 $Y=0.086
c16 25 vss 0.00578534f $X=1.594 $Y=0.232
c17 26 vss 0.0028304f $X=0.998 $Y=0.176
c18 27 vss 0.000807572f $X=1.323 $Y=0.1045
c19 28 vss 0.00192698f $X=1.594 $Y=0.148
c20 29 vss 0.0196109f $X=0.9855 $Y=0.189
r1 92 91 0.0308642 $w=8.1e-08 $l=2.5e-09 $layer=P_src_drn $thickness=1e-09
+ $X=1.6373 $Y=0.2025 $X2=1.6345 $Y2=0.2025
r2 19 91 0.154321 $w=8.1e-08 $l=1.25e-08 $layer=P_src_drn $thickness=1e-09
+ $X=1.622 $Y=0.2025 $X2=1.6345 $Y2=0.2025
r3 90 89 0.0308642 $w=8.1e-08 $l=2.5e-09 $layer=N_src_drn $thickness=1e-09
+ $X=1.6373 $Y=0.0675 $X2=1.6345 $Y2=0.0675
r4 17 89 0.154321 $w=8.1e-08 $l=1.25e-08 $layer=N_src_drn $thickness=1e-09
+ $X=1.622 $Y=0.0675 $X2=1.6345 $Y2=0.0675
r5 18 4 0.154321 $w=8.1e-08 $l=1.25e-08 $layer=P_src_drn $thickness=1e-09
+ $X=0.9575 $Y=0.2025 $X2=0.972 $Y2=0.216
r6 88 18 0.0308642 $w=8.1e-08 $l=2.5e-09 $layer=P_src_drn $thickness=1e-09
+ $X=0.9546 $Y=0.2025 $X2=0.9575 $Y2=0.2025
r7 16 3 0.154321 $w=8.1e-08 $l=1.25e-08 $layer=N_src_drn $thickness=1e-09
+ $X=0.9575 $Y=0.0675 $X2=0.972 $Y2=0.054
r8 86 16 0.0308642 $w=8.1e-08 $l=2.5e-09 $layer=N_src_drn $thickness=1e-09
+ $X=0.9546 $Y=0.0675 $X2=0.9575 $Y2=0.0675
r9 6 79 19.3796 $a=3.24e-16 $layer=V0LISD $X=1.62 $Y=0.2295 $X2=1.62 $Y2=0.232
r10 6 19 23.8708 $w=2.02e-08 $l=4.05e-08 $layer=LISD $thickness=2.7e-08 $X=1.62
+ $Y=0.2295 $X2=1.622 $Y2=0.2025
r11 5 76 19.3796 $a=3.24e-16 $layer=V0LISD $X=1.62 $Y=0.0605 $X2=1.62 $Y2=0.086
r12 4 73 19.3796 $a=3.24e-16 $layer=V0LISD $X=0.972 $Y=0.216 $X2=0.972 $Y2=0.232
r13 3 81 23.8708 $w=2.02e-08 $l=4.05e-08 $layer=LISD $thickness=2.7e-08
+ $X=0.972 $Y=0.054 $X2=0.972 $Y2=0.0945
r14 78 79 3.03147 $w=1.3e-08 $l=1.3e-08 $layer=M1 $thickness=3.6e-08 $X=1.607
+ $Y=0.232 $X2=1.62 $Y2=0.232
r15 25 68 1.03499 $w=1.77368e-08 $l=9.5e-09 $layer=M1 $thickness=3.6e-08
+ $X=1.594 $Y=0.232 $X2=1.594 $Y2=0.2225
r16 25 78 1.85116 $w=1.64615e-08 $l=1.3e-08 $layer=M1 $thickness=3.6e-08
+ $X=1.594 $Y=0.232 $X2=1.607 $Y2=0.232
r17 75 76 3.03147 $w=1.3e-08 $l=1.3e-08 $layer=M1 $thickness=3.6e-08 $X=1.607
+ $Y=0.086 $X2=1.62 $Y2=0.086
r18 24 65 3.36689 $w=1.53077e-08 $l=1.95e-08 $layer=M1 $thickness=3.6e-08
+ $X=1.594 $Y=0.086 $X2=1.594 $Y2=0.1055
r19 24 75 1.85116 $w=1.64615e-08 $l=1.3e-08 $layer=M1 $thickness=3.6e-08
+ $X=1.594 $Y=0.086 $X2=1.607 $Y2=0.086
r20 73 74 3.03147 $w=1.3e-08 $l=1.3e-08 $layer=M1 $thickness=3.6e-08 $X=0.972
+ $Y=0.232 $X2=0.985 $Y2=0.232
r21 21 63 1.03499 $w=1.77368e-08 $l=9.5e-09 $layer=M1 $thickness=3.6e-08
+ $X=0.998 $Y=0.232 $X2=0.998 $Y2=0.2225
r22 21 74 1.85116 $w=1.64615e-08 $l=1.3e-08 $layer=M1 $thickness=3.6e-08
+ $X=0.998 $Y=0.232 $X2=0.985 $Y2=0.232
r23 70 71 3.03147 $w=1.3e-08 $l=1.3e-08 $layer=M1 $thickness=3.6e-08 $X=0.972
+ $Y=0.086 $X2=0.985 $Y2=0.086
r24 70 81 19.3796 $a=3.24e-16 $layer=V0LISD $X=0.972 $Y=0.086 $X2=0.972
+ $Y2=0.0945
r25 20 59 1.38478 $w=1.70909e-08 $l=1.1e-08 $layer=M1 $thickness=3.6e-08
+ $X=0.998 $Y=0.086 $X2=0.998 $Y2=0.097
r26 20 71 1.85116 $w=1.64615e-08 $l=1.3e-08 $layer=M1 $thickness=3.6e-08
+ $X=0.998 $Y=0.086 $X2=0.985 $Y2=0.086
r27 67 68 2.91487 $w=1.3e-08 $l=1.25e-08 $layer=M1 $thickness=3.6e-08 $X=1.594
+ $Y=0.21 $X2=1.594 $Y2=0.2225
r28 66 67 3.03147 $w=1.3e-08 $l=1.3e-08 $layer=M1 $thickness=3.6e-08 $X=1.594
+ $Y=0.197 $X2=1.594 $Y2=0.21
r29 64 66 2.09871 $w=1.3e-08 $l=9e-09 $layer=M1 $thickness=3.6e-08 $X=1.594
+ $Y=0.188 $X2=1.594 $Y2=0.197
r30 28 64 9.32759 $w=1.3e-08 $l=4e-08 $layer=M1 $thickness=3.6e-08 $X=1.594
+ $Y=0.148 $X2=1.594 $Y2=0.188
r31 28 65 9.91056 $w=1.3e-08 $l=4.25e-08 $layer=M1 $thickness=3.6e-08 $X=1.594
+ $Y=0.148 $X2=1.594 $Y2=0.1055
r32 62 63 2.79828 $w=1.3e-08 $l=1.2e-08 $layer=M1 $thickness=3.6e-08 $X=0.998
+ $Y=0.2105 $X2=0.998 $Y2=0.2225
r33 61 62 2.79828 $w=1.3e-08 $l=1.2e-08 $layer=M1 $thickness=3.6e-08 $X=0.998
+ $Y=0.1985 $X2=0.998 $Y2=0.2105
r34 60 61 0.349785 $w=1.3e-08 $l=1.5e-09 $layer=M1 $thickness=3.6e-08 $X=0.998
+ $Y=0.197 $X2=0.998 $Y2=0.1985
r35 58 59 2.44849 $w=1.3e-08 $l=1.05e-08 $layer=M1 $thickness=3.6e-08 $X=0.998
+ $Y=0.1075 $X2=0.998 $Y2=0.097
r36 57 58 8.51143 $w=1.3e-08 $l=3.65e-08 $layer=M1 $thickness=3.6e-08 $X=0.998
+ $Y=0.144 $X2=0.998 $Y2=0.1075
r37 56 60 2.09871 $w=1.3e-08 $l=9e-09 $layer=M1 $thickness=3.6e-08 $X=0.998
+ $Y=0.188 $X2=0.998 $Y2=0.197
r38 26 56 2.79828 $w=1.3e-08 $l=1.2e-08 $layer=M1 $thickness=3.6e-08 $X=0.998
+ $Y=0.176 $X2=0.998 $Y2=0.188
r39 26 57 7.46207 $w=1.3e-08 $l=3.2e-08 $layer=M1 $thickness=3.6e-08 $X=0.998
+ $Y=0.176 $X2=0.998 $Y2=0.144
r40 54 64 19.5347 $a=3.24e-16 $layer=V1 $X=1.594 $Y=0.189 $X2=1.594 $Y2=0.188
r41 53 54 30.0815 $w=1.3e-08 $l=1.29e-07 $layer=M2 $thickness=3.6e-08 $X=1.465
+ $Y=0.189 $X2=1.594 $Y2=0.189
r42 52 53 30.0815 $w=1.3e-08 $l=1.29e-07 $layer=M2 $thickness=3.6e-08 $X=1.336
+ $Y=0.189 $X2=1.465 $Y2=0.189
r43 51 52 12.5922 $w=1.3e-08 $l=5.4e-08 $layer=M2 $thickness=3.6e-08 $X=1.282
+ $Y=0.189 $X2=1.336 $Y2=0.189
r44 50 51 37.3104 $w=1.3e-08 $l=1.6e-07 $layer=M2 $thickness=3.6e-08 $X=1.122
+ $Y=0.189 $X2=1.282 $Y2=0.189
r45 49 50 28.9155 $w=1.3e-08 $l=1.24e-07 $layer=M2 $thickness=3.6e-08 $X=0.998
+ $Y=0.189 $X2=1.122 $Y2=0.189
r46 49 56 19.5347 $a=3.24e-16 $layer=V1 $X=0.998 $Y=0.189 $X2=0.998 $Y2=0.188
r47 29 49 2.91487 $w=1.3e-08 $l=1.25e-08 $layer=M2 $thickness=3.6e-08 $X=0.9855
+ $Y=0.189 $X2=0.998 $Y2=0.189
r48 47 52 19.5347 $a=3.24e-16 $layer=V1 $X=1.3405 $Y=0.189 $X2=1.336 $Y2=0.189
r49 46 47 1.51573 $w=1.3e-08 $l=6.5e-09 $layer=M1 $thickness=3.6e-08 $X=1.334
+ $Y=0.189 $X2=1.3405 $Y2=0.189
r50 45 46 0.721491 $w=1.57778e-08 $l=4.5e-09 $layer=M1 $thickness=3.6e-08
+ $X=1.3295 $Y=0.189 $X2=1.334 $Y2=0.189
r51 23 45 0.9184 $w=1.8e-08 $l=9e-09 $layer=M1 $thickness=3.6e-08 $X=1.3205
+ $Y=0.189 $X2=1.3295 $Y2=0.189
r52 22 27 4.29965 $w=1.49149e-08 $l=2.35e-08 $layer=M1 $thickness=3.6e-08
+ $X=1.323 $Y=0.081 $X2=1.323 $Y2=0.1045
r53 43 45 4.68572 $w=1.35814e-08 $l=2.87446e-08 $layer=M1 $thickness=3.6e-08
+ $X=1.323 $Y=0.161 $X2=1.3295 $Y2=0.189
r54 42 43 6.52931 $w=1.3e-08 $l=2.8e-08 $layer=M1 $thickness=3.6e-08 $X=1.323
+ $Y=0.133 $X2=1.323 $Y2=0.161
r55 41 42 2.68168 $w=1.3e-08 $l=1.15e-08 $layer=M1 $thickness=3.6e-08 $X=1.323
+ $Y=0.1215 $X2=1.323 $Y2=0.133
r56 27 41 3.96423 $w=1.3e-08 $l=1.7e-08 $layer=M1 $thickness=3.6e-08 $X=1.323
+ $Y=0.1045 $X2=1.323 $Y2=0.1215
r57 1 35 6.63025 $w=2.04878e-08 $layer=Gate_1 $thickness=5.20976e-08 $X=1.323
+ $Y=0.1335 $X2=1.323 $Y2=0.1335
r58 1 42 19.3796 $a=3.24e-16 $layer=V0LIG $X=1.323 $Y=0.1335 $X2=1.323 $Y2=0.133
r59 37 36 16.8368 $w=2.1e-08 $l=4.95e-08 $layer=Gate_1 $thickness=5.6e-08
+ $X=1.323 $Y=0.2295 $X2=1.323 $Y2=0.18
r60 35 36 15.995 $w=2.07742e-08 $l=4.65e-08 $layer=Gate_1 $thickness=5.6e-08
+ $X=1.323 $Y=0.1335 $X2=1.323 $Y2=0.18
r61 34 35 6.30106 $w=2.04167e-08 $l=1.8e-08 $layer=Gate_1 $thickness=5.6e-08
+ $X=1.323 $Y=0.1155 $X2=1.323 $Y2=0.1335
r62 33 34 16.3266 $w=2.1e-08 $l=4.8e-08 $layer=Gate_1 $thickness=5.6e-08
+ $X=1.323 $Y=0.0675 $X2=1.323 $Y2=0.1155
r63 33 15 14.6259 $w=2.1e-08 $l=4.3e-08 $layer=Gate_1 $thickness=5.6e-08
+ $X=1.323 $Y=0.0675 $X2=1.323 $Y2=0.0245
r64 5 17 1e-05 $l=7.28011e-09 $X=1.62 $Y=0.0605 $X2=1.622 $Y2=0.0675
.ends

.subckt PM_ICGx4DC_ASAP7_75t_R%23__2 vss 2 3 1
c1 1 vss 0.000893482f $X=0.216 $Y=0.0675
r1 2 1 0.209877 $w=8.1e-08 $l=1.7e-08 $layer=N_src_drn $thickness=1e-09
+ $X=0.1986 $Y=0.0675 $X2=0.216 $Y2=0.0675
r2 3 1 0.209877 $w=8.1e-08 $l=1.7e-08 $layer=N_src_drn $thickness=1e-09
+ $X=0.2333 $Y=0.0675 $X2=0.216 $Y2=0.0675
.ends

.subckt PM_ICGx4DC_ASAP7_75t_R%24 vss 2 3 1
c1 1 vss 0.000803317f $X=0.324 $Y=0.0675
r1 2 1 0.209877 $w=8.1e-08 $l=1.7e-08 $layer=N_src_drn $thickness=1e-09
+ $X=0.3066 $Y=0.0675 $X2=0.324 $Y2=0.0675
r2 3 1 0.209877 $w=8.1e-08 $l=1.7e-08 $layer=N_src_drn $thickness=1e-09
+ $X=0.3413 $Y=0.0675 $X2=0.324 $Y2=0.0675
.ends

.subckt PM_ICGx4DC_ASAP7_75t_R%25__2 vss 2 3 1
c1 1 vss 0.000883228f $X=0.756 $Y=0.0675
r1 2 1 0.209877 $w=8.1e-08 $l=1.7e-08 $layer=N_src_drn $thickness=1e-09
+ $X=0.7386 $Y=0.0675 $X2=0.756 $Y2=0.0675
r2 3 1 0.209877 $w=8.1e-08 $l=1.7e-08 $layer=N_src_drn $thickness=1e-09
+ $X=0.7733 $Y=0.0675 $X2=0.756 $Y2=0.0675
.ends

.subckt PM_ICGx4DC_ASAP7_75t_R%26 vss 2 3 1
c1 1 vss 0.000779609f $X=0.864 $Y=0.0675
r1 2 1 0.209877 $w=8.1e-08 $l=1.7e-08 $layer=N_src_drn $thickness=1e-09
+ $X=0.8466 $Y=0.0675 $X2=0.864 $Y2=0.0675
r2 3 1 0.209877 $w=8.1e-08 $l=1.7e-08 $layer=N_src_drn $thickness=1e-09
+ $X=0.8813 $Y=0.0675 $X2=0.864 $Y2=0.0675
.ends

.subckt PM_ICGx4DC_ASAP7_75t_R%27__2 vss 2 3 1
c1 1 vss 0.000777456f $X=1.728 $Y=0.0675
r1 2 1 0.209877 $w=8.1e-08 $l=1.7e-08 $layer=N_src_drn $thickness=1e-09
+ $X=1.7106 $Y=0.0675 $X2=1.728 $Y2=0.0675
r2 3 1 0.209877 $w=8.1e-08 $l=1.7e-08 $layer=N_src_drn $thickness=1e-09
+ $X=1.7453 $Y=0.0675 $X2=1.728 $Y2=0.0675
.ends

.subckt PM_ICGx4DC_ASAP7_75t_R%28 vss 2 3 1
c1 1 vss 0.000883163f $X=1.836 $Y=0.0675
r1 2 1 0.209877 $w=8.1e-08 $l=1.7e-08 $layer=N_src_drn $thickness=1e-09
+ $X=1.8186 $Y=0.0675 $X2=1.836 $Y2=0.0675
r2 3 1 0.209877 $w=8.1e-08 $l=1.7e-08 $layer=N_src_drn $thickness=1e-09
+ $X=1.8533 $Y=0.0675 $X2=1.836 $Y2=0.0675
.ends

.subckt PM_ICGx4DC_ASAP7_75t_R%29__2 vss 2 3 1
c1 1 vss 0.000802985f $X=2.268 $Y=0.0675
r1 2 1 0.209877 $w=8.1e-08 $l=1.7e-08 $layer=N_src_drn $thickness=1e-09
+ $X=2.2506 $Y=0.0675 $X2=2.268 $Y2=0.0675
r2 3 1 0.209877 $w=8.1e-08 $l=1.7e-08 $layer=N_src_drn $thickness=1e-09
+ $X=2.2853 $Y=0.0675 $X2=2.268 $Y2=0.0675
.ends

.subckt PM_ICGx4DC_ASAP7_75t_R%30 vss 2 3 1
c1 1 vss 0.00089336f $X=2.376 $Y=0.0675
r1 2 1 0.209877 $w=8.1e-08 $l=1.7e-08 $layer=N_src_drn $thickness=1e-09
+ $X=2.3586 $Y=0.0675 $X2=2.376 $Y2=0.0675
r2 3 1 0.209877 $w=8.1e-08 $l=1.7e-08 $layer=N_src_drn $thickness=1e-09
+ $X=2.3933 $Y=0.0675 $X2=2.376 $Y2=0.0675
.ends

.subckt PM_ICGx4DC_ASAP7_75t_R%ENA vss 30 11 15 8 9 1 3 6 5 7 4
c1 1 vss 0.00197255f $X=1.107 $Y=0.135
c2 3 vss 0.0424621f $X=1.107 $Y=0.0245
c3 4 vss 0.000771294f $X=1.107 $Y=0.1855
c4 5 vss 0.00268057f $X=1.0855 $Y=0.223
c5 6 vss 0.00416994f $X=1.054 $Y=0.2315
c6 7 vss 0.000617176f $X=1.0855 $Y=0.2075
c7 8 vss 0.00302817f $X=1.107 $Y=0.1115
c8 9 vss 0.011533f $X=1.029 $Y=0.225
r1 6 26 4.85944 $w=1.49259e-08 $l=3.15991e-08 $layer=M1 $thickness=3.6e-08
+ $X=1.054 $Y=0.2315 $X2=1.0855 $Y2=0.229
r2 30 29 1.57403 $w=1.3e-08 $l=6.8e-09 $layer=M2 $thickness=3.6e-08 $X=1.108
+ $Y=0.224 $X2=1.1012 $Y2=0.225
r3 28 29 3.67274 $w=1.3e-08 $l=1.57e-08 $layer=M2 $thickness=3.6e-08 $X=1.0855
+ $Y=0.225 $X2=1.1012 $Y2=0.225
r4 9 28 13.1752 $w=1.3e-08 $l=5.65e-08 $layer=M2 $thickness=3.6e-08 $X=1.029
+ $Y=0.225 $X2=1.0855 $Y2=0.225
r5 26 28 26.9768 $a=2.28e-16 $layer=V1 $X=1.0855 $Y=0.229 $X2=1.0855 $Y2=0.225
r6 5 25 0.692634 $w=1.525e-08 $l=4e-09 $layer=M1 $thickness=3.6e-08 $X=1.0855
+ $Y=0.223 $X2=1.0855 $Y2=0.219
r7 5 26 0.565404 $w=1.9e-08 $l=6e-09 $layer=M1 $thickness=3.6e-08 $X=1.0855
+ $Y=0.223 $X2=1.0855 $Y2=0.229
r8 5 6 4.4825 $w=1.42174e-08 $l=3.26267e-08 $layer=M1 $thickness=3.6e-08
+ $X=1.0855 $Y=0.223 $X2=1.054 $Y2=0.2315
r9 25 28 53.9535 $a=1.14e-16 $layer=V1 $X=1.0855 $Y=0.219 $X2=1.0855 $Y2=0.225
r10 7 25 2.29387 $w=1.4e-08 $l=1.15e-08 $layer=M1 $thickness=3.6e-08 $X=1.0855
+ $Y=0.2075 $X2=1.0855 $Y2=0.219
r11 7 24 2.19496 $w=2.08611e-08 $l=2.2e-08 $layer=M1 $thickness=3.6e-08
+ $X=1.0855 $Y=0.2075 $X2=1.0855 $Y2=0.1855
r12 23 24 0.612083 $w=2.63182e-08 $l=1.1e-08 $layer=M1 $thickness=3.6e-08
+ $X=1.0965 $Y=0.1855 $X2=1.0855 $Y2=0.1855
r13 4 20 3.50467 $w=1.87273e-08 $l=2.65e-08 $layer=M1 $thickness=3.6e-08
+ $X=1.107 $Y=0.1855 $X2=1.107 $Y2=0.159
r14 4 23 0.585794 $w=2.62857e-08 $l=1.05e-08 $layer=M1 $thickness=3.6e-08
+ $X=1.107 $Y=0.1855 $X2=1.0965 $Y2=0.1855
r15 19 20 5.13018 $w=1.3e-08 $l=2.2e-08 $layer=M1 $thickness=3.6e-08 $X=1.107
+ $Y=0.137 $X2=1.107 $Y2=0.159
r16 8 19 5.94634 $w=1.3e-08 $l=2.55e-08 $layer=M1 $thickness=3.6e-08 $X=1.107
+ $Y=0.1115 $X2=1.107 $Y2=0.137
r17 1 13 6.54019 $w=2.09524e-08 $layer=Gate_1 $thickness=5.21905e-08 $X=1.107
+ $Y=0.135 $X2=1.107 $Y2=0.135
r18 1 19 19.3796 $a=3.24e-16 $layer=V0LIG $X=1.107 $Y=0.135 $X2=1.107 $Y2=0.137
r19 15 14 16.4967 $w=2.1e-08 $l=4.85e-08 $layer=Gate_1 $thickness=5.6e-08
+ $X=1.107 $Y=0.216 $X2=1.107 $Y2=0.1675
r20 13 14 11.2416 $w=2.06615e-08 $l=3.25e-08 $layer=Gate_1 $thickness=5.6e-08
+ $X=1.107 $Y=0.135 $X2=1.107 $Y2=0.1675
r21 12 13 11.2416 $w=2.06615e-08 $l=3.25e-08 $layer=Gate_1 $thickness=5.6e-08
+ $X=1.107 $Y=0.1025 $X2=1.107 $Y2=0.135
r22 11 12 16.4967 $w=2.1e-08 $l=4.85e-08 $layer=Gate_1 $thickness=5.6e-08
+ $X=1.107 $Y=0.054 $X2=1.107 $Y2=0.1025
r23 11 3 10.0341 $w=2.1e-08 $l=2.95e-08 $layer=Gate_1 $thickness=5.6e-08
+ $X=1.107 $Y=0.054 $X2=1.107 $Y2=0.0245
.ends

.subckt PM_ICGx4DC_ASAP7_75t_R%11 vss 17 21 50 51 53 16 1 9 11 3 15 14 4 10
c1 1 vss 0.00352115f $X=1.215 $Y=0.134
c2 3 vss 0.0136571f $X=1.1235 $Y=0.216
c3 4 vss 0.00840718f $X=1.134 $Y=0.054
c4 9 vss 0.0862417f $X=1.215 $Y=0.0245
c5 10 vss 0.007888f $X=1.1195 $Y=0.054
c6 11 vss 0.0326293f $X=1.082 $Y=0.216
c7 12 vss 0.00324576f $X=1.215 $Y=0.036
c8 13 vss 0.00311378f $X=1.215 $Y=0.2325
c9 14 vss 0.0116984f $X=1.188 $Y=0.036
c10 15 vss 0.00897412f $X=1.188 $Y=0.233
c11 16 vss 0.00687343f $X=1.215 $Y=0.1045
r1 53 52 0.0462963 $w=5.4e-08 $l=2.5e-09 $layer=P_src_drn $thickness=1e-09
+ $X=1.0973 $Y=0.216 $X2=1.0945 $Y2=0.216
r2 11 52 0.231482 $w=5.4e-08 $l=1.25e-08 $layer=P_src_drn $thickness=1e-09
+ $X=1.082 $Y=0.216 $X2=1.0945 $Y2=0.216
r3 51 49 0.0462963 $w=5.4e-08 $l=2.5e-09 $layer=N_src_drn $thickness=1e-09
+ $X=1.1513 $Y=0.054 $X2=1.1485 $Y2=0.054
r4 4 49 0.268519 $w=5.4e-08 $l=1.45e-08 $layer=N_src_drn $thickness=1e-09
+ $X=1.134 $Y=0.054 $X2=1.1485 $Y2=0.054
r5 10 4 0.268519 $w=5.4e-08 $l=1.45e-08 $layer=N_src_drn $thickness=1e-09
+ $X=1.1195 $Y=0.054 $X2=1.134 $Y2=0.054
r6 50 10 0.0462963 $w=5.4e-08 $l=2.5e-09 $layer=N_src_drn $thickness=1e-09
+ $X=1.1166 $Y=0.054 $X2=1.1195 $Y2=0.054
r7 45 11 4.04632 $w=5.02e-08 $l=2.7e-08 $layer=LISD $thickness=2.7e-08 $X=1.107
+ $Y=0.216 $X2=1.082 $Y2=0.216
r8 3 43 1.57357 $w=5.02e-08 $l=1.05e-08 $layer=LISD $thickness=2.7e-08
+ $X=1.1235 $Y=0.216 $X2=1.134 $Y2=0.216
r9 3 45 2.47275 $w=5.02e-08 $l=1.65e-08 $layer=LISD $thickness=2.7e-08
+ $X=1.1235 $Y=0.216 $X2=1.107 $Y2=0.216
r10 4 35 19.3796 $a=3.24e-16 $layer=V0LISD $X=1.134 $Y=0.054 $X2=1.134 $Y2=0.036
r11 41 42 3.14806 $w=1.3e-08 $l=1.35e-08 $layer=M1 $thickness=3.6e-08 $X=1.134
+ $Y=0.233 $X2=1.1475 $Y2=0.233
r12 41 43 19.3796 $a=3.24e-16 $layer=V0LISD $X=1.134 $Y=0.233 $X2=1.134
+ $Y2=0.216
r13 39 42 3.14806 $w=1.3e-08 $l=1.35e-08 $layer=M1 $thickness=3.6e-08 $X=1.161
+ $Y=0.233 $X2=1.1475 $Y2=0.233
r14 15 39 6.29612 $w=1.3e-08 $l=2.7e-08 $layer=M1 $thickness=3.6e-08 $X=1.188
+ $Y=0.233 $X2=1.161 $Y2=0.233
r15 35 36 3.14806 $w=1.3e-08 $l=1.35e-08 $layer=M1 $thickness=3.6e-08 $X=1.134
+ $Y=0.036 $X2=1.1475 $Y2=0.036
r16 33 36 3.14806 $w=1.3e-08 $l=1.35e-08 $layer=M1 $thickness=3.6e-08 $X=1.161
+ $Y=0.036 $X2=1.1475 $Y2=0.036
r17 14 33 6.29612 $w=1.3e-08 $l=2.7e-08 $layer=M1 $thickness=3.6e-08 $X=1.188
+ $Y=0.036 $X2=1.161 $Y2=0.036
r18 13 31 0.983973 $w=1.77222e-08 $l=9e-09 $layer=M1 $thickness=3.6e-08
+ $X=1.215 $Y=0.2325 $X2=1.215 $Y2=0.2235
r19 13 15 5.06479 $w=1.46038e-08 $l=2.70046e-08 $layer=M1 $thickness=3.6e-08
+ $X=1.215 $Y=0.2325 $X2=1.188 $Y2=0.233
r20 12 26 3.36447 $w=1.71023e-08 $l=2.15e-08 $layer=M1 $thickness=3.6e-08
+ $X=1.215 $Y=0.036 $X2=1.215 $Y2=0.0575
r21 12 14 4.64701 $w=1.46667e-08 $l=2.7e-08 $layer=M1 $thickness=3.6e-08
+ $X=1.215 $Y=0.036 $X2=1.188 $Y2=0.036
r22 30 31 2.91487 $w=1.3e-08 $l=1.25e-08 $layer=M1 $thickness=3.6e-08 $X=1.215
+ $Y=0.211 $X2=1.215 $Y2=0.2235
r23 29 30 2.91487 $w=1.3e-08 $l=1.25e-08 $layer=M1 $thickness=3.6e-08 $X=1.215
+ $Y=0.1985 $X2=1.215 $Y2=0.211
r24 28 29 1.74892 $w=1.3e-08 $l=7.5e-09 $layer=M1 $thickness=3.6e-08 $X=1.215
+ $Y=0.191 $X2=1.215 $Y2=0.1985
r25 27 28 9.211 $w=1.3e-08 $l=3.95e-08 $layer=M1 $thickness=3.6e-08 $X=1.215
+ $Y=0.1515 $X2=1.215 $Y2=0.191
r26 25 26 3.14806 $w=1.3e-08 $l=1.35e-08 $layer=M1 $thickness=3.6e-08 $X=1.215
+ $Y=0.071 $X2=1.215 $Y2=0.0575
r27 24 25 2.3319 $w=1.3e-08 $l=1e-08 $layer=M1 $thickness=3.6e-08 $X=1.215
+ $Y=0.081 $X2=1.215 $Y2=0.071
r28 16 24 5.47996 $w=1.3e-08 $l=2.35e-08 $layer=M1 $thickness=3.6e-08 $X=1.215
+ $Y=0.1045 $X2=1.215 $Y2=0.081
r29 16 27 10.9599 $w=1.3e-08 $l=4.7e-08 $layer=M1 $thickness=3.6e-08 $X=1.215
+ $Y=0.1045 $X2=1.215 $Y2=0.1515
r30 1 19 9.83583 $w=1.77619e-08 $l=1e-09 $layer=LIG $thickness=5.21905e-08
+ $X=1.215 $Y=0.134 $X2=1.215 $Y2=0.135
r31 1 27 19.3796 $a=3.24e-16 $layer=V0LIG $X=1.215 $Y=0.134 $X2=1.215 $Y2=0.1515
r32 21 20 16.4967 $w=2.1e-08 $l=4.85e-08 $layer=Gate_1 $thickness=5.6e-08
+ $X=1.215 $Y=0.2025 $X2=1.215 $Y2=0.154
r33 19 20 6.6497 $w=2.04211e-08 $l=1.9e-08 $layer=Gate_1 $thickness=5.6e-08
+ $X=1.215 $Y=0.135 $X2=1.215 $Y2=0.154
r34 18 19 6.6497 $w=2.04211e-08 $l=1.9e-08 $layer=Gate_1 $thickness=5.6e-08
+ $X=1.215 $Y=0.116 $X2=1.215 $Y2=0.135
r35 17 18 16.4967 $w=2.1e-08 $l=4.85e-08 $layer=Gate_1 $thickness=5.6e-08
+ $X=1.215 $Y=0.0675 $X2=1.215 $Y2=0.116
r36 17 9 14.6259 $w=2.1e-08 $l=4.3e-08 $layer=Gate_1 $thickness=5.6e-08
+ $X=1.215 $Y=0.0675 $X2=1.215 $Y2=0.0245
.ends

.subckt PM_ICGx4DC_ASAP7_75t_R%31 vss 2 3 1
c1 1 vss 0.00632774f $X=1.134 $Y=0.216
r1 2 1 0.314815 $w=5.4e-08 $l=1.7e-08 $layer=P_src_drn $thickness=1e-09
+ $X=1.1166 $Y=0.216 $X2=1.134 $Y2=0.216
r2 3 1 0.314815 $w=5.4e-08 $l=1.7e-08 $layer=P_src_drn $thickness=1e-09
+ $X=1.1513 $Y=0.216 $X2=1.134 $Y2=0.216
.ends

.subckt PM_ICGx4DC_ASAP7_75t_R%3 vss 24 30 39 42 60 61 70 71 74 75 13 16 15 3 5
+ 19 4 21 1 20 14 23 12 22 18 17
c1 1 vss 0.00659268f $X=0.081 $Y=0.136
c2 3 vss 0.00704175f $X=0.216 $Y=0.216
c3 4 vss 0.00481197f $X=0.27 $Y=0.0675
c4 5 vss 0.00787855f $X=0.324 $Y=0.216
c5 12 vss 0.0630696f $X=0.081 $Y=0.0245
c6 13 vss 0.0727305f $X=0.135 $Y=0.136
c7 14 vss 0.00277162f $X=0.2555 $Y=0.0675
c8 15 vss 0.00369096f $X=0.2015 $Y=0.216
c9 16 vss 0.00387428f $X=0.3095 $Y=0.216
c10 17 vss 0.00051094f $X=0.135 $Y=0.072
c11 18 vss 0.00061853f $X=0.135 $Y=0.197
c12 19 vss 0.00300522f $X=0.189 $Y=0.1885
c13 20 vss 0.00148774f $X=0.135 $Y=0.113
c14 21 vss 0.00460153f $X=0.1455 $Y=0.072
c15 22 vss 0.0013182f $X=0.162 $Y=0.197
c16 23 vss 0.0116066f $X=0.2025 $Y=0.231
r1 75 73 0.0462963 $w=5.4e-08 $l=2.5e-09 $layer=P_src_drn $thickness=1e-09
+ $X=0.3413 $Y=0.216 $X2=0.3385 $Y2=0.216
r2 5 73 0.268519 $w=5.4e-08 $l=1.45e-08 $layer=P_src_drn $thickness=1e-09
+ $X=0.324 $Y=0.216 $X2=0.3385 $Y2=0.216
r3 16 5 0.268519 $w=5.4e-08 $l=1.45e-08 $layer=P_src_drn $thickness=1e-09
+ $X=0.3095 $Y=0.216 $X2=0.324 $Y2=0.216
r4 74 16 0.0462963 $w=5.4e-08 $l=2.5e-09 $layer=P_src_drn $thickness=1e-09
+ $X=0.3066 $Y=0.216 $X2=0.3095 $Y2=0.216
r5 71 69 0.0462963 $w=5.4e-08 $l=2.5e-09 $layer=P_src_drn $thickness=1e-09
+ $X=0.2333 $Y=0.216 $X2=0.2305 $Y2=0.216
r6 3 69 0.268519 $w=5.4e-08 $l=1.45e-08 $layer=P_src_drn $thickness=1e-09
+ $X=0.216 $Y=0.216 $X2=0.2305 $Y2=0.216
r7 15 3 0.268519 $w=5.4e-08 $l=1.45e-08 $layer=P_src_drn $thickness=1e-09
+ $X=0.2015 $Y=0.216 $X2=0.216 $Y2=0.216
r8 70 15 0.0462963 $w=5.4e-08 $l=2.5e-09 $layer=P_src_drn $thickness=1e-09
+ $X=0.1986 $Y=0.216 $X2=0.2015 $Y2=0.216
r9 5 66 19.3796 $a=3.24e-16 $layer=V0LISD $X=0.324 $Y=0.216 $X2=0.325 $Y2=0.231
r10 3 62 19.3796 $a=3.24e-16 $layer=V0LISD $X=0.216 $Y=0.216 $X2=0.216 $Y2=0.231
r11 65 66 2.09871 $w=1.3e-08 $l=9e-09 $layer=M1 $thickness=3.6e-08 $X=0.316
+ $Y=0.231 $X2=0.325 $Y2=0.231
r12 64 65 8.04505 $w=1.3e-08 $l=3.45e-08 $layer=M1 $thickness=3.6e-08 $X=0.2815
+ $Y=0.231 $X2=0.316 $Y2=0.231
r13 63 64 10.4935 $w=1.3e-08 $l=4.5e-08 $layer=M1 $thickness=3.6e-08 $X=0.2365
+ $Y=0.231 $X2=0.2815 $Y2=0.231
r14 62 63 4.78039 $w=1.3e-08 $l=2.05e-08 $layer=M1 $thickness=3.6e-08 $X=0.216
+ $Y=0.231 $X2=0.2365 $Y2=0.231
r15 23 62 3.14806 $w=1.3e-08 $l=1.35e-08 $layer=M1 $thickness=3.6e-08 $X=0.2025
+ $Y=0.231 $X2=0.216 $Y2=0.231
r16 23 56 1.20242 $w=1.425e-08 $l=1.54434e-08 $layer=M1 $thickness=3.6e-08
+ $X=0.2025 $Y=0.231 $X2=0.189 $Y2=0.2235
r17 61 59 0.0308642 $w=8.1e-08 $l=2.5e-09 $layer=N_src_drn $thickness=1e-09
+ $X=0.2873 $Y=0.0675 $X2=0.2845 $Y2=0.0675
r18 4 59 0.179012 $w=8.1e-08 $l=1.45e-08 $layer=N_src_drn $thickness=1e-09
+ $X=0.27 $Y=0.0675 $X2=0.2845 $Y2=0.0675
r19 14 4 0.179012 $w=8.1e-08 $l=1.45e-08 $layer=N_src_drn $thickness=1e-09
+ $X=0.2555 $Y=0.0675 $X2=0.27 $Y2=0.0675
r20 60 14 0.0308642 $w=8.1e-08 $l=2.5e-09 $layer=N_src_drn $thickness=1e-09
+ $X=0.2526 $Y=0.0675 $X2=0.2555 $Y2=0.0675
r21 55 56 2.01858 $w=1.37895e-08 $l=9.5e-09 $layer=M1 $thickness=3.6e-08
+ $X=0.189 $Y=0.214 $X2=0.189 $Y2=0.2235
r22 54 55 2.7329 $w=1.55758e-08 $l=1.65e-08 $layer=M1 $thickness=3.6e-08
+ $X=0.189 $Y=0.1975 $X2=0.189 $Y2=0.214
r23 19 22 4.24844 $w=1.31351e-08 $l=2.83064e-08 $layer=M1 $thickness=3.6e-08
+ $X=0.189 $Y=0.1885 $X2=0.162 $Y2=0.197
r24 19 54 0.9184 $w=1.8e-08 $l=9e-09 $layer=M1 $thickness=3.6e-08 $X=0.189
+ $Y=0.1885 $X2=0.189 $Y2=0.1975
r25 4 52 19.3796 $a=3.24e-16 $layer=V0LISD $X=0.27 $Y=0.0675 $X2=0.27 $Y2=0.072
r26 51 52 9.44419 $w=1.3e-08 $l=4.05e-08 $layer=M1 $thickness=3.6e-08 $X=0.2295
+ $Y=0.072 $X2=0.27 $Y2=0.072
r27 50 51 9.44419 $w=1.3e-08 $l=4.05e-08 $layer=M1 $thickness=3.6e-08 $X=0.189
+ $Y=0.072 $X2=0.2295 $Y2=0.072
r28 49 50 5.94634 $w=1.3e-08 $l=2.55e-08 $layer=M1 $thickness=3.6e-08 $X=0.1635
+ $Y=0.072 $X2=0.189 $Y2=0.072
r29 21 49 4.19742 $w=1.3e-08 $l=1.8e-08 $layer=M1 $thickness=3.6e-08 $X=0.1455
+ $Y=0.072 $X2=0.1635 $Y2=0.072
r30 18 48 5.22999 $w=1.59898e-08 $l=2.95e-08 $layer=M1 $thickness=3.6e-08
+ $X=0.135 $Y=0.197 $X2=0.135 $Y2=0.1675
r31 18 22 4.64701 $w=1.46667e-08 $l=2.7e-08 $layer=M1 $thickness=3.6e-08
+ $X=0.135 $Y=0.197 $X2=0.162 $Y2=0.197
r32 17 47 1.49895 $w=1.95333e-08 $l=1.35e-08 $layer=M1 $thickness=3.6e-08
+ $X=0.135 $Y=0.072 $X2=0.135 $Y2=0.0855
r33 17 21 0.79938 $w=1.72857e-08 $l=1.05e-08 $layer=M1 $thickness=3.6e-08
+ $X=0.135 $Y=0.072 $X2=0.1455 $Y2=0.072
r34 46 47 2.09871 $w=1.3e-08 $l=9e-09 $layer=M1 $thickness=3.6e-08 $X=0.135
+ $Y=0.0945 $X2=0.135 $Y2=0.0855
r35 45 48 5.01358 $w=1.3e-08 $l=2.15e-08 $layer=M1 $thickness=3.6e-08 $X=0.135
+ $Y=0.146 $X2=0.135 $Y2=0.1675
r36 44 45 2.3319 $w=1.3e-08 $l=1e-08 $layer=M1 $thickness=3.6e-08 $X=0.135
+ $Y=0.136 $X2=0.135 $Y2=0.146
r37 20 44 5.36336 $w=1.3e-08 $l=2.3e-08 $layer=M1 $thickness=3.6e-08 $X=0.135
+ $Y=0.113 $X2=0.135 $Y2=0.136
r38 20 46 4.31401 $w=1.3e-08 $l=1.85e-08 $layer=M1 $thickness=3.6e-08 $X=0.135
+ $Y=0.113 $X2=0.135 $Y2=0.0945
r39 42 41 16.3266 $w=2.1e-08 $l=4.8e-08 $layer=Gate_1 $thickness=5.6e-08
+ $X=0.135 $Y=0.2295 $X2=0.135 $Y2=0.1815
r40 39 40 16.6668 $w=2.1e-08 $l=4.9e-08 $layer=Gate_1 $thickness=5.6e-08
+ $X=0.135 $Y=0.0405 $X2=0.135 $Y2=0.0895
r41 13 35 6.27904 $w=2.09e-08 $layer=Gate_1 $thickness=5.24e-08 $X=0.135
+ $Y=0.136 $X2=0.135 $Y2=0.136
r42 13 40 16.0035 $w=2.07634e-08 $l=4.65e-08 $layer=Gate_1 $thickness=5.6e-08
+ $X=0.135 $Y=0.136 $X2=0.135 $Y2=0.0895
r43 13 41 15.6634 $w=2.07582e-08 $l=4.55e-08 $layer=Gate_1 $thickness=5.6e-08
+ $X=0.135 $Y=0.136 $X2=0.135 $Y2=0.1815
r44 35 44 19.3796 $a=3.24e-16 $layer=V0LIG $X=0.135 $Y=0.136 $X2=0.135 $Y2=0.136
r45 34 35 2.48102 $w=2.2e-08 $l=9.5e-09 $layer=LIG $thickness=4.8e-08 $X=0.1255
+ $Y=0.136 $X2=0.135 $Y2=0.136
r46 33 34 10.1729 $w=1.54914e-08 $l=1.75e-08 $layer=LIG $thickness=4.8e-08
+ $X=0.108 $Y=0.136 $X2=0.1255 $Y2=0.136
r47 1 27 6.54019 $w=2.09524e-08 $layer=Gate_1 $thickness=5.21905e-08 $X=0.081
+ $Y=0.136 $X2=0.081 $Y2=0.136
r48 1 33 12.6539 $w=1.77815e-08 $l=2.7e-08 $layer=LIG $thickness=4.8e-08
+ $X=0.081 $Y=0.136 $X2=0.108 $Y2=0.136
r49 30 29 14.6259 $w=2.1e-08 $l=4.3e-08 $layer=Gate_1 $thickness=5.6e-08
+ $X=0.081 $Y=0.2295 $X2=0.081 $Y2=0.1865
r50 28 29 11.7348 $w=2.1e-08 $l=3.45e-08 $layer=Gate_1 $thickness=5.6e-08
+ $X=0.081 $Y=0.152 $X2=0.081 $Y2=0.1865
r51 27 28 5.62929 $w=2.03125e-08 $l=1.6e-08 $layer=Gate_1 $thickness=5.6e-08
+ $X=0.081 $Y=0.136 $X2=0.081 $Y2=0.152
r52 26 27 5.96942 $w=2.03529e-08 $l=1.7e-08 $layer=Gate_1 $thickness=5.6e-08
+ $X=0.081 $Y=0.119 $X2=0.081 $Y2=0.136
r53 25 26 12.0749 $w=2.1e-08 $l=3.55e-08 $layer=Gate_1 $thickness=5.6e-08
+ $X=0.081 $Y=0.0835 $X2=0.081 $Y2=0.119
r54 24 25 14.6259 $w=2.1e-08 $l=4.3e-08 $layer=Gate_1 $thickness=5.6e-08
+ $X=0.081 $Y=0.0405 $X2=0.081 $Y2=0.0835
r55 24 12 5.44221 $w=2.1e-08 $l=1.6e-08 $layer=Gate_1 $thickness=5.6e-08
+ $X=0.081 $Y=0.0405 $X2=0.081 $Y2=0.0245
.ends

.subckt PM_ICGx4DC_ASAP7_75t_R%4 vss 68 72 93 96 132 135 160 163 170 173 176
+ 179 192 195 198 201 217 220 234 237 246 249 38 39 26 2 25 50 1 62 41 46 44 55
+ 36 34 51 59 43 60 19 37 3 7 9 58 8 5 56 52 63 35 61 48 54 49 40 47 29 20 4 57
+ 6 28 33 30 32 27 31 53 42 45
c1 1 vss 0.00526291f $X=0.189 $Y=0.135
c2 2 vss 0.00582459f $X=0.351 $Y=0.135
c3 3 vss 0.00526316f $X=0.729 $Y=0.135
c4 4 vss 0.00568747f $X=0.891 $Y=0.135
c5 5 vss 0.00440749f $X=1.485 $Y=0.19
c6 6 vss 0.00568747f $X=1.701 $Y=0.135
c7 7 vss 0.00526316f $X=1.863 $Y=0.135
c8 8 vss 0.00585463f $X=2.241 $Y=0.135
c9 9 vss 0.00526291f $X=2.403 $Y=0.135
c10 19 vss 0.00587725f $X=1.296 $Y=0.2295
c11 20 vss 0.00577008f $X=1.35 $Y=0.0405
c12 25 vss 0.0926682f $X=0.189 $Y=0.135
c13 26 vss 0.0952272f $X=0.351 $Y=0.135
c14 27 vss 0.0955786f $X=0.729 $Y=0.0245
c15 28 vss 0.0951076f $X=0.891 $Y=0.135
c16 29 vss 0.0502928f $X=1.485 $Y=0.19
c17 30 vss 0.0943815f $X=1.701 $Y=0.135
c18 31 vss 0.0955786f $X=1.863 $Y=0.135
c19 32 vss 0.0952272f $X=2.241 $Y=0.135
c20 33 vss 0.0937156f $X=2.403 $Y=0.135
c21 34 vss 0.00331812f $X=1.3355 $Y=0.0405
c22 35 vss 0.00179309f $X=1.3355 $Y=0.081
c23 36 vss 0.0033106f $X=1.2815 $Y=0.2295
c24 37 vss 0.00178984f $X=1.2815 $Y=0.189
c25 38 vss 0.00163409f $X=0.189 $Y=0.108
c26 39 vss 0.0029923f $X=0.351 $Y=0.1125
c27 40 vss 0.00130736f $X=0.729 $Y=0.1205
c28 41 vss 0.00285975f $X=0.891 $Y=0.1035
c29 42 vss 0.00269227f $X=1.384 $Y=0.036
c30 43 vss 0.000906355f $X=1.384 $Y=0.1895
c31 44 vss 0.00328837f $X=1.384 $Y=0.2235
c32 45 vss 0.00366509f $X=1.701 $Y=0.036
c33 46 vss 0.00280717f $X=1.701 $Y=0.1165
c34 47 vss 0.00130736f $X=1.863 $Y=0.108
c35 48 vss 0.00300862f $X=2.241 $Y=0.1125
c36 49 vss 0.00164554f $X=2.403 $Y=0.108
c37 50 vss 0.00246314f $X=0.34 $Y=0.108
c38 51 vss 0.00188726f $X=0.7695 $Y=0.108
c39 52 vss 0.0079837f $X=1.3625 $Y=0.232
c40 53 vss 0.00414189f $X=1.3545 $Y=0.036
c41 54 vss 0.0011758f $X=1.384 $Y=0.0585
c42 55 vss 0.00118579f $X=1.384 $Y=0.211
c43 56 vss 0.024934f $X=1.674 $Y=0.036
c44 57 vss 0.00281506f $X=1.4055 $Y=0.19
c45 58 vss 0.00255919f $X=1.701 $Y=0.097
c46 59 vss 0.00188726f $X=1.739 $Y=0.108
c47 60 vss 0.00255819f $X=2.252 $Y=0.108
c48 61 vss 0.00493334f $X=0.339 $Y=0.117
c49 62 vss 0.00480509f $X=1.654 $Y=0.117
c50 63 vss 0.00228358f $X=0.979 $Y=0.117
r1 37 244 0.231482 $w=5.4e-08 $l=1.25e-08 $layer=P_src_drn $thickness=1e-09
+ $X=1.2815 $Y=0.189 $X2=1.296 $Y2=0.189
r2 249 248 0.0925926 $w=2.7e-08 $l=2.5e-09 $layer=P_src_drn $thickness=1e-09
+ $X=1.3133 $Y=0.2295 $X2=1.3105 $Y2=0.2295
r3 247 248 0.166667 $w=2.7e-08 $l=4.5e-09 $layer=P_src_drn $thickness=1e-09
+ $X=1.306 $Y=0.2295 $X2=1.3105 $Y2=0.2295
r4 244 247 0.444445 $w=2.7e-08 $l=1.2e-08 $layer=P_src_drn $thickness=1e-09
+ $X=1.296 $Y=0.189 $X2=1.306 $Y2=0.2295
r5 36 244 0.462963 $w=2.7e-08 $l=1.25e-08 $layer=P_src_drn $thickness=1e-09
+ $X=1.2815 $Y=0.2295 $X2=1.296 $Y2=0.189
r6 246 36 0.0925926 $w=2.7e-08 $l=2.5e-09 $layer=P_src_drn $thickness=1e-09
+ $X=1.2786 $Y=0.2025 $X2=1.2815 $Y2=0.2295
r7 19 241 19.3796 $a=3.24e-16 $layer=V0LISD $X=1.296 $Y=0.2295 $X2=1.296
+ $Y2=0.232
r8 19 244 23.8708 $w=2.02e-08 $l=4.05e-08 $layer=LISD $thickness=2.7e-08
+ $X=1.296 $Y=0.2295 $X2=1.296 $Y2=0.189
r9 241 242 3.14806 $w=1.3e-08 $l=1.35e-08 $layer=M1 $thickness=3.6e-08 $X=1.296
+ $Y=0.232 $X2=1.3095 $Y2=0.232
r10 239 242 5.24677 $w=1.3e-08 $l=2.25e-08 $layer=M1 $thickness=3.6e-08
+ $X=1.332 $Y=0.232 $X2=1.3095 $Y2=0.232
r11 52 239 7.11229 $w=1.3e-08 $l=3.05e-08 $layer=M1 $thickness=3.6e-08
+ $X=1.3625 $Y=0.232 $X2=1.332 $Y2=0.232
r12 237 236 7.31297 $w=2.1e-08 $l=2.15e-08 $layer=Gate_1 $thickness=5.6e-08
+ $X=1.485 $Y=0.2295 $X2=1.485 $Y2=0.208
r13 234 235 14.6259 $w=2.1e-08 $l=4.3e-08 $layer=Gate_1 $thickness=5.6e-08
+ $X=1.485 $Y=0.0405 $X2=1.485 $Y2=0.0835
r14 232 235 17.5171 $w=2.1e-08 $l=5.15e-08 $layer=Gate_1 $thickness=5.6e-08
+ $X=1.485 $Y=0.135 $X2=1.485 $Y2=0.0835
r15 231 232 11.3946 $w=2.1e-08 $l=3.35e-08 $layer=Gate_1 $thickness=5.6e-08
+ $X=1.485 $Y=0.1685 $X2=1.485 $Y2=0.135
r16 29 231 7.48304 $w=2.05349e-08 $l=2.15e-08 $layer=Gate_1 $thickness=5.6e-08
+ $X=1.485 $Y=0.19 $X2=1.485 $Y2=0.1685
r17 29 236 6.29255 $w=2.04444e-08 $l=1.8e-08 $layer=Gate_1 $thickness=5.6e-08
+ $X=1.485 $Y=0.19 $X2=1.485 $Y2=0.208
r18 44 55 2.8493 $w=1.32e-08 $l=1.25e-08 $layer=M1 $thickness=3.6e-08 $X=1.384
+ $Y=0.2235 $X2=1.384 $Y2=0.211
r19 44 52 2.96589 $w=1.31923e-08 $l=2.31193e-08 $layer=M1 $thickness=3.6e-08
+ $X=1.384 $Y=0.2235 $X2=1.3625 $Y2=0.232
r20 5 226 19.3796 $a=3.24e-16 $layer=V0LIG $X=1.485 $Y=0.19 $X2=1.485 $Y2=0.19
r21 5 29 6.74717 $w=2e-08 $layer=Gate_1 $thickness=5.2e-08 $X=1.485 $Y=0.19
+ $X2=1.485 $Y2=0.19
r22 55 215 2.8493 $w=1.32e-08 $l=1.25e-08 $layer=M1 $thickness=3.6e-08 $X=1.384
+ $Y=0.211 $X2=1.384 $Y2=0.1985
r23 225 226 2.44849 $w=1.3e-08 $l=1.05e-08 $layer=M1 $thickness=3.6e-08
+ $X=1.4745 $Y=0.19 $X2=1.485 $Y2=0.19
r24 224 225 4.19742 $w=1.3e-08 $l=1.8e-08 $layer=M1 $thickness=3.6e-08
+ $X=1.4565 $Y=0.19 $X2=1.4745 $Y2=0.19
r25 223 224 5.94634 $w=1.3e-08 $l=2.55e-08 $layer=M1 $thickness=3.6e-08
+ $X=1.431 $Y=0.19 $X2=1.4565 $Y2=0.19
r26 222 223 2.56509 $w=1.3e-08 $l=1.1e-08 $layer=M1 $thickness=3.6e-08 $X=1.42
+ $Y=0.19 $X2=1.431 $Y2=0.19
r27 57 222 3.38125 $w=1.3e-08 $l=1.45e-08 $layer=M1 $thickness=3.6e-08
+ $X=1.4055 $Y=0.19 $X2=1.42 $Y2=0.19
r28 35 213 0.231482 $w=5.4e-08 $l=1.25e-08 $layer=N_src_drn $thickness=1e-09
+ $X=1.3355 $Y=0.081 $X2=1.35 $Y2=0.074
r29 220 219 0.0925926 $w=2.7e-08 $l=2.5e-09 $layer=N_src_drn $thickness=1e-09
+ $X=1.3673 $Y=0.0405 $X2=1.3645 $Y2=0.0405
r30 218 219 0.166667 $w=2.7e-08 $l=4.5e-09 $layer=N_src_drn $thickness=1e-09
+ $X=1.36 $Y=0.0405 $X2=1.3645 $Y2=0.0405
r31 213 218 0.444445 $w=2.7e-08 $l=1.2e-08 $layer=N_src_drn $thickness=1e-09
+ $X=1.35 $Y=0.074 $X2=1.36 $Y2=0.0405
r32 34 213 0.462963 $w=2.7e-08 $l=1.25e-08 $layer=N_src_drn $thickness=1e-09
+ $X=1.3355 $Y=0.0405 $X2=1.35 $Y2=0.074
r33 217 34 0.0925926 $w=2.7e-08 $l=2.5e-09 $layer=N_src_drn $thickness=1e-09
+ $X=1.3326 $Y=0.0675 $X2=1.3355 $Y2=0.0405
r34 43 212 0.983973 $w=1.77222e-08 $l=9e-09 $layer=M1 $thickness=3.6e-08
+ $X=1.384 $Y=0.1895 $X2=1.384 $Y2=0.1805
r35 43 215 0.9184 $w=1.8e-08 $l=9e-09 $layer=M1 $thickness=3.6e-08 $X=1.384
+ $Y=0.1895 $X2=1.384 $Y2=0.1985
r36 43 57 3.78225 $w=1.50238e-08 $l=2.15058e-08 $layer=M1 $thickness=3.6e-08
+ $X=1.384 $Y=0.1895 $X2=1.4055 $Y2=0.19
r37 20 205 19.3796 $a=3.24e-16 $layer=V0LISD $X=1.35 $Y=0.0405 $X2=1.3455
+ $Y2=0.036
r38 20 213 19.745 $w=2.02e-08 $l=3.35e-08 $layer=LISD $thickness=2.7e-08
+ $X=1.35 $Y=0.0405 $X2=1.35 $Y2=0.074
r39 211 212 2.2153 $w=1.3e-08 $l=9.5e-09 $layer=M1 $thickness=3.6e-08 $X=1.384
+ $Y=0.171 $X2=1.384 $Y2=0.1805
r40 210 211 6.99569 $w=1.3e-08 $l=3e-08 $layer=M1 $thickness=3.6e-08 $X=1.384
+ $Y=0.141 $X2=1.384 $Y2=0.171
r41 209 210 8.27824 $w=1.3e-08 $l=3.55e-08 $layer=M1 $thickness=3.6e-08
+ $X=1.384 $Y=0.1055 $X2=1.384 $Y2=0.141
r42 208 209 3.49785 $w=1.3e-08 $l=1.5e-08 $layer=M1 $thickness=3.6e-08 $X=1.384
+ $Y=0.0905 $X2=1.384 $Y2=0.1055
r43 207 208 2.09871 $w=1.3e-08 $l=9e-09 $layer=M1 $thickness=3.6e-08 $X=1.384
+ $Y=0.0815 $X2=1.384 $Y2=0.0905
r44 206 207 2.09871 $w=1.3e-08 $l=9e-09 $layer=M1 $thickness=3.6e-08 $X=1.384
+ $Y=0.0725 $X2=1.384 $Y2=0.0815
r45 54 206 3.26466 $w=1.3e-08 $l=1.4e-08 $layer=M1 $thickness=3.6e-08 $X=1.384
+ $Y=0.0585 $X2=1.384 $Y2=0.0725
r46 53 203 2.91487 $w=1.3e-08 $l=1.25e-08 $layer=M1 $thickness=3.6e-08
+ $X=1.3545 $Y=0.036 $X2=1.367 $Y2=0.036
r47 53 205 2.09871 $w=1.3e-08 $l=9e-09 $layer=M1 $thickness=3.6e-08 $X=1.3545
+ $Y=0.036 $X2=1.3455 $Y2=0.036
r48 201 200 16.4967 $w=2.1e-08 $l=4.85e-08 $layer=Gate_1 $thickness=5.6e-08
+ $X=2.403 $Y=0.216 $X2=2.403 $Y2=0.1675
r49 198 199 16.4967 $w=2.1e-08 $l=4.85e-08 $layer=Gate_1 $thickness=5.6e-08
+ $X=2.403 $Y=0.0675 $X2=2.403 $Y2=0.116
r50 33 199 6.6497 $w=2.04211e-08 $l=1.9e-08 $layer=Gate_1 $thickness=5.6e-08
+ $X=2.403 $Y=0.135 $X2=2.403 $Y2=0.116
r51 33 200 11.2416 $w=2.06615e-08 $l=3.25e-08 $layer=Gate_1 $thickness=5.6e-08
+ $X=2.403 $Y=0.135 $X2=2.403 $Y2=0.1675
r52 42 188 3.83327 $w=1.5093e-08 $l=2.15e-08 $layer=M1 $thickness=3.6e-08
+ $X=1.384 $Y=0.036 $X2=1.4055 $Y2=0.036
r53 42 203 2.78392 $w=1.56471e-08 $l=1.7e-08 $layer=M1 $thickness=3.6e-08
+ $X=1.384 $Y=0.036 $X2=1.367 $Y2=0.036
r54 42 54 4.06646 $w=1.5e-08 $l=2.25e-08 $layer=M1 $thickness=3.6e-08 $X=1.384
+ $Y=0.036 $X2=1.384 $Y2=0.0585
r55 195 194 16.4967 $w=2.1e-08 $l=4.85e-08 $layer=Gate_1 $thickness=5.6e-08
+ $X=1.863 $Y=0.216 $X2=1.863 $Y2=0.1675
r56 192 193 16.4967 $w=2.1e-08 $l=4.85e-08 $layer=Gate_1 $thickness=5.6e-08
+ $X=1.863 $Y=0.0675 $X2=1.863 $Y2=0.116
r57 31 193 6.6497 $w=2.04211e-08 $l=1.9e-08 $layer=Gate_1 $thickness=5.6e-08
+ $X=1.863 $Y=0.135 $X2=1.863 $Y2=0.116
r58 31 194 11.2416 $w=2.06615e-08 $l=3.25e-08 $layer=Gate_1 $thickness=5.6e-08
+ $X=1.863 $Y=0.135 $X2=1.863 $Y2=0.1675
r59 9 166 19.3796 $a=3.24e-16 $layer=V0LIG $X=2.403 $Y=0.135 $X2=2.403
+ $Y2=0.1295
r60 9 33 6.54019 $w=2.09524e-08 $layer=Gate_1 $thickness=5.21905e-08 $X=2.403
+ $Y=0.135 $X2=2.403 $Y2=0.135
r61 187 188 18.0722 $w=1.3e-08 $l=7.75e-08 $layer=M1 $thickness=3.6e-08
+ $X=1.483 $Y=0.036 $X2=1.4055 $Y2=0.036
r62 186 187 19.4713 $w=1.3e-08 $l=8.35e-08 $layer=M1 $thickness=3.6e-08
+ $X=1.5665 $Y=0.036 $X2=1.483 $Y2=0.036
r63 185 186 10.1438 $w=1.3e-08 $l=4.35e-08 $layer=M1 $thickness=3.6e-08 $X=1.61
+ $Y=0.036 $X2=1.5665 $Y2=0.036
r64 184 185 6.17953 $w=1.3e-08 $l=2.65e-08 $layer=M1 $thickness=3.6e-08
+ $X=1.6365 $Y=0.036 $X2=1.61 $Y2=0.036
r65 183 184 2.44849 $w=1.3e-08 $l=1.05e-08 $layer=M1 $thickness=3.6e-08
+ $X=1.647 $Y=0.036 $X2=1.6365 $Y2=0.036
r66 56 183 6.29612 $w=1.3e-08 $l=2.7e-08 $layer=M1 $thickness=3.6e-08 $X=1.674
+ $Y=0.036 $X2=1.647 $Y2=0.036
r67 7 157 19.3796 $a=3.24e-16 $layer=V0LIG $X=1.863 $Y=0.135 $X2=1.863 $Y2=0.133
r68 7 31 6.54019 $w=2.09524e-08 $layer=Gate_1 $thickness=5.21905e-08 $X=1.863
+ $Y=0.135 $X2=1.863 $Y2=0.135
r69 179 178 16.4967 $w=2.1e-08 $l=4.85e-08 $layer=Gate_1 $thickness=5.6e-08
+ $X=0.189 $Y=0.216 $X2=0.189 $Y2=0.1675
r70 176 177 16.4967 $w=2.1e-08 $l=4.85e-08 $layer=Gate_1 $thickness=5.6e-08
+ $X=0.189 $Y=0.0675 $X2=0.189 $Y2=0.116
r71 25 177 6.6497 $w=2.04211e-08 $l=1.9e-08 $layer=Gate_1 $thickness=5.6e-08
+ $X=0.189 $Y=0.135 $X2=0.189 $Y2=0.116
r72 25 178 11.2416 $w=2.06615e-08 $l=3.25e-08 $layer=Gate_1 $thickness=5.6e-08
+ $X=0.189 $Y=0.135 $X2=0.189 $Y2=0.1675
r73 173 172 16.4967 $w=2.1e-08 $l=4.85e-08 $layer=Gate_1 $thickness=5.6e-08
+ $X=2.241 $Y=0.216 $X2=2.241 $Y2=0.1675
r74 170 171 16.4967 $w=2.1e-08 $l=4.85e-08 $layer=Gate_1 $thickness=5.6e-08
+ $X=2.241 $Y=0.0675 $X2=2.241 $Y2=0.116
r75 32 171 6.6497 $w=2.04211e-08 $l=1.9e-08 $layer=Gate_1 $thickness=5.6e-08
+ $X=2.241 $Y=0.135 $X2=2.241 $Y2=0.116
r76 32 172 11.2416 $w=2.06615e-08 $l=3.25e-08 $layer=Gate_1 $thickness=5.6e-08
+ $X=2.241 $Y=0.135 $X2=2.241 $Y2=0.1675
r77 165 166 2.09871 $w=1.3e-08 $l=9e-09 $layer=M1 $thickness=3.6e-08 $X=2.403
+ $Y=0.1205 $X2=2.403 $Y2=0.1295
r78 49 151 6.04857 $w=1.44516e-08 $l=3.1e-08 $layer=M1 $thickness=3.6e-08
+ $X=2.403 $Y=0.108 $X2=2.372 $Y2=0.108
r79 49 165 1.73456 $w=1.66e-08 $l=1.25e-08 $layer=M1 $thickness=3.6e-08
+ $X=2.403 $Y=0.108 $X2=2.403 $Y2=0.1205
r80 163 162 16.4967 $w=2.1e-08 $l=4.85e-08 $layer=Gate_1 $thickness=5.6e-08
+ $X=1.701 $Y=0.216 $X2=1.701 $Y2=0.1675
r81 160 161 16.4967 $w=2.1e-08 $l=4.85e-08 $layer=Gate_1 $thickness=5.6e-08
+ $X=1.701 $Y=0.0675 $X2=1.701 $Y2=0.116
r82 30 161 6.6497 $w=2.04211e-08 $l=1.9e-08 $layer=Gate_1 $thickness=5.6e-08
+ $X=1.701 $Y=0.135 $X2=1.701 $Y2=0.116
r83 30 162 11.2416 $w=2.06615e-08 $l=3.25e-08 $layer=Gate_1 $thickness=5.6e-08
+ $X=1.701 $Y=0.135 $X2=1.701 $Y2=0.1675
r84 45 144 2.5483 $w=1.79e-08 $l=1.8e-08 $layer=M1 $thickness=3.6e-08 $X=1.701
+ $Y=0.036 $X2=1.701 $Y2=0.054
r85 45 56 4.64701 $w=1.46667e-08 $l=2.7e-08 $layer=M1 $thickness=3.6e-08
+ $X=1.701 $Y=0.036 $X2=1.674 $Y2=0.036
r86 156 157 2.91487 $w=1.3e-08 $l=1.25e-08 $layer=M1 $thickness=3.6e-08
+ $X=1.863 $Y=0.1205 $X2=1.863 $Y2=0.133
r87 47 139 8.26388 $w=1.41111e-08 $l=4.05e-08 $layer=M1 $thickness=3.6e-08
+ $X=1.863 $Y=0.108 $X2=1.8225 $Y2=0.108
r88 47 156 1.73456 $w=1.66e-08 $l=1.25e-08 $layer=M1 $thickness=3.6e-08
+ $X=1.863 $Y=0.108 $X2=1.863 $Y2=0.1205
r89 1 128 19.3796 $a=3.24e-16 $layer=V0LIG $X=0.189 $Y=0.135 $X2=0.189
+ $Y2=0.1295
r90 1 25 6.54019 $w=2.09524e-08 $layer=Gate_1 $thickness=5.21905e-08 $X=0.189
+ $Y=0.135 $X2=0.189 $Y2=0.135
r91 8 123 19.3796 $a=3.24e-16 $layer=V0LIG $X=2.241 $Y=0.135 $X2=2.241
+ $Y2=0.1305
r92 8 32 6.54019 $w=2.09524e-08 $layer=Gate_1 $thickness=5.21905e-08 $X=2.241
+ $Y=0.135 $X2=2.241 $Y2=0.135
r93 150 151 10.0272 $w=1.3e-08 $l=4.3e-08 $layer=M1 $thickness=3.6e-08 $X=2.329
+ $Y=0.108 $X2=2.372 $Y2=0.108
r94 149 150 6.7625 $w=1.3e-08 $l=2.9e-08 $layer=M1 $thickness=3.6e-08 $X=2.3
+ $Y=0.108 $X2=2.329 $Y2=0.108
r95 148 149 3.14806 $w=1.3e-08 $l=1.35e-08 $layer=M1 $thickness=3.6e-08
+ $X=2.2865 $Y=0.108 $X2=2.3 $Y2=0.108
r96 147 148 4.43061 $w=1.3e-08 $l=1.9e-08 $layer=M1 $thickness=3.6e-08
+ $X=2.2675 $Y=0.108 $X2=2.2865 $Y2=0.108
r97 60 147 3.61444 $w=1.3e-08 $l=1.55e-08 $layer=M1 $thickness=3.6e-08 $X=2.252
+ $Y=0.108 $X2=2.2675 $Y2=0.108
r98 6 119 19.3796 $a=3.24e-16 $layer=V0LIG $X=1.701 $Y=0.135 $X2=1.701
+ $Y2=0.1295
r99 6 30 6.54019 $w=2.09524e-08 $layer=Gate_1 $thickness=5.21905e-08 $X=1.701
+ $Y=0.135 $X2=1.701 $Y2=0.135
r100 143 144 3.26466 $w=1.3e-08 $l=1.4e-08 $layer=M1 $thickness=3.6e-08
+ $X=1.701 $Y=0.068 $X2=1.701 $Y2=0.054
r101 142 143 1.63233 $w=1.3e-08 $l=7e-09 $layer=M1 $thickness=3.6e-08 $X=1.701
+ $Y=0.075 $X2=1.701 $Y2=0.068
r102 141 142 0.932759 $w=1.3e-08 $l=4e-09 $layer=M1 $thickness=3.6e-08 $X=1.701
+ $Y=0.079 $X2=1.701 $Y2=0.075
r103 140 141 2.09871 $w=1.3e-08 $l=9e-09 $layer=M1 $thickness=3.6e-08 $X=1.701
+ $Y=0.088 $X2=1.701 $Y2=0.079
r104 58 117 0.925579 $w=1.64615e-08 $l=6.5e-09 $layer=M1 $thickness=3.6e-08
+ $X=1.701 $Y=0.097 $X2=1.701 $Y2=0.1035
r105 58 140 2.09871 $w=1.3e-08 $l=9e-09 $layer=M1 $thickness=3.6e-08 $X=1.701
+ $Y=0.097 $X2=1.701 $Y2=0.088
r106 138 139 9.44419 $w=1.3e-08 $l=4.05e-08 $layer=M1 $thickness=3.6e-08
+ $X=1.782 $Y=0.108 $X2=1.8225 $Y2=0.108
r107 137 138 2.68168 $w=1.3e-08 $l=1.15e-08 $layer=M1 $thickness=3.6e-08
+ $X=1.7705 $Y=0.108 $X2=1.782 $Y2=0.108
r108 59 117 7.2217 $w=1.36716e-08 $l=3.82655e-08 $layer=M1 $thickness=3.6e-08
+ $X=1.739 $Y=0.108 $X2=1.701 $Y2=0.1035
r109 59 137 7.34548 $w=1.3e-08 $l=3.15e-08 $layer=M1 $thickness=3.6e-08
+ $X=1.739 $Y=0.108 $X2=1.7705 $Y2=0.108
r110 135 134 16.4967 $w=2.1e-08 $l=4.85e-08 $layer=Gate_1 $thickness=5.6e-08
+ $X=0.351 $Y=0.216 $X2=0.351 $Y2=0.1675
r111 132 133 16.4967 $w=2.1e-08 $l=4.85e-08 $layer=Gate_1 $thickness=5.6e-08
+ $X=0.351 $Y=0.0675 $X2=0.351 $Y2=0.116
r112 26 133 6.6497 $w=2.04211e-08 $l=1.9e-08 $layer=Gate_1 $thickness=5.6e-08
+ $X=0.351 $Y=0.135 $X2=0.351 $Y2=0.116
r113 26 134 11.2416 $w=2.06615e-08 $l=3.25e-08 $layer=Gate_1 $thickness=5.6e-08
+ $X=0.351 $Y=0.135 $X2=0.351 $Y2=0.1675
r114 127 128 2.09871 $w=1.3e-08 $l=9e-09 $layer=M1 $thickness=3.6e-08 $X=0.189
+ $Y=0.1205 $X2=0.189 $Y2=0.1295
r115 38 114 6.74814 $w=1.43235e-08 $l=3.4e-08 $layer=M1 $thickness=3.6e-08
+ $X=0.189 $Y=0.108 $X2=0.223 $Y2=0.108
r116 38 127 1.73456 $w=1.66e-08 $l=1.25e-08 $layer=M1 $thickness=3.6e-08
+ $X=0.189 $Y=0.108 $X2=0.189 $Y2=0.1205
r117 122 123 2.09871 $w=1.3e-08 $l=9e-09 $layer=M1 $thickness=3.6e-08 $X=2.241
+ $Y=0.1215 $X2=2.241 $Y2=0.1305
r118 48 108 19.5347 $a=3.24e-16 $layer=V1 $X=2.241 $Y=0.1125 $X2=2.241 $Y2=0.117
r119 48 122 1.50855 $w=1.55e-08 $l=9e-09 $layer=M1 $thickness=3.6e-08 $X=2.241
+ $Y=0.1125 $X2=2.241 $Y2=0.1215
r120 48 60 0.925579 $w=1.64615e-08 $l=1.18849e-08 $layer=M1 $thickness=3.6e-08
+ $X=2.241 $Y=0.1125 $X2=2.252 $Y2=0.108
r121 117 118 0.867378 $w=1.8e-08 $l=8.5e-09 $layer=M1 $thickness=3.6e-08
+ $X=1.701 $Y=0.1035 $X2=1.701 $Y2=0.112
r122 46 118 0.4592 $w=1.8e-08 $l=4.5e-09 $layer=M1 $thickness=3.6e-08 $X=1.701
+ $Y=0.1165 $X2=1.701 $Y2=0.112
r123 46 119 2.96589 $w=1.31923e-08 $l=1.3e-08 $layer=M1 $thickness=3.6e-08
+ $X=1.701 $Y=0.1165 $X2=1.701 $Y2=0.1295
r124 46 59 6.81353 $w=1.30847e-08 $l=3.89391e-08 $layer=M1 $thickness=3.6e-08
+ $X=1.701 $Y=0.1165 $X2=1.739 $Y2=0.108
r125 2 102 19.3796 $a=3.24e-16 $layer=V0LIG $X=0.351 $Y=0.135 $X2=0.351
+ $Y2=0.1305
r126 2 26 6.54019 $w=2.09524e-08 $layer=Gate_1 $thickness=5.21905e-08 $X=0.351
+ $Y=0.135 $X2=0.351 $Y2=0.135
r127 113 114 10.0272 $w=1.3e-08 $l=4.3e-08 $layer=M1 $thickness=3.6e-08
+ $X=0.266 $Y=0.108 $X2=0.223 $Y2=0.108
r128 112 113 6.7625 $w=1.3e-08 $l=2.9e-08 $layer=M1 $thickness=3.6e-08 $X=0.295
+ $Y=0.108 $X2=0.266 $Y2=0.108
r129 111 112 3.84763 $w=1.3e-08 $l=1.65e-08 $layer=M1 $thickness=3.6e-08
+ $X=0.3115 $Y=0.108 $X2=0.295 $Y2=0.108
r130 110 111 3.73104 $w=1.3e-08 $l=1.6e-08 $layer=M1 $thickness=3.6e-08
+ $X=0.3275 $Y=0.108 $X2=0.3115 $Y2=0.108
r131 50 110 2.91487 $w=1.3e-08 $l=1.25e-08 $layer=M1 $thickness=3.6e-08 $X=0.34
+ $Y=0.108 $X2=0.3275 $Y2=0.108
r132 107 108 62.9612 $w=1.3e-08 $l=2.7e-07 $layer=M2 $thickness=3.6e-08
+ $X=1.971 $Y=0.117 $X2=2.241 $Y2=0.117
r133 106 107 62.9612 $w=1.3e-08 $l=2.7e-07 $layer=M2 $thickness=3.6e-08
+ $X=1.701 $Y=0.117 $X2=1.971 $Y2=0.117
r134 106 119 19.5347 $a=3.24e-16 $layer=V1 $X=1.701 $Y=0.117 $X2=1.701
+ $Y2=0.1295
r135 62 106 10.9599 $w=1.3e-08 $l=4.7e-08 $layer=M2 $thickness=3.6e-08 $X=1.654
+ $Y=0.117 $X2=1.701 $Y2=0.117
r136 62 99 53.0507 $w=1.3e-08 $l=2.275e-07 $layer=M2 $thickness=3.6e-08
+ $X=1.654 $Y=0.117 $X2=1.4265 $Y2=0.117
r137 101 102 2.09871 $w=1.3e-08 $l=9e-09 $layer=M1 $thickness=3.6e-08 $X=0.351
+ $Y=0.1215 $X2=0.351 $Y2=0.1305
r138 39 88 19.5347 $a=3.24e-16 $layer=V1 $X=0.351 $Y=0.1125 $X2=0.351 $Y2=0.117
r139 39 101 1.50855 $w=1.55e-08 $l=9e-09 $layer=M1 $thickness=3.6e-08 $X=0.351
+ $Y=0.1125 $X2=0.351 $Y2=0.1215
r140 39 50 0.925579 $w=1.64615e-08 $l=1.18849e-08 $layer=M1 $thickness=3.6e-08
+ $X=0.351 $Y=0.1125 $X2=0.34 $Y2=0.108
r141 98 99 73.9212 $w=1.3e-08 $l=3.17e-07 $layer=M2 $thickness=3.6e-08
+ $X=1.1095 $Y=0.117 $X2=1.4265 $Y2=0.117
r142 63 91 9.56078 $w=1.3e-08 $l=4.1e-08 $layer=M2 $thickness=3.6e-08 $X=0.979
+ $Y=0.117 $X2=0.938 $Y2=0.117
r143 63 98 30.4313 $w=1.3e-08 $l=1.305e-07 $layer=M2 $thickness=3.6e-08
+ $X=0.979 $Y=0.117 $X2=1.1095 $Y2=0.117
r144 96 95 16.4967 $w=2.1e-08 $l=4.85e-08 $layer=Gate_1 $thickness=5.6e-08
+ $X=0.891 $Y=0.216 $X2=0.891 $Y2=0.1675
r145 93 94 16.4967 $w=2.1e-08 $l=4.85e-08 $layer=Gate_1 $thickness=5.6e-08
+ $X=0.891 $Y=0.0675 $X2=0.891 $Y2=0.116
r146 28 94 6.6497 $w=2.04211e-08 $l=1.9e-08 $layer=Gate_1 $thickness=5.6e-08
+ $X=0.891 $Y=0.135 $X2=0.891 $Y2=0.116
r147 28 95 11.2416 $w=2.06615e-08 $l=3.25e-08 $layer=Gate_1 $thickness=5.6e-08
+ $X=0.891 $Y=0.135 $X2=0.891 $Y2=0.1675
r148 90 91 10.9599 $w=1.3e-08 $l=4.7e-08 $layer=M2 $thickness=3.6e-08 $X=0.891
+ $Y=0.117 $X2=0.938 $Y2=0.117
r149 89 90 62.9612 $w=1.3e-08 $l=2.7e-07 $layer=M2 $thickness=3.6e-08 $X=0.621
+ $Y=0.117 $X2=0.891 $Y2=0.117
r150 88 89 62.9612 $w=1.3e-08 $l=2.7e-07 $layer=M2 $thickness=3.6e-08 $X=0.351
+ $Y=0.117 $X2=0.621 $Y2=0.117
r151 61 88 2.79828 $w=1.3e-08 $l=1.2e-08 $layer=M2 $thickness=3.6e-08 $X=0.339
+ $Y=0.117 $X2=0.351 $Y2=0.117
r152 4 84 19.3796 $a=3.24e-16 $layer=V0LIG $X=0.891 $Y=0.135 $X2=0.891
+ $Y2=0.1295
r153 4 28 6.54019 $w=2.09524e-08 $layer=Gate_1 $thickness=5.21905e-08 $X=0.891
+ $Y=0.135 $X2=0.891 $Y2=0.135
r154 84 90 19.5347 $a=3.24e-16 $layer=V1 $X=0.891 $Y=0.1295 $X2=0.891 $Y2=0.117
r155 83 84 2.96589 $w=1.31923e-08 $l=1.3e-08 $layer=M1 $thickness=3.6e-08
+ $X=0.891 $Y=0.1165 $X2=0.891 $Y2=0.1295
r156 82 83 0.4592 $w=1.8e-08 $l=4.5e-09 $layer=M1 $thickness=3.6e-08 $X=0.891
+ $Y=0.112 $X2=0.891 $Y2=0.1165
r157 41 82 0.867378 $w=1.8e-08 $l=8.5e-09 $layer=M1 $thickness=3.6e-08 $X=0.891
+ $Y=0.1035 $X2=0.891 $Y2=0.112
r158 81 83 6.81353 $w=1.30847e-08 $l=3.89391e-08 $layer=M1 $thickness=3.6e-08
+ $X=0.853 $Y=0.108 $X2=0.891 $Y2=0.1165
r159 80 81 7.34548 $w=1.3e-08 $l=3.15e-08 $layer=M1 $thickness=3.6e-08
+ $X=0.8215 $Y=0.108 $X2=0.853 $Y2=0.108
r160 79 80 2.68168 $w=1.3e-08 $l=1.15e-08 $layer=M1 $thickness=3.6e-08 $X=0.81
+ $Y=0.108 $X2=0.8215 $Y2=0.108
r161 51 77 8.26388 $w=1.41111e-08 $l=4.05e-08 $layer=M1 $thickness=3.6e-08
+ $X=0.7695 $Y=0.108 $X2=0.729 $Y2=0.108
r162 51 79 9.44419 $w=1.3e-08 $l=4.05e-08 $layer=M1 $thickness=3.6e-08
+ $X=0.7695 $Y=0.108 $X2=0.81 $Y2=0.108
r163 40 76 2.91487 $w=1.3e-08 $l=1.25e-08 $layer=M1 $thickness=3.6e-08 $X=0.729
+ $Y=0.1205 $X2=0.729 $Y2=0.133
r164 40 77 1.73456 $w=1.66e-08 $l=1.25e-08 $layer=M1 $thickness=3.6e-08
+ $X=0.729 $Y=0.1205 $X2=0.729 $Y2=0.108
r165 3 70 6.54019 $w=2.09524e-08 $layer=Gate_1 $thickness=5.21905e-08 $X=0.729
+ $Y=0.135 $X2=0.729 $Y2=0.135
r166 3 76 19.3796 $a=3.24e-16 $layer=V0LIG $X=0.729 $Y=0.135 $X2=0.729 $Y2=0.133
r167 72 71 16.4967 $w=2.1e-08 $l=4.85e-08 $layer=Gate_1 $thickness=5.6e-08
+ $X=0.729 $Y=0.216 $X2=0.729 $Y2=0.1675
r168 70 71 11.2416 $w=2.06615e-08 $l=3.25e-08 $layer=Gate_1 $thickness=5.6e-08
+ $X=0.729 $Y=0.135 $X2=0.729 $Y2=0.1675
r169 69 70 6.6497 $w=2.04211e-08 $l=1.9e-08 $layer=Gate_1 $thickness=5.6e-08
+ $X=0.729 $Y=0.116 $X2=0.729 $Y2=0.135
r170 68 69 16.4967 $w=2.1e-08 $l=4.85e-08 $layer=Gate_1 $thickness=5.6e-08
+ $X=0.729 $Y=0.0675 $X2=0.729 $Y2=0.116
r171 68 27 14.6259 $w=2.1e-08 $l=4.3e-08 $layer=Gate_1 $thickness=5.6e-08
+ $X=0.729 $Y=0.0675 $X2=0.729 $Y2=0.0245
.ends

.subckt PM_ICGx4DC_ASAP7_75t_R%CLK vss 101 62 66 76 79 125 128 149 152 155 158
+ 163 180 184 192 195 198 201 206 217 220 223 226 30 31 40 41 42 18 19 1 53 24
+ 33 36 34 23 32 37 52 39 46 4 2 7 8 47 38 16 35 50 45 54 20 27 29 28 5 51 3 6
+ 44 48 22 43 49 26 25 21 55
c1 1 vss 0.0055002f $X=0.2405 $Y=0.162
c2 2 vss 0.00547868f $X=0.783 $Y=0.162
c3 3 vss 0.00490916f $X=0.945 $Y=0.135
c4 4 vss 0.000615087f $X=1.269 $Y=0.1335
c5 5 vss 0.000196199f $X=1.378 $Y=0.1335
c6 6 vss 0.00562645f $X=1.647 $Y=0.135
c7 7 vss 0.00547868f $X=1.782 $Y=0.162
c8 8 vss 0.00548689f $X=2.3185 $Y=0.162
c9 16 vss 0.0020422f $X=1.419 $Y=0.1335
c10 18 vss 0.0342199f $X=0.243 $Y=0.162
c11 19 vss 0.0358477f $X=0.297 $Y=0.162
c12 20 vss 0.0342979f $X=0.783 $Y=0.0245
c13 21 vss 0.034731f $X=0.837 $Y=0.162
c14 22 vss 0.0984854f $X=0.945 $Y=0.135
c15 23 vss 0.00786122f $X=1.269 $Y=0.1335
c16 24 vss 0.00614928f $X=1.377 $Y=0.1335
c17 25 vss 0.0971027f $X=1.647 $Y=0.135
c18 26 vss 0.0345428f $X=1.755 $Y=0.162
c19 27 vss 0.0342979f $X=1.809 $Y=0.162
c20 28 vss 0.0358207f $X=2.295 $Y=0.162
c21 29 vss 0.0342346f $X=2.349 $Y=0.162
c22 30 vss 0.000412303f $X=0.257 $Y=0.15
c23 31 vss 0.000506065f $X=0.257 $Y=0.1795
c24 32 vss 0.000531928f $X=0.81 $Y=0.183
c25 33 vss 0.000751174f $X=0.945 $Y=0.187
c26 34 vss 0.000600156f $X=1.431 $Y=0.153
c27 35 vss 0.000935474f $X=1.449 $Y=0.153
c28 36 vss 0.000639042f $X=1.647 $Y=0.187
c29 37 vss 0.000531928f $X=1.782 $Y=0.183
c30 38 vss 0.000432479f $X=2.341 $Y=0.15
c31 39 vss 0.000496198f $X=2.341 $Y=0.1795
c32 40 vss 7.83617e-20 $X=0.257 $Y=0.1575
c33 41 vss 0.000613521f $X=0.286 $Y=0.144
c34 42 vss 0.0019818f $X=0.286 $Y=0.18
c35 43 vss 0.000488089f $X=0.81 $Y=0.1445
c36 44 vss 0.00321797f $X=0.8485 $Y=0.187
c37 45 vss 0.00158142f $X=0.945 $Y=0.1545
c38 46 vss 0.0017429f $X=1.269 $Y=0.1215
c39 47 vss 0.00113355f $X=1.647 $Y=0.12
c40 48 vss 0.00324739f $X=1.674 $Y=0.187
c41 49 vss 0.000488089f $X=1.782 $Y=0.15
c42 50 vss 0.00186073f $X=2.312 $Y=0.18
c43 51 vss 0.000490343f $X=2.312 $Y=0.144
c44 52 vss 7.52902e-20 $X=2.341 $Y=0.1575
c45 53 vss 0.0452641f $X=0.636 $Y=0.153
c46 54 vss 0.0431305f $X=1.653 $Y=0.153
c47 55 vss 0.0198512f $X=0.9482 $Y=0.153
r1 226 225 11.9048 $w=2.1e-08 $l=3.5e-08 $layer=Gate_1 $thickness=5.6e-08
+ $X=1.809 $Y=0.216 $X2=1.809 $Y2=0.181
r2 223 224 21.0886 $w=2.1e-08 $l=6.2e-08 $layer=Gate_1 $thickness=5.6e-08
+ $X=1.809 $Y=0.0675 $X2=1.809 $Y2=0.1295
r3 27 214 6.54019 $w=2.09524e-08 $layer=Gate_1 $thickness=5.21905e-08 $X=1.809
+ $Y=0.162 $X2=1.809 $Y2=0.162
r4 27 224 11.2416 $w=2.06615e-08 $l=3.25e-08 $layer=Gate_1 $thickness=5.6e-08
+ $X=1.809 $Y=0.162 $X2=1.809 $Y2=0.1295
r5 27 225 6.6497 $w=2.04211e-08 $l=1.9e-08 $layer=Gate_1 $thickness=5.6e-08
+ $X=1.809 $Y=0.162 $X2=1.809 $Y2=0.181
r6 220 219 11.9048 $w=2.1e-08 $l=3.5e-08 $layer=Gate_1 $thickness=5.6e-08
+ $X=1.755 $Y=0.216 $X2=1.755 $Y2=0.181
r7 217 218 21.0886 $w=2.1e-08 $l=6.2e-08 $layer=Gate_1 $thickness=5.6e-08
+ $X=1.755 $Y=0.0675 $X2=1.755 $Y2=0.1295
r8 26 212 6.54019 $w=2.09524e-08 $layer=Gate_1 $thickness=5.21905e-08 $X=1.755
+ $Y=0.162 $X2=1.755 $Y2=0.162
r9 26 218 11.2416 $w=2.06615e-08 $l=3.25e-08 $layer=Gate_1 $thickness=5.6e-08
+ $X=1.755 $Y=0.162 $X2=1.755 $Y2=0.1295
r10 26 219 6.6497 $w=2.04211e-08 $l=1.9e-08 $layer=Gate_1 $thickness=5.6e-08
+ $X=1.755 $Y=0.162 $X2=1.755 $Y2=0.181
r11 7 209 19.3796 $a=3.24e-16 $layer=V0LIG $X=1.782 $Y=0.162 $X2=1.782 $Y2=0.162
r12 7 212 12.6539 $w=1.77815e-08 $l=2.7e-08 $layer=LIG $thickness=4.8e-08
+ $X=1.782 $Y=0.162 $X2=1.755 $Y2=0.162
r13 7 214 12.6539 $w=1.77815e-08 $l=2.7e-08 $layer=LIG $thickness=4.8e-08
+ $X=1.782 $Y=0.162 $X2=1.809 $Y2=0.162
r14 209 210 2.91487 $w=1.3e-08 $l=1.25e-08 $layer=M1 $thickness=3.6e-08
+ $X=1.782 $Y=0.162 $X2=1.782 $Y2=0.1745
r15 49 209 2.79828 $w=1.3e-08 $l=1.2e-08 $layer=M1 $thickness=3.6e-08 $X=1.782
+ $Y=0.15 $X2=1.782 $Y2=0.162
r16 206 207 16.3266 $w=2.1e-08 $l=4.8e-08 $layer=Gate_1 $thickness=5.6e-08
+ $X=1.377 $Y=0.0405 $X2=1.377 $Y2=0.0885
r17 24 189 3.75002 $w=2e-08 $layer=Gate_1 $thickness=5.6e-08 $X=1.377 $Y=0.1335
+ $X2=1.377 $Y2=0.1335
r18 24 207 15.4848 $w=2.07667e-08 $l=4.5e-08 $layer=Gate_1 $thickness=5.6e-08
+ $X=1.377 $Y=0.1335 $X2=1.377 $Y2=0.0885
r19 37 188 7.38932 $w=1.37246e-08 $l=3.87072e-08 $layer=M1 $thickness=3.6e-08
+ $X=1.782 $Y=0.183 $X2=1.7435 $Y2=0.187
r20 37 210 1.32639 $w=1.59412e-08 $l=8.5e-09 $layer=M1 $thickness=3.6e-08
+ $X=1.782 $Y=0.183 $X2=1.782 $Y2=0.1745
r21 201 200 11.9048 $w=2.1e-08 $l=3.5e-08 $layer=Gate_1 $thickness=5.6e-08
+ $X=2.349 $Y=0.216 $X2=2.349 $Y2=0.181
r22 198 199 21.0886 $w=2.1e-08 $l=6.2e-08 $layer=Gate_1 $thickness=5.6e-08
+ $X=2.349 $Y=0.0675 $X2=2.349 $Y2=0.1295
r23 29 175 3.9286 $w=2e-08 $layer=Gate_1 $thickness=5.6e-08 $X=2.349 $Y=0.162
+ $X2=2.349 $Y2=0.162
r24 29 199 11.2416 $w=2.06615e-08 $l=3.25e-08 $layer=Gate_1 $thickness=5.6e-08
+ $X=2.349 $Y=0.162 $X2=2.349 $Y2=0.1295
r25 29 200 6.6497 $w=2.04211e-08 $l=1.9e-08 $layer=Gate_1 $thickness=5.6e-08
+ $X=2.349 $Y=0.162 $X2=2.349 $Y2=0.181
r26 195 194 11.9048 $w=2.1e-08 $l=3.5e-08 $layer=Gate_1 $thickness=5.6e-08
+ $X=2.295 $Y=0.216 $X2=2.295 $Y2=0.181
r27 192 193 21.0886 $w=2.1e-08 $l=6.2e-08 $layer=Gate_1 $thickness=5.6e-08
+ $X=2.295 $Y=0.0675 $X2=2.295 $Y2=0.1295
r28 28 171 6.54019 $w=2.09524e-08 $layer=Gate_1 $thickness=5.21905e-08 $X=2.295
+ $Y=0.162 $X2=2.295 $Y2=0.162
r29 28 193 11.2416 $w=2.06615e-08 $l=3.25e-08 $layer=Gate_1 $thickness=5.6e-08
+ $X=2.295 $Y=0.162 $X2=2.295 $Y2=0.1295
r30 28 194 6.6497 $w=2.04211e-08 $l=1.9e-08 $layer=Gate_1 $thickness=5.6e-08
+ $X=2.295 $Y=0.162 $X2=2.295 $Y2=0.181
r31 5 169 3.16825 $w=2.1e-08 $l=3.5e-09 $layer=LIG $thickness=4.8e-08 $X=1.378
+ $Y=0.1335 $X2=1.3815 $Y2=0.1335
r32 5 189 3.16825 $w=2.1e-08 $l=1e-09 $layer=LIG $thickness=4.8e-08 $X=1.378
+ $Y=0.1335 $X2=1.377 $Y2=0.1335
r33 187 188 7.34548 $w=1.3e-08 $l=3.15e-08 $layer=M1 $thickness=3.6e-08
+ $X=1.712 $Y=0.187 $X2=1.7435 $Y2=0.187
r34 186 187 2.56509 $w=1.3e-08 $l=1.1e-08 $layer=M1 $thickness=3.6e-08 $X=1.701
+ $Y=0.187 $X2=1.712 $Y2=0.187
r35 48 186 6.29612 $w=1.3e-08 $l=2.7e-08 $layer=M1 $thickness=3.6e-08 $X=1.674
+ $Y=0.187 $X2=1.701 $Y2=0.187
r36 184 183 14.6259 $w=2.1e-08 $l=4.3e-08 $layer=Gate_1 $thickness=5.6e-08
+ $X=1.647 $Y=0.2025 $X2=1.647 $Y2=0.1595
r37 182 183 2.7211 $w=2.1e-08 $l=8e-09 $layer=Gate_1 $thickness=5.6e-08
+ $X=1.647 $Y=0.1515 $X2=1.647 $Y2=0.1595
r38 180 181 14.6259 $w=2.1e-08 $l=4.3e-08 $layer=Gate_1 $thickness=5.6e-08
+ $X=1.647 $Y=0.0675 $X2=1.647 $Y2=0.1105
r39 178 181 2.7211 $w=2.1e-08 $l=8e-09 $layer=Gate_1 $thickness=5.6e-08
+ $X=1.647 $Y=0.1185 $X2=1.647 $Y2=0.1105
r40 25 178 5.79936 $w=2.03333e-08 $l=1.65e-08 $layer=Gate_1 $thickness=5.6e-08
+ $X=1.647 $Y=0.135 $X2=1.647 $Y2=0.1185
r41 25 182 5.79936 $w=2.03333e-08 $l=1.65e-08 $layer=Gate_1 $thickness=5.6e-08
+ $X=1.647 $Y=0.135 $X2=1.647 $Y2=0.1515
r42 39 145 1.91673 $w=1.62692e-08 $l=1.3e-08 $layer=M1 $thickness=3.6e-08
+ $X=2.341 $Y=0.1795 $X2=2.341 $Y2=0.1665
r43 39 50 5.53117 $w=1.44912e-08 $l=2.90043e-08 $layer=M1 $thickness=3.6e-08
+ $X=2.341 $Y=0.1795 $X2=2.312 $Y2=0.18
r44 173 175 1.43638 $w=2.2e-08 $l=4.5e-09 $layer=LIG $thickness=4.8e-08
+ $X=2.3445 $Y=0.162 $X2=2.349 $Y2=0.162
r45 170 173 3.50391 $w=1.93944e-08 $l=9e-09 $layer=LIG $thickness=4.8e-08
+ $X=2.3355 $Y=0.162 $X2=2.3445 $Y2=0.162
r46 8 170 10.0423 $w=1.53e-08 $l=1.7e-08 $layer=LIG $thickness=4.8e-08
+ $X=2.3185 $Y=0.162 $X2=2.3355 $Y2=0.162
r47 8 171 10.5864 $w=1.81511e-08 $l=2.35e-08 $layer=LIG $thickness=4.8e-08
+ $X=2.3185 $Y=0.162 $X2=2.295 $Y2=0.162
r48 51 143 5.12299 $w=1.39184e-08 $l=2.93471e-08 $layer=M1 $thickness=3.6e-08
+ $X=2.312 $Y=0.144 $X2=2.341 $Y2=0.1395
r49 168 169 4.91375 $w=2.12e-08 $l=1.5e-09 $layer=LISD $thickness=2.7e-08
+ $X=1.383 $Y=0.1335 $X2=1.3815 $Y2=0.1335
r50 167 168 11.4654 $w=2.12e-08 $l=2.1e-08 $layer=LISD $thickness=2.7e-08
+ $X=1.404 $Y=0.1335 $X2=1.383 $Y2=0.1335
r51 16 165 6.55166 $w=2.12e-08 $l=1.2e-08 $layer=LISD $thickness=2.7e-08
+ $X=1.419 $Y=0.1335 $X2=1.431 $Y2=0.1335
r52 16 167 8.18958 $w=2.12e-08 $l=1.5e-08 $layer=LISD $thickness=2.7e-08
+ $X=1.419 $Y=0.1335 $X2=1.404 $Y2=0.1335
r53 163 162 16.8368 $w=2.1e-08 $l=4.95e-08 $layer=Gate_1 $thickness=5.6e-08
+ $X=1.269 $Y=0.2025 $X2=1.269 $Y2=0.153
r54 23 162 6.81127 $w=2.04615e-08 $l=1.95e-08 $layer=Gate_1 $thickness=5.6e-08
+ $X=1.269 $Y=0.1335 $X2=1.269 $Y2=0.153
r55 158 157 11.9048 $w=2.1e-08 $l=3.5e-08 $layer=Gate_1 $thickness=5.6e-08
+ $X=0.297 $Y=0.216 $X2=0.297 $Y2=0.181
r56 155 156 21.0886 $w=2.1e-08 $l=6.2e-08 $layer=Gate_1 $thickness=5.6e-08
+ $X=0.297 $Y=0.0675 $X2=0.297 $Y2=0.1295
r57 19 135 6.54019 $w=2.09524e-08 $layer=Gate_1 $thickness=5.21905e-08 $X=0.297
+ $Y=0.162 $X2=0.297 $Y2=0.162
r58 19 156 11.2416 $w=2.06615e-08 $l=3.25e-08 $layer=Gate_1 $thickness=5.6e-08
+ $X=0.297 $Y=0.162 $X2=0.297 $Y2=0.1295
r59 19 157 6.6497 $w=2.04211e-08 $l=1.9e-08 $layer=Gate_1 $thickness=5.6e-08
+ $X=0.297 $Y=0.162 $X2=0.297 $Y2=0.181
r60 152 151 11.9048 $w=2.1e-08 $l=3.5e-08 $layer=Gate_1 $thickness=5.6e-08
+ $X=0.243 $Y=0.216 $X2=0.243 $Y2=0.181
r61 149 150 21.0886 $w=2.1e-08 $l=6.2e-08 $layer=Gate_1 $thickness=5.6e-08
+ $X=0.243 $Y=0.0675 $X2=0.243 $Y2=0.1295
r62 18 131 3.9286 $w=2e-08 $layer=Gate_1 $thickness=5.6e-08 $X=0.243 $Y=0.162
+ $X2=0.243 $Y2=0.162
r63 18 150 11.2416 $w=2.06615e-08 $l=3.25e-08 $layer=Gate_1 $thickness=5.6e-08
+ $X=0.243 $Y=0.162 $X2=0.243 $Y2=0.1295
r64 18 151 6.6497 $w=2.04211e-08 $l=1.9e-08 $layer=Gate_1 $thickness=5.6e-08
+ $X=0.243 $Y=0.162 $X2=0.243 $Y2=0.181
r65 36 123 2.31511 $w=1.81882e-08 $l=1.7e-08 $layer=M1 $thickness=3.6e-08
+ $X=1.647 $Y=0.187 $X2=1.647 $Y2=0.17
r66 36 48 4.64701 $w=1.46667e-08 $l=2.7e-08 $layer=M1 $thickness=3.6e-08
+ $X=1.647 $Y=0.187 $X2=1.674 $Y2=0.187
r67 6 119 19.3796 $a=3.24e-16 $layer=V0LIG $X=1.647 $Y=0.135 $X2=1.647 $Y2=0.133
r68 6 25 6.54019 $w=2.09524e-08 $layer=Gate_1 $thickness=5.21905e-08 $X=1.647
+ $Y=0.135 $X2=1.647 $Y2=0.135
r69 52 117 39.0693 $a=1.62e-16 $layer=V1 $X=2.341 $Y=0.1575 $X2=2.341 $Y2=0.153
r70 52 145 2.09871 $w=1.3e-08 $l=9e-09 $layer=M1 $thickness=3.6e-08 $X=2.341
+ $Y=0.1575 $X2=2.341 $Y2=0.1665
r71 52 173 19.3796 $a=3.24e-16 $layer=V0LIG $X=2.341 $Y=0.1575 $X2=2.3445
+ $Y2=0.162
r72 143 144 0.612267 $w=1.8e-08 $l=6e-09 $layer=M1 $thickness=3.6e-08 $X=2.341
+ $Y=0.1395 $X2=2.341 $Y2=0.1455
r73 38 117 39.0693 $a=1.62e-16 $layer=V1 $X=2.341 $Y=0.15 $X2=2.341 $Y2=0.153
r74 38 144 0.4592 $w=1.8e-08 $l=4.5e-09 $layer=M1 $thickness=3.6e-08 $X=2.341
+ $Y=0.15 $X2=2.341 $Y2=0.1455
r75 38 52 1.35549 $w=1.5e-08 $l=7.5e-09 $layer=M1 $thickness=3.6e-08 $X=2.341
+ $Y=0.15 $X2=2.341 $Y2=0.1575
r76 38 51 4.96993 $w=1.36522e-08 $l=2.96142e-08 $layer=M1 $thickness=3.6e-08
+ $X=2.341 $Y=0.15 $X2=2.312 $Y2=0.144
r77 141 142 2.2153 $w=1.3e-08 $l=9.5e-09 $layer=M1 $thickness=3.6e-08 $X=1.431
+ $Y=0.134 $X2=1.431 $Y2=0.1435
r78 141 165 19.3796 $a=3.24e-16 $layer=V0LISD $X=1.431 $Y=0.134 $X2=1.431
+ $Y2=0.1335
r79 34 35 3.01711 $w=1.55e-08 $l=1.8e-08 $layer=M1 $thickness=3.6e-08 $X=1.431
+ $Y=0.153 $X2=1.449 $Y2=0.153
r80 34 142 1.03499 $w=1.77368e-08 $l=9.5e-09 $layer=M1 $thickness=3.6e-08
+ $X=1.431 $Y=0.153 $X2=1.431 $Y2=0.1435
r81 4 109 19.3796 $a=3.24e-16 $layer=V0LIG $X=1.269 $Y=0.1335 $X2=1.269
+ $Y2=0.133
r82 4 23 6.63025 $w=2.04878e-08 $layer=Gate_1 $thickness=5.20976e-08 $X=1.269
+ $Y=0.1335 $X2=1.269 $Y2=0.1335
r83 31 108 1.91673 $w=1.62692e-08 $l=1.3e-08 $layer=M1 $thickness=3.6e-08
+ $X=0.257 $Y=0.1795 $X2=0.257 $Y2=0.1665
r84 31 42 5.53117 $w=1.44912e-08 $l=2.90043e-08 $layer=M1 $thickness=3.6e-08
+ $X=0.257 $Y=0.1795 $X2=0.286 $Y2=0.18
r85 134 135 8.81419 $w=1.85683e-08 $l=2.05e-08 $layer=LIG $thickness=4.8e-08
+ $X=0.2765 $Y=0.162 $X2=0.297 $Y2=0.162
r86 133 134 10.0423 $w=1.53e-08 $l=1.7e-08 $layer=LIG $thickness=4.8e-08
+ $X=0.2595 $Y=0.162 $X2=0.2765 $Y2=0.162
r87 130 133 4.4926 $w=1.71611e-08 $l=9e-09 $layer=LIG $thickness=4.8e-08
+ $X=0.2505 $Y=0.162 $X2=0.2595 $Y2=0.162
r88 1 130 2.6116 $w=2.2e-08 $l=1e-08 $layer=LIG $thickness=4.8e-08 $X=0.2405
+ $Y=0.162 $X2=0.2505 $Y2=0.162
r89 1 131 1.9587 $w=2.2e-08 $l=2.5e-09 $layer=LIG $thickness=4.8e-08 $X=0.2405
+ $Y=0.162 $X2=0.243 $Y2=0.162
r90 41 106 5.12299 $w=1.39184e-08 $l=2.93471e-08 $layer=M1 $thickness=3.6e-08
+ $X=0.286 $Y=0.144 $X2=0.257 $Y2=0.1395
r91 128 127 16.4967 $w=2.1e-08 $l=4.85e-08 $layer=Gate_1 $thickness=5.6e-08
+ $X=0.945 $Y=0.2025 $X2=0.945 $Y2=0.154
r92 125 126 16.4967 $w=2.1e-08 $l=4.85e-08 $layer=Gate_1 $thickness=5.6e-08
+ $X=0.945 $Y=0.0675 $X2=0.945 $Y2=0.116
r93 22 126 6.6497 $w=2.04211e-08 $l=1.9e-08 $layer=Gate_1 $thickness=5.6e-08
+ $X=0.945 $Y=0.135 $X2=0.945 $Y2=0.116
r94 22 127 6.6497 $w=2.04211e-08 $l=1.9e-08 $layer=Gate_1 $thickness=5.6e-08
+ $X=0.945 $Y=0.135 $X2=0.945 $Y2=0.154
r95 122 123 3.61444 $w=1.3e-08 $l=1.55e-08 $layer=M1 $thickness=3.6e-08
+ $X=1.647 $Y=0.1545 $X2=1.647 $Y2=0.17
r96 121 122 2.09871 $w=1.3e-08 $l=9e-09 $layer=M1 $thickness=3.6e-08 $X=1.647
+ $Y=0.1455 $X2=1.647 $Y2=0.1545
r97 120 121 0.582974 $w=1.3e-08 $l=2.5e-09 $layer=M1 $thickness=3.6e-08
+ $X=1.647 $Y=0.143 $X2=1.647 $Y2=0.1455
r98 119 120 2.3319 $w=1.3e-08 $l=1e-08 $layer=M1 $thickness=3.6e-08 $X=1.647
+ $Y=0.133 $X2=1.647 $Y2=0.143
r99 47 119 3.03147 $w=1.3e-08 $l=1.3e-08 $layer=M1 $thickness=3.6e-08 $X=1.647
+ $Y=0.12 $X2=1.647 $Y2=0.133
r100 116 117 10.9599 $w=1.3e-08 $l=4.7e-08 $layer=M2 $thickness=3.6e-08
+ $X=2.294 $Y=0.153 $X2=2.341 $Y2=0.153
r101 115 116 78.8181 $w=1.3e-08 $l=3.38e-07 $layer=M2 $thickness=3.6e-08
+ $X=1.956 $Y=0.153 $X2=2.294 $Y2=0.153
r102 54 115 70.6565 $w=1.3e-08 $l=3.03e-07 $layer=M2 $thickness=3.6e-08
+ $X=1.653 $Y=0.153 $X2=1.956 $Y2=0.153
r103 54 103 2.09871 $w=1.3e-08 $l=9e-09 $layer=M2 $thickness=3.6e-08 $X=1.653
+ $Y=0.153 $X2=1.644 $Y2=0.153
r104 54 122 58.604 $a=1.08e-16 $layer=V1 $X=1.653 $Y=0.153 $X2=1.647 $Y2=0.1545
r105 35 98 19.5347 $a=3.24e-16 $layer=V1 $X=1.449 $Y=0.153 $X2=1.449 $Y2=0.153
r106 110 111 2.3319 $w=1.3e-08 $l=1e-08 $layer=M1 $thickness=3.6e-08 $X=1.269
+ $Y=0.143 $X2=1.269 $Y2=0.153
r107 109 110 2.3319 $w=1.3e-08 $l=1e-08 $layer=M1 $thickness=3.6e-08 $X=1.269
+ $Y=0.133 $X2=1.269 $Y2=0.143
r108 46 109 2.68168 $w=1.3e-08 $l=1.15e-08 $layer=M1 $thickness=3.6e-08
+ $X=1.269 $Y=0.1215 $X2=1.269 $Y2=0.133
r109 40 92 39.0693 $a=1.62e-16 $layer=V1 $X=0.257 $Y=0.1575 $X2=0.257 $Y2=0.153
r110 40 108 2.09871 $w=1.3e-08 $l=9e-09 $layer=M1 $thickness=3.6e-08 $X=0.257
+ $Y=0.1575 $X2=0.257 $Y2=0.1665
r111 40 133 19.3796 $a=3.24e-16 $layer=V0LIG $X=0.257 $Y=0.1575 $X2=0.2595
+ $Y2=0.162
r112 106 107 0.612267 $w=1.8e-08 $l=6e-09 $layer=M1 $thickness=3.6e-08 $X=0.257
+ $Y=0.1395 $X2=0.257 $Y2=0.1455
r113 30 92 39.0693 $a=1.62e-16 $layer=V1 $X=0.257 $Y=0.15 $X2=0.257 $Y2=0.153
r114 30 107 0.4592 $w=1.8e-08 $l=4.5e-09 $layer=M1 $thickness=3.6e-08 $X=0.257
+ $Y=0.15 $X2=0.257 $Y2=0.1455
r115 30 40 1.35549 $w=1.5e-08 $l=7.5e-09 $layer=M1 $thickness=3.6e-08 $X=0.257
+ $Y=0.15 $X2=0.257 $Y2=0.1575
r116 30 41 4.96993 $w=1.36522e-08 $l=2.96142e-08 $layer=M1 $thickness=3.6e-08
+ $X=0.257 $Y=0.15 $X2=0.286 $Y2=0.144
r117 3 87 19.3796 $a=3.24e-16 $layer=V0LIG $X=0.945 $Y=0.135 $X2=0.945 $Y2=0.133
r118 3 22 6.54019 $w=2.09524e-08 $layer=Gate_1 $thickness=5.21905e-08 $X=0.945
+ $Y=0.135 $X2=0.945 $Y2=0.135
r119 103 122 29.302 $a=2.16e-16 $layer=V1 $X=1.644 $Y=0.153 $X2=1.647 $Y2=0.1545
r120 102 103 4.37231 $w=1.3e-08 $l=1.88e-08 $layer=M2 $thickness=3.6e-08
+ $X=1.6252 $Y=0.153 $X2=1.644 $Y2=0.153
r121 101 102 3.08976 $w=1.3e-08 $l=1.32e-08 $layer=M2 $thickness=3.6e-08
+ $X=1.612 $Y=0.156 $X2=1.6252 $Y2=0.153
r122 101 100 0.524677 $w=1.3e-08 $l=2.3e-09 $layer=M2 $thickness=3.6e-08
+ $X=1.612 $Y=0.156 $X2=1.6097 $Y2=0.153
r123 99 100 17.8973 $w=1.3e-08 $l=7.67e-08 $layer=M2 $thickness=3.6e-08
+ $X=1.533 $Y=0.153 $X2=1.6097 $Y2=0.153
r124 98 99 19.5879 $w=1.3e-08 $l=8.4e-08 $layer=M2 $thickness=3.6e-08 $X=1.449
+ $Y=0.153 $X2=1.533 $Y2=0.153
r125 97 98 20.9871 $w=1.3e-08 $l=9e-08 $layer=M2 $thickness=3.6e-08 $X=1.359
+ $Y=0.153 $X2=1.449 $Y2=0.153
r126 96 97 20.9871 $w=1.3e-08 $l=9e-08 $layer=M2 $thickness=3.6e-08 $X=1.269
+ $Y=0.153 $X2=1.359 $Y2=0.153
r127 96 111 19.5347 $a=3.24e-16 $layer=V1 $X=1.269 $Y=0.153 $X2=1.269 $Y2=0.153
r128 95 96 34.5121 $w=1.3e-08 $l=1.48e-07 $layer=M2 $thickness=3.6e-08 $X=1.121
+ $Y=0.153 $X2=1.269 $Y2=0.153
r129 94 95 35.678 $w=1.3e-08 $l=1.53e-07 $layer=M2 $thickness=3.6e-08 $X=0.968
+ $Y=0.153 $X2=1.121 $Y2=0.153
r130 55 94 4.6055 $w=1.3e-08 $l=1.98e-08 $layer=M2 $thickness=3.6e-08 $X=0.9482
+ $Y=0.153 $X2=0.968 $Y2=0.153
r131 55 90 2.09871 $w=1.3e-08 $l=9e-09 $layer=M2 $thickness=3.6e-08 $X=0.9482
+ $Y=0.153 $X2=0.9392 $Y2=0.153
r132 92 93 10.2603 $w=1.3e-08 $l=4.4e-08 $layer=M2 $thickness=3.6e-08 $X=0.257
+ $Y=0.153 $X2=0.301 $Y2=0.153
r133 53 90 70.7148 $w=1.3e-08 $l=3.032e-07 $layer=M2 $thickness=3.6e-08
+ $X=0.636 $Y=0.153 $X2=0.9392 $Y2=0.153
r134 53 93 78.1186 $w=1.3e-08 $l=3.35e-07 $layer=M2 $thickness=3.6e-08 $X=0.636
+ $Y=0.153 $X2=0.301 $Y2=0.153
r135 88 89 0.582974 $w=1.3e-08 $l=2.5e-09 $layer=M1 $thickness=3.6e-08 $X=0.945
+ $Y=0.143 $X2=0.945 $Y2=0.1455
r136 87 88 2.3319 $w=1.3e-08 $l=1e-08 $layer=M1 $thickness=3.6e-08 $X=0.945
+ $Y=0.133 $X2=0.945 $Y2=0.143
r137 45 85 3.61444 $w=1.3e-08 $l=1.55e-08 $layer=M1 $thickness=3.6e-08 $X=0.945
+ $Y=0.1545 $X2=0.945 $Y2=0.17
r138 45 89 2.09871 $w=1.3e-08 $l=9e-09 $layer=M1 $thickness=3.6e-08 $X=0.945
+ $Y=0.1545 $X2=0.945 $Y2=0.1455
r139 45 90 54.096 $a=1.17e-16 $layer=V1 $X=0.945 $Y=0.1545 $X2=0.9392 $Y2=0.153
r140 45 55 30.576 $a=2.07e-16 $layer=V1 $X=0.945 $Y=0.1545 $X2=0.9482 $Y2=0.153
r141 33 84 4.64701 $w=1.46667e-08 $l=2.7e-08 $layer=M1 $thickness=3.6e-08
+ $X=0.945 $Y=0.187 $X2=0.918 $Y2=0.187
r142 33 85 2.31511 $w=1.81882e-08 $l=1.7e-08 $layer=M1 $thickness=3.6e-08
+ $X=0.945 $Y=0.187 $X2=0.945 $Y2=0.17
r143 83 84 6.29612 $w=1.3e-08 $l=2.7e-08 $layer=M1 $thickness=3.6e-08 $X=0.891
+ $Y=0.187 $X2=0.918 $Y2=0.187
r144 82 83 2.56509 $w=1.3e-08 $l=1.1e-08 $layer=M1 $thickness=3.6e-08 $X=0.88
+ $Y=0.187 $X2=0.891 $Y2=0.187
r145 44 82 7.34548 $w=1.3e-08 $l=3.15e-08 $layer=M1 $thickness=3.6e-08
+ $X=0.8485 $Y=0.187 $X2=0.88 $Y2=0.187
r146 32 74 1.32639 $w=1.59412e-08 $l=8.5e-09 $layer=M1 $thickness=3.6e-08
+ $X=0.81 $Y=0.183 $X2=0.81 $Y2=0.1745
r147 32 44 7.38932 $w=1.37246e-08 $l=3.87072e-08 $layer=M1 $thickness=3.6e-08
+ $X=0.81 $Y=0.183 $X2=0.8485 $Y2=0.187
r148 79 78 11.9048 $w=2.1e-08 $l=3.5e-08 $layer=Gate_1 $thickness=5.6e-08
+ $X=0.837 $Y=0.216 $X2=0.837 $Y2=0.181
r149 76 77 21.0886 $w=2.1e-08 $l=6.2e-08 $layer=Gate_1 $thickness=5.6e-08
+ $X=0.837 $Y=0.0675 $X2=0.837 $Y2=0.1295
r150 21 70 6.54019 $w=2.09524e-08 $layer=Gate_1 $thickness=5.21905e-08 $X=0.837
+ $Y=0.162 $X2=0.837 $Y2=0.162
r151 21 77 11.2416 $w=2.06615e-08 $l=3.25e-08 $layer=Gate_1 $thickness=5.6e-08
+ $X=0.837 $Y=0.162 $X2=0.837 $Y2=0.1295
r152 21 78 6.6497 $w=2.04211e-08 $l=1.9e-08 $layer=Gate_1 $thickness=5.6e-08
+ $X=0.837 $Y=0.162 $X2=0.837 $Y2=0.181
r153 73 74 2.91487 $w=1.3e-08 $l=1.25e-08 $layer=M1 $thickness=3.6e-08 $X=0.81
+ $Y=0.162 $X2=0.81 $Y2=0.1745
r154 72 73 2.79828 $w=1.3e-08 $l=1.2e-08 $layer=M1 $thickness=3.6e-08 $X=0.81
+ $Y=0.15 $X2=0.81 $Y2=0.162
r155 43 72 1.28254 $w=1.3e-08 $l=5.5e-09 $layer=M1 $thickness=3.6e-08 $X=0.81
+ $Y=0.1445 $X2=0.81 $Y2=0.15
r156 69 70 12.6539 $w=1.77815e-08 $l=2.7e-08 $layer=LIG $thickness=4.8e-08
+ $X=0.81 $Y=0.162 $X2=0.837 $Y2=0.162
r157 69 73 19.3796 $a=3.24e-16 $layer=V0LIG $X=0.81 $Y=0.162 $X2=0.81 $Y2=0.162
r158 2 64 6.54019 $w=2.09524e-08 $layer=Gate_1 $thickness=5.21905e-08 $X=0.783
+ $Y=0.162 $X2=0.783 $Y2=0.162
r159 2 69 12.6539 $w=1.77815e-08 $l=2.7e-08 $layer=LIG $thickness=4.8e-08
+ $X=0.783 $Y=0.162 $X2=0.81 $Y2=0.162
r160 66 65 11.9048 $w=2.1e-08 $l=3.5e-08 $layer=Gate_1 $thickness=5.6e-08
+ $X=0.783 $Y=0.216 $X2=0.783 $Y2=0.181
r161 64 65 6.6497 $w=2.04211e-08 $l=1.9e-08 $layer=Gate_1 $thickness=5.6e-08
+ $X=0.783 $Y=0.162 $X2=0.783 $Y2=0.181
r162 63 64 11.2416 $w=2.06615e-08 $l=3.25e-08 $layer=Gate_1 $thickness=5.6e-08
+ $X=0.783 $Y=0.1295 $X2=0.783 $Y2=0.162
r163 62 63 21.0886 $w=2.1e-08 $l=6.2e-08 $layer=Gate_1 $thickness=5.6e-08
+ $X=0.783 $Y=0.0675 $X2=0.783 $Y2=0.1295
r164 62 20 14.6259 $w=2.1e-08 $l=4.3e-08 $layer=Gate_1 $thickness=5.6e-08
+ $X=0.783 $Y=0.0675 $X2=0.783 $Y2=0.0245
.ends

.subckt PM_ICGx4DC_ASAP7_75t_R%6 vss 19 23 33 36 46 47 50 51 9 15 1 18 10 16 4
+ 12 14
c1 1 vss 0.00696437f $X=0.405 $Y=0.135
c2 3 vss 0.00831441f $X=0.432 $Y=0.0675
c3 4 vss 0.00828702f $X=0.54 $Y=0.0675
c4 9 vss 0.0849424f $X=0.405 $Y=0.0245
c5 10 vss 0.0823494f $X=0.459 $Y=0.135
c6 11 vss 0.00894005f $X=0.4175 $Y=0.0675
c7 12 vss 0.00924676f $X=0.5255 $Y=0.0675
c8 13 vss 0.000644247f $X=0.459 $Y=0.099
c9 14 vss 0.000576362f $X=0.459 $Y=0.135
c10 15 vss 0.00136488f $X=0.4175 $Y=0.099
c11 16 vss 0.00203564f $X=0.415 $Y=0.135
c12 17 vss 0.000171972f $X=0.459 $Y=0.117
c13 18 vss 0.00279652f $X=0.486 $Y=0.099
r1 51 49 0.0308642 $w=8.1e-08 $l=2.5e-09 $layer=N_src_drn $thickness=1e-09
+ $X=0.5573 $Y=0.0675 $X2=0.5545 $Y2=0.0675
r2 4 49 0.179012 $w=8.1e-08 $l=1.45e-08 $layer=N_src_drn $thickness=1e-09
+ $X=0.54 $Y=0.0675 $X2=0.5545 $Y2=0.0675
r3 12 4 0.179012 $w=8.1e-08 $l=1.45e-08 $layer=N_src_drn $thickness=1e-09
+ $X=0.5255 $Y=0.0675 $X2=0.54 $Y2=0.0675
r4 50 12 0.0308642 $w=8.1e-08 $l=2.5e-09 $layer=N_src_drn $thickness=1e-09
+ $X=0.5226 $Y=0.0675 $X2=0.5255 $Y2=0.0675
r5 47 45 0.0308642 $w=8.1e-08 $l=2.5e-09 $layer=N_src_drn $thickness=1e-09
+ $X=0.4493 $Y=0.0675 $X2=0.4465 $Y2=0.0675
r6 3 45 0.179012 $w=8.1e-08 $l=1.45e-08 $layer=N_src_drn $thickness=1e-09
+ $X=0.432 $Y=0.0675 $X2=0.4465 $Y2=0.0675
r7 11 3 0.179012 $w=8.1e-08 $l=1.45e-08 $layer=N_src_drn $thickness=1e-09
+ $X=0.4175 $Y=0.0675 $X2=0.432 $Y2=0.0675
r8 46 11 0.0308642 $w=8.1e-08 $l=2.5e-09 $layer=N_src_drn $thickness=1e-09
+ $X=0.4146 $Y=0.0675 $X2=0.4175 $Y2=0.0675
r9 4 42 19.3796 $a=3.24e-16 $layer=V0LISD $X=0.54 $Y=0.0675 $X2=0.54 $Y2=0.099
r10 3 38 19.3796 $a=3.24e-16 $layer=V0LISD $X=0.432 $Y=0.0675 $X2=0.432
+ $Y2=0.099
r11 41 42 5.24677 $w=1.3e-08 $l=2.25e-08 $layer=M1 $thickness=3.6e-08 $X=0.5175
+ $Y=0.099 $X2=0.54 $Y2=0.099
r12 18 41 7.34548 $w=1.3e-08 $l=3.15e-08 $layer=M1 $thickness=3.6e-08 $X=0.486
+ $Y=0.099 $X2=0.5175 $Y2=0.099
r13 38 39 3.14806 $w=1.3e-08 $l=1.35e-08 $layer=M1 $thickness=3.6e-08 $X=0.432
+ $Y=0.099 $X2=0.4455 $Y2=0.099
r14 15 38 3.38125 $w=1.3e-08 $l=1.45e-08 $layer=M1 $thickness=3.6e-08 $X=0.4175
+ $Y=0.099 $X2=0.432 $Y2=0.099
r15 13 17 3.01711 $w=1.55e-08 $l=1.8e-08 $layer=M1 $thickness=3.6e-08 $X=0.459
+ $Y=0.099 $X2=0.459 $Y2=0.117
r16 13 39 1.96775 $w=1.63333e-08 $l=1.35e-08 $layer=M1 $thickness=3.6e-08
+ $X=0.459 $Y=0.099 $X2=0.4455 $Y2=0.099
r17 13 18 5.11582 $w=1.46667e-08 $l=2.7e-08 $layer=M1 $thickness=3.6e-08
+ $X=0.459 $Y=0.099 $X2=0.486 $Y2=0.099
r18 14 31 1.49895 $w=1.63333e-08 $l=1.35e-08 $layer=M1 $thickness=3.6e-08
+ $X=0.459 $Y=0.135 $X2=0.4455 $Y2=0.135
r19 14 17 2.5483 $w=1.79e-08 $l=1.8e-08 $layer=M1 $thickness=3.6e-08 $X=0.459
+ $Y=0.135 $X2=0.459 $Y2=0.117
r20 36 35 16.4967 $w=2.1e-08 $l=4.85e-08 $layer=Gate_1 $thickness=5.6e-08
+ $X=0.459 $Y=0.2025 $X2=0.459 $Y2=0.154
r21 33 34 16.4967 $w=2.1e-08 $l=4.85e-08 $layer=Gate_1 $thickness=5.6e-08
+ $X=0.459 $Y=0.0675 $X2=0.459 $Y2=0.116
r22 10 27 6.54019 $w=2.09524e-08 $layer=Gate_1 $thickness=5.21905e-08 $X=0.459
+ $Y=0.135 $X2=0.459 $Y2=0.135
r23 10 34 6.6497 $w=2.04211e-08 $l=1.9e-08 $layer=Gate_1 $thickness=5.6e-08
+ $X=0.459 $Y=0.135 $X2=0.459 $Y2=0.116
r24 10 35 6.6497 $w=2.04211e-08 $l=1.9e-08 $layer=Gate_1 $thickness=5.6e-08
+ $X=0.459 $Y=0.135 $X2=0.459 $Y2=0.154
r25 30 31 3.14806 $w=1.3e-08 $l=1.35e-08 $layer=M1 $thickness=3.6e-08 $X=0.432
+ $Y=0.135 $X2=0.4455 $Y2=0.135
r26 29 30 2.68168 $w=1.3e-08 $l=1.15e-08 $layer=M1 $thickness=3.6e-08 $X=0.4205
+ $Y=0.135 $X2=0.432 $Y2=0.135
r27 16 29 1.28254 $w=1.3e-08 $l=5.5e-09 $layer=M1 $thickness=3.6e-08 $X=0.415
+ $Y=0.135 $X2=0.4205 $Y2=0.135
r28 26 27 12.6539 $w=1.77815e-08 $l=2.7e-08 $layer=LIG $thickness=4.8e-08
+ $X=0.432 $Y=0.135 $X2=0.459 $Y2=0.135
r29 26 30 19.3796 $a=3.24e-16 $layer=V0LIG $X=0.432 $Y=0.135 $X2=0.432 $Y2=0.135
r30 1 21 6.54019 $w=2.09524e-08 $layer=Gate_1 $thickness=5.21905e-08 $X=0.405
+ $Y=0.135 $X2=0.405 $Y2=0.135
r31 1 26 12.6539 $w=1.77815e-08 $l=2.7e-08 $layer=LIG $thickness=4.8e-08
+ $X=0.405 $Y=0.135 $X2=0.432 $Y2=0.135
r32 23 22 16.4967 $w=2.1e-08 $l=4.85e-08 $layer=Gate_1 $thickness=5.6e-08
+ $X=0.405 $Y=0.2025 $X2=0.405 $Y2=0.154
r33 21 22 6.6497 $w=2.04211e-08 $l=1.9e-08 $layer=Gate_1 $thickness=5.6e-08
+ $X=0.405 $Y=0.135 $X2=0.405 $Y2=0.154
r34 20 21 6.6497 $w=2.04211e-08 $l=1.9e-08 $layer=Gate_1 $thickness=5.6e-08
+ $X=0.405 $Y=0.116 $X2=0.405 $Y2=0.135
r35 19 20 16.4967 $w=2.1e-08 $l=4.85e-08 $layer=Gate_1 $thickness=5.6e-08
+ $X=0.405 $Y=0.0675 $X2=0.405 $Y2=0.116
r36 19 9 14.6259 $w=2.1e-08 $l=4.3e-08 $layer=Gate_1 $thickness=5.6e-08
+ $X=0.405 $Y=0.0675 $X2=0.405 $Y2=0.0245
.ends

.subckt PM_ICGx4DC_ASAP7_75t_R%8 vss 24 28 37 40 57 58 66 67 70 71 13 22 16 15
+ 5 3 19 4 21 1 20 14 23 12 17 18
c1 1 vss 0.00623909f $X=0.621 $Y=0.136
c2 3 vss 0.00718596f $X=0.756 $Y=0.216
c3 4 vss 0.00470467f $X=0.81 $Y=0.0675
c4 5 vss 0.00753767f $X=0.864 $Y=0.216
c5 12 vss 0.0851121f $X=0.621 $Y=0.0245
c6 13 vss 0.0962963f $X=0.675 $Y=0.136
c7 14 vss 0.00441904f $X=0.7955 $Y=0.0675
c8 15 vss 0.00499195f $X=0.7415 $Y=0.216
c9 16 vss 0.00510404f $X=0.8495 $Y=0.216
c10 17 vss 0.000523499f $X=0.675 $Y=0.072
c11 18 vss 0.000599385f $X=0.675 $Y=0.197
c12 19 vss 0.00312948f $X=0.729 $Y=0.192
c13 20 vss 0.00138037f $X=0.675 $Y=0.113
c14 21 vss 0.00470836f $X=0.6855 $Y=0.072
c15 22 vss 0.00125005f $X=0.702 $Y=0.197
c16 23 vss 0.0118586f $X=0.7425 $Y=0.231
r1 71 69 0.0462963 $w=5.4e-08 $l=2.5e-09 $layer=P_src_drn $thickness=1e-09
+ $X=0.8813 $Y=0.216 $X2=0.8785 $Y2=0.216
r2 5 69 0.268519 $w=5.4e-08 $l=1.45e-08 $layer=P_src_drn $thickness=1e-09
+ $X=0.864 $Y=0.216 $X2=0.8785 $Y2=0.216
r3 16 5 0.268519 $w=5.4e-08 $l=1.45e-08 $layer=P_src_drn $thickness=1e-09
+ $X=0.8495 $Y=0.216 $X2=0.864 $Y2=0.216
r4 70 16 0.0462963 $w=5.4e-08 $l=2.5e-09 $layer=P_src_drn $thickness=1e-09
+ $X=0.8466 $Y=0.216 $X2=0.8495 $Y2=0.216
r5 67 65 0.0462963 $w=5.4e-08 $l=2.5e-09 $layer=P_src_drn $thickness=1e-09
+ $X=0.7733 $Y=0.216 $X2=0.7705 $Y2=0.216
r6 3 65 0.268519 $w=5.4e-08 $l=1.45e-08 $layer=P_src_drn $thickness=1e-09
+ $X=0.756 $Y=0.216 $X2=0.7705 $Y2=0.216
r7 15 3 0.268519 $w=5.4e-08 $l=1.45e-08 $layer=P_src_drn $thickness=1e-09
+ $X=0.7415 $Y=0.216 $X2=0.756 $Y2=0.216
r8 66 15 0.0462963 $w=5.4e-08 $l=2.5e-09 $layer=P_src_drn $thickness=1e-09
+ $X=0.7386 $Y=0.216 $X2=0.7415 $Y2=0.216
r9 5 62 19.3796 $a=3.24e-16 $layer=V0LISD $X=0.864 $Y=0.216 $X2=0.864 $Y2=0.231
r10 3 59 19.3796 $a=3.24e-16 $layer=V0LISD $X=0.756 $Y=0.216 $X2=0.756 $Y2=0.231
r11 61 62 8.39483 $w=1.3e-08 $l=3.6e-08 $layer=M1 $thickness=3.6e-08 $X=0.828
+ $Y=0.231 $X2=0.864 $Y2=0.231
r12 60 61 10.4935 $w=1.3e-08 $l=4.5e-08 $layer=M1 $thickness=3.6e-08 $X=0.783
+ $Y=0.231 $X2=0.828 $Y2=0.231
r13 59 60 6.29612 $w=1.3e-08 $l=2.7e-08 $layer=M1 $thickness=3.6e-08 $X=0.756
+ $Y=0.231 $X2=0.783 $Y2=0.231
r14 23 59 3.14806 $w=1.3e-08 $l=1.35e-08 $layer=M1 $thickness=3.6e-08 $X=0.7425
+ $Y=0.231 $X2=0.756 $Y2=0.231
r15 23 53 1.20242 $w=1.425e-08 $l=1.54434e-08 $layer=M1 $thickness=3.6e-08
+ $X=0.7425 $Y=0.231 $X2=0.729 $Y2=0.2235
r16 58 56 0.0308642 $w=8.1e-08 $l=2.5e-09 $layer=N_src_drn $thickness=1e-09
+ $X=0.8273 $Y=0.0675 $X2=0.8245 $Y2=0.0675
r17 4 56 0.179012 $w=8.1e-08 $l=1.45e-08 $layer=N_src_drn $thickness=1e-09
+ $X=0.81 $Y=0.0675 $X2=0.8245 $Y2=0.0675
r18 14 4 0.179012 $w=8.1e-08 $l=1.45e-08 $layer=N_src_drn $thickness=1e-09
+ $X=0.7955 $Y=0.0675 $X2=0.81 $Y2=0.0675
r19 57 14 0.0308642 $w=8.1e-08 $l=2.5e-09 $layer=N_src_drn $thickness=1e-09
+ $X=0.7926 $Y=0.0675 $X2=0.7955 $Y2=0.0675
r20 52 53 2.01858 $w=1.37895e-08 $l=9.5e-09 $layer=M1 $thickness=3.6e-08
+ $X=0.729 $Y=0.214 $X2=0.729 $Y2=0.2235
r21 51 52 2.37574 $w=1.49231e-08 $l=1.3e-08 $layer=M1 $thickness=3.6e-08
+ $X=0.729 $Y=0.201 $X2=0.729 $Y2=0.214
r22 19 22 4.60559 $w=1.39091e-08 $l=2.74591e-08 $layer=M1 $thickness=3.6e-08
+ $X=0.729 $Y=0.192 $X2=0.702 $Y2=0.197
r23 19 51 0.9184 $w=1.8e-08 $l=9e-09 $layer=M1 $thickness=3.6e-08 $X=0.729
+ $Y=0.192 $X2=0.729 $Y2=0.201
r24 4 49 19.3796 $a=3.24e-16 $layer=V0LISD $X=0.81 $Y=0.0675 $X2=0.81 $Y2=0.072
r25 48 49 9.44419 $w=1.3e-08 $l=4.05e-08 $layer=M1 $thickness=3.6e-08 $X=0.7695
+ $Y=0.072 $X2=0.81 $Y2=0.072
r26 47 48 9.44419 $w=1.3e-08 $l=4.05e-08 $layer=M1 $thickness=3.6e-08 $X=0.729
+ $Y=0.072 $X2=0.7695 $Y2=0.072
r27 46 47 5.94634 $w=1.3e-08 $l=2.55e-08 $layer=M1 $thickness=3.6e-08 $X=0.7035
+ $Y=0.072 $X2=0.729 $Y2=0.072
r28 21 46 4.19742 $w=1.3e-08 $l=1.8e-08 $layer=M1 $thickness=3.6e-08 $X=0.6855
+ $Y=0.072 $X2=0.7035 $Y2=0.072
r29 18 45 5.22999 $w=1.59898e-08 $l=2.95e-08 $layer=M1 $thickness=3.6e-08
+ $X=0.675 $Y=0.197 $X2=0.675 $Y2=0.1675
r30 18 22 4.64701 $w=1.46667e-08 $l=2.7e-08 $layer=M1 $thickness=3.6e-08
+ $X=0.675 $Y=0.197 $X2=0.702 $Y2=0.197
r31 17 44 2.5483 $w=1.79e-08 $l=1.8e-08 $layer=M1 $thickness=3.6e-08 $X=0.675
+ $Y=0.072 $X2=0.675 $Y2=0.09
r32 17 21 0.79938 $w=1.72857e-08 $l=1.05e-08 $layer=M1 $thickness=3.6e-08
+ $X=0.675 $Y=0.072 $X2=0.6855 $Y2=0.072
r33 43 45 5.01358 $w=1.3e-08 $l=2.15e-08 $layer=M1 $thickness=3.6e-08 $X=0.675
+ $Y=0.146 $X2=0.675 $Y2=0.1675
r34 42 43 2.3319 $w=1.3e-08 $l=1e-08 $layer=M1 $thickness=3.6e-08 $X=0.675
+ $Y=0.136 $X2=0.675 $Y2=0.146
r35 20 42 5.36336 $w=1.3e-08 $l=2.3e-08 $layer=M1 $thickness=3.6e-08 $X=0.675
+ $Y=0.113 $X2=0.675 $Y2=0.136
r36 20 44 5.36336 $w=1.3e-08 $l=2.3e-08 $layer=M1 $thickness=3.6e-08 $X=0.675
+ $Y=0.113 $X2=0.675 $Y2=0.09
r37 40 39 16.3266 $w=2.1e-08 $l=4.8e-08 $layer=Gate_1 $thickness=5.6e-08
+ $X=0.675 $Y=0.216 $X2=0.675 $Y2=0.168
r38 37 38 16.6668 $w=2.1e-08 $l=4.9e-08 $layer=Gate_1 $thickness=5.6e-08
+ $X=0.675 $Y=0.054 $X2=0.675 $Y2=0.103
r39 13 33 6.27904 $w=2.09e-08 $layer=Gate_1 $thickness=5.24e-08 $X=0.675
+ $Y=0.136 $X2=0.675 $Y2=0.136
r40 13 38 11.4116 $w=2.06667e-08 $l=3.3e-08 $layer=Gate_1 $thickness=5.6e-08
+ $X=0.675 $Y=0.136 $X2=0.675 $Y2=0.103
r41 13 39 11.0715 $w=2.06563e-08 $l=3.2e-08 $layer=Gate_1 $thickness=5.6e-08
+ $X=0.675 $Y=0.136 $X2=0.675 $Y2=0.168
r42 33 42 19.3796 $a=3.24e-16 $layer=V0LIG $X=0.675 $Y=0.136 $X2=0.675 $Y2=0.136
r43 32 33 2.48102 $w=2.2e-08 $l=9.5e-09 $layer=LIG $thickness=4.8e-08 $X=0.6655
+ $Y=0.136 $X2=0.675 $Y2=0.136
r44 31 32 10.1729 $w=1.54914e-08 $l=1.75e-08 $layer=LIG $thickness=4.8e-08
+ $X=0.648 $Y=0.136 $X2=0.6655 $Y2=0.136
r45 1 26 6.54019 $w=2.09524e-08 $layer=Gate_1 $thickness=5.21905e-08 $X=0.621
+ $Y=0.136 $X2=0.621 $Y2=0.136
r46 1 31 12.6539 $w=1.77815e-08 $l=2.7e-08 $layer=LIG $thickness=4.8e-08
+ $X=0.621 $Y=0.136 $X2=0.648 $Y2=0.136
r47 28 27 16.3266 $w=2.1e-08 $l=4.8e-08 $layer=Gate_1 $thickness=5.6e-08
+ $X=0.621 $Y=0.216 $X2=0.621 $Y2=0.168
r48 26 27 11.0715 $w=2.06563e-08 $l=3.2e-08 $layer=Gate_1 $thickness=5.6e-08
+ $X=0.621 $Y=0.136 $X2=0.621 $Y2=0.168
r49 25 26 11.4116 $w=2.06667e-08 $l=3.3e-08 $layer=Gate_1 $thickness=5.6e-08
+ $X=0.621 $Y=0.103 $X2=0.621 $Y2=0.136
r50 24 25 16.6668 $w=2.1e-08 $l=4.9e-08 $layer=Gate_1 $thickness=5.6e-08
+ $X=0.621 $Y=0.054 $X2=0.621 $Y2=0.103
r51 24 12 10.0341 $w=2.1e-08 $l=2.95e-08 $layer=Gate_1 $thickness=5.6e-08
+ $X=0.621 $Y=0.054 $X2=0.621 $Y2=0.0245
.ends

.subckt PM_ICGx4DC_ASAP7_75t_R%SE vss 20 7 11 5 4 1 3
c1 1 vss 0.00381371f $X=1.161 $Y=0.135
c2 3 vss 0.0851187f $X=1.161 $Y=0.0245
c3 4 vss 0.00231835f $X=1.161 $Y=0.071
c4 5 vss 0.000879587f $X=1.067 $Y=0.081
r1 20 5 21.9198 $w=1.3e-08 $l=9.4e-08 $layer=M2 $thickness=3.6e-08 $X=1.161
+ $Y=0.08 $X2=1.067 $Y2=0.081
r2 16 17 6.52931 $w=1.3e-08 $l=2.8e-08 $layer=M1 $thickness=3.6e-08 $X=1.161
+ $Y=0.109 $X2=1.161 $Y2=0.137
r3 15 16 6.52931 $w=1.3e-08 $l=2.8e-08 $layer=M1 $thickness=3.6e-08 $X=1.161
+ $Y=0.081 $X2=1.161 $Y2=0.109
r4 20 15 19.5347 $a=3.24e-16 $layer=V1 $X=1.161 $Y=0.08 $X2=1.161 $Y2=0.081
r5 4 15 2.3319 $w=1.3e-08 $l=1e-08 $layer=M1 $thickness=3.6e-08 $X=1.161
+ $Y=0.071 $X2=1.161 $Y2=0.081
r6 1 9 6.54019 $w=2.09524e-08 $layer=Gate_1 $thickness=5.21905e-08 $X=1.161
+ $Y=0.135 $X2=1.161 $Y2=0.135
r7 1 17 19.3796 $a=3.24e-16 $layer=V0LIG $X=1.161 $Y=0.135 $X2=1.161 $Y2=0.137
r8 11 10 16.4967 $w=2.1e-08 $l=4.85e-08 $layer=Gate_1 $thickness=5.6e-08
+ $X=1.161 $Y=0.216 $X2=1.161 $Y2=0.1675
r9 9 10 11.2416 $w=2.06615e-08 $l=3.25e-08 $layer=Gate_1 $thickness=5.6e-08
+ $X=1.161 $Y=0.135 $X2=1.161 $Y2=0.1675
r10 8 9 11.2416 $w=2.06615e-08 $l=3.25e-08 $layer=Gate_1 $thickness=5.6e-08
+ $X=1.161 $Y=0.1025 $X2=1.161 $Y2=0.135
r11 7 8 16.4967 $w=2.1e-08 $l=4.85e-08 $layer=Gate_1 $thickness=5.6e-08
+ $X=1.161 $Y=0.054 $X2=1.161 $Y2=0.1025
r12 7 3 10.0341 $w=2.1e-08 $l=2.95e-08 $layer=Gate_1 $thickness=5.6e-08
+ $X=1.161 $Y=0.054 $X2=1.161 $Y2=0.0245
.ends

.subckt PM_ICGx4DC_ASAP7_75t_R%14 vss 24 28 41 44 57 58 66 67 70 71 12 14 22 21
+ 15 16 3 5 17 4 1 23 20 13 18 19
c1 1 vss 0.00623909f $X=1.9075 $Y=0.136
c2 3 vss 0.00753658f $X=1.728 $Y=0.216
c3 4 vss 0.00462216f $X=1.782 $Y=0.0675
c4 5 vss 0.00718596f $X=1.836 $Y=0.216
c5 12 vss 0.0965063f $X=1.917 $Y=0.0245
c6 13 vss 0.0851113f $X=1.971 $Y=0.136
c7 14 vss 0.00447514f $X=1.7675 $Y=0.0675
c8 15 vss 0.00509257f $X=1.7135 $Y=0.216
c9 16 vss 0.00499195f $X=1.8215 $Y=0.216
c10 17 vss 0.00312948f $X=1.863 $Y=0.192
c11 18 vss 0.000523499f $X=1.917 $Y=0.072
c12 19 vss 0.000599385f $X=1.917 $Y=0.197
c13 20 vss 0.0117733f $X=1.809 $Y=0.231
c14 21 vss 0.00451247f $X=1.9065 $Y=0.072
c15 22 vss 0.00125005f $X=1.89 $Y=0.197
c16 23 vss 0.00138037f $X=1.917 $Y=0.113
r1 71 69 0.0462963 $w=5.4e-08 $l=2.5e-09 $layer=P_src_drn $thickness=1e-09
+ $X=1.7453 $Y=0.216 $X2=1.7425 $Y2=0.216
r2 3 69 0.268519 $w=5.4e-08 $l=1.45e-08 $layer=P_src_drn $thickness=1e-09
+ $X=1.728 $Y=0.216 $X2=1.7425 $Y2=0.216
r3 15 3 0.268519 $w=5.4e-08 $l=1.45e-08 $layer=P_src_drn $thickness=1e-09
+ $X=1.7135 $Y=0.216 $X2=1.728 $Y2=0.216
r4 70 15 0.0462963 $w=5.4e-08 $l=2.5e-09 $layer=P_src_drn $thickness=1e-09
+ $X=1.7106 $Y=0.216 $X2=1.7135 $Y2=0.216
r5 67 65 0.0462963 $w=5.4e-08 $l=2.5e-09 $layer=P_src_drn $thickness=1e-09
+ $X=1.8533 $Y=0.216 $X2=1.8505 $Y2=0.216
r6 5 65 0.268519 $w=5.4e-08 $l=1.45e-08 $layer=P_src_drn $thickness=1e-09
+ $X=1.836 $Y=0.216 $X2=1.8505 $Y2=0.216
r7 16 5 0.268519 $w=5.4e-08 $l=1.45e-08 $layer=P_src_drn $thickness=1e-09
+ $X=1.8215 $Y=0.216 $X2=1.836 $Y2=0.216
r8 66 16 0.0462963 $w=5.4e-08 $l=2.5e-09 $layer=P_src_drn $thickness=1e-09
+ $X=1.8186 $Y=0.216 $X2=1.8215 $Y2=0.216
r9 3 62 19.3796 $a=3.24e-16 $layer=V0LISD $X=1.728 $Y=0.216 $X2=1.728 $Y2=0.231
r10 5 59 19.3796 $a=3.24e-16 $layer=V0LISD $X=1.836 $Y=0.216 $X2=1.836 $Y2=0.231
r11 62 63 8.39483 $w=1.3e-08 $l=3.6e-08 $layer=M1 $thickness=3.6e-08 $X=1.728
+ $Y=0.231 $X2=1.764 $Y2=0.231
r12 59 60 3.14806 $w=1.3e-08 $l=1.35e-08 $layer=M1 $thickness=3.6e-08 $X=1.836
+ $Y=0.231 $X2=1.8495 $Y2=0.231
r13 20 59 6.29612 $w=1.3e-08 $l=2.7e-08 $layer=M1 $thickness=3.6e-08 $X=1.809
+ $Y=0.231 $X2=1.836 $Y2=0.231
r14 20 63 10.4935 $w=1.3e-08 $l=4.5e-08 $layer=M1 $thickness=3.6e-08 $X=1.809
+ $Y=0.231 $X2=1.764 $Y2=0.231
r15 58 56 0.0308642 $w=8.1e-08 $l=2.5e-09 $layer=N_src_drn $thickness=1e-09
+ $X=1.7993 $Y=0.0675 $X2=1.7965 $Y2=0.0675
r16 4 56 0.179012 $w=8.1e-08 $l=1.45e-08 $layer=N_src_drn $thickness=1e-09
+ $X=1.782 $Y=0.0675 $X2=1.7965 $Y2=0.0675
r17 14 4 0.179012 $w=8.1e-08 $l=1.45e-08 $layer=N_src_drn $thickness=1e-09
+ $X=1.7675 $Y=0.0675 $X2=1.782 $Y2=0.0675
r18 57 14 0.0308642 $w=8.1e-08 $l=2.5e-09 $layer=N_src_drn $thickness=1e-09
+ $X=1.7646 $Y=0.0675 $X2=1.7675 $Y2=0.0675
r19 53 60 1.20242 $w=1.425e-08 $l=1.54434e-08 $layer=M1 $thickness=3.6e-08
+ $X=1.863 $Y=0.2235 $X2=1.8495 $Y2=0.231
r20 52 53 2.01858 $w=1.37895e-08 $l=9.5e-09 $layer=M1 $thickness=3.6e-08
+ $X=1.863 $Y=0.214 $X2=1.863 $Y2=0.2235
r21 51 52 2.37574 $w=1.49231e-08 $l=1.3e-08 $layer=M1 $thickness=3.6e-08
+ $X=1.863 $Y=0.201 $X2=1.863 $Y2=0.214
r22 17 22 4.60559 $w=1.39091e-08 $l=2.74591e-08 $layer=M1 $thickness=3.6e-08
+ $X=1.863 $Y=0.192 $X2=1.89 $Y2=0.197
r23 17 51 0.9184 $w=1.8e-08 $l=9e-09 $layer=M1 $thickness=3.6e-08 $X=1.863
+ $Y=0.192 $X2=1.863 $Y2=0.201
r24 4 49 19.3796 $a=3.24e-16 $layer=V0LISD $X=1.782 $Y=0.0675 $X2=1.782
+ $Y2=0.072
r25 49 50 9.44419 $w=1.3e-08 $l=4.05e-08 $layer=M1 $thickness=3.6e-08 $X=1.782
+ $Y=0.072 $X2=1.8225 $Y2=0.072
r26 47 50 9.44419 $w=1.3e-08 $l=4.05e-08 $layer=M1 $thickness=3.6e-08 $X=1.863
+ $Y=0.072 $X2=1.8225 $Y2=0.072
r27 46 47 5.94634 $w=1.3e-08 $l=2.55e-08 $layer=M1 $thickness=3.6e-08 $X=1.8885
+ $Y=0.072 $X2=1.863 $Y2=0.072
r28 21 46 4.19742 $w=1.3e-08 $l=1.8e-08 $layer=M1 $thickness=3.6e-08 $X=1.9065
+ $Y=0.072 $X2=1.8885 $Y2=0.072
r29 19 39 5.22999 $w=1.59898e-08 $l=2.95e-08 $layer=M1 $thickness=3.6e-08
+ $X=1.917 $Y=0.197 $X2=1.917 $Y2=0.1675
r30 19 22 4.64701 $w=1.46667e-08 $l=2.7e-08 $layer=M1 $thickness=3.6e-08
+ $X=1.917 $Y=0.197 $X2=1.89 $Y2=0.197
r31 18 38 2.5483 $w=1.79e-08 $l=1.8e-08 $layer=M1 $thickness=3.6e-08 $X=1.917
+ $Y=0.072 $X2=1.917 $Y2=0.09
r32 18 21 0.79938 $w=1.72857e-08 $l=1.05e-08 $layer=M1 $thickness=3.6e-08
+ $X=1.917 $Y=0.072 $X2=1.9065 $Y2=0.072
r33 44 43 16.3266 $w=2.1e-08 $l=4.8e-08 $layer=Gate_1 $thickness=5.6e-08
+ $X=1.971 $Y=0.216 $X2=1.971 $Y2=0.168
r34 41 42 16.6668 $w=2.1e-08 $l=4.9e-08 $layer=Gate_1 $thickness=5.6e-08
+ $X=1.971 $Y=0.054 $X2=1.971 $Y2=0.103
r35 13 34 6.54019 $w=2.09524e-08 $layer=Gate_1 $thickness=5.21905e-08 $X=1.971
+ $Y=0.136 $X2=1.971 $Y2=0.136
r36 13 42 11.4116 $w=2.06667e-08 $l=3.3e-08 $layer=Gate_1 $thickness=5.6e-08
+ $X=1.971 $Y=0.136 $X2=1.971 $Y2=0.103
r37 13 43 11.0715 $w=2.06563e-08 $l=3.2e-08 $layer=Gate_1 $thickness=5.6e-08
+ $X=1.971 $Y=0.136 $X2=1.971 $Y2=0.168
r38 37 39 5.01358 $w=1.3e-08 $l=2.15e-08 $layer=M1 $thickness=3.6e-08 $X=1.917
+ $Y=0.146 $X2=1.917 $Y2=0.1675
r39 36 37 2.3319 $w=1.3e-08 $l=1e-08 $layer=M1 $thickness=3.6e-08 $X=1.917
+ $Y=0.136 $X2=1.917 $Y2=0.146
r40 23 36 5.36336 $w=1.3e-08 $l=2.3e-08 $layer=M1 $thickness=3.6e-08 $X=1.917
+ $Y=0.113 $X2=1.917 $Y2=0.136
r41 23 38 5.36336 $w=1.3e-08 $l=2.3e-08 $layer=M1 $thickness=3.6e-08 $X=1.917
+ $Y=0.113 $X2=1.917 $Y2=0.09
r42 33 34 12.6539 $w=1.77815e-08 $l=2.7e-08 $layer=LIG $thickness=4.8e-08
+ $X=1.944 $Y=0.136 $X2=1.971 $Y2=0.136
r43 31 33 10.1729 $w=1.54914e-08 $l=1.75e-08 $layer=LIG $thickness=4.8e-08
+ $X=1.9265 $Y=0.136 $X2=1.944 $Y2=0.136
r44 30 31 2.48102 $w=2.2e-08 $l=9.5e-09 $layer=LIG $thickness=4.8e-08 $X=1.917
+ $Y=0.136 $X2=1.9265 $Y2=0.136
r45 30 36 19.3796 $a=3.24e-16 $layer=V0LIG $X=1.917 $Y=0.136 $X2=1.917 $Y2=0.136
r46 1 30 2.48102 $w=2.2e-08 $l=9.5e-09 $layer=LIG $thickness=4.8e-08 $X=1.9075
+ $Y=0.136 $X2=1.917 $Y2=0.136
r47 28 27 16.3266 $w=2.1e-08 $l=4.8e-08 $layer=Gate_1 $thickness=5.6e-08
+ $X=1.917 $Y=0.216 $X2=1.917 $Y2=0.168
r48 26 27 11.0715 $w=2.06563e-08 $l=3.2e-08 $layer=Gate_1 $thickness=5.6e-08
+ $X=1.917 $Y=0.136 $X2=1.917 $Y2=0.168
r49 26 31 4.05918 $w=2.0087e-08 $l=9.5e-09 $layer=Gate_1 $thickness=5.56522e-08
+ $X=1.917 $Y=0.136 $X2=1.9265 $Y2=0.136
r50 26 30 6.27904 $w=2.09e-08 $layer=Gate_1 $thickness=5.24e-08 $X=1.917
+ $Y=0.136 $X2=1.917 $Y2=0.136
r51 25 26 11.4116 $w=2.06667e-08 $l=3.3e-08 $layer=Gate_1 $thickness=5.6e-08
+ $X=1.917 $Y=0.103 $X2=1.917 $Y2=0.136
r52 24 25 16.6668 $w=2.1e-08 $l=4.9e-08 $layer=Gate_1 $thickness=5.6e-08
+ $X=1.917 $Y=0.054 $X2=1.917 $Y2=0.103
r53 24 12 10.0341 $w=2.1e-08 $l=2.95e-08 $layer=Gate_1 $thickness=5.6e-08
+ $X=1.917 $Y=0.054 $X2=1.917 $Y2=0.0245
.ends

.subckt PM_ICGx4DC_ASAP7_75t_R%16 vss 19 23 33 36 46 47 50 51 10 17 1 15 9 18 3
+ 11 14
c1 1 vss 0.00696938f $X=2.133 $Y=0.135
c2 3 vss 0.00829109f $X=2.052 $Y=0.0675
c3 4 vss 0.00831719f $X=2.16 $Y=0.0675
c4 9 vss 0.0823531f $X=2.133 $Y=0.0245
c5 10 vss 0.0849514f $X=2.187 $Y=0.135
c6 11 vss 0.00929295f $X=2.0375 $Y=0.0675
c7 12 vss 0.00898583f $X=2.1455 $Y=0.0675
c8 13 vss 0.000644736f $X=2.133 $Y=0.099
c9 14 vss 0.000577089f $X=2.133 $Y=0.135
c10 15 vss 0.00279987f $X=2.106 $Y=0.099
c11 16 vss 0.000172259f $X=2.133 $Y=0.117
c12 17 vss 0.00136562f $X=2.1465 $Y=0.099
c13 18 vss 0.0020599f $X=2.1465 $Y=0.135
r1 51 49 0.0308642 $w=8.1e-08 $l=2.5e-09 $layer=N_src_drn $thickness=1e-09
+ $X=2.1773 $Y=0.0675 $X2=2.1745 $Y2=0.0675
r2 4 49 0.179012 $w=8.1e-08 $l=1.45e-08 $layer=N_src_drn $thickness=1e-09
+ $X=2.16 $Y=0.0675 $X2=2.1745 $Y2=0.0675
r3 12 4 0.179012 $w=8.1e-08 $l=1.45e-08 $layer=N_src_drn $thickness=1e-09
+ $X=2.1455 $Y=0.0675 $X2=2.16 $Y2=0.0675
r4 50 12 0.0308642 $w=8.1e-08 $l=2.5e-09 $layer=N_src_drn $thickness=1e-09
+ $X=2.1426 $Y=0.0675 $X2=2.1455 $Y2=0.0675
r5 47 45 0.0308642 $w=8.1e-08 $l=2.5e-09 $layer=N_src_drn $thickness=1e-09
+ $X=2.0693 $Y=0.0675 $X2=2.0665 $Y2=0.0675
r6 3 45 0.179012 $w=8.1e-08 $l=1.45e-08 $layer=N_src_drn $thickness=1e-09
+ $X=2.052 $Y=0.0675 $X2=2.0665 $Y2=0.0675
r7 11 3 0.179012 $w=8.1e-08 $l=1.45e-08 $layer=N_src_drn $thickness=1e-09
+ $X=2.0375 $Y=0.0675 $X2=2.052 $Y2=0.0675
r8 46 11 0.0308642 $w=8.1e-08 $l=2.5e-09 $layer=N_src_drn $thickness=1e-09
+ $X=2.0346 $Y=0.0675 $X2=2.0375 $Y2=0.0675
r9 4 41 19.3796 $a=3.24e-16 $layer=V0LISD $X=2.16 $Y=0.0675 $X2=2.16 $Y2=0.099
r10 3 39 19.3796 $a=3.24e-16 $layer=V0LISD $X=2.052 $Y=0.0675 $X2=2.052
+ $Y2=0.099
r11 17 41 3.14806 $w=1.3e-08 $l=1.35e-08 $layer=M1 $thickness=3.6e-08 $X=2.1465
+ $Y=0.099 $X2=2.16 $Y2=0.099
r12 39 40 5.24677 $w=1.3e-08 $l=2.25e-08 $layer=M1 $thickness=3.6e-08 $X=2.052
+ $Y=0.099 $X2=2.0745 $Y2=0.099
r13 15 40 7.34548 $w=1.3e-08 $l=3.15e-08 $layer=M1 $thickness=3.6e-08 $X=2.106
+ $Y=0.099 $X2=2.0745 $Y2=0.099
r14 13 16 3.01711 $w=1.55e-08 $l=1.8e-08 $layer=M1 $thickness=3.6e-08 $X=2.133
+ $Y=0.099 $X2=2.133 $Y2=0.117
r15 13 15 5.11582 $w=1.46667e-08 $l=2.7e-08 $layer=M1 $thickness=3.6e-08
+ $X=2.133 $Y=0.099 $X2=2.106 $Y2=0.099
r16 13 17 1.96775 $w=1.63333e-08 $l=1.35e-08 $layer=M1 $thickness=3.6e-08
+ $X=2.133 $Y=0.099 $X2=2.1465 $Y2=0.099
r17 14 18 1.49895 $w=1.63333e-08 $l=1.35e-08 $layer=M1 $thickness=3.6e-08
+ $X=2.133 $Y=0.135 $X2=2.1465 $Y2=0.135
r18 14 16 2.5483 $w=1.79e-08 $l=1.8e-08 $layer=M1 $thickness=3.6e-08 $X=2.133
+ $Y=0.135 $X2=2.133 $Y2=0.117
r19 36 35 16.4967 $w=2.1e-08 $l=4.85e-08 $layer=Gate_1 $thickness=5.6e-08
+ $X=2.187 $Y=0.2025 $X2=2.187 $Y2=0.154
r20 33 34 16.4967 $w=2.1e-08 $l=4.85e-08 $layer=Gate_1 $thickness=5.6e-08
+ $X=2.187 $Y=0.0675 $X2=2.187 $Y2=0.116
r21 10 27 6.54019 $w=2.09524e-08 $layer=Gate_1 $thickness=5.21905e-08 $X=2.187
+ $Y=0.135 $X2=2.187 $Y2=0.135
r22 10 34 6.6497 $w=2.04211e-08 $l=1.9e-08 $layer=Gate_1 $thickness=5.6e-08
+ $X=2.187 $Y=0.135 $X2=2.187 $Y2=0.116
r23 10 35 6.6497 $w=2.04211e-08 $l=1.9e-08 $layer=Gate_1 $thickness=5.6e-08
+ $X=2.187 $Y=0.135 $X2=2.187 $Y2=0.154
r24 18 29 3.14806 $w=1.3e-08 $l=1.35e-08 $layer=M1 $thickness=3.6e-08 $X=2.1465
+ $Y=0.135 $X2=2.16 $Y2=0.135
r25 26 27 12.6539 $w=1.77815e-08 $l=2.7e-08 $layer=LIG $thickness=4.8e-08
+ $X=2.16 $Y=0.135 $X2=2.187 $Y2=0.135
r26 26 29 19.3796 $a=3.24e-16 $layer=V0LIG $X=2.16 $Y=0.135 $X2=2.16 $Y2=0.135
r27 1 21 6.54019 $w=2.09524e-08 $layer=Gate_1 $thickness=5.21905e-08 $X=2.133
+ $Y=0.135 $X2=2.133 $Y2=0.135
r28 1 26 12.6539 $w=1.77815e-08 $l=2.7e-08 $layer=LIG $thickness=4.8e-08
+ $X=2.133 $Y=0.135 $X2=2.16 $Y2=0.135
r29 23 22 16.4967 $w=2.1e-08 $l=4.85e-08 $layer=Gate_1 $thickness=5.6e-08
+ $X=2.133 $Y=0.2025 $X2=2.133 $Y2=0.154
r30 21 22 6.6497 $w=2.04211e-08 $l=1.9e-08 $layer=Gate_1 $thickness=5.6e-08
+ $X=2.133 $Y=0.135 $X2=2.133 $Y2=0.154
r31 20 21 6.6497 $w=2.04211e-08 $l=1.9e-08 $layer=Gate_1 $thickness=5.6e-08
+ $X=2.133 $Y=0.116 $X2=2.133 $Y2=0.135
r32 19 20 16.4967 $w=2.1e-08 $l=4.85e-08 $layer=Gate_1 $thickness=5.6e-08
+ $X=2.133 $Y=0.0675 $X2=2.133 $Y2=0.116
r33 19 9 14.6259 $w=2.1e-08 $l=4.3e-08 $layer=Gate_1 $thickness=5.6e-08
+ $X=2.133 $Y=0.0675 $X2=2.133 $Y2=0.0245
.ends

.subckt PM_ICGx4DC_ASAP7_75t_R%17 vss 24 28 43 47 60 61 70 71 74 75 12 16 3 5
+ 15 17 4 21 1 23 14 20 19 18 13
c1 1 vss 0.00660721f $X=2.4475 $Y=0.136
c2 3 vss 0.00788907f $X=2.268 $Y=0.216
c3 4 vss 0.00486644f $X=2.322 $Y=0.0675
c4 5 vss 0.00704455f $X=2.376 $Y=0.216
c5 12 vss 0.0720994f $X=2.457 $Y=0.0245
c6 13 vss 0.0515528f $X=2.511 $Y=0.136
c7 14 vss 0.00277293f $X=2.3075 $Y=0.0675
c8 15 vss 0.00387585f $X=2.2535 $Y=0.216
c9 16 vss 0.00369178f $X=2.3615 $Y=0.216
c10 17 vss 0.0030103f $X=2.403 $Y=0.1885
c11 18 vss 0.000511139f $X=2.457 $Y=0.072
c12 19 vss 0.000631018f $X=2.457 $Y=0.197
c13 20 vss 0.0115103f $X=2.3585 $Y=0.231
c14 21 vss 0.00460183f $X=2.4465 $Y=0.072
c15 22 vss 0.0013188f $X=2.43 $Y=0.197
c16 23 vss 0.0014883f $X=2.457 $Y=0.113
r1 75 73 0.0462963 $w=5.4e-08 $l=2.5e-09 $layer=P_src_drn $thickness=1e-09
+ $X=2.2853 $Y=0.216 $X2=2.2825 $Y2=0.216
r2 3 73 0.268519 $w=5.4e-08 $l=1.45e-08 $layer=P_src_drn $thickness=1e-09
+ $X=2.268 $Y=0.216 $X2=2.2825 $Y2=0.216
r3 15 3 0.268519 $w=5.4e-08 $l=1.45e-08 $layer=P_src_drn $thickness=1e-09
+ $X=2.2535 $Y=0.216 $X2=2.268 $Y2=0.216
r4 74 15 0.0462963 $w=5.4e-08 $l=2.5e-09 $layer=P_src_drn $thickness=1e-09
+ $X=2.2506 $Y=0.216 $X2=2.2535 $Y2=0.216
r5 71 69 0.0462963 $w=5.4e-08 $l=2.5e-09 $layer=P_src_drn $thickness=1e-09
+ $X=2.3933 $Y=0.216 $X2=2.3905 $Y2=0.216
r6 5 69 0.268519 $w=5.4e-08 $l=1.45e-08 $layer=P_src_drn $thickness=1e-09
+ $X=2.376 $Y=0.216 $X2=2.3905 $Y2=0.216
r7 16 5 0.268519 $w=5.4e-08 $l=1.45e-08 $layer=P_src_drn $thickness=1e-09
+ $X=2.3615 $Y=0.216 $X2=2.376 $Y2=0.216
r8 70 16 0.0462963 $w=5.4e-08 $l=2.5e-09 $layer=P_src_drn $thickness=1e-09
+ $X=2.3586 $Y=0.216 $X2=2.3615 $Y2=0.216
r9 3 66 19.3796 $a=3.24e-16 $layer=V0LISD $X=2.268 $Y=0.216 $X2=2.268 $Y2=0.231
r10 5 62 19.3796 $a=3.24e-16 $layer=V0LISD $X=2.376 $Y=0.216 $X2=2.376 $Y2=0.231
r11 66 67 2.56509 $w=1.3e-08 $l=1.1e-08 $layer=M1 $thickness=3.6e-08 $X=2.268
+ $Y=0.231 $X2=2.279 $Y2=0.231
r12 64 67 8.51143 $w=1.3e-08 $l=3.65e-08 $layer=M1 $thickness=3.6e-08 $X=2.3155
+ $Y=0.231 $X2=2.279 $Y2=0.231
r13 62 63 3.14806 $w=1.3e-08 $l=1.35e-08 $layer=M1 $thickness=3.6e-08 $X=2.376
+ $Y=0.231 $X2=2.3895 $Y2=0.231
r14 20 62 4.08082 $w=1.3e-08 $l=1.75e-08 $layer=M1 $thickness=3.6e-08 $X=2.3585
+ $Y=0.231 $X2=2.376 $Y2=0.231
r15 20 64 10.0272 $w=1.3e-08 $l=4.3e-08 $layer=M1 $thickness=3.6e-08 $X=2.3585
+ $Y=0.231 $X2=2.3155 $Y2=0.231
r16 61 59 0.0308642 $w=8.1e-08 $l=2.5e-09 $layer=N_src_drn $thickness=1e-09
+ $X=2.3393 $Y=0.0675 $X2=2.3365 $Y2=0.0675
r17 4 59 0.179012 $w=8.1e-08 $l=1.45e-08 $layer=N_src_drn $thickness=1e-09
+ $X=2.322 $Y=0.0675 $X2=2.3365 $Y2=0.0675
r18 14 4 0.179012 $w=8.1e-08 $l=1.45e-08 $layer=N_src_drn $thickness=1e-09
+ $X=2.3075 $Y=0.0675 $X2=2.322 $Y2=0.0675
r19 60 14 0.0308642 $w=8.1e-08 $l=2.5e-09 $layer=N_src_drn $thickness=1e-09
+ $X=2.3046 $Y=0.0675 $X2=2.3075 $Y2=0.0675
r20 56 63 1.20242 $w=1.425e-08 $l=1.54434e-08 $layer=M1 $thickness=3.6e-08
+ $X=2.403 $Y=0.2235 $X2=2.3895 $Y2=0.231
r21 55 56 2.01858 $w=1.37895e-08 $l=9.5e-09 $layer=M1 $thickness=3.6e-08
+ $X=2.403 $Y=0.214 $X2=2.403 $Y2=0.2235
r22 54 55 2.7329 $w=1.55758e-08 $l=1.65e-08 $layer=M1 $thickness=3.6e-08
+ $X=2.403 $Y=0.1975 $X2=2.403 $Y2=0.214
r23 17 22 4.24844 $w=1.31351e-08 $l=2.83064e-08 $layer=M1 $thickness=3.6e-08
+ $X=2.403 $Y=0.1885 $X2=2.43 $Y2=0.197
r24 17 54 0.9184 $w=1.8e-08 $l=9e-09 $layer=M1 $thickness=3.6e-08 $X=2.403
+ $Y=0.1885 $X2=2.403 $Y2=0.1975
r25 4 52 19.3796 $a=3.24e-16 $layer=V0LISD $X=2.322 $Y=0.0675 $X2=2.322
+ $Y2=0.072
r26 52 53 9.44419 $w=1.3e-08 $l=4.05e-08 $layer=M1 $thickness=3.6e-08 $X=2.322
+ $Y=0.072 $X2=2.3625 $Y2=0.072
r27 50 53 9.44419 $w=1.3e-08 $l=4.05e-08 $layer=M1 $thickness=3.6e-08 $X=2.403
+ $Y=0.072 $X2=2.3625 $Y2=0.072
r28 49 50 5.94634 $w=1.3e-08 $l=2.55e-08 $layer=M1 $thickness=3.6e-08 $X=2.4285
+ $Y=0.072 $X2=2.403 $Y2=0.072
r29 21 49 4.19742 $w=1.3e-08 $l=1.8e-08 $layer=M1 $thickness=3.6e-08 $X=2.4465
+ $Y=0.072 $X2=2.4285 $Y2=0.072
r30 19 40 5.22999 $w=1.59898e-08 $l=2.95e-08 $layer=M1 $thickness=3.6e-08
+ $X=2.457 $Y=0.197 $X2=2.457 $Y2=0.1675
r31 19 22 4.64701 $w=1.46667e-08 $l=2.7e-08 $layer=M1 $thickness=3.6e-08
+ $X=2.457 $Y=0.197 $X2=2.43 $Y2=0.197
r32 18 39 1.49895 $w=1.95333e-08 $l=1.35e-08 $layer=M1 $thickness=3.6e-08
+ $X=2.457 $Y=0.072 $X2=2.457 $Y2=0.0855
r33 18 21 0.79938 $w=1.72857e-08 $l=1.05e-08 $layer=M1 $thickness=3.6e-08
+ $X=2.457 $Y=0.072 $X2=2.4465 $Y2=0.072
r34 47 46 14.6259 $w=2.1e-08 $l=4.3e-08 $layer=Gate_1 $thickness=5.6e-08
+ $X=2.511 $Y=0.2295 $X2=2.511 $Y2=0.1865
r35 45 46 11.7348 $w=2.1e-08 $l=3.45e-08 $layer=Gate_1 $thickness=5.6e-08
+ $X=2.511 $Y=0.152 $X2=2.511 $Y2=0.1865
r36 43 44 14.6259 $w=2.1e-08 $l=4.3e-08 $layer=Gate_1 $thickness=5.6e-08
+ $X=2.511 $Y=0.0405 $X2=2.511 $Y2=0.0835
r37 41 44 12.0749 $w=2.1e-08 $l=3.55e-08 $layer=Gate_1 $thickness=5.6e-08
+ $X=2.511 $Y=0.119 $X2=2.511 $Y2=0.0835
r38 13 34 6.54019 $w=2.09524e-08 $layer=Gate_1 $thickness=5.21905e-08 $X=2.511
+ $Y=0.136 $X2=2.511 $Y2=0.136
r39 13 41 5.96942 $w=2.03529e-08 $l=1.7e-08 $layer=Gate_1 $thickness=5.6e-08
+ $X=2.511 $Y=0.136 $X2=2.511 $Y2=0.119
r40 13 45 5.62929 $w=2.03125e-08 $l=1.6e-08 $layer=Gate_1 $thickness=5.6e-08
+ $X=2.511 $Y=0.136 $X2=2.511 $Y2=0.152
r41 38 39 2.09871 $w=1.3e-08 $l=9e-09 $layer=M1 $thickness=3.6e-08 $X=2.457
+ $Y=0.0945 $X2=2.457 $Y2=0.0855
r42 37 40 5.01358 $w=1.3e-08 $l=2.15e-08 $layer=M1 $thickness=3.6e-08 $X=2.457
+ $Y=0.146 $X2=2.457 $Y2=0.1675
r43 36 37 2.3319 $w=1.3e-08 $l=1e-08 $layer=M1 $thickness=3.6e-08 $X=2.457
+ $Y=0.136 $X2=2.457 $Y2=0.146
r44 23 36 5.36336 $w=1.3e-08 $l=2.3e-08 $layer=M1 $thickness=3.6e-08 $X=2.457
+ $Y=0.113 $X2=2.457 $Y2=0.136
r45 23 38 4.31401 $w=1.3e-08 $l=1.85e-08 $layer=M1 $thickness=3.6e-08 $X=2.457
+ $Y=0.113 $X2=2.457 $Y2=0.0945
r46 33 34 12.6539 $w=1.77815e-08 $l=2.7e-08 $layer=LIG $thickness=4.8e-08
+ $X=2.484 $Y=0.136 $X2=2.511 $Y2=0.136
r47 31 33 10.1729 $w=1.54914e-08 $l=1.75e-08 $layer=LIG $thickness=4.8e-08
+ $X=2.4665 $Y=0.136 $X2=2.484 $Y2=0.136
r48 30 31 2.48102 $w=2.2e-08 $l=9.5e-09 $layer=LIG $thickness=4.8e-08 $X=2.457
+ $Y=0.136 $X2=2.4665 $Y2=0.136
r49 30 36 19.3796 $a=3.24e-16 $layer=V0LIG $X=2.457 $Y=0.136 $X2=2.457 $Y2=0.136
r50 1 30 2.48102 $w=2.2e-08 $l=9.5e-09 $layer=LIG $thickness=4.8e-08 $X=2.4475
+ $Y=0.136 $X2=2.457 $Y2=0.136
r51 28 27 16.3266 $w=2.1e-08 $l=4.8e-08 $layer=Gate_1 $thickness=5.6e-08
+ $X=2.457 $Y=0.2295 $X2=2.457 $Y2=0.1815
r52 26 27 15.6634 $w=2.07582e-08 $l=4.55e-08 $layer=Gate_1 $thickness=5.6e-08
+ $X=2.457 $Y=0.136 $X2=2.457 $Y2=0.1815
r53 26 31 4.05918 $w=2.0087e-08 $l=9.5e-09 $layer=Gate_1 $thickness=5.56522e-08
+ $X=2.457 $Y=0.136 $X2=2.4665 $Y2=0.136
r54 26 30 6.27904 $w=2.09e-08 $layer=Gate_1 $thickness=5.24e-08 $X=2.457
+ $Y=0.136 $X2=2.457 $Y2=0.136
r55 25 26 16.0035 $w=2.07634e-08 $l=4.65e-08 $layer=Gate_1 $thickness=5.6e-08
+ $X=2.457 $Y=0.0895 $X2=2.457 $Y2=0.136
r56 24 25 16.6668 $w=2.1e-08 $l=4.9e-08 $layer=Gate_1 $thickness=5.6e-08
+ $X=2.457 $Y=0.0405 $X2=2.457 $Y2=0.0895
r57 24 12 5.44221 $w=2.1e-08 $l=1.6e-08 $layer=Gate_1 $thickness=5.6e-08
+ $X=2.457 $Y=0.0405 $X2=2.457 $Y2=0.0245
.ends

.subckt PM_ICGx4DC_ASAP7_75t_R%GCLK vss 71 90 99 113 62 63 125 126 135 136 144
+ 145 148 149 153 154 158 159 162 163 29 33 34 43 53 1 25 2 42 41 54 5 7 3 55
+ 35 37 49 44 51 36 38 46 48 30 4 26 45 31 6 27 47 32 39 40 28 8 50 52
c1 1 vss 0.00956138f $X=0.108 $Y=0.0405
c2 2 vss 0.00935774f $X=0.108 $Y=0.189
c3 3 vss 0.00897614f $X=0.648 $Y=0.054
c4 4 vss 0.00903033f $X=0.648 $Y=0.1755
c5 5 vss 0.00897614f $X=1.944 $Y=0.054
c6 6 vss 0.00903033f $X=1.944 $Y=0.1755
c7 7 vss 0.00944904f $X=2.484 $Y=0.0405
c8 8 vss 0.00935771f $X=2.484 $Y=0.189
c9 25 vss 0.00298598f $X=0.0935 $Y=0.0405
c10 26 vss 0.0036987f $X=0.6335 $Y=0.054
c11 27 vss 0.0036987f $X=1.9295 $Y=0.054
c12 28 vss 0.00297006f $X=2.4695 $Y=0.0405
c13 29 vss 0.00296929f $X=0.0935 $Y=0.2295
c14 30 vss 0.00369126f $X=0.6335 $Y=0.216
c15 31 vss 0.0036912f $X=1.9295 $Y=0.216
c16 32 vss 0.00296935f $X=2.4695 $Y=0.2295
c17 33 vss 0.00374716f $X=0.081 $Y=0.0315
c18 34 vss 0.00317634f $X=0.081 $Y=0.234
c19 35 vss 0.00355692f $X=0.621 $Y=0.0315
c20 36 vss 0.00323486f $X=0.621 $Y=0.234
c21 37 vss 0.00355692f $X=1.971 $Y=0.0315
c22 38 vss 0.00323486f $X=1.971 $Y=0.234
c23 39 vss 0.00373359f $X=2.511 $Y=0.0315
c24 40 vss 0.00317634f $X=2.511 $Y=0.234
c25 41 vss 0.00690528f $X=0.081 $Y=0.0495
c26 42 vss 0.00515529f $X=0.0945 $Y=0.036
c27 43 vss 0.00370311f $X=0.108 $Y=0.234
c28 44 vss 0.00710913f $X=0.621 $Y=0.0495
c29 45 vss 0.00515529f $X=0.6345 $Y=0.036
c30 46 vss 0.00363729f $X=0.648 $Y=0.234
c31 47 vss 0.00515529f $X=1.9305 $Y=0.036
c32 48 vss 0.00363729f $X=1.944 $Y=0.234
c33 49 vss 0.0073166f $X=1.971 $Y=0.0495
c34 50 vss 0.00515529f $X=2.4705 $Y=0.036
c35 51 vss 0.00370068f $X=2.484 $Y=0.234
c36 52 vss 0.00690522f $X=2.511 $Y=0.0495
c37 53 vss 0.0219701f $X=0.0665 $Y=0.045
c38 54 vss 0.0216537f $X=1.8347 $Y=0.045
c39 55 vss 0.0284167f $X=0.9331 $Y=0.045
r1 163 161 0.0925926 $w=2.7e-08 $l=2.5e-09 $layer=P_src_drn $thickness=1e-09
+ $X=2.5013 $Y=0.2295 $X2=2.4985 $Y2=0.2295
r2 155 161 0.537037 $w=2.7e-08 $l=1.45e-08 $layer=P_src_drn $thickness=1e-09
+ $X=2.484 $Y=0.2295 $X2=2.4985 $Y2=0.2295
r3 32 155 0.537037 $w=2.7e-08 $l=1.45e-08 $layer=P_src_drn $thickness=1e-09
+ $X=2.4695 $Y=0.2295 $X2=2.484 $Y2=0.2295
r4 162 32 0.0925926 $w=2.7e-08 $l=2.5e-09 $layer=P_src_drn $thickness=1e-09
+ $X=2.4666 $Y=0.2295 $X2=2.4695 $Y2=0.2295
r5 159 157 0.0462963 $w=5.4e-08 $l=2.5e-09 $layer=P_src_drn $thickness=1e-09
+ $X=1.9613 $Y=0.216 $X2=1.9585 $Y2=0.216
r6 150 157 0.268519 $w=5.4e-08 $l=1.45e-08 $layer=P_src_drn $thickness=1e-09
+ $X=1.944 $Y=0.216 $X2=1.9585 $Y2=0.216
r7 31 150 0.268519 $w=5.4e-08 $l=1.45e-08 $layer=P_src_drn $thickness=1e-09
+ $X=1.9295 $Y=0.216 $X2=1.944 $Y2=0.216
r8 158 31 0.0462963 $w=5.4e-08 $l=2.5e-09 $layer=P_src_drn $thickness=1e-09
+ $X=1.9266 $Y=0.216 $X2=1.9295 $Y2=0.216
r9 8 155 23.8708 $w=2.02e-08 $l=4.05e-08 $layer=LISD $thickness=2.7e-08
+ $X=2.484 $Y=0.189 $X2=2.484 $Y2=0.2295
r10 154 152 0.0925926 $w=2.7e-08 $l=2.5e-09 $layer=N_src_drn $thickness=1e-09
+ $X=2.5013 $Y=0.0405 $X2=2.4985 $Y2=0.0405
r11 7 152 0.537037 $w=2.7e-08 $l=1.45e-08 $layer=N_src_drn $thickness=1e-09
+ $X=2.484 $Y=0.0405 $X2=2.4985 $Y2=0.0405
r12 28 7 0.537037 $w=2.7e-08 $l=1.45e-08 $layer=N_src_drn $thickness=1e-09
+ $X=2.4695 $Y=0.0405 $X2=2.484 $Y2=0.0405
r13 153 28 0.0925926 $w=2.7e-08 $l=2.5e-09 $layer=N_src_drn $thickness=1e-09
+ $X=2.4666 $Y=0.0405 $X2=2.4695 $Y2=0.0405
r14 6 150 23.8708 $w=2.02e-08 $l=4.05e-08 $layer=LISD $thickness=2.7e-08
+ $X=1.944 $Y=0.1755 $X2=1.944 $Y2=0.216
r15 149 147 0.0462963 $w=5.4e-08 $l=2.5e-09 $layer=N_src_drn $thickness=1e-09
+ $X=1.9613 $Y=0.054 $X2=1.9585 $Y2=0.054
r16 5 147 0.268519 $w=5.4e-08 $l=1.45e-08 $layer=N_src_drn $thickness=1e-09
+ $X=1.944 $Y=0.054 $X2=1.9585 $Y2=0.054
r17 27 5 0.268519 $w=5.4e-08 $l=1.45e-08 $layer=N_src_drn $thickness=1e-09
+ $X=1.9295 $Y=0.054 $X2=1.944 $Y2=0.054
r18 148 27 0.0462963 $w=5.4e-08 $l=2.5e-09 $layer=N_src_drn $thickness=1e-09
+ $X=1.9266 $Y=0.054 $X2=1.9295 $Y2=0.054
r19 145 143 0.0462963 $w=5.4e-08 $l=2.5e-09 $layer=P_src_drn $thickness=1e-09
+ $X=0.6653 $Y=0.216 $X2=0.6625 $Y2=0.216
r20 137 143 0.268519 $w=5.4e-08 $l=1.45e-08 $layer=P_src_drn $thickness=1e-09
+ $X=0.648 $Y=0.216 $X2=0.6625 $Y2=0.216
r21 30 137 0.268519 $w=5.4e-08 $l=1.45e-08 $layer=P_src_drn $thickness=1e-09
+ $X=0.6335 $Y=0.216 $X2=0.648 $Y2=0.216
r22 144 30 0.0462963 $w=5.4e-08 $l=2.5e-09 $layer=P_src_drn $thickness=1e-09
+ $X=0.6306 $Y=0.216 $X2=0.6335 $Y2=0.216
r23 51 155 19.3796 $a=3.24e-16 $layer=V0LISD $X=2.484 $Y=0.234 $X2=2.484
+ $Y2=0.2295
r24 7 130 19.3796 $a=3.24e-16 $layer=V0LISD $X=2.484 $Y=0.0405 $X2=2.484
+ $Y2=0.036
r25 48 150 19.3796 $a=3.24e-16 $layer=V0LISD $X=1.944 $Y=0.234 $X2=1.944
+ $Y2=0.216
r26 5 127 19.3796 $a=3.24e-16 $layer=V0LISD $X=1.944 $Y=0.054 $X2=1.944
+ $Y2=0.036
r27 4 137 23.8708 $w=2.02e-08 $l=4.05e-08 $layer=LISD $thickness=2.7e-08
+ $X=0.648 $Y=0.1755 $X2=0.648 $Y2=0.216
r28 136 134 0.0462963 $w=5.4e-08 $l=2.5e-09 $layer=N_src_drn $thickness=1e-09
+ $X=0.6653 $Y=0.054 $X2=0.6625 $Y2=0.054
r29 3 134 0.268519 $w=5.4e-08 $l=1.45e-08 $layer=N_src_drn $thickness=1e-09
+ $X=0.648 $Y=0.054 $X2=0.6625 $Y2=0.054
r30 26 3 0.268519 $w=5.4e-08 $l=1.45e-08 $layer=N_src_drn $thickness=1e-09
+ $X=0.6335 $Y=0.054 $X2=0.648 $Y2=0.054
r31 135 26 0.0462963 $w=5.4e-08 $l=2.5e-09 $layer=N_src_drn $thickness=1e-09
+ $X=0.6306 $Y=0.054 $X2=0.6335 $Y2=0.054
r32 40 120 2.6649 $w=1.77676e-08 $l=1.85e-08 $layer=M1 $thickness=3.6e-08
+ $X=2.511 $Y=0.234 $X2=2.511 $Y2=0.2155
r33 40 51 4.64701 $w=1.46667e-08 $l=2.7e-08 $layer=M1 $thickness=3.6e-08
+ $X=2.511 $Y=0.234 $X2=2.484 $Y2=0.234
r34 130 131 3.14806 $w=1.3e-08 $l=1.35e-08 $layer=M1 $thickness=3.6e-08
+ $X=2.484 $Y=0.036 $X2=2.4975 $Y2=0.036
r35 50 130 3.14806 $w=1.3e-08 $l=1.35e-08 $layer=M1 $thickness=3.6e-08
+ $X=2.4705 $Y=0.036 $X2=2.484 $Y2=0.036
r36 38 116 2.6649 $w=1.77676e-08 $l=1.85e-08 $layer=M1 $thickness=3.6e-08
+ $X=1.971 $Y=0.234 $X2=1.971 $Y2=0.2155
r37 38 48 4.64701 $w=1.46667e-08 $l=2.7e-08 $layer=M1 $thickness=3.6e-08
+ $X=1.971 $Y=0.234 $X2=1.944 $Y2=0.234
r38 127 128 3.14806 $w=1.3e-08 $l=1.35e-08 $layer=M1 $thickness=3.6e-08
+ $X=1.944 $Y=0.036 $X2=1.9575 $Y2=0.036
r39 47 127 3.14806 $w=1.3e-08 $l=1.35e-08 $layer=M1 $thickness=3.6e-08
+ $X=1.9305 $Y=0.036 $X2=1.944 $Y2=0.036
r40 126 124 0.0925926 $w=2.7e-08 $l=2.5e-09 $layer=P_src_drn $thickness=1e-09
+ $X=0.1253 $Y=0.2295 $X2=0.1225 $Y2=0.2295
r41 104 124 0.537037 $w=2.7e-08 $l=1.45e-08 $layer=P_src_drn $thickness=1e-09
+ $X=0.108 $Y=0.2295 $X2=0.1225 $Y2=0.2295
r42 29 104 0.537037 $w=2.7e-08 $l=1.45e-08 $layer=P_src_drn $thickness=1e-09
+ $X=0.0935 $Y=0.2295 $X2=0.108 $Y2=0.2295
r43 125 29 0.0925926 $w=2.7e-08 $l=2.5e-09 $layer=P_src_drn $thickness=1e-09
+ $X=0.0906 $Y=0.2295 $X2=0.0935 $Y2=0.2295
r44 46 137 19.3796 $a=3.24e-16 $layer=V0LISD $X=0.648 $Y=0.234 $X2=0.648
+ $Y2=0.216
r45 3 101 19.3796 $a=3.24e-16 $layer=V0LISD $X=0.648 $Y=0.054 $X2=0.648
+ $Y2=0.036
r46 119 120 18.8884 $w=1.3e-08 $l=8.1e-08 $layer=M1 $thickness=3.6e-08 $X=2.511
+ $Y=0.1345 $X2=2.511 $Y2=0.2155
r47 118 119 17.7224 $w=1.3e-08 $l=7.6e-08 $layer=M1 $thickness=3.6e-08 $X=2.511
+ $Y=0.0585 $X2=2.511 $Y2=0.1345
r48 52 118 2.09871 $w=1.3e-08 $l=9e-09 $layer=M1 $thickness=3.6e-08 $X=2.511
+ $Y=0.0495 $X2=2.511 $Y2=0.0585
r49 52 117 1.50855 $w=1.55e-08 $l=9e-09 $layer=M1 $thickness=3.6e-08 $X=2.511
+ $Y=0.0495 $X2=2.511 $Y2=0.0405
r50 99 52 39.0693 $a=1.62e-16 $layer=V1 $X=2.511 $Y=0.047 $X2=2.511 $Y2=0.0495
r51 117 131 1.50855 $w=1.03333e-08 $l=1.42302e-08 $layer=M1 $thickness=3.6e-08
+ $X=2.511 $Y=0.0405 $X2=2.4975 $Y2=0.036
r52 39 117 0.9184 $w=1.8e-08 $l=9e-09 $layer=M1 $thickness=3.6e-08 $X=2.511
+ $Y=0.0315 $X2=2.511 $Y2=0.0405
r53 115 116 5.24677 $w=1.3e-08 $l=2.25e-08 $layer=M1 $thickness=3.6e-08
+ $X=1.971 $Y=0.193 $X2=1.971 $Y2=0.2155
r54 114 115 4.6055 $w=1.3e-08 $l=1.98e-08 $layer=M1 $thickness=3.6e-08 $X=1.971
+ $Y=0.1732 $X2=1.971 $Y2=0.193
r55 113 114 1.69063 $w=1.3e-08 $l=7.2e-09 $layer=M1 $thickness=3.6e-08 $X=1.971
+ $Y=0.166 $X2=1.971 $Y2=0.1732
r56 113 112 0.524677 $w=1.3e-08 $l=2.3e-09 $layer=M1 $thickness=3.6e-08
+ $X=1.971 $Y=0.166 $X2=1.971 $Y2=0.1637
r57 111 112 2.50679 $w=1.3e-08 $l=1.07e-08 $layer=M1 $thickness=3.6e-08
+ $X=1.971 $Y=0.153 $X2=1.971 $Y2=0.1637
r58 110 111 4.19742 $w=1.3e-08 $l=1.8e-08 $layer=M1 $thickness=3.6e-08 $X=1.971
+ $Y=0.135 $X2=1.971 $Y2=0.153
r59 109 110 4.19742 $w=1.3e-08 $l=1.8e-08 $layer=M1 $thickness=3.6e-08 $X=1.971
+ $Y=0.117 $X2=1.971 $Y2=0.135
r60 108 109 4.19742 $w=1.3e-08 $l=1.8e-08 $layer=M1 $thickness=3.6e-08 $X=1.971
+ $Y=0.099 $X2=1.971 $Y2=0.117
r61 107 108 5.24677 $w=1.3e-08 $l=2.25e-08 $layer=M1 $thickness=3.6e-08
+ $X=1.971 $Y=0.0765 $X2=1.971 $Y2=0.099
r62 106 107 4.19742 $w=1.3e-08 $l=1.8e-08 $layer=M1 $thickness=3.6e-08 $X=1.971
+ $Y=0.0585 $X2=1.971 $Y2=0.0765
r63 49 106 2.09871 $w=1.3e-08 $l=9e-09 $layer=M1 $thickness=3.6e-08 $X=1.971
+ $Y=0.0495 $X2=1.971 $Y2=0.0585
r64 49 105 1.50855 $w=1.55e-08 $l=9e-09 $layer=M1 $thickness=3.6e-08 $X=1.971
+ $Y=0.0495 $X2=1.971 $Y2=0.0405
r65 49 95 39.0693 $a=1.62e-16 $layer=V1 $X=1.971 $Y=0.0495 $X2=1.971 $Y2=0.045
r66 105 128 1.50855 $w=1.03333e-08 $l=1.42302e-08 $layer=M1 $thickness=3.6e-08
+ $X=1.971 $Y=0.0405 $X2=1.9575 $Y2=0.036
r67 37 105 0.9184 $w=1.8e-08 $l=9e-09 $layer=M1 $thickness=3.6e-08 $X=1.971
+ $Y=0.0315 $X2=1.971 $Y2=0.0405
r68 2 104 23.8708 $w=2.02e-08 $l=4.05e-08 $layer=LISD $thickness=2.7e-08
+ $X=0.108 $Y=0.189 $X2=0.108 $Y2=0.2295
r69 36 93 2.6649 $w=1.77676e-08 $l=1.85e-08 $layer=M1 $thickness=3.6e-08
+ $X=0.621 $Y=0.234 $X2=0.621 $Y2=0.2155
r70 36 46 4.64701 $w=1.46667e-08 $l=2.7e-08 $layer=M1 $thickness=3.6e-08
+ $X=0.621 $Y=0.234 $X2=0.648 $Y2=0.234
r71 45 101 3.14806 $w=1.3e-08 $l=1.35e-08 $layer=M1 $thickness=3.6e-08
+ $X=0.6345 $Y=0.036 $X2=0.648 $Y2=0.036
r72 45 82 1.50855 $w=1.03333e-08 $l=1.42302e-08 $layer=M1 $thickness=3.6e-08
+ $X=0.6345 $Y=0.036 $X2=0.621 $Y2=0.0405
r73 99 117 39.0693 $a=1.62e-16 $layer=V1 $X=2.511 $Y=0.047 $X2=2.511 $Y2=0.0405
r74 99 98 18.8884 $w=1.3e-08 $l=8.1e-08 $layer=M2 $thickness=3.6e-08 $X=2.511
+ $Y=0.047 $X2=2.43 $Y2=0.045
r75 97 98 28.6823 $w=1.3e-08 $l=1.23e-07 $layer=M2 $thickness=3.6e-08 $X=2.307
+ $Y=0.045 $X2=2.43 $Y2=0.045
r76 96 97 44.0729 $w=1.3e-08 $l=1.89e-07 $layer=M2 $thickness=3.6e-08 $X=2.118
+ $Y=0.045 $X2=2.307 $Y2=0.045
r77 95 96 34.2789 $w=1.3e-08 $l=1.47e-07 $layer=M2 $thickness=3.6e-08 $X=1.971
+ $Y=0.045 $X2=2.118 $Y2=0.045
r78 95 105 39.0693 $a=1.62e-16 $layer=V1 $X=1.971 $Y=0.045 $X2=1.971 $Y2=0.0405
r79 54 95 31.7721 $w=1.3e-08 $l=1.363e-07 $layer=M2 $thickness=3.6e-08
+ $X=1.8347 $Y=0.045 $X2=1.971 $Y2=0.045
r80 54 81 84.5313 $w=1.3e-08 $l=3.625e-07 $layer=M2 $thickness=3.6e-08
+ $X=1.8347 $Y=0.045 $X2=1.4722 $Y2=0.045
r81 43 104 19.3796 $a=3.24e-16 $layer=V0LISD $X=0.108 $Y=0.234 $X2=0.108
+ $Y2=0.2295
r82 92 93 5.24677 $w=1.3e-08 $l=2.25e-08 $layer=M1 $thickness=3.6e-08 $X=0.621
+ $Y=0.193 $X2=0.621 $Y2=0.2155
r83 91 92 4.6055 $w=1.3e-08 $l=1.98e-08 $layer=M1 $thickness=3.6e-08 $X=0.621
+ $Y=0.1732 $X2=0.621 $Y2=0.193
r84 90 91 1.69063 $w=1.3e-08 $l=7.2e-09 $layer=M1 $thickness=3.6e-08 $X=0.621
+ $Y=0.166 $X2=0.621 $Y2=0.1732
r85 90 89 0.524677 $w=1.3e-08 $l=2.3e-09 $layer=M1 $thickness=3.6e-08 $X=0.621
+ $Y=0.166 $X2=0.621 $Y2=0.1637
r86 88 89 2.50679 $w=1.3e-08 $l=1.07e-08 $layer=M1 $thickness=3.6e-08 $X=0.621
+ $Y=0.153 $X2=0.621 $Y2=0.1637
r87 87 88 4.19742 $w=1.3e-08 $l=1.8e-08 $layer=M1 $thickness=3.6e-08 $X=0.621
+ $Y=0.135 $X2=0.621 $Y2=0.153
r88 86 87 4.19742 $w=1.3e-08 $l=1.8e-08 $layer=M1 $thickness=3.6e-08 $X=0.621
+ $Y=0.117 $X2=0.621 $Y2=0.135
r89 85 86 4.19742 $w=1.3e-08 $l=1.8e-08 $layer=M1 $thickness=3.6e-08 $X=0.621
+ $Y=0.099 $X2=0.621 $Y2=0.117
r90 84 85 5.24677 $w=1.3e-08 $l=2.25e-08 $layer=M1 $thickness=3.6e-08 $X=0.621
+ $Y=0.0765 $X2=0.621 $Y2=0.099
r91 83 84 4.19742 $w=1.3e-08 $l=1.8e-08 $layer=M1 $thickness=3.6e-08 $X=0.621
+ $Y=0.0585 $X2=0.621 $Y2=0.0765
r92 44 83 2.09871 $w=1.3e-08 $l=9e-09 $layer=M1 $thickness=3.6e-08 $X=0.621
+ $Y=0.0495 $X2=0.621 $Y2=0.0585
r93 44 82 1.50855 $w=1.55e-08 $l=9e-09 $layer=M1 $thickness=3.6e-08 $X=0.621
+ $Y=0.0495 $X2=0.621 $Y2=0.0405
r94 44 78 39.0693 $a=1.62e-16 $layer=V1 $X=0.621 $Y=0.0495 $X2=0.621 $Y2=0.045
r95 35 82 0.9184 $w=1.8e-08 $l=9e-09 $layer=M1 $thickness=3.6e-08 $X=0.621
+ $Y=0.0315 $X2=0.621 $Y2=0.0405
r96 80 81 84.5896 $w=1.3e-08 $l=3.627e-07 $layer=M2 $thickness=3.6e-08
+ $X=1.1095 $Y=0.045 $X2=1.4722 $Y2=0.045
r97 55 79 41.0414 $w=1.3e-08 $l=1.76e-07 $layer=M2 $thickness=3.6e-08 $X=0.9331
+ $Y=0.045 $X2=0.7571 $Y2=0.045
r98 55 80 41.1347 $w=1.3e-08 $l=1.764e-07 $layer=M2 $thickness=3.6e-08
+ $X=0.9331 $Y=0.045 $X2=1.1095 $Y2=0.045
r99 34 73 2.6649 $w=1.77676e-08 $l=1.85e-08 $layer=M1 $thickness=3.6e-08
+ $X=0.081 $Y=0.234 $X2=0.081 $Y2=0.2155
r100 34 43 4.64701 $w=1.46667e-08 $l=2.7e-08 $layer=M1 $thickness=3.6e-08
+ $X=0.081 $Y=0.234 $X2=0.108 $Y2=0.234
r101 78 79 31.7371 $w=1.3e-08 $l=1.361e-07 $layer=M2 $thickness=3.6e-08
+ $X=0.621 $Y=0.045 $X2=0.7571 $Y2=0.045
r102 78 82 39.0693 $a=1.62e-16 $layer=V1 $X=0.621 $Y=0.045 $X2=0.621 $Y2=0.0405
r103 77 78 34.2789 $w=1.3e-08 $l=1.47e-07 $layer=M2 $thickness=3.6e-08 $X=0.474
+ $Y=0.045 $X2=0.621 $Y2=0.045
r104 76 77 43.9563 $w=1.3e-08 $l=1.885e-07 $layer=M2 $thickness=3.6e-08
+ $X=0.2855 $Y=0.045 $X2=0.474 $Y2=0.045
r105 75 76 28.6823 $w=1.3e-08 $l=1.23e-07 $layer=M2 $thickness=3.6e-08
+ $X=0.1625 $Y=0.045 $X2=0.2855 $Y2=0.045
r106 74 75 19.005 $w=1.3e-08 $l=8.15e-08 $layer=M2 $thickness=3.6e-08 $X=0.081
+ $Y=0.045 $X2=0.1625 $Y2=0.045
r107 53 74 3.38125 $w=1.3e-08 $l=1.45e-08 $layer=M2 $thickness=3.6e-08
+ $X=0.0665 $Y=0.045 $X2=0.081 $Y2=0.045
r108 72 73 6.8208 $w=1.3e-08 $l=2.93e-08 $layer=M1 $thickness=3.6e-08 $X=0.081
+ $Y=0.1862 $X2=0.081 $Y2=0.2155
r109 71 72 4.72209 $w=1.3e-08 $l=2.02e-08 $layer=M1 $thickness=3.6e-08 $X=0.081
+ $Y=0.166 $X2=0.081 $Y2=0.1862
r110 71 70 12.0676 $w=1.3e-08 $l=5.18e-08 $layer=M1 $thickness=3.6e-08 $X=0.081
+ $Y=0.166 $X2=0.081 $Y2=0.1142
r111 69 70 13.0003 $w=1.3e-08 $l=5.57e-08 $layer=M1 $thickness=3.6e-08 $X=0.081
+ $Y=0.0585 $X2=0.081 $Y2=0.1142
r112 41 69 2.09871 $w=1.3e-08 $l=9e-09 $layer=M1 $thickness=3.6e-08 $X=0.081
+ $Y=0.0495 $X2=0.081 $Y2=0.0585
r113 41 68 1.50855 $w=1.55e-08 $l=9e-09 $layer=M1 $thickness=3.6e-08 $X=0.081
+ $Y=0.0495 $X2=0.081 $Y2=0.0405
r114 41 74 39.0693 $a=1.62e-16 $layer=V1 $X=0.081 $Y=0.0495 $X2=0.081 $Y2=0.045
r115 68 74 39.0693 $a=1.62e-16 $layer=V1 $X=0.081 $Y=0.0405 $X2=0.081 $Y2=0.045
r116 33 68 0.9184 $w=1.8e-08 $l=9e-09 $layer=M1 $thickness=3.6e-08 $X=0.081
+ $Y=0.0315 $X2=0.081 $Y2=0.0405
r117 42 65 3.14806 $w=1.3e-08 $l=1.35e-08 $layer=M1 $thickness=3.6e-08
+ $X=0.0945 $Y=0.036 $X2=0.108 $Y2=0.036
r118 42 68 1.50855 $w=1.03333e-08 $l=1.42302e-08 $layer=M1 $thickness=3.6e-08
+ $X=0.0945 $Y=0.036 $X2=0.081 $Y2=0.0405
r119 1 65 19.3796 $a=3.24e-16 $layer=V0LISD $X=0.108 $Y=0.0405 $X2=0.108
+ $Y2=0.036
r120 63 61 0.0925926 $w=2.7e-08 $l=2.5e-09 $layer=N_src_drn $thickness=1e-09
+ $X=0.1253 $Y=0.0405 $X2=0.1225 $Y2=0.0405
r121 1 61 0.537037 $w=2.7e-08 $l=1.45e-08 $layer=N_src_drn $thickness=1e-09
+ $X=0.108 $Y=0.0405 $X2=0.1225 $Y2=0.0405
r122 25 1 0.537037 $w=2.7e-08 $l=1.45e-08 $layer=N_src_drn $thickness=1e-09
+ $X=0.0935 $Y=0.0405 $X2=0.108 $Y2=0.0405
r123 62 25 0.0925926 $w=2.7e-08 $l=2.5e-09 $layer=N_src_drn $thickness=1e-09
+ $X=0.0906 $Y=0.0405 $X2=0.0935 $Y2=0.0405
.ends

.subckt PM_ICGx4DC_ASAP7_75t_R%15 vss 19 23 33 36 48 49 52 53 18 9 12 16 10 4 1
+ 13
c1 1 vss 0.00660659f $X=2.025 $Y=0.135
c2 3 vss 0.00828023f $X=2.052 $Y=0.2025
c3 4 vss 0.00844745f $X=2.16 $Y=0.2025
c4 9 vss 0.118195f $X=2.025 $Y=0.0245
c5 10 vss 0.081764f $X=2.079 $Y=0.135
c6 11 vss 0.00430641f $X=2.0375 $Y=0.2025
c7 12 vss 0.00469704f $X=2.1455 $Y=0.2025
c8 13 vss 0.00129177f $X=2.079 $Y=0.135
c9 14 vss 0.000655121f $X=2.079 $Y=0.171
c10 15 vss 0.00362036f $X=2.0365 $Y=0.171
c11 16 vss 0.00142109f $X=2.034 $Y=0.135
c12 17 vss 0.000231585f $X=2.079 $Y=0.1455
c13 18 vss 0.00353606f $X=2.106 $Y=0.171
r1 53 51 0.0308642 $w=8.1e-08 $l=2.5e-09 $layer=P_src_drn $thickness=1e-09
+ $X=2.1773 $Y=0.2025 $X2=2.1745 $Y2=0.2025
r2 4 51 0.179012 $w=8.1e-08 $l=1.45e-08 $layer=P_src_drn $thickness=1e-09
+ $X=2.16 $Y=0.2025 $X2=2.1745 $Y2=0.2025
r3 12 4 0.179012 $w=8.1e-08 $l=1.45e-08 $layer=P_src_drn $thickness=1e-09
+ $X=2.1455 $Y=0.2025 $X2=2.16 $Y2=0.2025
r4 52 12 0.0308642 $w=8.1e-08 $l=2.5e-09 $layer=P_src_drn $thickness=1e-09
+ $X=2.1426 $Y=0.2025 $X2=2.1455 $Y2=0.2025
r5 49 47 0.0308642 $w=8.1e-08 $l=2.5e-09 $layer=P_src_drn $thickness=1e-09
+ $X=2.0693 $Y=0.2025 $X2=2.0665 $Y2=0.2025
r6 3 47 0.179012 $w=8.1e-08 $l=1.45e-08 $layer=P_src_drn $thickness=1e-09
+ $X=2.052 $Y=0.2025 $X2=2.0665 $Y2=0.2025
r7 11 3 0.179012 $w=8.1e-08 $l=1.45e-08 $layer=P_src_drn $thickness=1e-09
+ $X=2.0375 $Y=0.2025 $X2=2.052 $Y2=0.2025
r8 48 11 0.0308642 $w=8.1e-08 $l=2.5e-09 $layer=P_src_drn $thickness=1e-09
+ $X=2.0346 $Y=0.2025 $X2=2.0375 $Y2=0.2025
r9 4 44 19.3796 $a=3.24e-16 $layer=V0LISD $X=2.16 $Y=0.2025 $X2=2.16 $Y2=0.171
r10 3 40 19.3796 $a=3.24e-16 $layer=V0LISD $X=2.052 $Y=0.2025 $X2=2.052
+ $Y2=0.171
r11 43 44 5.24677 $w=1.3e-08 $l=2.25e-08 $layer=M1 $thickness=3.6e-08 $X=2.1375
+ $Y=0.171 $X2=2.16 $Y2=0.171
r12 18 43 7.34548 $w=1.3e-08 $l=3.15e-08 $layer=M1 $thickness=3.6e-08 $X=2.106
+ $Y=0.171 $X2=2.1375 $Y2=0.171
r13 40 41 3.14806 $w=1.3e-08 $l=1.35e-08 $layer=M1 $thickness=3.6e-08 $X=2.052
+ $Y=0.171 $X2=2.0655 $Y2=0.171
r14 15 40 3.61444 $w=1.3e-08 $l=1.55e-08 $layer=M1 $thickness=3.6e-08 $X=2.0365
+ $Y=0.171 $X2=2.052 $Y2=0.171
r15 14 39 1.96775 $w=1.63333e-08 $l=1.35e-08 $layer=M1 $thickness=3.6e-08
+ $X=2.079 $Y=0.171 $X2=2.079 $Y2=0.1575
r16 14 41 1.96775 $w=1.63333e-08 $l=1.35e-08 $layer=M1 $thickness=3.6e-08
+ $X=2.079 $Y=0.171 $X2=2.0655 $Y2=0.171
r17 14 18 5.11582 $w=1.46667e-08 $l=2.7e-08 $layer=M1 $thickness=3.6e-08
+ $X=2.079 $Y=0.171 $X2=2.106 $Y2=0.171
r18 38 39 1.74892 $w=1.3e-08 $l=7.5e-09 $layer=M1 $thickness=3.6e-08 $X=2.079
+ $Y=0.15 $X2=2.079 $Y2=0.1575
r19 17 38 1.04935 $w=1.3e-08 $l=4.5e-09 $layer=M1 $thickness=3.6e-08 $X=2.079
+ $Y=0.1455 $X2=2.079 $Y2=0.15
r20 13 31 1.49895 $w=1.63333e-08 $l=1.35e-08 $layer=M1 $thickness=3.6e-08
+ $X=2.079 $Y=0.135 $X2=2.0655 $Y2=0.135
r21 13 17 0.79938 $w=2.14e-08 $l=1.05e-08 $layer=M1 $thickness=3.6e-08 $X=2.079
+ $Y=0.135 $X2=2.079 $Y2=0.1455
r22 36 35 16.4967 $w=2.1e-08 $l=4.85e-08 $layer=Gate_1 $thickness=5.6e-08
+ $X=2.079 $Y=0.2025 $X2=2.079 $Y2=0.154
r23 33 34 16.4967 $w=2.1e-08 $l=4.85e-08 $layer=Gate_1 $thickness=5.6e-08
+ $X=2.079 $Y=0.0675 $X2=2.079 $Y2=0.116
r24 10 27 6.54019 $w=2.09524e-08 $layer=Gate_1 $thickness=5.21905e-08 $X=2.079
+ $Y=0.135 $X2=2.079 $Y2=0.135
r25 10 34 6.6497 $w=2.04211e-08 $l=1.9e-08 $layer=Gate_1 $thickness=5.6e-08
+ $X=2.079 $Y=0.135 $X2=2.079 $Y2=0.116
r26 10 35 6.6497 $w=2.04211e-08 $l=1.9e-08 $layer=Gate_1 $thickness=5.6e-08
+ $X=2.079 $Y=0.135 $X2=2.079 $Y2=0.154
r27 30 31 3.14806 $w=1.3e-08 $l=1.35e-08 $layer=M1 $thickness=3.6e-08 $X=2.052
+ $Y=0.135 $X2=2.0655 $Y2=0.135
r28 29 30 2.68168 $w=1.3e-08 $l=1.15e-08 $layer=M1 $thickness=3.6e-08 $X=2.0405
+ $Y=0.135 $X2=2.052 $Y2=0.135
r29 16 29 1.51573 $w=1.3e-08 $l=6.5e-09 $layer=M1 $thickness=3.6e-08 $X=2.034
+ $Y=0.135 $X2=2.0405 $Y2=0.135
r30 26 27 12.6539 $w=1.77815e-08 $l=2.7e-08 $layer=LIG $thickness=4.8e-08
+ $X=2.052 $Y=0.135 $X2=2.079 $Y2=0.135
r31 26 30 19.3796 $a=3.24e-16 $layer=V0LIG $X=2.052 $Y=0.135 $X2=2.052 $Y2=0.135
r32 1 21 6.54019 $w=2.09524e-08 $layer=Gate_1 $thickness=5.21905e-08 $X=2.025
+ $Y=0.135 $X2=2.025 $Y2=0.135
r33 1 26 12.6539 $w=1.77815e-08 $l=2.7e-08 $layer=LIG $thickness=4.8e-08
+ $X=2.025 $Y=0.135 $X2=2.052 $Y2=0.135
r34 23 22 16.4967 $w=2.1e-08 $l=4.85e-08 $layer=Gate_1 $thickness=5.6e-08
+ $X=2.025 $Y=0.2025 $X2=2.025 $Y2=0.154
r35 21 22 6.6497 $w=2.04211e-08 $l=1.9e-08 $layer=Gate_1 $thickness=5.6e-08
+ $X=2.025 $Y=0.135 $X2=2.025 $Y2=0.154
r36 20 21 6.6497 $w=2.04211e-08 $l=1.9e-08 $layer=Gate_1 $thickness=5.6e-08
+ $X=2.025 $Y=0.116 $X2=2.025 $Y2=0.135
r37 19 20 16.4967 $w=2.1e-08 $l=4.85e-08 $layer=Gate_1 $thickness=5.6e-08
+ $X=2.025 $Y=0.0675 $X2=2.025 $Y2=0.116
r38 19 9 14.6259 $w=2.1e-08 $l=4.3e-08 $layer=Gate_1 $thickness=5.6e-08
+ $X=2.025 $Y=0.0675 $X2=2.025 $Y2=0.0245
.ends

.subckt PM_ICGx4DC_ASAP7_75t_R%19 vss 7 9 1 4 5
c1 1 vss 0.00806339f $X=1.269 $Y=0.0675
c2 4 vss 0.00292776f $X=1.2275 $Y=0.0675
c3 5 vss 0.00176387f $X=1.298 $Y=0.0675
r1 9 8 0.0308642 $w=8.1e-08 $l=2.5e-09 $layer=N_src_drn $thickness=1e-09
+ $X=1.3133 $Y=0.0675 $X2=1.3105 $Y2=0.0675
r2 5 8 0.154321 $w=8.1e-08 $l=1.25e-08 $layer=N_src_drn $thickness=1e-09
+ $X=1.298 $Y=0.0675 $X2=1.3105 $Y2=0.0675
r3 4 1 0.154321 $w=8.1e-08 $l=1.25e-08 $layer=N_src_drn $thickness=1e-09
+ $X=1.2275 $Y=0.0675 $X2=1.269 $Y2=0.0675
r4 7 4 0.0308642 $w=8.1e-08 $l=2.5e-09 $layer=N_src_drn $thickness=1e-09
+ $X=1.2246 $Y=0.0675 $X2=1.2275 $Y2=0.0675
r5 1 5 1e-05 $l=2.9e-08 $X=1.269 $Y=0.0675 $X2=1.298 $Y2=0.0675
.ends

* End of included file ICGx4DC_ASAP7_75t_R.pex.sp.pex

*
.subckt ICGx4DC_ASAP7_75t_CUSTOM_4_25_0_7 VSS VDD CLK ENA SE GCLK
*
* VSS VSS
* VDD VDD
* CLK CLK
* ENA ENA
* SE SE
* GCLK GCLK
*
*

M0 N_M0_d N_M0_g VSS VSS nmos_rvt L=2e-08 W=2.7e-08 nfin=1 $X=0.071 $Y=0.027
M1 N_M1_d N_M1_g VSS VSS nmos_rvt L=2e-08 W=2.7e-08 nfin=1 $X=0.125 $Y=0.027
M2 VSS N_M2_g N_M2_s VSS nmos_rvt L=2e-08 W=8.1e-08 nfin=3 $X=0.179 $Y=0.027
M3 N_M3_d N_M3_g N_M3_s VSS nmos_rvt L=2e-08 W=8.1e-08 nfin=3 $X=0.233 $Y=0.027
M4 N_M4_d N_M4_g N_M4_s VSS nmos_rvt L=2e-08 W=8.1e-08 nfin=3 $X=0.287 $Y=0.027
M5 VSS N_M5_g N_M5_s VSS nmos_rvt L=2e-08 W=8.1e-08 nfin=3 $X=0.341 $Y=0.027
M6 N_M6_d N_M6_g VSS VSS nmos_rvt L=2e-08 W=8.1e-08 nfin=3 $X=0.395 $Y=0.027
M7 N_M7_d N_M7_g VSS VSS nmos_rvt L=2e-08 W=8.1e-08 nfin=3 $X=0.449 $Y=0.027
M8 N_M8_d N_M8_g VSS VSS nmos_rvt L=2e-08 W=8.1e-08 nfin=3 $X=0.503 $Y=0.027
M9 N_M9_d N_M9_g VSS VSS nmos_rvt L=2e-08 W=8.1e-08 nfin=3 $X=0.557 $Y=0.027
M10 N_M10_d N_M10_g VSS VSS nmos_rvt L=2e-08 W=5.4e-08 nfin=2 $X=0.611 $Y=0.027
M11 N_M11_d N_M11_g VSS VSS nmos_rvt L=2e-08 W=5.4e-08 nfin=2 $X=0.665 $Y=0.027
M12 VSS N_M12_g N_M12_s VSS nmos_rvt L=2e-08 W=8.1e-08 nfin=3 $X=0.719 $Y=0.027
M13 N_M13_d N_M13_g N_M13_s VSS nmos_rvt L=2e-08 W=8.1e-08 nfin=3 $X=0.773
+ $Y=0.027
M14 N_M14_d N_M14_g N_M14_s VSS nmos_rvt L=2e-08 W=8.1e-08 nfin=3 $X=0.827
+ $Y=0.027
M15 VSS N_M15_g N_M15_s VSS nmos_rvt L=2e-08 W=8.1e-08 nfin=3 $X=0.881 $Y=0.027
M16 N_M16_d N_M16_g VSS VSS nmos_rvt L=2e-08 W=8.1e-08 nfin=3 $X=0.935 $Y=0.027
M17 N_M17_d N_M17_g VSS VSS nmos_rvt L=2e-08 W=5.4e-08 nfin=2 $X=1.097 $Y=0.027
M18 VSS N_M18_g N_M18_s VSS nmos_rvt L=2e-08 W=5.4e-08 nfin=2 $X=1.151 $Y=0.027
M19 N_M19_d N_M19_g VSS VSS nmos_rvt L=2e-08 W=8.1e-08 nfin=3 $X=1.205 $Y=0.027
M20 N_M20_d N_M20_g N_M20_s VSS nmos_rvt L=2e-08 W=8.1e-08 nfin=3 $X=1.313
+ $Y=0.027
M21 N_M21_d N_M21_g N_M21_s VSS nmos_rvt L=2e-08 W=2.7e-08 nfin=1 $X=1.367
+ $Y=0.027
M22 VSS N_M22_g N_M22_s VSS nmos_rvt L=2e-08 W=2.7e-08 nfin=1 $X=1.421 $Y=0.027
M23 N_M23_d N_M23_g VSS VSS nmos_rvt L=2e-08 W=2.7e-08 nfin=1 $X=1.475 $Y=0.027
M24 N_M24_d N_M24_g VSS VSS nmos_rvt L=2e-08 W=8.1e-08 nfin=3 $X=1.637 $Y=0.027
M25 VSS N_M25_g N_M25_s VSS nmos_rvt L=2e-08 W=8.1e-08 nfin=3 $X=1.691 $Y=0.027
M26 N_M26_d N_M26_g N_M26_s VSS nmos_rvt L=2e-08 W=8.1e-08 nfin=3 $X=1.745
+ $Y=0.027
M27 N_M27_d N_M27_g N_M27_s VSS nmos_rvt L=2e-08 W=8.1e-08 nfin=3 $X=1.799
+ $Y=0.027
M28 VSS N_M28_g N_M28_s VSS nmos_rvt L=2e-08 W=8.1e-08 nfin=3 $X=1.853 $Y=0.027
M29 N_M29_d N_M29_g VSS VSS nmos_rvt L=2e-08 W=5.4e-08 nfin=2 $X=1.907 $Y=0.027
M30 N_M30_d N_M30_g VSS VSS nmos_rvt L=2e-08 W=5.4e-08 nfin=2 $X=1.961 $Y=0.027
M31 N_M31_d N_M31_g VSS VSS nmos_rvt L=2e-08 W=8.1e-08 nfin=3 $X=2.015 $Y=0.027
M32 N_M32_d N_M32_g VSS VSS nmos_rvt L=2e-08 W=8.1e-08 nfin=3 $X=2.069 $Y=0.027
M33 N_M33_d N_M33_g VSS VSS nmos_rvt L=2e-08 W=8.1e-08 nfin=3 $X=2.123 $Y=0.027
M34 N_M34_d N_M34_g VSS VSS nmos_rvt L=2e-08 W=8.1e-08 nfin=3 $X=2.177 $Y=0.027
M35 VSS N_M35_g N_M35_s VSS nmos_rvt L=2e-08 W=8.1e-08 nfin=3 $X=2.231 $Y=0.027
M36 N_M36_d N_M36_g N_M36_s VSS nmos_rvt L=2e-08 W=8.1e-08 nfin=3 $X=2.285
+ $Y=0.027
M37 N_M37_d N_M37_g N_M37_s VSS nmos_rvt L=2e-08 W=8.1e-08 nfin=3 $X=2.339
+ $Y=0.027
M38 VSS N_M38_g N_M38_s VSS nmos_rvt L=2e-08 W=8.1e-08 nfin=3 $X=2.393 $Y=0.027
M39 N_M39_d N_M39_g VSS VSS nmos_rvt L=2e-08 W=2.7e-08 nfin=1 $X=2.447 $Y=0.027
M40 N_M40_d N_M40_g VSS VSS nmos_rvt L=2e-08 W=2.7e-08 nfin=1 $X=2.501 $Y=0.027
M41 N_M41_d N_M41_g VDD VDD pmos_rvt L=2e-08 W=2.7e-08 nfin=1 $X=0.071 $Y=0.216
M42 N_M42_d N_M42_g VDD VDD pmos_rvt L=2e-08 W=2.7e-08 nfin=1 $X=0.125 $Y=0.216
M43 N_M43_d N_M43_g VDD VDD pmos_rvt L=2e-08 W=5.4e-08 nfin=2 $X=0.179 $Y=0.189
M44 VDD N_M44_g N_M44_s VDD pmos_rvt L=2e-08 W=5.4e-08 nfin=2 $X=0.233 $Y=0.189
M45 VDD N_M45_g N_M45_s VDD pmos_rvt L=2e-08 W=5.4e-08 nfin=2 $X=0.287 $Y=0.189
M46 N_M46_d N_M46_g VDD VDD pmos_rvt L=2e-08 W=5.4e-08 nfin=2 $X=0.341 $Y=0.189
M47 N_M47_d N_M47_g VDD VDD pmos_rvt L=2e-08 W=8.1e-08 nfin=3 $X=0.395 $Y=0.162
M48 N_M48_d N_M48_g VDD VDD pmos_rvt L=2e-08 W=8.1e-08 nfin=3 $X=0.449 $Y=0.162
M49 N_M49_d N_M49_g VDD VDD pmos_rvt L=2e-08 W=8.1e-08 nfin=3 $X=0.503 $Y=0.162
M50 N_M50_d N_M50_g VDD VDD pmos_rvt L=2e-08 W=8.1e-08 nfin=3 $X=0.557 $Y=0.162
M51 N_M51_d N_M51_g VDD VDD pmos_rvt L=2e-08 W=5.4e-08 nfin=2 $X=0.611 $Y=0.189
M52 N_M52_d N_M52_g VDD VDD pmos_rvt L=2e-08 W=5.4e-08 nfin=2 $X=0.665 $Y=0.189
M53 N_M53_d N_M53_g VDD VDD pmos_rvt L=2e-08 W=5.4e-08 nfin=2 $X=0.719 $Y=0.189
M54 VDD N_M54_g N_M54_s VDD pmos_rvt L=2e-08 W=5.4e-08 nfin=2 $X=0.773 $Y=0.189
M55 VDD N_M55_g N_M55_s VDD pmos_rvt L=2e-08 W=5.4e-08 nfin=2 $X=0.827 $Y=0.189
M56 N_M56_d N_M56_g VDD VDD pmos_rvt L=2e-08 W=5.4e-08 nfin=2 $X=0.881 $Y=0.189
M57 N_M57_d N_M57_g VDD VDD pmos_rvt L=2e-08 W=8.1e-08 nfin=3 $X=0.935 $Y=0.162
M58 N_M58_d N_M58_g N_M58_s VDD pmos_rvt L=2e-08 W=5.4e-08 nfin=2 $X=1.097
+ $Y=0.189
M59 VDD N_M59_g N_M59_s VDD pmos_rvt L=2e-08 W=5.4e-08 nfin=2 $X=1.151 $Y=0.189
M60 N_M60_d N_M60_g VDD VDD pmos_rvt L=2e-08 W=8.1e-08 nfin=3 $X=1.205 $Y=0.162
M61 N_M61_d N_M61_g N_M61_s VDD pmos_rvt L=2e-08 W=8.1e-08 nfin=3 $X=1.259
+ $Y=0.162
M62 N_M62_d N_M62_g N_M62_s VDD pmos_rvt L=2e-08 W=2.7e-08 nfin=1 $X=1.313
+ $Y=0.216
M63 VDD N_M63_g N_M63_s VDD pmos_rvt L=2e-08 W=2.7e-08 nfin=1 $X=1.421 $Y=0.216
M64 N_M64_d N_M64_g VDD VDD pmos_rvt L=2e-08 W=2.7e-08 nfin=1 $X=1.475 $Y=0.216
M65 N_M65_d N_M65_g VDD VDD pmos_rvt L=2e-08 W=8.1e-08 nfin=3 $X=1.637 $Y=0.162
M66 N_M66_d N_M66_g VDD VDD pmos_rvt L=2e-08 W=5.4e-08 nfin=2 $X=1.691 $Y=0.189
M67 VDD N_M67_g N_M67_s VDD pmos_rvt L=2e-08 W=5.4e-08 nfin=2 $X=1.745 $Y=0.189
M68 VDD N_M68_g N_M68_s VDD pmos_rvt L=2e-08 W=5.4e-08 nfin=2 $X=1.799 $Y=0.189
M69 N_M69_d N_M69_g VDD VDD pmos_rvt L=2e-08 W=5.4e-08 nfin=2 $X=1.853 $Y=0.189
M70 N_M70_d N_M70_g VDD VDD pmos_rvt L=2e-08 W=5.4e-08 nfin=2 $X=1.907 $Y=0.189
M71 N_M71_d N_M71_g VDD VDD pmos_rvt L=2e-08 W=5.4e-08 nfin=2 $X=1.961 $Y=0.189
M72 N_M72_d N_M72_g VDD VDD pmos_rvt L=2e-08 W=8.1e-08 nfin=3 $X=2.015 $Y=0.162
M73 N_M73_d N_M73_g VDD VDD pmos_rvt L=2e-08 W=8.1e-08 nfin=3 $X=2.069 $Y=0.162
M74 N_M74_d N_M74_g VDD VDD pmos_rvt L=2e-08 W=8.1e-08 nfin=3 $X=2.123 $Y=0.162
M75 N_M75_d N_M75_g VDD VDD pmos_rvt L=2e-08 W=8.1e-08 nfin=3 $X=2.177 $Y=0.162
M76 N_M76_d N_M76_g VDD VDD pmos_rvt L=2e-08 W=5.4e-08 nfin=2 $X=2.231 $Y=0.189
M77 VDD N_M77_g N_M77_s VDD pmos_rvt L=2e-08 W=5.4e-08 nfin=2 $X=2.285 $Y=0.189
M78 VDD N_M78_g N_M78_s VDD pmos_rvt L=2e-08 W=5.4e-08 nfin=2 $X=2.339 $Y=0.189
M79 N_M79_d N_M79_g VDD VDD pmos_rvt L=2e-08 W=5.4e-08 nfin=2 $X=2.393 $Y=0.189
M80 N_M80_d N_M80_g VDD VDD pmos_rvt L=2e-08 W=2.7e-08 nfin=1 $X=2.447 $Y=0.216
M81 N_M81_d N_M81_g VDD VDD pmos_rvt L=2e-08 W=2.7e-08 nfin=1 $X=2.501 $Y=0.216

* .include "ICGx4DC_ASAP7_75t_R.pex.sp.pxi"

* Start of included file ICGx4DC_ASAP7_75t_R.pex.sp.pxi
x_PM_ICGx4DC_ASAP7_75t_R%7 vss N_M8_g N_M49_g N_M9_g N_M50_g N_M47_d N_M48_d
+ N_M49_d N_M50_d N_7_15 N_7_11 N_7_17 N_7_9 N_7_3 N_7_1 N_7_13 N_7_10
+ PM_ICGx4DC_ASAP7_75t_R%7
cc_1 N_7_15 N_CLK_53 0.00516876f $X=0.486 $Y=0.171
cc_2 N_7_11 N_6_10 0.0405941f $X=0.4175 $Y=0.2025
cc_3 N_7_17 N_6_18 0.00104605f $X=0.5265 $Y=0.135
cc_4 N_7_15 N_6_16 0.00107369f $X=0.486 $Y=0.171
cc_5 N_7_9 N_6_4 0.00141556f $X=0.513 $Y=0.0245
cc_6 N_7_3 N_6_10 0.00143146f $X=0.432 $Y=0.2025
cc_7 N_7_3 N_6_1 0.00177556f $X=0.432 $Y=0.2025
cc_8 N_7_1 N_6_4 0.00178602f $X=0.513 $Y=0.135
cc_9 N_7_1 N_6_12 0.00300429f $X=0.513 $Y=0.135
cc_10 N_7_11 N_6_1 0.00300567f $X=0.4175 $Y=0.2025
cc_11 N_7_15 N_6_14 0.00335463f $X=0.486 $Y=0.171
cc_12 N_7_13 N_6_18 0.00362136f $X=0.513 $Y=0.135
cc_13 N_7_9 N_6_12 0.0208351f $X=0.513 $Y=0.0245
cc_14 N_7_11 N_6_9 0.0299715f $X=0.4175 $Y=0.2025
cc_15 N_7_10 N_6_12 0.044261f $X=0.567 $Y=0.135
x_PM_ICGx4DC_ASAP7_75t_R%20 vss N_M60_d N_M61_s N_20_1 N_20_3
+ PM_ICGx4DC_ASAP7_75t_R%20
cc_16 N_20_1 N_4_37 0.000637158f $X=1.242 $Y=0.2025
cc_17 N_20_1 N_4_52 0.000126269f $X=1.242 $Y=0.2025
cc_18 N_20_1 N_4_36 0.000525201f $X=1.242 $Y=0.2025
cc_19 N_20_1 N_4_19 0.00240973f $X=1.242 $Y=0.2025
cc_20 N_20_3 N_CLK_4 0.000714708f $X=1.2275 $Y=0.2025
cc_21 N_20_3 N_CLK_46 0.000305957f $X=1.2275 $Y=0.2025
cc_22 N_20_3 N_CLK_23 0.0331417f $X=1.2275 $Y=0.2025
cc_23 N_20_3 N_11_1 0.000619315f $X=1.2275 $Y=0.2025
cc_24 N_20_3 N_11_9 0.0349182f $X=1.2275 $Y=0.2025
x_PM_ICGx4DC_ASAP7_75t_R%21 vss N_M62_d N_M63_s N_21_1 N_21_4 N_21_5
+ PM_ICGx4DC_ASAP7_75t_R%21
cc_25 N_21_1 N_4_36 3.36331e-20 $X=1.35 $Y=0.2295
cc_26 N_21_1 N_4_5 4.68377e-20 $X=1.35 $Y=0.2295
cc_27 N_21_1 N_4_43 7.1216e-20 $X=1.35 $Y=0.2295
cc_28 N_21_1 N_4_54 9.48527e-20 $X=1.35 $Y=0.2295
cc_29 N_21_1 N_4_19 0.000104084f $X=1.35 $Y=0.2295
cc_30 N_21_1 N_4_55 0.000201775f $X=1.35 $Y=0.2295
cc_31 N_21_1 N_4_57 0.00027772f $X=1.35 $Y=0.2295
cc_32 N_21_4 N_4_36 0.000278705f $X=1.3355 $Y=0.2295
cc_33 N_21_4 N_4_37 0.000308682f $X=1.3355 $Y=0.2295
cc_34 N_21_1 N_4_52 0.000435982f $X=1.35 $Y=0.2295
cc_35 N_21_4 N_4_19 0.00050957f $X=1.3355 $Y=0.2295
cc_36 N_21_1 N_4_44 0.00224263f $X=1.35 $Y=0.2295
cc_37 N_21_5 N_CLK_16 0.000176353f $X=1.406 $Y=0.2295
cc_38 N_21_5 N_CLK_5 0.00015524f $X=1.406 $Y=0.2295
cc_39 N_21_1 N_CLK_24 0.000839986f $X=1.35 $Y=0.2295
cc_40 N_21_4 N_CLK_24 0.00643064f $X=1.3355 $Y=0.2295
cc_41 N_21_5 N_CLK_24 0.0249834f $X=1.406 $Y=0.2295
cc_42 N_21_1 N_12_15 0.000406556f $X=1.35 $Y=0.2295
cc_43 N_21_4 N_12_15 0.0143291f $X=1.3355 $Y=0.2295
cc_44 N_21_5 N_13_9 0.0161029f $X=1.406 $Y=0.2295
x_PM_ICGx4DC_ASAP7_75t_R%13 vss N_M22_g N_M63_g N_M23_d N_M64_d N_13_9 N_13_1
+ N_13_4 N_13_11 N_13_14 N_13_3 N_13_15 N_13_12 N_13_10 N_13_13
+ PM_ICGx4DC_ASAP7_75t_R%13
cc_45 N_13_9 N_4_20 0.000306484f $X=1.431 $Y=0.0245
cc_46 N_13_9 N_4_55 2.83181e-20 $X=1.431 $Y=0.0245
cc_47 N_13_9 N_4_42 2.84993e-20 $X=1.431 $Y=0.0245
cc_48 N_13_9 N_4_5 0.000375729f $X=1.431 $Y=0.0245
cc_49 N_13_9 N_4_56 0.000384715f $X=1.431 $Y=0.0245
cc_50 N_13_1 N_4_29 0.000681339f $X=1.422 $Y=0.082
cc_51 N_13_1 N_4_56 0.000736748f $X=1.422 $Y=0.082
cc_52 N_13_4 N_4_5 0.00157746f $X=1.512 $Y=0.2295
cc_53 N_13_11 N_4_5 0.00124267f $X=1.4975 $Y=0.2295
cc_54 N_13_14 N_4_54 0.00126924f $X=1.4225 $Y=0.082
cc_55 N_13_14 N_4_63 0.00156f $X=1.4225 $Y=0.082
cc_56 N_13_3 N_4_29 0.00165321f $X=1.512 $Y=0.0635
cc_57 N_13_15 N_4_57 0.00212832f $X=1.5385 $Y=0.093
cc_58 N_13_12 N_4_57 0.00219002f $X=1.5385 $Y=0.233
cc_59 N_13_10 N_4_29 0.00636912f $X=1.4975 $Y=0.0405
cc_60 N_13_11 N_4_29 0.00663383f $X=1.4975 $Y=0.2295
cc_61 N_13_14 N_4_56 0.0039054f $X=1.4225 $Y=0.082
cc_62 N_13_13 N_4_56 0.00477851f $X=1.5385 $Y=0.082
cc_63 N_13_9 N_4_29 0.0301112f $X=1.431 $Y=0.0245
cc_64 N_13_9 N_CLK_36 2.63089e-20 $X=1.431 $Y=0.0245
cc_65 N_13_9 N_CLK_5 3.39357e-20 $X=1.431 $Y=0.0245
cc_66 N_13_9 N_CLK_55 9.73565e-20 $X=1.431 $Y=0.0245
cc_67 N_13_9 N_CLK_6 5.65323e-20 $X=1.431 $Y=0.0245
cc_68 N_13_9 N_CLK_47 7.16591e-20 $X=1.431 $Y=0.0245
cc_69 N_13_9 N_CLK_35 0.00027888f $X=1.431 $Y=0.0245
cc_70 N_13_9 N_CLK_16 0.00283648f $X=1.431 $Y=0.0245
cc_71 N_13_9 N_CLK_34 0.000459774f $X=1.431 $Y=0.0245
cc_72 N_13_1 N_CLK_16 0.0014111f $X=1.422 $Y=0.082
cc_73 N_13_14 N_CLK_35 0.00061452f $X=1.4225 $Y=0.082
cc_74 N_13_15 N_CLK_55 0.00189046f $X=1.5385 $Y=0.093
cc_75 N_13_14 N_CLK_34 0.0018919f $X=1.4225 $Y=0.082
cc_76 N_13_9 N_CLK_24 0.0125837f $X=1.431 $Y=0.0245
cc_77 N_13_15 N_12_25 0.000137209f $X=1.5385 $Y=0.093
cc_78 N_13_15 N_12_5 0.000429405f $X=1.5385 $Y=0.093
cc_79 N_13_15 N_12_24 0.000226921f $X=1.5385 $Y=0.093
cc_80 N_13_15 N_12_6 0.000275123f $X=1.5385 $Y=0.093
cc_81 N_13_12 N_12_25 0.000804848f $X=1.5385 $Y=0.233
cc_82 N_13_13 N_12_24 0.000855383f $X=1.5385 $Y=0.082
cc_83 N_13_12 N_12_29 0.00156058f $X=1.5385 $Y=0.233
cc_84 N_13_15 N_12_28 0.00577434f $X=1.5385 $Y=0.093
x_PM_ICGx4DC_ASAP7_75t_R%22 vss N_M21_d N_M22_s N_22_1 N_22_3
+ PM_ICGx4DC_ASAP7_75t_R%22
cc_85 N_22_1 N_4_34 0.000300181f $X=1.404 $Y=0.0405
cc_86 N_22_1 N_4_42 5.19015e-20 $X=1.404 $Y=0.0405
cc_87 N_22_1 N_4_54 0.000147938f $X=1.404 $Y=0.0405
cc_88 N_22_1 N_4_56 0.000208096f $X=1.404 $Y=0.0405
cc_89 N_22_1 N_4_35 0.00030843f $X=1.404 $Y=0.0405
cc_90 N_22_1 N_4_20 0.00161968f $X=1.404 $Y=0.0405
cc_91 N_22_3 N_CLK_5 1.95729e-20 $X=1.3895 $Y=0.0405
cc_92 N_22_3 N_CLK_24 0.013307f $X=1.3895 $Y=0.0405
cc_93 N_22_3 N_13_9 0.0177079f $X=1.3895 $Y=0.0405
x_PM_ICGx4DC_ASAP7_75t_R%12 vss N_M20_g N_M62_g N_M16_d N_M57_d N_M24_d N_M65_d
+ N_12_15 N_12_3 N_12_28 N_12_29 N_12_20 N_12_24 N_12_23 N_12_22 N_12_5 N_12_26
+ N_12_1 N_12_27 N_12_4 N_12_6 N_12_18 N_12_16 N_12_17 N_12_19 N_12_21 N_12_25
+ PM_ICGx4DC_ASAP7_75t_R%12
cc_94 N_12_15 N_4_57 2.34028e-20 $X=1.323 $Y=0.0245
cc_95 N_12_15 N_4_46 5.14658e-20 $X=1.323 $Y=0.0245
cc_96 N_12_15 N_4_41 5.66945e-20 $X=1.323 $Y=0.0245
cc_97 N_12_15 N_4_30 5.80476e-20 $X=1.323 $Y=0.0245
cc_98 N_12_15 N_4_63 6.98601e-20 $X=1.323 $Y=0.0245
cc_99 N_12_15 N_4_4 8.2041e-20 $X=1.323 $Y=0.0245
cc_100 N_12_15 N_4_6 8.247e-20 $X=1.323 $Y=0.0245
cc_101 N_12_3 N_4_41 8.69503e-20 $X=0.972 $Y=0.054
cc_102 N_12_28 N_4_63 0.000948543f $X=1.594 $Y=0.148
cc_103 N_12_3 N_4_28 9.0053e-20 $X=0.972 $Y=0.054
cc_104 N_12_29 N_4_5 9.43956e-20 $X=0.9855 $Y=0.189
cc_105 N_12_28 N_4_5 0.000104006f $X=1.594 $Y=0.148
cc_106 N_12_20 N_4_51 0.00011482f $X=0.998 $Y=0.086
cc_107 N_12_24 N_4_59 0.000116255f $X=1.594 $Y=0.086
cc_108 N_12_20 N_4_63 0.000126669f $X=0.998 $Y=0.086
cc_109 N_12_15 N_4_34 0.00983302f $X=1.323 $Y=0.0245
cc_110 N_12_15 N_4_36 0.0109491f $X=1.323 $Y=0.0245
cc_111 N_12_23 N_4_19 0.000169624f $X=1.3205 $Y=0.189
cc_112 N_12_20 N_4_41 0.00019911f $X=0.998 $Y=0.086
cc_113 N_12_24 N_4_58 0.000202379f $X=1.594 $Y=0.086
cc_114 N_12_22 N_4_20 0.000213224f $X=1.323 $Y=0.081
cc_115 N_12_24 N_4_46 0.000241993f $X=1.594 $Y=0.086
cc_116 N_12_23 N_4_44 0.000246093f $X=1.3205 $Y=0.189
cc_117 N_12_5 N_4_56 0.00112925f $X=1.62 $Y=0.0605
cc_118 N_12_24 N_4_62 0.000419055f $X=1.594 $Y=0.086
cc_119 N_12_15 N_4_37 0.00556698f $X=1.323 $Y=0.0245
cc_120 N_12_23 N_4_52 0.0048171f $X=1.3205 $Y=0.189
cc_121 N_12_23 N_4_55 0.000520684f $X=1.3205 $Y=0.189
cc_122 N_12_26 N_4_63 0.000574478f $X=0.998 $Y=0.176
cc_123 N_12_23 N_4_43 0.000638018f $X=1.3205 $Y=0.189
cc_124 N_12_1 N_4_20 0.000698514f $X=1.323 $Y=0.1335
cc_125 N_12_20 N_4_61 0.000736653f $X=0.998 $Y=0.086
cc_126 N_12_15 N_4_19 0.00131887f $X=1.323 $Y=0.0245
cc_127 N_12_15 N_4_20 0.00136004f $X=1.323 $Y=0.0245
cc_128 N_12_1 N_4_34 0.00154987f $X=1.323 $Y=0.1335
cc_129 N_12_22 N_4_53 0.0020287f $X=1.323 $Y=0.081
cc_130 N_12_24 N_4_56 0.00398396f $X=1.594 $Y=0.086
cc_131 N_12_29 N_4_57 0.00402523f $X=0.9855 $Y=0.189
cc_132 N_12_27 N_4_54 0.0040357f $X=1.323 $Y=0.1045
cc_133 N_12_29 N_4_63 0.0040614f $X=0.9855 $Y=0.189
cc_134 N_12_15 N_4_35 0.0451638f $X=1.323 $Y=0.0245
cc_135 N_12_29 N_CLK_35 0.000480817f $X=0.9855 $Y=0.189
cc_136 N_12_29 N_CLK_34 0.000127821f $X=0.9855 $Y=0.189
cc_137 N_12_26 N_CLK_33 0.000145019f $X=0.998 $Y=0.176
cc_138 N_12_28 N_CLK_36 0.000150008f $X=1.594 $Y=0.148
cc_139 N_12_4 N_CLK_33 0.000205659f $X=0.972 $Y=0.216
cc_140 N_12_6 N_CLK_36 0.000206013f $X=1.62 $Y=0.2295
cc_141 N_12_20 N_CLK_53 0.000260296f $X=0.998 $Y=0.086
cc_142 N_12_3 N_CLK_45 0.000300941f $X=0.972 $Y=0.054
cc_143 N_12_5 N_CLK_47 0.00030525f $X=1.62 $Y=0.0605
cc_144 N_12_26 N_CLK_45 0.00416771f $X=0.998 $Y=0.176
cc_145 N_12_24 N_CLK_54 0.000331248f $X=1.594 $Y=0.086
cc_146 N_12_28 N_CLK_47 0.00412831f $X=1.594 $Y=0.148
cc_147 N_12_23 N_CLK_46 0.000397121f $X=1.3205 $Y=0.189
cc_148 N_12_1 N_CLK_16 0.000398805f $X=1.323 $Y=0.1335
cc_149 N_12_18 N_CLK_22 0.0422514f $X=0.9575 $Y=0.2025
cc_150 N_12_23 N_CLK_55 0.000408689f $X=1.3205 $Y=0.189
cc_151 N_12_16 N_CLK_22 0.0153336f $X=0.9575 $Y=0.0675
cc_152 N_12_17 N_CLK_25 0.0153175f $X=1.622 $Y=0.0675
cc_153 N_12_19 N_CLK_25 0.0426012f $X=1.622 $Y=0.2025
cc_154 N_12_21 N_CLK_44 0.00042799f $X=0.998 $Y=0.232
cc_155 N_12_25 N_CLK_48 0.000471691f $X=1.594 $Y=0.232
cc_156 N_12_26 N_CLK_55 0.000510991f $X=0.998 $Y=0.176
cc_157 N_12_1 N_CLK_4 0.00151761f $X=1.323 $Y=0.1335
cc_158 N_12_29 N_CLK_46 0.00054439f $X=0.9855 $Y=0.189
cc_159 N_12_28 N_CLK_55 0.000568644f $X=1.594 $Y=0.148
cc_160 N_12_22 N_CLK_46 0.00057326f $X=1.323 $Y=0.081
cc_161 N_12_24 N_CLK_47 0.00061877f $X=1.594 $Y=0.086
cc_162 N_12_20 N_CLK_45 0.000740964f $X=0.998 $Y=0.086
cc_163 N_12_5 N_CLK_6 0.000806179f $X=1.62 $Y=0.0605
cc_164 N_12_3 N_CLK_22 0.000850678f $X=0.972 $Y=0.054
cc_165 N_12_3 N_CLK_3 0.00089607f $X=0.972 $Y=0.054
cc_166 N_12_5 N_CLK_25 0.000938536f $X=1.62 $Y=0.0605
cc_167 N_12_4 N_CLK_22 0.00126438f $X=0.972 $Y=0.216
cc_168 N_12_6 N_CLK_25 0.00135543f $X=1.62 $Y=0.2295
cc_169 N_12_1 N_CLK_5 0.0016162f $X=1.323 $Y=0.1335
cc_170 N_12_15 N_CLK_23 0.00164607f $X=1.323 $Y=0.0245
cc_171 N_12_21 N_CLK_33 0.00167642f $X=0.998 $Y=0.232
cc_172 N_12_16 N_CLK_3 0.00175493f $X=0.9575 $Y=0.0675
cc_173 N_12_19 N_CLK_6 0.00175593f $X=1.622 $Y=0.2025
cc_174 N_12_25 N_CLK_36 0.00179062f $X=1.594 $Y=0.232
cc_175 N_12_27 N_CLK_46 0.00320408f $X=1.323 $Y=0.1045
cc_176 N_12_15 N_CLK_24 0.00878825f $X=1.323 $Y=0.0245
cc_177 N_12_29 N_CLK_55 0.0436777f $X=0.9855 $Y=0.189
cc_178 N_12_3 N_ENA_9 0.000117927f $X=0.972 $Y=0.054
cc_179 N_12_4 N_ENA_9 0.000195646f $X=0.972 $Y=0.216
cc_180 N_12_26 N_ENA_9 0.000752023f $X=0.998 $Y=0.176
cc_181 N_12_21 N_ENA_9 0.00029481f $X=0.998 $Y=0.232
cc_182 N_12_29 N_ENA_5 0.000374931f $X=0.9855 $Y=0.189
cc_183 N_12_29 N_ENA_8 0.000454452f $X=0.9855 $Y=0.189
cc_184 N_12_29 N_ENA_4 0.000866725f $X=0.9855 $Y=0.189
cc_185 N_12_26 N_ENA_6 0.00135927f $X=0.998 $Y=0.176
cc_186 N_12_21 N_ENA_6 0.00172624f $X=0.998 $Y=0.232
cc_187 N_12_29 N_ENA_9 0.0192929f $X=0.9855 $Y=0.189
cc_188 N_12_20 N_SE_4 0.000394597f $X=0.998 $Y=0.086
cc_189 N_12_29 N_SE_4 0.00202816f $X=0.9855 $Y=0.189
x_PM_ICGx4DC_ASAP7_75t_R%23__2 vss N_M2_s N_M3_d N_23__2_1
+ PM_ICGx4DC_ASAP7_75t_R%23__2
cc_190 N_23__2_1 N_4_25 0.0168262f $X=0.216 $Y=0.0675
cc_191 N_23__2_1 N_CLK_18 0.0169374f $X=0.216 $Y=0.0675
x_PM_ICGx4DC_ASAP7_75t_R%24 vss N_M4_d N_M5_s N_24_1 PM_ICGx4DC_ASAP7_75t_R%24
cc_192 N_24_1 N_4_26 0.0168976f $X=0.324 $Y=0.0675
cc_193 N_24_1 N_CLK_19 0.0169401f $X=0.324 $Y=0.0675
x_PM_ICGx4DC_ASAP7_75t_R%25__2 vss N_M12_s N_M13_d N_25__2_1
+ PM_ICGx4DC_ASAP7_75t_R%25__2
cc_194 N_25__2_1 N_4_51 0.000103112f $X=0.756 $Y=0.0675
cc_195 N_25__2_1 N_4_27 0.0166531f $X=0.756 $Y=0.0675
cc_196 N_25__2_1 N_CLK_20 0.0167221f $X=0.756 $Y=0.0675
x_PM_ICGx4DC_ASAP7_75t_R%26 vss N_M14_d N_M15_s N_26_1 PM_ICGx4DC_ASAP7_75t_R%26
cc_197 N_26_1 N_4_51 0.000145578f $X=0.864 $Y=0.0675
cc_198 N_26_1 N_4_28 0.0168268f $X=0.864 $Y=0.0675
cc_199 N_26_1 N_CLK_21 0.0168889f $X=0.864 $Y=0.0675
x_PM_ICGx4DC_ASAP7_75t_R%27__2 vss N_M25_s N_M26_d N_27__2_1
+ PM_ICGx4DC_ASAP7_75t_R%27__2
cc_200 N_27__2_1 N_4_6 2.26742e-20 $X=1.728 $Y=0.0675
cc_201 N_27__2_1 N_4_59 0.000145565f $X=1.728 $Y=0.0675
cc_202 N_27__2_1 N_4_30 0.0168224f $X=1.728 $Y=0.0675
cc_203 N_27__2_1 N_CLK_26 0.0168728f $X=1.728 $Y=0.0675
x_PM_ICGx4DC_ASAP7_75t_R%28 vss N_M27_d N_M28_s N_28_1 PM_ICGx4DC_ASAP7_75t_R%28
cc_204 N_28_1 N_4_59 0.000103112f $X=1.836 $Y=0.0675
cc_205 N_28_1 N_4_31 0.0166531f $X=1.836 $Y=0.0675
cc_206 N_28_1 N_CLK_27 0.0167221f $X=1.836 $Y=0.0675
x_PM_ICGx4DC_ASAP7_75t_R%29__2 vss N_M35_s N_M36_d N_29__2_1
+ PM_ICGx4DC_ASAP7_75t_R%29__2
cc_207 N_29__2_1 N_4_32 0.0169067f $X=2.268 $Y=0.0675
cc_208 N_29__2_1 N_CLK_28 0.0169312f $X=2.268 $Y=0.0675
x_PM_ICGx4DC_ASAP7_75t_R%30 vss N_M37_d N_M38_s N_30_1 PM_ICGx4DC_ASAP7_75t_R%30
cc_209 N_30_1 N_4_33 0.0168247f $X=2.376 $Y=0.0675
cc_210 N_30_1 N_CLK_29 0.016939f $X=2.376 $Y=0.0675
x_PM_ICGx4DC_ASAP7_75t_R%ENA vss ENA N_M17_g N_M58_g N_ENA_8 N_ENA_9 N_ENA_1
+ N_ENA_3 N_ENA_6 N_ENA_5 N_ENA_7 N_ENA_4 PM_ICGx4DC_ASAP7_75t_R%ENA
cc_211 N_ENA_8 N_4_52 0.00014448f $X=1.107 $Y=0.1115
cc_212 N_ENA_8 N_4_63 0.00216271f $X=1.107 $Y=0.1115
cc_213 N_ENA_8 N_CLK_45 4.8712e-20 $X=1.107 $Y=0.1115
cc_214 N_ENA_8 N_CLK_33 4.92868e-20 $X=1.107 $Y=0.1115
cc_215 N_ENA_8 N_CLK_44 7.53863e-20 $X=1.107 $Y=0.1115
cc_216 N_ENA_8 N_CLK_53 0.000193365f $X=1.107 $Y=0.1115
cc_217 N_ENA_9 N_CLK_55 0.000966253f $X=1.029 $Y=0.225
cc_218 N_ENA_8 N_CLK_55 0.00255922f $X=1.107 $Y=0.1115
x_PM_ICGx4DC_ASAP7_75t_R%11 vss N_M19_g N_M60_g N_M17_d N_M18_s N_M58_s N_11_16
+ N_11_1 N_11_9 N_11_11 N_11_3 N_11_15 N_11_14 N_11_4 N_11_10
+ PM_ICGx4DC_ASAP7_75t_R%11
cc_219 N_11_16 N_CLK_55 0.000587305f $X=1.215 $Y=0.1045
cc_220 N_11_1 N_CLK_4 0.00183816f $X=1.215 $Y=0.134
cc_221 N_11_9 N_CLK_23 0.0032378f $X=1.215 $Y=0.0245
cc_222 N_11_16 N_CLK_46 0.00379799f $X=1.215 $Y=0.1045
cc_223 N_11_11 N_ENA_3 0.0109494f $X=1.082 $Y=0.216
cc_224 N_11_3 N_ENA_6 0.000352932f $X=1.1235 $Y=0.216
cc_225 N_11_3 N_ENA_5 0.000381321f $X=1.1235 $Y=0.216
cc_226 N_11_3 N_ENA_1 0.000401279f $X=1.1235 $Y=0.216
cc_227 N_11_16 N_ENA_9 0.000433141f $X=1.215 $Y=0.1045
cc_228 N_11_15 N_ENA_7 0.000474274f $X=1.188 $Y=0.233
cc_229 N_11_14 N_ENA_8 0.000593255f $X=1.188 $Y=0.036
cc_230 N_11_15 N_ENA_5 0.000636294f $X=1.188 $Y=0.233
cc_231 N_11_4 N_ENA_3 0.000648383f $X=1.134 $Y=0.054
cc_232 N_11_15 N_ENA_4 0.000774801f $X=1.188 $Y=0.233
cc_233 N_11_11 N_ENA_1 0.000782519f $X=1.082 $Y=0.216
cc_234 N_11_4 N_ENA_8 0.00105276f $X=1.134 $Y=0.054
cc_235 N_11_15 N_ENA_9 0.00302025f $X=1.188 $Y=0.233
cc_236 N_11_3 N_ENA_3 0.00380984f $X=1.1235 $Y=0.216
cc_237 N_11_10 N_ENA_3 0.0412207f $X=1.1195 $Y=0.054
cc_238 N_11_4 N_SE_3 0.000599424f $X=1.134 $Y=0.054
cc_239 N_11_14 N_SE_5 0.000653757f $X=1.188 $Y=0.036
cc_240 N_11_1 N_SE_1 0.00251624f $X=1.215 $Y=0.134
cc_241 N_11_15 N_SE_4 0.00094636f $X=1.188 $Y=0.233
cc_242 N_11_14 N_SE_4 0.00118833f $X=1.188 $Y=0.036
cc_243 N_11_3 N_SE_3 0.00162816f $X=1.1235 $Y=0.216
cc_244 N_11_10 N_SE_3 0.0104283f $X=1.1195 $Y=0.054
cc_245 N_11_16 N_SE_4 0.00656007f $X=1.215 $Y=0.1045
cc_246 N_11_9 N_SE_3 0.0148616f $X=1.215 $Y=0.0245
x_PM_ICGx4DC_ASAP7_75t_R%31 vss N_M58_d N_M59_s N_31_1 PM_ICGx4DC_ASAP7_75t_R%31
cc_247 N_31_1 N_ENA_3 0.0126122f $X=1.134 $Y=0.216
cc_248 N_31_1 N_SE_3 0.00568333f $X=1.134 $Y=0.216
cc_249 N_31_1 N_11_11 0.000430644f $X=1.134 $Y=0.216
x_PM_ICGx4DC_ASAP7_75t_R%3 vss N_M0_g N_M41_g N_M1_g N_M42_g N_M3_s N_M4_s
+ N_M43_d N_M44_s N_M45_s N_M46_d N_3_13 N_3_16 N_3_15 N_3_3 N_3_5 N_3_19 N_3_4
+ N_3_21 N_3_1 N_3_20 N_3_14 N_3_23 N_3_12 N_3_22 N_3_18 N_3_17
+ PM_ICGx4DC_ASAP7_75t_R%3
x_PM_ICGx4DC_ASAP7_75t_R%4 vss N_M12_g N_M53_g N_M15_g N_M56_g N_M5_g N_M46_g
+ N_M25_g N_M66_g N_M35_g N_M76_g N_M2_g N_M43_g N_M28_g N_M69_g N_M38_g
+ N_M79_g N_M20_d N_M21_s N_M23_g N_M64_g N_M61_d N_M62_s N_4_38 N_4_39 N_4_26
+ N_4_2 N_4_25 N_4_50 N_4_1 N_4_62 N_4_41 N_4_46 N_4_44 N_4_55 N_4_36 N_4_34
+ N_4_51 N_4_59 N_4_43 N_4_60 N_4_19 N_4_37 N_4_3 N_4_7 N_4_9 N_4_58 N_4_8
+ N_4_5 N_4_56 N_4_52 N_4_63 N_4_35 N_4_61 N_4_48 N_4_54 N_4_49 N_4_40 N_4_47
+ N_4_29 N_4_20 N_4_4 N_4_57 N_4_6 N_4_28 N_4_33 N_4_30 N_4_32 N_4_27 N_4_31
+ N_4_53 N_4_42 N_4_45 PM_ICGx4DC_ASAP7_75t_R%4
cc_250 N_4_38 N_3_13 0.000632345f $X=0.189 $Y=0.108
cc_251 N_4_39 N_3_13 0.000332268f $X=0.351 $Y=0.1125
cc_252 N_4_26 N_3_13 9.27777e-20 $X=0.351 $Y=0.135
cc_253 N_4_2 N_3_13 0.000250188f $X=0.351 $Y=0.135
cc_254 N_4_26 N_3_16 0.0249253f $X=0.351 $Y=0.135
cc_255 N_4_25 N_3_15 0.010787f $X=0.189 $Y=0.135
cc_256 N_4_25 N_3_3 0.000370362f $X=0.189 $Y=0.135
cc_257 N_4_26 N_3_5 0.000395633f $X=0.351 $Y=0.135
cc_258 N_4_2 N_3_16 0.000401475f $X=0.351 $Y=0.135
cc_259 N_4_38 N_3_19 0.00045324f $X=0.189 $Y=0.108
cc_260 N_4_50 N_3_4 0.00163392f $X=0.34 $Y=0.108
cc_261 N_4_38 N_3_21 0.0012325f $X=0.189 $Y=0.108
cc_262 N_4_1 N_3_1 0.00300573f $X=0.189 $Y=0.135
cc_263 N_4_38 N_3_20 0.0022809f $X=0.189 $Y=0.108
cc_264 N_4_50 N_3_21 0.00907469f $X=0.34 $Y=0.108
cc_265 N_4_25 N_3_13 0.0191764f $X=0.189 $Y=0.135
x_PM_ICGx4DC_ASAP7_75t_R%CLK vss CLK N_M13_g N_M54_g N_M14_g N_M55_g N_M16_g
+ N_M57_g N_M3_g N_M44_g N_M4_g N_M45_g N_M61_g N_M24_g N_M65_g N_M36_g N_M77_g
+ N_M37_g N_M78_g N_M21_g N_M26_g N_M67_g N_M27_g N_M68_g N_CLK_30 N_CLK_31
+ N_CLK_40 N_CLK_41 N_CLK_42 N_CLK_18 N_CLK_19 N_CLK_1 N_CLK_53 N_CLK_24
+ N_CLK_33 N_CLK_36 N_CLK_34 N_CLK_23 N_CLK_32 N_CLK_37 N_CLK_52 N_CLK_39
+ N_CLK_46 N_CLK_4 N_CLK_2 N_CLK_7 N_CLK_8 N_CLK_47 N_CLK_38 N_CLK_16 N_CLK_35
+ N_CLK_50 N_CLK_45 N_CLK_54 N_CLK_20 N_CLK_27 N_CLK_29 N_CLK_28 N_CLK_5
+ N_CLK_51 N_CLK_3 N_CLK_6 N_CLK_44 N_CLK_48 N_CLK_22 N_CLK_43 N_CLK_49
+ N_CLK_26 N_CLK_25 N_CLK_21 N_CLK_55 PM_ICGx4DC_ASAP7_75t_R%CLK
cc_266 N_CLK_30 N_3_14 0.000403756f $X=0.257 $Y=0.15
cc_267 N_CLK_31 N_3_14 0.000369688f $X=0.257 $Y=0.1795
cc_268 N_CLK_40 N_3_14 0.000141886f $X=0.257 $Y=0.1575
cc_269 N_CLK_41 N_3_14 0.000451772f $X=0.286 $Y=0.144
cc_270 N_CLK_42 N_3_14 0.000225553f $X=0.286 $Y=0.18
cc_271 N_CLK_18 N_3_15 0.0109548f $X=0.243 $Y=0.162
cc_272 N_CLK_19 N_3_16 0.011085f $X=0.297 $Y=0.162
cc_273 N_CLK_1 N_3_3 0.000407947f $X=0.2405 $Y=0.162
cc_274 N_CLK_31 N_3_19 0.000573232f $X=0.257 $Y=0.1795
cc_275 N_CLK_18 N_3_3 0.000801409f $X=0.243 $Y=0.162
cc_276 N_CLK_53 N_3_23 0.000802859f $X=0.636 $Y=0.153
cc_277 N_CLK_30 N_3_21 0.000840642f $X=0.257 $Y=0.15
cc_278 N_CLK_19 N_3_5 0.000860012f $X=0.297 $Y=0.162
cc_279 N_CLK_31 N_3_23 0.000909303f $X=0.257 $Y=0.1795
cc_280 N_CLK_19 N_3_4 0.00154885f $X=0.297 $Y=0.162
cc_281 N_CLK_1 N_3_15 0.00245042f $X=0.2405 $Y=0.162
cc_282 N_CLK_42 N_3_23 0.00363282f $X=0.286 $Y=0.18
cc_283 N_CLK_19 N_3_14 0.0335931f $X=0.297 $Y=0.162
cc_284 N_CLK_18 N_3_14 0.0640926f $X=0.243 $Y=0.162
cc_285 N_CLK_24 N_4_62 3.00899e-20 $X=1.377 $Y=0.1335
cc_286 N_CLK_33 N_4_41 3.97668e-20 $X=0.945 $Y=0.187
cc_287 N_CLK_36 N_4_46 4.11145e-20 $X=1.647 $Y=0.187
cc_288 N_CLK_34 N_4_44 7.02254e-20 $X=1.431 $Y=0.153
cc_289 N_CLK_34 N_4_55 8.20511e-20 $X=1.431 $Y=0.153
cc_290 N_CLK_23 N_4_36 0.00979849f $X=1.269 $Y=0.1335
cc_291 N_CLK_40 N_4_50 0.000154802f $X=0.257 $Y=0.1575
cc_292 N_CLK_24 N_4_34 0.0312472f $X=1.377 $Y=0.1335
cc_293 N_CLK_32 N_4_51 0.00016272f $X=0.81 $Y=0.183
cc_294 N_CLK_37 N_4_59 0.00016272f $X=1.782 $Y=0.183
cc_295 N_CLK_34 N_4_43 0.000167837f $X=1.431 $Y=0.153
cc_296 N_CLK_52 N_4_60 0.0001764f $X=2.341 $Y=0.1575
cc_297 N_CLK_39 N_4_60 0.000181345f $X=2.341 $Y=0.1795
cc_298 N_CLK_31 N_4_50 0.00018427f $X=0.257 $Y=0.1795
cc_299 N_CLK_46 N_4_19 0.00134434f $X=1.269 $Y=0.1215
cc_300 N_CLK_23 N_4_37 0.0241884f $X=1.269 $Y=0.1335
cc_301 N_CLK_4 N_4_19 0.000271385f $X=1.269 $Y=0.1335
cc_302 N_CLK_2 N_4_3 0.000275303f $X=0.783 $Y=0.162
cc_303 N_CLK_7 N_4_7 0.000275303f $X=1.782 $Y=0.162
cc_304 N_CLK_8 N_4_9 0.000285245f $X=2.3185 $Y=0.162
cc_305 N_CLK_1 N_4_1 0.000285288f $X=0.2405 $Y=0.162
cc_306 N_CLK_47 N_4_58 0.000289257f $X=1.647 $Y=0.12
cc_307 N_CLK_8 N_4_8 0.000306796f $X=2.3185 $Y=0.162
cc_308 N_CLK_30 N_4_50 0.00148385f $X=0.257 $Y=0.15
cc_309 N_CLK_38 N_4_60 0.00148065f $X=2.341 $Y=0.15
cc_310 N_CLK_1 N_4_50 0.000345255f $X=0.2405 $Y=0.162
cc_311 N_CLK_16 N_4_5 0.00035077f $X=1.419 $Y=0.1335
cc_312 N_CLK_47 N_4_56 0.000372722f $X=1.647 $Y=0.12
cc_313 N_CLK_46 N_4_52 0.000375122f $X=1.269 $Y=0.1215
cc_314 N_CLK_8 N_4_60 0.000384693f $X=2.3185 $Y=0.162
cc_315 N_CLK_2 N_4_51 0.000394458f $X=0.783 $Y=0.162
cc_316 N_CLK_7 N_4_59 0.000394458f $X=1.782 $Y=0.162
cc_317 N_CLK_41 N_4_2 0.000414828f $X=0.286 $Y=0.144
cc_318 N_CLK_35 N_4_5 0.000424371f $X=1.449 $Y=0.153
cc_319 N_CLK_46 N_4_63 0.00045003f $X=1.269 $Y=0.1215
cc_320 N_CLK_24 N_4_35 0.0056098f $X=1.377 $Y=0.1335
cc_321 N_CLK_50 N_4_60 0.000471421f $X=2.312 $Y=0.18
cc_322 N_CLK_30 N_4_38 0.000480785f $X=0.257 $Y=0.15
cc_323 N_CLK_45 N_4_61 0.000484205f $X=0.945 $Y=0.1545
cc_324 N_CLK_47 N_4_62 0.000496833f $X=1.647 $Y=0.12
cc_325 N_CLK_42 N_4_39 0.000507788f $X=0.286 $Y=0.18
cc_326 N_CLK_54 N_4_48 0.000563722f $X=1.653 $Y=0.153
cc_327 N_CLK_16 N_4_54 0.00264407f $X=1.419 $Y=0.1335
cc_328 N_CLK_53 N_4_39 0.000582087f $X=0.636 $Y=0.153
cc_329 N_CLK_18 N_4_1 0.000583386f $X=0.243 $Y=0.162
cc_330 N_CLK_20 N_4_3 0.000583386f $X=0.783 $Y=0.0245
cc_331 N_CLK_27 N_4_7 0.000583386f $X=1.809 $Y=0.162
cc_332 N_CLK_29 N_4_9 0.000583386f $X=2.349 $Y=0.162
cc_333 N_CLK_38 N_4_49 0.000585527f $X=2.341 $Y=0.15
cc_334 N_CLK_53 N_4_40 0.000601625f $X=0.636 $Y=0.153
cc_335 N_CLK_54 N_4_47 0.000601625f $X=1.653 $Y=0.153
cc_336 N_CLK_4 N_4_36 0.000602145f $X=1.269 $Y=0.1335
cc_337 N_CLK_54 N_4_46 0.000602638f $X=1.653 $Y=0.153
cc_338 N_CLK_53 N_4_41 0.000606096f $X=0.636 $Y=0.153
cc_339 N_CLK_19 N_4_2 0.000676298f $X=0.297 $Y=0.162
cc_340 N_CLK_28 N_4_8 0.000676298f $X=2.295 $Y=0.162
cc_341 N_CLK_35 N_4_63 0.000697403f $X=1.449 $Y=0.153
cc_342 N_CLK_16 N_4_29 0.000851751f $X=1.419 $Y=0.1335
cc_343 N_CLK_24 N_4_20 0.000879894f $X=1.377 $Y=0.1335
cc_344 N_CLK_5 N_4_34 0.000938408f $X=1.378 $Y=0.1335
cc_345 N_CLK_51 N_4_48 0.000973114f $X=2.312 $Y=0.144
cc_346 N_CLK_41 N_4_39 0.00110951f $X=0.286 $Y=0.144
cc_347 N_CLK_23 N_4_19 0.0011426f $X=1.269 $Y=0.1335
cc_348 N_CLK_3 N_4_4 0.00292497f $X=0.945 $Y=0.135
cc_349 N_CLK_34 N_4_57 0.00121066f $X=1.431 $Y=0.153
cc_350 N_CLK_6 N_4_6 0.00304517f $X=1.647 $Y=0.135
cc_351 N_CLK_44 N_4_41 0.00133405f $X=0.8485 $Y=0.187
cc_352 N_CLK_48 N_4_46 0.00134134f $X=1.674 $Y=0.187
cc_353 N_CLK_22 N_4_28 0.00166559f $X=0.945 $Y=0.135
cc_354 N_CLK_8 N_4_33 0.00186413f $X=2.3185 $Y=0.162
cc_355 N_CLK_1 N_4_25 0.00191787f $X=0.2405 $Y=0.162
cc_356 N_CLK_2 N_4_28 0.00196775f $X=0.783 $Y=0.162
cc_357 N_CLK_7 N_4_30 0.00196775f $X=1.782 $Y=0.162
cc_358 N_CLK_47 N_4_46 0.00321296f $X=1.647 $Y=0.12
cc_359 N_CLK_45 N_4_41 0.003342f $X=0.945 $Y=0.1545
cc_360 N_CLK_43 N_4_51 0.00366274f $X=0.81 $Y=0.1445
cc_361 N_CLK_49 N_4_59 0.00366274f $X=1.782 $Y=0.15
cc_362 N_CLK_26 N_4_30 0.0036961f $X=1.755 $Y=0.162
cc_363 N_CLK_34 N_4_54 0.00371636f $X=1.431 $Y=0.153
cc_364 N_CLK_35 N_4_57 0.0046742f $X=1.449 $Y=0.153
cc_365 N_CLK_41 N_4_50 0.00524615f $X=0.286 $Y=0.144
cc_366 N_CLK_51 N_4_60 0.00565075f $X=2.312 $Y=0.144
cc_367 N_CLK_25 N_4_30 0.00689926f $X=1.647 $Y=0.135
cc_368 N_CLK_28 N_4_32 0.00711289f $X=2.295 $Y=0.162
cc_369 N_CLK_19 N_4_26 0.00711827f $X=0.297 $Y=0.162
cc_370 N_CLK_29 N_4_33 0.00711836f $X=2.349 $Y=0.162
cc_371 N_CLK_18 N_4_25 0.00712125f $X=0.243 $Y=0.162
cc_372 N_CLK_20 N_4_27 0.00717292f $X=0.783 $Y=0.0245
cc_373 N_CLK_27 N_4_31 0.00717292f $X=1.809 $Y=0.162
cc_374 N_CLK_21 N_4_28 0.00856608f $X=0.837 $Y=0.162
cc_375 N_CLK_53 N_4_61 0.0443822f $X=0.636 $Y=0.153
cc_376 N_CLK_55 N_4_63 0.0444244f $X=0.9482 $Y=0.153
cc_377 N_CLK_54 N_4_62 0.0445247f $X=1.653 $Y=0.153
x_PM_ICGx4DC_ASAP7_75t_R%6 vss N_M6_g N_M47_g N_M7_g N_M48_g N_M6_d N_M7_d
+ N_M8_d N_M9_d N_6_9 N_6_15 N_6_1 N_6_18 N_6_10 N_6_16 N_6_4 N_6_12 N_6_14
+ PM_ICGx4DC_ASAP7_75t_R%6
cc_378 N_6_9 N_4_2 0.000478134f $X=0.405 $Y=0.0245
cc_379 N_6_9 N_4_39 0.000190413f $X=0.405 $Y=0.0245
cc_380 N_6_9 N_4_50 0.000106784f $X=0.405 $Y=0.0245
cc_381 N_6_9 N_4_61 0.001127f $X=0.405 $Y=0.0245
cc_382 N_6_15 N_4_39 0.000707971f $X=0.4175 $Y=0.099
cc_383 N_6_15 N_4_61 0.00109283f $X=0.4175 $Y=0.099
cc_384 N_6_1 N_4_2 0.00117522f $X=0.405 $Y=0.135
cc_385 N_6_18 N_4_61 0.00276498f $X=0.486 $Y=0.099
cc_386 N_6_9 N_4_26 0.00322802f $X=0.405 $Y=0.0245
x_PM_ICGx4DC_ASAP7_75t_R%8 vss N_M10_g N_M51_g N_M11_g N_M52_g N_M13_s N_M14_s
+ N_M53_d N_M54_s N_M55_s N_M56_d N_8_13 N_8_22 N_8_16 N_8_15 N_8_5 N_8_3
+ N_8_19 N_8_4 N_8_21 N_8_1 N_8_20 N_8_14 N_8_23 N_8_12 N_8_17 N_8_18
+ PM_ICGx4DC_ASAP7_75t_R%8
cc_387 N_8_13 N_4_28 4.15995e-20 $X=0.675 $Y=0.136
cc_388 N_8_13 N_4_40 0.000261483f $X=0.675 $Y=0.136
cc_389 N_8_13 N_4_41 0.000199354f $X=0.675 $Y=0.136
cc_390 N_8_13 N_4_4 0.000154477f $X=0.675 $Y=0.136
cc_391 N_8_13 N_4_61 0.000234681f $X=0.675 $Y=0.136
cc_392 N_8_22 N_4_40 0.000315061f $X=0.702 $Y=0.197
cc_393 N_8_16 N_4_28 0.0252027f $X=0.8495 $Y=0.216
cc_394 N_8_15 N_4_27 0.0107949f $X=0.7415 $Y=0.216
cc_395 N_8_5 N_4_28 0.000351004f $X=0.864 $Y=0.216
cc_396 N_8_16 N_4_4 0.000392154f $X=0.8495 $Y=0.216
cc_397 N_8_3 N_4_27 0.000405728f $X=0.756 $Y=0.216
cc_398 N_8_19 N_4_40 0.000418905f $X=0.729 $Y=0.192
cc_399 N_8_4 N_4_51 0.00187304f $X=0.81 $Y=0.0675
cc_400 N_8_21 N_4_61 0.00112531f $X=0.6855 $Y=0.072
cc_401 N_8_21 N_4_40 0.00117879f $X=0.6855 $Y=0.072
cc_402 N_8_1 N_4_3 0.00286931f $X=0.621 $Y=0.136
cc_403 N_8_20 N_4_40 0.00284606f $X=0.675 $Y=0.113
cc_404 N_8_21 N_4_51 0.0086743f $X=0.6855 $Y=0.072
cc_405 N_8_13 N_4_27 0.0200369f $X=0.675 $Y=0.136
cc_406 N_8_14 N_CLK_33 9.04087e-20 $X=0.7955 $Y=0.0675
cc_407 N_8_14 N_CLK_32 0.000240414f $X=0.7955 $Y=0.0675
cc_408 N_8_14 N_CLK_53 0.000207874f $X=0.7955 $Y=0.0675
cc_409 N_8_14 N_CLK_20 0.0345057f $X=0.7955 $Y=0.0675
cc_410 N_8_23 N_CLK_43 0.000339413f $X=0.7425 $Y=0.231
cc_411 N_8_22 N_CLK_53 0.000340881f $X=0.702 $Y=0.197
cc_412 N_8_16 N_CLK_21 0.0112319f $X=0.8495 $Y=0.216
cc_413 N_8_3 N_CLK_2 0.000417335f $X=0.756 $Y=0.216
cc_414 N_8_5 N_CLK_44 0.000421836f $X=0.864 $Y=0.216
cc_415 N_8_21 N_CLK_43 0.000474026f $X=0.6855 $Y=0.072
cc_416 N_8_20 N_CLK_53 0.00075042f $X=0.675 $Y=0.113
cc_417 N_8_3 N_CLK_20 0.000765559f $X=0.756 $Y=0.216
cc_418 N_8_5 N_CLK_21 0.00114917f $X=0.864 $Y=0.216
cc_419 N_8_4 N_CLK_21 0.00142216f $X=0.81 $Y=0.0675
cc_420 N_8_19 N_CLK_53 0.00245131f $X=0.729 $Y=0.192
cc_421 N_8_23 N_CLK_44 0.00245197f $X=0.7425 $Y=0.231
cc_422 N_8_16 N_CLK_2 0.00247162f $X=0.8495 $Y=0.216
cc_423 N_8_15 N_CLK_20 0.0106215f $X=0.7415 $Y=0.216
cc_424 N_8_23 N_CLK_32 0.00407945f $X=0.7425 $Y=0.231
cc_425 N_8_14 N_CLK_21 0.064731f $X=0.7955 $Y=0.0675
cc_426 N_8_1 N_7_10 0.00130578f $X=0.621 $Y=0.136
cc_427 N_8_12 N_7_10 0.00340165f $X=0.621 $Y=0.0245
x_PM_ICGx4DC_ASAP7_75t_R%SE vss SE N_M18_g N_M59_g N_SE_5 N_SE_4 N_SE_1 N_SE_3
+ PM_ICGx4DC_ASAP7_75t_R%SE
cc_428 N_SE_5 N_4_61 0.000442011f $X=1.067 $Y=0.081
cc_429 N_SE_5 N_4_63 0.0183971f $X=1.067 $Y=0.081
cc_430 N_SE_4 N_CLK_46 0.000131886f $X=1.161 $Y=0.071
cc_431 N_SE_4 N_CLK_4 2.97256e-20 $X=1.161 $Y=0.071
cc_432 N_SE_4 N_CLK_55 0.00218098f $X=1.161 $Y=0.071
cc_433 N_SE_5 N_ENA_8 0.000659637f $X=1.067 $Y=0.081
cc_434 N_SE_1 N_ENA_1 0.00235919f $X=1.161 $Y=0.135
cc_435 N_SE_4 N_ENA_8 0.00414389f $X=1.161 $Y=0.071
cc_436 N_SE_3 N_ENA_3 0.0121128f $X=1.161 $Y=0.0245
x_PM_ICGx4DC_ASAP7_75t_R%14 vss N_M29_g N_M70_g N_M30_g N_M71_g N_M26_s N_M27_s
+ N_M68_s N_M69_d N_M66_d N_M67_s N_14_12 N_14_14 N_14_22 N_14_21 N_14_15
+ N_14_16 N_14_3 N_14_5 N_14_17 N_14_4 N_14_1 N_14_23 N_14_20 N_14_13 N_14_18
+ N_14_19 PM_ICGx4DC_ASAP7_75t_R%14
cc_437 N_14_12 N_4_30 4.15995e-20 $X=1.917 $Y=0.0245
cc_438 N_14_12 N_4_47 0.000261483f $X=1.917 $Y=0.0245
cc_439 N_14_12 N_4_46 0.000204417f $X=1.917 $Y=0.0245
cc_440 N_14_12 N_4_45 9.27724e-20 $X=1.917 $Y=0.0245
cc_441 N_14_12 N_4_6 0.000154477f $X=1.917 $Y=0.0245
cc_442 N_14_12 N_4_62 0.000233341f $X=1.917 $Y=0.0245
cc_443 N_14_14 N_4_31 0.000291291f $X=1.7675 $Y=0.0675
cc_444 N_14_22 N_4_47 0.000315061f $X=1.89 $Y=0.197
cc_445 N_14_21 N_4_58 0.000315492f $X=1.9065 $Y=0.072
cc_446 N_14_15 N_4_30 0.0251829f $X=1.7135 $Y=0.216
cc_447 N_14_16 N_4_31 0.0107949f $X=1.8215 $Y=0.216
cc_448 N_14_3 N_4_30 0.000351004f $X=1.728 $Y=0.216
cc_449 N_14_15 N_4_6 0.000392154f $X=1.7135 $Y=0.216
cc_450 N_14_5 N_4_31 0.000405728f $X=1.836 $Y=0.216
cc_451 N_14_17 N_4_47 0.000418905f $X=1.863 $Y=0.192
cc_452 N_14_4 N_4_59 0.00193324f $X=1.782 $Y=0.0675
cc_453 N_14_21 N_4_62 0.00101808f $X=1.9065 $Y=0.072
cc_454 N_14_21 N_4_47 0.00117879f $X=1.9065 $Y=0.072
cc_455 N_14_1 N_4_7 0.00286931f $X=1.9075 $Y=0.136
cc_456 N_14_23 N_4_47 0.00284606f $X=1.917 $Y=0.113
cc_457 N_14_21 N_4_59 0.00882002f $X=1.9065 $Y=0.072
cc_458 N_14_12 N_4_31 0.019638f $X=1.917 $Y=0.0245
cc_459 N_14_14 N_CLK_36 9.10006e-20 $X=1.7675 $Y=0.0675
cc_460 N_14_14 N_CLK_37 0.000240414f $X=1.7675 $Y=0.0675
cc_461 N_14_14 N_CLK_54 0.000207874f $X=1.7675 $Y=0.0675
cc_462 N_14_14 N_CLK_27 0.0347566f $X=1.7675 $Y=0.0675
cc_463 N_14_20 N_CLK_49 0.000339413f $X=1.809 $Y=0.231
cc_464 N_14_22 N_CLK_54 0.000340881f $X=1.89 $Y=0.197
cc_465 N_14_15 N_CLK_26 0.0112319f $X=1.7135 $Y=0.216
cc_466 N_14_5 N_CLK_7 0.000417335f $X=1.836 $Y=0.216
cc_467 N_14_3 N_CLK_48 0.000421836f $X=1.728 $Y=0.216
cc_468 N_14_21 N_CLK_49 0.000469782f $X=1.9065 $Y=0.072
cc_469 N_14_23 N_CLK_54 0.00075042f $X=1.917 $Y=0.113
cc_470 N_14_5 N_CLK_27 0.000765559f $X=1.836 $Y=0.216
cc_471 N_14_3 N_CLK_26 0.00114917f $X=1.728 $Y=0.216
cc_472 N_14_4 N_CLK_27 0.00142216f $X=1.782 $Y=0.0675
cc_473 N_14_20 N_CLK_48 0.00245354f $X=1.809 $Y=0.231
cc_474 N_14_17 N_CLK_54 0.00245591f $X=1.863 $Y=0.192
cc_475 N_14_15 N_CLK_7 0.00247162f $X=1.7135 $Y=0.216
cc_476 N_14_16 N_CLK_27 0.0106215f $X=1.8215 $Y=0.216
cc_477 N_14_20 N_CLK_37 0.00407945f $X=1.809 $Y=0.231
cc_478 N_14_14 N_CLK_26 0.0644827f $X=1.7675 $Y=0.0675
x_PM_ICGx4DC_ASAP7_75t_R%16 vss N_M33_g N_M74_g N_M34_g N_M75_g N_M31_d N_M32_d
+ N_M33_d N_M34_d N_16_10 N_16_17 N_16_1 N_16_15 N_16_9 N_16_18 N_16_3 N_16_11
+ N_16_14 PM_ICGx4DC_ASAP7_75t_R%16
cc_479 N_16_10 N_4_8 0.000472565f $X=2.187 $Y=0.135
cc_480 N_16_10 N_4_48 0.000190687f $X=2.187 $Y=0.135
cc_481 N_16_10 N_4_62 0.001127f $X=2.187 $Y=0.135
cc_482 N_16_17 N_4_48 0.000706306f $X=2.1465 $Y=0.099
cc_483 N_16_17 N_4_62 0.00109283f $X=2.1465 $Y=0.099
cc_484 N_16_1 N_4_8 0.00117522f $X=2.133 $Y=0.135
cc_485 N_16_15 N_4_62 0.00276924f $X=2.106 $Y=0.099
cc_486 N_16_10 N_4_32 0.00322802f $X=2.187 $Y=0.135
cc_487 N_16_9 N_15_12 0.0405889f $X=2.133 $Y=0.0245
cc_488 N_16_15 N_15_16 0.00104592f $X=2.106 $Y=0.099
cc_489 N_16_18 N_15_18 0.00107355f $X=2.1465 $Y=0.135
cc_490 N_16_3 N_15_10 0.00141538f $X=2.052 $Y=0.0675
cc_491 N_16_9 N_15_4 0.00143128f $X=2.133 $Y=0.0245
cc_492 N_16_1 N_15_4 0.00177534f $X=2.133 $Y=0.135
cc_493 N_16_3 N_15_1 0.00178579f $X=2.052 $Y=0.0675
cc_494 N_16_11 N_15_1 0.00300391f $X=2.0375 $Y=0.0675
cc_495 N_16_1 N_15_12 0.00300528f $X=2.133 $Y=0.135
cc_496 N_16_14 N_15_18 0.0033539f $X=2.133 $Y=0.135
cc_497 N_16_15 N_15_13 0.0036209f $X=2.106 $Y=0.099
cc_498 N_16_11 N_15_10 0.0208324f $X=2.0375 $Y=0.0675
cc_499 N_16_10 N_15_12 0.0299676f $X=2.187 $Y=0.135
cc_500 N_16_11 N_15_9 0.0442553f $X=2.0375 $Y=0.0675
x_PM_ICGx4DC_ASAP7_75t_R%17 vss N_M39_g N_M80_g N_M40_g N_M81_g N_M36_s N_M37_s
+ N_M78_s N_M79_d N_M76_d N_M77_s N_17_12 N_17_16 N_17_3 N_17_5 N_17_15 N_17_17
+ N_17_4 N_17_21 N_17_1 N_17_23 N_17_14 N_17_20 N_17_19 N_17_18 N_17_13
+ PM_ICGx4DC_ASAP7_75t_R%17
cc_501 N_17_12 N_4_48 0.000331724f $X=2.457 $Y=0.0245
cc_502 N_17_12 N_4_49 0.000595022f $X=2.457 $Y=0.0245
cc_503 N_17_12 N_4_32 0.000689254f $X=2.457 $Y=0.0245
cc_504 N_17_16 N_4_33 0.01079f $X=2.3615 $Y=0.216
cc_505 N_17_3 N_4_8 0.000345392f $X=2.268 $Y=0.216
cc_506 N_17_5 N_4_33 0.000370609f $X=2.376 $Y=0.216
cc_507 N_17_3 N_4_32 0.000395786f $X=2.268 $Y=0.216
cc_508 N_17_15 N_4_8 0.000401631f $X=2.2535 $Y=0.216
cc_509 N_17_17 N_4_49 0.000442024f $X=2.403 $Y=0.1885
cc_510 N_17_4 N_4_60 0.00167097f $X=2.322 $Y=0.0675
cc_511 N_17_21 N_4_49 0.00123275f $X=2.4465 $Y=0.072
cc_512 N_17_1 N_4_9 0.00298276f $X=2.4475 $Y=0.136
cc_513 N_17_23 N_4_49 0.00229441f $X=2.457 $Y=0.113
cc_514 N_17_15 N_4_32 0.0246162f $X=2.2535 $Y=0.216
cc_515 N_17_21 N_4_60 0.00834955f $X=2.4465 $Y=0.072
cc_516 N_17_12 N_4_33 0.0189287f $X=2.457 $Y=0.0245
cc_517 N_17_14 N_CLK_8 4.739e-20 $X=2.3075 $Y=0.0675
cc_518 N_17_14 N_CLK_39 0.000392888f $X=2.3075 $Y=0.0675
cc_519 N_17_14 N_CLK_38 0.000392042f $X=2.3075 $Y=0.0675
cc_520 N_17_14 N_CLK_52 0.000154471f $X=2.3075 $Y=0.0675
cc_521 N_17_14 N_CLK_50 0.000207183f $X=2.3075 $Y=0.0675
cc_522 N_17_14 N_CLK_51 0.000503197f $X=2.3075 $Y=0.0675
cc_523 N_17_16 N_CLK_29 0.0109619f $X=2.3615 $Y=0.216
cc_524 N_17_15 N_CLK_28 0.0110893f $X=2.2535 $Y=0.216
cc_525 N_17_5 N_CLK_8 0.000444798f $X=2.376 $Y=0.216
cc_526 N_17_17 N_CLK_39 0.000603875f $X=2.403 $Y=0.1885
cc_527 N_17_5 N_CLK_29 0.000801937f $X=2.376 $Y=0.216
cc_528 N_17_20 N_CLK_54 0.000815272f $X=2.3585 $Y=0.231
cc_529 N_17_21 N_CLK_38 0.000826963f $X=2.4465 $Y=0.072
cc_530 N_17_3 N_CLK_28 0.000860345f $X=2.268 $Y=0.216
cc_531 N_17_20 N_CLK_39 0.000981052f $X=2.3585 $Y=0.231
cc_532 N_17_4 N_CLK_28 0.00152542f $X=2.322 $Y=0.0675
cc_533 N_17_16 N_CLK_8 0.0024029f $X=2.3615 $Y=0.216
cc_534 N_17_20 N_CLK_50 0.00362081f $X=2.3585 $Y=0.231
cc_535 N_17_14 N_CLK_28 0.0336144f $X=2.3075 $Y=0.0675
cc_536 N_17_14 N_CLK_29 0.0641278f $X=2.3075 $Y=0.0675
x_PM_ICGx4DC_ASAP7_75t_R%GCLK vss GCLK GCLK GCLK GCLK N_M0_d N_M1_d N_M41_d
+ N_M42_d N_M10_d N_M11_d N_M51_d N_M52_d N_M29_d N_M30_d N_M39_d N_M40_d
+ N_M70_d N_M71_d N_M80_d N_M81_d N_GCLK_29 N_GCLK_33 N_GCLK_34 N_GCLK_43
+ N_GCLK_53 N_GCLK_1 N_GCLK_25 N_GCLK_2 N_GCLK_42 N_GCLK_41 N_GCLK_54 N_GCLK_5
+ N_GCLK_7 N_GCLK_3 N_GCLK_55 N_GCLK_35 N_GCLK_37 N_GCLK_49 N_GCLK_44 N_GCLK_51
+ N_GCLK_36 N_GCLK_38 N_GCLK_46 N_GCLK_48 N_GCLK_30 N_GCLK_4 N_GCLK_26
+ N_GCLK_45 N_GCLK_31 N_GCLK_6 N_GCLK_27 N_GCLK_47 N_GCLK_32 N_GCLK_39
+ N_GCLK_40 N_GCLK_28 N_GCLK_8 N_GCLK_50 N_GCLK_52 PM_ICGx4DC_ASAP7_75t_R%GCLK
cc_537 N_GCLK_29 N_3_12 0.00765293f $X=0.0935 $Y=0.2295
cc_538 N_GCLK_33 N_3_12 7.50235e-20 $X=0.081 $Y=0.0315
cc_539 N_GCLK_34 N_3_12 0.00010098f $X=0.081 $Y=0.234
cc_540 N_GCLK_43 N_3_12 0.000117944f $X=0.108 $Y=0.234
cc_541 N_GCLK_53 N_3_12 0.000151161f $X=0.0665 $Y=0.045
cc_542 N_GCLK_1 N_3_12 0.00375712f $X=0.108 $Y=0.0405
cc_543 N_GCLK_25 N_3_12 0.000431512f $X=0.0935 $Y=0.0405
cc_544 N_GCLK_43 N_3_22 0.000431618f $X=0.108 $Y=0.234
cc_545 N_GCLK_29 N_3_13 0.00518896f $X=0.0935 $Y=0.2295
cc_546 N_GCLK_2 N_3_1 0.00476626f $X=0.108 $Y=0.189
cc_547 N_GCLK_43 N_3_19 0.000559185f $X=0.108 $Y=0.234
cc_548 N_GCLK_43 N_3_18 0.00202316f $X=0.108 $Y=0.234
cc_549 N_GCLK_42 N_3_17 0.00308012f $X=0.0945 $Y=0.036
cc_550 N_GCLK_53 N_3_21 0.00443569f $X=0.0665 $Y=0.045
cc_551 N_GCLK_25 N_3_13 0.0124025f $X=0.0935 $Y=0.0405
cc_552 N_GCLK_41 N_3_20 0.00613103f $X=0.081 $Y=0.0495
cc_553 N_GCLK_1 N_3_13 0.0179096f $X=0.108 $Y=0.0405
cc_554 N_GCLK_2 N_3_12 0.0218555f $X=0.108 $Y=0.189
cc_555 N_GCLK_54 N_4_38 1.30908e-20 $X=1.8347 $Y=0.045
cc_556 N_GCLK_54 N_4_20 1.6743e-20 $X=1.8347 $Y=0.045
cc_557 N_GCLK_54 N_4_49 0.000189233f $X=1.8347 $Y=0.045
cc_558 N_GCLK_54 N_4_3 3.992e-20 $X=1.8347 $Y=0.045
cc_559 N_GCLK_5 N_4_7 3.992e-20 $X=1.944 $Y=0.054
cc_560 N_GCLK_1 N_4_1 4.19435e-20 $X=0.108 $Y=0.0405
cc_561 N_GCLK_7 N_4_9 4.19766e-20 $X=2.484 $Y=0.0405
cc_562 N_GCLK_3 N_4_40 7.4023e-20 $X=0.648 $Y=0.054
cc_563 N_GCLK_5 N_4_47 7.4023e-20 $X=1.944 $Y=0.054
cc_564 N_GCLK_53 N_4_40 0.000106065f $X=0.0665 $Y=0.045
cc_565 N_GCLK_54 N_4_47 0.000106065f $X=1.8347 $Y=0.045
cc_566 N_GCLK_55 N_4_46 0.000306952f $X=0.9331 $Y=0.045
cc_567 N_GCLK_35 N_4_61 0.00013506f $X=0.621 $Y=0.0315
cc_568 N_GCLK_37 N_4_62 0.00013506f $X=1.971 $Y=0.0315
cc_569 N_GCLK_55 N_4_41 0.000287342f $X=0.9331 $Y=0.045
cc_570 N_GCLK_1 N_4_38 0.000157002f $X=0.108 $Y=0.0405
cc_571 N_GCLK_7 N_4_49 0.000159526f $X=2.484 $Y=0.0405
cc_572 N_GCLK_53 N_4_38 0.000162295f $X=0.0665 $Y=0.045
cc_573 N_GCLK_55 N_4_42 0.000180091f $X=0.9331 $Y=0.045
cc_574 N_GCLK_53 N_4_39 0.000387393f $X=0.0665 $Y=0.045
cc_575 N_GCLK_54 N_4_48 0.000384997f $X=1.8347 $Y=0.045
cc_576 N_GCLK_55 N_4_45 0.000323471f $X=0.9331 $Y=0.045
cc_577 N_GCLK_55 N_4_54 0.000439958f $X=0.9331 $Y=0.045
cc_578 N_GCLK_53 N_4_51 0.000492118f $X=0.0665 $Y=0.045
cc_579 N_GCLK_54 N_4_59 0.000492118f $X=1.8347 $Y=0.045
cc_580 N_GCLK_55 N_4_58 0.000540764f $X=0.9331 $Y=0.045
cc_581 N_GCLK_55 N_4_53 0.000561043f $X=0.9331 $Y=0.045
cc_582 N_GCLK_49 N_4_62 0.000988665f $X=1.971 $Y=0.0495
cc_583 N_GCLK_44 N_4_61 0.00126782f $X=0.621 $Y=0.0495
cc_584 N_GCLK_53 N_4_50 0.00355154f $X=0.0665 $Y=0.045
cc_585 N_GCLK_54 N_4_60 0.00355591f $X=1.8347 $Y=0.045
cc_586 N_GCLK_55 N_4_63 0.00765837f $X=0.9331 $Y=0.045
cc_587 N_GCLK_55 N_4_56 0.0120854f $X=0.9331 $Y=0.045
cc_588 N_GCLK_53 N_4_61 0.0142518f $X=0.0665 $Y=0.045
cc_589 N_GCLK_54 N_4_62 0.0147514f $X=1.8347 $Y=0.045
cc_590 N_GCLK_54 N_CLK_52 2.35328e-20 $X=1.8347 $Y=0.045
cc_591 N_GCLK_54 N_CLK_53 2.63768e-20 $X=1.8347 $Y=0.045
cc_592 N_GCLK_54 N_CLK_42 3.74174e-20 $X=1.8347 $Y=0.045
cc_593 N_GCLK_55 N_CLK_47 3.75041e-20 $X=0.9331 $Y=0.045
cc_594 N_GCLK_54 N_CLK_50 4.28669e-20 $X=1.8347 $Y=0.045
cc_595 N_GCLK_55 N_CLK_34 5.20102e-20 $X=0.9331 $Y=0.045
cc_596 N_GCLK_51 N_CLK_39 5.58027e-20 $X=2.484 $Y=0.234
cc_597 N_GCLK_43 N_CLK_31 5.58551e-20 $X=0.108 $Y=0.234
cc_598 N_GCLK_53 N_CLK_30 0.000178839f $X=0.0665 $Y=0.045
cc_599 N_GCLK_54 N_CLK_38 0.000189866f $X=1.8347 $Y=0.045
cc_600 N_GCLK_55 N_CLK_46 7.9288e-20 $X=0.9331 $Y=0.045
cc_601 N_GCLK_41 N_CLK_1 8.06279e-20 $X=0.081 $Y=0.0495
cc_602 N_GCLK_55 N_CLK_45 0.000101664f $X=0.9331 $Y=0.045
cc_603 N_GCLK_53 N_CLK_41 0.000106774f $X=0.0665 $Y=0.045
cc_604 N_GCLK_54 N_CLK_51 0.000110696f $X=1.8347 $Y=0.045
cc_605 N_GCLK_36 N_CLK_53 0.000144813f $X=0.621 $Y=0.234
cc_606 N_GCLK_38 N_CLK_54 0.000144813f $X=1.971 $Y=0.234
cc_607 N_GCLK_46 N_CLK_53 0.000187107f $X=0.648 $Y=0.234
cc_608 N_GCLK_48 N_CLK_54 0.000187107f $X=1.944 $Y=0.234
cc_609 N_GCLK_44 N_CLK_53 0.00101942f $X=0.621 $Y=0.0495
cc_610 N_GCLK_49 N_CLK_54 0.00101942f $X=1.971 $Y=0.0495
cc_611 N_GCLK_55 N_CLK_55 0.00222019f $X=0.9331 $Y=0.045
cc_612 N_GCLK_53 N_CLK_53 0.00541588f $X=0.0665 $Y=0.045
cc_613 N_GCLK_54 N_CLK_54 0.00548091f $X=1.8347 $Y=0.045
cc_614 N_GCLK_3 N_6_18 9.06822e-20 $X=0.648 $Y=0.054
cc_615 N_GCLK_44 N_6_18 0.00111524f $X=0.621 $Y=0.0495
cc_616 N_GCLK_53 N_6_15 0.00104156f $X=0.0665 $Y=0.045
cc_617 N_GCLK_53 N_6_18 0.00213403f $X=0.0665 $Y=0.045
cc_618 N_GCLK_30 N_8_13 0.0136449f $X=0.6335 $Y=0.216
cc_619 N_GCLK_36 N_8_13 6.15538e-20 $X=0.621 $Y=0.234
cc_620 N_GCLK_35 N_8_13 6.66058e-20 $X=0.621 $Y=0.0315
cc_621 N_GCLK_46 N_8_13 9.45253e-20 $X=0.648 $Y=0.234
cc_622 N_GCLK_53 N_8_13 0.000124306f $X=0.0665 $Y=0.045
cc_623 N_GCLK_3 N_8_13 0.000231188f $X=0.648 $Y=0.054
cc_624 N_GCLK_4 N_8_13 0.000306077f $X=0.648 $Y=0.1755
cc_625 N_GCLK_46 N_8_22 0.00035403f $X=0.648 $Y=0.234
cc_626 N_GCLK_46 N_8_19 0.000378047f $X=0.648 $Y=0.234
cc_627 N_GCLK_4 N_8_1 0.00477243f $X=0.648 $Y=0.1755
cc_628 N_GCLK_26 N_8_12 0.000653922f $X=0.6335 $Y=0.054
cc_629 N_GCLK_53 N_8_17 0.00168052f $X=0.0665 $Y=0.045
cc_630 N_GCLK_46 N_8_18 0.00204596f $X=0.648 $Y=0.234
cc_631 N_GCLK_53 N_8_21 0.00221305f $X=0.0665 $Y=0.045
cc_632 N_GCLK_3 N_8_12 0.00276594f $X=0.648 $Y=0.054
cc_633 N_GCLK_4 N_8_12 0.00289445f $X=0.648 $Y=0.1755
cc_634 N_GCLK_45 N_8_17 0.00311549f $X=0.6345 $Y=0.036
cc_635 N_GCLK_44 N_8_20 0.00520558f $X=0.621 $Y=0.0495
cc_636 N_GCLK_30 N_8_12 0.0364f $X=0.6335 $Y=0.216
cc_637 N_GCLK_26 N_8_13 0.0496153f $X=0.6335 $Y=0.054
cc_638 N_GCLK_55 N_SE_5 0.0184992f $X=0.9331 $Y=0.045
cc_639 N_GCLK_31 N_14_12 0.0129862f $X=1.9295 $Y=0.216
cc_640 N_GCLK_38 N_14_12 6.15538e-20 $X=1.971 $Y=0.234
cc_641 N_GCLK_37 N_14_12 6.66058e-20 $X=1.971 $Y=0.0315
cc_642 N_GCLK_48 N_14_12 9.72702e-20 $X=1.944 $Y=0.234
cc_643 N_GCLK_54 N_14_12 0.000124306f $X=1.8347 $Y=0.045
cc_644 N_GCLK_5 N_14_12 0.000231188f $X=1.944 $Y=0.054
cc_645 N_GCLK_6 N_14_12 0.000306077f $X=1.944 $Y=0.1755
cc_646 N_GCLK_48 N_14_22 0.00035403f $X=1.944 $Y=0.234
cc_647 N_GCLK_48 N_14_17 0.000378047f $X=1.944 $Y=0.234
cc_648 N_GCLK_6 N_14_1 0.00477243f $X=1.944 $Y=0.1755
cc_649 N_GCLK_27 N_14_13 0.000653922f $X=1.9295 $Y=0.054
cc_650 N_GCLK_31 N_14_13 0.0370591f $X=1.9295 $Y=0.216
cc_651 N_GCLK_54 N_14_18 0.00166356f $X=1.8347 $Y=0.045
cc_652 N_GCLK_48 N_14_19 0.00204596f $X=1.944 $Y=0.234
cc_653 N_GCLK_54 N_14_21 0.00218057f $X=1.8347 $Y=0.045
cc_654 N_GCLK_5 N_14_13 0.00276594f $X=1.944 $Y=0.054
cc_655 N_GCLK_6 N_14_13 0.00289445f $X=1.944 $Y=0.1755
cc_656 N_GCLK_47 N_14_18 0.00311549f $X=1.9305 $Y=0.036
cc_657 N_GCLK_49 N_14_23 0.00520555f $X=1.971 $Y=0.0495
cc_658 N_GCLK_27 N_14_12 0.0496056f $X=1.9295 $Y=0.054
cc_659 N_GCLK_5 N_16_15 9.06822e-20 $X=1.944 $Y=0.054
cc_660 N_GCLK_49 N_16_15 0.00111524f $X=1.971 $Y=0.0495
cc_661 N_GCLK_54 N_16_17 0.00104225f $X=1.8347 $Y=0.045
cc_662 N_GCLK_54 N_16_15 0.00211685f $X=1.8347 $Y=0.045
cc_663 N_GCLK_32 N_17_12 0.00524557f $X=2.4695 $Y=0.2295
cc_664 N_GCLK_39 N_17_12 7.50525e-20 $X=2.511 $Y=0.0315
cc_665 N_GCLK_40 N_17_12 0.000101019f $X=2.511 $Y=0.234
cc_666 N_GCLK_54 N_17_12 0.00014947f $X=1.8347 $Y=0.045
cc_667 N_GCLK_51 N_17_12 0.000592746f $X=2.484 $Y=0.234
cc_668 N_GCLK_7 N_17_12 0.00379547f $X=2.484 $Y=0.0405
cc_669 N_GCLK_28 N_17_12 0.00803042f $X=2.4695 $Y=0.0405
cc_670 N_GCLK_8 N_17_1 0.00474581f $X=2.484 $Y=0.189
cc_671 N_GCLK_51 N_17_17 0.000559039f $X=2.484 $Y=0.234
cc_672 N_GCLK_51 N_17_19 0.00201874f $X=2.484 $Y=0.234
cc_673 N_GCLK_50 N_17_18 0.00308131f $X=2.4705 $Y=0.036
cc_674 N_GCLK_54 N_17_21 0.00443732f $X=1.8347 $Y=0.045
cc_675 N_GCLK_28 N_17_13 0.00475751f $X=2.4695 $Y=0.0405
cc_676 N_GCLK_52 N_17_23 0.00621459f $X=2.511 $Y=0.0495
cc_677 N_GCLK_32 N_17_13 0.00760124f $X=2.4695 $Y=0.2295
cc_678 N_GCLK_8 N_17_13 0.0178352f $X=2.484 $Y=0.189
cc_679 N_GCLK_8 N_17_12 0.0219901f $X=2.484 $Y=0.189
x_PM_ICGx4DC_ASAP7_75t_R%15 vss N_M31_g N_M72_g N_M32_g N_M73_g N_M72_d N_M73_d
+ N_M74_d N_M75_d N_15_18 N_15_9 N_15_12 N_15_16 N_15_10 N_15_4 N_15_1 N_15_13
+ PM_ICGx4DC_ASAP7_75t_R%15
cc_680 N_15_18 N_CLK_54 0.00531918f $X=2.106 $Y=0.171
cc_681 N_15_9 N_14_1 0.00130561f $X=2.025 $Y=0.0245
cc_682 N_15_9 N_14_13 0.00340119f $X=2.025 $Y=0.0245
x_PM_ICGx4DC_ASAP7_75t_R%19 vss N_M19_d N_M20_s N_19_1 N_19_4 N_19_5
+ PM_ICGx4DC_ASAP7_75t_R%19
cc_683 N_19_1 N_4_53 6.47833e-20 $X=1.269 $Y=0.0675
cc_684 N_19_1 N_4_35 0.000676826f $X=1.269 $Y=0.0675
cc_685 N_19_1 N_4_20 0.00113637f $X=1.269 $Y=0.0675
cc_686 N_19_1 N_4_34 0.00178849f $X=1.269 $Y=0.0675
cc_687 N_19_4 N_CLK_46 0.000226859f $X=1.2275 $Y=0.0675
cc_688 N_19_4 N_CLK_4 0.00202585f $X=1.2275 $Y=0.0675
cc_689 N_19_4 N_CLK_23 0.0725169f $X=1.2275 $Y=0.0675
cc_690 N_19_4 N_11_1 0.000637199f $X=1.2275 $Y=0.0675
cc_691 N_19_4 N_11_16 0.000650421f $X=1.2275 $Y=0.0675
cc_692 N_19_4 N_11_9 0.035209f $X=1.2275 $Y=0.0675
cc_693 N_19_5 N_12_1 0.000674742f $X=1.298 $Y=0.0675
cc_694 N_19_5 N_12_22 0.0028189f $X=1.298 $Y=0.0675
cc_695 N_19_5 N_12_15 0.0333461f $X=1.298 $Y=0.0675

* End of included file ICGx4DC_ASAP7_75t_R.pex.sp.pxi
.ends

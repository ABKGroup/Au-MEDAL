.subckt PM_ICGx5_ASAP7_75t_R%13 vss 6 7 3 1
c1 1 vss 0.00454994f $X=0.216 $Y=0.2025
c2 3 vss 0.00309909f $X=0.2015 $Y=0.2025
r1 7 5 0.0308642 $w=8.1e-08 $l=2.5e-09 $layer=P_src_drn $thickness=1e-09
+ $X=0.2333 $Y=0.2025 $X2=0.2305 $Y2=0.2025
r2 1 5 0.179012 $w=8.1e-08 $l=1.45e-08 $layer=P_src_drn $thickness=1e-09
+ $X=0.216 $Y=0.2025 $X2=0.2305 $Y2=0.2025
r3 3 1 0.179012 $w=8.1e-08 $l=1.45e-08 $layer=P_src_drn $thickness=1e-09
+ $X=0.2015 $Y=0.2025 $X2=0.216 $Y2=0.2025
r4 6 3 0.0308642 $w=8.1e-08 $l=2.5e-09 $layer=P_src_drn $thickness=1e-09
+ $X=0.1986 $Y=0.2025 $X2=0.2015 $Y2=0.2025
.ends

.subckt PM_ICGx5_ASAP7_75t_R%16__2 vss 2 3 1
c1 1 vss 0.000790131f $X=0.702 $Y=0.0675
r1 2 1 0.209877 $w=8.1e-08 $l=1.7e-08 $layer=N_src_drn $thickness=1e-09
+ $X=0.6846 $Y=0.0675 $X2=0.702 $Y2=0.0675
r2 3 1 0.209877 $w=8.1e-08 $l=1.7e-08 $layer=N_src_drn $thickness=1e-09
+ $X=0.7193 $Y=0.0675 $X2=0.702 $Y2=0.0675
.ends

.subckt PM_ICGx5_ASAP7_75t_R%GCLK vss 42 32 33 47 48 50 60 61 64 65 67 19 20 23
+ 28 27 1 3 4 2 24 21 22
c1 1 vss 0.00838677f $X=0.918 $Y=0.0675
c2 2 vss 0.00823492f $X=0.918 $Y=0.2025
c3 3 vss 0.0087819f $X=1.026 $Y=0.0675
c4 4 vss 0.0087392f $X=1.026 $Y=0.2025
c5 5 vss 0.00805908f $X=1.134 $Y=0.0675
c6 6 vss 0.007989f $X=1.134 $Y=0.2025
c7 19 vss 0.00440855f $X=0.9035 $Y=0.0675
c8 20 vss 0.00445321f $X=1.0115 $Y=0.0675
c9 21 vss 0.0366014f $X=1.1195 $Y=0.0675
c10 22 vss 0.00433828f $X=0.9035 $Y=0.2025
c11 23 vss 0.00445853f $X=1.0115 $Y=0.2025
c12 24 vss 0.0366305f $X=1.1195 $Y=0.2025
c13 25 vss 0.00262591f $X=1.161 $Y=0.036
c14 26 vss 0.00262591f $X=1.161 $Y=0.234
c15 27 vss 0.0237862f $X=0.8945 $Y=0.036
c16 28 vss 0.0233358f $X=0.9045 $Y=0.234
c17 29 vss 0.00487172f $X=1.161 $Y=0.054
r1 24 6 0.154321 $w=8.1e-08 $l=1.25e-08 $layer=P_src_drn $thickness=1e-09
+ $X=1.1195 $Y=0.2025 $X2=1.134 $Y2=0.2025
r2 67 24 0.0308642 $w=8.1e-08 $l=2.5e-09 $layer=P_src_drn $thickness=1e-09
+ $X=1.1166 $Y=0.2025 $X2=1.1195 $Y2=0.2025
r3 65 63 0.0308642 $w=8.1e-08 $l=2.5e-09 $layer=P_src_drn $thickness=1e-09
+ $X=1.0433 $Y=0.2025 $X2=1.0405 $Y2=0.2025
r4 4 63 0.179012 $w=8.1e-08 $l=1.45e-08 $layer=P_src_drn $thickness=1e-09
+ $X=1.026 $Y=0.2025 $X2=1.0405 $Y2=0.2025
r5 23 4 0.179012 $w=8.1e-08 $l=1.45e-08 $layer=P_src_drn $thickness=1e-09
+ $X=1.0115 $Y=0.2025 $X2=1.026 $Y2=0.2025
r6 64 23 0.0308642 $w=8.1e-08 $l=2.5e-09 $layer=P_src_drn $thickness=1e-09
+ $X=1.0086 $Y=0.2025 $X2=1.0115 $Y2=0.2025
r7 61 59 0.0308642 $w=8.1e-08 $l=2.5e-09 $layer=P_src_drn $thickness=1e-09
+ $X=0.9353 $Y=0.2025 $X2=0.9325 $Y2=0.2025
r8 2 59 0.179012 $w=8.1e-08 $l=1.45e-08 $layer=P_src_drn $thickness=1e-09
+ $X=0.918 $Y=0.2025 $X2=0.9325 $Y2=0.2025
r9 22 2 0.179012 $w=8.1e-08 $l=1.45e-08 $layer=P_src_drn $thickness=1e-09
+ $X=0.9035 $Y=0.2025 $X2=0.918 $Y2=0.2025
r10 60 22 0.0308642 $w=8.1e-08 $l=2.5e-09 $layer=P_src_drn $thickness=1e-09
+ $X=0.9006 $Y=0.2025 $X2=0.9035 $Y2=0.2025
r11 6 55 19.3796 $a=3.24e-16 $layer=V0LISD $X=1.134 $Y=0.2025 $X2=1.134
+ $Y2=0.234
r12 4 53 19.3796 $a=3.24e-16 $layer=V0LISD $X=1.026 $Y=0.2025 $X2=1.026
+ $Y2=0.234
r13 2 51 19.3796 $a=3.24e-16 $layer=V0LISD $X=0.918 $Y=0.2025 $X2=0.918
+ $Y2=0.234
r14 55 56 3.14806 $w=1.3e-08 $l=1.35e-08 $layer=M1 $thickness=3.6e-08 $X=1.134
+ $Y=0.234 $X2=1.1475 $Y2=0.234
r15 54 55 12.5922 $w=1.3e-08 $l=5.4e-08 $layer=M1 $thickness=3.6e-08 $X=1.08
+ $Y=0.234 $X2=1.134 $Y2=0.234
r16 53 54 12.5922 $w=1.3e-08 $l=5.4e-08 $layer=M1 $thickness=3.6e-08 $X=1.026
+ $Y=0.234 $X2=1.08 $Y2=0.234
r17 52 53 12.5922 $w=1.3e-08 $l=5.4e-08 $layer=M1 $thickness=3.6e-08 $X=0.972
+ $Y=0.234 $X2=1.026 $Y2=0.234
r18 51 52 12.5922 $w=1.3e-08 $l=5.4e-08 $layer=M1 $thickness=3.6e-08 $X=0.918
+ $Y=0.234 $X2=0.972 $Y2=0.234
r19 28 51 3.14806 $w=1.3e-08 $l=1.35e-08 $layer=M1 $thickness=3.6e-08 $X=0.9045
+ $Y=0.234 $X2=0.918 $Y2=0.234
r20 26 44 2.6649 $w=1.77676e-08 $l=1.85e-08 $layer=M1 $thickness=3.6e-08
+ $X=1.161 $Y=0.234 $X2=1.161 $Y2=0.2155
r21 26 56 1.49895 $w=1.63333e-08 $l=1.35e-08 $layer=M1 $thickness=3.6e-08
+ $X=1.161 $Y=0.234 $X2=1.1475 $Y2=0.234
r22 21 5 0.154321 $w=8.1e-08 $l=1.25e-08 $layer=N_src_drn $thickness=1e-09
+ $X=1.1195 $Y=0.0675 $X2=1.134 $Y2=0.0675
r23 50 21 0.0308642 $w=8.1e-08 $l=2.5e-09 $layer=N_src_drn $thickness=1e-09
+ $X=1.1166 $Y=0.0675 $X2=1.1195 $Y2=0.0675
r24 48 46 0.0308642 $w=8.1e-08 $l=2.5e-09 $layer=N_src_drn $thickness=1e-09
+ $X=1.0433 $Y=0.0675 $X2=1.0405 $Y2=0.0675
r25 3 46 0.179012 $w=8.1e-08 $l=1.45e-08 $layer=N_src_drn $thickness=1e-09
+ $X=1.026 $Y=0.0675 $X2=1.0405 $Y2=0.0675
r26 20 3 0.179012 $w=8.1e-08 $l=1.45e-08 $layer=N_src_drn $thickness=1e-09
+ $X=1.0115 $Y=0.0675 $X2=1.026 $Y2=0.0675
r27 47 20 0.0308642 $w=8.1e-08 $l=2.5e-09 $layer=N_src_drn $thickness=1e-09
+ $X=1.0086 $Y=0.0675 $X2=1.0115 $Y2=0.0675
r28 43 44 6.8208 $w=1.3e-08 $l=2.93e-08 $layer=M1 $thickness=3.6e-08 $X=1.161
+ $Y=0.1862 $X2=1.161 $Y2=0.2155
r29 42 43 4.72209 $w=1.3e-08 $l=2.02e-08 $layer=M1 $thickness=3.6e-08 $X=1.163
+ $Y=0.166 $X2=1.161 $Y2=0.1862
r30 42 41 12.0676 $w=1.3e-08 $l=5.18e-08 $layer=M1 $thickness=3.6e-08 $X=1.163
+ $Y=0.166 $X2=1.161 $Y2=0.1142
r31 29 41 14.0497 $w=1.3e-08 $l=6.02e-08 $layer=M1 $thickness=3.6e-08 $X=1.161
+ $Y=0.054 $X2=1.161 $Y2=0.1142
r32 5 39 19.3796 $a=3.24e-16 $layer=V0LISD $X=1.134 $Y=0.0675 $X2=1.134
+ $Y2=0.036
r33 3 37 19.3796 $a=3.24e-16 $layer=V0LISD $X=1.026 $Y=0.0675 $X2=1.026
+ $Y2=0.036
r34 25 40 1.49895 $w=1.63333e-08 $l=1.35e-08 $layer=M1 $thickness=3.6e-08
+ $X=1.161 $Y=0.036 $X2=1.1475 $Y2=0.036
r35 25 29 2.5483 $w=1.79e-08 $l=1.8e-08 $layer=M1 $thickness=3.6e-08 $X=1.161
+ $Y=0.036 $X2=1.161 $Y2=0.054
r36 39 40 3.14806 $w=1.3e-08 $l=1.35e-08 $layer=M1 $thickness=3.6e-08 $X=1.134
+ $Y=0.036 $X2=1.1475 $Y2=0.036
r37 38 39 12.5922 $w=1.3e-08 $l=5.4e-08 $layer=M1 $thickness=3.6e-08 $X=1.08
+ $Y=0.036 $X2=1.134 $Y2=0.036
r38 37 38 12.5922 $w=1.3e-08 $l=5.4e-08 $layer=M1 $thickness=3.6e-08 $X=1.026
+ $Y=0.036 $X2=1.08 $Y2=0.036
r39 36 37 12.5922 $w=1.3e-08 $l=5.4e-08 $layer=M1 $thickness=3.6e-08 $X=0.972
+ $Y=0.036 $X2=1.026 $Y2=0.036
r40 35 36 12.5922 $w=1.3e-08 $l=5.4e-08 $layer=M1 $thickness=3.6e-08 $X=0.918
+ $Y=0.036 $X2=0.972 $Y2=0.036
r41 34 35 3.14806 $w=1.3e-08 $l=1.35e-08 $layer=M1 $thickness=3.6e-08 $X=0.9045
+ $Y=0.036 $X2=0.918 $Y2=0.036
r42 27 34 2.3319 $w=1.3e-08 $l=1e-08 $layer=M1 $thickness=3.6e-08 $X=0.8945
+ $Y=0.036 $X2=0.9045 $Y2=0.036
r43 1 35 19.3796 $a=3.24e-16 $layer=V0LISD $X=0.918 $Y=0.0675 $X2=0.918
+ $Y2=0.036
r44 33 31 0.0308642 $w=8.1e-08 $l=2.5e-09 $layer=N_src_drn $thickness=1e-09
+ $X=0.9353 $Y=0.0675 $X2=0.9325 $Y2=0.0675
r45 1 31 0.179012 $w=8.1e-08 $l=1.45e-08 $layer=N_src_drn $thickness=1e-09
+ $X=0.918 $Y=0.0675 $X2=0.9325 $Y2=0.0675
r46 19 1 0.179012 $w=8.1e-08 $l=1.45e-08 $layer=N_src_drn $thickness=1e-09
+ $X=0.9035 $Y=0.0675 $X2=0.918 $Y2=0.0675
r47 32 19 0.0308642 $w=8.1e-08 $l=2.5e-09 $layer=N_src_drn $thickness=1e-09
+ $X=0.9006 $Y=0.0675 $X2=0.9035 $Y2=0.0675
.ends

.subckt PM_ICGx5_ASAP7_75t_R%10 vss 27 31 50 53 56 59 62 65 69 73 85 86 94 95
+ 98 99 17 19 18 24 3 5 23 4 25 20 1 26 12 22 16 15 21 14 13
c1 1 vss 0.023566f $X=0.8815 $Y=0.136
c2 3 vss 0.0106189f $X=0.702 $Y=0.216
c3 4 vss 0.00780584f $X=0.756 $Y=0.0675
c4 5 vss 0.0102409f $X=0.81 $Y=0.216
c5 12 vss 0.103531f $X=0.891 $Y=0.0245
c6 13 vss 0.0819733f $X=0.945 $Y=0.136
c7 14 vss 0.0817499f $X=0.999 $Y=0.136
c8 15 vss 0.0817412f $X=1.053 $Y=0.136
c9 16 vss 0.0812683f $X=1.107 $Y=0.136
c10 17 vss 0.00731413f $X=0.7415 $Y=0.0675
c11 18 vss 0.00844458f $X=0.6875 $Y=0.216
c12 19 vss 0.00836639f $X=0.7955 $Y=0.216
c13 20 vss 0.00486557f $X=0.837 $Y=0.192
c14 21 vss 0.00241294f $X=0.891 $Y=0.072
c15 22 vss 0.00226926f $X=0.891 $Y=0.197
c16 23 vss 0.0130857f $X=0.783 $Y=0.231
c17 24 vss 0.00735995f $X=0.864 $Y=0.072
c18 25 vss 0.0030152f $X=0.864 $Y=0.197
c19 26 vss 0.00368037f $X=0.891 $Y=0.113
r1 99 97 0.0462963 $w=5.4e-08 $l=2.5e-09 $layer=P_src_drn $thickness=1e-09
+ $X=0.7193 $Y=0.216 $X2=0.7165 $Y2=0.216
r2 3 97 0.268519 $w=5.4e-08 $l=1.45e-08 $layer=P_src_drn $thickness=1e-09
+ $X=0.702 $Y=0.216 $X2=0.7165 $Y2=0.216
r3 18 3 0.268519 $w=5.4e-08 $l=1.45e-08 $layer=P_src_drn $thickness=1e-09
+ $X=0.6875 $Y=0.216 $X2=0.702 $Y2=0.216
r4 98 18 0.0462963 $w=5.4e-08 $l=2.5e-09 $layer=P_src_drn $thickness=1e-09
+ $X=0.6846 $Y=0.216 $X2=0.6875 $Y2=0.216
r5 95 93 0.0462963 $w=5.4e-08 $l=2.5e-09 $layer=P_src_drn $thickness=1e-09
+ $X=0.8273 $Y=0.216 $X2=0.8245 $Y2=0.216
r6 5 93 0.268519 $w=5.4e-08 $l=1.45e-08 $layer=P_src_drn $thickness=1e-09
+ $X=0.81 $Y=0.216 $X2=0.8245 $Y2=0.216
r7 19 5 0.268519 $w=5.4e-08 $l=1.45e-08 $layer=P_src_drn $thickness=1e-09
+ $X=0.7955 $Y=0.216 $X2=0.81 $Y2=0.216
r8 94 19 0.0462963 $w=5.4e-08 $l=2.5e-09 $layer=P_src_drn $thickness=1e-09
+ $X=0.7926 $Y=0.216 $X2=0.7955 $Y2=0.216
r9 3 90 19.3796 $a=3.24e-16 $layer=V0LISD $X=0.702 $Y=0.216 $X2=0.702 $Y2=0.231
r10 5 87 19.3796 $a=3.24e-16 $layer=V0LISD $X=0.81 $Y=0.216 $X2=0.81 $Y2=0.231
r11 90 91 8.39483 $w=1.3e-08 $l=3.6e-08 $layer=M1 $thickness=3.6e-08 $X=0.702
+ $Y=0.231 $X2=0.738 $Y2=0.231
r12 87 88 3.14806 $w=1.3e-08 $l=1.35e-08 $layer=M1 $thickness=3.6e-08 $X=0.81
+ $Y=0.231 $X2=0.8235 $Y2=0.231
r13 23 87 6.29612 $w=1.3e-08 $l=2.7e-08 $layer=M1 $thickness=3.6e-08 $X=0.783
+ $Y=0.231 $X2=0.81 $Y2=0.231
r14 23 91 10.4935 $w=1.3e-08 $l=4.5e-08 $layer=M1 $thickness=3.6e-08 $X=0.783
+ $Y=0.231 $X2=0.738 $Y2=0.231
r15 85 84 0.0308642 $w=8.1e-08 $l=2.5e-09 $layer=N_src_drn $thickness=1e-09
+ $X=0.7733 $Y=0.0675 $X2=0.7705 $Y2=0.0675
r16 4 84 0.179012 $w=8.1e-08 $l=1.45e-08 $layer=N_src_drn $thickness=1e-09
+ $X=0.756 $Y=0.0675 $X2=0.7705 $Y2=0.0675
r17 17 4 0.179012 $w=8.1e-08 $l=1.45e-08 $layer=N_src_drn $thickness=1e-09
+ $X=0.7415 $Y=0.0675 $X2=0.756 $Y2=0.0675
r18 86 17 0.0308642 $w=8.1e-08 $l=2.5e-09 $layer=N_src_drn $thickness=1e-09
+ $X=0.7386 $Y=0.0675 $X2=0.7415 $Y2=0.0675
r19 81 88 1.20242 $w=1.425e-08 $l=1.54434e-08 $layer=M1 $thickness=3.6e-08
+ $X=0.837 $Y=0.2235 $X2=0.8235 $Y2=0.231
r20 80 81 2.01858 $w=1.37895e-08 $l=9.5e-09 $layer=M1 $thickness=3.6e-08
+ $X=0.837 $Y=0.214 $X2=0.837 $Y2=0.2235
r21 79 80 2.37574 $w=1.49231e-08 $l=1.3e-08 $layer=M1 $thickness=3.6e-08
+ $X=0.837 $Y=0.201 $X2=0.837 $Y2=0.214
r22 20 25 4.60559 $w=1.39091e-08 $l=2.74591e-08 $layer=M1 $thickness=3.6e-08
+ $X=0.837 $Y=0.192 $X2=0.864 $Y2=0.197
r23 20 79 0.9184 $w=1.8e-08 $l=9e-09 $layer=M1 $thickness=3.6e-08 $X=0.837
+ $Y=0.192 $X2=0.837 $Y2=0.201
r24 4 77 19.3796 $a=3.24e-16 $layer=V0LISD $X=0.756 $Y=0.0675 $X2=0.756
+ $Y2=0.072
r25 77 78 9.44419 $w=1.3e-08 $l=4.05e-08 $layer=M1 $thickness=3.6e-08 $X=0.756
+ $Y=0.072 $X2=0.7965 $Y2=0.072
r26 75 78 9.44419 $w=1.3e-08 $l=4.05e-08 $layer=M1 $thickness=3.6e-08 $X=0.837
+ $Y=0.072 $X2=0.7965 $Y2=0.072
r27 24 75 6.29612 $w=1.3e-08 $l=2.7e-08 $layer=M1 $thickness=3.6e-08 $X=0.864
+ $Y=0.072 $X2=0.837 $Y2=0.072
r28 22 48 5.22999 $w=1.59898e-08 $l=2.95e-08 $layer=M1 $thickness=3.6e-08
+ $X=0.891 $Y=0.197 $X2=0.891 $Y2=0.1675
r29 22 25 4.64701 $w=1.46667e-08 $l=2.7e-08 $layer=M1 $thickness=3.6e-08
+ $X=0.891 $Y=0.197 $X2=0.864 $Y2=0.197
r30 21 47 2.5483 $w=1.79e-08 $l=1.8e-08 $layer=M1 $thickness=3.6e-08 $X=0.891
+ $Y=0.072 $X2=0.891 $Y2=0.09
r31 21 24 4.64701 $w=1.46667e-08 $l=2.7e-08 $layer=M1 $thickness=3.6e-08
+ $X=0.891 $Y=0.072 $X2=0.864 $Y2=0.072
r32 73 72 14.6259 $w=2.1e-08 $l=4.3e-08 $layer=Gate_1 $thickness=5.6e-08
+ $X=1.107 $Y=0.2025 $X2=1.107 $Y2=0.1595
r33 71 72 2.55104 $w=2.1e-08 $l=7.5e-09 $layer=Gate_1 $thickness=5.6e-08
+ $X=1.107 $Y=0.152 $X2=1.107 $Y2=0.1595
r34 69 70 14.6259 $w=2.1e-08 $l=4.3e-08 $layer=Gate_1 $thickness=5.6e-08
+ $X=1.107 $Y=0.0675 $X2=1.107 $Y2=0.1105
r35 67 70 2.89117 $w=2.1e-08 $l=8.5e-09 $layer=Gate_1 $thickness=5.6e-08
+ $X=1.107 $Y=0.119 $X2=1.107 $Y2=0.1105
r36 16 43 6.54019 $w=2.09524e-08 $layer=Gate_1 $thickness=5.21905e-08 $X=1.107
+ $Y=0.136 $X2=1.107 $Y2=0.136
r37 16 67 5.96942 $w=2.03529e-08 $l=1.7e-08 $layer=Gate_1 $thickness=5.6e-08
+ $X=1.107 $Y=0.136 $X2=1.107 $Y2=0.119
r38 16 71 5.62929 $w=2.03125e-08 $l=1.6e-08 $layer=Gate_1 $thickness=5.6e-08
+ $X=1.107 $Y=0.136 $X2=1.107 $Y2=0.152
r39 65 64 16.3266 $w=2.1e-08 $l=4.8e-08 $layer=Gate_1 $thickness=5.6e-08
+ $X=1.053 $Y=0.2025 $X2=1.053 $Y2=0.1545
r40 62 63 16.6668 $w=2.1e-08 $l=4.9e-08 $layer=Gate_1 $thickness=5.6e-08
+ $X=1.053 $Y=0.0675 $X2=1.053 $Y2=0.1165
r41 15 41 6.54019 $w=2.09524e-08 $layer=Gate_1 $thickness=5.21905e-08 $X=1.053
+ $Y=0.136 $X2=1.053 $Y2=0.136
r42 15 63 6.81977 $w=2.04359e-08 $l=1.95e-08 $layer=Gate_1 $thickness=5.6e-08
+ $X=1.053 $Y=0.136 $X2=1.053 $Y2=0.1165
r43 15 64 6.47963 $w=2.04054e-08 $l=1.85e-08 $layer=Gate_1 $thickness=5.6e-08
+ $X=1.053 $Y=0.136 $X2=1.053 $Y2=0.1545
r44 59 58 16.3266 $w=2.1e-08 $l=4.8e-08 $layer=Gate_1 $thickness=5.6e-08
+ $X=0.999 $Y=0.2025 $X2=0.999 $Y2=0.1545
r45 56 57 16.6668 $w=2.1e-08 $l=4.9e-08 $layer=Gate_1 $thickness=5.6e-08
+ $X=0.999 $Y=0.0675 $X2=0.999 $Y2=0.1165
r46 14 39 6.54019 $w=2.09524e-08 $layer=Gate_1 $thickness=5.21905e-08 $X=0.999
+ $Y=0.136 $X2=0.999 $Y2=0.136
r47 14 57 6.81977 $w=2.04359e-08 $l=1.95e-08 $layer=Gate_1 $thickness=5.6e-08
+ $X=0.999 $Y=0.136 $X2=0.999 $Y2=0.1165
r48 14 58 6.47963 $w=2.04054e-08 $l=1.85e-08 $layer=Gate_1 $thickness=5.6e-08
+ $X=0.999 $Y=0.136 $X2=0.999 $Y2=0.1545
r49 53 52 16.3266 $w=2.1e-08 $l=4.8e-08 $layer=Gate_1 $thickness=5.6e-08
+ $X=0.945 $Y=0.2025 $X2=0.945 $Y2=0.1545
r50 50 51 16.6668 $w=2.1e-08 $l=4.9e-08 $layer=Gate_1 $thickness=5.6e-08
+ $X=0.945 $Y=0.0675 $X2=0.945 $Y2=0.1165
r51 13 37 6.54019 $w=2.09524e-08 $layer=Gate_1 $thickness=5.21905e-08 $X=0.945
+ $Y=0.136 $X2=0.945 $Y2=0.136
r52 13 51 6.81977 $w=2.04359e-08 $l=1.95e-08 $layer=Gate_1 $thickness=5.6e-08
+ $X=0.945 $Y=0.136 $X2=0.945 $Y2=0.1165
r53 13 52 6.47963 $w=2.04054e-08 $l=1.85e-08 $layer=Gate_1 $thickness=5.6e-08
+ $X=0.945 $Y=0.136 $X2=0.945 $Y2=0.1545
r54 46 48 5.01358 $w=1.3e-08 $l=2.15e-08 $layer=M1 $thickness=3.6e-08 $X=0.891
+ $Y=0.146 $X2=0.891 $Y2=0.1675
r55 45 46 2.3319 $w=1.3e-08 $l=1e-08 $layer=M1 $thickness=3.6e-08 $X=0.891
+ $Y=0.136 $X2=0.891 $Y2=0.146
r56 26 45 5.36336 $w=1.3e-08 $l=2.3e-08 $layer=M1 $thickness=3.6e-08 $X=0.891
+ $Y=0.113 $X2=0.891 $Y2=0.136
r57 26 47 5.36336 $w=1.3e-08 $l=2.3e-08 $layer=M1 $thickness=3.6e-08 $X=0.891
+ $Y=0.113 $X2=0.891 $Y2=0.09
r58 42 43 12.6539 $w=1.77815e-08 $l=2.7e-08 $layer=LIG $thickness=4.8e-08
+ $X=1.08 $Y=0.136 $X2=1.107 $Y2=0.136
r59 41 42 12.6539 $w=1.77815e-08 $l=2.7e-08 $layer=LIG $thickness=4.8e-08
+ $X=1.053 $Y=0.136 $X2=1.08 $Y2=0.136
r60 40 41 12.6539 $w=1.77815e-08 $l=2.7e-08 $layer=LIG $thickness=4.8e-08
+ $X=1.026 $Y=0.136 $X2=1.053 $Y2=0.136
r61 39 40 12.6539 $w=1.77815e-08 $l=2.7e-08 $layer=LIG $thickness=4.8e-08
+ $X=0.999 $Y=0.136 $X2=1.026 $Y2=0.136
r62 38 39 12.6539 $w=1.77815e-08 $l=2.7e-08 $layer=LIG $thickness=4.8e-08
+ $X=0.972 $Y=0.136 $X2=0.999 $Y2=0.136
r63 37 38 12.6539 $w=1.77815e-08 $l=2.7e-08 $layer=LIG $thickness=4.8e-08
+ $X=0.945 $Y=0.136 $X2=0.972 $Y2=0.136
r64 36 37 12.6539 $w=1.77815e-08 $l=2.7e-08 $layer=LIG $thickness=4.8e-08
+ $X=0.918 $Y=0.136 $X2=0.945 $Y2=0.136
r65 34 36 10.1729 $w=1.54914e-08 $l=1.75e-08 $layer=LIG $thickness=4.8e-08
+ $X=0.9005 $Y=0.136 $X2=0.918 $Y2=0.136
r66 33 34 2.48102 $w=2.2e-08 $l=9.5e-09 $layer=LIG $thickness=4.8e-08 $X=0.891
+ $Y=0.136 $X2=0.9005 $Y2=0.136
r67 33 45 19.3796 $a=3.24e-16 $layer=V0LIG $X=0.891 $Y=0.136 $X2=0.891 $Y2=0.136
r68 1 33 2.48102 $w=2.2e-08 $l=9.5e-09 $layer=LIG $thickness=4.8e-08 $X=0.8815
+ $Y=0.136 $X2=0.891 $Y2=0.136
r69 31 30 16.3266 $w=2.1e-08 $l=4.8e-08 $layer=Gate_1 $thickness=5.6e-08
+ $X=0.891 $Y=0.2025 $X2=0.891 $Y2=0.1545
r70 29 30 6.47963 $w=2.04054e-08 $l=1.85e-08 $layer=Gate_1 $thickness=5.6e-08
+ $X=0.891 $Y=0.136 $X2=0.891 $Y2=0.1545
r71 29 34 4.05918 $w=2.0087e-08 $l=9.5e-09 $layer=Gate_1 $thickness=5.56522e-08
+ $X=0.891 $Y=0.136 $X2=0.9005 $Y2=0.136
r72 29 33 6.27904 $w=2.09e-08 $layer=Gate_1 $thickness=5.24e-08 $X=0.891
+ $Y=0.136 $X2=0.891 $Y2=0.136
r73 28 29 6.81977 $w=2.04359e-08 $l=1.95e-08 $layer=Gate_1 $thickness=5.6e-08
+ $X=0.891 $Y=0.1165 $X2=0.891 $Y2=0.136
r74 27 28 16.6668 $w=2.1e-08 $l=4.9e-08 $layer=Gate_1 $thickness=5.6e-08
+ $X=0.891 $Y=0.0675 $X2=0.891 $Y2=0.1165
r75 27 12 14.6259 $w=2.1e-08 $l=4.3e-08 $layer=Gate_1 $thickness=5.6e-08
+ $X=0.891 $Y=0.0675 $X2=0.891 $Y2=0.0245
.ends

.subckt PM_ICGx5_ASAP7_75t_R%17 vss 2 3 1
c1 1 vss 0.000779366f $X=0.81 $Y=0.0675
r1 2 1 0.209877 $w=8.1e-08 $l=1.7e-08 $layer=N_src_drn $thickness=1e-09
+ $X=0.7926 $Y=0.0675 $X2=0.81 $Y2=0.0675
r2 3 1 0.209877 $w=8.1e-08 $l=1.7e-08 $layer=N_src_drn $thickness=1e-09
+ $X=0.8273 $Y=0.0675 $X2=0.81 $Y2=0.0675
.ends

.subckt PM_ICGx5_ASAP7_75t_R%14 vss 7 12 4 1 5
c1 1 vss 0.00605979f $X=0.324 $Y=0.2295
c2 4 vss 0.00168524f $X=0.3095 $Y=0.2295
c3 5 vss 0.00207735f $X=0.38 $Y=0.2295
r1 12 11 0.0925926 $w=2.7e-08 $l=2.5e-09 $layer=P_src_drn $thickness=1e-09
+ $X=0.3953 $Y=0.2295 $X2=0.3925 $Y2=0.2295
r2 5 11 0.462963 $w=2.7e-08 $l=1.25e-08 $layer=P_src_drn $thickness=1e-09
+ $X=0.38 $Y=0.2295 $X2=0.3925 $Y2=0.2295
r3 9 5 9.87715 $w=2.32e-08 $l=2.1e-08 $layer=LISD $thickness=2.7e-08 $X=0.357
+ $Y=0.2295 $X2=0.38 $Y2=0.2295
r4 8 9 7.05511 $w=2.32e-08 $l=1.5e-08 $layer=LISD $thickness=2.7e-08 $X=0.342
+ $Y=0.2295 $X2=0.357 $Y2=0.2295
r5 1 8 8.46613 $w=2.32e-08 $l=1.8e-08 $layer=LISD $thickness=2.7e-08 $X=0.324
+ $Y=0.2295 $X2=0.342 $Y2=0.2295
r6 4 1 0.462963 $w=2.7e-08 $l=1.25e-08 $layer=P_src_drn $thickness=1e-09
+ $X=0.3095 $Y=0.2295 $X2=0.324 $Y2=0.2295
r7 7 4 0.0925926 $w=2.7e-08 $l=2.5e-09 $layer=P_src_drn $thickness=1e-09
+ $X=0.3066 $Y=0.2295 $X2=0.3095 $Y2=0.2295
.ends

.subckt PM_ICGx5_ASAP7_75t_R%7 vss 21 25 55 57 11 16 3 17 18 1 10 15 13 12 14 4
+ 9
c1 1 vss 0.00038402f $X=0.297 $Y=0.1335
c2 3 vss 0.00673934f $X=0.594 $Y=0.0605
c3 4 vss 0.00837598f $X=0.594 $Y=0.2295
c4 9 vss 0.00767042f $X=0.297 $Y=0.0245
c5 10 vss 0.0453706f $X=0.596 $Y=0.0675
c6 11 vss 0.0452552f $X=0.596 $Y=0.2025
c7 12 vss 0.0032241f $X=0.297 $Y=0.081
c8 13 vss 0.000737982f $X=0.2945 $Y=0.189
c9 14 vss 0.00136686f $X=0.568 $Y=0.086
c10 15 vss 0.00601205f $X=0.568 $Y=0.232
c11 16 vss 0.00113537f $X=0.297 $Y=0.1045
c12 17 vss 0.00209594f $X=0.568 $Y=0.148
c13 18 vss 0.0150002f $X=0.2985 $Y=0.189
r1 57 56 0.0308642 $w=8.1e-08 $l=2.5e-09 $layer=P_src_drn $thickness=1e-09
+ $X=0.6113 $Y=0.2025 $X2=0.6085 $Y2=0.2025
r2 11 56 0.154321 $w=8.1e-08 $l=1.25e-08 $layer=P_src_drn $thickness=1e-09
+ $X=0.596 $Y=0.2025 $X2=0.6085 $Y2=0.2025
r3 55 54 0.0308642 $w=8.1e-08 $l=2.5e-09 $layer=N_src_drn $thickness=1e-09
+ $X=0.6113 $Y=0.0675 $X2=0.6085 $Y2=0.0675
r4 10 54 0.154321 $w=8.1e-08 $l=1.25e-08 $layer=N_src_drn $thickness=1e-09
+ $X=0.596 $Y=0.0675 $X2=0.6085 $Y2=0.0675
r5 4 50 19.3796 $a=3.24e-16 $layer=V0LISD $X=0.594 $Y=0.2295 $X2=0.594 $Y2=0.232
r6 4 11 23.8708 $w=2.02e-08 $l=4.05e-08 $layer=LISD $thickness=2.7e-08 $X=0.594
+ $Y=0.2295 $X2=0.596 $Y2=0.2025
r7 3 47 19.3796 $a=3.24e-16 $layer=V0LISD $X=0.594 $Y=0.0605 $X2=0.594 $Y2=0.086
r8 49 50 3.03147 $w=1.3e-08 $l=1.3e-08 $layer=M1 $thickness=3.6e-08 $X=0.581
+ $Y=0.232 $X2=0.594 $Y2=0.232
r9 15 45 1.03499 $w=1.77368e-08 $l=9.5e-09 $layer=M1 $thickness=3.6e-08
+ $X=0.568 $Y=0.232 $X2=0.568 $Y2=0.2225
r10 15 49 1.85116 $w=1.64615e-08 $l=1.3e-08 $layer=M1 $thickness=3.6e-08
+ $X=0.568 $Y=0.232 $X2=0.581 $Y2=0.232
r11 46 47 3.03147 $w=1.3e-08 $l=1.3e-08 $layer=M1 $thickness=3.6e-08 $X=0.581
+ $Y=0.086 $X2=0.594 $Y2=0.086
r12 14 42 3.36689 $w=1.53077e-08 $l=1.95e-08 $layer=M1 $thickness=3.6e-08
+ $X=0.568 $Y=0.086 $X2=0.568 $Y2=0.1055
r13 14 46 1.85116 $w=1.64615e-08 $l=1.3e-08 $layer=M1 $thickness=3.6e-08
+ $X=0.568 $Y=0.086 $X2=0.581 $Y2=0.086
r14 44 45 2.91487 $w=1.3e-08 $l=1.25e-08 $layer=M1 $thickness=3.6e-08 $X=0.568
+ $Y=0.21 $X2=0.568 $Y2=0.2225
r15 43 44 3.03147 $w=1.3e-08 $l=1.3e-08 $layer=M1 $thickness=3.6e-08 $X=0.568
+ $Y=0.197 $X2=0.568 $Y2=0.21
r16 41 43 2.09871 $w=1.3e-08 $l=9e-09 $layer=M1 $thickness=3.6e-08 $X=0.568
+ $Y=0.188 $X2=0.568 $Y2=0.197
r17 17 41 9.32759 $w=1.3e-08 $l=4e-08 $layer=M1 $thickness=3.6e-08 $X=0.568
+ $Y=0.148 $X2=0.568 $Y2=0.188
r18 17 42 9.91056 $w=1.3e-08 $l=4.25e-08 $layer=M1 $thickness=3.6e-08 $X=0.568
+ $Y=0.148 $X2=0.568 $Y2=0.1055
r19 39 41 19.5347 $a=3.24e-16 $layer=V1 $X=0.568 $Y=0.189 $X2=0.568 $Y2=0.188
r20 38 39 30.0815 $w=1.3e-08 $l=1.29e-07 $layer=M2 $thickness=3.6e-08 $X=0.439
+ $Y=0.189 $X2=0.568 $Y2=0.189
r21 37 38 30.0815 $w=1.3e-08 $l=1.29e-07 $layer=M2 $thickness=3.6e-08 $X=0.31
+ $Y=0.189 $X2=0.439 $Y2=0.189
r22 18 37 2.68168 $w=1.3e-08 $l=1.15e-08 $layer=M2 $thickness=3.6e-08 $X=0.2985
+ $Y=0.189 $X2=0.31 $Y2=0.189
r23 35 37 19.5347 $a=3.24e-16 $layer=V1 $X=0.3145 $Y=0.189 $X2=0.31 $Y2=0.189
r24 34 35 1.51573 $w=1.3e-08 $l=6.5e-09 $layer=M1 $thickness=3.6e-08 $X=0.308
+ $Y=0.189 $X2=0.3145 $Y2=0.189
r25 33 34 0.721491 $w=1.57778e-08 $l=4.5e-09 $layer=M1 $thickness=3.6e-08
+ $X=0.3035 $Y=0.189 $X2=0.308 $Y2=0.189
r26 13 33 0.9184 $w=1.8e-08 $l=9e-09 $layer=M1 $thickness=3.6e-08 $X=0.2945
+ $Y=0.189 $X2=0.3035 $Y2=0.189
r27 12 16 4.29965 $w=1.49149e-08 $l=2.35e-08 $layer=M1 $thickness=3.6e-08
+ $X=0.297 $Y=0.081 $X2=0.297 $Y2=0.1045
r28 31 33 4.68572 $w=1.35814e-08 $l=2.87446e-08 $layer=M1 $thickness=3.6e-08
+ $X=0.297 $Y=0.161 $X2=0.3035 $Y2=0.189
r29 30 31 6.52931 $w=1.3e-08 $l=2.8e-08 $layer=M1 $thickness=3.6e-08 $X=0.297
+ $Y=0.133 $X2=0.297 $Y2=0.161
r30 29 30 2.68168 $w=1.3e-08 $l=1.15e-08 $layer=M1 $thickness=3.6e-08 $X=0.297
+ $Y=0.1215 $X2=0.297 $Y2=0.133
r31 16 29 3.96423 $w=1.3e-08 $l=1.7e-08 $layer=M1 $thickness=3.6e-08 $X=0.297
+ $Y=0.1045 $X2=0.297 $Y2=0.1215
r32 1 23 6.63025 $w=2.04878e-08 $layer=Gate_1 $thickness=5.20976e-08 $X=0.297
+ $Y=0.1335 $X2=0.297 $Y2=0.1335
r33 1 30 19.3796 $a=3.24e-16 $layer=V0LIG $X=0.297 $Y=0.1335 $X2=0.297 $Y2=0.133
r34 25 24 16.8368 $w=2.1e-08 $l=4.95e-08 $layer=Gate_1 $thickness=5.6e-08
+ $X=0.297 $Y=0.2295 $X2=0.297 $Y2=0.18
r35 23 24 15.995 $w=2.07742e-08 $l=4.65e-08 $layer=Gate_1 $thickness=5.6e-08
+ $X=0.297 $Y=0.1335 $X2=0.297 $Y2=0.18
r36 22 23 6.30106 $w=2.04167e-08 $l=1.8e-08 $layer=Gate_1 $thickness=5.6e-08
+ $X=0.297 $Y=0.1155 $X2=0.297 $Y2=0.1335
r37 21 22 16.3266 $w=2.1e-08 $l=4.8e-08 $layer=Gate_1 $thickness=5.6e-08
+ $X=0.297 $Y=0.0675 $X2=0.297 $Y2=0.1155
r38 21 9 14.6259 $w=2.1e-08 $l=4.3e-08 $layer=Gate_1 $thickness=5.6e-08
+ $X=0.297 $Y=0.0675 $X2=0.297 $Y2=0.0245
r39 3 10 1e-05 $l=7.28011e-09 $X=0.594 $Y=0.0605 $X2=0.596 $Y2=0.0675
.ends

.subckt PM_ICGx5_ASAP7_75t_R%8 vss 16 20 44 50 9 1 14 15 12 13 4 11 3 10
c1 1 vss 0.00261944f $X=0.396 $Y=0.082
c2 3 vss 0.00737291f $X=0.486 $Y=0.0635
c3 4 vss 0.00604779f $X=0.486 $Y=0.2295
c4 9 vss 0.059137f $X=0.405 $Y=0.0245
c5 10 vss 0.0218468f $X=0.4715 $Y=0.0405
c6 11 vss 0.022277f $X=0.4715 $Y=0.2295
c7 12 vss 0.0064701f $X=0.5125 $Y=0.233
c8 13 vss 0.000609164f $X=0.5125 $Y=0.082
c9 14 vss 0.0026361f $X=0.3965 $Y=0.082
c10 15 vss 0.0018805f $X=0.5125 $Y=0.093
r1 11 4 0.462963 $w=2.7e-08 $l=1.25e-08 $layer=P_src_drn $thickness=1e-09
+ $X=0.4715 $Y=0.2295 $X2=0.486 $Y2=0.2295
r2 50 11 0.0925926 $w=2.7e-08 $l=2.5e-09 $layer=P_src_drn $thickness=1e-09
+ $X=0.4686 $Y=0.2295 $X2=0.4715 $Y2=0.2295
r3 4 46 19.3796 $a=3.24e-16 $layer=V0LISD $X=0.486 $Y=0.2295 $X2=0.486 $Y2=0.233
r4 46 47 3.03147 $w=1.3e-08 $l=1.3e-08 $layer=M1 $thickness=3.6e-08 $X=0.486
+ $Y=0.233 $X2=0.499 $Y2=0.233
r5 12 42 1.06916 $w=1.78e-08 $l=9.5e-09 $layer=M1 $thickness=3.6e-08 $X=0.5125
+ $Y=0.233 $X2=0.5125 $Y2=0.2235
r6 12 47 1.90218 $w=1.65185e-08 $l=1.35e-08 $layer=M1 $thickness=3.6e-08
+ $X=0.5125 $Y=0.233 $X2=0.499 $Y2=0.233
r7 10 35 0.462963 $w=2.7e-08 $l=1.25e-08 $layer=N_src_drn $thickness=1e-09
+ $X=0.4715 $Y=0.0405 $X2=0.486 $Y2=0.0405
r8 44 10 0.0925926 $w=2.7e-08 $l=2.5e-09 $layer=N_src_drn $thickness=1e-09
+ $X=0.4686 $Y=0.0405 $X2=0.4715 $Y2=0.0405
r9 41 42 2.49333 $w=1.4e-08 $l=1.25e-08 $layer=M1 $thickness=3.6e-08 $X=0.5125
+ $Y=0.211 $X2=0.5125 $Y2=0.2235
r10 40 41 4.1888 $w=1.4e-08 $l=2.1e-08 $layer=M1 $thickness=3.6e-08 $X=0.5125
+ $Y=0.19 $X2=0.5125 $Y2=0.211
r11 39 40 3.69013 $w=1.4e-08 $l=1.85e-08 $layer=M1 $thickness=3.6e-08 $X=0.5125
+ $Y=0.1715 $X2=0.5125 $Y2=0.19
r12 38 39 3.69013 $w=1.4e-08 $l=1.85e-08 $layer=M1 $thickness=3.6e-08 $X=0.5125
+ $Y=0.153 $X2=0.5125 $Y2=0.1715
r13 37 38 4.1888 $w=1.4e-08 $l=2.1e-08 $layer=M1 $thickness=3.6e-08 $X=0.5125
+ $Y=0.132 $X2=0.5125 $Y2=0.153
r14 36 37 4.88693 $w=1.4e-08 $l=2.45e-08 $layer=M1 $thickness=3.6e-08 $X=0.5125
+ $Y=0.1075 $X2=0.5125 $Y2=0.132
r15 15 36 2.89227 $w=1.4e-08 $l=1.45e-08 $layer=M1 $thickness=3.6e-08 $X=0.5125
+ $Y=0.093 $X2=0.5125 $Y2=0.1075
r16 3 33 10.904 $w=2.02e-08 $l=1.85e-08 $layer=LISD $thickness=2.7e-08 $X=0.486
+ $Y=0.0635 $X2=0.486 $Y2=0.082
r17 3 35 13.5563 $w=2.02e-08 $l=2.3e-08 $layer=LISD $thickness=2.7e-08 $X=0.486
+ $Y=0.0635 $X2=0.486 $Y2=0.0405
r18 13 32 1.37684 $w=2.03185e-08 $l=1.35e-08 $layer=M1 $thickness=3.6e-08
+ $X=0.5125 $Y=0.082 $X2=0.499 $Y2=0.082
r19 13 15 0.843012 $w=1.80909e-08 $l=1.1e-08 $layer=M1 $thickness=3.6e-08
+ $X=0.5125 $Y=0.082 $X2=0.5125 $Y2=0.093
r20 31 32 3.03147 $w=1.3e-08 $l=1.3e-08 $layer=M1 $thickness=3.6e-08 $X=0.486
+ $Y=0.082 $X2=0.499 $Y2=0.082
r21 31 33 19.3796 $a=3.24e-16 $layer=V0LISD $X=0.486 $Y=0.082 $X2=0.486
+ $Y2=0.082
r22 30 31 2.56509 $w=1.3e-08 $l=1.1e-08 $layer=M1 $thickness=3.6e-08 $X=0.475
+ $Y=0.082 $X2=0.486 $Y2=0.082
r23 29 30 3.49785 $w=1.3e-08 $l=1.5e-08 $layer=M1 $thickness=3.6e-08 $X=0.46
+ $Y=0.082 $X2=0.475 $Y2=0.082
r24 28 29 6.7625 $w=1.3e-08 $l=2.9e-08 $layer=M1 $thickness=3.6e-08 $X=0.431
+ $Y=0.082 $X2=0.46 $Y2=0.082
r25 27 28 3.84763 $w=1.3e-08 $l=1.65e-08 $layer=M1 $thickness=3.6e-08 $X=0.4145
+ $Y=0.082 $X2=0.431 $Y2=0.082
r26 25 27 2.09871 $w=1.3e-08 $l=9e-09 $layer=M1 $thickness=3.6e-08 $X=0.4055
+ $Y=0.082 $X2=0.4145 $Y2=0.082
r27 14 25 2.09871 $w=1.3e-08 $l=9e-09 $layer=M1 $thickness=3.6e-08 $X=0.3965
+ $Y=0.082 $X2=0.4055 $Y2=0.082
r28 22 25 19.3796 $a=3.24e-16 $layer=V0LIG $X=0.406 $Y=0.082 $X2=0.4055
+ $Y2=0.082
r29 1 22 2.6116 $w=2.2e-08 $l=1e-08 $layer=LIG $thickness=4.8e-08 $X=0.396
+ $Y=0.082 $X2=0.406 $Y2=0.082
r30 20 19 25.5104 $w=2.1e-08 $l=7.5e-08 $layer=Gate_1 $thickness=5.6e-08
+ $X=0.405 $Y=0.2295 $X2=0.405 $Y2=0.1545
r31 18 19 24.8471 $w=2.08483e-08 $l=7.25e-08 $layer=Gate_1 $thickness=5.6e-08
+ $X=0.405 $Y=0.082 $X2=0.405 $Y2=0.1545
r32 18 22 6.27904 $w=2.09e-08 $l=1e-09 $layer=Gate_1 $thickness=5.24e-08
+ $X=0.405 $Y=0.082 $X2=0.406 $Y2=0.082
r33 17 18 6.81977 $w=2.04359e-08 $l=1.95e-08 $layer=Gate_1 $thickness=5.6e-08
+ $X=0.405 $Y=0.0625 $X2=0.405 $Y2=0.082
r34 16 17 7.48304 $w=2.1e-08 $l=2.2e-08 $layer=Gate_1 $thickness=5.6e-08
+ $X=0.405 $Y=0.0405 $X2=0.405 $Y2=0.0625
r35 16 9 5.44221 $w=2.1e-08 $l=1.6e-08 $layer=Gate_1 $thickness=5.6e-08
+ $X=0.405 $Y=0.0405 $X2=0.405 $Y2=0.0245
.ends

.subckt PM_ICGx5_ASAP7_75t_R%CLK vss 55 27 31 41 44 75 79 93 98 23 1 10 19 17
+ 15 20 16 8 12 21 2 3 11 18 4 14 22 13
c1 1 vss 0.000476009f $X=0.243 $Y=0.1335
c2 2 vss 0.000209509f $X=0.352 $Y=0.1335
c3 3 vss 0.00582392f $X=0.621 $Y=0.135
c4 4 vss 0.00548011f $X=0.783 $Y=0.162
c5 8 vss 0.00221025f $X=0.393 $Y=0.1335
c6 10 vss 0.00741513f $X=0.243 $Y=0.1335
c7 11 vss 0.00616464f $X=0.351 $Y=0.1335
c8 12 vss 0.097551f $X=0.621 $Y=0.135
c9 13 vss 0.0347179f $X=0.729 $Y=0.162
c10 14 vss 0.0345999f $X=0.783 $Y=0.0245
c11 15 vss 0.000504542f $X=0.405 $Y=0.153
c12 16 vss 0.000844443f $X=0.423 $Y=0.153
c13 17 vss 0.000719056f $X=0.621 $Y=0.187
c14 18 vss 0.000616612f $X=0.756 $Y=0.183
c15 19 vss 0.00346143f $X=0.243 $Y=0.1215
c16 20 vss 0.00188965f $X=0.621 $Y=0.1545
c17 21 vss 0.00546244f $X=0.7175 $Y=0.187
c18 22 vss 0.00138184f $X=0.756 $Y=0.1445
c19 23 vss 0.0384176f $X=0.5872 $Y=0.153
r1 98 99 16.3266 $w=2.1e-08 $l=4.8e-08 $layer=Gate_1 $thickness=5.6e-08
+ $X=0.351 $Y=0.0405 $X2=0.351 $Y2=0.0885
r2 11 95 3.75002 $w=2e-08 $layer=Gate_1 $thickness=5.6e-08 $X=0.351 $Y=0.1335
+ $X2=0.351 $Y2=0.1335
r3 11 99 15.4848 $w=2.07667e-08 $l=4.5e-08 $layer=Gate_1 $thickness=5.6e-08
+ $X=0.351 $Y=0.1335 $X2=0.351 $Y2=0.0885
r4 2 90 3.16825 $w=2.1e-08 $l=3.5e-09 $layer=LIG $thickness=4.8e-08 $X=0.352
+ $Y=0.1335 $X2=0.3555 $Y2=0.1335
r5 2 95 3.16825 $w=2.1e-08 $l=1e-09 $layer=LIG $thickness=4.8e-08 $X=0.352
+ $Y=0.1335 $X2=0.351 $Y2=0.1335
r6 93 92 16.8368 $w=2.1e-08 $l=4.95e-08 $layer=Gate_1 $thickness=5.6e-08
+ $X=0.243 $Y=0.2025 $X2=0.243 $Y2=0.153
r7 10 92 6.81127 $w=2.04615e-08 $l=1.95e-08 $layer=Gate_1 $thickness=5.6e-08
+ $X=0.243 $Y=0.1335 $X2=0.243 $Y2=0.153
r8 89 90 4.91375 $w=2.12e-08 $l=1.5e-09 $layer=LISD $thickness=2.7e-08 $X=0.357
+ $Y=0.1335 $X2=0.3555 $Y2=0.1335
r9 88 89 11.4654 $w=2.12e-08 $l=2.1e-08 $layer=LISD $thickness=2.7e-08 $X=0.378
+ $Y=0.1335 $X2=0.357 $Y2=0.1335
r10 8 86 6.55166 $w=2.12e-08 $l=1.2e-08 $layer=LISD $thickness=2.7e-08 $X=0.393
+ $Y=0.1335 $X2=0.405 $Y2=0.1335
r11 8 88 8.18958 $w=2.12e-08 $l=1.5e-08 $layer=LISD $thickness=2.7e-08 $X=0.393
+ $Y=0.1335 $X2=0.378 $Y2=0.1335
r12 1 68 19.3796 $a=3.24e-16 $layer=V0LIG $X=0.243 $Y=0.1335 $X2=0.243 $Y2=0.133
r13 1 10 6.63025 $w=2.04878e-08 $layer=Gate_1 $thickness=5.20976e-08 $X=0.243
+ $Y=0.1335 $X2=0.243 $Y2=0.1335
r14 82 83 2.2153 $w=1.3e-08 $l=9.5e-09 $layer=M1 $thickness=3.6e-08 $X=0.405
+ $Y=0.134 $X2=0.405 $Y2=0.1435
r15 82 86 19.3796 $a=3.24e-16 $layer=V0LISD $X=0.405 $Y=0.134 $X2=0.405
+ $Y2=0.1335
r16 15 16 3.01711 $w=1.55e-08 $l=1.8e-08 $layer=M1 $thickness=3.6e-08 $X=0.405
+ $Y=0.153 $X2=0.423 $Y2=0.153
r17 15 83 1.03499 $w=1.77368e-08 $l=9.5e-09 $layer=M1 $thickness=3.6e-08
+ $X=0.405 $Y=0.153 $X2=0.405 $Y2=0.1435
r18 79 78 14.6259 $w=2.1e-08 $l=4.3e-08 $layer=Gate_1 $thickness=5.6e-08
+ $X=0.621 $Y=0.2025 $X2=0.621 $Y2=0.1595
r19 77 78 2.7211 $w=2.1e-08 $l=8e-09 $layer=Gate_1 $thickness=5.6e-08 $X=0.621
+ $Y=0.1515 $X2=0.621 $Y2=0.1595
r20 75 76 14.6259 $w=2.1e-08 $l=4.3e-08 $layer=Gate_1 $thickness=5.6e-08
+ $X=0.621 $Y=0.0675 $X2=0.621 $Y2=0.1105
r21 73 76 2.7211 $w=2.1e-08 $l=8e-09 $layer=Gate_1 $thickness=5.6e-08 $X=0.621
+ $Y=0.1185 $X2=0.621 $Y2=0.1105
r22 12 73 5.79936 $w=2.03333e-08 $l=1.65e-08 $layer=Gate_1 $thickness=5.6e-08
+ $X=0.621 $Y=0.135 $X2=0.621 $Y2=0.1185
r23 12 77 5.79936 $w=2.03333e-08 $l=1.65e-08 $layer=Gate_1 $thickness=5.6e-08
+ $X=0.621 $Y=0.135 $X2=0.621 $Y2=0.1515
r24 69 70 2.3319 $w=1.3e-08 $l=1e-08 $layer=M1 $thickness=3.6e-08 $X=0.243
+ $Y=0.143 $X2=0.243 $Y2=0.153
r25 68 69 2.3319 $w=1.3e-08 $l=1e-08 $layer=M1 $thickness=3.6e-08 $X=0.243
+ $Y=0.133 $X2=0.243 $Y2=0.143
r26 19 68 2.68168 $w=1.3e-08 $l=1.15e-08 $layer=M1 $thickness=3.6e-08 $X=0.243
+ $Y=0.1215 $X2=0.243 $Y2=0.133
r27 16 60 19.5347 $a=3.24e-16 $layer=V1 $X=0.423 $Y=0.153 $X2=0.423 $Y2=0.153
r28 3 52 19.3796 $a=3.24e-16 $layer=V0LIG $X=0.621 $Y=0.135 $X2=0.621 $Y2=0.133
r29 3 12 6.54019 $w=2.09524e-08 $layer=Gate_1 $thickness=5.21905e-08 $X=0.621
+ $Y=0.135 $X2=0.621 $Y2=0.135
r30 63 64 7.22888 $w=1.3e-08 $l=3.1e-08 $layer=M2 $thickness=3.6e-08 $X=0.243
+ $Y=0.153 $X2=0.274 $Y2=0.153
r31 63 70 19.5347 $a=3.24e-16 $layer=V1 $X=0.243 $Y=0.153 $X2=0.243 $Y2=0.153
r32 60 61 19.5879 $w=1.3e-08 $l=8.4e-08 $layer=M2 $thickness=3.6e-08 $X=0.423
+ $Y=0.153 $X2=0.507 $Y2=0.153
r33 59 60 15.8569 $w=1.3e-08 $l=6.8e-08 $layer=M2 $thickness=3.6e-08 $X=0.355
+ $Y=0.153 $X2=0.423 $Y2=0.153
r34 59 64 18.8884 $w=1.3e-08 $l=8.1e-08 $layer=M2 $thickness=3.6e-08 $X=0.355
+ $Y=0.153 $X2=0.274 $Y2=0.153
r35 56 57 4.25571 $w=1.3e-08 $l=1.83e-08 $layer=M2 $thickness=3.6e-08 $X=0.6027
+ $Y=0.153 $X2=0.621 $Y2=0.153
r36 55 56 2.2736 $w=1.3e-08 $l=9.7e-09 $layer=M2 $thickness=3.6e-08 $X=0.593
+ $Y=0.15 $X2=0.6027 $Y2=0.153
r37 55 23 1.34084 $w=1.3e-08 $l=5.8e-09 $layer=M2 $thickness=3.6e-08 $X=0.593
+ $Y=0.15 $X2=0.5872 $Y2=0.153
r38 23 61 18.7135 $w=1.3e-08 $l=8.02e-08 $layer=M2 $thickness=3.6e-08 $X=0.5872
+ $Y=0.153 $X2=0.507 $Y2=0.153
r39 53 54 0.582974 $w=1.3e-08 $l=2.5e-09 $layer=M1 $thickness=3.6e-08 $X=0.621
+ $Y=0.143 $X2=0.621 $Y2=0.1455
r40 52 53 2.3319 $w=1.3e-08 $l=1e-08 $layer=M1 $thickness=3.6e-08 $X=0.621
+ $Y=0.133 $X2=0.621 $Y2=0.143
r41 20 50 3.61444 $w=1.3e-08 $l=1.55e-08 $layer=M1 $thickness=3.6e-08 $X=0.621
+ $Y=0.1545 $X2=0.621 $Y2=0.17
r42 20 54 2.09871 $w=1.3e-08 $l=9e-09 $layer=M1 $thickness=3.6e-08 $X=0.621
+ $Y=0.1545 $X2=0.621 $Y2=0.1455
r43 20 57 19.5347 $a=3.24e-16 $layer=V1 $X=0.621 $Y=0.1545 $X2=0.621 $Y2=0.153
r44 17 49 4.64701 $w=1.46667e-08 $l=2.7e-08 $layer=M1 $thickness=3.6e-08
+ $X=0.621 $Y=0.187 $X2=0.648 $Y2=0.187
r45 17 50 2.31511 $w=1.81882e-08 $l=1.7e-08 $layer=M1 $thickness=3.6e-08
+ $X=0.621 $Y=0.187 $X2=0.621 $Y2=0.17
r46 48 49 6.29612 $w=1.3e-08 $l=2.7e-08 $layer=M1 $thickness=3.6e-08 $X=0.675
+ $Y=0.187 $X2=0.648 $Y2=0.187
r47 47 48 2.56509 $w=1.3e-08 $l=1.1e-08 $layer=M1 $thickness=3.6e-08 $X=0.686
+ $Y=0.187 $X2=0.675 $Y2=0.187
r48 21 47 7.34548 $w=1.3e-08 $l=3.15e-08 $layer=M1 $thickness=3.6e-08 $X=0.7175
+ $Y=0.187 $X2=0.686 $Y2=0.187
r49 18 39 1.32639 $w=1.59412e-08 $l=8.5e-09 $layer=M1 $thickness=3.6e-08
+ $X=0.756 $Y=0.183 $X2=0.756 $Y2=0.1745
r50 18 21 7.38932 $w=1.37246e-08 $l=3.87072e-08 $layer=M1 $thickness=3.6e-08
+ $X=0.756 $Y=0.183 $X2=0.7175 $Y2=0.187
r51 44 43 11.9048 $w=2.1e-08 $l=3.5e-08 $layer=Gate_1 $thickness=5.6e-08
+ $X=0.729 $Y=0.216 $X2=0.729 $Y2=0.181
r52 41 42 21.0886 $w=2.1e-08 $l=6.2e-08 $layer=Gate_1 $thickness=5.6e-08
+ $X=0.729 $Y=0.0675 $X2=0.729 $Y2=0.1295
r53 13 34 6.54019 $w=2.09524e-08 $layer=Gate_1 $thickness=5.21905e-08 $X=0.729
+ $Y=0.162 $X2=0.729 $Y2=0.162
r54 13 42 11.2416 $w=2.06615e-08 $l=3.25e-08 $layer=Gate_1 $thickness=5.6e-08
+ $X=0.729 $Y=0.162 $X2=0.729 $Y2=0.1295
r55 13 43 6.6497 $w=2.04211e-08 $l=1.9e-08 $layer=Gate_1 $thickness=5.6e-08
+ $X=0.729 $Y=0.162 $X2=0.729 $Y2=0.181
r56 38 39 2.91487 $w=1.3e-08 $l=1.25e-08 $layer=M1 $thickness=3.6e-08 $X=0.756
+ $Y=0.162 $X2=0.756 $Y2=0.1745
r57 37 38 2.79828 $w=1.3e-08 $l=1.2e-08 $layer=M1 $thickness=3.6e-08 $X=0.756
+ $Y=0.15 $X2=0.756 $Y2=0.162
r58 22 37 1.28254 $w=1.3e-08 $l=5.5e-09 $layer=M1 $thickness=3.6e-08 $X=0.756
+ $Y=0.1445 $X2=0.756 $Y2=0.15
r59 33 34 12.6539 $w=1.77815e-08 $l=2.7e-08 $layer=LIG $thickness=4.8e-08
+ $X=0.756 $Y=0.162 $X2=0.729 $Y2=0.162
r60 33 38 19.3796 $a=3.24e-16 $layer=V0LIG $X=0.756 $Y=0.162 $X2=0.756 $Y2=0.162
r61 4 29 6.54019 $w=2.09524e-08 $layer=Gate_1 $thickness=5.21905e-08 $X=0.783
+ $Y=0.162 $X2=0.783 $Y2=0.162
r62 4 33 12.6539 $w=1.77815e-08 $l=2.7e-08 $layer=LIG $thickness=4.8e-08
+ $X=0.783 $Y=0.162 $X2=0.756 $Y2=0.162
r63 31 30 11.9048 $w=2.1e-08 $l=3.5e-08 $layer=Gate_1 $thickness=5.6e-08
+ $X=0.783 $Y=0.216 $X2=0.783 $Y2=0.181
r64 29 30 6.6497 $w=2.04211e-08 $l=1.9e-08 $layer=Gate_1 $thickness=5.6e-08
+ $X=0.783 $Y=0.162 $X2=0.783 $Y2=0.181
r65 28 29 11.2416 $w=2.06615e-08 $l=3.25e-08 $layer=Gate_1 $thickness=5.6e-08
+ $X=0.783 $Y=0.1295 $X2=0.783 $Y2=0.162
r66 27 28 21.0886 $w=2.1e-08 $l=6.2e-08 $layer=Gate_1 $thickness=5.6e-08
+ $X=0.783 $Y=0.0675 $X2=0.783 $Y2=0.1295
r67 27 14 14.6259 $w=2.1e-08 $l=4.3e-08 $layer=Gate_1 $thickness=5.6e-08
+ $X=0.783 $Y=0.0675 $X2=0.783 $Y2=0.0245
.ends

.subckt PM_ICGx5_ASAP7_75t_R%15 vss 6 7 3 1
c1 1 vss 0.00266913f $X=0.378 $Y=0.0405
c2 3 vss 0.00214296f $X=0.3635 $Y=0.0405
r1 7 5 0.0925926 $w=2.7e-08 $l=2.5e-09 $layer=N_src_drn $thickness=1e-09
+ $X=0.3953 $Y=0.0405 $X2=0.3925 $Y2=0.0405
r2 1 5 0.537037 $w=2.7e-08 $l=1.45e-08 $layer=N_src_drn $thickness=1e-09
+ $X=0.378 $Y=0.0405 $X2=0.3925 $Y2=0.0405
r3 3 1 0.537037 $w=2.7e-08 $l=1.45e-08 $layer=N_src_drn $thickness=1e-09
+ $X=0.3635 $Y=0.0405 $X2=0.378 $Y2=0.0405
r4 6 3 0.0925926 $w=2.7e-08 $l=2.5e-09 $layer=N_src_drn $thickness=1e-09
+ $X=0.3606 $Y=0.0405 $X2=0.3635 $Y2=0.0405
.ends

.subckt PM_ICGx5_ASAP7_75t_R%ENA vss 15 5 11 1 4 3
c1 1 vss 0.0029848f $X=0.081 $Y=0.135
c2 3 vss 0.0423184f $X=0.081 $Y=0.0245
c3 4 vss 0.00957416f $X=0.081 $Y=0.0972
r1 16 17 2.3902 $w=1.3e-08 $l=1.03e-08 $layer=M1 $thickness=3.6e-08 $X=0.081
+ $Y=0.1267 $X2=0.081 $Y2=0.137
r2 15 16 0.408082 $w=1.3e-08 $l=1.7e-09 $layer=M1 $thickness=3.6e-08 $X=0.082
+ $Y=0.125 $X2=0.081 $Y2=0.1267
r3 15 4 6.47102 $w=1.3e-08 $l=2.78e-08 $layer=M1 $thickness=3.6e-08 $X=0.082
+ $Y=0.125 $X2=0.081 $Y2=0.0972
r4 1 8 6.54019 $w=2.09524e-08 $layer=Gate_1 $thickness=5.21905e-08 $X=0.081
+ $Y=0.135 $X2=0.081 $Y2=0.135
r5 1 17 19.3796 $a=3.24e-16 $layer=V0LIG $X=0.081 $Y=0.135 $X2=0.081 $Y2=0.137
r6 11 10 14.6259 $w=2.1e-08 $l=4.3e-08 $layer=Gate_1 $thickness=5.6e-08
+ $X=0.081 $Y=0.216 $X2=0.081 $Y2=0.173
r7 9 10 7.31297 $w=2.1e-08 $l=2.15e-08 $layer=Gate_1 $thickness=5.6e-08
+ $X=0.081 $Y=0.1515 $X2=0.081 $Y2=0.173
r8 8 9 5.79936 $w=2.03333e-08 $l=1.65e-08 $layer=Gate_1 $thickness=5.6e-08
+ $X=0.081 $Y=0.135 $X2=0.081 $Y2=0.1515
r9 7 8 5.79936 $w=2.03333e-08 $l=1.65e-08 $layer=Gate_1 $thickness=5.6e-08
+ $X=0.081 $Y=0.1185 $X2=0.081 $Y2=0.135
r10 6 7 7.31297 $w=2.1e-08 $l=2.15e-08 $layer=Gate_1 $thickness=5.6e-08
+ $X=0.081 $Y=0.097 $X2=0.081 $Y2=0.1185
r11 5 6 14.6259 $w=2.1e-08 $l=4.3e-08 $layer=Gate_1 $thickness=5.6e-08 $X=0.081
+ $Y=0.054 $X2=0.081 $Y2=0.097
r12 5 3 10.0341 $w=2.1e-08 $l=2.95e-08 $layer=Gate_1 $thickness=5.6e-08
+ $X=0.081 $Y=0.054 $X2=0.081 $Y2=0.0245
.ends

.subckt PM_ICGx5_ASAP7_75t_R%18 vss 2 3 1
c1 1 vss 0.0067421f $X=0.108 $Y=0.216
r1 2 1 0.314815 $w=5.4e-08 $l=1.7e-08 $layer=P_src_drn $thickness=1e-09
+ $X=0.0906 $Y=0.216 $X2=0.108 $Y2=0.216
r2 3 1 0.314815 $w=5.4e-08 $l=1.7e-08 $layer=P_src_drn $thickness=1e-09
+ $X=0.1253 $Y=0.216 $X2=0.108 $Y2=0.216
.ends

.subckt PM_ICGx5_ASAP7_75t_R%SE vss 13 5 9 3 4 1
c1 1 vss 0.00405787f $X=0.135 $Y=0.135
c2 3 vss 0.0941788f $X=0.135 $Y=0.0245
c3 4 vss 0.00331315f $X=0.135 $Y=0.0972
r1 14 15 2.3902 $w=1.3e-08 $l=1.03e-08 $layer=M1 $thickness=3.6e-08 $X=0.135
+ $Y=0.1267 $X2=0.135 $Y2=0.137
r2 13 14 0.408082 $w=1.3e-08 $l=1.7e-09 $layer=M1 $thickness=3.6e-08 $X=0.135
+ $Y=0.125 $X2=0.135 $Y2=0.1267
r3 13 4 6.47102 $w=1.3e-08 $l=2.78e-08 $layer=M1 $thickness=3.6e-08 $X=0.135
+ $Y=0.125 $X2=0.135 $Y2=0.0972
r4 1 7 6.54019 $w=2.09524e-08 $layer=Gate_1 $thickness=5.21905e-08 $X=0.135
+ $Y=0.135 $X2=0.135 $Y2=0.135
r5 1 15 19.3796 $a=3.24e-16 $layer=V0LIG $X=0.135 $Y=0.135 $X2=0.135 $Y2=0.137
r6 9 8 16.4967 $w=2.1e-08 $l=4.85e-08 $layer=Gate_1 $thickness=5.6e-08 $X=0.135
+ $Y=0.216 $X2=0.135 $Y2=0.1675
r7 7 8 11.2416 $w=2.06615e-08 $l=3.25e-08 $layer=Gate_1 $thickness=5.6e-08
+ $X=0.135 $Y=0.135 $X2=0.135 $Y2=0.1675
r8 6 7 11.2416 $w=2.06615e-08 $l=3.25e-08 $layer=Gate_1 $thickness=5.6e-08
+ $X=0.135 $Y=0.1025 $X2=0.135 $Y2=0.135
r9 5 6 16.4967 $w=2.1e-08 $l=4.85e-08 $layer=Gate_1 $thickness=5.6e-08 $X=0.135
+ $Y=0.054 $X2=0.135 $Y2=0.1025
r10 5 3 10.0341 $w=2.1e-08 $l=2.95e-08 $layer=Gate_1 $thickness=5.6e-08
+ $X=0.135 $Y=0.054 $X2=0.135 $Y2=0.0245
.ends

.subckt PM_ICGx5_ASAP7_75t_R%9 vss 34 38 60 63 85 88 102 105 114 117 16 23 22
+ 29 27 18 21 24 33 7 19 25 3 1 31 32 17 26 28 30 13 8 2 14 15
c1 1 vss 0.00290432f $X=0.459 $Y=0.19
c2 2 vss 0.00411972f $X=0.675 $Y=0.135
c3 3 vss 0.00398914f $X=0.837 $Y=0.135
c4 7 vss 0.00482774f $X=0.27 $Y=0.2295
c5 8 vss 0.00424153f $X=0.324 $Y=0.0405
c6 13 vss 0.049992f $X=0.459 $Y=0.19
c7 14 vss 0.0938424f $X=0.675 $Y=0.135
c8 15 vss 0.0938563f $X=0.837 $Y=0.0245
c9 16 vss 0.00218846f $X=0.3095 $Y=0.0405
c10 17 vss 0.000900983f $X=0.3095 $Y=0.081
c11 18 vss 0.00215431f $X=0.2555 $Y=0.2295
c12 19 vss 0.000902617f $X=0.2555 $Y=0.189
c13 20 vss 0.00204132f $X=0.358 $Y=0.036
c14 21 vss 0.000138446f $X=0.358 $Y=0.1895
c15 22 vss 0.0025439f $X=0.358 $Y=0.2235
c16 23 vss 0.0031245f $X=0.675 $Y=0.036
c17 24 vss 0.000753728f $X=0.675 $Y=0.1075
c18 25 vss 0.00105869f $X=0.837 $Y=0.1205
c19 26 vss 0.00766082f $X=0.3365 $Y=0.232
c20 27 vss 0.00397499f $X=0.3285 $Y=0.036
c21 28 vss 0.000905126f $X=0.358 $Y=0.0585
c22 29 vss 0.000436123f $X=0.358 $Y=0.211
c23 30 vss 0.026843f $X=0.648 $Y=0.036
c24 31 vss 0.00204718f $X=0.3795 $Y=0.19
c25 32 vss 0.00218973f $X=0.675 $Y=0.097
c26 33 vss 0.00200838f $X=0.7965 $Y=0.108
r1 19 112 0.231482 $w=5.4e-08 $l=1.25e-08 $layer=P_src_drn $thickness=1e-09
+ $X=0.2555 $Y=0.189 $X2=0.27 $Y2=0.189
r2 117 116 0.0925926 $w=2.7e-08 $l=2.5e-09 $layer=P_src_drn $thickness=1e-09
+ $X=0.2873 $Y=0.2295 $X2=0.2845 $Y2=0.2295
r3 115 116 0.166667 $w=2.7e-08 $l=4.5e-09 $layer=P_src_drn $thickness=1e-09
+ $X=0.28 $Y=0.2295 $X2=0.2845 $Y2=0.2295
r4 112 115 0.444445 $w=2.7e-08 $l=1.2e-08 $layer=P_src_drn $thickness=1e-09
+ $X=0.27 $Y=0.189 $X2=0.28 $Y2=0.2295
r5 18 112 0.462963 $w=2.7e-08 $l=1.25e-08 $layer=P_src_drn $thickness=1e-09
+ $X=0.2555 $Y=0.2295 $X2=0.27 $Y2=0.189
r6 114 18 0.0925926 $w=2.7e-08 $l=2.5e-09 $layer=P_src_drn $thickness=1e-09
+ $X=0.2526 $Y=0.2025 $X2=0.2555 $Y2=0.2295
r7 7 109 19.3796 $a=3.24e-16 $layer=V0LISD $X=0.27 $Y=0.2295 $X2=0.27 $Y2=0.232
r8 7 112 23.8708 $w=2.02e-08 $l=4.05e-08 $layer=LISD $thickness=2.7e-08 $X=0.27
+ $Y=0.2295 $X2=0.27 $Y2=0.189
r9 109 110 3.14806 $w=1.3e-08 $l=1.35e-08 $layer=M1 $thickness=3.6e-08 $X=0.27
+ $Y=0.232 $X2=0.2835 $Y2=0.232
r10 107 110 5.24677 $w=1.3e-08 $l=2.25e-08 $layer=M1 $thickness=3.6e-08
+ $X=0.306 $Y=0.232 $X2=0.2835 $Y2=0.232
r11 26 107 7.11229 $w=1.3e-08 $l=3.05e-08 $layer=M1 $thickness=3.6e-08
+ $X=0.3365 $Y=0.232 $X2=0.306 $Y2=0.232
r12 105 104 7.31297 $w=2.1e-08 $l=2.15e-08 $layer=Gate_1 $thickness=5.6e-08
+ $X=0.459 $Y=0.2295 $X2=0.459 $Y2=0.208
r13 102 103 14.6259 $w=2.1e-08 $l=4.3e-08 $layer=Gate_1 $thickness=5.6e-08
+ $X=0.459 $Y=0.0405 $X2=0.459 $Y2=0.0835
r14 100 103 17.5171 $w=2.1e-08 $l=5.15e-08 $layer=Gate_1 $thickness=5.6e-08
+ $X=0.459 $Y=0.135 $X2=0.459 $Y2=0.0835
r15 99 100 11.3946 $w=2.1e-08 $l=3.35e-08 $layer=Gate_1 $thickness=5.6e-08
+ $X=0.459 $Y=0.1685 $X2=0.459 $Y2=0.135
r16 13 99 7.48304 $w=2.05349e-08 $l=2.15e-08 $layer=Gate_1 $thickness=5.6e-08
+ $X=0.459 $Y=0.19 $X2=0.459 $Y2=0.1685
r17 13 104 6.29255 $w=2.04444e-08 $l=1.8e-08 $layer=Gate_1 $thickness=5.6e-08
+ $X=0.459 $Y=0.19 $X2=0.459 $Y2=0.208
r18 22 29 2.8493 $w=1.32e-08 $l=1.25e-08 $layer=M1 $thickness=3.6e-08 $X=0.358
+ $Y=0.2235 $X2=0.358 $Y2=0.211
r19 22 26 2.96589 $w=1.31923e-08 $l=2.31193e-08 $layer=M1 $thickness=3.6e-08
+ $X=0.358 $Y=0.2235 $X2=0.3365 $Y2=0.232
r20 1 94 19.3796 $a=3.24e-16 $layer=V0LIG $X=0.459 $Y=0.19 $X2=0.459 $Y2=0.19
r21 1 13 6.74717 $w=2e-08 $layer=Gate_1 $thickness=5.2e-08 $X=0.459 $Y=0.19
+ $X2=0.459 $Y2=0.19
r22 29 83 2.8493 $w=1.32e-08 $l=1.25e-08 $layer=M1 $thickness=3.6e-08 $X=0.358
+ $Y=0.211 $X2=0.358 $Y2=0.1985
r23 93 94 2.44849 $w=1.3e-08 $l=1.05e-08 $layer=M1 $thickness=3.6e-08 $X=0.4485
+ $Y=0.19 $X2=0.459 $Y2=0.19
r24 92 93 4.19742 $w=1.3e-08 $l=1.8e-08 $layer=M1 $thickness=3.6e-08 $X=0.4305
+ $Y=0.19 $X2=0.4485 $Y2=0.19
r25 91 92 5.94634 $w=1.3e-08 $l=2.55e-08 $layer=M1 $thickness=3.6e-08 $X=0.405
+ $Y=0.19 $X2=0.4305 $Y2=0.19
r26 90 91 2.56509 $w=1.3e-08 $l=1.1e-08 $layer=M1 $thickness=3.6e-08 $X=0.394
+ $Y=0.19 $X2=0.405 $Y2=0.19
r27 31 90 3.38125 $w=1.3e-08 $l=1.45e-08 $layer=M1 $thickness=3.6e-08 $X=0.3795
+ $Y=0.19 $X2=0.394 $Y2=0.19
r28 17 81 0.231482 $w=5.4e-08 $l=1.25e-08 $layer=N_src_drn $thickness=1e-09
+ $X=0.3095 $Y=0.081 $X2=0.324 $Y2=0.074
r29 88 87 0.0925926 $w=2.7e-08 $l=2.5e-09 $layer=N_src_drn $thickness=1e-09
+ $X=0.3413 $Y=0.0405 $X2=0.3385 $Y2=0.0405
r30 86 87 0.166667 $w=2.7e-08 $l=4.5e-09 $layer=N_src_drn $thickness=1e-09
+ $X=0.334 $Y=0.0405 $X2=0.3385 $Y2=0.0405
r31 81 86 0.444445 $w=2.7e-08 $l=1.2e-08 $layer=N_src_drn $thickness=1e-09
+ $X=0.324 $Y=0.074 $X2=0.334 $Y2=0.0405
r32 16 81 0.462963 $w=2.7e-08 $l=1.25e-08 $layer=N_src_drn $thickness=1e-09
+ $X=0.3095 $Y=0.0405 $X2=0.324 $Y2=0.074
r33 85 16 0.0925926 $w=2.7e-08 $l=2.5e-09 $layer=N_src_drn $thickness=1e-09
+ $X=0.3066 $Y=0.0675 $X2=0.3095 $Y2=0.0405
r34 21 80 0.983973 $w=1.77222e-08 $l=9e-09 $layer=M1 $thickness=3.6e-08
+ $X=0.358 $Y=0.1895 $X2=0.358 $Y2=0.1805
r35 21 83 0.9184 $w=1.8e-08 $l=9e-09 $layer=M1 $thickness=3.6e-08 $X=0.358
+ $Y=0.1895 $X2=0.358 $Y2=0.1985
r36 21 31 3.78225 $w=1.50238e-08 $l=2.15058e-08 $layer=M1 $thickness=3.6e-08
+ $X=0.358 $Y=0.1895 $X2=0.3795 $Y2=0.19
r37 8 73 19.3796 $a=3.24e-16 $layer=V0LISD $X=0.324 $Y=0.0405 $X2=0.3195
+ $Y2=0.036
r38 8 81 19.745 $w=2.02e-08 $l=3.35e-08 $layer=LISD $thickness=2.7e-08 $X=0.324
+ $Y=0.0405 $X2=0.324 $Y2=0.074
r39 79 80 2.2153 $w=1.3e-08 $l=9.5e-09 $layer=M1 $thickness=3.6e-08 $X=0.358
+ $Y=0.171 $X2=0.358 $Y2=0.1805
r40 78 79 6.99569 $w=1.3e-08 $l=3e-08 $layer=M1 $thickness=3.6e-08 $X=0.358
+ $Y=0.141 $X2=0.358 $Y2=0.171
r41 77 78 8.27824 $w=1.3e-08 $l=3.55e-08 $layer=M1 $thickness=3.6e-08 $X=0.358
+ $Y=0.1055 $X2=0.358 $Y2=0.141
r42 76 77 3.49785 $w=1.3e-08 $l=1.5e-08 $layer=M1 $thickness=3.6e-08 $X=0.358
+ $Y=0.0905 $X2=0.358 $Y2=0.1055
r43 75 76 2.09871 $w=1.3e-08 $l=9e-09 $layer=M1 $thickness=3.6e-08 $X=0.358
+ $Y=0.0815 $X2=0.358 $Y2=0.0905
r44 74 75 2.09871 $w=1.3e-08 $l=9e-09 $layer=M1 $thickness=3.6e-08 $X=0.358
+ $Y=0.0725 $X2=0.358 $Y2=0.0815
r45 28 74 3.26466 $w=1.3e-08 $l=1.4e-08 $layer=M1 $thickness=3.6e-08 $X=0.358
+ $Y=0.0585 $X2=0.358 $Y2=0.0725
r46 27 71 2.91487 $w=1.3e-08 $l=1.25e-08 $layer=M1 $thickness=3.6e-08 $X=0.3285
+ $Y=0.036 $X2=0.341 $Y2=0.036
r47 27 73 2.09871 $w=1.3e-08 $l=9e-09 $layer=M1 $thickness=3.6e-08 $X=0.3285
+ $Y=0.036 $X2=0.3195 $Y2=0.036
r48 20 70 3.83327 $w=1.5093e-08 $l=2.15e-08 $layer=M1 $thickness=3.6e-08
+ $X=0.358 $Y=0.036 $X2=0.3795 $Y2=0.036
r49 20 71 2.78392 $w=1.56471e-08 $l=1.7e-08 $layer=M1 $thickness=3.6e-08
+ $X=0.358 $Y=0.036 $X2=0.341 $Y2=0.036
r50 20 28 4.06646 $w=1.5e-08 $l=2.25e-08 $layer=M1 $thickness=3.6e-08 $X=0.358
+ $Y=0.036 $X2=0.358 $Y2=0.0585
r51 69 70 18.0722 $w=1.3e-08 $l=7.75e-08 $layer=M1 $thickness=3.6e-08 $X=0.457
+ $Y=0.036 $X2=0.3795 $Y2=0.036
r52 68 69 19.4713 $w=1.3e-08 $l=8.35e-08 $layer=M1 $thickness=3.6e-08 $X=0.5405
+ $Y=0.036 $X2=0.457 $Y2=0.036
r53 67 68 10.1438 $w=1.3e-08 $l=4.35e-08 $layer=M1 $thickness=3.6e-08 $X=0.584
+ $Y=0.036 $X2=0.5405 $Y2=0.036
r54 66 67 6.17953 $w=1.3e-08 $l=2.65e-08 $layer=M1 $thickness=3.6e-08 $X=0.6105
+ $Y=0.036 $X2=0.584 $Y2=0.036
r55 65 66 2.44849 $w=1.3e-08 $l=1.05e-08 $layer=M1 $thickness=3.6e-08 $X=0.621
+ $Y=0.036 $X2=0.6105 $Y2=0.036
r56 30 65 6.29612 $w=1.3e-08 $l=2.7e-08 $layer=M1 $thickness=3.6e-08 $X=0.648
+ $Y=0.036 $X2=0.621 $Y2=0.036
r57 63 62 16.4967 $w=2.1e-08 $l=4.85e-08 $layer=Gate_1 $thickness=5.6e-08
+ $X=0.675 $Y=0.216 $X2=0.675 $Y2=0.1675
r58 60 61 16.4967 $w=2.1e-08 $l=4.85e-08 $layer=Gate_1 $thickness=5.6e-08
+ $X=0.675 $Y=0.0675 $X2=0.675 $Y2=0.116
r59 14 61 6.6497 $w=2.04211e-08 $l=1.9e-08 $layer=Gate_1 $thickness=5.6e-08
+ $X=0.675 $Y=0.135 $X2=0.675 $Y2=0.116
r60 14 62 11.2416 $w=2.06615e-08 $l=3.25e-08 $layer=Gate_1 $thickness=5.6e-08
+ $X=0.675 $Y=0.135 $X2=0.675 $Y2=0.1675
r61 23 56 2.5483 $w=1.79e-08 $l=1.8e-08 $layer=M1 $thickness=3.6e-08 $X=0.675
+ $Y=0.036 $X2=0.675 $Y2=0.054
r62 23 30 4.64701 $w=1.46667e-08 $l=2.7e-08 $layer=M1 $thickness=3.6e-08
+ $X=0.675 $Y=0.036 $X2=0.648 $Y2=0.036
r63 2 50 19.3796 $a=3.24e-16 $layer=V0LIG $X=0.675 $Y=0.135 $X2=0.675 $Y2=0.133
r64 2 14 6.54019 $w=2.09524e-08 $layer=Gate_1 $thickness=5.21905e-08 $X=0.675
+ $Y=0.135 $X2=0.675 $Y2=0.135
r65 55 56 3.26466 $w=1.3e-08 $l=1.4e-08 $layer=M1 $thickness=3.6e-08 $X=0.675
+ $Y=0.068 $X2=0.675 $Y2=0.054
r66 54 55 1.63233 $w=1.3e-08 $l=7e-09 $layer=M1 $thickness=3.6e-08 $X=0.675
+ $Y=0.075 $X2=0.675 $Y2=0.068
r67 53 54 0.932759 $w=1.3e-08 $l=4e-09 $layer=M1 $thickness=3.6e-08 $X=0.675
+ $Y=0.079 $X2=0.675 $Y2=0.075
r68 52 53 2.09871 $w=1.3e-08 $l=9e-09 $layer=M1 $thickness=3.6e-08 $X=0.675
+ $Y=0.088 $X2=0.675 $Y2=0.079
r69 32 52 2.09871 $w=1.3e-08 $l=9e-09 $layer=M1 $thickness=3.6e-08 $X=0.675
+ $Y=0.097 $X2=0.675 $Y2=0.088
r70 49 50 2.91487 $w=1.3e-08 $l=1.25e-08 $layer=M1 $thickness=3.6e-08 $X=0.675
+ $Y=0.1205 $X2=0.675 $Y2=0.133
r71 48 49 0.867186 $w=1.3625e-08 $l=4e-09 $layer=M1 $thickness=3.6e-08 $X=0.675
+ $Y=0.1165 $X2=0.675 $Y2=0.1205
r72 24 48 0.9184 $w=1.8e-08 $l=9e-09 $layer=M1 $thickness=3.6e-08 $X=0.675
+ $Y=0.1075 $X2=0.675 $Y2=0.1165
r73 24 32 1.33376 $w=1.70476e-08 $l=1.05e-08 $layer=M1 $thickness=3.6e-08
+ $X=0.675 $Y=0.1075 $X2=0.675 $Y2=0.097
r74 47 48 6.81353 $w=1.30847e-08 $l=3.89391e-08 $layer=M1 $thickness=3.6e-08
+ $X=0.713 $Y=0.108 $X2=0.675 $Y2=0.1165
r75 46 47 7.34548 $w=1.3e-08 $l=3.15e-08 $layer=M1 $thickness=3.6e-08 $X=0.7445
+ $Y=0.108 $X2=0.713 $Y2=0.108
r76 45 46 2.68168 $w=1.3e-08 $l=1.15e-08 $layer=M1 $thickness=3.6e-08 $X=0.756
+ $Y=0.108 $X2=0.7445 $Y2=0.108
r77 33 43 8.26388 $w=1.41111e-08 $l=4.05e-08 $layer=M1 $thickness=3.6e-08
+ $X=0.7965 $Y=0.108 $X2=0.837 $Y2=0.108
r78 33 45 9.44419 $w=1.3e-08 $l=4.05e-08 $layer=M1 $thickness=3.6e-08 $X=0.7965
+ $Y=0.108 $X2=0.756 $Y2=0.108
r79 25 42 2.91487 $w=1.3e-08 $l=1.25e-08 $layer=M1 $thickness=3.6e-08 $X=0.837
+ $Y=0.1205 $X2=0.837 $Y2=0.133
r80 25 43 1.73456 $w=1.66e-08 $l=1.25e-08 $layer=M1 $thickness=3.6e-08 $X=0.837
+ $Y=0.1205 $X2=0.837 $Y2=0.108
r81 3 36 6.54019 $w=2.09524e-08 $layer=Gate_1 $thickness=5.21905e-08 $X=0.837
+ $Y=0.135 $X2=0.837 $Y2=0.135
r82 3 42 19.3796 $a=3.24e-16 $layer=V0LIG $X=0.837 $Y=0.135 $X2=0.837 $Y2=0.133
r83 38 37 16.4967 $w=2.1e-08 $l=4.85e-08 $layer=Gate_1 $thickness=5.6e-08
+ $X=0.837 $Y=0.216 $X2=0.837 $Y2=0.1675
r84 36 37 11.2416 $w=2.06615e-08 $l=3.25e-08 $layer=Gate_1 $thickness=5.6e-08
+ $X=0.837 $Y=0.135 $X2=0.837 $Y2=0.1675
r85 35 36 6.6497 $w=2.04211e-08 $l=1.9e-08 $layer=Gate_1 $thickness=5.6e-08
+ $X=0.837 $Y=0.116 $X2=0.837 $Y2=0.135
r86 34 35 16.4967 $w=2.1e-08 $l=4.85e-08 $layer=Gate_1 $thickness=5.6e-08
+ $X=0.837 $Y=0.0675 $X2=0.837 $Y2=0.116
r87 34 15 14.6259 $w=2.1e-08 $l=4.3e-08 $layer=Gate_1 $thickness=5.6e-08
+ $X=0.837 $Y=0.0675 $X2=0.837 $Y2=0.0245
.ends

.subckt PM_ICGx5_ASAP7_75t_R%12 vss 7 9 4 5 1
c1 1 vss 0.00810918f $X=0.243 $Y=0.0675
c2 4 vss 0.00293167f $X=0.2015 $Y=0.0675
c3 5 vss 0.0017648f $X=0.272 $Y=0.0675
r1 9 8 0.0308642 $w=8.1e-08 $l=2.5e-09 $layer=N_src_drn $thickness=1e-09
+ $X=0.2873 $Y=0.0675 $X2=0.2845 $Y2=0.0675
r2 5 8 0.154321 $w=8.1e-08 $l=1.25e-08 $layer=N_src_drn $thickness=1e-09
+ $X=0.272 $Y=0.0675 $X2=0.2845 $Y2=0.0675
r3 4 1 0.154321 $w=8.1e-08 $l=1.25e-08 $layer=N_src_drn $thickness=1e-09
+ $X=0.2015 $Y=0.0675 $X2=0.243 $Y2=0.0675
r4 7 4 0.0308642 $w=8.1e-08 $l=2.5e-09 $layer=N_src_drn $thickness=1e-09
+ $X=0.1986 $Y=0.0675 $X2=0.2015 $Y2=0.0675
r5 1 5 1e-05 $l=2.9e-08 $X=0.243 $Y=0.0675 $X2=0.272 $Y2=0.0675
.ends

.subckt PM_ICGx5_ASAP7_75t_R%5 vss 17 21 46 47 49 16 15 4 11 3 14 10 1 9
c1 1 vss 0.00345351f $X=0.189 $Y=0.134
c2 3 vss 0.00751034f $X=0.054 $Y=0.216
c3 4 vss 0.00832095f $X=0.108 $Y=0.054
c4 9 vss 0.107183f $X=0.189 $Y=0.0245
c5 10 vss 0.00668849f $X=0.0935 $Y=0.054
c6 11 vss 0.0315405f $X=0.056 $Y=0.216
c7 12 vss 0.00331199f $X=0.189 $Y=0.036
c8 13 vss 0.00334967f $X=0.189 $Y=0.2325
c9 14 vss 0.0174509f $X=0.162 $Y=0.233
c10 15 vss 0.0108416f $X=0.162 $Y=0.036
c11 16 vss 0.00700498f $X=0.189 $Y=0.1045
r1 49 48 0.0462963 $w=5.4e-08 $l=2.5e-09 $layer=P_src_drn $thickness=1e-09
+ $X=0.0713 $Y=0.216 $X2=0.0685 $Y2=0.216
r2 11 48 0.231482 $w=5.4e-08 $l=1.25e-08 $layer=P_src_drn $thickness=1e-09
+ $X=0.056 $Y=0.216 $X2=0.0685 $Y2=0.216
r3 47 45 0.0462963 $w=5.4e-08 $l=2.5e-09 $layer=N_src_drn $thickness=1e-09
+ $X=0.1253 $Y=0.054 $X2=0.1225 $Y2=0.054
r4 4 45 0.268519 $w=5.4e-08 $l=1.45e-08 $layer=N_src_drn $thickness=1e-09
+ $X=0.108 $Y=0.054 $X2=0.1225 $Y2=0.054
r5 10 4 0.268519 $w=5.4e-08 $l=1.45e-08 $layer=N_src_drn $thickness=1e-09
+ $X=0.0935 $Y=0.054 $X2=0.108 $Y2=0.054
r6 46 10 0.0462963 $w=5.4e-08 $l=2.5e-09 $layer=N_src_drn $thickness=1e-09
+ $X=0.0906 $Y=0.054 $X2=0.0935 $Y2=0.054
r7 3 42 19.3796 $a=3.24e-16 $layer=V0LISD $X=0.054 $Y=0.216 $X2=0.054 $Y2=0.233
r8 4 35 19.3796 $a=3.24e-16 $layer=V0LISD $X=0.108 $Y=0.054 $X2=0.108 $Y2=0.036
r9 42 43 3.14806 $w=1.3e-08 $l=1.35e-08 $layer=M1 $thickness=3.6e-08 $X=0.054
+ $Y=0.233 $X2=0.0675 $Y2=0.233
r10 40 43 3.14806 $w=1.3e-08 $l=1.35e-08 $layer=M1 $thickness=3.6e-08 $X=0.081
+ $Y=0.233 $X2=0.0675 $Y2=0.233
r11 39 40 6.29612 $w=1.3e-08 $l=2.7e-08 $layer=M1 $thickness=3.6e-08 $X=0.108
+ $Y=0.233 $X2=0.081 $Y2=0.233
r12 38 39 6.29612 $w=1.3e-08 $l=2.7e-08 $layer=M1 $thickness=3.6e-08 $X=0.135
+ $Y=0.233 $X2=0.108 $Y2=0.233
r13 14 38 6.29612 $w=1.3e-08 $l=2.7e-08 $layer=M1 $thickness=3.6e-08 $X=0.162
+ $Y=0.233 $X2=0.135 $Y2=0.233
r14 35 36 3.14806 $w=1.3e-08 $l=1.35e-08 $layer=M1 $thickness=3.6e-08 $X=0.108
+ $Y=0.036 $X2=0.1215 $Y2=0.036
r15 33 36 3.14806 $w=1.3e-08 $l=1.35e-08 $layer=M1 $thickness=3.6e-08 $X=0.135
+ $Y=0.036 $X2=0.1215 $Y2=0.036
r16 15 33 6.29612 $w=1.3e-08 $l=2.7e-08 $layer=M1 $thickness=3.6e-08 $X=0.162
+ $Y=0.036 $X2=0.135 $Y2=0.036
r17 13 31 0.983973 $w=1.77222e-08 $l=9e-09 $layer=M1 $thickness=3.6e-08
+ $X=0.189 $Y=0.2325 $X2=0.189 $Y2=0.2235
r18 13 14 5.06479 $w=1.46038e-08 $l=2.70046e-08 $layer=M1 $thickness=3.6e-08
+ $X=0.189 $Y=0.2325 $X2=0.162 $Y2=0.233
r19 12 26 3.36447 $w=1.71023e-08 $l=2.15e-08 $layer=M1 $thickness=3.6e-08
+ $X=0.189 $Y=0.036 $X2=0.189 $Y2=0.0575
r20 12 15 4.64701 $w=1.46667e-08 $l=2.7e-08 $layer=M1 $thickness=3.6e-08
+ $X=0.189 $Y=0.036 $X2=0.162 $Y2=0.036
r21 30 31 2.91487 $w=1.3e-08 $l=1.25e-08 $layer=M1 $thickness=3.6e-08 $X=0.189
+ $Y=0.211 $X2=0.189 $Y2=0.2235
r22 29 30 2.91487 $w=1.3e-08 $l=1.25e-08 $layer=M1 $thickness=3.6e-08 $X=0.189
+ $Y=0.1985 $X2=0.189 $Y2=0.211
r23 28 29 1.74892 $w=1.3e-08 $l=7.5e-09 $layer=M1 $thickness=3.6e-08 $X=0.189
+ $Y=0.191 $X2=0.189 $Y2=0.1985
r24 27 28 9.211 $w=1.3e-08 $l=3.95e-08 $layer=M1 $thickness=3.6e-08 $X=0.189
+ $Y=0.1515 $X2=0.189 $Y2=0.191
r25 25 26 3.14806 $w=1.3e-08 $l=1.35e-08 $layer=M1 $thickness=3.6e-08 $X=0.189
+ $Y=0.071 $X2=0.189 $Y2=0.0575
r26 24 25 2.3319 $w=1.3e-08 $l=1e-08 $layer=M1 $thickness=3.6e-08 $X=0.189
+ $Y=0.081 $X2=0.189 $Y2=0.071
r27 16 24 5.47996 $w=1.3e-08 $l=2.35e-08 $layer=M1 $thickness=3.6e-08 $X=0.189
+ $Y=0.1045 $X2=0.189 $Y2=0.081
r28 16 27 10.9599 $w=1.3e-08 $l=4.7e-08 $layer=M1 $thickness=3.6e-08 $X=0.189
+ $Y=0.1045 $X2=0.189 $Y2=0.1515
r29 1 19 9.83583 $w=1.77619e-08 $l=1e-09 $layer=LIG $thickness=5.21905e-08
+ $X=0.189 $Y=0.134 $X2=0.189 $Y2=0.135
r30 1 27 19.3796 $a=3.24e-16 $layer=V0LIG $X=0.189 $Y=0.134 $X2=0.189 $Y2=0.1515
r31 21 20 16.4967 $w=2.1e-08 $l=4.85e-08 $layer=Gate_1 $thickness=5.6e-08
+ $X=0.189 $Y=0.2025 $X2=0.189 $Y2=0.154
r32 19 20 6.6497 $w=2.04211e-08 $l=1.9e-08 $layer=Gate_1 $thickness=5.6e-08
+ $X=0.189 $Y=0.135 $X2=0.189 $Y2=0.154
r33 18 19 6.6497 $w=2.04211e-08 $l=1.9e-08 $layer=Gate_1 $thickness=5.6e-08
+ $X=0.189 $Y=0.116 $X2=0.189 $Y2=0.135
r34 17 18 16.4967 $w=2.1e-08 $l=4.85e-08 $layer=Gate_1 $thickness=5.6e-08
+ $X=0.189 $Y=0.0675 $X2=0.189 $Y2=0.116
r35 17 9 14.6259 $w=2.1e-08 $l=4.3e-08 $layer=Gate_1 $thickness=5.6e-08
+ $X=0.189 $Y=0.0675 $X2=0.189 $Y2=0.0245
r36 3 11 1e-05 $l=2e-09 $X=0.054 $Y=0.216 $X2=0.056 $Y2=0.216
.ends

* End of included file ICGx5_ASAP7_75t_R.pex.sp.pex

*
.subckt ICGx5_ASAP7_75t_CUSTOM_4_25_0_7 VSS VDD ENA SE CLK GCLK
*
* VSS VSS
* VDD VDD
* ENA ENA
* SE SE
* CLK CLK
* GCLK GCLK
*
*

M0 N_M0_d N_M0_g VSS VSS nmos_rvt L=2e-08 W=5.4e-08 nfin=2 $X=0.071 $Y=0.027
M1 VSS N_M1_g N_M1_s VSS nmos_rvt L=2e-08 W=5.4e-08 nfin=2 $X=0.125 $Y=0.027
M2 N_M2_d N_M2_g VSS VSS nmos_rvt L=2e-08 W=8.1e-08 nfin=3 $X=0.179 $Y=0.027
M3 N_M3_d N_M3_g N_M3_s VSS nmos_rvt L=2e-08 W=8.1e-08 nfin=3 $X=0.287 $Y=0.027
M4 N_M4_d N_M4_g N_M4_s VSS nmos_rvt L=2e-08 W=2.7e-08 nfin=1 $X=0.341 $Y=0.027
M5 VSS N_M5_g N_M5_s VSS nmos_rvt L=2e-08 W=2.7e-08 nfin=1 $X=0.395 $Y=0.027
M6 N_M6_d N_M6_g VSS VSS nmos_rvt L=2e-08 W=2.7e-08 nfin=1 $X=0.449 $Y=0.027
M7 VSS N_M7_g N_M7_s VSS nmos_rvt L=2e-08 W=8.1e-08 nfin=3 $X=0.611 $Y=0.027
M8 VSS N_M8_g N_M8_s VSS nmos_rvt L=2e-08 W=8.1e-08 nfin=3 $X=0.665 $Y=0.027
M9 N_M9_d N_M9_g N_M9_s VSS nmos_rvt L=2e-08 W=8.1e-08 nfin=3 $X=0.719 $Y=0.027
M10 N_M10_d N_M10_g N_M10_s VSS nmos_rvt L=2e-08 W=8.1e-08 nfin=3 $X=0.773
+ $Y=0.027
M11 VSS N_M11_g N_M11_s VSS nmos_rvt L=2e-08 W=8.1e-08 nfin=3 $X=0.827 $Y=0.027
M12 N_M12_d N_M12_g VSS VSS nmos_rvt L=2e-08 W=8.1e-08 nfin=3 $X=0.881 $Y=0.027
M13 N_M13_d N_M13_g VSS VSS nmos_rvt L=2e-08 W=8.1e-08 nfin=3 $X=0.935 $Y=0.027
M14 N_M14_d N_M14_g VSS VSS nmos_rvt L=2e-08 W=8.1e-08 nfin=3 $X=0.989 $Y=0.027
M15 N_M15_d N_M15_g VSS VSS nmos_rvt L=2e-08 W=8.1e-08 nfin=3 $X=1.043 $Y=0.027
M16 N_M16_d N_M16_g VSS VSS nmos_rvt L=2e-08 W=8.1e-08 nfin=3 $X=1.097 $Y=0.027
M17 N_M17_d N_M17_g N_M17_s VDD pmos_rvt L=2e-08 W=5.4e-08 nfin=2 $X=0.071
+ $Y=0.189
M18 VDD N_M18_g N_M18_s VDD pmos_rvt L=2e-08 W=5.4e-08 nfin=2 $X=0.125 $Y=0.189
M19 N_M19_d N_M19_g VDD VDD pmos_rvt L=2e-08 W=8.1e-08 nfin=3 $X=0.179 $Y=0.162
M20 N_M20_d N_M20_g N_M20_s VDD pmos_rvt L=2e-08 W=8.1e-08 nfin=3 $X=0.233
+ $Y=0.162
M21 N_M21_d N_M21_g N_M21_s VDD pmos_rvt L=2e-08 W=2.7e-08 nfin=1 $X=0.287
+ $Y=0.216
M22 VDD N_M22_g N_M22_s VDD pmos_rvt L=2e-08 W=2.7e-08 nfin=1 $X=0.395 $Y=0.216
M23 N_M23_d N_M23_g VDD VDD pmos_rvt L=2e-08 W=2.7e-08 nfin=1 $X=0.449 $Y=0.216
M24 VDD N_M24_g N_M24_s VDD pmos_rvt L=2e-08 W=8.1e-08 nfin=3 $X=0.611 $Y=0.162
M25 N_M25_d N_M25_g VDD VDD pmos_rvt L=2e-08 W=5.4e-08 nfin=2 $X=0.665 $Y=0.189
M26 VDD N_M26_g N_M26_s VDD pmos_rvt L=2e-08 W=5.4e-08 nfin=2 $X=0.719 $Y=0.189
M27 VDD N_M27_g N_M27_s VDD pmos_rvt L=2e-08 W=5.4e-08 nfin=2 $X=0.773 $Y=0.189
M28 N_M28_d N_M28_g VDD VDD pmos_rvt L=2e-08 W=5.4e-08 nfin=2 $X=0.827 $Y=0.189
M29 N_M29_d N_M29_g VDD VDD pmos_rvt L=2e-08 W=8.1e-08 nfin=3 $X=0.881 $Y=0.162
M30 N_M30_d N_M30_g VDD VDD pmos_rvt L=2e-08 W=8.1e-08 nfin=3 $X=0.935 $Y=0.162
M31 N_M31_d N_M31_g VDD VDD pmos_rvt L=2e-08 W=8.1e-08 nfin=3 $X=0.989 $Y=0.162
M32 N_M32_d N_M32_g VDD VDD pmos_rvt L=2e-08 W=8.1e-08 nfin=3 $X=1.043 $Y=0.162
M33 N_M33_d N_M33_g VDD VDD pmos_rvt L=2e-08 W=8.1e-08 nfin=3 $X=1.097 $Y=0.162

* .include "ICGx5_ASAP7_75t_R.pex.sp.pxi"

* Start of included file ICGx5_ASAP7_75t_R.pex.sp.pxi
x_PM_ICGx5_ASAP7_75t_R%13 vss N_M19_d N_M20_s N_13_3 N_13_1
+ PM_ICGx5_ASAP7_75t_R%13
cc_1 N_13_3 N_5_1 0.000619695f $X=0.2015 $Y=0.2025
cc_2 N_13_3 N_5_9 0.034835f $X=0.2015 $Y=0.2025
cc_3 N_13_3 N_CLK_19 0.000321977f $X=0.2015 $Y=0.2025
cc_4 N_13_3 N_CLK_1 0.000534588f $X=0.2015 $Y=0.2025
cc_5 N_13_3 N_CLK_10 0.0333797f $X=0.2015 $Y=0.2025
cc_6 N_13_1 N_9_18 0.000525719f $X=0.216 $Y=0.2025
cc_7 N_13_1 N_9_19 0.000567509f $X=0.216 $Y=0.2025
cc_8 N_13_1 N_9_7 0.00255998f $X=0.216 $Y=0.2025
x_PM_ICGx5_ASAP7_75t_R%16__2 vss N_M8_s N_M9_d N_16__2_1
+ PM_ICGx5_ASAP7_75t_R%16__2
cc_9 N_16__2_1 N_CLK_13 0.0168566f $X=0.702 $Y=0.0675
cc_10 N_16__2_1 N_9_14 0.0168143f $X=0.702 $Y=0.0675
x_PM_ICGx5_ASAP7_75t_R%GCLK vss GCLK N_M12_d N_M13_d N_M14_d N_M15_d N_M16_d
+ N_M29_d N_M30_d N_M31_d N_M32_d N_M33_d N_GCLK_19 N_GCLK_20 N_GCLK_23
+ N_GCLK_28 N_GCLK_27 N_GCLK_1 N_GCLK_3 N_GCLK_4 N_GCLK_2 N_GCLK_24 N_GCLK_21
+ N_GCLK_22 PM_ICGx5_ASAP7_75t_R%GCLK
cc_11 N_GCLK_19 N_10_22 0.00033455f $X=0.9035 $Y=0.0675
cc_12 N_GCLK_19 N_10_1 0.000840412f $X=0.9035 $Y=0.0675
cc_13 N_GCLK_19 N_10_25 0.000405177f $X=0.9035 $Y=0.0675
cc_14 N_GCLK_19 N_10_16 0.00228725f $X=0.9035 $Y=0.0675
cc_15 N_GCLK_19 N_10_20 0.000431238f $X=0.9035 $Y=0.0675
cc_16 N_GCLK_19 N_10_24 0.00067387f $X=0.9035 $Y=0.0675
cc_17 N_GCLK_19 N_10_12 0.0570081f $X=0.9035 $Y=0.0675
cc_18 N_GCLK_20 N_10_15 0.0555192f $X=1.0115 $Y=0.0675
cc_19 N_GCLK_23 N_10_15 0.011098f $X=1.0115 $Y=0.2025
cc_20 N_GCLK_28 N_10_22 0.00113761f $X=0.9045 $Y=0.234
cc_21 N_GCLK_27 N_10_21 0.00122327f $X=0.8945 $Y=0.036
cc_22 N_GCLK_1 N_10_26 0.00155102f $X=0.918 $Y=0.0675
cc_23 N_GCLK_3 N_10_14 0.00165897f $X=1.026 $Y=0.0675
cc_24 N_GCLK_4 N_10_15 0.00175444f $X=1.026 $Y=0.2025
cc_25 N_GCLK_27 N_10_14 0.00189218f $X=0.8945 $Y=0.036
cc_26 N_GCLK_28 N_10_14 0.00197927f $X=0.9045 $Y=0.234
cc_27 N_GCLK_1 N_10_12 0.00209268f $X=0.918 $Y=0.0675
cc_28 N_GCLK_2 N_10_13 0.00217011f $X=0.918 $Y=0.2025
cc_29 N_GCLK_24 N_10_16 0.0143588f $X=1.1195 $Y=0.2025
cc_30 N_GCLK_21 N_10_16 0.051462f $X=1.1195 $Y=0.0675
cc_31 N_GCLK_22 N_10_12 0.0285281f $X=0.9035 $Y=0.2025
cc_32 N_GCLK_23 N_10_1 0.0109218f $X=1.0115 $Y=0.2025
cc_33 N_GCLK_23 N_10_14 0.018397f $X=1.0115 $Y=0.2025
cc_34 N_GCLK_20 N_10_14 0.046765f $X=1.0115 $Y=0.0675
cc_35 N_GCLK_19 N_10_13 0.0484196f $X=0.9035 $Y=0.0675
x_PM_ICGx5_ASAP7_75t_R%10 vss N_M12_g N_M29_g N_M13_g N_M30_g N_M14_g N_M31_g
+ N_M15_g N_M32_g N_M16_g N_M33_g N_M10_s N_M9_s N_M27_s N_M28_d N_M25_d
+ N_M26_s N_10_17 N_10_19 N_10_18 N_10_24 N_10_3 N_10_5 N_10_23 N_10_4 N_10_25
+ N_10_20 N_10_1 N_10_26 N_10_12 N_10_22 N_10_16 N_10_15 N_10_21 N_10_14
+ N_10_13 PM_ICGx5_ASAP7_75t_R%10
cc_36 N_10_17 N_CLK_4 9.72076e-20 $X=0.7415 $Y=0.0675
cc_37 N_10_17 N_CLK_18 0.000365293f $X=0.7415 $Y=0.0675
cc_38 N_10_17 N_CLK_14 0.0534735f $X=0.7415 $Y=0.0675
cc_39 N_10_19 N_CLK_14 0.0111932f $X=0.7955 $Y=0.216
cc_40 N_10_18 N_CLK_13 0.0111363f $X=0.6875 $Y=0.216
cc_41 N_10_24 N_CLK_22 0.000366025f $X=0.864 $Y=0.072
cc_42 N_10_3 N_CLK_21 0.000421158f $X=0.702 $Y=0.216
cc_43 N_10_5 N_CLK_4 0.000438805f $X=0.81 $Y=0.216
cc_44 N_10_23 N_CLK_22 0.000463517f $X=0.783 $Y=0.231
cc_45 N_10_5 N_CLK_14 0.00076038f $X=0.81 $Y=0.216
cc_46 N_10_3 N_CLK_13 0.00114541f $X=0.702 $Y=0.216
cc_47 N_10_4 N_CLK_13 0.00141691f $X=0.756 $Y=0.0675
cc_48 N_10_19 N_CLK_4 0.00248498f $X=0.7955 $Y=0.216
cc_49 N_10_23 N_CLK_21 0.0024884f $X=0.783 $Y=0.231
cc_50 N_10_23 N_CLK_18 0.00367016f $X=0.783 $Y=0.231
cc_51 N_10_17 N_CLK_13 0.045606f $X=0.7415 $Y=0.0675
cc_52 N_10_18 N_9_25 7.27132e-20 $X=0.6875 $Y=0.216
cc_53 N_10_18 N_9_24 0.000132989f $X=0.6875 $Y=0.216
cc_54 N_10_18 N_9_23 0.000135419f $X=0.6875 $Y=0.216
cc_55 N_10_18 N_9_2 0.000148965f $X=0.6875 $Y=0.216
cc_56 N_10_23 N_9_25 0.000236455f $X=0.783 $Y=0.231
cc_57 N_10_25 N_9_25 0.000255461f $X=0.864 $Y=0.197
cc_58 N_10_17 N_9_14 0.000291403f $X=0.7415 $Y=0.0675
cc_59 N_10_19 N_9_15 0.0110179f $X=0.7955 $Y=0.216
cc_60 N_10_3 N_9_14 0.000354555f $X=0.702 $Y=0.216
cc_61 N_10_24 N_9_32 0.000383641f $X=0.864 $Y=0.072
cc_62 N_10_5 N_9_15 0.000402576f $X=0.81 $Y=0.216
cc_63 N_10_20 N_9_25 0.000479485f $X=0.837 $Y=0.192
cc_64 N_10_4 N_9_33 0.00196948f $X=0.756 $Y=0.0675
cc_65 N_10_24 N_9_25 0.0013692f $X=0.864 $Y=0.072
cc_66 N_10_1 N_9_3 0.00278576f $X=0.8815 $Y=0.136
cc_67 N_10_26 N_9_25 0.00250897f $X=0.891 $Y=0.113
cc_68 N_10_24 N_9_33 0.00902321f $X=0.864 $Y=0.072
cc_69 N_10_12 N_9_15 0.0173852f $X=0.891 $Y=0.0245
cc_70 N_10_18 N_9_14 0.0253222f $X=0.6875 $Y=0.216
x_PM_ICGx5_ASAP7_75t_R%17 vss N_M10_d N_M11_s N_17_1 PM_ICGx5_ASAP7_75t_R%17
cc_71 N_17_1 N_CLK_14 0.0168788f $X=0.81 $Y=0.0675
cc_72 N_17_1 N_9_15 0.0168189f $X=0.81 $Y=0.0675
x_PM_ICGx5_ASAP7_75t_R%14 vss N_M21_d N_M22_s N_14_4 N_14_1 N_14_5
+ PM_ICGx5_ASAP7_75t_R%14
cc_73 N_14_4 N_CLK_2 0.000155161f $X=0.3095 $Y=0.2295
cc_74 N_14_1 N_CLK_11 0.000840404f $X=0.324 $Y=0.2295
cc_75 N_14_5 N_CLK_11 0.00643017f $X=0.38 $Y=0.2295
cc_76 N_14_4 N_CLK_11 0.0251552f $X=0.3095 $Y=0.2295
cc_77 N_14_1 N_7_9 0.000405483f $X=0.324 $Y=0.2295
cc_78 N_14_4 N_7_9 0.0143454f $X=0.3095 $Y=0.2295
cc_79 N_14_5 N_8_9 0.0161122f $X=0.38 $Y=0.2295
cc_80 N_14_1 N_9_28 0.000138291f $X=0.324 $Y=0.2295
cc_81 N_14_1 N_9_29 0.000212527f $X=0.324 $Y=0.2295
cc_82 N_14_1 N_9_31 0.000277494f $X=0.324 $Y=0.2295
cc_83 N_14_4 N_9_18 0.000278585f $X=0.3095 $Y=0.2295
cc_84 N_14_4 N_9_19 0.000308534f $X=0.3095 $Y=0.2295
cc_85 N_14_1 N_9_26 0.000455925f $X=0.324 $Y=0.2295
cc_86 N_14_4 N_9_7 0.000509336f $X=0.3095 $Y=0.2295
cc_87 N_14_1 N_9_22 0.00249421f $X=0.324 $Y=0.2295
x_PM_ICGx5_ASAP7_75t_R%7 vss N_M3_g N_M21_g N_M7_s N_M24_s N_7_11 N_7_16 N_7_3
+ N_7_17 N_7_18 N_7_1 N_7_10 N_7_15 N_7_13 N_7_12 N_7_14 N_7_4 N_7_9
+ PM_ICGx5_ASAP7_75t_R%7
cc_88 N_7_11 N_CLK_17 0.00035076f $X=0.596 $Y=0.2025
cc_89 N_7_11 N_CLK_23 0.000159389f $X=0.596 $Y=0.2025
cc_90 N_7_11 N_CLK_15 0.000165392f $X=0.596 $Y=0.2025
cc_91 N_7_16 N_CLK_19 0.00387217f $X=0.297 $Y=0.1045
cc_92 N_7_3 N_CLK_20 0.000312186f $X=0.594 $Y=0.0605
cc_93 N_7_17 N_CLK_20 0.00439908f $X=0.568 $Y=0.148
cc_94 N_7_18 N_CLK_16 0.000390719f $X=0.2985 $Y=0.189
cc_95 N_7_1 N_CLK_8 0.000400588f $X=0.297 $Y=0.1335
cc_96 N_7_10 N_CLK_12 0.0153157f $X=0.596 $Y=0.0675
cc_97 N_7_15 N_CLK_21 0.000441317f $X=0.568 $Y=0.232
cc_98 N_7_13 N_CLK_19 0.000454351f $X=0.2945 $Y=0.189
cc_99 N_7_13 N_CLK_23 0.000584547f $X=0.2945 $Y=0.189
cc_100 N_7_1 N_CLK_2 0.000585725f $X=0.297 $Y=0.1335
cc_101 N_7_17 N_CLK_23 0.000631809f $X=0.568 $Y=0.148
cc_102 N_7_3 N_CLK_3 0.000806492f $X=0.594 $Y=0.0605
cc_103 N_7_12 N_CLK_19 0.000897779f $X=0.297 $Y=0.081
cc_104 N_7_3 N_CLK_12 0.000943874f $X=0.594 $Y=0.0605
cc_105 N_7_14 N_CLK_20 0.000976986f $X=0.568 $Y=0.086
cc_106 N_7_1 N_CLK_1 0.00255651f $X=0.297 $Y=0.1335
cc_107 N_7_4 N_CLK_12 0.00135412f $X=0.594 $Y=0.2295
cc_108 N_7_15 N_CLK_17 0.00172918f $X=0.568 $Y=0.232
cc_109 N_7_11 N_CLK_3 0.00175707f $X=0.596 $Y=0.2025
cc_110 N_7_9 N_CLK_11 0.00357992f $X=0.297 $Y=0.0245
cc_111 N_7_9 N_CLK_10 0.00685973f $X=0.297 $Y=0.0245
cc_112 N_7_18 N_CLK_23 0.0237638f $X=0.2985 $Y=0.189
cc_113 N_7_11 N_CLK_12 0.0427653f $X=0.596 $Y=0.2025
x_PM_ICGx5_ASAP7_75t_R%8 vss N_M5_g N_M22_g N_M6_d N_M23_d N_8_9 N_8_1 N_8_14
+ N_8_15 N_8_12 N_8_13 N_8_4 N_8_11 N_8_3 N_8_10 PM_ICGx5_ASAP7_75t_R%8
cc_114 N_8_9 N_CLK_20 8.51921e-20 $X=0.405 $Y=0.0245
cc_115 N_8_9 N_CLK_16 0.000324887f $X=0.405 $Y=0.0245
cc_116 N_8_9 N_CLK_23 0.000173783f $X=0.405 $Y=0.0245
cc_117 N_8_9 N_CLK_8 0.00285646f $X=0.405 $Y=0.0245
cc_118 N_8_9 N_CLK_15 0.000466423f $X=0.405 $Y=0.0245
cc_119 N_8_1 N_CLK_8 0.00141587f $X=0.396 $Y=0.082
cc_120 N_8_14 N_CLK_16 0.000642637f $X=0.3965 $Y=0.082
cc_121 N_8_14 N_CLK_23 0.00155734f $X=0.3965 $Y=0.082
cc_122 N_8_15 N_CLK_23 0.00157823f $X=0.5125 $Y=0.093
cc_123 N_8_14 N_CLK_15 0.00247149f $X=0.3965 $Y=0.082
cc_124 N_8_9 N_CLK_11 0.0127679f $X=0.405 $Y=0.0245
cc_125 N_8_15 N_7_14 0.000228667f $X=0.5125 $Y=0.093
cc_126 N_8_15 N_7_3 0.000280756f $X=0.5125 $Y=0.093
cc_127 N_8_15 N_7_4 0.000292444f $X=0.5125 $Y=0.093
cc_128 N_8_12 N_7_15 0.000806226f $X=0.5125 $Y=0.233
cc_129 N_8_13 N_7_14 0.000937378f $X=0.5125 $Y=0.082
cc_130 N_8_12 N_7_18 0.00156621f $X=0.5125 $Y=0.233
cc_131 N_8_15 N_7_17 0.00617374f $X=0.5125 $Y=0.093
x_PM_ICGx5_ASAP7_75t_R%CLK vss CLK N_M10_g N_M27_g N_M9_g N_M26_g N_M7_g
+ N_M24_g N_M20_g N_M4_g N_CLK_23 N_CLK_1 N_CLK_10 N_CLK_19 N_CLK_17 N_CLK_15
+ N_CLK_20 N_CLK_16 N_CLK_8 N_CLK_12 N_CLK_21 N_CLK_2 N_CLK_3 N_CLK_11 N_CLK_18
+ N_CLK_4 N_CLK_14 N_CLK_22 N_CLK_13 PM_ICGx5_ASAP7_75t_R%CLK
cc_132 N_CLK_23 N_5_16 0.000601974f $X=0.5872 $Y=0.153
cc_133 N_CLK_1 N_5_1 0.00184411f $X=0.243 $Y=0.1335
cc_134 N_CLK_10 N_5_9 0.00322624f $X=0.243 $Y=0.1335
cc_135 N_CLK_19 N_5_16 0.00444523f $X=0.243 $Y=0.1215
x_PM_ICGx5_ASAP7_75t_R%15 vss N_M4_d N_M5_s N_15_3 N_15_1
+ PM_ICGx5_ASAP7_75t_R%15
cc_136 N_15_3 N_CLK_11 0.0133804f $X=0.3635 $Y=0.0405
cc_137 N_15_3 N_8_9 0.0177706f $X=0.3635 $Y=0.0405
cc_138 N_15_1 N_9_28 0.000147706f $X=0.378 $Y=0.0405
cc_139 N_15_1 N_9_30 0.000222865f $X=0.378 $Y=0.0405
cc_140 N_15_1 N_9_16 0.000261766f $X=0.378 $Y=0.0405
cc_141 N_15_1 N_9_17 0.000309281f $X=0.378 $Y=0.0405
cc_142 N_15_1 N_9_8 0.00168633f $X=0.378 $Y=0.0405
x_PM_ICGx5_ASAP7_75t_R%ENA vss ENA N_M0_g N_M17_g N_ENA_1 N_ENA_4 N_ENA_3
+ PM_ICGx5_ASAP7_75t_R%ENA
x_PM_ICGx5_ASAP7_75t_R%18 vss N_M17_d N_M18_s N_18_1 PM_ICGx5_ASAP7_75t_R%18
cc_143 N_18_1 N_ENA_3 0.0126169f $X=0.108 $Y=0.216
cc_144 N_18_1 N_SE_3 0.0056717f $X=0.108 $Y=0.216
x_PM_ICGx5_ASAP7_75t_R%SE vss SE N_M1_g N_M18_g N_SE_3 N_SE_4 N_SE_1
+ PM_ICGx5_ASAP7_75t_R%SE
cc_145 N_SE_3 N_ENA_1 0.00152482f $X=0.135 $Y=0.0245
cc_146 N_SE_4 N_ENA_4 0.00463405f $X=0.135 $Y=0.0972
cc_147 N_SE_3 N_ENA_3 0.0125629f $X=0.135 $Y=0.0245
x_PM_ICGx5_ASAP7_75t_R%9 vss N_M11_g N_M28_g N_M8_g N_M25_g N_M3_d N_M4_s
+ N_M6_g N_M23_g N_M20_d N_M21_s N_9_16 N_9_23 N_9_22 N_9_29 N_9_27 N_9_18
+ N_9_21 N_9_24 N_9_33 N_9_7 N_9_19 N_9_25 N_9_3 N_9_1 N_9_31 N_9_32 N_9_17
+ N_9_26 N_9_28 N_9_30 N_9_13 N_9_8 N_9_2 N_9_14 N_9_15 PM_ICGx5_ASAP7_75t_R%9
cc_148 N_9_16 N_CLK_19 6.02313e-20 $X=0.3095 $Y=0.0405
cc_149 N_9_23 N_CLK_20 6.78246e-20 $X=0.675 $Y=0.036
cc_150 N_9_22 N_CLK_15 7.44739e-20 $X=0.358 $Y=0.2235
cc_151 N_9_29 N_CLK_15 8.98681e-20 $X=0.358 $Y=0.211
cc_152 N_9_27 N_CLK_11 0.000144993f $X=0.3285 $Y=0.036
cc_153 N_9_18 N_CLK_10 0.00979901f $X=0.2555 $Y=0.2295
cc_154 N_9_21 N_CLK_15 0.000181462f $X=0.358 $Y=0.1895
cc_155 N_9_24 N_CLK_20 0.00328819f $X=0.675 $Y=0.1075
cc_156 N_9_33 N_CLK_18 0.000208148f $X=0.7965 $Y=0.108
cc_157 N_9_7 N_CLK_19 0.000969544f $X=0.27 $Y=0.2295
cc_158 N_9_19 N_CLK_10 0.0242072f $X=0.2555 $Y=0.189
cc_159 N_9_25 N_CLK_4 0.000257284f $X=0.837 $Y=0.1205
cc_160 N_9_7 N_CLK_1 0.000263747f $X=0.27 $Y=0.2295
cc_161 N_9_3 N_CLK_4 0.000272865f $X=0.837 $Y=0.135
cc_162 N_9_1 N_CLK_8 0.000351617f $X=0.459 $Y=0.19
cc_163 N_9_33 N_CLK_4 0.000391602f $X=0.7965 $Y=0.108
cc_164 N_9_31 N_CLK_16 0.00494911f $X=0.3795 $Y=0.19
cc_165 N_9_1 N_CLK_16 0.000426476f $X=0.459 $Y=0.19
cc_166 N_9_32 N_CLK_20 0.000431095f $X=0.675 $Y=0.097
cc_167 N_9_17 N_CLK_11 0.00558743f $X=0.3095 $Y=0.081
cc_168 N_9_26 N_CLK_19 0.000468898f $X=0.3365 $Y=0.232
cc_169 N_9_28 N_CLK_8 0.00261529f $X=0.358 $Y=0.0585
cc_170 N_9_18 N_CLK_1 0.000596496f $X=0.2555 $Y=0.2295
cc_171 N_9_3 N_CLK_14 0.000622808f $X=0.837 $Y=0.135
cc_172 N_9_30 N_CLK_23 0.000792841f $X=0.648 $Y=0.036
cc_173 N_9_13 N_CLK_8 0.000851751f $X=0.459 $Y=0.19
cc_174 N_9_8 N_CLK_11 0.000883182f $X=0.324 $Y=0.0405
cc_175 N_9_16 N_CLK_2 0.00093465f $X=0.3095 $Y=0.0405
cc_176 N_9_7 N_CLK_10 0.00114478f $X=0.27 $Y=0.2295
cc_177 N_9_31 N_CLK_15 0.00120323f $X=0.3795 $Y=0.19
cc_178 N_9_2 N_CLK_3 0.00344929f $X=0.675 $Y=0.135
cc_179 N_9_24 N_CLK_21 0.00139707f $X=0.675 $Y=0.1075
cc_180 N_9_14 N_CLK_12 0.0019858f $X=0.675 $Y=0.135
cc_181 N_9_15 N_CLK_4 0.00201313f $X=0.837 $Y=0.0245
cc_182 N_9_31 N_CLK_23 0.00228066f $X=0.3795 $Y=0.19
cc_183 N_9_33 N_CLK_22 0.00355565f $X=0.7965 $Y=0.108
cc_184 N_9_28 N_CLK_15 0.00390573f $X=0.358 $Y=0.0585
cc_185 N_9_15 N_CLK_14 0.00708218f $X=0.837 $Y=0.0245
cc_186 N_9_14 N_CLK_13 0.00859434f $X=0.675 $Y=0.135
cc_187 N_9_16 N_CLK_11 0.0314725f $X=0.3095 $Y=0.0405
cc_188 N_9_1 N_7_9 0.000198409f $X=0.459 $Y=0.19
cc_189 N_9_33 N_7_9 0.000114045f $X=0.7965 $Y=0.108
cc_190 N_9_16 N_7_9 0.00982922f $X=0.3095 $Y=0.0405
cc_191 N_9_18 N_7_9 0.0109484f $X=0.2555 $Y=0.2295
cc_192 N_9_7 N_7_9 0.00148028f $X=0.27 $Y=0.2295
cc_193 N_9_8 N_7_12 0.0002143f $X=0.324 $Y=0.0405
cc_194 N_9_24 N_7_14 0.000228503f $X=0.675 $Y=0.1075
cc_195 N_9_22 N_7_13 0.000242723f $X=0.358 $Y=0.2235
cc_196 N_9_32 N_7_14 0.000266286f $X=0.675 $Y=0.097
cc_197 N_9_30 N_7_3 0.00112818f $X=0.648 $Y=0.036
cc_198 N_9_19 N_7_9 0.00558956f $X=0.2555 $Y=0.189
cc_199 N_9_31 N_7_17 0.000497559f $X=0.3795 $Y=0.19
cc_200 N_9_26 N_7_13 0.00454485f $X=0.3365 $Y=0.232
cc_201 N_9_29 N_7_13 0.00052119f $X=0.358 $Y=0.211
cc_202 N_9_21 N_7_13 0.000634201f $X=0.358 $Y=0.1895
cc_203 N_9_8 N_7_1 0.000695191f $X=0.324 $Y=0.0405
cc_204 N_9_8 N_7_9 0.00136079f $X=0.324 $Y=0.0405
cc_205 N_9_16 N_7_1 0.00154494f $X=0.3095 $Y=0.0405
cc_206 N_9_27 N_7_12 0.00179045f $X=0.3285 $Y=0.036
cc_207 N_9_31 N_7_18 0.00344855f $X=0.3795 $Y=0.19
cc_208 N_9_28 N_7_16 0.00362367f $X=0.358 $Y=0.0585
cc_209 N_9_30 N_7_14 0.00412425f $X=0.648 $Y=0.036
cc_210 N_9_17 N_7_9 0.0453363f $X=0.3095 $Y=0.081
cc_211 N_9_8 N_8_9 0.000281101f $X=0.324 $Y=0.0405
cc_212 N_9_1 N_8_9 0.000375515f $X=0.459 $Y=0.19
cc_213 N_9_30 N_8_9 0.000378543f $X=0.648 $Y=0.036
cc_214 N_9_13 N_8_1 0.000671617f $X=0.459 $Y=0.19
cc_215 N_9_30 N_8_1 0.000730946f $X=0.648 $Y=0.036
cc_216 N_9_1 N_8_4 0.00157746f $X=0.459 $Y=0.19
cc_217 N_9_1 N_8_11 0.00124276f $X=0.459 $Y=0.19
cc_218 N_9_28 N_8_14 0.00131585f $X=0.358 $Y=0.0585
cc_219 N_9_31 N_8_15 0.00153361f $X=0.3795 $Y=0.19
cc_220 N_9_13 N_8_3 0.00164165f $X=0.459 $Y=0.19
cc_221 N_9_31 N_8_12 0.00219459f $X=0.3795 $Y=0.19
cc_222 N_9_13 N_8_10 0.00636915f $X=0.459 $Y=0.19
cc_223 N_9_13 N_8_11 0.00657486f $X=0.459 $Y=0.19
cc_224 N_9_30 N_8_14 0.00362092f $X=0.648 $Y=0.036
cc_225 N_9_30 N_8_13 0.00509099f $X=0.648 $Y=0.036
cc_226 N_9_13 N_8_9 0.0302439f $X=0.459 $Y=0.19
x_PM_ICGx5_ASAP7_75t_R%12 vss N_M2_d N_M3_s N_12_4 N_12_5 N_12_1
+ PM_ICGx5_ASAP7_75t_R%12
cc_227 N_12_4 N_5_16 0.000664342f $X=0.2015 $Y=0.0675
cc_228 N_12_4 N_5_9 0.0358517f $X=0.2015 $Y=0.0675
cc_229 N_12_5 N_CLK_1 0.00202828f $X=0.272 $Y=0.0675
cc_230 N_12_5 N_CLK_10 0.0729106f $X=0.272 $Y=0.0675
cc_231 N_12_5 N_7_1 0.000675522f $X=0.272 $Y=0.0675
cc_232 N_12_5 N_7_12 0.0028595f $X=0.272 $Y=0.0675
cc_233 N_12_5 N_7_9 0.033516f $X=0.272 $Y=0.0675
cc_234 N_12_1 N_9_8 0.00113786f $X=0.243 $Y=0.0675
cc_235 N_12_1 N_9_17 0.000592945f $X=0.243 $Y=0.0675
cc_236 N_12_1 N_9_16 0.00193764f $X=0.243 $Y=0.0675
x_PM_ICGx5_ASAP7_75t_R%5 vss N_M2_g N_M19_g N_M0_d N_M1_s N_M17_s N_5_16 N_5_15
+ N_5_4 N_5_11 N_5_3 N_5_14 N_5_10 N_5_1 N_5_9 PM_ICGx5_ASAP7_75t_R%5
cc_237 N_5_16 N_ENA_3 0.000406189f $X=0.189 $Y=0.1045
cc_238 N_5_15 N_ENA_4 0.000636073f $X=0.162 $Y=0.036
cc_239 N_5_4 N_ENA_3 0.000690733f $X=0.108 $Y=0.054
cc_240 N_5_11 N_ENA_1 0.000728847f $X=0.056 $Y=0.216
cc_241 N_5_3 N_ENA_3 0.00108554f $X=0.054 $Y=0.216
cc_242 N_5_14 N_ENA_4 0.00131656f $X=0.162 $Y=0.233
cc_243 N_5_4 N_ENA_4 0.00294816f $X=0.108 $Y=0.054
cc_244 N_5_10 N_ENA_3 0.0104931f $X=0.0935 $Y=0.054
cc_245 N_5_11 N_ENA_3 0.0407702f $X=0.056 $Y=0.216
cc_246 N_5_1 N_SE_3 0.000921233f $X=0.189 $Y=0.134
cc_247 N_5_15 N_SE_4 0.000964947f $X=0.162 $Y=0.036
cc_248 N_5_14 N_SE_4 0.00116427f $X=0.162 $Y=0.233
cc_249 N_5_1 N_SE_1 0.00133614f $X=0.189 $Y=0.134
cc_250 N_5_10 N_SE_3 0.0103602f $X=0.0935 $Y=0.054
cc_251 N_5_16 N_SE_4 0.00700367f $X=0.189 $Y=0.1045
cc_252 N_5_9 N_SE_3 0.0140654f $X=0.189 $Y=0.0245

* End of included file ICGx5_ASAP7_75t_R.pex.sp.pxi
.ends

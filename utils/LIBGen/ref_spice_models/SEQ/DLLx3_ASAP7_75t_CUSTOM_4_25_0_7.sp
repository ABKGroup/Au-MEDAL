.subckt PM_DLLx3_ASAP7_75t_R%12 vss 2 3 1
c1 1 vss 0.000538973f $X=0.486 $Y=0.0405
r1 2 1 0.62963 $w=2.7e-08 $l=1.7e-08 $layer=N_src_drn $thickness=1e-09
+ $X=0.4686 $Y=0.0405 $X2=0.486 $Y2=0.0405
r2 3 1 0.62963 $w=2.7e-08 $l=1.7e-08 $layer=N_src_drn $thickness=1e-09
+ $X=0.5033 $Y=0.0405 $X2=0.486 $Y2=0.0405
.ends

.subckt PM_DLLx3_ASAP7_75t_R%CLK vss 18 9 15 3 1 4 5 7 8 6
c1 1 vss 0.00374618f $X=0.081 $Y=0.135
c2 3 vss 0.0695535f $X=0.081 $Y=0.0245
c3 4 vss 0.00207097f $X=0.081 $Y=0.099
c4 5 vss 0.00173247f $X=0.081 $Y=0.171
c5 6 vss 0.000984222f $X=0.081 $Y=0.135
c6 7 vss 0.00435708f $X=0.108 $Y=0.063
c7 8 vss 0.00439511f $X=0.108 $Y=0.198
r1 8 24 2.40741 $w=2.45e-08 $l=2.7e-08 $layer=M1 $thickness=3.6e-08 $X=0.108
+ $Y=0.198 $X2=0.108 $Y2=0.171
r2 7 22 4.50612 $w=2.06667e-08 $l=3.6e-08 $layer=M1 $thickness=3.6e-08 $X=0.108
+ $Y=0.063 $X2=0.108 $Y2=0.099
r3 23 24 0.502848 $w=3.43333e-08 $l=1.35e-08 $layer=M1 $thickness=3.6e-08
+ $X=0.0945 $Y=0.171 $X2=0.108 $Y2=0.171
r4 5 20 1.35805 $w=2.83333e-08 $l=2.25e-08 $layer=M1 $thickness=3.6e-08
+ $X=0.081 $Y=0.171 $X2=0.081 $Y2=0.1485
r5 5 23 0.502848 $w=3.43333e-08 $l=1.35e-08 $layer=M1 $thickness=3.6e-08
+ $X=0.081 $Y=0.171 $X2=0.0945 $Y2=0.171
r6 21 22 0.502848 $w=3.43333e-08 $l=1.35e-08 $layer=M1 $thickness=3.6e-08
+ $X=0.0945 $Y=0.099 $X2=0.108 $Y2=0.099
r7 4 17 0.483592 $w=3.42308e-08 $l=1.87e-08 $layer=M1 $thickness=3.6e-08
+ $X=0.081 $Y=0.099 $X2=0.081 $Y2=0.1177
r8 4 21 0.502848 $w=3.43333e-08 $l=1.35e-08 $layer=M1 $thickness=3.6e-08
+ $X=0.081 $Y=0.099 $X2=0.0945 $Y2=0.099
r9 18 19 0.874462 $w=1.3e-08 $l=3.7e-09 $layer=M1 $thickness=3.6e-08 $X=0.082
+ $Y=0.119 $X2=0.081 $Y2=0.1227
r10 18 17 0.291487 $w=1.3e-08 $l=1.3e-09 $layer=M1 $thickness=3.6e-08 $X=0.082
+ $Y=0.119 $X2=0.081 $Y2=0.1177
r11 6 19 2.85657 $w=1.3e-08 $l=1.23e-08 $layer=M1 $thickness=3.6e-08 $X=0.081
+ $Y=0.135 $X2=0.081 $Y2=0.1227
r12 6 20 3.14806 $w=1.3e-08 $l=1.35e-08 $layer=M1 $thickness=3.6e-08 $X=0.081
+ $Y=0.135 $X2=0.081 $Y2=0.1485
r13 1 12 10.4265 $w=1.765e-08 $layer=LIG $thickness=5.2e-08 $X=0.081 $Y=0.135
+ $X2=0.081 $Y2=0.135
r14 1 6 19.3796 $a=3.24e-16 $layer=V0LIG $X=0.081 $Y=0.135 $X2=0.081 $Y2=0.135
r15 15 14 14.6259 $w=2.1e-08 $l=4.3e-08 $layer=Gate_1 $thickness=5.6e-08
+ $X=0.081 $Y=0.216 $X2=0.081 $Y2=0.173
r16 13 14 7.31297 $w=2.1e-08 $l=2.15e-08 $layer=Gate_1 $thickness=5.6e-08
+ $X=0.081 $Y=0.1515 $X2=0.081 $Y2=0.173
r17 12 13 5.79936 $w=2.03333e-08 $l=1.65e-08 $layer=Gate_1 $thickness=5.6e-08
+ $X=0.081 $Y=0.135 $X2=0.081 $Y2=0.1515
r18 11 12 5.79936 $w=2.03333e-08 $l=1.65e-08 $layer=Gate_1 $thickness=5.6e-08
+ $X=0.081 $Y=0.1185 $X2=0.081 $Y2=0.135
r19 10 11 7.31297 $w=2.1e-08 $l=2.15e-08 $layer=Gate_1 $thickness=5.6e-08
+ $X=0.081 $Y=0.097 $X2=0.081 $Y2=0.1185
r20 9 10 14.6259 $w=2.1e-08 $l=4.3e-08 $layer=Gate_1 $thickness=5.6e-08
+ $X=0.081 $Y=0.054 $X2=0.081 $Y2=0.097
r21 9 3 10.0341 $w=2.1e-08 $l=2.95e-08 $layer=Gate_1 $thickness=5.6e-08
+ $X=0.081 $Y=0.054 $X2=0.081 $Y2=0.0245
.ends

.subckt PM_DLLx3_ASAP7_75t_R%D vss 16 7 13 6 4 5 1 3
c1 1 vss 0.00500498f $X=0.297 $Y=0.135
c2 3 vss 0.0918971f $X=0.297 $Y=0.0245
c3 4 vss 0.00541871f $X=0.297 $Y=0.036
c4 5 vss 0.00519739f $X=0.297 $Y=0.234
c5 6 vss 0.00567003f $X=0.297 $Y=0.0755
r1 5 20 3.48349 $w=1.525e-08 $l=2e-08 $layer=M1 $thickness=3.6e-08 $X=0.297
+ $Y=0.234 $X2=0.297 $Y2=0.214
r2 4 6 8.03069 $w=1.41392e-08 $l=3.95e-08 $layer=M1 $thickness=3.6e-08 $X=0.297
+ $Y=0.036 $X2=0.297 $Y2=0.0755
r3 19 20 9.44419 $w=1.3e-08 $l=4.05e-08 $layer=M1 $thickness=3.6e-08 $X=0.297
+ $Y=0.1735 $X2=0.297 $Y2=0.214
r4 18 19 8.97781 $w=1.3e-08 $l=3.85e-08 $layer=M1 $thickness=3.6e-08 $X=0.297
+ $Y=0.135 $X2=0.297 $Y2=0.1735
r5 17 18 3.14806 $w=1.3e-08 $l=1.35e-08 $layer=M1 $thickness=3.6e-08 $X=0.297
+ $Y=0.1215 $X2=0.297 $Y2=0.135
r6 16 17 1.16595 $w=1.3e-08 $l=5e-09 $layer=M1 $thickness=3.6e-08 $X=0.297
+ $Y=0.1165 $X2=0.297 $Y2=0.1215
r7 16 15 1.28254 $w=1.3e-08 $l=5.5e-09 $layer=M1 $thickness=3.6e-08 $X=0.297
+ $Y=0.1165 $X2=0.297 $Y2=0.111
r8 6 15 8.27824 $w=1.3e-08 $l=3.55e-08 $layer=M1 $thickness=3.6e-08 $X=0.297
+ $Y=0.0755 $X2=0.297 $Y2=0.111
r9 1 10 10.4265 $w=1.765e-08 $layer=LIG $thickness=5.2e-08 $X=0.297 $Y=0.135
+ $X2=0.297 $Y2=0.135
r10 1 18 19.3796 $a=3.24e-16 $layer=V0LIG $X=0.297 $Y=0.135 $X2=0.297 $Y2=0.135
r11 13 12 14.6259 $w=2.1e-08 $l=4.3e-08 $layer=Gate_1 $thickness=5.6e-08
+ $X=0.297 $Y=0.2025 $X2=0.297 $Y2=0.1595
r12 11 12 2.7211 $w=2.1e-08 $l=8e-09 $layer=Gate_1 $thickness=5.6e-08 $X=0.297
+ $Y=0.1515 $X2=0.297 $Y2=0.1595
r13 10 11 5.79936 $w=2.03333e-08 $l=1.65e-08 $layer=Gate_1 $thickness=5.6e-08
+ $X=0.297 $Y=0.135 $X2=0.297 $Y2=0.1515
r14 9 10 5.79936 $w=2.03333e-08 $l=1.65e-08 $layer=Gate_1 $thickness=5.6e-08
+ $X=0.297 $Y=0.1185 $X2=0.297 $Y2=0.135
r15 8 9 2.7211 $w=2.1e-08 $l=8e-09 $layer=Gate_1 $thickness=5.6e-08 $X=0.297
+ $Y=0.1105 $X2=0.297 $Y2=0.1185
r16 7 8 14.6259 $w=2.1e-08 $l=4.3e-08 $layer=Gate_1 $thickness=5.6e-08 $X=0.297
+ $Y=0.0675 $X2=0.297 $Y2=0.1105
r17 7 3 14.6259 $w=2.1e-08 $l=4.3e-08 $layer=Gate_1 $thickness=5.6e-08 $X=0.297
+ $Y=0.0675 $X2=0.297 $Y2=0.0245
.ends

.subckt PM_DLLx3_ASAP7_75t_R%7 vss 18 22 42 47 9 1 13 4 17 3 16 12 11 10 15
c1 1 vss 0.0026414f $X=0.513 $Y=0.082
c2 3 vss 0.0062082f $X=0.594 $Y=0.0405
c3 4 vss 0.00611612f $X=0.594 $Y=0.2295
c4 9 vss 0.0406937f $X=0.513 $Y=0.0245
c5 10 vss 0.0186555f $X=0.5795 $Y=0.0405
c6 11 vss 0.0184896f $X=0.5795 $Y=0.2295
c7 12 vss 0.00291311f $X=0.513 $Y=0.036
c8 13 vss 0.00649527f $X=0.621 $Y=0.234
c9 14 vss 0.00334161f $X=0.621 $Y=0.0315
c10 15 vss 0.0014715f $X=0.513 $Y=0.059
c11 16 vss 0.00828746f $X=0.551 $Y=0.036
c12 17 vss 0.00690796f $X=0.621 $Y=0.0495
r1 11 4 0.462963 $w=2.7e-08 $l=1.25e-08 $layer=P_src_drn $thickness=1e-09
+ $X=0.5795 $Y=0.2295 $X2=0.594 $Y2=0.2295
r2 47 11 0.0925926 $w=2.7e-08 $l=2.5e-09 $layer=P_src_drn $thickness=1e-09
+ $X=0.5766 $Y=0.2295 $X2=0.5795 $Y2=0.2295
r3 4 44 19.3796 $a=3.24e-16 $layer=V0LISD $X=0.594 $Y=0.2295 $X2=0.594 $Y2=0.234
r4 44 45 3.14806 $w=1.3e-08 $l=1.35e-08 $layer=M1 $thickness=3.6e-08 $X=0.594
+ $Y=0.234 $X2=0.6075 $Y2=0.234
r5 13 40 1.96775 $w=1.63333e-08 $l=1.35e-08 $layer=M1 $thickness=3.6e-08
+ $X=0.621 $Y=0.234 $X2=0.621 $Y2=0.2205
r6 13 45 1.96775 $w=1.63333e-08 $l=1.35e-08 $layer=M1 $thickness=3.6e-08
+ $X=0.621 $Y=0.234 $X2=0.6075 $Y2=0.234
r7 10 3 0.462963 $w=2.7e-08 $l=1.25e-08 $layer=N_src_drn $thickness=1e-09
+ $X=0.5795 $Y=0.0405 $X2=0.594 $Y2=0.0405
r8 42 10 0.0925926 $w=2.7e-08 $l=2.5e-09 $layer=N_src_drn $thickness=1e-09
+ $X=0.5766 $Y=0.0405 $X2=0.5795 $Y2=0.0405
r9 39 40 2.56509 $w=1.3e-08 $l=1.1e-08 $layer=M1 $thickness=3.6e-08 $X=0.621
+ $Y=0.2095 $X2=0.621 $Y2=0.2205
r10 38 39 5.71315 $w=1.3e-08 $l=2.45e-08 $layer=M1 $thickness=3.6e-08 $X=0.621
+ $Y=0.185 $X2=0.621 $Y2=0.2095
r11 37 38 4.43061 $w=1.3e-08 $l=1.9e-08 $layer=M1 $thickness=3.6e-08 $X=0.621
+ $Y=0.166 $X2=0.621 $Y2=0.185
r12 36 37 3.14806 $w=1.3e-08 $l=1.35e-08 $layer=M1 $thickness=3.6e-08 $X=0.621
+ $Y=0.1525 $X2=0.621 $Y2=0.166
r13 35 36 5.01358 $w=1.3e-08 $l=2.15e-08 $layer=M1 $thickness=3.6e-08 $X=0.621
+ $Y=0.131 $X2=0.621 $Y2=0.1525
r14 34 35 5.01358 $w=1.3e-08 $l=2.15e-08 $layer=M1 $thickness=3.6e-08 $X=0.621
+ $Y=0.1095 $X2=0.621 $Y2=0.131
r15 33 34 3.73104 $w=1.3e-08 $l=1.6e-08 $layer=M1 $thickness=3.6e-08 $X=0.621
+ $Y=0.0935 $X2=0.621 $Y2=0.1095
r16 32 33 5.01358 $w=1.3e-08 $l=2.15e-08 $layer=M1 $thickness=3.6e-08 $X=0.621
+ $Y=0.072 $X2=0.621 $Y2=0.0935
r17 17 31 1.50855 $w=1.55e-08 $l=9e-09 $layer=M1 $thickness=3.6e-08 $X=0.621
+ $Y=0.0495 $X2=0.621 $Y2=0.0405
r18 17 32 5.24677 $w=1.3e-08 $l=2.25e-08 $layer=M1 $thickness=3.6e-08 $X=0.621
+ $Y=0.0495 $X2=0.621 $Y2=0.072
r19 3 29 19.3796 $a=3.24e-16 $layer=V0LISD $X=0.594 $Y=0.0405 $X2=0.594
+ $Y2=0.036
r20 14 30 1.50855 $w=1.55e-08 $l=1.42302e-08 $layer=M1 $thickness=3.6e-08
+ $X=0.621 $Y=0.0315 $X2=0.6075 $Y2=0.036
r21 14 31 0.9184 $w=1.8e-08 $l=9e-09 $layer=M1 $thickness=3.6e-08 $X=0.621
+ $Y=0.0315 $X2=0.621 $Y2=0.0405
r22 29 30 3.14806 $w=1.3e-08 $l=1.35e-08 $layer=M1 $thickness=3.6e-08 $X=0.594
+ $Y=0.036 $X2=0.6075 $Y2=0.036
r23 28 29 2.68168 $w=1.3e-08 $l=1.15e-08 $layer=M1 $thickness=3.6e-08 $X=0.5825
+ $Y=0.036 $X2=0.594 $Y2=0.036
r24 16 28 7.34548 $w=1.3e-08 $l=3.15e-08 $layer=M1 $thickness=3.6e-08 $X=0.551
+ $Y=0.036 $X2=0.5825 $Y2=0.036
r25 12 15 3.71425 $w=1.68348e-08 $l=2.3e-08 $layer=M1 $thickness=3.6e-08
+ $X=0.513 $Y=0.036 $X2=0.513 $Y2=0.059
r26 12 16 7.2121 $w=1.41842e-08 $l=3.8e-08 $layer=M1 $thickness=3.6e-08
+ $X=0.513 $Y=0.036 $X2=0.551 $Y2=0.036
r27 15 26 5.36336 $w=1.3e-08 $l=2.3e-08 $layer=M1 $thickness=3.6e-08 $X=0.513
+ $Y=0.059 $X2=0.513 $Y2=0.082
r28 1 20 6.54019 $w=2.09524e-08 $layer=Gate_1 $thickness=5.21905e-08 $X=0.513
+ $Y=0.082 $X2=0.513 $Y2=0.082
r29 1 26 19.3796 $a=3.24e-16 $layer=V0LIG $X=0.513 $Y=0.082 $X2=0.513 $Y2=0.082
r30 22 21 25.5104 $w=2.1e-08 $l=7.5e-08 $layer=Gate_1 $thickness=5.6e-08
+ $X=0.513 $Y=0.2295 $X2=0.513 $Y2=0.1545
r31 20 21 24.8471 $w=2.08483e-08 $l=7.25e-08 $layer=Gate_1 $thickness=5.6e-08
+ $X=0.513 $Y=0.082 $X2=0.513 $Y2=0.1545
r32 19 20 6.81977 $w=2.04359e-08 $l=1.95e-08 $layer=Gate_1 $thickness=5.6e-08
+ $X=0.513 $Y=0.0625 $X2=0.513 $Y2=0.082
r33 18 19 7.48304 $w=2.1e-08 $l=2.2e-08 $layer=Gate_1 $thickness=5.6e-08
+ $X=0.513 $Y=0.0405 $X2=0.513 $Y2=0.0625
r34 18 9 5.44221 $w=2.1e-08 $l=1.6e-08 $layer=Gate_1 $thickness=5.6e-08
+ $X=0.513 $Y=0.0405 $X2=0.513 $Y2=0.0245
.ends

.subckt PM_DLLx3_ASAP7_75t_R%6 vss 29 70 74 76 4 5 20 19 18 17 16 15 21 2 23 1
+ 14 12 13 6 22
c1 1 vss 0.000418474f $X=0.351 $Y=0.135
c2 2 vss 0.00015026f $X=0.459 $Y=0.179
c3 4 vss 0.00760115f $X=0.162 $Y=0.054
c4 5 vss 0.00748855f $X=0.162 $Y=0.216
c5 6 vss 0.00963084f $X=0.501 $Y=0.179
c6 12 vss 0.00787692f $X=0.351 $Y=0.073
c7 13 vss 0.00644353f $X=0.459 $Y=0.179
c8 14 vss 0.0325172f $X=0.1475 $Y=0.054
c9 15 vss 0.0323173f $X=0.1475 $Y=0.216
c10 16 vss 0.00308825f $X=0.243 $Y=0.036
c11 17 vss 0.00283725f $X=0.243 $Y=0.234
c12 18 vss 0.00969199f $X=0.216 $Y=0.036
c13 19 vss 0.00877381f $X=0.216 $Y=0.234
c14 20 vss 0.00802217f $X=0.243 $Y=0.153
c15 21 vss 0.00172291f $X=0.351 $Y=0.116
c16 22 vss 0.00144174f $X=0.513 $Y=0.168
c17 23 vss 0.013232f $X=0.2315 $Y=0.189
r1 15 5 0.231482 $w=5.4e-08 $l=1.25e-08 $layer=P_src_drn $thickness=1e-09
+ $X=0.1475 $Y=0.216 $X2=0.162 $Y2=0.216
r2 76 15 0.0462963 $w=5.4e-08 $l=2.5e-09 $layer=P_src_drn $thickness=1e-09
+ $X=0.1446 $Y=0.216 $X2=0.1475 $Y2=0.216
r3 14 4 0.231482 $w=5.4e-08 $l=1.25e-08 $layer=N_src_drn $thickness=1e-09
+ $X=0.1475 $Y=0.054 $X2=0.162 $Y2=0.054
r4 74 14 0.0462963 $w=5.4e-08 $l=2.5e-09 $layer=N_src_drn $thickness=1e-09
+ $X=0.1446 $Y=0.054 $X2=0.1475 $Y2=0.054
r5 70 71 23.4695 $w=2.1e-08 $l=6.9e-08 $layer=Gate_1 $thickness=5.6e-08
+ $X=0.459 $Y=0.0405 $X2=0.459 $Y2=0.1095
r6 13 71 23.8777 $w=2.07986e-08 $l=6.95e-08 $layer=Gate_1 $thickness=5.6e-08
+ $X=0.459 $Y=0.179 $X2=0.459 $Y2=0.1095
r7 5 65 19.3796 $a=3.24e-16 $layer=V0LISD $X=0.162 $Y=0.216 $X2=0.162 $Y2=0.234
r8 4 62 19.3796 $a=3.24e-16 $layer=V0LISD $X=0.162 $Y=0.054 $X2=0.162 $Y2=0.036
r9 2 56 5.67512 $w=2.4e-08 $l=5e-09 $layer=LISD $thickness=4.02632e-08 $X=0.459
+ $Y=0.179 $X2=0.464 $Y2=0.179
r10 2 13 7.56983 $w=2.18462e-08 $layer=Gate_1 $thickness=5.23077e-08 $X=0.459
+ $Y=0.179 $X2=0.459 $Y2=0.179
r11 65 66 5.24677 $w=1.3e-08 $l=2.25e-08 $layer=M1 $thickness=3.6e-08 $X=0.162
+ $Y=0.234 $X2=0.1845 $Y2=0.234
r12 19 66 7.34548 $w=1.3e-08 $l=3.15e-08 $layer=M1 $thickness=3.6e-08 $X=0.216
+ $Y=0.234 $X2=0.1845 $Y2=0.234
r13 62 63 5.24677 $w=1.3e-08 $l=2.25e-08 $layer=M1 $thickness=3.6e-08 $X=0.162
+ $Y=0.036 $X2=0.1845 $Y2=0.036
r14 18 63 7.34548 $w=1.3e-08 $l=3.15e-08 $layer=M1 $thickness=3.6e-08 $X=0.216
+ $Y=0.036 $X2=0.1845 $Y2=0.036
r15 55 56 11.0623 $w=2.14976e-08 $l=2.05e-08 $layer=LISD $thickness=2.7e-08
+ $X=0.4845 $Y=0.179 $X2=0.464 $Y2=0.179
r16 6 53 7.07284 $w=2.02e-08 $l=1.2e-08 $layer=LISD $thickness=2.7e-08 $X=0.501
+ $Y=0.179 $X2=0.513 $Y2=0.179
r17 6 55 9.72516 $w=2.02e-08 $l=1.65e-08 $layer=LISD $thickness=2.7e-08
+ $X=0.501 $Y=0.179 $X2=0.4845 $Y2=0.179
r18 17 50 2.5483 $w=1.79e-08 $l=1.8e-08 $layer=M1 $thickness=3.6e-08 $X=0.243
+ $Y=0.234 $X2=0.243 $Y2=0.216
r19 17 19 4.64701 $w=1.46667e-08 $l=2.7e-08 $layer=M1 $thickness=3.6e-08
+ $X=0.243 $Y=0.234 $X2=0.216 $Y2=0.234
r20 16 47 4.64701 $w=1.62667e-08 $l=2.7e-08 $layer=M1 $thickness=3.6e-08
+ $X=0.243 $Y=0.036 $X2=0.243 $Y2=0.063
r21 16 18 4.64701 $w=1.46667e-08 $l=2.7e-08 $layer=M1 $thickness=3.6e-08
+ $X=0.243 $Y=0.036 $X2=0.216 $Y2=0.036
r22 51 53 19.3796 $a=3.24e-16 $layer=V0LISD $X=0.513 $Y=0.1845 $X2=0.513
+ $Y2=0.179
r23 22 51 3.84763 $w=1.3e-08 $l=1.65e-08 $layer=M1 $thickness=3.6e-08 $X=0.513
+ $Y=0.168 $X2=0.513 $Y2=0.1845
r24 49 50 3.14806 $w=1.3e-08 $l=1.35e-08 $layer=M1 $thickness=3.6e-08 $X=0.243
+ $Y=0.2025 $X2=0.243 $Y2=0.216
r25 48 49 2.09871 $w=1.3e-08 $l=9e-09 $layer=M1 $thickness=3.6e-08 $X=0.243
+ $Y=0.1935 $X2=0.243 $Y2=0.2025
r26 46 47 8.39483 $w=1.3e-08 $l=3.6e-08 $layer=M1 $thickness=3.6e-08 $X=0.243
+ $Y=0.099 $X2=0.243 $Y2=0.063
r27 45 46 5.24677 $w=1.3e-08 $l=2.25e-08 $layer=M1 $thickness=3.6e-08 $X=0.243
+ $Y=0.1215 $X2=0.243 $Y2=0.099
r28 44 48 2.09871 $w=1.3e-08 $l=9e-09 $layer=M1 $thickness=3.6e-08 $X=0.243
+ $Y=0.1845 $X2=0.243 $Y2=0.1935
r29 20 44 7.34548 $w=1.3e-08 $l=3.15e-08 $layer=M1 $thickness=3.6e-08 $X=0.243
+ $Y=0.153 $X2=0.243 $Y2=0.1845
r30 20 45 7.34548 $w=1.3e-08 $l=3.15e-08 $layer=M1 $thickness=3.6e-08 $X=0.243
+ $Y=0.153 $X2=0.243 $Y2=0.1215
r31 42 51 19.5347 $a=3.24e-16 $layer=V1 $X=0.513 $Y=0.189 $X2=0.513 $Y2=0.1845
r32 41 42 8.39483 $w=1.3e-08 $l=3.6e-08 $layer=M2 $thickness=3.6e-08 $X=0.477
+ $Y=0.189 $X2=0.513 $Y2=0.189
r33 40 41 10.4935 $w=1.3e-08 $l=4.5e-08 $layer=M2 $thickness=3.6e-08 $X=0.432
+ $Y=0.189 $X2=0.477 $Y2=0.189
r34 39 40 10.4935 $w=1.3e-08 $l=4.5e-08 $layer=M2 $thickness=3.6e-08 $X=0.387
+ $Y=0.189 $X2=0.432 $Y2=0.189
r35 38 39 8.39483 $w=1.3e-08 $l=3.6e-08 $layer=M2 $thickness=3.6e-08 $X=0.351
+ $Y=0.189 $X2=0.387 $Y2=0.189
r36 37 38 12.5922 $w=1.3e-08 $l=5.4e-08 $layer=M2 $thickness=3.6e-08 $X=0.297
+ $Y=0.189 $X2=0.351 $Y2=0.189
r37 36 37 12.5922 $w=1.3e-08 $l=5.4e-08 $layer=M2 $thickness=3.6e-08 $X=0.243
+ $Y=0.189 $X2=0.297 $Y2=0.189
r38 36 44 19.5347 $a=3.24e-16 $layer=V1 $X=0.243 $Y=0.189 $X2=0.243 $Y2=0.1845
r39 23 36 2.68168 $w=1.3e-08 $l=1.15e-08 $layer=M2 $thickness=3.6e-08 $X=0.2315
+ $Y=0.189 $X2=0.243 $Y2=0.189
r40 33 38 19.5347 $a=3.24e-16 $layer=V1 $X=0.351 $Y=0.189 $X2=0.351 $Y2=0.189
r41 32 33 6.29612 $w=1.3e-08 $l=2.7e-08 $layer=M1 $thickness=3.6e-08 $X=0.351
+ $Y=0.162 $X2=0.351 $Y2=0.189
r42 31 32 6.29612 $w=1.3e-08 $l=2.7e-08 $layer=M1 $thickness=3.6e-08 $X=0.351
+ $Y=0.135 $X2=0.351 $Y2=0.162
r43 21 31 4.4306 $w=1.3e-08 $l=1.9e-08 $layer=M1 $thickness=3.6e-08 $X=0.351
+ $Y=0.116 $X2=0.351 $Y2=0.135
r44 1 27 10.4265 $w=1.765e-08 $layer=LIG $thickness=5.2e-08 $X=0.351 $Y=0.135
+ $X2=0.351 $Y2=0.135
r45 1 31 19.3796 $a=3.24e-16 $layer=V0LIG $X=0.351 $Y=0.135 $X2=0.351 $Y2=0.135
r46 29 28 16.4967 $w=2.1e-08 $l=4.85e-08 $layer=Gate_1 $thickness=5.6e-08
+ $X=0.351 $Y=0.2025 $X2=0.351 $Y2=0.154
r47 27 28 6.6497 $w=2.04211e-08 $l=1.9e-08 $layer=Gate_1 $thickness=5.6e-08
+ $X=0.351 $Y=0.135 $X2=0.351 $Y2=0.154
r48 12 27 21.2756 $w=2.08226e-08 $l=6.2e-08 $layer=Gate_1 $thickness=5.6e-08
+ $X=0.351 $Y=0.073 $X2=0.351 $Y2=0.135
.ends

.subckt PM_DLLx3_ASAP7_75t_R%Q vss 33 24 25 37 45 48 49 15 1 2 16 14 13
c1 1 vss 0.00888332f $X=0.756 $Y=0.0675
c2 2 vss 0.00900632f $X=0.756 $Y=0.2025
c3 3 vss 0.00761426f $X=0.864 $Y=0.0675
c4 4 vss 0.00765329f $X=0.864 $Y=0.2025
c5 13 vss 0.00448758f $X=0.7415 $Y=0.0675
c6 14 vss 0.0371081f $X=0.8495 $Y=0.0675
c7 15 vss 0.00451395f $X=0.7415 $Y=0.2025
c8 16 vss 0.0370862f $X=0.8495 $Y=0.2025
c9 17 vss 0.00201124f $X=0.8915 $Y=0.045
c10 18 vss 0.00203188f $X=0.8915 $Y=0.225
c11 19 vss 0.0104267f $X=0.7445 $Y=0.045
c12 20 vss 0.0103469f $X=0.8235 $Y=0.225
c13 21 vss 0.00427719f $X=0.8915 $Y=0.072
r1 49 47 0.0308642 $w=8.1e-08 $l=2.5e-09 $layer=P_src_drn $thickness=1e-09
+ $X=0.7733 $Y=0.2025 $X2=0.7705 $Y2=0.2025
r2 2 47 0.179012 $w=8.1e-08 $l=1.45e-08 $layer=P_src_drn $thickness=1e-09
+ $X=0.756 $Y=0.2025 $X2=0.7705 $Y2=0.2025
r3 15 2 0.179012 $w=8.1e-08 $l=1.45e-08 $layer=P_src_drn $thickness=1e-09
+ $X=0.7415 $Y=0.2025 $X2=0.756 $Y2=0.2025
r4 48 15 0.0308642 $w=8.1e-08 $l=2.5e-09 $layer=P_src_drn $thickness=1e-09
+ $X=0.7386 $Y=0.2025 $X2=0.7415 $Y2=0.2025
r5 16 4 0.154321 $w=8.1e-08 $l=1.25e-08 $layer=P_src_drn $thickness=1e-09
+ $X=0.8495 $Y=0.2025 $X2=0.864 $Y2=0.2025
r6 45 16 0.0308642 $w=8.1e-08 $l=2.5e-09 $layer=P_src_drn $thickness=1e-09
+ $X=0.8466 $Y=0.2025 $X2=0.8495 $Y2=0.2025
r7 2 42 19.3796 $a=3.24e-16 $layer=V0LISD $X=0.756 $Y=0.2025 $X2=0.756 $Y2=0.225
r8 4 38 19.3796 $a=3.24e-16 $layer=V0LISD $X=0.864 $Y=0.2025 $X2=0.864 $Y2=0.225
r9 42 43 3.14806 $w=1.3e-08 $l=1.35e-08 $layer=M1 $thickness=3.6e-08 $X=0.756
+ $Y=0.225 $X2=0.7695 $Y2=0.225
r10 40 43 3.14806 $w=1.3e-08 $l=1.35e-08 $layer=M1 $thickness=3.6e-08 $X=0.783
+ $Y=0.225 $X2=0.7695 $Y2=0.225
r11 38 39 3.14806 $w=1.3e-08 $l=1.35e-08 $layer=M1 $thickness=3.6e-08 $X=0.864
+ $Y=0.225 $X2=0.8775 $Y2=0.225
r12 20 38 9.44419 $w=1.3e-08 $l=4.05e-08 $layer=M1 $thickness=3.6e-08 $X=0.8235
+ $Y=0.225 $X2=0.864 $Y2=0.225
r13 20 40 9.44419 $w=1.3e-08 $l=4.05e-08 $layer=M1 $thickness=3.6e-08 $X=0.8235
+ $Y=0.225 $X2=0.783 $Y2=0.225
r14 18 35 5.33101 $w=1.53433e-08 $l=3.35e-08 $layer=M1 $thickness=3.6e-08
+ $X=0.8915 $Y=0.225 $X2=0.8915 $Y2=0.1915
r15 18 39 1.49343 $w=2.00571e-08 $l=1.4e-08 $layer=M1 $thickness=3.6e-08
+ $X=0.8915 $Y=0.225 $X2=0.8775 $Y2=0.225
r16 14 3 0.154321 $w=8.1e-08 $l=1.25e-08 $layer=N_src_drn $thickness=1e-09
+ $X=0.8495 $Y=0.0675 $X2=0.864 $Y2=0.0675
r17 37 14 0.0308642 $w=8.1e-08 $l=2.5e-09 $layer=N_src_drn $thickness=1e-09
+ $X=0.8466 $Y=0.0675 $X2=0.8495 $Y2=0.0675
r18 34 35 10.2227 $w=1.4e-08 $l=5.13e-08 $layer=M1 $thickness=3.6e-08 $X=0.8915
+ $Y=0.1402 $X2=0.8915 $Y2=0.1915
r19 33 34 5.43547 $w=1.4e-08 $l=2.72e-08 $layer=M1 $thickness=3.6e-08 $X=0.889
+ $Y=0.113 $X2=0.8915 $Y2=0.1402
r20 33 32 2.34373 $w=1.4e-08 $l=1.18e-08 $layer=M1 $thickness=3.6e-08 $X=0.889
+ $Y=0.113 $X2=0.8915 $Y2=0.1012
r21 21 32 5.8344 $w=1.4e-08 $l=2.92e-08 $layer=M1 $thickness=3.6e-08 $X=0.8915
+ $Y=0.072 $X2=0.8915 $Y2=0.1012
r22 3 30 19.3796 $a=3.24e-16 $layer=V0LISD $X=0.864 $Y=0.0675 $X2=0.864
+ $Y2=0.045
r23 17 31 1.49343 $w=2.00571e-08 $l=1.4e-08 $layer=M1 $thickness=3.6e-08
+ $X=0.8915 $Y=0.045 $X2=0.8775 $Y2=0.045
r24 17 21 4.03448 $w=1.56667e-08 $l=2.7e-08 $layer=M1 $thickness=3.6e-08
+ $X=0.8915 $Y=0.045 $X2=0.8915 $Y2=0.072
r25 30 31 3.14806 $w=1.3e-08 $l=1.35e-08 $layer=M1 $thickness=3.6e-08 $X=0.864
+ $Y=0.045 $X2=0.8775 $Y2=0.045
r26 29 30 9.44419 $w=1.3e-08 $l=4.05e-08 $layer=M1 $thickness=3.6e-08 $X=0.8235
+ $Y=0.045 $X2=0.864 $Y2=0.045
r27 28 29 9.44419 $w=1.3e-08 $l=4.05e-08 $layer=M1 $thickness=3.6e-08 $X=0.783
+ $Y=0.045 $X2=0.8235 $Y2=0.045
r28 27 28 3.14806 $w=1.3e-08 $l=1.35e-08 $layer=M1 $thickness=3.6e-08 $X=0.7695
+ $Y=0.045 $X2=0.783 $Y2=0.045
r29 26 27 3.14806 $w=1.3e-08 $l=1.35e-08 $layer=M1 $thickness=3.6e-08 $X=0.756
+ $Y=0.045 $X2=0.7695 $Y2=0.045
r30 19 26 2.68168 $w=1.3e-08 $l=1.15e-08 $layer=M1 $thickness=3.6e-08 $X=0.7445
+ $Y=0.045 $X2=0.756 $Y2=0.045
r31 1 26 19.3796 $a=3.24e-16 $layer=V0LISD $X=0.756 $Y=0.0675 $X2=0.756
+ $Y2=0.045
r32 25 23 0.0308642 $w=8.1e-08 $l=2.5e-09 $layer=N_src_drn $thickness=1e-09
+ $X=0.7733 $Y=0.0675 $X2=0.7705 $Y2=0.0675
r33 1 23 0.179012 $w=8.1e-08 $l=1.45e-08 $layer=N_src_drn $thickness=1e-09
+ $X=0.756 $Y=0.0675 $X2=0.7705 $Y2=0.0675
r34 13 1 0.179012 $w=8.1e-08 $l=1.45e-08 $layer=N_src_drn $thickness=1e-09
+ $X=0.7415 $Y=0.0675 $X2=0.756 $Y2=0.0675
r35 24 13 0.0308642 $w=8.1e-08 $l=2.5e-09 $layer=N_src_drn $thickness=1e-09
+ $X=0.7386 $Y=0.0675 $X2=0.7415 $Y2=0.0675
.ends

.subckt PM_DLLx3_ASAP7_75t_R%10 vss 7 9 5 4 1
c1 1 vss 0.00824965f $X=0.351 $Y=0.0675
c2 4 vss 0.00289127f $X=0.3095 $Y=0.0675
c3 5 vss 0.00175739f $X=0.38 $Y=0.0675
r1 9 8 0.0308642 $w=8.1e-08 $l=2.5e-09 $layer=N_src_drn $thickness=1e-09
+ $X=0.3953 $Y=0.0675 $X2=0.3925 $Y2=0.0675
r2 5 8 0.154321 $w=8.1e-08 $l=1.25e-08 $layer=N_src_drn $thickness=1e-09
+ $X=0.38 $Y=0.0675 $X2=0.3925 $Y2=0.0675
r3 4 1 0.154321 $w=8.1e-08 $l=1.25e-08 $layer=N_src_drn $thickness=1e-09
+ $X=0.3095 $Y=0.0675 $X2=0.351 $Y2=0.0675
r4 7 4 0.0308642 $w=8.1e-08 $l=2.5e-09 $layer=N_src_drn $thickness=1e-09
+ $X=0.3066 $Y=0.0675 $X2=0.3095 $Y2=0.0675
r5 1 5 1e-05 $l=2.9e-08 $X=0.351 $Y=0.0675 $X2=0.38 $Y2=0.0675
.ends

.subckt PM_DLLx3_ASAP7_75t_R%11 vss 7 12 4 1 5
c1 1 vss 0.0062802f $X=0.432 $Y=0.2295
c2 4 vss 0.00175568f $X=0.4175 $Y=0.2295
c3 5 vss 0.00216769f $X=0.488 $Y=0.2295
r1 12 11 0.0925926 $w=2.7e-08 $l=2.5e-09 $layer=P_src_drn $thickness=1e-09
+ $X=0.5033 $Y=0.2295 $X2=0.5005 $Y2=0.2295
r2 5 11 0.462963 $w=2.7e-08 $l=1.25e-08 $layer=P_src_drn $thickness=1e-09
+ $X=0.488 $Y=0.2295 $X2=0.5005 $Y2=0.2295
r3 9 5 9.64198 $w=2.32e-08 $l=2.05e-08 $layer=LISD $thickness=2.7e-08 $X=0.4655
+ $Y=0.2295 $X2=0.488 $Y2=0.2295
r4 8 9 7.05511 $w=2.32e-08 $l=1.5e-08 $layer=LISD $thickness=2.7e-08 $X=0.4505
+ $Y=0.2295 $X2=0.4655 $Y2=0.2295
r5 1 8 8.7013 $w=2.32e-08 $l=1.85e-08 $layer=LISD $thickness=2.7e-08 $X=0.432
+ $Y=0.2295 $X2=0.4505 $Y2=0.2295
r6 4 1 0.462963 $w=2.7e-08 $l=1.25e-08 $layer=P_src_drn $thickness=1e-09
+ $X=0.4175 $Y=0.2295 $X2=0.432 $Y2=0.2295
r7 7 4 0.0925926 $w=2.7e-08 $l=2.5e-09 $layer=P_src_drn $thickness=1e-09
+ $X=0.4146 $Y=0.2295 $X2=0.4175 $Y2=0.2295
.ends

.subckt PM_DLLx3_ASAP7_75t_R%8 vss 31 37 73 76 79 82 86 90 94 98 101 104 17 26
+ 5 23 18 20 28 24 6 22 25 15 16 21 1 11 27 2 19 14 12 13
c1 1 vss 0.00123685f $X=0.567 $Y=0.131
c2 2 vss 0.0148166f $X=0.783 $Y=0.136
c3 5 vss 0.00475468f $X=0.378 $Y=0.2295
c4 6 vss 0.00480302f $X=0.432 $Y=0.0405
c5 11 vss 0.0508928f $X=0.567 $Y=0.0245
c6 12 vss 0.0859768f $X=0.729 $Y=0.136
c7 13 vss 0.0805266f $X=0.783 $Y=0.136
c8 14 vss 0.0847679f $X=0.837 $Y=0.136
c9 15 vss 0.00358231f $X=0.4175 $Y=0.0405
c10 16 vss 0.0022964f $X=0.4175 $Y=0.081
c11 17 vss 0.00365518f $X=0.3635 $Y=0.2295
c12 18 vss 0.00233124f $X=0.3635 $Y=0.189
c13 19 vss 0.00274433f $X=0.459 $Y=0.036
c14 20 vss 6.14214e-20 $X=0.459 $Y=0.131
c15 21 vss 0.00277678f $X=0.459 $Y=0.234
c16 22 vss 0.007398f $X=0.432 $Y=0.234
c17 23 vss 0.00396212f $X=0.432 $Y=0.036
c18 24 vss 0.00123121f $X=0.459 $Y=0.114
c19 25 vss 0.000751646f $X=0.459 $Y=0.142
c20 26 vss 0.00106835f $X=0.5395 $Y=0.131
c21 27 vss 0.0038438f $X=0.783 $Y=0.1085
c22 28 vss 0.0151047f $X=0.459 $Y=0.153
r1 18 5 0.231482 $w=5.4e-08 $l=1.25e-08 $layer=P_src_drn $thickness=1e-09
+ $X=0.3635 $Y=0.189 $X2=0.378 $Y2=0.2295
r2 104 103 0.0925926 $w=2.7e-08 $l=2.5e-09 $layer=P_src_drn $thickness=1e-09
+ $X=0.3953 $Y=0.2295 $X2=0.3925 $Y2=0.2295
r3 102 103 0.166667 $w=2.7e-08 $l=4.5e-09 $layer=P_src_drn $thickness=1e-09
+ $X=0.388 $Y=0.2295 $X2=0.3925 $Y2=0.2295
r4 5 102 0.444445 $w=2.7e-08 $l=1.2e-08 $layer=P_src_drn $thickness=1e-09
+ $X=0.378 $Y=0.2295 $X2=0.388 $Y2=0.2295
r5 17 5 0.462963 $w=2.7e-08 $l=1.25e-08 $layer=P_src_drn $thickness=1e-09
+ $X=0.3635 $Y=0.2295 $X2=0.378 $Y2=0.2295
r6 101 17 0.0925926 $w=2.7e-08 $l=2.5e-09 $layer=P_src_drn $thickness=1e-09
+ $X=0.3606 $Y=0.2025 $X2=0.3635 $Y2=0.2295
r7 98 97 14.6259 $w=2.1e-08 $l=4.3e-08 $layer=Gate_1 $thickness=5.6e-08
+ $X=0.837 $Y=0.2025 $X2=0.837 $Y2=0.1595
r8 96 97 2.55104 $w=2.1e-08 $l=7.5e-09 $layer=Gate_1 $thickness=5.6e-08
+ $X=0.837 $Y=0.152 $X2=0.837 $Y2=0.1595
r9 94 95 14.6259 $w=2.1e-08 $l=4.3e-08 $layer=Gate_1 $thickness=5.6e-08
+ $X=0.837 $Y=0.0675 $X2=0.837 $Y2=0.1105
r10 92 95 2.89117 $w=2.1e-08 $l=8.5e-09 $layer=Gate_1 $thickness=5.6e-08
+ $X=0.837 $Y=0.119 $X2=0.837 $Y2=0.1105
r11 14 67 6.54019 $w=2.09524e-08 $layer=Gate_1 $thickness=5.21905e-08 $X=0.837
+ $Y=0.136 $X2=0.837 $Y2=0.136
r12 14 92 5.96942 $w=2.03529e-08 $l=1.7e-08 $layer=Gate_1 $thickness=5.6e-08
+ $X=0.837 $Y=0.136 $X2=0.837 $Y2=0.119
r13 14 96 5.62929 $w=2.03125e-08 $l=1.6e-08 $layer=Gate_1 $thickness=5.6e-08
+ $X=0.837 $Y=0.136 $X2=0.837 $Y2=0.152
r14 90 89 14.6259 $w=2.1e-08 $l=4.3e-08 $layer=Gate_1 $thickness=5.6e-08
+ $X=0.729 $Y=0.2025 $X2=0.729 $Y2=0.1595
r15 88 89 2.55104 $w=2.1e-08 $l=7.5e-09 $layer=Gate_1 $thickness=5.6e-08
+ $X=0.729 $Y=0.152 $X2=0.729 $Y2=0.1595
r16 86 87 14.6259 $w=2.1e-08 $l=4.3e-08 $layer=Gate_1 $thickness=5.6e-08
+ $X=0.729 $Y=0.0675 $X2=0.729 $Y2=0.1105
r17 84 87 2.89117 $w=2.1e-08 $l=8.5e-09 $layer=Gate_1 $thickness=5.6e-08
+ $X=0.729 $Y=0.119 $X2=0.729 $Y2=0.1105
r18 12 64 6.54019 $w=2.09524e-08 $layer=Gate_1 $thickness=5.21905e-08 $X=0.729
+ $Y=0.136 $X2=0.729 $Y2=0.136
r19 12 84 5.96942 $w=2.03529e-08 $l=1.7e-08 $layer=Gate_1 $thickness=5.6e-08
+ $X=0.729 $Y=0.136 $X2=0.729 $Y2=0.119
r20 12 88 5.62929 $w=2.03125e-08 $l=1.6e-08 $layer=Gate_1 $thickness=5.6e-08
+ $X=0.729 $Y=0.136 $X2=0.729 $Y2=0.152
r21 82 81 16.3266 $w=2.1e-08 $l=4.8e-08 $layer=Gate_1 $thickness=5.6e-08
+ $X=0.783 $Y=0.2025 $X2=0.783 $Y2=0.1545
r22 79 80 16.6668 $w=2.1e-08 $l=4.9e-08 $layer=Gate_1 $thickness=5.6e-08
+ $X=0.783 $Y=0.0675 $X2=0.783 $Y2=0.1165
r23 13 80 6.81977 $w=2.04359e-08 $l=1.95e-08 $layer=Gate_1 $thickness=5.6e-08
+ $X=0.783 $Y=0.136 $X2=0.783 $Y2=0.1165
r24 13 81 6.47963 $w=2.04054e-08 $l=1.85e-08 $layer=Gate_1 $thickness=5.6e-08
+ $X=0.783 $Y=0.136 $X2=0.783 $Y2=0.1545
r25 16 62 0.231482 $w=5.4e-08 $l=1.25e-08 $layer=N_src_drn $thickness=1e-09
+ $X=0.4175 $Y=0.081 $X2=0.432 $Y2=0.081
r26 76 75 0.0925926 $w=2.7e-08 $l=2.5e-09 $layer=N_src_drn $thickness=1e-09
+ $X=0.4493 $Y=0.0405 $X2=0.4465 $Y2=0.0405
r27 74 75 0.166667 $w=2.7e-08 $l=4.5e-09 $layer=N_src_drn $thickness=1e-09
+ $X=0.442 $Y=0.0405 $X2=0.4465 $Y2=0.0405
r28 62 74 0.444445 $w=2.7e-08 $l=1.2e-08 $layer=N_src_drn $thickness=1e-09
+ $X=0.432 $Y=0.081 $X2=0.442 $Y2=0.0405
r29 15 62 0.462963 $w=2.7e-08 $l=1.25e-08 $layer=N_src_drn $thickness=1e-09
+ $X=0.4175 $Y=0.0405 $X2=0.432 $Y2=0.081
r30 73 15 0.0925926 $w=2.7e-08 $l=2.5e-09 $layer=N_src_drn $thickness=1e-09
+ $X=0.4146 $Y=0.0675 $X2=0.4175 $Y2=0.0405
r31 5 60 19.3796 $a=3.24e-16 $layer=V0LISD $X=0.378 $Y=0.2295 $X2=0.378
+ $Y2=0.234
r32 66 67 12.6539 $w=1.77815e-08 $l=2.7e-08 $layer=LIG $thickness=4.8e-08
+ $X=0.81 $Y=0.136 $X2=0.837 $Y2=0.136
r33 63 64 12.6539 $w=1.77815e-08 $l=2.7e-08 $layer=LIG $thickness=4.8e-08
+ $X=0.756 $Y=0.136 $X2=0.729 $Y2=0.136
r34 2 56 19.3796 $a=3.24e-16 $layer=V0LIG $X=0.783 $Y=0.136 $X2=0.783 $Y2=0.1445
r35 2 63 12.6539 $w=1.77815e-08 $l=2.7e-08 $layer=LIG $thickness=4.8e-08
+ $X=0.783 $Y=0.136 $X2=0.756 $Y2=0.136
r36 2 66 12.6539 $w=1.77815e-08 $l=2.7e-08 $layer=LIG $thickness=4.8e-08
+ $X=0.783 $Y=0.136 $X2=0.81 $Y2=0.136
r37 2 13 6.54019 $w=2.09524e-08 $layer=Gate_1 $thickness=5.21905e-08 $X=0.783
+ $Y=0.136 $X2=0.783 $Y2=0.136
r38 6 23 19.3796 $a=3.24e-16 $layer=V0LISD $X=0.432 $Y=0.0405 $X2=0.432
+ $Y2=0.036
r39 6 62 23.8708 $w=2.02e-08 $l=4.05e-08 $layer=LISD $thickness=2.7e-08
+ $X=0.432 $Y=0.0405 $X2=0.432 $Y2=0.081
r40 60 61 3.14806 $w=1.3e-08 $l=1.35e-08 $layer=M1 $thickness=3.6e-08 $X=0.378
+ $Y=0.234 $X2=0.3915 $Y2=0.234
r41 58 61 3.14806 $w=1.3e-08 $l=1.35e-08 $layer=M1 $thickness=3.6e-08 $X=0.405
+ $Y=0.234 $X2=0.3915 $Y2=0.234
r42 22 58 6.29612 $w=1.3e-08 $l=2.7e-08 $layer=M1 $thickness=3.6e-08 $X=0.432
+ $Y=0.234 $X2=0.405 $Y2=0.234
r43 27 56 8.39483 $w=1.3e-08 $l=3.6e-08 $layer=M1 $thickness=3.6e-08 $X=0.783
+ $Y=0.1085 $X2=0.783 $Y2=0.1445
r44 21 51 3.01468 $w=1.741e-08 $l=2e-08 $layer=M1 $thickness=3.6e-08 $X=0.459
+ $Y=0.234 $X2=0.459 $Y2=0.214
r45 21 22 4.64701 $w=1.46667e-08 $l=2.7e-08 $layer=M1 $thickness=3.6e-08
+ $X=0.459 $Y=0.234 $X2=0.432 $Y2=0.234
r46 54 56 19.5347 $a=3.24e-16 $layer=V1 $X=0.783 $Y=0.153 $X2=0.783 $Y2=0.1445
r47 53 54 30.8976 $w=1.3e-08 $l=1.325e-07 $layer=M2 $thickness=3.6e-08
+ $X=0.6505 $Y=0.153 $X2=0.783 $Y2=0.153
r48 52 53 35.678 $w=1.3e-08 $l=1.53e-07 $layer=M2 $thickness=3.6e-08 $X=0.4975
+ $Y=0.153 $X2=0.6505 $Y2=0.153
r49 28 52 8.97781 $w=1.3e-08 $l=3.85e-08 $layer=M2 $thickness=3.6e-08 $X=0.459
+ $Y=0.153 $X2=0.4975 $Y2=0.153
r50 28 47 19.5347 $a=3.24e-16 $layer=V1 $X=0.459 $Y=0.153 $X2=0.459 $Y2=0.153
r51 19 46 6.51253 $w=1.552e-08 $l=3.5e-08 $layer=M1 $thickness=3.6e-08 $X=0.459
+ $Y=0.036 $X2=0.459 $Y2=0.071
r52 19 23 4.64701 $w=1.46667e-08 $l=2.7e-08 $layer=M1 $thickness=3.6e-08
+ $X=0.459 $Y=0.036 $X2=0.432 $Y2=0.036
r53 50 51 2.91487 $w=1.3e-08 $l=1.25e-08 $layer=M1 $thickness=3.6e-08 $X=0.459
+ $Y=0.2015 $X2=0.459 $Y2=0.214
r54 49 50 4.43061 $w=1.3e-08 $l=1.9e-08 $layer=M1 $thickness=3.6e-08 $X=0.459
+ $Y=0.1825 $X2=0.459 $Y2=0.2015
r55 48 49 4.43061 $w=1.3e-08 $l=1.9e-08 $layer=M1 $thickness=3.6e-08 $X=0.459
+ $Y=0.1635 $X2=0.459 $Y2=0.1825
r56 47 48 2.44849 $w=1.3e-08 $l=1.05e-08 $layer=M1 $thickness=3.6e-08 $X=0.459
+ $Y=0.153 $X2=0.459 $Y2=0.1635
r57 25 47 2.56509 $w=1.3e-08 $l=1.1e-08 $layer=M1 $thickness=3.6e-08 $X=0.459
+ $Y=0.142 $X2=0.459 $Y2=0.153
r58 45 46 7.11229 $w=1.3e-08 $l=3.05e-08 $layer=M1 $thickness=3.6e-08 $X=0.459
+ $Y=0.1015 $X2=0.459 $Y2=0.071
r59 24 45 2.91487 $w=1.3e-08 $l=1.25e-08 $layer=M1 $thickness=3.6e-08 $X=0.459
+ $Y=0.114 $X2=0.459 $Y2=0.1015
r60 20 44 5.11582 $w=1.46667e-08 $l=2.7e-08 $layer=M1 $thickness=3.6e-08
+ $X=0.459 $Y=0.131 $X2=0.486 $Y2=0.131
r61 20 24 2.78392 $w=1.56471e-08 $l=1.7e-08 $layer=M1 $thickness=3.6e-08
+ $X=0.459 $Y=0.131 $X2=0.459 $Y2=0.114
r62 20 25 1.38478 $w=1.70909e-08 $l=1.1e-08 $layer=M1 $thickness=3.6e-08
+ $X=0.459 $Y=0.131 $X2=0.459 $Y2=0.142
r63 43 44 6.29612 $w=1.3e-08 $l=2.7e-08 $layer=M1 $thickness=3.6e-08 $X=0.513
+ $Y=0.131 $X2=0.486 $Y2=0.131
r64 26 41 6.17953 $w=1.3e-08 $l=2.65e-08 $layer=M1 $thickness=3.6e-08 $X=0.5395
+ $Y=0.131 $X2=0.566 $Y2=0.131
r65 26 43 6.17953 $w=1.3e-08 $l=2.65e-08 $layer=M1 $thickness=3.6e-08 $X=0.5395
+ $Y=0.131 $X2=0.513 $Y2=0.131
r66 1 34 6.54019 $w=2.09524e-08 $layer=Gate_1 $thickness=5.21905e-08 $X=0.567
+ $Y=0.131 $X2=0.567 $Y2=0.131
r67 1 41 19.3796 $a=3.24e-16 $layer=V0LIG $X=0.567 $Y=0.131 $X2=0.566 $Y2=0.131
r68 37 36 14.6259 $w=2.1e-08 $l=4.3e-08 $layer=Gate_1 $thickness=5.6e-08
+ $X=0.567 $Y=0.2295 $X2=0.567 $Y2=0.1865
r69 35 36 12.5851 $w=2.1e-08 $l=3.7e-08 $layer=Gate_1 $thickness=5.6e-08
+ $X=0.567 $Y=0.1495 $X2=0.567 $Y2=0.1865
r70 34 35 6.47963 $w=2.04054e-08 $l=1.85e-08 $layer=Gate_1 $thickness=5.6e-08
+ $X=0.567 $Y=0.131 $X2=0.567 $Y2=0.1495
r71 33 34 5.11908 $w=2.02414e-08 $l=1.45e-08 $layer=Gate_1 $thickness=5.6e-08
+ $X=0.567 $Y=0.1165 $X2=0.567 $Y2=0.131
r72 32 33 11.2246 $w=2.1e-08 $l=3.3e-08 $layer=Gate_1 $thickness=5.6e-08
+ $X=0.567 $Y=0.0835 $X2=0.567 $Y2=0.1165
r73 31 32 14.6259 $w=2.1e-08 $l=4.3e-08 $layer=Gate_1 $thickness=5.6e-08
+ $X=0.567 $Y=0.0405 $X2=0.567 $Y2=0.0835
r74 31 11 5.44221 $w=2.1e-08 $l=1.6e-08 $layer=Gate_1 $thickness=5.6e-08
+ $X=0.567 $Y=0.0405 $X2=0.567 $Y2=0.0245
.ends

.subckt PM_DLLx3_ASAP7_75t_R%13 vss 2 3 1
c1 1 vss 0.000763635f $X=0.324 $Y=0.2025
r1 2 1 0.209877 $w=8.1e-08 $l=1.7e-08 $layer=P_src_drn $thickness=1e-09
+ $X=0.3066 $Y=0.2025 $X2=0.324 $Y2=0.2025
r2 3 1 0.209877 $w=8.1e-08 $l=1.7e-08 $layer=P_src_drn $thickness=1e-09
+ $X=0.3413 $Y=0.2025 $X2=0.324 $Y2=0.2025
.ends

.subckt PM_DLLx3_ASAP7_75t_R%4 vss 31 37 65 68 77 79 6 5 16 13 14 21 25 1 23 24
+ 27 22 18 20 11 26 19 12 2
c1 1 vss 0.003439f $X=0.134 $Y=0.135
c2 2 vss 0.000336549f $X=0.405 $Y=0.144
c3 5 vss 0.00787056f $X=0.054 $Y=0.054
c4 6 vss 0.00790334f $X=0.054 $Y=0.216
c5 11 vss 0.0685534f $X=0.135 $Y=0.0245
c6 12 vss 0.00712885f $X=0.405 $Y=0.135
c7 13 vss 0.0309485f $X=0.056 $Y=0.054
c8 14 vss 0.0309076f $X=0.056 $Y=0.216
c9 15 vss 0.0035869f $X=0.018 $Y=0.036
c10 16 vss 0.00214598f $X=0.0165 $Y=0.153
c11 17 vss 0.00356155f $X=0.018 $Y=0.234
c12 18 vss 0.00137575f $X=0.189 $Y=0.198
c13 19 vss 0.000615083f $X=0.189 $Y=0.135
c14 20 vss 0.00639855f $X=0.018 $Y=0.1305
c15 21 vss 0.00414016f $X=0.018 $Y=0.1755
c16 22 vss 0.00460665f $X=0.036 $Y=0.036
c17 23 vss 0.00436605f $X=0.036 $Y=0.234
c18 24 vss 0.000624044f $X=0.1405 $Y=0.135
c19 25 vss 0.000806788f $X=0.189 $Y=0.1485
c20 26 vss 0.0012234f $X=0.405 $Y=0.116
c21 27 vss 0.0155562f $X=0.0215 $Y=0.153
r1 79 78 0.0462963 $w=5.4e-08 $l=2.5e-09 $layer=P_src_drn $thickness=1e-09
+ $X=0.0713 $Y=0.216 $X2=0.0685 $Y2=0.216
r2 14 78 0.231482 $w=5.4e-08 $l=1.25e-08 $layer=P_src_drn $thickness=1e-09
+ $X=0.056 $Y=0.216 $X2=0.0685 $Y2=0.216
r3 77 76 0.0462963 $w=5.4e-08 $l=2.5e-09 $layer=N_src_drn $thickness=1e-09
+ $X=0.0713 $Y=0.054 $X2=0.0685 $Y2=0.054
r4 13 76 0.231482 $w=5.4e-08 $l=1.25e-08 $layer=N_src_drn $thickness=1e-09
+ $X=0.056 $Y=0.054 $X2=0.0685 $Y2=0.054
r5 6 74 19.3796 $a=3.24e-16 $layer=V0LISD $X=0.054 $Y=0.216 $X2=0.055 $Y2=0.234
r6 5 71 19.3796 $a=3.24e-16 $layer=V0LISD $X=0.054 $Y=0.054 $X2=0.055 $Y2=0.036
r7 73 74 2.09871 $w=1.3e-08 $l=9e-09 $layer=M1 $thickness=3.6e-08 $X=0.046
+ $Y=0.234 $X2=0.055 $Y2=0.234
r8 23 73 2.3319 $w=1.3e-08 $l=1e-08 $layer=M1 $thickness=3.6e-08 $X=0.036
+ $Y=0.234 $X2=0.046 $Y2=0.234
r9 70 71 2.09871 $w=1.3e-08 $l=9e-09 $layer=M1 $thickness=3.6e-08 $X=0.046
+ $Y=0.036 $X2=0.055 $Y2=0.036
r10 22 70 2.3319 $w=1.3e-08 $l=1e-08 $layer=M1 $thickness=3.6e-08 $X=0.036
+ $Y=0.036 $X2=0.046 $Y2=0.036
r11 68 67 16.4967 $w=2.1e-08 $l=4.85e-08 $layer=Gate_1 $thickness=5.6e-08
+ $X=0.405 $Y=0.2295 $X2=0.405 $Y2=0.181
r12 65 66 16.4967 $w=2.1e-08 $l=4.85e-08 $layer=Gate_1 $thickness=5.6e-08
+ $X=0.405 $Y=0.0675 $X2=0.405 $Y2=0.116
r13 12 66 6.6497 $w=2.04211e-08 $l=1.9e-08 $layer=Gate_1 $thickness=5.6e-08
+ $X=0.405 $Y=0.135 $X2=0.405 $Y2=0.116
r14 12 67 15.8334 $w=2.07609e-08 $l=4.6e-08 $layer=Gate_1 $thickness=5.6e-08
+ $X=0.405 $Y=0.135 $X2=0.405 $Y2=0.181
r15 17 62 4.64701 $w=1.62667e-08 $l=2.7e-08 $layer=M1 $thickness=3.6e-08
+ $X=0.018 $Y=0.234 $X2=0.018 $Y2=0.207
r16 17 23 2.5483 $w=1.55e-08 $l=1.8e-08 $layer=M1 $thickness=3.6e-08 $X=0.018
+ $Y=0.234 $X2=0.036 $Y2=0.234
r17 15 61 4.64701 $w=1.62667e-08 $l=2.7e-08 $layer=M1 $thickness=3.6e-08
+ $X=0.018 $Y=0.036 $X2=0.018 $Y2=0.063
r18 15 22 2.5483 $w=1.55e-08 $l=1.8e-08 $layer=M1 $thickness=3.6e-08 $X=0.018
+ $Y=0.036 $X2=0.036 $Y2=0.036
r19 2 63 6.49795 $w=1.53e-08 $l=1.1e-08 $layer=LIG $thickness=4.8e-08 $X=0.405
+ $Y=0.144 $X2=0.405 $Y2=0.133
r20 2 12 5.11004 $w=1.92769e-08 $l=9e-09 $layer=Gate_1 $thickness=5.47692e-08
+ $X=0.405 $Y=0.144 $X2=0.405 $Y2=0.135
r21 21 62 7.34548 $w=1.3e-08 $l=3.15e-08 $layer=M1 $thickness=3.6e-08 $X=0.018
+ $Y=0.1755 $X2=0.018 $Y2=0.207
r22 60 61 8.39483 $w=1.3e-08 $l=3.6e-08 $layer=M1 $thickness=3.6e-08 $X=0.018
+ $Y=0.099 $X2=0.018 $Y2=0.063
r23 20 60 7.34548 $w=1.3e-08 $l=3.15e-08 $layer=M1 $thickness=3.6e-08 $X=0.018
+ $Y=0.1305 $X2=0.018 $Y2=0.099
r24 58 63 19.3796 $a=3.24e-16 $layer=V0LIG $X=0.405 $Y=0.144 $X2=0.405 $Y2=0.133
r25 26 58 6.52931 $w=1.3e-08 $l=2.8e-08 $layer=M1 $thickness=3.6e-08 $X=0.405
+ $Y=0.116 $X2=0.405 $Y2=0.144
r26 55 56 1.90199 $w=1.38333e-08 $l=9e-09 $layer=M1 $thickness=3.6e-08
+ $X=0.0255 $Y=0.153 $X2=0.0345 $Y2=0.153
r27 16 55 0.9184 $w=1.8e-08 $l=9e-09 $layer=M1 $thickness=3.6e-08 $X=0.0165
+ $Y=0.153 $X2=0.0255 $Y2=0.153
r28 16 20 3.9134 $w=1.47857e-08 $l=2.25499e-08 $layer=M1 $thickness=3.6e-08
+ $X=0.0165 $Y=0.153 $X2=0.018 $Y2=0.1305
r29 16 21 3.9134 $w=1.47857e-08 $l=2.25499e-08 $layer=M1 $thickness=3.6e-08
+ $X=0.0165 $Y=0.153 $X2=0.018 $Y2=0.1755
r30 18 47 4.06646 $w=1.5e-08 $l=2.25e-08 $layer=M1 $thickness=3.6e-08 $X=0.189
+ $Y=0.198 $X2=0.189 $Y2=0.1755
r31 53 58 19.5347 $a=3.24e-16 $layer=V1 $X=0.405 $Y=0.153 $X2=0.405 $Y2=0.144
r32 52 53 21.5701 $w=1.3e-08 $l=9.25e-08 $layer=M2 $thickness=3.6e-08 $X=0.3125
+ $Y=0.153 $X2=0.405 $Y2=0.153
r33 51 52 23.0858 $w=1.3e-08 $l=9.9e-08 $layer=M2 $thickness=3.6e-08 $X=0.2135
+ $Y=0.153 $X2=0.3125 $Y2=0.153
r34 50 51 5.71315 $w=1.3e-08 $l=2.45e-08 $layer=M2 $thickness=3.6e-08 $X=0.189
+ $Y=0.153 $X2=0.2135 $Y2=0.153
r35 49 50 18.1888 $w=1.3e-08 $l=7.8e-08 $layer=M2 $thickness=3.6e-08 $X=0.111
+ $Y=0.153 $X2=0.189 $Y2=0.153
r36 48 49 18.1888 $w=1.3e-08 $l=7.8e-08 $layer=M2 $thickness=3.6e-08 $X=0.033
+ $Y=0.153 $X2=0.111 $Y2=0.153
r37 48 56 19.5347 $a=3.24e-16 $layer=V1 $X=0.033 $Y=0.153 $X2=0.0345 $Y2=0.153
r38 27 48 2.68168 $w=1.3e-08 $l=1.15e-08 $layer=M2 $thickness=3.6e-08 $X=0.0215
+ $Y=0.153 $X2=0.033 $Y2=0.153
r39 46 47 4.19742 $w=1.3e-08 $l=1.8e-08 $layer=M1 $thickness=3.6e-08 $X=0.189
+ $Y=0.1575 $X2=0.189 $Y2=0.1755
r40 25 46 2.09871 $w=1.3e-08 $l=9e-09 $layer=M1 $thickness=3.6e-08 $X=0.189
+ $Y=0.1485 $X2=0.189 $Y2=0.1575
r41 25 50 19.5347 $a=3.24e-16 $layer=V1 $X=0.189 $Y=0.1485 $X2=0.189 $Y2=0.153
r42 19 45 2.6649 $w=1.54324e-08 $l=1.85e-08 $layer=M1 $thickness=3.6e-08
+ $X=0.189 $Y=0.135 $X2=0.1705 $Y2=0.135
r43 19 25 1.49895 $w=1.95333e-08 $l=1.35e-08 $layer=M1 $thickness=3.6e-08
+ $X=0.189 $Y=0.135 $X2=0.189 $Y2=0.1485
r44 44 45 3.73104 $w=1.3e-08 $l=1.6e-08 $layer=M1 $thickness=3.6e-08 $X=0.1545
+ $Y=0.135 $X2=0.1705 $Y2=0.135
r45 43 44 2.09871 $w=1.3e-08 $l=9e-09 $layer=M1 $thickness=3.6e-08 $X=0.1455
+ $Y=0.135 $X2=0.1545 $Y2=0.135
r46 24 43 1.16595 $w=1.3e-08 $l=5e-09 $layer=M1 $thickness=3.6e-08 $X=0.1405
+ $Y=0.135 $X2=0.1455 $Y2=0.135
r47 41 44 19.3796 $a=3.24e-16 $layer=V0LIG $X=0.153 $Y=0.135 $X2=0.1545
+ $Y2=0.135
r48 39 41 4.98695 $w=1.60444e-08 $l=9e-09 $layer=LIG $thickness=4.8e-08
+ $X=0.144 $Y=0.135 $X2=0.153 $Y2=0.135
r49 1 39 2.6116 $w=2.2e-08 $l=1e-08 $layer=LIG $thickness=4.8e-08 $X=0.134
+ $Y=0.135 $X2=0.144 $Y2=0.135
r50 1 34 6.27904 $w=2.09e-08 $l=1e-09 $layer=Gate_1 $thickness=5.24e-08
+ $X=0.134 $Y=0.135 $X2=0.135 $Y2=0.135
r51 37 36 14.6259 $w=2.1e-08 $l=4.3e-08 $layer=Gate_1 $thickness=5.6e-08
+ $X=0.135 $Y=0.216 $X2=0.135 $Y2=0.173
r52 35 36 7.31297 $w=2.1e-08 $l=2.15e-08 $layer=Gate_1 $thickness=5.6e-08
+ $X=0.135 $Y=0.1515 $X2=0.135 $Y2=0.173
r53 34 35 5.79936 $w=2.03333e-08 $l=1.65e-08 $layer=Gate_1 $thickness=5.6e-08
+ $X=0.135 $Y=0.135 $X2=0.135 $Y2=0.1515
r54 34 39 4.18976 $w=2.01667e-08 $l=9e-09 $layer=Gate_1 $thickness=5.53333e-08
+ $X=0.135 $Y=0.135 $X2=0.144 $Y2=0.135
r55 33 34 5.79936 $w=2.03333e-08 $l=1.65e-08 $layer=Gate_1 $thickness=5.6e-08
+ $X=0.135 $Y=0.1185 $X2=0.135 $Y2=0.135
r56 32 33 7.31297 $w=2.1e-08 $l=2.15e-08 $layer=Gate_1 $thickness=5.6e-08
+ $X=0.135 $Y=0.097 $X2=0.135 $Y2=0.1185
r57 31 32 14.6259 $w=2.1e-08 $l=4.3e-08 $layer=Gate_1 $thickness=5.6e-08
+ $X=0.135 $Y=0.054 $X2=0.135 $Y2=0.097
r58 31 11 10.0341 $w=2.1e-08 $l=2.95e-08 $layer=Gate_1 $thickness=5.6e-08
+ $X=0.135 $Y=0.054 $X2=0.135 $Y2=0.0245
r59 6 14 1e-05 $l=2e-09 $X=0.054 $Y=0.216 $X2=0.056 $Y2=0.216
r60 5 13 1e-05 $l=2e-09 $X=0.054 $Y=0.054 $X2=0.056 $Y2=0.054
.ends

* End of included file DLLx3_ASAP7_75t_R.pex.sp.pex

*
.subckt DLLx3_ASAP7_75t_CUSTOM_4_25_0_7 VSS VDD CLK D Q
*
* VSS VSS
* VDD VDD
* CLK CLK
* D D
* Q Q
*
*

M0 VSS N_M0_g N_M0_s VSS nmos_rvt L=2e-08 W=5.4e-08 nfin=2 $X=0.071 $Y=0.027
M1 N_M1_d N_M1_g VSS VSS nmos_rvt L=2e-08 W=5.4e-08 nfin=2 $X=0.125 $Y=0.027
M2 N_M2_d N_M2_g VSS VSS nmos_rvt L=2e-08 W=8.1e-08 nfin=3 $X=0.287 $Y=0.027
M3 N_M3_d N_M3_g N_M3_s VSS nmos_rvt L=2e-08 W=8.1e-08 nfin=3 $X=0.395 $Y=0.027
M4 N_M4_d N_M4_g N_M4_s VSS nmos_rvt L=2e-08 W=2.7e-08 nfin=1 $X=0.449 $Y=0.027
M5 VSS N_M5_g N_M5_s VSS nmos_rvt L=2e-08 W=2.7e-08 nfin=1 $X=0.503 $Y=0.027
M6 N_M6_d N_M6_g VSS VSS nmos_rvt L=2e-08 W=2.7e-08 nfin=1 $X=0.557 $Y=0.027
M7 N_M7_d N_M7_g VSS VSS nmos_rvt L=2e-08 W=8.1e-08 nfin=3 $X=0.719 $Y=0.027
M8 N_M8_d N_M8_g VSS VSS nmos_rvt L=2e-08 W=8.1e-08 nfin=3 $X=0.773 $Y=0.027
M9 N_M9_d N_M9_g VSS VSS nmos_rvt L=2e-08 W=8.1e-08 nfin=3 $X=0.827 $Y=0.027
M10 VDD N_M10_g N_M10_s VDD pmos_rvt L=2e-08 W=5.4e-08 nfin=2 $X=0.071 $Y=0.189
M11 N_M11_d N_M11_g VDD VDD pmos_rvt L=2e-08 W=5.4e-08 nfin=2 $X=0.125 $Y=0.189
M12 N_M12_d N_M12_g VDD VDD pmos_rvt L=2e-08 W=8.1e-08 nfin=3 $X=0.287 $Y=0.162
M13 N_M13_d N_M13_g N_M13_s VDD pmos_rvt L=2e-08 W=8.1e-08 nfin=3 $X=0.341
+ $Y=0.162
M14 N_M14_d N_M14_g N_M14_s VDD pmos_rvt L=2e-08 W=2.7e-08 nfin=1 $X=0.395
+ $Y=0.216
M15 VDD N_M15_g N_M15_s VDD pmos_rvt L=2e-08 W=2.7e-08 nfin=1 $X=0.503 $Y=0.216
M16 N_M16_d N_M16_g VDD VDD pmos_rvt L=2e-08 W=2.7e-08 nfin=1 $X=0.557 $Y=0.216
M17 N_M17_d N_M17_g VDD VDD pmos_rvt L=2e-08 W=8.1e-08 nfin=3 $X=0.719 $Y=0.162
M18 N_M18_d N_M18_g VDD VDD pmos_rvt L=2e-08 W=8.1e-08 nfin=3 $X=0.773 $Y=0.162
M19 N_M19_d N_M19_g VDD VDD pmos_rvt L=2e-08 W=8.1e-08 nfin=3 $X=0.827 $Y=0.162

* .include "DLLx3_ASAP7_75t_R.pex.sp.pxi"

* Start of included file DLLx3_ASAP7_75t_R.pex.sp.pxi
x_PM_DLLx3_ASAP7_75t_R%12 vss N_M4_d N_M5_s N_12_1 PM_DLLx3_ASAP7_75t_R%12
cc_1 N_12_1 N_6_13 0.00755795f $X=0.486 $Y=0.0405
cc_2 N_12_1 N_7_9 0.00766767f $X=0.486 $Y=0.0405
x_PM_DLLx3_ASAP7_75t_R%CLK vss CLK N_M0_g N_M10_g N_CLK_3 N_CLK_1 N_CLK_4
+ N_CLK_5 N_CLK_7 N_CLK_8 N_CLK_6 PM_DLLx3_ASAP7_75t_R%CLK
x_PM_DLLx3_ASAP7_75t_R%D vss D N_M2_g N_M12_g N_D_6 N_D_4 N_D_5 N_D_1 N_D_3
+ PM_DLLx3_ASAP7_75t_R%D
cc_3 N_D_6 N_4_26 0.000182953f $X=0.297 $Y=0.0755
cc_4 N_D_6 N_4_27 0.00293152f $X=0.297 $Y=0.0755
x_PM_DLLx3_ASAP7_75t_R%7 vss N_M5_g N_M15_g N_M6_d N_M16_d N_7_9 N_7_1 N_7_13
+ N_7_4 N_7_17 N_7_3 N_7_16 N_7_12 N_7_11 N_7_10 N_7_15 PM_DLLx3_ASAP7_75t_R%7
cc_5 N_7_9 N_6_2 0.000171758f $X=0.513 $Y=0.0245
cc_6 N_7_9 N_6_6 0.00551209f $X=0.513 $Y=0.0245
cc_7 N_7_9 N_6_23 0.000222884f $X=0.513 $Y=0.0245
cc_8 N_7_9 N_6_22 0.000315472f $X=0.513 $Y=0.0245
cc_9 N_7_1 N_6_13 0.000446617f $X=0.513 $Y=0.082
cc_10 N_7_13 N_6_6 0.00049724f $X=0.621 $Y=0.234
cc_11 N_7_4 N_6_6 0.000782268f $X=0.594 $Y=0.2295
cc_12 N_7_17 N_6_6 0.00140704f $X=0.621 $Y=0.0495
cc_13 N_7_9 N_6_13 0.0138317f $X=0.513 $Y=0.0245
x_PM_DLLx3_ASAP7_75t_R%6 vss N_M13_g N_M4_g N_M1_d N_M11_d N_6_4 N_6_5 N_6_20
+ N_6_19 N_6_18 N_6_17 N_6_16 N_6_15 N_6_21 N_6_2 N_6_23 N_6_1 N_6_14 N_6_12
+ N_6_13 N_6_6 N_6_22 PM_DLLx3_ASAP7_75t_R%6
cc_14 N_6_4 N_CLK_7 0.000442678f $X=0.162 $Y=0.054
cc_15 N_6_5 N_CLK_7 0.000214549f $X=0.162 $Y=0.216
cc_16 N_6_20 N_CLK_7 0.000233434f $X=0.243 $Y=0.153
cc_17 N_6_19 N_CLK_7 0.00108487f $X=0.216 $Y=0.234
cc_18 N_6_18 N_CLK_7 0.00221044f $X=0.216 $Y=0.036
cc_19 N_6_17 N_4_11 7.69943e-20 $X=0.243 $Y=0.234
cc_20 N_6_18 N_4_11 0.00023207f $X=0.216 $Y=0.036
cc_21 N_6_4 N_4_11 0.000921477f $X=0.162 $Y=0.054
cc_22 N_6_19 N_4_23 0.000122839f $X=0.216 $Y=0.234
cc_23 N_6_16 N_4_19 0.000136727f $X=0.243 $Y=0.036
cc_24 N_6_15 N_4_11 0.0110403f $X=0.1475 $Y=0.216
cc_25 N_6_20 N_4_25 0.00147822f $X=0.243 $Y=0.153
cc_26 N_6_5 N_4_1 0.000430755f $X=0.162 $Y=0.216
cc_27 N_6_20 N_4_24 0.000442721f $X=0.243 $Y=0.153
cc_28 N_6_5 N_4_18 0.000482167f $X=0.162 $Y=0.216
cc_29 N_6_21 N_4_27 0.000508097f $X=0.351 $Y=0.116
cc_30 N_6_2 N_4_12 0.000547773f $X=0.459 $Y=0.179
cc_31 N_6_18 N_4_19 0.000595956f $X=0.216 $Y=0.036
cc_32 N_6_23 N_4_26 0.000641947f $X=0.2315 $Y=0.189
cc_33 N_6_20 N_4_27 0.000671882f $X=0.243 $Y=0.153
cc_34 N_6_1 N_4_2 0.00237901f $X=0.351 $Y=0.135
cc_35 N_6_14 N_4_1 0.00102757f $X=0.1475 $Y=0.054
cc_36 N_6_5 N_4_11 0.00111616f $X=0.162 $Y=0.216
cc_37 N_6_12 N_4_12 0.00160932f $X=0.351 $Y=0.073
cc_38 N_6_20 N_4_19 0.0036289f $X=0.243 $Y=0.153
cc_39 N_6_21 N_4_26 0.00437697f $X=0.351 $Y=0.116
cc_40 N_6_19 N_4_18 0.00511358f $X=0.216 $Y=0.234
cc_41 N_6_13 N_4_12 0.00852141f $X=0.459 $Y=0.179
cc_42 N_6_23 N_4_27 0.0171255f $X=0.2315 $Y=0.189
cc_43 N_6_14 N_4_11 0.039013f $X=0.1475 $Y=0.054
cc_44 N_6_23 N_D_6 0.000880636f $X=0.2315 $Y=0.189
cc_45 N_6_16 N_D_4 0.00103613f $X=0.243 $Y=0.036
cc_46 N_6_17 N_D_5 0.00109263f $X=0.243 $Y=0.234
cc_47 N_6_1 N_D_1 0.00255796f $X=0.351 $Y=0.135
cc_48 N_6_20 N_D_6 0.00307155f $X=0.243 $Y=0.153
cc_49 N_6_12 N_D_3 0.00495332f $X=0.351 $Y=0.073
cc_50 N_6_21 N_D_6 0.00836003f $X=0.351 $Y=0.116
x_PM_DLLx3_ASAP7_75t_R%Q vss Q N_M7_d N_M8_d N_M9_d N_M19_d N_M17_d N_M18_d
+ N_Q_15 N_Q_1 N_Q_2 N_Q_16 N_Q_14 N_Q_13 PM_DLLx3_ASAP7_75t_R%Q
cc_51 N_Q_15 N_8_27 0.00365392f $X=0.7415 $Y=0.2025
cc_52 N_Q_15 N_8_14 0.00255375f $X=0.7415 $Y=0.2025
cc_53 N_Q_15 N_8_2 0.00784093f $X=0.7415 $Y=0.2025
cc_54 N_Q_15 N_8_12 0.0563238f $X=0.7415 $Y=0.2025
cc_55 N_Q_15 N_8_28 0.00143064f $X=0.7415 $Y=0.2025
cc_56 N_Q_1 N_8_12 0.00188508f $X=0.756 $Y=0.0675
cc_57 N_Q_2 N_8_13 0.00191991f $X=0.756 $Y=0.2025
cc_58 N_Q_1 N_8_27 0.00248751f $X=0.756 $Y=0.0675
cc_59 N_Q_16 N_8_14 0.014595f $X=0.8495 $Y=0.2025
cc_60 N_Q_14 N_8_14 0.0521458f $X=0.8495 $Y=0.0675
cc_61 N_Q_13 N_8_12 0.0102584f $X=0.7415 $Y=0.0675
cc_62 N_Q_13 N_8_13 0.0184762f $X=0.7415 $Y=0.0675
cc_63 N_Q_15 N_8_13 0.0484091f $X=0.7415 $Y=0.2025
x_PM_DLLx3_ASAP7_75t_R%10 vss N_M2_d N_M3_s N_10_5 N_10_4 N_10_1
+ PM_DLLx3_ASAP7_75t_R%10
cc_64 N_10_5 N_4_2 0.000625359f $X=0.38 $Y=0.0675
cc_65 N_10_5 N_4_12 0.0344954f $X=0.38 $Y=0.0675
cc_66 N_10_4 N_D_6 0.000686184f $X=0.3095 $Y=0.0675
cc_67 N_10_4 N_D_3 0.0356896f $X=0.3095 $Y=0.0675
cc_68 N_10_5 N_6_1 0.00184899f $X=0.38 $Y=0.0675
cc_69 N_10_5 N_6_12 0.0730928f $X=0.38 $Y=0.0675
cc_70 N_10_1 N_8_23 0.000141285f $X=0.351 $Y=0.0675
cc_71 N_10_1 N_8_6 0.00123873f $X=0.351 $Y=0.0675
cc_72 N_10_1 N_8_16 0.000588539f $X=0.351 $Y=0.0675
cc_73 N_10_1 N_8_15 0.00240519f $X=0.351 $Y=0.0675
x_PM_DLLx3_ASAP7_75t_R%11 vss N_M14_d N_M15_s N_11_4 N_11_1 N_11_5
+ PM_DLLx3_ASAP7_75t_R%11
cc_74 N_11_4 N_4_12 0.0150966f $X=0.4175 $Y=0.2295
cc_75 N_11_1 N_6_2 0.00100733f $X=0.432 $Y=0.2295
cc_76 N_11_5 N_6_6 0.00107836f $X=0.488 $Y=0.2295
cc_77 N_11_1 N_6_13 0.00202011f $X=0.432 $Y=0.2295
cc_78 N_11_5 N_6_13 0.00696613f $X=0.488 $Y=0.2295
cc_79 N_11_4 N_6_13 0.0242921f $X=0.4175 $Y=0.2295
cc_80 N_11_5 N_7_9 0.0145353f $X=0.488 $Y=0.2295
cc_81 N_11_1 N_8_17 0.000282416f $X=0.432 $Y=0.2295
cc_82 N_11_1 N_8_18 0.0002923f $X=0.432 $Y=0.2295
cc_83 N_11_1 N_8_22 0.000369535f $X=0.432 $Y=0.2295
cc_84 N_11_1 N_8_25 0.000385984f $X=0.432 $Y=0.2295
cc_85 N_11_4 N_8_5 0.000497457f $X=0.4175 $Y=0.2295
cc_86 N_11_1 N_8_21 0.00176244f $X=0.432 $Y=0.2295
x_PM_DLLx3_ASAP7_75t_R%8 vss N_M6_g N_M16_g N_M3_d N_M4_s N_M8_g N_M18_g N_M7_g
+ N_M17_g N_M9_g N_M19_g N_M13_d N_M14_s N_8_17 N_8_26 N_8_5 N_8_23 N_8_18
+ N_8_20 N_8_28 N_8_24 N_8_6 N_8_22 N_8_25 N_8_15 N_8_16 N_8_21 N_8_1 N_8_11
+ N_8_27 N_8_2 N_8_19 N_8_14 N_8_12 N_8_13 PM_DLLx3_ASAP7_75t_R%8
cc_87 N_8_17 N_4_12 0.010988f $X=0.3635 $Y=0.2295
cc_88 N_8_26 N_4_12 0.0001546f $X=0.5395 $Y=0.131
cc_89 N_8_5 N_4_26 0.00017871f $X=0.378 $Y=0.2295
cc_90 N_8_23 N_4_26 0.000278431f $X=0.432 $Y=0.036
cc_91 N_8_18 N_4_12 0.00556711f $X=0.3635 $Y=0.189
cc_92 N_8_20 N_4_26 0.000461872f $X=0.459 $Y=0.131
cc_93 N_8_28 N_4_27 0.000662809f $X=0.459 $Y=0.153
cc_94 N_8_24 N_4_26 0.000749679f $X=0.459 $Y=0.114
cc_95 N_8_6 N_4_2 0.00079311f $X=0.432 $Y=0.0405
cc_96 N_8_22 N_4_27 0.000826671f $X=0.432 $Y=0.234
cc_97 N_8_25 N_4_26 0.00527166f $X=0.459 $Y=0.142
cc_98 N_8_22 N_4_26 0.000939795f $X=0.432 $Y=0.234
cc_99 N_8_6 N_4_12 0.00103354f $X=0.432 $Y=0.0405
cc_100 N_8_5 N_4_12 0.00123227f $X=0.378 $Y=0.2295
cc_101 N_8_15 N_4_2 0.00165224f $X=0.4175 $Y=0.0405
cc_102 N_8_15 N_4_12 0.00961569f $X=0.4175 $Y=0.0405
cc_103 N_8_16 N_4_12 0.0453371f $X=0.4175 $Y=0.081
cc_104 N_8_23 N_D_5 0.000166893f $X=0.432 $Y=0.036
cc_105 N_8_5 N_D_5 0.000820943f $X=0.378 $Y=0.2295
cc_106 N_8_22 N_D_5 0.00119002f $X=0.432 $Y=0.234
cc_107 N_8_20 N_6_22 0.000153573f $X=0.459 $Y=0.131
cc_108 N_8_22 N_6_21 0.00144588f $X=0.432 $Y=0.234
cc_109 N_8_5 N_6_21 0.0014984f $X=0.378 $Y=0.2295
cc_110 N_8_18 N_6_12 0.0245212f $X=0.3635 $Y=0.189
cc_111 N_8_5 N_6_1 0.0002804f $X=0.378 $Y=0.2295
cc_112 N_8_24 N_6_22 0.000314045f $X=0.459 $Y=0.114
cc_113 N_8_21 N_6_22 0.000424694f $X=0.459 $Y=0.234
cc_114 N_8_16 N_6_13 0.00558785f $X=0.4175 $Y=0.081
cc_115 N_8_1 N_6_6 0.00171537f $X=0.567 $Y=0.131
cc_116 N_8_25 N_6_23 0.000589308f $X=0.459 $Y=0.142
cc_117 N_8_26 N_6_6 0.00064243f $X=0.5395 $Y=0.131
cc_118 N_8_6 N_6_13 0.000645244f $X=0.432 $Y=0.0405
cc_119 N_8_17 N_6_1 0.000754773f $X=0.3635 $Y=0.2295
cc_120 N_8_28 N_6_22 0.000902948f $X=0.459 $Y=0.153
cc_121 N_8_25 N_6_2 0.00101558f $X=0.459 $Y=0.142
cc_122 N_8_5 N_6_12 0.0016301f $X=0.378 $Y=0.2295
cc_123 N_8_25 N_6_22 0.00246066f $X=0.459 $Y=0.142
cc_124 N_8_26 N_6_22 0.00359763f $X=0.5395 $Y=0.131
cc_125 N_8_28 N_6_23 0.00401737f $X=0.459 $Y=0.153
cc_126 N_8_22 N_6_23 0.00503273f $X=0.432 $Y=0.234
cc_127 N_8_11 N_6_6 0.0062691f $X=0.567 $Y=0.0245
cc_128 N_8_17 N_6_12 0.00991145f $X=0.3635 $Y=0.2295
cc_129 N_8_15 N_6_13 0.0319528f $X=0.4175 $Y=0.0405
cc_130 N_8_27 N_7_9 0.000139871f $X=0.783 $Y=0.1085
cc_131 N_8_2 N_7_9 0.000143215f $X=0.783 $Y=0.136
cc_132 N_8_26 N_7_9 0.000181828f $X=0.5395 $Y=0.131
cc_133 N_8_6 N_7_9 0.000394384f $X=0.432 $Y=0.0405
cc_134 N_8_11 N_7_3 0.000420725f $X=0.567 $Y=0.0245
cc_135 N_8_28 N_7_13 0.000440817f $X=0.459 $Y=0.153
cc_136 N_8_26 N_7_16 0.00060627f $X=0.5395 $Y=0.131
cc_137 N_8_1 N_7_17 0.000736688f $X=0.567 $Y=0.131
cc_138 N_8_19 N_7_12 0.000860946f $X=0.459 $Y=0.036
cc_139 N_8_1 N_7_9 0.000936324f $X=0.567 $Y=0.131
cc_140 N_8_26 N_7_1 0.00094089f $X=0.5395 $Y=0.131
cc_141 N_8_11 N_7_1 0.00098848f $X=0.567 $Y=0.0245
cc_142 N_8_11 N_7_11 0.00633436f $X=0.567 $Y=0.0245
cc_143 N_8_11 N_7_10 0.00644541f $X=0.567 $Y=0.0245
cc_144 N_8_28 N_7_17 0.00271534f $X=0.459 $Y=0.153
cc_145 N_8_26 N_7_15 0.00273695f $X=0.5395 $Y=0.131
cc_146 N_8_24 N_7_15 0.00346916f $X=0.459 $Y=0.114
cc_147 N_8_26 N_7_17 0.00369079f $X=0.5395 $Y=0.131
cc_148 N_8_11 N_7_9 0.0306089f $X=0.567 $Y=0.0245
x_PM_DLLx3_ASAP7_75t_R%13 vss N_M12_d N_M13_s N_13_1 PM_DLLx3_ASAP7_75t_R%13
cc_149 N_13_1 N_D_3 0.0166307f $X=0.324 $Y=0.2025
cc_150 N_13_1 N_6_12 0.0168123f $X=0.324 $Y=0.2025
x_PM_DLLx3_ASAP7_75t_R%4 vss N_M1_g N_M11_g N_M3_g N_M14_g N_M0_s N_M10_s N_4_6
+ N_4_5 N_4_16 N_4_13 N_4_14 N_4_21 N_4_25 N_4_1 N_4_23 N_4_24 N_4_27 N_4_22
+ N_4_18 N_4_20 N_4_11 N_4_26 N_4_19 N_4_12 N_4_2 PM_DLLx3_ASAP7_75t_R%4
cc_151 N_4_6 N_CLK_3 0.00102557f $X=0.054 $Y=0.216
cc_152 N_4_5 N_CLK_3 0.00104107f $X=0.054 $Y=0.054
cc_153 N_4_16 N_CLK_3 0.000282723f $X=0.0165 $Y=0.153
cc_154 N_4_13 N_CLK_3 0.0110998f $X=0.056 $Y=0.054
cc_155 N_4_14 N_CLK_3 0.011027f $X=0.056 $Y=0.216
cc_156 N_4_21 N_CLK_3 0.000437827f $X=0.018 $Y=0.1755
cc_157 N_4_25 N_CLK_3 0.000533765f $X=0.189 $Y=0.1485
cc_158 N_4_1 N_CLK_3 0.000554283f $X=0.134 $Y=0.135
cc_159 N_4_23 N_CLK_3 0.000630518f $X=0.036 $Y=0.234
cc_160 N_4_16 N_CLK_1 0.000829288f $X=0.0165 $Y=0.153
cc_161 N_4_24 N_CLK_4 0.00159818f $X=0.1405 $Y=0.135
cc_162 N_4_27 N_CLK_5 0.00184756f $X=0.0215 $Y=0.153
cc_163 N_4_22 N_CLK_7 0.00186347f $X=0.036 $Y=0.036
cc_164 N_4_18 N_CLK_8 0.00223913f $X=0.189 $Y=0.198
cc_165 N_4_16 N_CLK_6 0.00226098f $X=0.0165 $Y=0.153
cc_166 N_4_16 N_CLK_5 0.00226693f $X=0.0165 $Y=0.153
cc_167 N_4_20 N_CLK_4 0.00256111f $X=0.018 $Y=0.1305
cc_168 N_4_24 N_CLK_5 0.0026269f $X=0.1405 $Y=0.135
cc_169 N_4_1 N_CLK_1 0.00280785f $X=0.134 $Y=0.135
cc_170 N_4_11 N_CLK_3 0.0359077f $X=0.135 $Y=0.0245

* End of included file DLLx3_ASAP7_75t_R.pex.sp.pxi
.ends

.subckt PM_SDFLx1_ASAP7_75t_R%CLK vss 18 7 13 3 4 1 5 6
c1 1 vss 0.00438919f $X=0.081 $Y=0.135
c2 3 vss 0.0688813f $X=0.081 $Y=0.0245
c3 4 vss 0.00223948f $X=0.081 $Y=0.09
c4 5 vss 0.00201937f $X=0.081 $Y=0.11
c5 6 vss 0.00494023f $X=0.108 $Y=0.063
r1 6 21 4.60559 $w=1.39091e-08 $l=2.74591e-08 $layer=M1 $thickness=3.6e-08
+ $X=0.108 $Y=0.063 $X2=0.103 $Y2=0.09
r2 20 21 1.45753 $w=1.53529e-08 $l=8.5e-09 $layer=M1 $thickness=3.6e-08
+ $X=0.0945 $Y=0.09 $X2=0.103 $Y2=0.09
r3 4 5 3.48349 $w=1.525e-08 $l=2e-08 $layer=M1 $thickness=3.6e-08 $X=0.081
+ $Y=0.09 $X2=0.081 $Y2=0.11
r4 4 20 1.96775 $w=1.63333e-08 $l=1.35e-08 $layer=M1 $thickness=3.6e-08
+ $X=0.081 $Y=0.09 $X2=0.0945 $Y2=0.09
r5 18 17 0.757867 $w=1.3e-08 $l=3.3e-09 $layer=M1 $thickness=3.6e-08 $X=0.078
+ $Y=0.15 $X2=0.081 $Y2=0.1467
r6 16 17 2.73998 $w=1.3e-08 $l=1.17e-08 $layer=M1 $thickness=3.6e-08 $X=0.081
+ $Y=0.135 $X2=0.081 $Y2=0.1467
r7 15 16 2.68168 $w=1.3e-08 $l=1.15e-08 $layer=M1 $thickness=3.6e-08 $X=0.081
+ $Y=0.1235 $X2=0.081 $Y2=0.135
r8 5 15 3.14806 $w=1.3e-08 $l=1.35e-08 $layer=M1 $thickness=3.6e-08 $X=0.081
+ $Y=0.11 $X2=0.081 $Y2=0.1235
r9 1 10 10.4265 $w=1.765e-08 $layer=LIG $thickness=5.2e-08 $X=0.081 $Y=0.135
+ $X2=0.081 $Y2=0.135
r10 1 16 19.3796 $a=3.24e-16 $layer=V0LIG $X=0.081 $Y=0.135 $X2=0.081 $Y2=0.135
r11 13 12 14.6259 $w=2.1e-08 $l=4.3e-08 $layer=Gate_1 $thickness=5.6e-08
+ $X=0.081 $Y=0.216 $X2=0.081 $Y2=0.173
r12 11 12 7.31297 $w=2.1e-08 $l=2.15e-08 $layer=Gate_1 $thickness=5.6e-08
+ $X=0.081 $Y=0.1515 $X2=0.081 $Y2=0.173
r13 10 11 5.79936 $w=2.03333e-08 $l=1.65e-08 $layer=Gate_1 $thickness=5.6e-08
+ $X=0.081 $Y=0.135 $X2=0.081 $Y2=0.1515
r14 9 10 5.79936 $w=2.03333e-08 $l=1.65e-08 $layer=Gate_1 $thickness=5.6e-08
+ $X=0.081 $Y=0.1185 $X2=0.081 $Y2=0.135
r15 8 9 7.31297 $w=2.1e-08 $l=2.15e-08 $layer=Gate_1 $thickness=5.6e-08
+ $X=0.081 $Y=0.097 $X2=0.081 $Y2=0.1185
r16 7 8 14.6259 $w=2.1e-08 $l=4.3e-08 $layer=Gate_1 $thickness=5.6e-08 $X=0.081
+ $Y=0.054 $X2=0.081 $Y2=0.097
r17 7 3 10.0341 $w=2.1e-08 $l=2.95e-08 $layer=Gate_1 $thickness=5.6e-08
+ $X=0.081 $Y=0.054 $X2=0.081 $Y2=0.0245
.ends

.subckt PM_SDFLx1_ASAP7_75t_R%20 vss 7 12 1 4 5
c1 1 vss 0.00626509f $X=0.918 $Y=0.0405
c2 4 vss 0.00174941f $X=0.9035 $Y=0.0405
c3 5 vss 0.00217788f $X=0.974 $Y=0.0405
r1 12 11 0.0925926 $w=2.7e-08 $l=2.5e-09 $layer=N_src_drn $thickness=1e-09
+ $X=0.9893 $Y=0.0405 $X2=0.9865 $Y2=0.0405
r2 5 11 0.462963 $w=2.7e-08 $l=1.25e-08 $layer=N_src_drn $thickness=1e-09
+ $X=0.974 $Y=0.0405 $X2=0.9865 $Y2=0.0405
r3 9 5 6.3496 $w=2.32e-08 $l=1.35e-08 $layer=LISD $thickness=2.7e-08 $X=0.9585
+ $Y=0.0405 $X2=0.974 $Y2=0.0405
r4 8 9 7.05511 $w=2.32e-08 $l=1.5e-08 $layer=LISD $thickness=2.7e-08 $X=0.9435
+ $Y=0.0405 $X2=0.9585 $Y2=0.0405
r5 1 8 11.9937 $w=2.32e-08 $l=2.55e-08 $layer=LISD $thickness=2.7e-08 $X=0.918
+ $Y=0.0405 $X2=0.9435 $Y2=0.0405
r6 4 1 0.462963 $w=2.7e-08 $l=1.25e-08 $layer=N_src_drn $thickness=1e-09
+ $X=0.9035 $Y=0.0405 $X2=0.918 $Y2=0.0405
r7 7 4 0.0925926 $w=2.7e-08 $l=2.5e-09 $layer=N_src_drn $thickness=1e-09
+ $X=0.9006 $Y=0.0405 $X2=0.9035 $Y2=0.0405
.ends

.subckt PM_SDFLx1_ASAP7_75t_R%D vss 5 6 10 3 4 1
c1 1 vss 0.00703718f $X=0.405 $Y=0.135
c2 3 vss 0.102699f $X=0.405 $Y=0.0245
c3 4 vss 0.00580563f $X=0.405 $Y=0.108
c4 5 vss 0.00348466f $X=0.405 $Y=0.134
r1 4 12 1.96775 $w=1.63333e-08 $l=1.35e-08 $layer=M1 $thickness=3.6e-08
+ $X=0.405 $Y=0.108 $X2=0.405 $Y2=0.1215
r2 5 12 3.14806 $w=1.3e-08 $l=1.35e-08 $layer=M1 $thickness=3.6e-08 $X=0.405
+ $Y=0.134 $X2=0.405 $Y2=0.1215
r3 1 8 10.4265 $w=1.765e-08 $layer=LIG $thickness=5.2e-08 $X=0.405 $Y=0.135
+ $X2=0.405 $Y2=0.135
r4 5 1 19.3796 $a=3.24e-16 $layer=V0LIG $X=0.405 $Y=0.134 $X2=0.405 $Y2=0.135
r5 10 9 16.4967 $w=2.1e-08 $l=4.85e-08 $layer=Gate_1 $thickness=5.6e-08
+ $X=0.405 $Y=0.2025 $X2=0.405 $Y2=0.154
r6 8 9 6.6497 $w=2.04211e-08 $l=1.9e-08 $layer=Gate_1 $thickness=5.6e-08
+ $X=0.405 $Y=0.135 $X2=0.405 $Y2=0.154
r7 7 8 6.6497 $w=2.04211e-08 $l=1.9e-08 $layer=Gate_1 $thickness=5.6e-08
+ $X=0.405 $Y=0.116 $X2=0.405 $Y2=0.135
r8 6 7 16.4967 $w=2.1e-08 $l=4.85e-08 $layer=Gate_1 $thickness=5.6e-08 $X=0.405
+ $Y=0.0675 $X2=0.405 $Y2=0.116
r9 6 3 14.6259 $w=2.1e-08 $l=4.3e-08 $layer=Gate_1 $thickness=5.6e-08 $X=0.405
+ $Y=0.0675 $X2=0.405 $Y2=0.0245
.ends

.subckt PM_SDFLx1_ASAP7_75t_R%SI vss 18 8 12 7 4 6 1 3
c1 1 vss 0.0100627f $X=0.4575 $Y=0.135
c2 3 vss 0.0846884f $X=0.459 $Y=0.0245
c3 4 vss 0.00248726f $X=0.513 $Y=0.198
c4 5 vss 0.00500285f $X=0.513 $Y=0.135
c5 6 vss 0.00276032f $X=0.4635 $Y=0.135
c6 7 vss 0.00213937f $X=0.513 $Y=0.154
r1 4 23 3.83327 $w=1.5093e-08 $l=2.15e-08 $layer=M1 $thickness=3.6e-08 $X=0.513
+ $Y=0.198 $X2=0.513 $Y2=0.1765
r2 7 23 5.24677 $w=1.3e-08 $l=2.25e-08 $layer=M1 $thickness=3.6e-08 $X=0.513
+ $Y=0.154 $X2=0.513 $Y2=0.1765
r3 5 20 3.1337 $w=1.54324e-08 $l=1.85e-08 $layer=M1 $thickness=3.6e-08 $X=0.513
+ $Y=0.135 $X2=0.4945 $Y2=0.135
r4 5 7 3.2503 $w=1.53684e-08 $l=1.9e-08 $layer=M1 $thickness=3.6e-08 $X=0.513
+ $Y=0.135 $X2=0.513 $Y2=0.154
r5 19 20 2.3319 $w=1.3e-08 $l=1e-08 $layer=M1 $thickness=3.6e-08 $X=0.4845
+ $Y=0.135 $X2=0.4945 $Y2=0.135
r6 18 19 2.2153 $w=1.3e-08 $l=9.5e-09 $layer=M1 $thickness=3.6e-08 $X=0.473
+ $Y=0.135 $X2=0.4845 $Y2=0.135
r7 18 6 2.68168 $w=1.3e-08 $l=1.15e-08 $layer=M1 $thickness=3.6e-08 $X=0.473
+ $Y=0.135 $X2=0.4635 $Y2=0.135
r8 18 16 19.3796 $a=3.24e-16 $layer=V0LIG $X=0.473 $Y=0.135 $X2=0.4765 $Y2=0.135
r9 14 16 4.82216 $w=1.64167e-08 $l=9e-09 $layer=LIG $thickness=4.8e-08
+ $X=0.4675 $Y=0.135 $X2=0.4765 $Y2=0.135
r10 1 14 2.6116 $w=2.2e-08 $l=1e-08 $layer=LIG $thickness=4.8e-08 $X=0.4575
+ $Y=0.135 $X2=0.4675 $Y2=0.135
r11 1 10 6.14846 $w=2.08718e-08 $l=1.5e-09 $layer=Gate_1 $thickness=5.25128e-08
+ $X=0.4575 $Y=0.135 $X2=0.459 $Y2=0.135
r12 12 11 16.4967 $w=2.1e-08 $l=4.85e-08 $layer=Gate_1 $thickness=5.6e-08
+ $X=0.459 $Y=0.2025 $X2=0.459 $Y2=0.154
r13 10 11 6.6497 $w=2.04211e-08 $l=1.9e-08 $layer=Gate_1 $thickness=5.6e-08
+ $X=0.459 $Y=0.135 $X2=0.459 $Y2=0.154
r14 10 14 4.32033 $w=2.024e-08 $l=8.5e-09 $layer=Gate_1 $thickness=5.504e-08
+ $X=0.459 $Y=0.135 $X2=0.4675 $Y2=0.135
r15 9 10 6.6497 $w=2.04211e-08 $l=1.9e-08 $layer=Gate_1 $thickness=5.6e-08
+ $X=0.459 $Y=0.116 $X2=0.459 $Y2=0.135
r16 8 9 16.4967 $w=2.1e-08 $l=4.85e-08 $layer=Gate_1 $thickness=5.6e-08
+ $X=0.459 $Y=0.0675 $X2=0.459 $Y2=0.116
r17 8 3 14.6259 $w=2.1e-08 $l=4.3e-08 $layer=Gate_1 $thickness=5.6e-08 $X=0.459
+ $Y=0.0675 $X2=0.459 $Y2=0.0245
.ends

.subckt PM_SDFLx1_ASAP7_75t_R%6 vss 19 23 49 54 12 3 15 1 11 10 13 4 14 9 16
c1 1 vss 0.00432459f $X=0.351 $Y=0.135
c2 3 vss 0.014206f $X=1.1725 $Y=0.0405
c3 4 vss 0.00837698f $X=1.188 $Y=0.2295
c4 9 vss 0.101704f $X=0.351 $Y=0.0245
c5 10 vss 0.0388048f $X=1.19 $Y=0.0675
c6 11 vss 0.040102f $X=1.19 $Y=0.2025
c7 12 vss 0.00715209f $X=0.351 $Y=0.072
c8 13 vss 0.00609018f $X=1.161 $Y=0.234
c9 14 vss 0.00305261f $X=0.351 $Y=0.135
c10 15 vss 0.00394435f $X=1.161 $Y=0.037
c11 16 vss 0.0176334f $X=0.3395 $Y=0.081
r1 54 53 0.0308642 $w=8.1e-08 $l=2.5e-09 $layer=P_src_drn $thickness=1e-09
+ $X=1.2053 $Y=0.2025 $X2=1.2025 $Y2=0.2025
r2 11 53 0.154321 $w=8.1e-08 $l=1.25e-08 $layer=P_src_drn $thickness=1e-09
+ $X=1.19 $Y=0.2025 $X2=1.2025 $Y2=0.2025
r3 4 46 19.3796 $a=3.24e-16 $layer=V0LISD $X=1.188 $Y=0.2295 $X2=1.188 $Y2=0.234
r4 49 48 0.0308642 $w=8.1e-08 $l=2.5e-09 $layer=N_src_drn $thickness=1e-09
+ $X=1.2053 $Y=0.0675 $X2=1.2025 $Y2=0.0675
r5 10 48 0.154321 $w=8.1e-08 $l=1.25e-08 $layer=N_src_drn $thickness=1e-09
+ $X=1.19 $Y=0.0675 $X2=1.2025 $Y2=0.0675
r6 45 46 3.14806 $w=1.3e-08 $l=1.35e-08 $layer=M1 $thickness=3.6e-08 $X=1.1745
+ $Y=0.234 $X2=1.188 $Y2=0.234
r7 13 42 3.83327 $w=1.5093e-08 $l=2.15e-08 $layer=M1 $thickness=3.6e-08
+ $X=1.161 $Y=0.234 $X2=1.161 $Y2=0.2125
r8 13 45 1.96775 $w=1.63333e-08 $l=1.35e-08 $layer=M1 $thickness=3.6e-08
+ $X=1.161 $Y=0.234 $X2=1.1745 $Y2=0.234
r9 3 38 19.3796 $a=3.24e-16 $layer=V0LISD $X=1.1725 $Y=0.0405 $X2=1.161
+ $Y2=0.0515
r10 3 10 4.30736 $w=5.12e-08 $l=2.95e-08 $layer=LISD $thickness=2.7e-08
+ $X=1.1725 $Y=0.0405 $X2=1.19 $Y2=0.0675
r11 41 42 15.7403 $w=1.3e-08 $l=6.75e-08 $layer=M1 $thickness=3.6e-08 $X=1.161
+ $Y=0.145 $X2=1.161 $Y2=0.2125
r12 40 41 14.9241 $w=1.3e-08 $l=6.4e-08 $layer=M1 $thickness=3.6e-08 $X=1.161
+ $Y=0.081 $X2=1.161 $Y2=0.145
r13 39 40 3.73104 $w=1.3e-08 $l=1.6e-08 $layer=M1 $thickness=3.6e-08 $X=1.161
+ $Y=0.065 $X2=1.161 $Y2=0.081
r14 38 39 3.14806 $w=1.3e-08 $l=1.35e-08 $layer=M1 $thickness=3.6e-08 $X=1.161
+ $Y=0.0515 $X2=1.161 $Y2=0.065
r15 37 38 2.09871 $w=1.3e-08 $l=9e-09 $layer=M1 $thickness=3.6e-08 $X=1.161
+ $Y=0.0425 $X2=1.161 $Y2=0.0515
r16 15 37 1.28254 $w=1.3e-08 $l=5.5e-09 $layer=M1 $thickness=3.6e-08 $X=1.161
+ $Y=0.037 $X2=1.161 $Y2=0.0425
r17 35 40 19.5347 $a=3.24e-16 $layer=V1 $X=1.161 $Y=0.081 $X2=1.161 $Y2=0.081
r18 34 35 27.2832 $w=1.3e-08 $l=1.17e-07 $layer=M2 $thickness=3.6e-08 $X=1.044
+ $Y=0.081 $X2=1.161 $Y2=0.081
r19 33 34 29.3819 $w=1.3e-08 $l=1.26e-07 $layer=M2 $thickness=3.6e-08 $X=0.918
+ $Y=0.081 $X2=1.044 $Y2=0.081
r20 32 33 67.1587 $w=1.3e-08 $l=2.88e-07 $layer=M2 $thickness=3.6e-08 $X=0.63
+ $Y=0.081 $X2=0.918 $Y2=0.081
r21 31 32 65.0599 $w=1.3e-08 $l=2.79e-07 $layer=M2 $thickness=3.6e-08 $X=0.351
+ $Y=0.081 $X2=0.63 $Y2=0.081
r22 16 31 2.68168 $w=1.3e-08 $l=1.15e-08 $layer=M2 $thickness=3.6e-08 $X=0.3395
+ $Y=0.081 $X2=0.351 $Y2=0.081
r23 12 27 1.96775 $w=1.63333e-08 $l=1.35e-08 $layer=M1 $thickness=3.6e-08
+ $X=0.351 $Y=0.072 $X2=0.351 $Y2=0.0855
r24 12 31 39.0693 $a=1.62e-16 $layer=V1 $X=0.351 $Y=0.072 $X2=0.351 $Y2=0.081
r25 27 28 2.09871 $w=1.3e-08 $l=9e-09 $layer=M1 $thickness=3.6e-08 $X=0.351
+ $Y=0.0855 $X2=0.351 $Y2=0.0945
r26 27 31 39.0693 $a=1.62e-16 $layer=V1 $X=0.351 $Y=0.0855 $X2=0.351 $Y2=0.081
r27 26 28 3.14806 $w=1.3e-08 $l=1.35e-08 $layer=M1 $thickness=3.6e-08 $X=0.351
+ $Y=0.108 $X2=0.351 $Y2=0.0945
r28 25 26 3.14806 $w=1.3e-08 $l=1.35e-08 $layer=M1 $thickness=3.6e-08 $X=0.351
+ $Y=0.1215 $X2=0.351 $Y2=0.108
r29 14 25 3.14806 $w=1.3e-08 $l=1.35e-08 $layer=M1 $thickness=3.6e-08 $X=0.351
+ $Y=0.135 $X2=0.351 $Y2=0.1215
r30 1 21 10.4265 $w=1.765e-08 $layer=LIG $thickness=5.2e-08 $X=0.351 $Y=0.135
+ $X2=0.351 $Y2=0.135
r31 1 14 19.3796 $a=3.24e-16 $layer=V0LIG $X=0.351 $Y=0.135 $X2=0.351 $Y2=0.135
r32 23 22 16.4967 $w=2.1e-08 $l=4.85e-08 $layer=Gate_1 $thickness=5.6e-08
+ $X=0.351 $Y=0.2025 $X2=0.351 $Y2=0.154
r33 21 22 6.6497 $w=2.04211e-08 $l=1.9e-08 $layer=Gate_1 $thickness=5.6e-08
+ $X=0.351 $Y=0.135 $X2=0.351 $Y2=0.154
r34 20 21 6.6497 $w=2.04211e-08 $l=1.9e-08 $layer=Gate_1 $thickness=5.6e-08
+ $X=0.351 $Y=0.116 $X2=0.351 $Y2=0.135
r35 19 20 16.4967 $w=2.1e-08 $l=4.85e-08 $layer=Gate_1 $thickness=5.6e-08
+ $X=0.351 $Y=0.0675 $X2=0.351 $Y2=0.116
r36 19 9 14.6259 $w=2.1e-08 $l=4.3e-08 $layer=Gate_1 $thickness=5.6e-08
+ $X=0.351 $Y=0.0675 $X2=0.351 $Y2=0.0245
r37 4 11 1e-05 $l=2.7074e-08 $X=1.188 $Y=0.2295 $X2=1.19 $Y2=0.2025
.ends

.subckt PM_SDFLx1_ASAP7_75t_R%9 vss 26 30 61 64 71 73 19 5 15 22 18 12 6 16 13
+ 14 21 2 11 17 1 20
c1 1 vss 0.00239851f $X=0.621 $Y=0.135
c2 2 vss 0.000385111f $X=0.891 $Y=0.135
c3 5 vss 0.00760938f $X=0.162 $Y=0.054
c4 6 vss 0.00731627f $X=0.162 $Y=0.216
c5 11 vss 0.0463512f $X=0.621 $Y=0.135
c6 12 vss 0.00717798f $X=0.891 $Y=0.0245
c7 13 vss 0.0316169f $X=0.1475 $Y=0.054
c8 14 vss 0.0314232f $X=0.1475 $Y=0.216
c9 15 vss 0.00546056f $X=0.189 $Y=0.036
c10 16 vss 0.00315899f $X=0.189 $Y=0.234
c11 17 vss 0.000429935f $X=0.621 $Y=0.162
c12 18 vss 0.00538179f $X=0.1505 $Y=0.234
c13 19 vss 0.00450909f $X=0.189 $Y=0.1325
c14 20 vss 0.00147398f $X=0.621 $Y=0.116
c15 21 vss 0.000790783f $X=0.891 $Y=0.1135
c16 22 vss 0.0193805f $X=0.8125 $Y=0.153
r1 14 6 0.231482 $w=5.4e-08 $l=1.25e-08 $layer=P_src_drn $thickness=1e-09
+ $X=0.1475 $Y=0.216 $X2=0.162 $Y2=0.216
r2 73 14 0.0462963 $w=5.4e-08 $l=2.5e-09 $layer=P_src_drn $thickness=1e-09
+ $X=0.1446 $Y=0.216 $X2=0.1475 $Y2=0.216
r3 6 66 19.3796 $a=3.24e-16 $layer=V0LISD $X=0.162 $Y=0.216 $X2=0.162 $Y2=0.234
r4 13 5 0.231482 $w=5.4e-08 $l=1.25e-08 $layer=N_src_drn $thickness=1e-09
+ $X=0.1475 $Y=0.054 $X2=0.162 $Y2=0.054
r5 71 13 0.0462963 $w=5.4e-08 $l=2.5e-09 $layer=N_src_drn $thickness=1e-09
+ $X=0.1446 $Y=0.054 $X2=0.1475 $Y2=0.054
r6 66 67 3.14806 $w=1.3e-08 $l=1.35e-08 $layer=M1 $thickness=3.6e-08 $X=0.162
+ $Y=0.234 $X2=0.1755 $Y2=0.234
r7 18 66 2.68168 $w=1.3e-08 $l=1.15e-08 $layer=M1 $thickness=3.6e-08 $X=0.1505
+ $Y=0.234 $X2=0.162 $Y2=0.234
r8 5 58 19.3796 $a=3.24e-16 $layer=V0LISD $X=0.162 $Y=0.054 $X2=0.162 $Y2=0.036
r9 64 63 16.4967 $w=2.1e-08 $l=4.85e-08 $layer=Gate_1 $thickness=5.6e-08
+ $X=0.621 $Y=0.2295 $X2=0.621 $Y2=0.181
r10 61 62 16.4967 $w=2.1e-08 $l=4.85e-08 $layer=Gate_1 $thickness=5.6e-08
+ $X=0.621 $Y=0.0675 $X2=0.621 $Y2=0.116
r11 11 62 6.6497 $w=2.04211e-08 $l=1.9e-08 $layer=Gate_1 $thickness=5.6e-08
+ $X=0.621 $Y=0.135 $X2=0.621 $Y2=0.116
r12 11 63 15.8334 $w=2.07609e-08 $l=4.6e-08 $layer=Gate_1 $thickness=5.6e-08
+ $X=0.621 $Y=0.135 $X2=0.621 $Y2=0.181
r13 16 54 2.5483 $w=1.79e-08 $l=1.8e-08 $layer=M1 $thickness=3.6e-08 $X=0.189
+ $Y=0.234 $X2=0.189 $Y2=0.216
r14 16 67 1.49895 $w=1.63333e-08 $l=1.35e-08 $layer=M1 $thickness=3.6e-08
+ $X=0.189 $Y=0.234 $X2=0.1755 $Y2=0.234
r15 58 59 3.14806 $w=1.3e-08 $l=1.35e-08 $layer=M1 $thickness=3.6e-08 $X=0.162
+ $Y=0.036 $X2=0.1755 $Y2=0.036
r16 15 49 5.11582 $w=1.46667e-08 $l=2.7e-08 $layer=M1 $thickness=3.6e-08
+ $X=0.189 $Y=0.036 $X2=0.189 $Y2=0.063
r17 15 59 1.96775 $w=1.63333e-08 $l=1.35e-08 $layer=M1 $thickness=3.6e-08
+ $X=0.189 $Y=0.036 $X2=0.1755 $Y2=0.036
r18 1 46 19.3796 $a=3.24e-16 $layer=V0LIG $X=0.621 $Y=0.135 $X2=0.621 $Y2=0.1395
r19 1 11 6.54019 $w=2.09524e-08 $layer=Gate_1 $thickness=5.21905e-08 $X=0.621
+ $Y=0.135 $X2=0.621 $Y2=0.135
r20 53 54 4.19742 $w=1.3e-08 $l=1.8e-08 $layer=M1 $thickness=3.6e-08 $X=0.189
+ $Y=0.198 $X2=0.189 $Y2=0.216
r21 52 53 5.01358 $w=1.3e-08 $l=2.15e-08 $layer=M1 $thickness=3.6e-08 $X=0.189
+ $Y=0.1765 $X2=0.189 $Y2=0.198
r22 51 52 3.14806 $w=1.3e-08 $l=1.35e-08 $layer=M1 $thickness=3.6e-08 $X=0.189
+ $Y=0.163 $X2=0.189 $Y2=0.1765
r23 50 51 2.3319 $w=1.3e-08 $l=1e-08 $layer=M1 $thickness=3.6e-08 $X=0.189
+ $Y=0.153 $X2=0.189 $Y2=0.163
r24 48 49 6.29612 $w=1.3e-08 $l=2.7e-08 $layer=M1 $thickness=3.6e-08 $X=0.189
+ $Y=0.09 $X2=0.189 $Y2=0.063
r25 47 48 4.6638 $w=1.3e-08 $l=2e-08 $layer=M1 $thickness=3.6e-08 $X=0.189
+ $Y=0.11 $X2=0.189 $Y2=0.09
r26 19 47 5.24677 $w=1.3e-08 $l=2.25e-08 $layer=M1 $thickness=3.6e-08 $X=0.189
+ $Y=0.1325 $X2=0.189 $Y2=0.11
r27 19 50 4.78039 $w=1.3e-08 $l=2.05e-08 $layer=M1 $thickness=3.6e-08 $X=0.189
+ $Y=0.1325 $X2=0.189 $Y2=0.153
r28 20 46 5.47996 $w=1.3e-08 $l=2.35e-08 $layer=M1 $thickness=3.6e-08 $X=0.621
+ $Y=0.116 $X2=0.621 $Y2=0.1395
r29 17 38 39.0693 $a=1.62e-16 $layer=V1 $X=0.621 $Y=0.162 $X2=0.621 $Y2=0.153
r30 17 46 4.06646 $w=1.5e-08 $l=2.25e-08 $layer=M1 $thickness=3.6e-08 $X=0.621
+ $Y=0.162 $X2=0.621 $Y2=0.1395
r31 42 43 3.61444 $w=1.3e-08 $l=1.55e-08 $layer=M2 $thickness=3.6e-08 $X=0.189
+ $Y=0.153 $X2=0.2045 $Y2=0.153
r32 42 50 19.5347 $a=3.24e-16 $layer=V1 $X=0.189 $Y=0.153 $X2=0.189 $Y2=0.153
r33 40 43 16.2067 $w=1.3e-08 $l=6.95e-08 $layer=M2 $thickness=3.6e-08 $X=0.274
+ $Y=0.153 $X2=0.2045 $Y2=0.153
r34 38 39 15.2739 $w=1.3e-08 $l=6.55e-08 $layer=M2 $thickness=3.6e-08 $X=0.621
+ $Y=0.153 $X2=0.6865 $Y2=0.153
r35 38 46 39.0693 $a=1.62e-16 $layer=V1 $X=0.621 $Y=0.153 $X2=0.621 $Y2=0.1395
r36 37 38 34.1623 $w=1.3e-08 $l=1.465e-07 $layer=M2 $thickness=3.6e-08
+ $X=0.4745 $Y=0.153 $X2=0.621 $Y2=0.153
r37 37 40 46.7545 $w=1.3e-08 $l=2.005e-07 $layer=M2 $thickness=3.6e-08
+ $X=0.4745 $Y=0.153 $X2=0.274 $Y2=0.153
r38 22 36 18.3054 $w=1.3e-08 $l=7.85e-08 $layer=M2 $thickness=3.6e-08 $X=0.8125
+ $Y=0.153 $X2=0.891 $Y2=0.153
r39 22 39 29.3819 $w=1.3e-08 $l=1.26e-07 $layer=M2 $thickness=3.6e-08 $X=0.8125
+ $Y=0.153 $X2=0.6865 $Y2=0.153
r40 34 36 19.5347 $a=3.24e-16 $layer=V1 $X=0.891 $Y=0.144 $X2=0.891 $Y2=0.153
r41 21 34 7.11229 $w=1.3e-08 $l=3.05e-08 $layer=M1 $thickness=3.6e-08 $X=0.891
+ $Y=0.1135 $X2=0.891 $Y2=0.144
r42 2 28 6.54019 $w=2.09524e-08 $layer=Gate_1 $thickness=5.21905e-08 $X=0.891
+ $Y=0.135 $X2=0.891 $Y2=0.135
r43 2 34 19.3796 $a=3.24e-16 $layer=V0LIG $X=0.891 $Y=0.135 $X2=0.891 $Y2=0.144
r44 30 29 16.4967 $w=2.1e-08 $l=4.85e-08 $layer=Gate_1 $thickness=5.6e-08
+ $X=0.891 $Y=0.2295 $X2=0.891 $Y2=0.181
r45 28 29 15.8334 $w=2.07609e-08 $l=4.6e-08 $layer=Gate_1 $thickness=5.6e-08
+ $X=0.891 $Y=0.135 $X2=0.891 $Y2=0.181
r46 27 28 15.8334 $w=2.07609e-08 $l=4.6e-08 $layer=Gate_1 $thickness=5.6e-08
+ $X=0.891 $Y=0.089 $X2=0.891 $Y2=0.135
r47 26 27 16.4967 $w=2.1e-08 $l=4.85e-08 $layer=Gate_1 $thickness=5.6e-08
+ $X=0.891 $Y=0.0405 $X2=0.891 $Y2=0.089
r48 26 12 5.44221 $w=2.1e-08 $l=1.6e-08 $layer=Gate_1 $thickness=5.6e-08
+ $X=0.891 $Y=0.0405 $X2=0.891 $Y2=0.0245
.ends

.subckt PM_SDFLx1_ASAP7_75t_R%14 vss 13 24 26 10 2 11 8 1 9
c1 1 vss 0.00730402f $X=0.27 $Y=0.1755
c2 2 vss 0.0102052f $X=0.513 $Y=0.2025
c3 8 vss 0.0366902f $X=0.272 $Y=0.2025
c4 9 vss 0.0358382f $X=0.4715 $Y=0.2025
c5 10 vss 0.0356932f $X=0.542 $Y=0.2025
c6 11 vss 0.0211806f $X=0.258 $Y=0.234
r1 26 25 0.0308642 $w=8.1e-08 $l=2.5e-09 $layer=P_src_drn $thickness=1e-09
+ $X=0.5573 $Y=0.2025 $X2=0.5545 $Y2=0.2025
r2 10 25 0.154321 $w=8.1e-08 $l=1.25e-08 $layer=P_src_drn $thickness=1e-09
+ $X=0.542 $Y=0.2025 $X2=0.5545 $Y2=0.2025
r3 9 2 0.154321 $w=8.1e-08 $l=1.25e-08 $layer=P_src_drn $thickness=1e-09
+ $X=0.4715 $Y=0.2025 $X2=0.513 $Y2=0.2025
r4 24 9 0.0308642 $w=8.1e-08 $l=2.5e-09 $layer=P_src_drn $thickness=1e-09
+ $X=0.4686 $Y=0.2025 $X2=0.4715 $Y2=0.2025
r5 2 21 19.3796 $a=3.24e-16 $layer=V0LISD $X=0.513 $Y=0.2025 $X2=0.49 $Y2=0.234
r6 20 21 2.09871 $w=1.3e-08 $l=9e-09 $layer=M1 $thickness=3.6e-08 $X=0.481
+ $Y=0.234 $X2=0.49 $Y2=0.234
r7 19 20 2.79828 $w=1.3e-08 $l=1.2e-08 $layer=M1 $thickness=3.6e-08 $X=0.469
+ $Y=0.234 $X2=0.481 $Y2=0.234
r8 18 19 3.49785 $w=1.3e-08 $l=1.5e-08 $layer=M1 $thickness=3.6e-08 $X=0.454
+ $Y=0.234 $X2=0.469 $Y2=0.234
r9 17 18 17.7224 $w=1.3e-08 $l=7.6e-08 $layer=M1 $thickness=3.6e-08 $X=0.378
+ $Y=0.234 $X2=0.454 $Y2=0.234
r10 16 17 19.5879 $w=1.3e-08 $l=8.4e-08 $layer=M1 $thickness=3.6e-08 $X=0.294
+ $Y=0.234 $X2=0.378 $Y2=0.234
r11 15 16 5.59655 $w=1.3e-08 $l=2.4e-08 $layer=M1 $thickness=3.6e-08 $X=0.27
+ $Y=0.234 $X2=0.294 $Y2=0.234
r12 11 15 2.79828 $w=1.3e-08 $l=1.2e-08 $layer=M1 $thickness=3.6e-08 $X=0.258
+ $Y=0.234 $X2=0.27 $Y2=0.234
r13 8 15 19.3796 $a=3.24e-16 $layer=V0LISD $X=0.272 $Y=0.2025 $X2=0.27 $Y2=0.234
r14 1 8 23.8708 $w=2.02e-08 $l=4.05e-08 $layer=LISD $thickness=2.7e-08 $X=0.27
+ $Y=0.1755 $X2=0.272 $Y2=0.2025
r15 13 12 0.0308642 $w=8.1e-08 $l=2.5e-09 $layer=P_src_drn $thickness=1e-09
+ $X=0.2873 $Y=0.2025 $X2=0.2845 $Y2=0.2025
r16 8 12 0.154321 $w=8.1e-08 $l=1.25e-08 $layer=P_src_drn $thickness=1e-09
+ $X=0.272 $Y=0.2025 $X2=0.2845 $Y2=0.2025
r17 2 10 1e-05 $l=2.9e-08 $X=0.513 $Y=0.2025 $X2=0.542 $Y2=0.2025
.ends

.subckt PM_SDFLx1_ASAP7_75t_R%16 vss 12 13 27 28 9 7 1 2 8
c1 1 vss 0.00461224f $X=0.324 $Y=0.2025
c2 2 vss 0.00450404f $X=0.432 $Y=0.2025
c3 7 vss 0.00309763f $X=0.3095 $Y=0.2025
c4 8 vss 0.00309989f $X=0.4175 $Y=0.2025
c5 9 vss 0.00346738f $X=0.31 $Y=0.198
r1 28 26 0.0308642 $w=8.1e-08 $l=2.5e-09 $layer=P_src_drn $thickness=1e-09
+ $X=0.4493 $Y=0.2025 $X2=0.4465 $Y2=0.2025
r2 2 26 0.179012 $w=8.1e-08 $l=1.45e-08 $layer=P_src_drn $thickness=1e-09
+ $X=0.432 $Y=0.2025 $X2=0.4465 $Y2=0.2025
r3 8 2 0.179012 $w=8.1e-08 $l=1.45e-08 $layer=P_src_drn $thickness=1e-09
+ $X=0.4175 $Y=0.2025 $X2=0.432 $Y2=0.2025
r4 27 8 0.0308642 $w=8.1e-08 $l=2.5e-09 $layer=P_src_drn $thickness=1e-09
+ $X=0.4146 $Y=0.2025 $X2=0.4175 $Y2=0.2025
r5 2 22 19.3796 $a=3.24e-16 $layer=V0LISD $X=0.432 $Y=0.2025 $X2=0.428 $Y2=0.198
r6 21 22 2.2153 $w=1.3e-08 $l=9.5e-09 $layer=M1 $thickness=3.6e-08 $X=0.4185
+ $Y=0.198 $X2=0.428 $Y2=0.198
r7 20 21 3.14806 $w=1.3e-08 $l=1.35e-08 $layer=M1 $thickness=3.6e-08 $X=0.405
+ $Y=0.198 $X2=0.4185 $Y2=0.198
r8 19 20 4.08082 $w=1.3e-08 $l=1.75e-08 $layer=M1 $thickness=3.6e-08 $X=0.3875
+ $Y=0.198 $X2=0.405 $Y2=0.198
r9 18 19 4.19742 $w=1.3e-08 $l=1.8e-08 $layer=M1 $thickness=3.6e-08 $X=0.3695
+ $Y=0.198 $X2=0.3875 $Y2=0.198
r10 17 18 4.31401 $w=1.3e-08 $l=1.85e-08 $layer=M1 $thickness=3.6e-08 $X=0.351
+ $Y=0.198 $X2=0.3695 $Y2=0.198
r11 16 17 3.14806 $w=1.3e-08 $l=1.35e-08 $layer=M1 $thickness=3.6e-08 $X=0.3375
+ $Y=0.198 $X2=0.351 $Y2=0.198
r12 15 16 3.14806 $w=1.3e-08 $l=1.35e-08 $layer=M1 $thickness=3.6e-08 $X=0.324
+ $Y=0.198 $X2=0.3375 $Y2=0.198
r13 14 15 2.56509 $w=1.3e-08 $l=1.1e-08 $layer=M1 $thickness=3.6e-08 $X=0.313
+ $Y=0.198 $X2=0.324 $Y2=0.198
r14 9 14 0.699569 $w=1.3e-08 $l=3e-09 $layer=M1 $thickness=3.6e-08 $X=0.31
+ $Y=0.198 $X2=0.313 $Y2=0.198
r15 1 15 19.3796 $a=3.24e-16 $layer=V0LISD $X=0.324 $Y=0.2025 $X2=0.324
+ $Y2=0.198
r16 13 11 0.0308642 $w=8.1e-08 $l=2.5e-09 $layer=P_src_drn $thickness=1e-09
+ $X=0.3413 $Y=0.2025 $X2=0.3385 $Y2=0.2025
r17 1 11 0.179012 $w=8.1e-08 $l=1.45e-08 $layer=P_src_drn $thickness=1e-09
+ $X=0.324 $Y=0.2025 $X2=0.3385 $Y2=0.2025
r18 7 1 0.179012 $w=8.1e-08 $l=1.45e-08 $layer=P_src_drn $thickness=1e-09
+ $X=0.3095 $Y=0.2025 $X2=0.324 $Y2=0.2025
r19 12 7 0.0308642 $w=8.1e-08 $l=2.5e-09 $layer=P_src_drn $thickness=1e-09
+ $X=0.3066 $Y=0.2025 $X2=0.3095 $Y2=0.2025
.ends

.subckt PM_SDFLx1_ASAP7_75t_R%22 vss 2 3 1
c1 1 vss 0.000541449f $X=0.702 $Y=0.0405
r1 2 1 0.62963 $w=2.7e-08 $l=1.7e-08 $layer=N_src_drn $thickness=1e-09
+ $X=0.6846 $Y=0.0405 $X2=0.702 $Y2=0.0405
r2 3 1 0.62963 $w=2.7e-08 $l=1.7e-08 $layer=N_src_drn $thickness=1e-09
+ $X=0.7193 $Y=0.0405 $X2=0.702 $Y2=0.0405
.ends

.subckt PM_SDFLx1_ASAP7_75t_R%10 vss 21 25 47 48 53 55 3 1 11 12 13 18 4 20 10
+ 17 14 15 16 19
c1 1 vss 0.00320735f $X=0.7285 $Y=0.09
c2 3 vss 0.005199f $X=0.81 $Y=0.0405
c3 4 vss 0.00826871f $X=0.81 $Y=0.2295
c4 10 vss 0.0489966f $X=0.729 $Y=0.0245
c5 11 vss 0.00380541f $X=0.7955 $Y=0.0405
c6 12 vss 0.00360111f $X=0.7955 $Y=0.2295
c7 13 vss 0.00322357f $X=0.866 $Y=0.2295
c8 14 vss 0.00131988f $X=0.729 $Y=0.09
c9 15 vss 0.00121233f $X=0.81 $Y=0.09
c10 16 vss 0.00262866f $X=0.837 $Y=0.234
c11 17 vss 0.00100803f $X=0.747 $Y=0.09
c12 18 vss 0.00376228f $X=0.8125 $Y=0.234
c13 19 vss 0.00182728f $X=0.81 $Y=0.0625
c14 20 vss 0.00117791f $X=0.837 $Y=0.1
r1 55 54 0.0925926 $w=2.7e-08 $l=2.5e-09 $layer=P_src_drn $thickness=1e-09
+ $X=0.8813 $Y=0.2295 $X2=0.8785 $Y2=0.2295
r2 13 54 0.462963 $w=2.7e-08 $l=1.25e-08 $layer=P_src_drn $thickness=1e-09
+ $X=0.866 $Y=0.2295 $X2=0.8785 $Y2=0.2295
r3 12 4 0.462963 $w=2.7e-08 $l=1.25e-08 $layer=P_src_drn $thickness=1e-09
+ $X=0.7955 $Y=0.2295 $X2=0.81 $Y2=0.2295
r4 53 12 0.0925926 $w=2.7e-08 $l=2.5e-09 $layer=P_src_drn $thickness=1e-09
+ $X=0.7926 $Y=0.2295 $X2=0.7955 $Y2=0.2295
r5 50 13 12.6992 $w=2.32e-08 $l=2.7e-08 $layer=LISD $thickness=2.7e-08 $X=0.837
+ $Y=0.2295 $X2=0.866 $Y2=0.2295
r6 4 50 12.6992 $w=2.32e-08 $l=2.7e-08 $layer=LISD $thickness=2.7e-08 $X=0.81
+ $Y=0.2295 $X2=0.837 $Y2=0.2295
r7 4 18 19.3796 $a=3.24e-16 $layer=V0LISD $X=0.81 $Y=0.2295 $X2=0.8125 $Y2=0.234
r8 47 46 0.0925926 $w=2.7e-08 $l=2.5e-09 $layer=N_src_drn $thickness=1e-09
+ $X=0.8273 $Y=0.0405 $X2=0.8245 $Y2=0.0405
r9 3 46 0.537037 $w=2.7e-08 $l=1.45e-08 $layer=N_src_drn $thickness=1e-09
+ $X=0.81 $Y=0.0405 $X2=0.8245 $Y2=0.0405
r10 11 3 0.537037 $w=2.7e-08 $l=1.45e-08 $layer=N_src_drn $thickness=1e-09
+ $X=0.7955 $Y=0.0405 $X2=0.81 $Y2=0.0405
r11 48 11 0.0925926 $w=2.7e-08 $l=2.5e-09 $layer=N_src_drn $thickness=1e-09
+ $X=0.7926 $Y=0.0405 $X2=0.7955 $Y2=0.0405
r12 16 42 2.5483 $w=1.79e-08 $l=1.8e-08 $layer=M1 $thickness=3.6e-08 $X=0.837
+ $Y=0.234 $X2=0.837 $Y2=0.216
r13 16 18 4.06404 $w=1.48367e-08 $l=2.45e-08 $layer=M1 $thickness=3.6e-08
+ $X=0.837 $Y=0.234 $X2=0.8125 $Y2=0.234
r14 3 36 19.3796 $a=3.24e-16 $layer=V0LISD $X=0.81 $Y=0.0405 $X2=0.81 $Y2=0.0535
r15 41 42 6.7625 $w=1.3e-08 $l=2.9e-08 $layer=M1 $thickness=3.6e-08 $X=0.837
+ $Y=0.187 $X2=0.837 $Y2=0.216
r16 40 41 4.89699 $w=1.3e-08 $l=2.1e-08 $layer=M1 $thickness=3.6e-08 $X=0.837
+ $Y=0.166 $X2=0.837 $Y2=0.187
r17 39 40 3.14806 $w=1.3e-08 $l=1.35e-08 $layer=M1 $thickness=3.6e-08 $X=0.837
+ $Y=0.1525 $X2=0.837 $Y2=0.166
r18 38 39 5.01358 $w=1.3e-08 $l=2.15e-08 $layer=M1 $thickness=3.6e-08 $X=0.837
+ $Y=0.131 $X2=0.837 $Y2=0.1525
r19 37 38 4.5472 $w=1.3e-08 $l=1.95e-08 $layer=M1 $thickness=3.6e-08 $X=0.837
+ $Y=0.1115 $X2=0.837 $Y2=0.131
r20 20 34 1.15159 $w=1.75e-08 $l=1e-08 $layer=M1 $thickness=3.6e-08 $X=0.837
+ $Y=0.1 $X2=0.837 $Y2=0.09
r21 20 37 2.68168 $w=1.3e-08 $l=1.15e-08 $layer=M1 $thickness=3.6e-08 $X=0.837
+ $Y=0.1 $X2=0.837 $Y2=0.1115
r22 19 35 2.2153 $w=1.3e-08 $l=9.5e-09 $layer=M1 $thickness=3.6e-08 $X=0.81
+ $Y=0.0625 $X2=0.81 $Y2=0.072
r23 19 36 2.09871 $w=1.3e-08 $l=9e-09 $layer=M1 $thickness=3.6e-08 $X=0.81
+ $Y=0.0625 $X2=0.81 $Y2=0.0535
r24 33 34 1.96775 $w=1.63333e-08 $l=1.35e-08 $layer=M1 $thickness=3.6e-08
+ $X=0.8235 $Y=0.09 $X2=0.837 $Y2=0.09
r25 15 31 1.38478 $w=1.70909e-08 $l=1.1e-08 $layer=M1 $thickness=3.6e-08
+ $X=0.81 $Y=0.09 $X2=0.799 $Y2=0.09
r26 15 33 1.96775 $w=1.63333e-08 $l=1.35e-08 $layer=M1 $thickness=3.6e-08
+ $X=0.81 $Y=0.09 $X2=0.8235 $Y2=0.09
r27 15 35 3.01711 $w=1.55e-08 $l=1.8e-08 $layer=M1 $thickness=3.6e-08 $X=0.81
+ $Y=0.09 $X2=0.81 $Y2=0.072
r28 14 17 3.01711 $w=1.55e-08 $l=1.8e-08 $layer=M1 $thickness=3.6e-08 $X=0.729
+ $Y=0.09 $X2=0.747 $Y2=0.09
r29 30 31 5.24677 $w=1.3e-08 $l=2.25e-08 $layer=M1 $thickness=3.6e-08 $X=0.7765
+ $Y=0.09 $X2=0.799 $Y2=0.09
r30 17 30 6.8791 $w=1.3e-08 $l=2.95e-08 $layer=M1 $thickness=3.6e-08 $X=0.747
+ $Y=0.09 $X2=0.7765 $Y2=0.09
r31 17 29 19.3796 $a=3.24e-16 $layer=V0LIG $X=0.747 $Y=0.09 $X2=0.7475 $Y2=0.09
r32 27 29 5.15173 $w=1.56722e-08 $l=9e-09 $layer=LIG $thickness=4.8e-08
+ $X=0.7385 $Y=0.09 $X2=0.7475 $Y2=0.09
r33 1 27 2.6116 $w=2.2e-08 $l=1e-08 $layer=LIG $thickness=4.8e-08 $X=0.7285
+ $Y=0.09 $X2=0.7385 $Y2=0.09
r34 1 23 6.40962 $w=2.09268e-08 $l=5e-10 $layer=Gate_1 $thickness=5.22927e-08
+ $X=0.7285 $Y=0.09 $X2=0.729 $Y2=0.09
r35 25 24 24.1498 $w=2.1e-08 $l=7.1e-08 $layer=Gate_1 $thickness=5.6e-08
+ $X=0.729 $Y=0.2295 $X2=0.729 $Y2=0.1585
r36 23 24 23.4865 $w=2.08394e-08 $l=6.85e-08 $layer=Gate_1 $thickness=5.6e-08
+ $X=0.729 $Y=0.09 $X2=0.729 $Y2=0.1585
r37 23 27 4.05918 $w=2.0087e-08 $l=9.5e-09 $layer=Gate_1 $thickness=5.56522e-08
+ $X=0.729 $Y=0.09 $X2=0.7385 $Y2=0.09
r38 22 23 8.18032 $w=2.05319e-08 $l=2.35e-08 $layer=Gate_1 $thickness=5.6e-08
+ $X=0.729 $Y=0.0665 $X2=0.729 $Y2=0.09
r39 21 22 8.84359 $w=2.1e-08 $l=2.6e-08 $layer=Gate_1 $thickness=5.6e-08
+ $X=0.729 $Y=0.0405 $X2=0.729 $Y2=0.0665
r40 21 10 5.44221 $w=2.1e-08 $l=1.6e-08 $layer=Gate_1 $thickness=5.6e-08
+ $X=0.729 $Y=0.0405 $X2=0.729 $Y2=0.0245
.ends

.subckt PM_SDFLx1_ASAP7_75t_R%SE vss 41 16 22 51 55 13 12 9 11 1 6 2 5 10 7 8
c1 1 vss 0.00486367f $X=0.297 $Y=0.135
c2 2 vss 0.00396541f $X=1.215 $Y=0.136
c3 5 vss 0.0859955f $X=0.297 $Y=0.135
c4 6 vss 0.0854711f $X=1.215 $Y=0.0245
c5 7 vss 0.00795417f $X=0.225 $Y=0.036
c6 8 vss 0.00160575f $X=0.225 $Y=0.1297
c7 9 vss 0.00650281f $X=1.215 $Y=0.036
c8 10 vss 0.0043924f $X=0.225 $Y=0.0495
c9 11 vss 0.00386296f $X=0.2445 $Y=0.135
c10 12 vss 0.00345177f $X=1.215 $Y=0.0495
c11 13 vss 0.0566707f $X=1.1905 $Y=0.045
r1 55 54 14.6259 $w=2.1e-08 $l=4.3e-08 $layer=Gate_1 $thickness=5.6e-08
+ $X=0.297 $Y=0.2025 $X2=0.297 $Y2=0.1595
r2 53 54 2.7211 $w=2.1e-08 $l=8e-09 $layer=Gate_1 $thickness=5.6e-08 $X=0.297
+ $Y=0.1515 $X2=0.297 $Y2=0.1595
r3 51 52 14.6259 $w=2.1e-08 $l=4.3e-08 $layer=Gate_1 $thickness=5.6e-08
+ $X=0.297 $Y=0.0675 $X2=0.297 $Y2=0.1105
r4 49 52 2.7211 $w=2.1e-08 $l=8e-09 $layer=Gate_1 $thickness=5.6e-08 $X=0.297
+ $Y=0.1185 $X2=0.297 $Y2=0.1105
r5 5 49 5.79936 $w=2.03333e-08 $l=1.65e-08 $layer=Gate_1 $thickness=5.6e-08
+ $X=0.297 $Y=0.135 $X2=0.297 $Y2=0.1185
r6 5 53 5.79936 $w=2.03333e-08 $l=1.65e-08 $layer=Gate_1 $thickness=5.6e-08
+ $X=0.297 $Y=0.135 $X2=0.297 $Y2=0.1515
r7 1 46 19.3796 $a=3.24e-16 $layer=V0LIG $X=0.297 $Y=0.135 $X2=0.297 $Y2=0.135
r8 1 5 10.4265 $w=1.765e-08 $layer=LIG $thickness=5.2e-08 $X=0.297 $Y=0.135
+ $X2=0.297 $Y2=0.135
r9 45 46 5.24677 $w=1.3e-08 $l=2.25e-08 $layer=M1 $thickness=3.6e-08 $X=0.2745
+ $Y=0.135 $X2=0.297 $Y2=0.135
r10 44 45 3.49785 $w=1.3e-08 $l=1.5e-08 $layer=M1 $thickness=3.6e-08 $X=0.2595
+ $Y=0.135 $X2=0.2745 $Y2=0.135
r11 43 44 0.699569 $w=1.3e-08 $l=3e-09 $layer=M1 $thickness=3.6e-08 $X=0.2565
+ $Y=0.135 $X2=0.2595 $Y2=0.135
r12 41 11 2.49951 $w=7.46154e-09 $l=1.95256e-08 $layer=M1 $thickness=3.6e-08
+ $X=0.227 $Y=0.134 $X2=0.2445 $Y2=0.135
r13 11 43 2.79828 $w=1.3e-08 $l=1.2e-08 $layer=M1 $thickness=3.6e-08 $X=0.2445
+ $Y=0.135 $X2=0.2565 $Y2=0.135
r14 41 8 0.433689 $w=1.8e-08 $l=4.3e-09 $layer=M1 $thickness=3.6e-08 $X=0.227
+ $Y=0.134 $X2=0.225 $Y2=0.1297
r15 8 40 3.53073 $w=1.4087e-08 $l=1.72e-08 $layer=M1 $thickness=3.6e-08
+ $X=0.225 $Y=0.1297 $X2=0.225 $Y2=0.1125
r16 39 40 5.24677 $w=1.3e-08 $l=2.25e-08 $layer=M1 $thickness=3.6e-08 $X=0.225
+ $Y=0.09 $X2=0.225 $Y2=0.1125
r17 38 39 5.24677 $w=1.3e-08 $l=2.25e-08 $layer=M1 $thickness=3.6e-08 $X=0.225
+ $Y=0.0675 $X2=0.225 $Y2=0.09
r18 10 38 4.19742 $w=1.3e-08 $l=1.8e-08 $layer=M1 $thickness=3.6e-08 $X=0.225
+ $Y=0.0495 $X2=0.225 $Y2=0.0675
r19 10 35 39.0693 $a=1.62e-16 $layer=V1 $X=0.225 $Y=0.0495 $X2=0.225 $Y2=0.045
r20 7 35 39.0693 $a=1.62e-16 $layer=V1 $X=0.225 $Y=0.036 $X2=0.225 $Y2=0.045
r21 7 10 1.96775 $w=1.63333e-08 $l=1.35e-08 $layer=M1 $thickness=3.6e-08
+ $X=0.225 $Y=0.036 $X2=0.225 $Y2=0.0495
r22 35 36 14.108 $w=1.3e-08 $l=6.05e-08 $layer=M2 $thickness=3.6e-08 $X=0.225
+ $Y=0.045 $X2=0.2855 $Y2=0.045
r23 33 36 109.716 $w=1.3e-08 $l=4.705e-07 $layer=M2 $thickness=3.6e-08 $X=0.756
+ $Y=0.045 $X2=0.2855 $Y2=0.045
r24 13 31 5.71315 $w=1.3e-08 $l=2.45e-08 $layer=M2 $thickness=3.6e-08 $X=1.1905
+ $Y=0.045 $X2=1.215 $Y2=0.045
r25 13 33 101.321 $w=1.3e-08 $l=4.345e-07 $layer=M2 $thickness=3.6e-08
+ $X=1.1905 $Y=0.045 $X2=0.756 $Y2=0.045
r26 9 12 1.96775 $w=1.63333e-08 $l=1.35e-08 $layer=M1 $thickness=3.6e-08
+ $X=1.215 $Y=0.036 $X2=1.215 $Y2=0.0495
r27 9 31 39.0693 $a=1.62e-16 $layer=V1 $X=1.215 $Y=0.036 $X2=1.215 $Y2=0.045
r28 27 28 6.41272 $w=1.3e-08 $l=2.75e-08 $layer=M1 $thickness=3.6e-08 $X=1.215
+ $Y=0.1085 $X2=1.215 $Y2=0.136
r29 26 27 8.51143 $w=1.3e-08 $l=3.65e-08 $layer=M1 $thickness=3.6e-08 $X=1.215
+ $Y=0.072 $X2=1.215 $Y2=0.1085
r30 12 26 5.24677 $w=1.3e-08 $l=2.25e-08 $layer=M1 $thickness=3.6e-08 $X=1.215
+ $Y=0.0495 $X2=1.215 $Y2=0.072
r31 12 31 39.0693 $a=1.62e-16 $layer=V1 $X=1.215 $Y=0.0495 $X2=1.215 $Y2=0.045
r32 2 19 6.54019 $w=2.09524e-08 $layer=Gate_1 $thickness=5.21905e-08 $X=1.215
+ $Y=0.136 $X2=1.215 $Y2=0.136
r33 2 28 19.3796 $a=3.24e-16 $layer=V0LIG $X=1.215 $Y=0.136 $X2=1.215 $Y2=0.136
r34 22 21 14.6259 $w=2.1e-08 $l=4.3e-08 $layer=Gate_1 $thickness=5.6e-08
+ $X=1.215 $Y=0.2025 $X2=1.215 $Y2=0.1595
r35 20 21 2.55104 $w=2.1e-08 $l=7.5e-09 $layer=Gate_1 $thickness=5.6e-08
+ $X=1.215 $Y=0.152 $X2=1.215 $Y2=0.1595
r36 19 20 5.62929 $w=2.03125e-08 $l=1.6e-08 $layer=Gate_1 $thickness=5.6e-08
+ $X=1.215 $Y=0.136 $X2=1.215 $Y2=0.152
r37 18 19 5.96942 $w=2.03529e-08 $l=1.7e-08 $layer=Gate_1 $thickness=5.6e-08
+ $X=1.215 $Y=0.119 $X2=1.215 $Y2=0.136
r38 17 18 2.89117 $w=2.1e-08 $l=8.5e-09 $layer=Gate_1 $thickness=5.6e-08
+ $X=1.215 $Y=0.1105 $X2=1.215 $Y2=0.119
r39 16 17 14.6259 $w=2.1e-08 $l=4.3e-08 $layer=Gate_1 $thickness=5.6e-08
+ $X=1.215 $Y=0.0675 $X2=1.215 $Y2=0.1105
r40 16 6 14.6259 $w=2.1e-08 $l=4.3e-08 $layer=Gate_1 $thickness=5.6e-08
+ $X=1.215 $Y=0.0675 $X2=1.215 $Y2=0.0245
.ends

.subckt PM_SDFLx1_ASAP7_75t_R%13 vss 28 34 71 75 79 80 83 84 14 17 6 13 22 20
+ 21 5 16 2 19 25 12 24 18 1 23 15 11
c1 1 vss 0.00160451f $X=1.053 $Y=0.14
c2 2 vss 0.00360355f $X=1.269 $Y=0.136
c3 5 vss 0.00472477f $X=0.864 $Y=0.0405
c4 6 vss 0.00456345f $X=0.918 $Y=0.2295
c5 11 vss 0.0535597f $X=1.053 $Y=0.0245
c6 12 vss 0.0836629f $X=1.269 $Y=0.136
c7 13 vss 0.00313752f $X=0.8495 $Y=0.0405
c8 14 vss 0.00337059f $X=0.9035 $Y=0.2295
c9 15 vss 0.00605288f $X=0.945 $Y=0.234
c10 16 vss 0.00232558f $X=0.945 $Y=0.036
c11 17 vss 0.000198759f $X=0.945 $Y=0.1575
c12 18 vss 0.000364563f $X=1.053 $Y=0.162
c13 19 vss 0.00699577f $X=0.92 $Y=0.036
c14 20 vss 0.000567659f $X=0.945 $Y=0.1315
c15 21 vss 0.00127097f $X=0.945 $Y=0.198
c16 22 vss 0.00136345f $X=1.026 $Y=0.162
c17 23 vss 0.000273018f $X=1.053 $Y=0.125
c18 24 vss 0.0033318f $X=1.269 $Y=0.1085
c19 25 vss 0.00954133f $X=0.945 $Y=0.153
r1 84 82 0.0925926 $w=2.7e-08 $l=2.5e-09 $layer=N_src_drn $thickness=1e-09
+ $X=0.8813 $Y=0.0405 $X2=0.8785 $Y2=0.0405
r2 5 82 0.537037 $w=2.7e-08 $l=1.45e-08 $layer=N_src_drn $thickness=1e-09
+ $X=0.864 $Y=0.0405 $X2=0.8785 $Y2=0.0405
r3 13 5 0.537037 $w=2.7e-08 $l=1.45e-08 $layer=N_src_drn $thickness=1e-09
+ $X=0.8495 $Y=0.0405 $X2=0.864 $Y2=0.0405
r4 83 13 0.0925926 $w=2.7e-08 $l=2.5e-09 $layer=N_src_drn $thickness=1e-09
+ $X=0.8466 $Y=0.0405 $X2=0.8495 $Y2=0.0405
r5 80 78 0.0925926 $w=2.7e-08 $l=2.5e-09 $layer=P_src_drn $thickness=1e-09
+ $X=0.9353 $Y=0.2295 $X2=0.9325 $Y2=0.2295
r6 6 78 0.537037 $w=2.7e-08 $l=1.45e-08 $layer=P_src_drn $thickness=1e-09
+ $X=0.918 $Y=0.2295 $X2=0.9325 $Y2=0.2295
r7 14 6 0.537037 $w=2.7e-08 $l=1.45e-08 $layer=P_src_drn $thickness=1e-09
+ $X=0.9035 $Y=0.2295 $X2=0.918 $Y2=0.2295
r8 79 14 0.0925926 $w=2.7e-08 $l=2.5e-09 $layer=P_src_drn $thickness=1e-09
+ $X=0.9006 $Y=0.2295 $X2=0.9035 $Y2=0.2295
r9 75 74 14.6259 $w=2.1e-08 $l=4.3e-08 $layer=Gate_1 $thickness=5.6e-08
+ $X=1.269 $Y=0.2025 $X2=1.269 $Y2=0.1595
r10 73 74 2.55104 $w=2.1e-08 $l=7.5e-09 $layer=Gate_1 $thickness=5.6e-08
+ $X=1.269 $Y=0.152 $X2=1.269 $Y2=0.1595
r11 71 72 14.6259 $w=2.1e-08 $l=4.3e-08 $layer=Gate_1 $thickness=5.6e-08
+ $X=1.269 $Y=0.0675 $X2=1.269 $Y2=0.1105
r12 69 72 2.89117 $w=2.1e-08 $l=8.5e-09 $layer=Gate_1 $thickness=5.6e-08
+ $X=1.269 $Y=0.119 $X2=1.269 $Y2=0.1105
r13 12 69 5.96942 $w=2.03529e-08 $l=1.7e-08 $layer=Gate_1 $thickness=5.6e-08
+ $X=1.269 $Y=0.136 $X2=1.269 $Y2=0.119
r14 12 73 5.62929 $w=2.03125e-08 $l=1.6e-08 $layer=Gate_1 $thickness=5.6e-08
+ $X=1.269 $Y=0.136 $X2=1.269 $Y2=0.152
r15 5 63 19.3796 $a=3.24e-16 $layer=V0LISD $X=0.864 $Y=0.0405 $X2=0.864
+ $Y2=0.036
r16 6 58 19.3796 $a=3.24e-16 $layer=V0LISD $X=0.918 $Y=0.2295 $X2=0.918
+ $Y2=0.234
r17 2 55 19.3796 $a=3.24e-16 $layer=V0LIG $X=1.269 $Y=0.136 $X2=1.269 $Y2=0.1445
r18 2 12 6.54019 $w=2.09524e-08 $layer=Gate_1 $thickness=5.21905e-08 $X=1.269
+ $Y=0.136 $X2=1.269 $Y2=0.136
r19 63 64 3.14806 $w=1.3e-08 $l=1.35e-08 $layer=M1 $thickness=3.6e-08 $X=0.864
+ $Y=0.036 $X2=0.8775 $Y2=0.036
r20 61 64 3.14806 $w=1.3e-08 $l=1.35e-08 $layer=M1 $thickness=3.6e-08 $X=0.891
+ $Y=0.036 $X2=0.8775 $Y2=0.036
r21 60 61 2.56509 $w=1.3e-08 $l=1.1e-08 $layer=M1 $thickness=3.6e-08 $X=0.902
+ $Y=0.036 $X2=0.891 $Y2=0.036
r22 19 60 4.19742 $w=1.3e-08 $l=1.8e-08 $layer=M1 $thickness=3.6e-08 $X=0.92
+ $Y=0.036 $X2=0.902 $Y2=0.036
r23 58 59 3.14806 $w=1.3e-08 $l=1.35e-08 $layer=M1 $thickness=3.6e-08 $X=0.918
+ $Y=0.234 $X2=0.9315 $Y2=0.234
r24 15 21 7.21452 $w=1.425e-08 $l=3.6e-08 $layer=M1 $thickness=3.6e-08 $X=0.945
+ $Y=0.234 $X2=0.945 $Y2=0.198
r25 15 59 1.96775 $w=1.63333e-08 $l=1.35e-08 $layer=M1 $thickness=3.6e-08
+ $X=0.945 $Y=0.234 $X2=0.9315 $Y2=0.234
r26 24 55 8.39483 $w=1.3e-08 $l=3.6e-08 $layer=M1 $thickness=3.6e-08 $X=1.269
+ $Y=0.1085 $X2=1.269 $Y2=0.1445
r27 16 49 4.64701 $w=1.62667e-08 $l=2.7e-08 $layer=M1 $thickness=3.6e-08
+ $X=0.945 $Y=0.036 $X2=0.945 $Y2=0.063
r28 16 19 4.18063 $w=1.48e-08 $l=2.5e-08 $layer=M1 $thickness=3.6e-08 $X=0.945
+ $Y=0.036 $X2=0.92 $Y2=0.036
r29 21 44 6.50021 $w=1.33448e-08 $l=2.9e-08 $layer=M1 $thickness=3.6e-08
+ $X=0.945 $Y=0.198 $X2=0.945 $Y2=0.169
r30 53 55 19.5347 $a=3.24e-16 $layer=V1 $X=1.269 $Y=0.153 $X2=1.269 $Y2=0.1445
r31 52 53 5.71315 $w=1.3e-08 $l=2.45e-08 $layer=M2 $thickness=3.6e-08 $X=1.2445
+ $Y=0.153 $X2=1.269 $Y2=0.153
r32 51 52 9.91056 $w=1.3e-08 $l=4.25e-08 $layer=M2 $thickness=3.6e-08 $X=1.202
+ $Y=0.153 $X2=1.2445 $Y2=0.153
r33 50 51 32.0636 $w=1.3e-08 $l=1.375e-07 $layer=M2 $thickness=3.6e-08
+ $X=1.0645 $Y=0.153 $X2=1.202 $Y2=0.153
r34 25 50 27.8662 $w=1.3e-08 $l=1.195e-07 $layer=M2 $thickness=3.6e-08 $X=0.945
+ $Y=0.153 $X2=1.0645 $Y2=0.153
r35 25 45 39.0693 $a=1.62e-16 $layer=V1 $X=0.945 $Y=0.153 $X2=0.945 $Y2=0.1485
r36 48 49 6.29612 $w=1.3e-08 $l=2.7e-08 $layer=M1 $thickness=3.6e-08 $X=0.945
+ $Y=0.09 $X2=0.945 $Y2=0.063
r37 47 48 2.3319 $w=1.3e-08 $l=1e-08 $layer=M1 $thickness=3.6e-08 $X=0.945
+ $Y=0.1 $X2=0.945 $Y2=0.09
r38 46 47 2.3319 $w=1.3e-08 $l=1e-08 $layer=M1 $thickness=3.6e-08 $X=0.945
+ $Y=0.11 $X2=0.945 $Y2=0.1
r39 20 45 3.96423 $w=1.3e-08 $l=1.7e-08 $layer=M1 $thickness=3.6e-08 $X=0.945
+ $Y=0.1315 $X2=0.945 $Y2=0.1485
r40 20 46 5.01358 $w=1.3e-08 $l=2.15e-08 $layer=M1 $thickness=3.6e-08 $X=0.945
+ $Y=0.1315 $X2=0.945 $Y2=0.11
r41 43 44 0.4592 $w=1.8e-08 $l=4.5e-09 $layer=M1 $thickness=3.6e-08 $X=0.945
+ $Y=0.1645 $X2=0.945 $Y2=0.169
r42 17 43 0.714311 $w=1.8e-08 $l=7e-09 $layer=M1 $thickness=3.6e-08 $X=0.945
+ $Y=0.1575 $X2=0.945 $Y2=0.1645
r43 17 45 1.50855 $w=1.55e-08 $l=9e-09 $layer=M1 $thickness=3.6e-08 $X=0.945
+ $Y=0.1575 $X2=0.945 $Y2=0.1485
r44 17 25 39.0693 $a=1.62e-16 $layer=V1 $X=0.945 $Y=0.1575 $X2=0.945 $Y2=0.153
r45 42 44 4.4015 $w=1.35e-08 $l=2.78927e-08 $layer=M1 $thickness=3.6e-08
+ $X=0.972 $Y=0.162 $X2=0.945 $Y2=0.169
r46 41 42 6.29612 $w=1.3e-08 $l=2.7e-08 $layer=M1 $thickness=3.6e-08 $X=0.999
+ $Y=0.162 $X2=0.972 $Y2=0.162
r47 22 41 6.29612 $w=1.3e-08 $l=2.7e-08 $layer=M1 $thickness=3.6e-08 $X=1.026
+ $Y=0.162 $X2=0.999 $Y2=0.162
r48 18 39 0.915974 $w=2.10182e-08 $l=1.1e-08 $layer=M1 $thickness=3.6e-08
+ $X=1.053 $Y=0.162 $X2=1.053 $Y2=0.151
r49 18 22 4.64701 $w=1.46667e-08 $l=2.7e-08 $layer=M1 $thickness=3.6e-08
+ $X=1.053 $Y=0.162 $X2=1.026 $Y2=0.162
r50 38 39 2.56509 $w=1.3e-08 $l=1.1e-08 $layer=M1 $thickness=3.6e-08 $X=1.053
+ $Y=0.14 $X2=1.053 $Y2=0.151
r51 23 38 3.49785 $w=1.3e-08 $l=1.5e-08 $layer=M1 $thickness=3.6e-08 $X=1.053
+ $Y=0.125 $X2=1.053 $Y2=0.14
r52 1 31 6.54019 $w=2.09524e-08 $layer=Gate_1 $thickness=5.21905e-08 $X=1.053
+ $Y=0.14 $X2=1.053 $Y2=0.14
r53 1 38 19.3796 $a=3.24e-16 $layer=V0LIG $X=1.053 $Y=0.14 $X2=1.053 $Y2=0.14
r54 34 33 14.6259 $w=2.1e-08 $l=4.3e-08 $layer=Gate_1 $thickness=5.6e-08
+ $X=1.053 $Y=0.2295 $X2=1.053 $Y2=0.1865
r55 32 33 11.0545 $w=2.1e-08 $l=3.25e-08 $layer=Gate_1 $thickness=5.6e-08
+ $X=1.053 $Y=0.154 $X2=1.053 $Y2=0.1865
r56 31 32 4.94901 $w=2.02143e-08 $l=1.4e-08 $layer=Gate_1 $thickness=5.6e-08
+ $X=1.053 $Y=0.14 $X2=1.053 $Y2=0.154
r57 30 31 6.6497 $w=2.04211e-08 $l=1.9e-08 $layer=Gate_1 $thickness=5.6e-08
+ $X=1.053 $Y=0.121 $X2=1.053 $Y2=0.14
r58 29 30 12.7552 $w=2.1e-08 $l=3.75e-08 $layer=Gate_1 $thickness=5.6e-08
+ $X=1.053 $Y=0.0835 $X2=1.053 $Y2=0.121
r59 28 29 14.6259 $w=2.1e-08 $l=4.3e-08 $layer=Gate_1 $thickness=5.6e-08
+ $X=1.053 $Y=0.0405 $X2=1.053 $Y2=0.0835
r60 28 11 5.44221 $w=2.1e-08 $l=1.6e-08 $layer=Gate_1 $thickness=5.6e-08
+ $X=1.053 $Y=0.0405 $X2=1.053 $Y2=0.0245
.ends

.subckt PM_SDFLx1_ASAP7_75t_R%QN vss 19 13 25 9 7 1 2 8 11
c1 1 vss 0.00849686f $X=1.296 $Y=0.0675
c2 2 vss 0.00850111f $X=1.296 $Y=0.2025
c3 7 vss 0.0385041f $X=1.2815 $Y=0.0675
c4 8 vss 0.0385016f $X=1.2815 $Y=0.2025
c5 9 vss 0.00572385f $X=1.2845 $Y=0.036
c6 10 vss 0.00606076f $X=1.323 $Y=0.234
c7 11 vss 0.00508239f $X=1.323 $Y=0.0675
r1 8 2 0.154321 $w=8.1e-08 $l=1.25e-08 $layer=P_src_drn $thickness=1e-09
+ $X=1.2815 $Y=0.2025 $X2=1.296 $Y2=0.2025
r2 25 8 0.0308642 $w=8.1e-08 $l=2.5e-09 $layer=P_src_drn $thickness=1e-09
+ $X=1.2786 $Y=0.2025 $X2=1.2815 $Y2=0.2025
r3 2 22 19.3796 $a=3.24e-16 $layer=V0LISD $X=1.296 $Y=0.2025 $X2=1.296 $Y2=0.234
r4 22 23 3.14806 $w=1.3e-08 $l=1.35e-08 $layer=M1 $thickness=3.6e-08 $X=1.296
+ $Y=0.234 $X2=1.3095 $Y2=0.234
r5 10 20 1.09329 $w=1.76154e-08 $l=9.8e-09 $layer=M1 $thickness=3.6e-08
+ $X=1.323 $Y=0.234 $X2=1.323 $Y2=0.2242
r6 10 23 1.96775 $w=1.63333e-08 $l=1.35e-08 $layer=M1 $thickness=3.6e-08
+ $X=1.323 $Y=0.234 $X2=1.3095 $Y2=0.234
r7 19 20 0.291487 $w=1.3e-08 $l=1.2e-09 $layer=M1 $thickness=3.6e-08 $X=1.32
+ $Y=0.223 $X2=1.323 $Y2=0.2242
r8 19 18 2.73998 $w=1.3e-08 $l=1.18e-08 $layer=M1 $thickness=3.6e-08 $X=1.32
+ $Y=0.223 $X2=1.323 $Y2=0.2112
r9 17 18 15.4488 $w=1.3e-08 $l=6.62e-08 $layer=M1 $thickness=3.6e-08 $X=1.323
+ $Y=0.145 $X2=1.323 $Y2=0.2112
r10 11 16 6.16517 $w=1.44286e-08 $l=3.15e-08 $layer=M1 $thickness=3.6e-08
+ $X=1.323 $Y=0.0675 $X2=1.323 $Y2=0.036
r11 11 17 18.0722 $w=1.3e-08 $l=7.75e-08 $layer=M1 $thickness=3.6e-08 $X=1.323
+ $Y=0.0675 $X2=1.323 $Y2=0.145
r12 15 16 1.96775 $w=1.63333e-08 $l=1.35e-08 $layer=M1 $thickness=3.6e-08
+ $X=1.3095 $Y=0.036 $X2=1.323 $Y2=0.036
r13 14 15 3.14806 $w=1.3e-08 $l=1.35e-08 $layer=M1 $thickness=3.6e-08 $X=1.296
+ $Y=0.036 $X2=1.3095 $Y2=0.036
r14 9 14 2.68168 $w=1.3e-08 $l=1.15e-08 $layer=M1 $thickness=3.6e-08 $X=1.2845
+ $Y=0.036 $X2=1.296 $Y2=0.036
r15 1 14 19.3796 $a=3.24e-16 $layer=V0LISD $X=1.296 $Y=0.0675 $X2=1.296
+ $Y2=0.036
r16 7 1 0.154321 $w=8.1e-08 $l=1.25e-08 $layer=N_src_drn $thickness=1e-09
+ $X=1.2815 $Y=0.0675 $X2=1.296 $Y2=0.0675
r17 13 7 0.0308642 $w=8.1e-08 $l=2.5e-09 $layer=N_src_drn $thickness=1e-09
+ $X=1.2786 $Y=0.0675 $X2=1.2815 $Y2=0.0675
.ends

.subckt PM_SDFLx1_ASAP7_75t_R%4 vss 40 69 74 100 104 108 117 119 23 26 31 24 8
+ 21 22 9 1 35 30 32 28 16 27 2 33 4 5 34 10 3 17 20 18 19
c1 1 vss 0.00239619f $X=0.135 $Y=0.135
c2 2 vss 0.0034959f $X=0.567 $Y=0.1355
c3 3 vss 9.16479e-20 $X=0.675 $Y=0.178
c4 4 vss 4.38487e-20 $X=0.837 $Y=0.178
c5 5 vss 0.000755459f $X=0.945 $Y=0.178
c6 8 vss 0.00818255f $X=0.054 $Y=0.054
c7 9 vss 0.00830317f $X=0.054 $Y=0.216
c8 10 vss 0.0052359f $X=0.837 $Y=0.178
c9 16 vss 0.0710036f $X=0.135 $Y=0.135
c10 17 vss 0.0588292f $X=0.567 $Y=0.1355
c11 18 vss 0.00684001f $X=0.675 $Y=0.178
c12 19 vss 0.00636341f $X=0.837 $Y=0.0245
c13 20 vss 0.00761426f $X=0.945 $Y=0.178
c14 21 vss 0.0321407f $X=0.056 $Y=0.054
c15 22 vss 0.0321439f $X=0.056 $Y=0.216
c16 23 vss 0.00401044f $X=0.018 $Y=0.036
c17 24 vss 0.00272964f $X=0.0165 $Y=0.189
c18 25 vss 0.00397351f $X=0.018 $Y=0.234
c19 26 vss 0.00155881f $X=0.135 $Y=0.198
c20 27 vss 0.00119818f $X=0.567 $Y=0.198
c21 28 vss 0.0107568f $X=0.018 $Y=0.172
c22 29 vss 0.00226164f $X=0.018 $Y=0.2025
c23 30 vss 0.0048563f $X=0.036 $Y=0.036
c24 31 vss 0.00472021f $X=0.036 $Y=0.234
c25 32 vss 0.00130059f $X=0.135 $Y=0.1845
c26 33 vss 0.00495631f $X=0.567 $Y=0.1755
c27 34 vss 0.00141133f $X=0.729 $Y=0.168
c28 35 vss 0.0374237f $X=0.3665 $Y=0.189
r1 119 118 0.0462963 $w=5.4e-08 $l=2.5e-09 $layer=P_src_drn $thickness=1e-09
+ $X=0.0713 $Y=0.216 $X2=0.0685 $Y2=0.216
r2 22 118 0.231482 $w=5.4e-08 $l=1.25e-08 $layer=P_src_drn $thickness=1e-09
+ $X=0.056 $Y=0.216 $X2=0.0685 $Y2=0.216
r3 117 116 0.0462963 $w=5.4e-08 $l=2.5e-09 $layer=N_src_drn $thickness=1e-09
+ $X=0.0713 $Y=0.054 $X2=0.0685 $Y2=0.054
r4 21 116 0.231482 $w=5.4e-08 $l=1.25e-08 $layer=N_src_drn $thickness=1e-09
+ $X=0.056 $Y=0.054 $X2=0.0685 $Y2=0.054
r5 9 114 19.3796 $a=3.24e-16 $layer=V0LISD $X=0.054 $Y=0.216 $X2=0.055 $Y2=0.234
r6 8 111 19.3796 $a=3.24e-16 $layer=V0LISD $X=0.054 $Y=0.054 $X2=0.055 $Y2=0.036
r7 113 114 2.09871 $w=1.3e-08 $l=9e-09 $layer=M1 $thickness=3.6e-08 $X=0.046
+ $Y=0.234 $X2=0.055 $Y2=0.234
r8 31 113 2.3319 $w=1.3e-08 $l=1e-08 $layer=M1 $thickness=3.6e-08 $X=0.036
+ $Y=0.234 $X2=0.046 $Y2=0.234
r9 110 111 2.09871 $w=1.3e-08 $l=9e-09 $layer=M1 $thickness=3.6e-08 $X=0.046
+ $Y=0.036 $X2=0.055 $Y2=0.036
r10 30 110 2.3319 $w=1.3e-08 $l=1e-08 $layer=M1 $thickness=3.6e-08 $X=0.036
+ $Y=0.036 $X2=0.046 $Y2=0.036
r11 108 107 14.6259 $w=2.1e-08 $l=4.3e-08 $layer=Gate_1 $thickness=5.6e-08
+ $X=0.135 $Y=0.216 $X2=0.135 $Y2=0.173
r12 106 107 7.31297 $w=2.1e-08 $l=2.15e-08 $layer=Gate_1 $thickness=5.6e-08
+ $X=0.135 $Y=0.1515 $X2=0.135 $Y2=0.173
r13 104 105 14.6259 $w=2.1e-08 $l=4.3e-08 $layer=Gate_1 $thickness=5.6e-08
+ $X=0.135 $Y=0.054 $X2=0.135 $Y2=0.097
r14 102 105 7.31297 $w=2.1e-08 $l=2.15e-08 $layer=Gate_1 $thickness=5.6e-08
+ $X=0.135 $Y=0.1185 $X2=0.135 $Y2=0.097
r15 16 102 5.79936 $w=2.03333e-08 $l=1.65e-08 $layer=Gate_1 $thickness=5.6e-08
+ $X=0.135 $Y=0.135 $X2=0.135 $Y2=0.1185
r16 16 106 5.79936 $w=2.03333e-08 $l=1.65e-08 $layer=Gate_1 $thickness=5.6e-08
+ $X=0.135 $Y=0.135 $X2=0.135 $Y2=0.1515
r17 25 97 2.5483 $w=1.79e-08 $l=1.8e-08 $layer=M1 $thickness=3.6e-08 $X=0.018
+ $Y=0.234 $X2=0.018 $Y2=0.216
r18 25 31 2.5483 $w=1.55e-08 $l=1.8e-08 $layer=M1 $thickness=3.6e-08 $X=0.018
+ $Y=0.234 $X2=0.036 $Y2=0.234
r19 23 96 4.64701 $w=1.62667e-08 $l=2.7e-08 $layer=M1 $thickness=3.6e-08
+ $X=0.018 $Y=0.036 $X2=0.018 $Y2=0.063
r20 23 30 2.5483 $w=1.55e-08 $l=1.8e-08 $layer=M1 $thickness=3.6e-08 $X=0.018
+ $Y=0.036 $X2=0.036 $Y2=0.036
r21 100 99 16.4967 $w=2.1e-08 $l=4.85e-08 $layer=Gate_1 $thickness=5.6e-08
+ $X=0.567 $Y=0.2025 $X2=0.567 $Y2=0.154
r22 17 99 6.47113 $w=2.04324e-08 $l=1.85e-08 $layer=Gate_1 $thickness=5.6e-08
+ $X=0.567 $Y=0.1355 $X2=0.567 $Y2=0.154
r23 1 90 19.3796 $a=3.24e-16 $layer=V0LIG $X=0.135 $Y=0.135 $X2=0.135 $Y2=0.135
r24 1 16 10.4265 $w=1.765e-08 $layer=LIG $thickness=5.2e-08 $X=0.135 $Y=0.135
+ $X2=0.135 $Y2=0.135
r25 29 97 3.14806 $w=1.3e-08 $l=1.35e-08 $layer=M1 $thickness=3.6e-08 $X=0.018
+ $Y=0.2025 $X2=0.018 $Y2=0.216
r26 95 96 6.29612 $w=1.3e-08 $l=2.7e-08 $layer=M1 $thickness=3.6e-08 $X=0.018
+ $Y=0.09 $X2=0.018 $Y2=0.063
r27 94 95 9.67737 $w=1.3e-08 $l=4.15e-08 $layer=M1 $thickness=3.6e-08 $X=0.018
+ $Y=0.1315 $X2=0.018 $Y2=0.09
r28 28 94 9.44419 $w=1.3e-08 $l=4.05e-08 $layer=M1 $thickness=3.6e-08 $X=0.018
+ $Y=0.172 $X2=0.018 $Y2=0.1315
r29 2 81 19.3796 $a=3.24e-16 $layer=V0LIG $X=0.567 $Y=0.1355 $X2=0.567 $Y2=0.135
r30 2 17 6.63025 $w=2.04878e-08 $layer=Gate_1 $thickness=5.20976e-08 $X=0.567
+ $Y=0.1355 $X2=0.567 $Y2=0.1355
r31 90 91 4.43061 $w=1.3e-08 $l=1.9e-08 $layer=M1 $thickness=3.6e-08 $X=0.135
+ $Y=0.135 $X2=0.135 $Y2=0.154
r32 88 91 4.19742 $w=1.3e-08 $l=1.8e-08 $layer=M1 $thickness=3.6e-08 $X=0.135
+ $Y=0.172 $X2=0.135 $Y2=0.154
r33 32 66 39.0693 $a=1.62e-16 $layer=V1 $X=0.135 $Y=0.1845 $X2=0.135 $Y2=0.189
r34 32 88 2.91487 $w=1.3e-08 $l=1.25e-08 $layer=M1 $thickness=3.6e-08 $X=0.135
+ $Y=0.1845 $X2=0.135 $Y2=0.172
r35 26 66 39.0693 $a=1.62e-16 $layer=V1 $X=0.135 $Y=0.198 $X2=0.135 $Y2=0.189
r36 26 32 1.96775 $w=1.63333e-08 $l=1.35e-08 $layer=M1 $thickness=3.6e-08
+ $X=0.135 $Y=0.198 $X2=0.135 $Y2=0.1845
r37 83 84 1.90199 $w=1.38333e-08 $l=9e-09 $layer=M1 $thickness=3.6e-08
+ $X=0.0255 $Y=0.189 $X2=0.0345 $Y2=0.189
r38 24 83 0.9184 $w=1.8e-08 $l=9e-09 $layer=M1 $thickness=3.6e-08 $X=0.0165
+ $Y=0.189 $X2=0.0255 $Y2=0.189
r39 24 28 2.63085 $w=1.54194e-08 $l=1.7066e-08 $layer=M1 $thickness=3.6e-08
+ $X=0.0165 $Y=0.189 $X2=0.018 $Y2=0.172
r40 24 29 1.81469 $w=1.6125e-08 $l=1.35831e-08 $layer=M1 $thickness=3.6e-08
+ $X=0.0165 $Y=0.189 $X2=0.018 $Y2=0.2025
r41 81 82 3.14806 $w=1.3e-08 $l=1.35e-08 $layer=M1 $thickness=3.6e-08 $X=0.567
+ $Y=0.135 $X2=0.567 $Y2=0.1485
r42 79 82 3.14806 $w=1.3e-08 $l=1.35e-08 $layer=M1 $thickness=3.6e-08 $X=0.567
+ $Y=0.162 $X2=0.567 $Y2=0.1485
r43 33 78 2.09871 $w=1.3e-08 $l=9e-09 $layer=M1 $thickness=3.6e-08 $X=0.567
+ $Y=0.1755 $X2=0.567 $Y2=0.1845
r44 33 79 3.14806 $w=1.3e-08 $l=1.35e-08 $layer=M1 $thickness=3.6e-08 $X=0.567
+ $Y=0.1755 $X2=0.567 $Y2=0.162
r45 27 59 39.0693 $a=1.62e-16 $layer=V1 $X=0.567 $Y=0.198 $X2=0.567 $Y2=0.189
r46 27 78 1.96775 $w=1.63333e-08 $l=1.35e-08 $layer=M1 $thickness=3.6e-08
+ $X=0.567 $Y=0.198 $X2=0.567 $Y2=0.1845
r47 74 73 8.84359 $w=2.1e-08 $l=2.6e-08 $layer=Gate_1 $thickness=5.6e-08
+ $X=0.945 $Y=0.2295 $X2=0.945 $Y2=0.2035
r48 20 73 8.89461 $w=2.04902e-08 $l=2.55e-08 $layer=Gate_1 $thickness=5.6e-08
+ $X=0.945 $Y=0.178 $X2=0.945 $Y2=0.2035
r49 69 70 23.4695 $w=2.1e-08 $l=6.9e-08 $layer=Gate_1 $thickness=5.6e-08
+ $X=0.675 $Y=0.0405 $X2=0.675 $Y2=0.1095
r50 18 70 23.5205 $w=2.08102e-08 $l=6.85e-08 $layer=Gate_1 $thickness=5.6e-08
+ $X=0.675 $Y=0.178 $X2=0.675 $Y2=0.1095
r51 66 67 5.71315 $w=1.3e-08 $l=2.45e-08 $layer=M2 $thickness=3.6e-08 $X=0.135
+ $Y=0.189 $X2=0.1595 $Y2=0.189
r52 65 66 11.8927 $w=1.3e-08 $l=5.1e-08 $layer=M2 $thickness=3.6e-08 $X=0.084
+ $Y=0.189 $X2=0.135 $Y2=0.189
r53 64 65 11.8927 $w=1.3e-08 $l=5.1e-08 $layer=M2 $thickness=3.6e-08 $X=0.033
+ $Y=0.189 $X2=0.084 $Y2=0.189
r54 64 84 19.5347 $a=3.24e-16 $layer=V1 $X=0.033 $Y=0.189 $X2=0.0345 $Y2=0.189
r55 60 61 18.8884 $w=1.3e-08 $l=8.1e-08 $layer=M2 $thickness=3.6e-08 $X=0.648
+ $Y=0.189 $X2=0.729 $Y2=0.189
r56 59 60 18.8884 $w=1.3e-08 $l=8.1e-08 $layer=M2 $thickness=3.6e-08 $X=0.567
+ $Y=0.189 $X2=0.648 $Y2=0.189
r57 59 78 39.0693 $a=1.62e-16 $layer=V1 $X=0.567 $Y=0.189 $X2=0.567 $Y2=0.1845
r58 35 59 46.7546 $w=1.3e-08 $l=2.005e-07 $layer=M2 $thickness=3.6e-08
+ $X=0.3665 $Y=0.189 $X2=0.567 $Y2=0.189
r59 35 67 48.2703 $w=1.3e-08 $l=2.07e-07 $layer=M2 $thickness=3.6e-08 $X=0.3665
+ $Y=0.189 $X2=0.1595 $Y2=0.189
r60 5 56 2.78395 $w=2.4e-08 $layer=LIG $thickness=4.8e-08 $X=0.945 $Y=0.178
+ $X2=0.945 $Y2=0.178
r61 5 20 7.42683 $w=2.2e-08 $layer=Gate_1 $thickness=5.2e-08 $X=0.945 $Y=0.178
+ $X2=0.945 $Y2=0.178
r62 3 51 2.78395 $w=2.4e-08 $layer=LIG $thickness=4.8e-08 $X=0.675 $Y=0.178
+ $X2=0.675 $Y2=0.178
r63 3 18 7.42683 $w=2.2e-08 $layer=Gate_1 $thickness=5.2e-08 $X=0.675 $Y=0.178
+ $X2=0.675 $Y2=0.178
r64 57 61 19.5347 $a=3.24e-16 $layer=V1 $X=0.729 $Y=0.1845 $X2=0.729 $Y2=0.189
r65 34 57 3.84763 $w=1.3e-08 $l=1.65e-08 $layer=M1 $thickness=3.6e-08 $X=0.729
+ $Y=0.168 $X2=0.729 $Y2=0.1845
r66 55 56 6.83711 $w=2.22e-08 $l=1.5e-09 $layer=LISD $thickness=2.7e-08
+ $X=0.9435 $Y=0.178 $X2=0.945 $Y2=0.178
r67 54 55 12.9145 $w=2.22e-08 $l=2.55e-08 $layer=LISD $thickness=2.7e-08
+ $X=0.918 $Y=0.178 $X2=0.9435 $Y2=0.178
r68 53 54 13.6742 $w=2.22e-08 $l=2.7e-08 $layer=LISD $thickness=2.7e-08
+ $X=0.891 $Y=0.178 $X2=0.918 $Y2=0.178
r69 52 53 13.6742 $w=2.22e-08 $l=2.7e-08 $layer=LISD $thickness=2.7e-08
+ $X=0.864 $Y=0.178 $X2=0.891 $Y2=0.178
r70 50 51 12.9145 $w=2.22e-08 $l=1.35e-08 $layer=LISD $thickness=2.7e-08
+ $X=0.6885 $Y=0.178 $X2=0.675 $Y2=0.178
r71 48 49 6.07743 $w=2.22e-08 $l=1.2e-08 $layer=LISD $thickness=2.7e-08
+ $X=0.729 $Y=0.178 $X2=0.741 $Y2=0.178
r72 48 57 19.3796 $a=3.24e-16 $layer=V0LISD $X=0.729 $Y=0.178 $X2=0.729
+ $Y2=0.1845
r73 47 48 6.07743 $w=2.22e-08 $l=1.2e-08 $layer=LISD $thickness=2.7e-08
+ $X=0.717 $Y=0.178 $X2=0.729 $Y2=0.178
r74 47 50 14.4339 $w=2.22e-08 $l=2.85e-08 $layer=LISD $thickness=2.7e-08
+ $X=0.717 $Y=0.178 $X2=0.6885 $Y2=0.178
r75 46 49 7.59679 $w=2.22e-08 $l=1.5e-08 $layer=LISD $thickness=2.7e-08
+ $X=0.756 $Y=0.178 $X2=0.741 $Y2=0.178
r76 45 46 13.6742 $w=2.22e-08 $l=2.7e-08 $layer=LISD $thickness=2.7e-08
+ $X=0.783 $Y=0.178 $X2=0.756 $Y2=0.178
r77 44 45 13.6742 $w=2.22e-08 $l=2.7e-08 $layer=LISD $thickness=2.7e-08 $X=0.81
+ $Y=0.178 $X2=0.783 $Y2=0.178
r78 10 44 13.6742 $w=2.22e-08 $l=2.7e-08 $layer=LISD $thickness=2.7e-08
+ $X=0.837 $Y=0.178 $X2=0.81 $Y2=0.178
r79 10 52 13.6742 $w=2.22e-08 $l=2.7e-08 $layer=LISD $thickness=2.7e-08
+ $X=0.837 $Y=0.178 $X2=0.864 $Y2=0.178
r80 4 42 7.42683 $w=2.2e-08 $layer=Gate_1 $thickness=5.2e-08 $X=0.837 $Y=0.178
+ $X2=0.837 $Y2=0.178
r81 4 10 10.3807 $w=2.30357e-08 $layer=LISD $thickness=3.675e-08 $X=0.837
+ $Y=0.178 $X2=0.837 $Y2=0.178
r82 41 42 23.5205 $w=2.08102e-08 $l=6.85e-08 $layer=Gate_1 $thickness=5.6e-08
+ $X=0.837 $Y=0.1095 $X2=0.837 $Y2=0.178
r83 40 41 23.4695 $w=2.1e-08 $l=6.9e-08 $layer=Gate_1 $thickness=5.6e-08
+ $X=0.837 $Y=0.0405 $X2=0.837 $Y2=0.1095
r84 40 19 5.44221 $w=2.1e-08 $l=1.6e-08 $layer=Gate_1 $thickness=5.6e-08
+ $X=0.837 $Y=0.0405 $X2=0.837 $Y2=0.0245
r85 9 22 1e-05 $l=2e-09 $X=0.054 $Y=0.216 $X2=0.056 $Y2=0.216
r86 8 21 1e-05 $l=2e-09 $X=0.054 $Y=0.054 $X2=0.056 $Y2=0.054
.ends

.subckt PM_SDFLx1_ASAP7_75t_R%12 vss 18 22 38 43 9 1 16 15 17 14 13 3 4 12 10 11
c1 1 vss 0.00188946f $X=0.999 $Y=0.1055
c2 3 vss 0.00590135f $X=1.08 $Y=0.0405
c3 4 vss 0.00630963f $X=1.08 $Y=0.2295
c4 9 vss 0.0413029f $X=0.999 $Y=0.0245
c5 10 vss 0.0187716f $X=1.0655 $Y=0.0405
c6 11 vss 0.0188853f $X=1.0655 $Y=0.2295
c7 12 vss 0.0025463f $X=0.999 $Y=0.036
c8 13 vss 0.0060333f $X=1.107 $Y=0.234
c9 14 vss 0.00251735f $X=1.107 $Y=0.0305
c10 15 vss 0.00101058f $X=0.999 $Y=0.0705
c11 16 vss 0.00726571f $X=1.026 $Y=0.036
c12 17 vss 0.00279063f $X=1.107 $Y=0.081
r1 11 4 0.462963 $w=2.7e-08 $l=1.25e-08 $layer=P_src_drn $thickness=1e-09
+ $X=1.0655 $Y=0.2295 $X2=1.08 $Y2=0.2295
r2 43 11 0.0925926 $w=2.7e-08 $l=2.5e-09 $layer=P_src_drn $thickness=1e-09
+ $X=1.0626 $Y=0.2295 $X2=1.0655 $Y2=0.2295
r3 4 40 19.3796 $a=3.24e-16 $layer=V0LISD $X=1.08 $Y=0.2295 $X2=1.08 $Y2=0.234
r4 40 41 3.14806 $w=1.3e-08 $l=1.35e-08 $layer=M1 $thickness=3.6e-08 $X=1.08
+ $Y=0.234 $X2=1.0935 $Y2=0.234
r5 13 36 7.21452 $w=1.425e-08 $l=3.6e-08 $layer=M1 $thickness=3.6e-08 $X=1.107
+ $Y=0.234 $X2=1.107 $Y2=0.198
r6 13 41 1.96775 $w=1.63333e-08 $l=1.35e-08 $layer=M1 $thickness=3.6e-08
+ $X=1.107 $Y=0.234 $X2=1.0935 $Y2=0.234
r7 10 3 0.462963 $w=2.7e-08 $l=1.25e-08 $layer=N_src_drn $thickness=1e-09
+ $X=1.0655 $Y=0.0405 $X2=1.08 $Y2=0.0405
r8 38 10 0.0925926 $w=2.7e-08 $l=2.5e-09 $layer=N_src_drn $thickness=1e-09
+ $X=1.0626 $Y=0.0405 $X2=1.0655 $Y2=0.0405
r9 35 36 12.5922 $w=1.3e-08 $l=5.4e-08 $layer=M1 $thickness=3.6e-08 $X=1.107
+ $Y=0.144 $X2=1.107 $Y2=0.198
r10 17 34 8.95608 $w=1.36627e-08 $l=4.15e-08 $layer=M1 $thickness=3.6e-08
+ $X=1.107 $Y=0.081 $X2=1.107 $Y2=0.0395
r11 17 35 14.691 $w=1.3e-08 $l=6.3e-08 $layer=M1 $thickness=3.6e-08 $X=1.107
+ $Y=0.081 $X2=1.107 $Y2=0.144
r12 3 32 19.3796 $a=3.24e-16 $layer=V0LISD $X=1.08 $Y=0.0405 $X2=1.08 $Y2=0.036
r13 14 33 1.40651 $w=1.51875e-08 $l=1.45774e-08 $layer=M1 $thickness=3.6e-08
+ $X=1.107 $Y=0.0305 $X2=1.0935 $Y2=0.036
r14 14 34 0.9184 $w=1.8e-08 $l=9e-09 $layer=M1 $thickness=3.6e-08 $X=1.107
+ $Y=0.0305 $X2=1.107 $Y2=0.0395
r15 32 33 3.14806 $w=1.3e-08 $l=1.35e-08 $layer=M1 $thickness=3.6e-08 $X=1.08
+ $Y=0.036 $X2=1.0935 $Y2=0.036
r16 31 32 2.68168 $w=1.3e-08 $l=1.15e-08 $layer=M1 $thickness=3.6e-08 $X=1.0685
+ $Y=0.036 $X2=1.08 $Y2=0.036
r17 30 31 1.04935 $w=1.3e-08 $l=4.5e-09 $layer=M1 $thickness=3.6e-08 $X=1.064
+ $Y=0.036 $X2=1.0685 $Y2=0.036
r18 29 30 2.56509 $w=1.3e-08 $l=1.1e-08 $layer=M1 $thickness=3.6e-08 $X=1.053
+ $Y=0.036 $X2=1.064 $Y2=0.036
r19 16 29 6.29612 $w=1.3e-08 $l=2.7e-08 $layer=M1 $thickness=3.6e-08 $X=1.026
+ $Y=0.036 $X2=1.053 $Y2=0.036
r20 12 15 6.39593 $w=1.55565e-08 $l=3.45e-08 $layer=M1 $thickness=3.6e-08
+ $X=0.999 $Y=0.036 $X2=0.999 $Y2=0.0705
r21 12 16 4.64701 $w=1.46667e-08 $l=2.7e-08 $layer=M1 $thickness=3.6e-08
+ $X=0.999 $Y=0.036 $X2=1.026 $Y2=0.036
r22 15 26 8.04505 $w=1.3e-08 $l=3.45e-08 $layer=M1 $thickness=3.6e-08 $X=0.999
+ $Y=0.0705 $X2=0.999 $Y2=0.105
r23 1 20 6.4735 $w=2.13953e-08 $layer=Gate_1 $thickness=5.22791e-08 $X=0.999
+ $Y=0.1055 $X2=0.999 $Y2=0.1055
r24 1 26 19.3796 $a=3.24e-16 $layer=V0LIG $X=0.999 $Y=0.1055 $X2=0.999 $Y2=0.105
r25 22 21 21.4287 $w=2.1e-08 $l=6.3e-08 $layer=Gate_1 $thickness=5.6e-08
+ $X=0.999 $Y=0.2295 $X2=0.999 $Y2=0.1665
r26 20 21 20.944 $w=2.08115e-08 $l=6.1e-08 $layer=Gate_1 $thickness=5.6e-08
+ $X=0.999 $Y=0.1055 $X2=0.999 $Y2=0.1665
r27 19 20 10.9099 $w=2.06349e-08 $l=3.15e-08 $layer=Gate_1 $thickness=5.6e-08
+ $X=0.999 $Y=0.074 $X2=0.999 $Y2=0.1055
r28 18 19 11.3946 $w=2.1e-08 $l=3.35e-08 $layer=Gate_1 $thickness=5.6e-08
+ $X=0.999 $Y=0.0405 $X2=0.999 $Y2=0.074
r29 18 9 5.44221 $w=2.1e-08 $l=1.6e-08 $layer=Gate_1 $thickness=5.6e-08
+ $X=0.999 $Y=0.0405 $X2=0.999 $Y2=0.0245
.ends

.subckt PM_SDFLx1_ASAP7_75t_R%23 vss 2 3 1
c1 1 vss 0.000577181f $X=0.972 $Y=0.2295
r1 2 1 0.62963 $w=2.7e-08 $l=1.7e-08 $layer=P_src_drn $thickness=1e-09
+ $X=0.9546 $Y=0.2295 $X2=0.972 $Y2=0.2295
r2 3 1 0.62963 $w=2.7e-08 $l=1.7e-08 $layer=P_src_drn $thickness=1e-09
+ $X=0.9893 $Y=0.2295 $X2=0.972 $Y2=0.2295
.ends

.subckt PM_SDFLx1_ASAP7_75t_R%11 vss 22 26 60 63 66 69 10 13 3 11 16 20 1 4 12
+ 17 21 9 15 19 14
c1 1 vss 0.000286621f $X=0.783 $Y=0.131
c2 3 vss 0.00420251f $X=0.594 $Y=0.2295
c3 4 vss 0.00776371f $X=0.648 $Y=0.0405
c4 9 vss 0.038559f $X=0.783 $Y=0.0245
c5 10 vss 0.00308859f $X=0.6335 $Y=0.0405
c6 11 vss 0.000350138f $X=0.6335 $Y=0.081
c7 12 vss 0.00175678f $X=0.5795 $Y=0.2295
c8 13 vss 0.000287007f $X=0.5795 $Y=0.189
c9 14 vss 0.00296206f $X=0.693 $Y=0.036
c10 15 vss 9.7447e-20 $X=0.693 $Y=0.131
c11 16 vss 0.00264474f $X=0.693 $Y=0.234
c12 17 vss 0.00824406f $X=0.6665 $Y=0.234
c13 18 vss 0.00803311f $X=0.653 $Y=0.036
c14 19 vss 0.00167496f $X=0.693 $Y=0.114
c15 20 vss 0.000495139f $X=0.693 $Y=0.1465
c16 21 vss 0.000810315f $X=0.756 $Y=0.131
r1 13 3 0.231482 $w=5.4e-08 $l=1.25e-08 $layer=P_src_drn $thickness=1e-09
+ $X=0.5795 $Y=0.189 $X2=0.594 $Y2=0.2295
r2 69 68 0.0925926 $w=2.7e-08 $l=2.5e-09 $layer=P_src_drn $thickness=1e-09
+ $X=0.6113 $Y=0.2295 $X2=0.6085 $Y2=0.2295
r3 67 68 0.166667 $w=2.7e-08 $l=4.5e-09 $layer=P_src_drn $thickness=1e-09
+ $X=0.604 $Y=0.2295 $X2=0.6085 $Y2=0.2295
r4 3 67 0.444445 $w=2.7e-08 $l=1.2e-08 $layer=P_src_drn $thickness=1e-09
+ $X=0.594 $Y=0.2295 $X2=0.604 $Y2=0.2295
r5 12 3 0.462963 $w=2.7e-08 $l=1.25e-08 $layer=P_src_drn $thickness=1e-09
+ $X=0.5795 $Y=0.2295 $X2=0.594 $Y2=0.2295
r6 66 12 0.0925926 $w=2.7e-08 $l=2.5e-09 $layer=P_src_drn $thickness=1e-09
+ $X=0.5766 $Y=0.2025 $X2=0.5795 $Y2=0.2295
r7 11 53 0.231482 $w=5.4e-08 $l=1.25e-08 $layer=N_src_drn $thickness=1e-09
+ $X=0.6335 $Y=0.081 $X2=0.648 $Y2=0.0685
r8 63 62 0.0925926 $w=2.7e-08 $l=2.5e-09 $layer=N_src_drn $thickness=1e-09
+ $X=0.6653 $Y=0.0405 $X2=0.6625 $Y2=0.0405
r9 61 62 0.166667 $w=2.7e-08 $l=4.5e-09 $layer=N_src_drn $thickness=1e-09
+ $X=0.658 $Y=0.0405 $X2=0.6625 $Y2=0.0405
r10 53 61 0.444445 $w=2.7e-08 $l=1.2e-08 $layer=N_src_drn $thickness=1e-09
+ $X=0.648 $Y=0.0685 $X2=0.658 $Y2=0.0405
r11 10 53 0.462963 $w=2.7e-08 $l=1.25e-08 $layer=N_src_drn $thickness=1e-09
+ $X=0.6335 $Y=0.0405 $X2=0.648 $Y2=0.0685
r12 60 10 0.0925926 $w=2.7e-08 $l=2.5e-09 $layer=N_src_drn $thickness=1e-09
+ $X=0.6306 $Y=0.0675 $X2=0.6335 $Y2=0.0405
r13 3 52 19.3796 $a=3.24e-16 $layer=V0LISD $X=0.594 $Y=0.2295 $X2=0.59 $Y2=0.234
r14 4 46 19.3796 $a=3.24e-16 $layer=V0LISD $X=0.648 $Y=0.0405 $X2=0.644
+ $Y2=0.036
r15 4 53 16.5033 $w=2.02e-08 $l=2.8e-08 $layer=LISD $thickness=2.7e-08 $X=0.648
+ $Y=0.0405 $X2=0.648 $Y2=0.0685
r16 49 50 1.63233 $w=1.3e-08 $l=7e-09 $layer=M1 $thickness=3.6e-08 $X=0.599
+ $Y=0.234 $X2=0.606 $Y2=0.234
r17 49 52 2.09871 $w=1.3e-08 $l=9e-09 $layer=M1 $thickness=3.6e-08 $X=0.599
+ $Y=0.234 $X2=0.59 $Y2=0.234
r18 48 50 1.04935 $w=1.3e-08 $l=4.5e-09 $layer=M1 $thickness=3.6e-08 $X=0.6105
+ $Y=0.234 $X2=0.606 $Y2=0.234
r19 47 48 4.6638 $w=1.3e-08 $l=2e-08 $layer=M1 $thickness=3.6e-08 $X=0.6305
+ $Y=0.234 $X2=0.6105 $Y2=0.234
r20 17 47 8.39483 $w=1.3e-08 $l=3.6e-08 $layer=M1 $thickness=3.6e-08 $X=0.6665
+ $Y=0.234 $X2=0.6305 $Y2=0.234
r21 18 44 4.08082 $w=1.3e-08 $l=1.75e-08 $layer=M1 $thickness=3.6e-08 $X=0.653
+ $Y=0.036 $X2=0.6705 $Y2=0.036
r22 18 46 2.09871 $w=1.3e-08 $l=9e-09 $layer=M1 $thickness=3.6e-08 $X=0.653
+ $Y=0.036 $X2=0.644 $Y2=0.036
r23 16 43 2.5483 $w=1.79e-08 $l=1.8e-08 $layer=M1 $thickness=3.6e-08 $X=0.693
+ $Y=0.234 $X2=0.693 $Y2=0.216
r24 16 17 4.53042 $w=1.46981e-08 $l=2.65e-08 $layer=M1 $thickness=3.6e-08
+ $X=0.693 $Y=0.234 $X2=0.6665 $Y2=0.234
r25 14 38 2.43171 $w=1.804e-08 $l=1.75e-08 $layer=M1 $thickness=3.6e-08
+ $X=0.693 $Y=0.036 $X2=0.693 $Y2=0.0535
r26 14 44 3.59766 $w=1.5e-08 $l=2.25e-08 $layer=M1 $thickness=3.6e-08 $X=0.693
+ $Y=0.036 $X2=0.6705 $Y2=0.036
r27 42 43 4.19742 $w=1.3e-08 $l=1.8e-08 $layer=M1 $thickness=3.6e-08 $X=0.693
+ $Y=0.198 $X2=0.693 $Y2=0.216
r28 41 42 4.19742 $w=1.3e-08 $l=1.8e-08 $layer=M1 $thickness=3.6e-08 $X=0.693
+ $Y=0.18 $X2=0.693 $Y2=0.198
r29 40 41 2.79828 $w=1.3e-08 $l=1.2e-08 $layer=M1 $thickness=3.6e-08 $X=0.693
+ $Y=0.168 $X2=0.693 $Y2=0.18
r30 39 40 2.09871 $w=1.3e-08 $l=9e-09 $layer=M1 $thickness=3.6e-08 $X=0.693
+ $Y=0.159 $X2=0.693 $Y2=0.168
r31 20 39 2.91487 $w=1.3e-08 $l=1.25e-08 $layer=M1 $thickness=3.6e-08 $X=0.693
+ $Y=0.1465 $X2=0.693 $Y2=0.159
r32 37 38 2.09871 $w=1.3e-08 $l=9e-09 $layer=M1 $thickness=3.6e-08 $X=0.693
+ $Y=0.0625 $X2=0.693 $Y2=0.0535
r33 36 37 2.2153 $w=1.3e-08 $l=9.5e-09 $layer=M1 $thickness=3.6e-08 $X=0.693
+ $Y=0.072 $X2=0.693 $Y2=0.0625
r34 35 36 4.19742 $w=1.3e-08 $l=1.8e-08 $layer=M1 $thickness=3.6e-08 $X=0.693
+ $Y=0.09 $X2=0.693 $Y2=0.072
r35 34 35 2.91487 $w=1.3e-08 $l=1.25e-08 $layer=M1 $thickness=3.6e-08 $X=0.693
+ $Y=0.1025 $X2=0.693 $Y2=0.09
r36 19 34 2.68168 $w=1.3e-08 $l=1.15e-08 $layer=M1 $thickness=3.6e-08 $X=0.693
+ $Y=0.114 $X2=0.693 $Y2=0.1025
r37 15 32 3.01711 $w=1.55e-08 $l=1.8e-08 $layer=M1 $thickness=3.6e-08 $X=0.693
+ $Y=0.131 $X2=0.711 $Y2=0.131
r38 15 19 2.78392 $w=1.56471e-08 $l=1.7e-08 $layer=M1 $thickness=3.6e-08
+ $X=0.693 $Y=0.131 $X2=0.693 $Y2=0.114
r39 15 20 2.43413 $w=1.59032e-08 $l=1.55e-08 $layer=M1 $thickness=3.6e-08
+ $X=0.693 $Y=0.131 $X2=0.693 $Y2=0.1465
r40 31 32 4.19742 $w=1.3e-08 $l=1.8e-08 $layer=M1 $thickness=3.6e-08 $X=0.729
+ $Y=0.131 $X2=0.711 $Y2=0.131
r41 21 30 6.29612 $w=1.3e-08 $l=2.7e-08 $layer=M1 $thickness=3.6e-08 $X=0.756
+ $Y=0.131 $X2=0.783 $Y2=0.131
r42 21 31 6.29612 $w=1.3e-08 $l=2.7e-08 $layer=M1 $thickness=3.6e-08 $X=0.756
+ $Y=0.131 $X2=0.729 $Y2=0.131
r43 1 24 6.54019 $w=2.09524e-08 $layer=Gate_1 $thickness=5.21905e-08 $X=0.783
+ $Y=0.131 $X2=0.783 $Y2=0.131
r44 1 30 19.3796 $a=3.24e-16 $layer=V0LIG $X=0.783 $Y=0.131 $X2=0.783 $Y2=0.131
r45 26 25 17.177 $w=2.1e-08 $l=5.05e-08 $layer=Gate_1 $thickness=5.6e-08
+ $X=0.783 $Y=0.2295 $X2=0.783 $Y2=0.179
r46 24 25 16.5137 $w=2.07708e-08 $l=4.8e-08 $layer=Gate_1 $thickness=5.6e-08
+ $X=0.783 $Y=0.131 $X2=0.783 $Y2=0.179
r47 23 24 15.1532 $w=2.075e-08 $l=4.4e-08 $layer=Gate_1 $thickness=5.6e-08
+ $X=0.783 $Y=0.087 $X2=0.783 $Y2=0.131
r48 22 23 15.8164 $w=2.1e-08 $l=4.65e-08 $layer=Gate_1 $thickness=5.6e-08
+ $X=0.783 $Y=0.0405 $X2=0.783 $Y2=0.087
r49 22 9 5.44221 $w=2.1e-08 $l=1.6e-08 $layer=Gate_1 $thickness=5.6e-08
+ $X=0.783 $Y=0.0405 $X2=0.783 $Y2=0.0245
.ends

.subckt PM_SDFLx1_ASAP7_75t_R%19 vss 7 12 4 1 5
c1 1 vss 0.00593411f $X=0.648 $Y=0.2295
c2 4 vss 0.00167176f $X=0.6335 $Y=0.2295
c3 5 vss 0.00205131f $X=0.704 $Y=0.2295
r1 12 11 0.0925926 $w=2.7e-08 $l=2.5e-09 $layer=P_src_drn $thickness=1e-09
+ $X=0.7193 $Y=0.2295 $X2=0.7165 $Y2=0.2295
r2 5 11 0.462963 $w=2.7e-08 $l=1.25e-08 $layer=P_src_drn $thickness=1e-09
+ $X=0.704 $Y=0.2295 $X2=0.7165 $Y2=0.2295
r3 9 5 11.9937 $w=2.32e-08 $l=2.55e-08 $layer=LISD $thickness=2.7e-08 $X=0.6765
+ $Y=0.2295 $X2=0.704 $Y2=0.2295
r4 8 9 7.05511 $w=2.32e-08 $l=1.5e-08 $layer=LISD $thickness=2.7e-08 $X=0.6615
+ $Y=0.2295 $X2=0.6765 $Y2=0.2295
r5 1 8 6.3496 $w=2.32e-08 $l=1.35e-08 $layer=LISD $thickness=2.7e-08 $X=0.648
+ $Y=0.2295 $X2=0.6615 $Y2=0.2295
r6 4 1 0.462963 $w=2.7e-08 $l=1.25e-08 $layer=P_src_drn $thickness=1e-09
+ $X=0.6335 $Y=0.2295 $X2=0.648 $Y2=0.2295
r7 7 4 0.0925926 $w=2.7e-08 $l=2.5e-09 $layer=P_src_drn $thickness=1e-09
+ $X=0.6306 $Y=0.2295 $X2=0.6335 $Y2=0.2295
.ends

* End of included file SDFLx1_ASAP7_75t_R.pex.sp.pex

*
.subckt SDFLx1_ASAP7_75t_CUSTOM_4_25_0_7 VSS VDD CLK SE D SI QN
*
* VSS VSS
* VDD VDD
* CLK CLK
* SE SE
* D D
* SI SI
* QN QN
*
*

M0 VSS N_M0_g N_M0_s VSS nmos_rvt L=2e-08 W=5.4e-08 nfin=2 $X=0.071 $Y=0.027
M1 N_M1_d N_M1_g VSS VSS nmos_rvt L=2e-08 W=5.4e-08 nfin=2 $X=0.125 $Y=0.027
M2 VSS N_M2_g noxref_15 VSS nmos_rvt L=2e-08 W=8.1e-08 nfin=3 $X=0.287 $Y=0.027
M3 noxref_21 N_M3_g VSS VSS nmos_rvt L=2e-08 W=8.1e-08 nfin=3 $X=0.341 $Y=0.027
M4 noxref_17 N_M4_g noxref_21 VSS nmos_rvt L=2e-08 W=8.1e-08 nfin=3 $X=0.395
+ $Y=0.027
M5 noxref_15 N_M5_g noxref_17 VSS nmos_rvt L=2e-08 W=8.1e-08 nfin=3 $X=0.449
+ $Y=0.027
M6 N_M6_d N_M6_g noxref_17 VSS nmos_rvt L=2e-08 W=8.1e-08 nfin=3 $X=0.611
+ $Y=0.027
M7 N_M7_d N_M7_g N_M7_s VSS nmos_rvt L=2e-08 W=2.7e-08 nfin=1 $X=0.665 $Y=0.027
M8 VSS N_M8_g N_M8_s VSS nmos_rvt L=2e-08 W=2.7e-08 nfin=1 $X=0.719 $Y=0.027
M9 N_M9_d N_M9_g VSS VSS nmos_rvt L=2e-08 W=2.7e-08 nfin=1 $X=0.773 $Y=0.027
M10 N_M10_d N_M10_g N_M10_s VSS nmos_rvt L=2e-08 W=2.7e-08 nfin=1 $X=0.827
+ $Y=0.027
M11 N_M11_d N_M11_g N_M11_s VSS nmos_rvt L=2e-08 W=2.7e-08 nfin=1 $X=0.881
+ $Y=0.027
M12 VSS N_M12_g N_M12_s VSS nmos_rvt L=2e-08 W=2.7e-08 nfin=1 $X=0.989 $Y=0.027
M13 N_M13_d N_M13_g VSS VSS nmos_rvt L=2e-08 W=2.7e-08 nfin=1 $X=1.043 $Y=0.027
M14 VSS N_M14_g N_M14_s VSS nmos_rvt L=2e-08 W=8.1e-08 nfin=3 $X=1.205 $Y=0.027
M15 N_M15_d N_M15_g VSS VSS nmos_rvt L=2e-08 W=8.1e-08 nfin=3 $X=1.259 $Y=0.027
M16 VDD N_M16_g N_M16_s VDD pmos_rvt L=2e-08 W=5.4e-08 nfin=2 $X=0.071 $Y=0.189
M17 N_M17_d N_M17_g VDD VDD pmos_rvt L=2e-08 W=5.4e-08 nfin=2 $X=0.125 $Y=0.189
M18 N_M18_d N_M18_g N_M18_s VDD pmos_rvt L=2e-08 W=8.1e-08 nfin=3 $X=0.287
+ $Y=0.162
M19 VDD N_M19_g N_M19_s VDD pmos_rvt L=2e-08 W=8.1e-08 nfin=3 $X=0.341 $Y=0.162
M20 N_M20_d N_M20_g VDD VDD pmos_rvt L=2e-08 W=8.1e-08 nfin=3 $X=0.395 $Y=0.162
M21 N_M21_d N_M21_g N_M21_s VDD pmos_rvt L=2e-08 W=8.1e-08 nfin=3 $X=0.449
+ $Y=0.162
M22 N_M22_d N_M22_g N_M22_s VDD pmos_rvt L=2e-08 W=8.1e-08 nfin=3 $X=0.557
+ $Y=0.162
M23 N_M23_d N_M23_g N_M23_s VDD pmos_rvt L=2e-08 W=2.7e-08 nfin=1 $X=0.611
+ $Y=0.216
M24 VDD N_M24_g N_M24_s VDD pmos_rvt L=2e-08 W=2.7e-08 nfin=1 $X=0.719 $Y=0.216
M25 N_M25_d N_M25_g VDD VDD pmos_rvt L=2e-08 W=2.7e-08 nfin=1 $X=0.773 $Y=0.216
M26 N_M26_d N_M26_g N_M26_s VDD pmos_rvt L=2e-08 W=2.7e-08 nfin=1 $X=0.881
+ $Y=0.216
M27 N_M27_d N_M27_g N_M27_s VDD pmos_rvt L=2e-08 W=2.7e-08 nfin=1 $X=0.935
+ $Y=0.216
M28 VDD N_M28_g N_M28_s VDD pmos_rvt L=2e-08 W=2.7e-08 nfin=1 $X=0.989 $Y=0.216
M29 N_M29_d N_M29_g VDD VDD pmos_rvt L=2e-08 W=2.7e-08 nfin=1 $X=1.043 $Y=0.216
M30 VDD N_M30_g N_M30_s VDD pmos_rvt L=2e-08 W=8.1e-08 nfin=3 $X=1.205 $Y=0.162
M31 N_M31_d N_M31_g VDD VDD pmos_rvt L=2e-08 W=8.1e-08 nfin=3 $X=1.259 $Y=0.162

* .include "SDFLx1_ASAP7_75t_R.pex.sp.pxi"

* Start of included file SDFLx1_ASAP7_75t_R.pex.sp.pxi
x_PM_SDFLx1_ASAP7_75t_R%CLK vss CLK N_M0_g N_M16_g N_CLK_3 N_CLK_4 N_CLK_1
+ N_CLK_5 N_CLK_6 PM_SDFLx1_ASAP7_75t_R%CLK
x_PM_SDFLx1_ASAP7_75t_R%20 vss N_M11_d N_M12_s N_20_1 N_20_4 N_20_5
+ PM_SDFLx1_ASAP7_75t_R%20
cc_1 N_20_1 N_4_20 0.000693902f $X=0.918 $Y=0.0405
cc_2 N_20_4 N_4_20 0.00670577f $X=0.9035 $Y=0.0405
cc_3 N_20_5 N_4_20 0.0257351f $X=0.974 $Y=0.0405
cc_4 N_20_4 N_9_2 0.000238572f $X=0.9035 $Y=0.0405
cc_5 N_20_4 N_9_12 0.0147472f $X=0.9035 $Y=0.0405
cc_6 N_20_1 N_12_9 0.000854119f $X=0.918 $Y=0.0405
cc_7 N_20_5 N_12_9 0.0149646f $X=0.974 $Y=0.0405
cc_8 N_20_1 N_13_13 0.000301928f $X=0.918 $Y=0.0405
cc_9 N_20_1 N_13_19 0.00040664f $X=0.918 $Y=0.0405
cc_10 N_20_1 N_13_20 0.000465888f $X=0.918 $Y=0.0405
cc_11 N_20_4 N_13_5 0.000557333f $X=0.9035 $Y=0.0405
cc_12 N_20_1 N_13_16 0.0023232f $X=0.918 $Y=0.0405
x_PM_SDFLx1_ASAP7_75t_R%D vss D N_M4_g N_M20_g N_D_3 N_D_4 N_D_1
+ PM_SDFLx1_ASAP7_75t_R%D
cc_13 N_D_3 N_6_16 0.000473609f $X=0.405 $Y=0.0245
cc_14 N_D_3 N_6_1 0.00193952f $X=0.405 $Y=0.0245
cc_15 N_D_4 N_6_12 0.00131043f $X=0.405 $Y=0.108
cc_16 D N_6_14 0.00248294f $X=0.405 $Y=0.134
cc_17 N_D_3 N_6_9 0.00509212f $X=0.405 $Y=0.0245
x_PM_SDFLx1_ASAP7_75t_R%SI vss SI N_M5_g N_M21_g N_SI_7 N_SI_4 N_SI_6 N_SI_1
+ N_SI_3 PM_SDFLx1_ASAP7_75t_R%SI
cc_18 N_SI_7 N_4_27 0.000138924f $X=0.513 $Y=0.154
cc_19 N_SI_7 N_4_2 0.000436865f $X=0.513 $Y=0.154
cc_20 N_SI_7 N_4_35 0.000159738f $X=0.513 $Y=0.154
cc_21 N_SI_4 N_4_27 0.00110426f $X=0.513 $Y=0.198
cc_22 N_SI_4 N_4_35 0.00125546f $X=0.513 $Y=0.198
cc_23 N_SI_7 N_4_33 0.0037568f $X=0.513 $Y=0.154
cc_24 N_SI_6 N_D_3 0.00107425f $X=0.4635 $Y=0.135
cc_25 N_SI_1 N_D_1 0.00129834f $X=0.4575 $Y=0.135
cc_26 N_SI_3 N_D_3 0.00467726f $X=0.459 $Y=0.0245
x_PM_SDFLx1_ASAP7_75t_R%6 vss N_M3_g N_M19_g N_M14_s N_M30_s N_6_12 N_6_3
+ N_6_15 N_6_1 N_6_11 N_6_10 N_6_13 N_6_4 N_6_14 N_6_9 N_6_16
+ PM_SDFLx1_ASAP7_75t_R%6
cc_27 N_6_12 N_SE_13 0.000705751f $X=0.351 $Y=0.072
cc_28 N_6_3 N_SE_12 0.00021421f $X=1.1725 $Y=0.0405
cc_29 N_6_15 N_SE_9 0.000615171f $X=1.161 $Y=0.037
cc_30 N_6_1 N_SE_11 0.000301379f $X=0.351 $Y=0.135
cc_31 N_6_1 N_SE_1 0.00141881f $X=0.351 $Y=0.135
cc_32 N_6_11 N_SE_6 0.0533449f $X=1.19 $Y=0.2025
cc_33 N_6_10 N_SE_6 0.0153555f $X=1.19 $Y=0.0675
cc_34 N_6_13 N_SE_12 0.000474879f $X=1.161 $Y=0.234
cc_35 N_6_15 N_SE_13 0.000642231f $X=1.161 $Y=0.037
cc_36 N_6_4 N_SE_2 0.000740362f $X=1.188 $Y=0.2295
cc_37 N_6_4 N_SE_6 0.00126579f $X=1.188 $Y=0.2295
cc_38 N_6_14 N_SE_11 0.00156828f $X=0.351 $Y=0.135
cc_39 N_6_3 N_SE_6 0.00164045f $X=1.1725 $Y=0.0405
cc_40 N_6_11 N_SE_2 0.001715f $X=1.19 $Y=0.2025
cc_41 N_6_9 N_SE_5 0.00323557f $X=0.351 $Y=0.0245
cc_42 N_6_15 N_SE_12 0.00731633f $X=1.161 $Y=0.037
cc_43 N_6_16 N_SE_13 0.0578162f $X=0.3395 $Y=0.081
x_PM_SDFLx1_ASAP7_75t_R%9 vss N_M11_g N_M26_g N_M6_g N_M23_g N_M1_d N_M17_d
+ N_9_19 N_9_5 N_9_15 N_9_22 N_9_18 N_9_12 N_9_6 N_9_16 N_9_13 N_9_14 N_9_21
+ N_9_2 N_9_11 N_9_17 N_9_1 N_9_20 PM_SDFLx1_ASAP7_75t_R%9
cc_44 N_9_19 N_CLK_6 0.000731374f $X=0.189 $Y=0.1325
cc_45 N_9_5 N_CLK_6 0.000391713f $X=0.162 $Y=0.054
cc_46 N_9_15 N_CLK_6 0.002114f $X=0.189 $Y=0.036
cc_47 N_9_22 N_4_8 9.84707e-20 $X=0.8125 $Y=0.153
cc_48 N_9_22 N_4_30 4.37221e-20 $X=0.8125 $Y=0.153
cc_49 N_9_22 N_4_16 7.36294e-20 $X=0.8125 $Y=0.153
cc_50 N_9_18 N_4_9 0.000175221f $X=0.1505 $Y=0.234
cc_51 N_9_18 N_4_31 0.000121513f $X=0.1505 $Y=0.234
cc_52 N_9_15 N_4_32 0.000143453f $X=0.189 $Y=0.036
cc_53 N_9_12 N_4_4 0.000190356f $X=0.891 $Y=0.0245
cc_54 N_9_5 N_4_28 0.000201152f $X=0.162 $Y=0.054
cc_55 N_9_12 N_4_5 0.00021695f $X=0.891 $Y=0.0245
cc_56 N_9_6 N_4_26 0.000226424f $X=0.162 $Y=0.216
cc_57 N_9_16 N_4_26 0.000255001f $X=0.189 $Y=0.234
cc_58 N_9_22 N_4_34 0.000835265f $X=0.8125 $Y=0.153
cc_59 N_9_13 N_4_16 0.0109744f $X=0.1475 $Y=0.054
cc_60 N_9_14 N_4_16 0.0389108f $X=0.1475 $Y=0.216
cc_61 N_9_18 N_4_26 0.00388917f $X=0.1505 $Y=0.234
cc_62 N_9_21 N_4_10 0.000442496f $X=0.891 $Y=0.1135
cc_63 N_9_2 N_4_10 0.0024147f $X=0.891 $Y=0.135
cc_64 N_9_22 N_4_27 0.000469887f $X=0.8125 $Y=0.153
cc_65 N_9_11 N_4_3 0.000540799f $X=0.621 $Y=0.135
cc_66 N_9_5 N_4_16 0.000562547f $X=0.162 $Y=0.054
cc_67 N_9_17 N_4_35 0.000564136f $X=0.621 $Y=0.162
cc_68 N_9_19 N_4_1 0.000677651f $X=0.189 $Y=0.1325
cc_69 N_9_19 N_4_35 0.000678288f $X=0.189 $Y=0.1325
cc_70 N_9_6 N_4_16 0.000807456f $X=0.162 $Y=0.216
cc_71 N_9_14 N_4_1 0.000837747f $X=0.1475 $Y=0.216
cc_72 N_9_1 N_4_2 0.00237868f $X=0.621 $Y=0.135
cc_73 N_9_11 N_4_17 0.00158193f $X=0.621 $Y=0.135
cc_74 N_9_17 N_4_27 0.00175625f $X=0.621 $Y=0.162
cc_75 N_9_20 N_4_33 0.00249749f $X=0.621 $Y=0.116
cc_76 N_9_19 N_4_32 0.00458863f $X=0.189 $Y=0.1325
cc_77 N_9_12 N_4_10 0.00472398f $X=0.891 $Y=0.0245
cc_78 N_9_12 N_4_20 0.00553064f $X=0.891 $Y=0.0245
cc_79 N_9_11 N_4_18 0.00852248f $X=0.621 $Y=0.135
cc_80 N_9_12 N_4_19 0.0171889f $X=0.891 $Y=0.0245
cc_81 N_9_22 N_4_35 0.0425015f $X=0.8125 $Y=0.153
cc_82 N_9_5 N_SE_10 0.00021467f $X=0.162 $Y=0.054
cc_83 N_9_15 N_SE_7 0.00209431f $X=0.189 $Y=0.036
cc_84 N_9_21 N_SE_13 0.000538677f $X=0.891 $Y=0.1135
cc_85 N_9_22 N_SE_13 0.00238293f $X=0.8125 $Y=0.153
cc_86 N_9_19 N_SE_10 0.00284947f $X=0.189 $Y=0.1325
cc_87 N_9_22 N_SE_11 0.00347057f $X=0.8125 $Y=0.153
cc_88 N_9_19 N_SE_8 0.00611977f $X=0.189 $Y=0.1325
cc_89 N_9_21 N_6_16 0.00283054f $X=0.891 $Y=0.1135
cc_90 N_9_20 N_6_16 0.00030412f $X=0.621 $Y=0.116
cc_91 N_9_22 N_6_14 0.00380817f $X=0.8125 $Y=0.153
cc_92 N_9_22 N_6_16 0.00974025f $X=0.8125 $Y=0.153
cc_93 N_9_22 N_SI_6 0.00239392f $X=0.8125 $Y=0.153
x_PM_SDFLx1_ASAP7_75t_R%14 vss N_M18_s N_M21_d N_M22_s N_14_10 N_14_2 N_14_11
+ N_14_8 N_14_1 N_14_9 PM_SDFLx1_ASAP7_75t_R%14
cc_94 N_14_10 N_4_35 0.000108165f $X=0.542 $Y=0.2025
cc_95 N_14_10 N_4_2 0.000994242f $X=0.542 $Y=0.2025
cc_96 N_14_10 N_4_33 0.000306224f $X=0.542 $Y=0.2025
cc_97 N_14_10 N_4_27 0.000345862f $X=0.542 $Y=0.2025
cc_98 N_14_2 N_4_17 0.00162763f $X=0.513 $Y=0.2025
cc_99 N_14_11 N_4_35 0.00342344f $X=0.258 $Y=0.234
cc_100 N_14_10 N_4_17 0.0343583f $X=0.542 $Y=0.2025
cc_101 N_14_8 N_SE_1 0.00105285f $X=0.272 $Y=0.2025
cc_102 N_14_8 N_SE_11 0.000890391f $X=0.272 $Y=0.2025
cc_103 N_14_1 N_SE_5 0.00122697f $X=0.27 $Y=0.1755
cc_104 N_14_8 N_SE_5 0.0342432f $X=0.272 $Y=0.2025
cc_105 N_14_9 N_SI_7 0.000637278f $X=0.4715 $Y=0.2025
cc_106 N_14_9 N_SI_1 0.00165855f $X=0.4715 $Y=0.2025
cc_107 N_14_11 N_SI_4 0.00287045f $X=0.258 $Y=0.234
cc_108 N_14_2 N_SI_4 0.00317121f $X=0.513 $Y=0.2025
cc_109 N_14_9 N_SI_3 0.0350546f $X=0.4715 $Y=0.2025
cc_110 N_14_2 N_11_13 0.000567057f $X=0.513 $Y=0.2025
cc_111 N_14_2 N_11_3 0.00104216f $X=0.513 $Y=0.2025
cc_112 N_14_2 N_11_12 0.00216096f $X=0.513 $Y=0.2025
x_PM_SDFLx1_ASAP7_75t_R%16 vss N_M18_d N_M19_s N_M20_d N_M21_s N_16_9 N_16_7
+ N_16_1 N_16_2 N_16_8 PM_SDFLx1_ASAP7_75t_R%16
cc_113 N_16_9 N_4_35 0.0029093f $X=0.31 $Y=0.198
cc_114 N_16_7 N_SE_1 0.000959721f $X=0.3095 $Y=0.2025
cc_115 N_16_1 N_SE_5 0.000744736f $X=0.324 $Y=0.2025
cc_116 N_16_9 N_SE_11 0.000780084f $X=0.31 $Y=0.198
cc_117 N_16_7 N_SE_5 0.0324667f $X=0.3095 $Y=0.2025
cc_118 N_16_7 N_6_1 0.000997158f $X=0.3095 $Y=0.2025
cc_119 N_16_1 N_6_9 0.00079481f $X=0.324 $Y=0.2025
cc_120 N_16_9 N_6_14 0.00195946f $X=0.31 $Y=0.198
cc_121 N_16_7 N_6_9 0.0325595f $X=0.3095 $Y=0.2025
cc_122 N_16_2 N_D_3 0.000822566f $X=0.432 $Y=0.2025
cc_123 N_16_9 D 0.0020164f $X=0.31 $Y=0.198
cc_124 N_16_8 N_D_3 0.0336514f $X=0.4175 $Y=0.2025
cc_125 N_16_8 N_SI_1 0.000728988f $X=0.4175 $Y=0.2025
cc_126 N_16_9 N_SI_6 0.000747151f $X=0.31 $Y=0.198
cc_127 N_16_2 N_SI_3 0.000784796f $X=0.432 $Y=0.2025
cc_128 N_16_8 N_SI_3 0.0330636f $X=0.4175 $Y=0.2025
cc_129 N_16_7 N_14_11 0.00114145f $X=0.3095 $Y=0.2025
cc_130 N_16_8 N_14_11 0.000590086f $X=0.4175 $Y=0.2025
cc_131 N_16_2 N_14_11 0.000641504f $X=0.432 $Y=0.2025
cc_132 N_16_1 N_14_11 0.000661326f $X=0.324 $Y=0.2025
cc_133 N_16_8 N_14_2 0.0010533f $X=0.4175 $Y=0.2025
cc_134 N_16_2 N_14_2 0.00154158f $X=0.432 $Y=0.2025
cc_135 N_16_1 N_14_1 0.00276222f $X=0.324 $Y=0.2025
cc_136 N_16_9 N_14_11 0.0113235f $X=0.31 $Y=0.198
x_PM_SDFLx1_ASAP7_75t_R%22 vss N_M7_d N_M8_s N_22_1 PM_SDFLx1_ASAP7_75t_R%22
cc_137 N_22_1 N_4_18 0.00752715f $X=0.702 $Y=0.0405
cc_138 N_22_1 N_10_10 0.00761303f $X=0.702 $Y=0.0405
x_PM_SDFLx1_ASAP7_75t_R%10 vss N_M8_g N_M24_g N_M10_s N_M9_d N_M25_d N_M26_s
+ N_10_3 N_10_1 N_10_11 N_10_12 N_10_13 N_10_18 N_10_4 N_10_20 N_10_10 N_10_17
+ N_10_14 N_10_15 N_10_16 N_10_19 PM_SDFLx1_ASAP7_75t_R%10
cc_139 N_10_3 N_4_3 9.13883e-20 $X=0.81 $Y=0.0405
cc_140 N_10_3 N_4_10 0.000583389f $X=0.81 $Y=0.0405
cc_141 N_10_3 N_4_34 0.000114191f $X=0.81 $Y=0.0405
cc_142 N_10_1 N_4_10 0.000205917f $X=0.7285 $Y=0.09
cc_143 N_10_11 N_4_19 0.00654301f $X=0.7955 $Y=0.0405
cc_144 N_10_12 N_4_19 0.00763297f $X=0.7955 $Y=0.2295
cc_145 N_10_13 N_4_19 0.00767914f $X=0.866 $Y=0.2295
cc_146 N_10_18 N_4_34 0.000325138f $X=0.8125 $Y=0.234
cc_147 N_10_18 N_4_10 0.0003707f $X=0.8125 $Y=0.234
cc_148 N_10_1 N_4_18 0.00072975f $X=0.7285 $Y=0.09
cc_149 N_10_4 N_4_4 0.000871238f $X=0.81 $Y=0.2295
cc_150 N_10_20 N_4_10 0.00156511f $X=0.837 $Y=0.1
cc_151 N_10_4 N_4_19 0.00227824f $X=0.81 $Y=0.2295
cc_152 N_10_4 N_4_10 0.00629211f $X=0.81 $Y=0.2295
cc_153 N_10_10 N_4_18 0.0136685f $X=0.729 $Y=0.0245
cc_154 N_10_3 N_4_19 0.0288374f $X=0.81 $Y=0.0405
cc_155 N_10_17 N_6_16 0.000564679f $X=0.747 $Y=0.09
cc_156 N_10_14 N_6_16 0.00085596f $X=0.729 $Y=0.09
cc_157 N_10_15 N_6_16 0.00239031f $X=0.81 $Y=0.09
cc_158 N_10_13 N_9_21 0.000144118f $X=0.866 $Y=0.2295
cc_159 N_10_13 N_9_22 0.000180484f $X=0.866 $Y=0.2295
cc_160 N_10_13 N_9_11 0.000182029f $X=0.866 $Y=0.2295
cc_161 N_10_13 N_9_2 0.000194588f $X=0.866 $Y=0.2295
cc_162 N_10_18 N_9_22 0.00024779f $X=0.8125 $Y=0.234
cc_163 N_10_20 N_9_21 0.00409889f $X=0.837 $Y=0.1
cc_164 N_10_20 N_9_2 0.000355767f $X=0.837 $Y=0.1
cc_165 N_10_15 N_9_21 0.000527126f $X=0.81 $Y=0.09
cc_166 N_10_14 N_9_22 0.00163278f $X=0.729 $Y=0.09
cc_167 N_10_13 N_9_12 0.015396f $X=0.866 $Y=0.2295
x_PM_SDFLx1_ASAP7_75t_R%SE vss SE N_M14_g N_M30_g N_M2_g N_M18_g N_SE_13
+ N_SE_12 N_SE_9 N_SE_11 N_SE_1 N_SE_6 N_SE_2 N_SE_5 N_SE_10 N_SE_7 N_SE_8
+ PM_SDFLx1_ASAP7_75t_R%SE
x_PM_SDFLx1_ASAP7_75t_R%13 vss N_M13_g N_M29_g N_M15_g N_M31_g N_M26_d N_M27_s
+ N_M10_d N_M11_s N_13_14 N_13_17 N_13_6 N_13_13 N_13_22 N_13_20 N_13_21 N_13_5
+ N_13_16 N_13_2 N_13_19 N_13_25 N_13_12 N_13_24 N_13_18 N_13_1 N_13_23 N_13_15
+ N_13_11 PM_SDFLx1_ASAP7_75t_R%13
cc_168 N_13_14 N_4_10 0.000166262f $X=0.9035 $Y=0.2295
cc_169 N_13_17 N_4_10 0.000191523f $X=0.945 $Y=0.1575
cc_170 N_13_6 N_4_10 0.000219351f $X=0.918 $Y=0.2295
cc_171 N_13_13 N_4_19 0.00656553f $X=0.8495 $Y=0.0405
cc_172 N_13_22 N_4_10 0.000356942f $X=1.026 $Y=0.162
cc_173 N_13_20 N_4_10 0.000518558f $X=0.945 $Y=0.1315
cc_174 N_13_21 N_4_10 0.000569314f $X=0.945 $Y=0.198
cc_175 N_13_6 N_4_20 0.000928862f $X=0.918 $Y=0.2295
cc_176 N_13_14 N_4_5 0.0011704f $X=0.9035 $Y=0.2295
cc_177 N_13_5 N_4_10 0.00277409f $X=0.864 $Y=0.0405
cc_178 N_13_5 N_4_19 0.00946005f $X=0.864 $Y=0.0405
cc_179 N_13_14 N_4_20 0.0167646f $X=0.9035 $Y=0.2295
cc_180 N_13_16 N_SE_13 0.000257812f $X=0.945 $Y=0.036
cc_181 N_13_2 N_SE_2 0.00196254f $X=1.269 $Y=0.136
cc_182 N_13_19 N_SE_13 0.000975059f $X=0.92 $Y=0.036
cc_183 N_13_25 N_SE_13 0.00197529f $X=0.945 $Y=0.153
cc_184 N_13_20 N_SE_13 0.00276124f $X=0.945 $Y=0.1315
cc_185 N_13_12 N_SE_6 0.00336155f $X=1.269 $Y=0.136
cc_186 N_13_24 N_SE_12 0.00598075f $X=1.269 $Y=0.1085
cc_187 N_13_18 N_6_16 0.000108161f $X=1.053 $Y=0.162
cc_188 N_13_25 N_6_13 0.000121023f $X=0.945 $Y=0.153
cc_189 N_13_17 N_6_16 0.000160638f $X=0.945 $Y=0.1575
cc_190 N_13_25 N_6_15 0.00168831f $X=0.945 $Y=0.153
cc_191 N_13_24 N_6_4 0.000220566f $X=1.269 $Y=0.1085
cc_192 N_13_22 N_6_16 0.000220624f $X=1.026 $Y=0.162
cc_193 N_13_1 N_6_3 0.000245174f $X=1.053 $Y=0.14
cc_194 N_13_19 N_6_16 0.000293561f $X=0.92 $Y=0.036
cc_195 N_13_24 N_6_13 0.000309616f $X=1.269 $Y=0.1085
cc_196 N_13_12 N_6_3 0.000339283f $X=1.269 $Y=0.136
cc_197 N_13_23 N_6_16 0.000380977f $X=1.053 $Y=0.125
cc_198 N_13_25 N_6_16 0.00455194f $X=0.945 $Y=0.153
cc_199 N_13_20 N_6_16 0.00583613f $X=0.945 $Y=0.1315
cc_200 N_13_22 N_9_21 0.000163953f $X=1.026 $Y=0.162
cc_201 N_13_13 N_9_12 0.00655019f $X=0.8495 $Y=0.0405
cc_202 N_13_14 N_9_12 0.00650993f $X=0.9035 $Y=0.2295
cc_203 N_13_15 N_9_21 0.00031734f $X=0.945 $Y=0.234
cc_204 N_13_17 N_9_21 0.00139702f $X=0.945 $Y=0.1575
cc_205 N_13_19 N_9_21 0.000412871f $X=0.92 $Y=0.036
cc_206 N_13_21 N_9_21 0.000425881f $X=0.945 $Y=0.198
cc_207 N_13_5 N_9_2 0.000500019f $X=0.864 $Y=0.0405
cc_208 N_13_20 N_9_2 0.000513689f $X=0.945 $Y=0.1315
cc_209 N_13_25 N_9_22 0.000744241f $X=0.945 $Y=0.153
cc_210 N_13_19 N_9_22 0.000954372f $X=0.92 $Y=0.036
cc_211 N_13_20 N_9_21 0.00440535f $X=0.945 $Y=0.1315
cc_212 N_13_5 N_9_12 0.0187426f $X=0.864 $Y=0.0405
cc_213 N_13_14 N_10_3 0.000434954f $X=0.9035 $Y=0.2295
cc_214 N_13_13 N_10_11 0.00046067f $X=0.8495 $Y=0.0405
cc_215 N_13_15 N_10_16 0.000236742f $X=0.945 $Y=0.234
cc_216 N_13_15 N_10_4 0.000280225f $X=0.945 $Y=0.234
cc_217 N_13_6 N_10_4 0.000720855f $X=0.918 $Y=0.2295
cc_218 N_13_19 N_10_19 0.000391547f $X=0.92 $Y=0.036
cc_219 N_13_15 N_10_20 0.000580468f $X=0.945 $Y=0.234
cc_220 N_13_14 N_10_4 0.000581191f $X=0.9035 $Y=0.2295
cc_221 N_13_19 N_10_15 0.00136521f $X=0.92 $Y=0.036
cc_222 N_13_5 N_10_3 0.0035578f $X=0.864 $Y=0.0405
cc_223 N_13_21 N_12_9 0.000210214f $X=0.945 $Y=0.198
cc_224 N_13_23 N_12_16 0.000331548f $X=1.053 $Y=0.125
cc_225 N_13_11 N_12_3 0.000342506f $X=1.053 $Y=0.0245
cc_226 N_13_11 N_12_4 0.00048426f $X=1.053 $Y=0.0245
cc_227 N_13_18 N_12_13 0.000737979f $X=1.053 $Y=0.162
cc_228 N_13_18 N_12_17 0.000771559f $X=1.053 $Y=0.162
cc_229 N_13_16 N_12_12 0.000861407f $X=0.945 $Y=0.036
cc_230 N_13_1 N_12_17 0.000871949f $X=1.053 $Y=0.14
cc_231 N_13_20 N_12_1 0.000940325f $X=0.945 $Y=0.1315
cc_232 N_13_11 N_12_1 0.00106713f $X=1.053 $Y=0.0245
cc_233 N_13_1 N_12_9 0.00112027f $X=1.053 $Y=0.14
cc_234 N_13_22 N_12_15 0.0014871f $X=1.026 $Y=0.162
cc_235 N_13_25 N_12_17 0.0016229f $X=0.945 $Y=0.153
cc_236 N_13_11 N_12_10 0.00646531f $X=1.053 $Y=0.0245
cc_237 N_13_11 N_12_11 0.00655742f $X=1.053 $Y=0.0245
cc_238 N_13_20 N_12_15 0.00398834f $X=0.945 $Y=0.1315
cc_239 N_13_23 N_12_17 0.00481622f $X=1.053 $Y=0.125
cc_240 N_13_11 N_12_9 0.0307888f $X=1.053 $Y=0.0245
x_PM_SDFLx1_ASAP7_75t_R%QN vss QN N_M15_d N_M31_d N_QN_9 N_QN_7 N_QN_1 N_QN_2
+ N_QN_8 N_QN_11 PM_SDFLx1_ASAP7_75t_R%QN
cc_241 N_QN_9 N_SE_12 0.000650785f $X=1.2845 $Y=0.036
cc_242 N_QN_9 N_SE_9 0.00183932f $X=1.2845 $Y=0.036
cc_243 N_QN_7 N_13_24 0.00129355f $X=1.2815 $Y=0.0675
cc_244 N_QN_7 N_13_25 0.000670368f $X=1.2815 $Y=0.0675
cc_245 N_QN_7 N_13_2 0.000730427f $X=1.2815 $Y=0.0675
cc_246 N_QN_1 N_13_12 0.001105f $X=1.296 $Y=0.0675
cc_247 N_QN_2 N_13_12 0.00126401f $X=1.296 $Y=0.2025
cc_248 N_QN_8 N_13_2 0.00174214f $X=1.2815 $Y=0.2025
cc_249 N_QN_8 N_13_12 0.0148806f $X=1.2815 $Y=0.2025
cc_250 N_QN_11 N_13_24 0.00639908f $X=1.323 $Y=0.0675
cc_251 N_QN_7 N_13_12 0.0540923f $X=1.2815 $Y=0.0675
x_PM_SDFLx1_ASAP7_75t_R%4 vss N_M10_g N_M7_g N_M27_g N_M22_g N_M1_g N_M17_g
+ N_M0_s N_M16_s N_4_23 N_4_26 N_4_31 N_4_24 N_4_8 N_4_21 N_4_22 N_4_9 N_4_1
+ N_4_35 N_4_30 N_4_32 N_4_28 N_4_16 N_4_27 N_4_2 N_4_33 N_4_4 N_4_5 N_4_34
+ N_4_10 N_4_3 N_4_17 N_4_20 N_4_18 N_4_19 PM_SDFLx1_ASAP7_75t_R%4
cc_252 N_4_23 N_CLK_3 7.83829e-20 $X=0.018 $Y=0.036
cc_253 N_4_26 N_CLK_3 0.000536384f $X=0.135 $Y=0.198
cc_254 N_4_31 N_CLK_3 0.00012809f $X=0.036 $Y=0.234
cc_255 N_4_24 N_CLK_3 0.000503159f $X=0.0165 $Y=0.189
cc_256 N_4_8 N_CLK_3 0.00106973f $X=0.054 $Y=0.054
cc_257 N_4_21 N_CLK_3 0.011096f $X=0.056 $Y=0.054
cc_258 N_4_22 N_CLK_3 0.0110768f $X=0.056 $Y=0.216
cc_259 N_4_9 N_CLK_3 0.000509007f $X=0.054 $Y=0.216
cc_260 N_4_1 N_CLK_3 0.000547301f $X=0.135 $Y=0.135
cc_261 N_4_35 N_CLK_3 0.000612518f $X=0.3665 $Y=0.189
cc_262 N_4_30 N_CLK_4 0.000966203f $X=0.036 $Y=0.036
cc_263 N_4_32 N_CLK_4 0.000989324f $X=0.135 $Y=0.1845
cc_264 N_4_1 N_CLK_1 0.00356225f $X=0.135 $Y=0.135
cc_265 N_4_28 N_CLK_5 0.00156465f $X=0.018 $Y=0.172
cc_266 N_4_30 N_CLK_6 0.00177118f $X=0.036 $Y=0.036
cc_267 N_4_32 N_CLK_5 0.00455885f $X=0.135 $Y=0.1845
cc_268 N_4_16 N_CLK_3 0.0355226f $X=0.135 $Y=0.135
x_PM_SDFLx1_ASAP7_75t_R%12 vss N_M12_g N_M28_g N_M13_d N_M29_d N_12_9 N_12_1
+ N_12_16 N_12_15 N_12_17 N_12_14 N_12_13 N_12_3 N_12_4 N_12_12 N_12_10 N_12_11
+ PM_SDFLx1_ASAP7_75t_R%12
cc_269 N_12_9 N_4_10 0.000574831f $X=0.999 $Y=0.0245
cc_270 N_12_9 N_4_5 0.000352063f $X=0.999 $Y=0.0245
cc_271 N_12_1 N_4_20 0.000500111f $X=0.999 $Y=0.1055
cc_272 N_12_9 N_4_20 0.0122662f $X=0.999 $Y=0.0245
cc_273 N_12_16 N_SE_13 0.000897809f $X=1.026 $Y=0.036
cc_274 N_12_15 N_SE_13 0.00332291f $X=0.999 $Y=0.0705
cc_275 N_12_17 N_6_13 0.000143288f $X=1.107 $Y=0.081
cc_276 N_12_17 N_6_3 0.00150418f $X=1.107 $Y=0.081
cc_277 N_12_17 N_6_4 0.000311342f $X=1.107 $Y=0.081
cc_278 N_12_16 N_6_16 0.000341087f $X=1.026 $Y=0.036
cc_279 N_12_14 N_6_15 0.000403066f $X=1.107 $Y=0.0305
cc_280 N_12_13 N_6_13 0.000744661f $X=1.107 $Y=0.234
cc_281 N_12_15 N_6_16 0.00258141f $X=0.999 $Y=0.0705
cc_282 N_12_17 N_6_15 0.00834793f $X=1.107 $Y=0.081
x_PM_SDFLx1_ASAP7_75t_R%23 vss N_M27_d N_M28_s N_23_1 PM_SDFLx1_ASAP7_75t_R%23
cc_283 N_23_1 N_4_20 0.00757481f $X=0.972 $Y=0.2295
cc_284 N_23_1 N_12_9 0.00763514f $X=0.972 $Y=0.2295
x_PM_SDFLx1_ASAP7_75t_R%11 vss N_M9_g N_M25_g N_M6_d N_M7_s N_M22_d N_M23_s
+ N_11_10 N_11_13 N_11_3 N_11_11 N_11_16 N_11_20 N_11_1 N_11_4 N_11_12 N_11_17
+ N_11_21 N_11_9 N_11_15 N_11_19 N_11_14 PM_SDFLx1_ASAP7_75t_R%11
cc_285 N_11_10 N_4_17 0.000137634f $X=0.6335 $Y=0.0405
cc_286 N_11_10 N_4_34 0.000315525f $X=0.6335 $Y=0.0405
cc_287 N_11_10 N_4_4 0.00016815f $X=0.6335 $Y=0.0405
cc_288 N_11_10 N_4_2 0.0001812f $X=0.6335 $Y=0.0405
cc_289 N_11_13 N_4_17 0.0233787f $X=0.5795 $Y=0.189
cc_290 N_11_3 N_4_33 0.000356062f $X=0.594 $Y=0.2295
cc_291 N_11_3 N_4_27 0.000370052f $X=0.594 $Y=0.2295
cc_292 N_11_11 N_4_18 0.00542419f $X=0.6335 $Y=0.081
cc_293 N_11_16 N_4_34 0.000440525f $X=0.693 $Y=0.234
cc_294 N_11_20 N_4_34 0.00605864f $X=0.693 $Y=0.1465
cc_295 N_11_1 N_4_10 0.00199044f $X=0.783 $Y=0.131
cc_296 N_11_4 N_4_18 0.000645849f $X=0.648 $Y=0.0405
cc_297 N_11_12 N_4_2 0.000651679f $X=0.5795 $Y=0.2295
cc_298 N_11_20 N_4_3 0.000755543f $X=0.693 $Y=0.1465
cc_299 N_11_20 N_4_10 0.000761121f $X=0.693 $Y=0.1465
cc_300 N_11_17 N_4_35 0.00134857f $X=0.6665 $Y=0.234
cc_301 N_11_21 N_4_34 0.00139858f $X=0.756 $Y=0.131
cc_302 N_11_3 N_4_17 0.00157147f $X=0.594 $Y=0.2295
cc_303 N_11_17 N_4_27 0.00361146f $X=0.6665 $Y=0.234
cc_304 N_11_9 N_4_10 0.00489574f $X=0.783 $Y=0.0245
cc_305 N_11_12 N_4_17 0.00938856f $X=0.5795 $Y=0.2295
cc_306 N_11_9 N_4_19 0.0117273f $X=0.783 $Y=0.0245
cc_307 N_11_10 N_4_18 0.0308944f $X=0.6335 $Y=0.0405
cc_308 N_11_11 N_9_20 9.91421e-20 $X=0.6335 $Y=0.081
cc_309 N_11_11 N_9_2 0.0001041f $X=0.6335 $Y=0.081
cc_310 N_11_11 N_9_17 0.000195901f $X=0.6335 $Y=0.081
cc_311 N_11_3 N_9_17 0.000388837f $X=0.594 $Y=0.2295
cc_312 N_11_13 N_9_11 0.00540764f $X=0.5795 $Y=0.189
cc_313 N_11_15 N_9_17 0.000438531f $X=0.693 $Y=0.131
cc_314 N_11_17 N_9_17 0.000448186f $X=0.6665 $Y=0.234
cc_315 N_11_19 N_9_20 0.000575053f $X=0.693 $Y=0.114
cc_316 N_11_3 N_9_1 0.000754965f $X=0.594 $Y=0.2295
cc_317 N_11_4 N_9_20 0.000964593f $X=0.648 $Y=0.0405
cc_318 N_11_4 N_9_11 0.00100003f $X=0.648 $Y=0.0405
cc_319 N_11_3 N_9_11 0.00118005f $X=0.594 $Y=0.2295
cc_320 N_11_10 N_9_1 0.00162286f $X=0.6335 $Y=0.0405
cc_321 N_11_20 N_9_17 0.00207178f $X=0.693 $Y=0.1465
cc_322 N_11_21 N_9_22 0.00267513f $X=0.756 $Y=0.131
cc_323 N_11_10 N_9_11 0.00935515f $X=0.6335 $Y=0.0405
cc_324 N_11_12 N_9_11 0.0104916f $X=0.5795 $Y=0.2295
cc_325 N_11_11 N_9_11 0.0443096f $X=0.6335 $Y=0.081
cc_326 N_11_9 N_10_12 0.00644623f $X=0.783 $Y=0.0245
cc_327 N_11_9 N_10_11 0.0063733f $X=0.783 $Y=0.0245
cc_328 N_11_14 N_10_14 0.000285193f $X=0.693 $Y=0.036
cc_329 N_11_4 N_10_1 0.000321764f $X=0.648 $Y=0.0405
cc_330 N_11_20 N_10_14 0.00039693f $X=0.693 $Y=0.1465
cc_331 N_11_21 N_10_15 0.000452843f $X=0.756 $Y=0.131
cc_332 N_11_21 N_10_1 0.000615173f $X=0.756 $Y=0.131
cc_333 N_11_1 N_10_17 0.000981734f $X=0.783 $Y=0.131
cc_334 N_11_9 N_10_3 0.000992871f $X=0.783 $Y=0.0245
cc_335 N_11_21 N_10_20 0.00105772f $X=0.756 $Y=0.131
cc_336 N_11_1 N_10_1 0.0012168f $X=0.783 $Y=0.131
cc_337 N_11_9 N_10_1 0.00183162f $X=0.783 $Y=0.0245
cc_338 N_11_19 N_10_14 0.00440956f $X=0.693 $Y=0.114
cc_339 N_11_21 N_10_17 0.00472408f $X=0.756 $Y=0.131
cc_340 N_11_9 N_10_10 0.0287827f $X=0.783 $Y=0.0245
x_PM_SDFLx1_ASAP7_75t_R%19 vss N_M23_d N_M24_s N_19_4 N_19_1 N_19_5
+ PM_SDFLx1_ASAP7_75t_R%19
cc_341 N_19_4 N_4_10 8.53008e-20 $X=0.6335 $Y=0.2295
cc_342 N_19_1 N_4_3 0.000721244f $X=0.648 $Y=0.2295
cc_343 N_19_5 N_4_10 0.00142832f $X=0.704 $Y=0.2295
cc_344 N_19_1 N_4_18 0.00176943f $X=0.648 $Y=0.2295
cc_345 N_19_5 N_4_18 0.00660899f $X=0.704 $Y=0.2295
cc_346 N_19_4 N_4_18 0.0229511f $X=0.6335 $Y=0.2295
cc_347 N_19_4 N_9_11 0.0141786f $X=0.6335 $Y=0.2295
cc_348 N_19_5 N_10_10 0.01757f $X=0.704 $Y=0.2295
cc_349 N_19_4 N_11_3 0.000497923f $X=0.6335 $Y=0.2295
cc_350 N_19_1 N_11_17 0.00360377f $X=0.648 $Y=0.2295

* End of included file SDFLx1_ASAP7_75t_R.pex.sp.pxi
.ends

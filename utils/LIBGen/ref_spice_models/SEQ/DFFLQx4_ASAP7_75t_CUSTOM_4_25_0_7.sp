.subckt PM_DFFLQx4_ASAP7_75t_R%CLK vss 18 9 15 3 5 7 1 8 6 4
c1 1 vss 0.00364604f $X=0.081 $Y=0.135
c2 3 vss 0.0695598f $X=0.081 $Y=0.0245
c3 4 vss 0.00244471f $X=0.081 $Y=0.088
c4 5 vss 0.00212977f $X=0.081 $Y=0.182
c5 6 vss 0.00119532f $X=0.081 $Y=0.135
c6 7 vss 0.00407764f $X=0.108 $Y=0.0575
c7 8 vss 0.00387251f $X=0.108 $Y=0.2125
r1 8 24 3.22357 $w=2.26279e-08 $l=3.05e-08 $layer=M1 $thickness=3.6e-08
+ $X=0.108 $Y=0.2125 $X2=0.108 $Y2=0.182
r2 7 22 3.22357 $w=2.26279e-08 $l=3.05e-08 $layer=M1 $thickness=3.6e-08
+ $X=0.108 $Y=0.0575 $X2=0.108 $Y2=0.088
r3 23 24 0.502848 $w=3.43333e-08 $l=1.35e-08 $layer=M1 $thickness=3.6e-08
+ $X=0.0945 $Y=0.182 $X2=0.108 $Y2=0.182
r4 5 20 2.6406 $w=2.38947e-08 $l=2.8e-08 $layer=M1 $thickness=3.6e-08 $X=0.081
+ $Y=0.182 $X2=0.081 $Y2=0.154
r5 5 23 0.502848 $w=3.43333e-08 $l=1.35e-08 $layer=M1 $thickness=3.6e-08
+ $X=0.081 $Y=0.182 $X2=0.0945 $Y2=0.182
r6 21 22 0.502848 $w=3.43333e-08 $l=1.35e-08 $layer=M1 $thickness=3.6e-08
+ $X=0.0945 $Y=0.088 $X2=0.108 $Y2=0.088
r7 4 17 1.76614 $w=2.65738e-08 $l=2.42e-08 $layer=M1 $thickness=3.6e-08
+ $X=0.081 $Y=0.088 $X2=0.081 $Y2=0.1122
r8 4 21 0.502848 $w=3.43333e-08 $l=1.35e-08 $layer=M1 $thickness=3.6e-08
+ $X=0.081 $Y=0.088 $X2=0.0945 $Y2=0.088
r9 18 19 0.874462 $w=1.3e-08 $l=3.7e-09 $layer=M1 $thickness=3.6e-08 $X=0.082
+ $Y=0.119 $X2=0.081 $Y2=0.1227
r10 18 17 1.57403 $w=1.3e-08 $l=6.8e-09 $layer=M1 $thickness=3.6e-08 $X=0.082
+ $Y=0.119 $X2=0.081 $Y2=0.1122
r11 6 19 2.85657 $w=1.3e-08 $l=1.23e-08 $layer=M1 $thickness=3.6e-08 $X=0.081
+ $Y=0.135 $X2=0.081 $Y2=0.1227
r12 6 20 4.43061 $w=1.3e-08 $l=1.9e-08 $layer=M1 $thickness=3.6e-08 $X=0.081
+ $Y=0.135 $X2=0.081 $Y2=0.154
r13 1 12 10.4265 $w=1.765e-08 $layer=LIG $thickness=5.2e-08 $X=0.081 $Y=0.135
+ $X2=0.081 $Y2=0.135
r14 1 6 19.3796 $a=3.24e-16 $layer=V0LIG $X=0.081 $Y=0.135 $X2=0.081 $Y2=0.135
r15 15 14 14.6259 $w=2.1e-08 $l=4.3e-08 $layer=Gate_1 $thickness=5.6e-08
+ $X=0.081 $Y=0.216 $X2=0.081 $Y2=0.173
r16 13 14 7.31297 $w=2.1e-08 $l=2.15e-08 $layer=Gate_1 $thickness=5.6e-08
+ $X=0.081 $Y=0.1515 $X2=0.081 $Y2=0.173
r17 12 13 5.79936 $w=2.03333e-08 $l=1.65e-08 $layer=Gate_1 $thickness=5.6e-08
+ $X=0.081 $Y=0.135 $X2=0.081 $Y2=0.1515
r18 11 12 5.79936 $w=2.03333e-08 $l=1.65e-08 $layer=Gate_1 $thickness=5.6e-08
+ $X=0.081 $Y=0.1185 $X2=0.081 $Y2=0.135
r19 10 11 7.31297 $w=2.1e-08 $l=2.15e-08 $layer=Gate_1 $thickness=5.6e-08
+ $X=0.081 $Y=0.097 $X2=0.081 $Y2=0.1185
r20 9 10 14.6259 $w=2.1e-08 $l=4.3e-08 $layer=Gate_1 $thickness=5.6e-08
+ $X=0.081 $Y=0.054 $X2=0.081 $Y2=0.097
r21 9 3 10.0341 $w=2.1e-08 $l=2.95e-08 $layer=Gate_1 $thickness=5.6e-08
+ $X=0.081 $Y=0.054 $X2=0.081 $Y2=0.0245
.ends

.subckt PM_DFFLQx4_ASAP7_75t_R%14 vss 7 12 4 1 5
c1 1 vss 0.00590625f $X=0.432 $Y=0.2295
c2 4 vss 0.00165085f $X=0.4175 $Y=0.2295
c3 5 vss 0.002051f $X=0.488 $Y=0.2295
r1 12 11 0.0925926 $w=2.7e-08 $l=2.5e-09 $layer=P_src_drn $thickness=1e-09
+ $X=0.5033 $Y=0.2295 $X2=0.5005 $Y2=0.2295
r2 5 11 0.462963 $w=2.7e-08 $l=1.25e-08 $layer=P_src_drn $thickness=1e-09
+ $X=0.488 $Y=0.2295 $X2=0.5005 $Y2=0.2295
r3 9 5 9.64198 $w=2.32e-08 $l=2.05e-08 $layer=LISD $thickness=2.7e-08 $X=0.4655
+ $Y=0.2295 $X2=0.488 $Y2=0.2295
r4 8 9 7.05511 $w=2.32e-08 $l=1.5e-08 $layer=LISD $thickness=2.7e-08 $X=0.4505
+ $Y=0.2295 $X2=0.4655 $Y2=0.2295
r5 1 8 8.7013 $w=2.32e-08 $l=1.85e-08 $layer=LISD $thickness=2.7e-08 $X=0.432
+ $Y=0.2295 $X2=0.4505 $Y2=0.2295
r6 4 1 0.462963 $w=2.7e-08 $l=1.25e-08 $layer=P_src_drn $thickness=1e-09
+ $X=0.4175 $Y=0.2295 $X2=0.432 $Y2=0.2295
r7 7 4 0.0925926 $w=2.7e-08 $l=2.5e-09 $layer=P_src_drn $thickness=1e-09
+ $X=0.4146 $Y=0.2295 $X2=0.4175 $Y2=0.2295
.ends

.subckt PM_DFFLQx4_ASAP7_75t_R%16 vss 2 3 1
c1 1 vss 0.00056326f $X=0.486 $Y=0.0405
r1 2 1 0.62963 $w=2.7e-08 $l=1.7e-08 $layer=N_src_drn $thickness=1e-09
+ $X=0.4686 $Y=0.0405 $X2=0.486 $Y2=0.0405
r2 3 1 0.62963 $w=2.7e-08 $l=1.7e-08 $layer=N_src_drn $thickness=1e-09
+ $X=0.5033 $Y=0.0405 $X2=0.486 $Y2=0.0405
.ends

.subckt PM_DFFLQx4_ASAP7_75t_R%17 vss 2 3 1
c1 1 vss 0.000762816f $X=0.324 $Y=0.2025
r1 2 1 0.209877 $w=8.1e-08 $l=1.7e-08 $layer=P_src_drn $thickness=1e-09
+ $X=0.3066 $Y=0.2025 $X2=0.324 $Y2=0.2025
r2 3 1 0.209877 $w=8.1e-08 $l=1.7e-08 $layer=P_src_drn $thickness=1e-09
+ $X=0.3413 $Y=0.2025 $X2=0.324 $Y2=0.2025
.ends

.subckt PM_DFFLQx4_ASAP7_75t_R%D vss 16 7 13 3 1 6 5 4
c1 1 vss 0.00503455f $X=0.297 $Y=0.135
c2 3 vss 0.0918697f $X=0.297 $Y=0.0245
c3 4 vss 0.00537146f $X=0.297 $Y=0.036
c4 5 vss 0.00512684f $X=0.297 $Y=0.234
c5 6 vss 0.00581987f $X=0.297 $Y=0.116
r1 5 20 3.48349 $w=1.525e-08 $l=2e-08 $layer=M1 $thickness=3.6e-08 $X=0.297
+ $Y=0.234 $X2=0.297 $Y2=0.214
r2 4 15 5.17411 $w=1.46514e-08 $l=2.72e-08 $layer=M1 $thickness=3.6e-08
+ $X=0.297 $Y=0.036 $X2=0.297 $Y2=0.0632
r3 19 20 9.44419 $w=1.3e-08 $l=4.05e-08 $layer=M1 $thickness=3.6e-08 $X=0.297
+ $Y=0.1735 $X2=0.297 $Y2=0.214
r4 18 19 8.97781 $w=1.3e-08 $l=3.85e-08 $layer=M1 $thickness=3.6e-08 $X=0.297
+ $Y=0.135 $X2=0.297 $Y2=0.1735
r5 16 17 2.85657 $w=1.3e-08 $l=1.22e-08 $layer=M1 $thickness=3.6e-08 $X=0.298
+ $Y=0.082 $X2=0.297 $Y2=0.0942
r6 16 15 4.37231 $w=1.3e-08 $l=1.88e-08 $layer=M1 $thickness=3.6e-08 $X=0.298
+ $Y=0.082 $X2=0.297 $Y2=0.0632
r7 6 17 5.07188 $w=1.3e-08 $l=2.18e-08 $layer=M1 $thickness=3.6e-08 $X=0.297
+ $Y=0.116 $X2=0.297 $Y2=0.0942
r8 6 18 4.43061 $w=1.3e-08 $l=1.9e-08 $layer=M1 $thickness=3.6e-08 $X=0.297
+ $Y=0.116 $X2=0.297 $Y2=0.135
r9 1 10 10.4265 $w=1.765e-08 $layer=LIG $thickness=5.2e-08 $X=0.297 $Y=0.135
+ $X2=0.297 $Y2=0.135
r10 1 18 19.3796 $a=3.24e-16 $layer=V0LIG $X=0.297 $Y=0.135 $X2=0.297 $Y2=0.135
r11 13 12 14.6259 $w=2.1e-08 $l=4.3e-08 $layer=Gate_1 $thickness=5.6e-08
+ $X=0.297 $Y=0.2025 $X2=0.297 $Y2=0.1595
r12 11 12 2.7211 $w=2.1e-08 $l=8e-09 $layer=Gate_1 $thickness=5.6e-08 $X=0.297
+ $Y=0.1515 $X2=0.297 $Y2=0.1595
r13 10 11 5.79936 $w=2.03333e-08 $l=1.65e-08 $layer=Gate_1 $thickness=5.6e-08
+ $X=0.297 $Y=0.135 $X2=0.297 $Y2=0.1515
r14 9 10 5.79936 $w=2.03333e-08 $l=1.65e-08 $layer=Gate_1 $thickness=5.6e-08
+ $X=0.297 $Y=0.1185 $X2=0.297 $Y2=0.135
r15 8 9 2.7211 $w=2.1e-08 $l=8e-09 $layer=Gate_1 $thickness=5.6e-08 $X=0.297
+ $Y=0.1105 $X2=0.297 $Y2=0.1185
r16 7 8 14.6259 $w=2.1e-08 $l=4.3e-08 $layer=Gate_1 $thickness=5.6e-08 $X=0.297
+ $Y=0.0675 $X2=0.297 $Y2=0.1105
r17 7 3 14.6259 $w=2.1e-08 $l=4.3e-08 $layer=Gate_1 $thickness=5.6e-08 $X=0.297
+ $Y=0.0675 $X2=0.297 $Y2=0.0245
.ends

.subckt PM_DFFLQx4_ASAP7_75t_R%18 vss 2 3 1
c1 1 vss 0.000581326f $X=0.756 $Y=0.2295
r1 2 1 0.62963 $w=2.7e-08 $l=1.7e-08 $layer=P_src_drn $thickness=1e-09
+ $X=0.7386 $Y=0.2295 $X2=0.756 $Y2=0.2295
r2 3 1 0.62963 $w=2.7e-08 $l=1.7e-08 $layer=P_src_drn $thickness=1e-09
+ $X=0.7733 $Y=0.2295 $X2=0.756 $Y2=0.2295
.ends

.subckt PM_DFFLQx4_ASAP7_75t_R%8 vss 21 25 51 54 60 63 10 18 13 3 19 16 11 1 20
+ 4 12 17 9 14 15
c1 1 vss 0.000240175f $X=0.567 $Y=0.1215
c2 3 vss 0.00466348f $X=0.378 $Y=0.2295
c3 4 vss 0.0047385f $X=0.432 $Y=0.0405
c4 9 vss 0.0386684f $X=0.567 $Y=0.0245
c5 10 vss 0.0019602f $X=0.4175 $Y=0.0405
c6 11 vss 0.00031883f $X=0.4175 $Y=0.081
c7 12 vss 0.00203256f $X=0.3635 $Y=0.2295
c8 13 vss 0.00038698f $X=0.3635 $Y=0.189
c9 14 vss 0.00594797f $X=0.459 $Y=0.036
c10 15 vss 1.31178e-20 $X=0.459 $Y=0.131
c11 16 vss 0.00259883f $X=0.459 $Y=0.234
c12 17 vss 0.00692637f $X=0.434 $Y=0.234
c13 18 vss 0.00124979f $X=0.459 $Y=0.114
c14 19 vss 0.000656976f $X=0.459 $Y=0.1525
c15 20 vss 0.0008392f $X=0.54 $Y=0.131
r1 13 3 0.231482 $w=5.4e-08 $l=1.25e-08 $layer=P_src_drn $thickness=1e-09
+ $X=0.3635 $Y=0.189 $X2=0.378 $Y2=0.2295
r2 63 62 0.0925926 $w=2.7e-08 $l=2.5e-09 $layer=P_src_drn $thickness=1e-09
+ $X=0.3953 $Y=0.2295 $X2=0.3925 $Y2=0.2295
r3 61 62 0.166667 $w=2.7e-08 $l=4.5e-09 $layer=P_src_drn $thickness=1e-09
+ $X=0.388 $Y=0.2295 $X2=0.3925 $Y2=0.2295
r4 3 61 0.444445 $w=2.7e-08 $l=1.2e-08 $layer=P_src_drn $thickness=1e-09
+ $X=0.378 $Y=0.2295 $X2=0.388 $Y2=0.2295
r5 12 3 0.462963 $w=2.7e-08 $l=1.25e-08 $layer=P_src_drn $thickness=1e-09
+ $X=0.3635 $Y=0.2295 $X2=0.378 $Y2=0.2295
r6 60 12 0.0925926 $w=2.7e-08 $l=2.5e-09 $layer=P_src_drn $thickness=1e-09
+ $X=0.3606 $Y=0.2025 $X2=0.3635 $Y2=0.2295
r7 3 48 19.3796 $a=3.24e-16 $layer=V0LISD $X=0.378 $Y=0.2295 $X2=0.378 $Y2=0.234
r8 11 42 0.231482 $w=5.4e-08 $l=1.25e-08 $layer=N_src_drn $thickness=1e-09
+ $X=0.4175 $Y=0.081 $X2=0.432 $Y2=0.0685
r9 54 53 0.0925926 $w=2.7e-08 $l=2.5e-09 $layer=N_src_drn $thickness=1e-09
+ $X=0.4493 $Y=0.0405 $X2=0.4465 $Y2=0.0405
r10 52 53 0.166667 $w=2.7e-08 $l=4.5e-09 $layer=N_src_drn $thickness=1e-09
+ $X=0.442 $Y=0.0405 $X2=0.4465 $Y2=0.0405
r11 42 52 0.444445 $w=2.7e-08 $l=1.2e-08 $layer=N_src_drn $thickness=1e-09
+ $X=0.432 $Y=0.0685 $X2=0.442 $Y2=0.0405
r12 10 42 0.462963 $w=2.7e-08 $l=1.25e-08 $layer=N_src_drn $thickness=1e-09
+ $X=0.4175 $Y=0.0405 $X2=0.432 $Y2=0.0685
r13 51 10 0.0925926 $w=2.7e-08 $l=2.5e-09 $layer=N_src_drn $thickness=1e-09
+ $X=0.4146 $Y=0.0675 $X2=0.4175 $Y2=0.0405
r14 48 49 3.14806 $w=1.3e-08 $l=1.35e-08 $layer=M1 $thickness=3.6e-08 $X=0.378
+ $Y=0.234 $X2=0.3915 $Y2=0.234
r15 46 49 3.14806 $w=1.3e-08 $l=1.35e-08 $layer=M1 $thickness=3.6e-08 $X=0.405
+ $Y=0.234 $X2=0.3915 $Y2=0.234
r16 45 46 2.56509 $w=1.3e-08 $l=1.1e-08 $layer=M1 $thickness=3.6e-08 $X=0.416
+ $Y=0.234 $X2=0.405 $Y2=0.234
r17 17 45 4.19742 $w=1.3e-08 $l=1.8e-08 $layer=M1 $thickness=3.6e-08 $X=0.434
+ $Y=0.234 $X2=0.416 $Y2=0.234
r18 4 40 19.3796 $a=3.24e-16 $layer=V0LISD $X=0.432 $Y=0.0405 $X2=0.432
+ $Y2=0.036
r19 4 42 16.5033 $w=2.02e-08 $l=2.8e-08 $layer=LISD $thickness=2.7e-08 $X=0.432
+ $Y=0.0405 $X2=0.432 $Y2=0.0685
r20 16 38 3.01468 $w=1.741e-08 $l=2e-08 $layer=M1 $thickness=3.6e-08 $X=0.459
+ $Y=0.234 $X2=0.459 $Y2=0.214
r21 16 17 4.18063 $w=1.48e-08 $l=2.5e-08 $layer=M1 $thickness=3.6e-08 $X=0.459
+ $Y=0.234 $X2=0.434 $Y2=0.234
r22 40 41 3.14806 $w=1.3e-08 $l=1.35e-08 $layer=M1 $thickness=3.6e-08 $X=0.432
+ $Y=0.036 $X2=0.4455 $Y2=0.036
r23 14 35 5.11582 $w=1.46667e-08 $l=2.7e-08 $layer=M1 $thickness=3.6e-08
+ $X=0.459 $Y=0.036 $X2=0.459 $Y2=0.063
r24 14 41 1.96775 $w=1.63333e-08 $l=1.35e-08 $layer=M1 $thickness=3.6e-08
+ $X=0.459 $Y=0.036 $X2=0.4455 $Y2=0.036
r25 37 38 6.7625 $w=1.3e-08 $l=2.9e-08 $layer=M1 $thickness=3.6e-08 $X=0.459
+ $Y=0.185 $X2=0.459 $Y2=0.214
r26 36 37 4.43061 $w=1.3e-08 $l=1.9e-08 $layer=M1 $thickness=3.6e-08 $X=0.459
+ $Y=0.166 $X2=0.459 $Y2=0.185
r27 19 36 3.14806 $w=1.3e-08 $l=1.35e-08 $layer=M1 $thickness=3.6e-08 $X=0.459
+ $Y=0.1525 $X2=0.459 $Y2=0.166
r28 34 35 6.29612 $w=1.3e-08 $l=2.7e-08 $layer=M1 $thickness=3.6e-08 $X=0.459
+ $Y=0.09 $X2=0.459 $Y2=0.063
r29 33 34 2.91487 $w=1.3e-08 $l=1.25e-08 $layer=M1 $thickness=3.6e-08 $X=0.459
+ $Y=0.1025 $X2=0.459 $Y2=0.09
r30 18 33 2.68168 $w=1.3e-08 $l=1.15e-08 $layer=M1 $thickness=3.6e-08 $X=0.459
+ $Y=0.114 $X2=0.459 $Y2=0.1025
r31 15 31 4.18306 $w=1.49565e-08 $l=2.3e-08 $layer=M1 $thickness=3.6e-08
+ $X=0.459 $Y=0.131 $X2=0.482 $Y2=0.131
r32 15 18 2.78392 $w=1.56471e-08 $l=1.7e-08 $layer=M1 $thickness=3.6e-08
+ $X=0.459 $Y=0.131 $X2=0.459 $Y2=0.114
r33 15 19 3.83327 $w=1.5093e-08 $l=2.15e-08 $layer=M1 $thickness=3.6e-08
+ $X=0.459 $Y=0.131 $X2=0.459 $Y2=0.1525
r34 30 31 4.19742 $w=1.3e-08 $l=1.8e-08 $layer=M1 $thickness=3.6e-08 $X=0.5
+ $Y=0.131 $X2=0.482 $Y2=0.131
r35 29 30 3.03147 $w=1.3e-08 $l=1.3e-08 $layer=M1 $thickness=3.6e-08 $X=0.513
+ $Y=0.131 $X2=0.5 $Y2=0.131
r36 20 28 6.29612 $w=1.3e-08 $l=2.7e-08 $layer=M1 $thickness=3.6e-08 $X=0.54
+ $Y=0.131 $X2=0.567 $Y2=0.131
r37 20 29 6.29612 $w=1.3e-08 $l=2.7e-08 $layer=M1 $thickness=3.6e-08 $X=0.54
+ $Y=0.131 $X2=0.513 $Y2=0.131
r38 27 28 19.3796 $a=3.24e-16 $layer=V0LIG $X=0.567 $Y=0.133 $X2=0.567 $Y2=0.131
r39 1 23 5.58398 $w=1.91607e-08 $l=9e-09 $layer=Gate_1 $thickness=5.45714e-08
+ $X=0.567 $Y=0.1215 $X2=0.567 $Y2=0.1305
r40 1 27 6.79332 $w=1.53e-08 $l=1.15e-08 $layer=LIG $thickness=4.8e-08 $X=0.567
+ $Y=0.1215 $X2=0.567 $Y2=0.133
r41 25 24 17.177 $w=2.1e-08 $l=5.05e-08 $layer=Gate_1 $thickness=5.6e-08
+ $X=0.567 $Y=0.2295 $X2=0.567 $Y2=0.179
r42 23 24 16.6923 $w=2.07629e-08 $l=4.85e-08 $layer=Gate_1 $thickness=5.6e-08
+ $X=0.567 $Y=0.1305 $X2=0.567 $Y2=0.179
r43 22 23 15.1617 $w=2.07386e-08 $l=4.4e-08 $layer=Gate_1 $thickness=5.6e-08
+ $X=0.567 $Y=0.0865 $X2=0.567 $Y2=0.1305
r44 21 22 15.6464 $w=2.1e-08 $l=4.6e-08 $layer=Gate_1 $thickness=5.6e-08
+ $X=0.567 $Y=0.0405 $X2=0.567 $Y2=0.0865
r45 21 9 5.44221 $w=2.1e-08 $l=1.6e-08 $layer=Gate_1 $thickness=5.6e-08
+ $X=0.567 $Y=0.0405 $X2=0.567 $Y2=0.0245
.ends

.subckt PM_DFFLQx4_ASAP7_75t_R%4 vss 41 47 95 104 108 113 116 118 23 24 26 27 9
+ 8 33 21 22 32 31 1 30 36 28 16 34 2 17 4 5 35 3 10 18 20 19
c1 1 vss 0.00233934f $X=0.135 $Y=0.135
c2 2 vss 0.000505106f $X=0.351 $Y=0.135
c3 3 vss 7.75729e-20 $X=0.459 $Y=0.178
c4 4 vss 4.35482e-20 $X=0.621 $Y=0.178
c5 5 vss 0.000934205f $X=0.729 $Y=0.178
c6 8 vss 0.00830728f $X=0.054 $Y=0.054
c7 9 vss 0.00822871f $X=0.054 $Y=0.216
c8 10 vss 0.00457677f $X=0.501 $Y=0.178
c9 16 vss 0.0708136f $X=0.135 $Y=0.0245
c10 17 vss 0.00795728f $X=0.351 $Y=0.135
c11 18 vss 0.00668344f $X=0.459 $Y=0.178
c12 19 vss 0.00616124f $X=0.621 $Y=0.178
c13 20 vss 0.00737809f $X=0.729 $Y=0.178
c14 21 vss 0.0329266f $X=0.056 $Y=0.054
c15 22 vss 0.0329335f $X=0.056 $Y=0.216
c16 23 vss 0.004293f $X=0.018 $Y=0.036
c17 24 vss 0.00331665f $X=0.0165 $Y=0.189
c18 25 vss 0.00410487f $X=0.018 $Y=0.234
c19 26 vss 0.00146453f $X=0.189 $Y=0.189
c20 27 vss 0.000717248f $X=0.189 $Y=0.135
c21 28 vss 0.0122284f $X=0.018 $Y=0.172
c22 29 vss 0.00258643f $X=0.018 $Y=0.199
c23 30 vss 0.00499991f $X=0.036 $Y=0.036
c24 31 vss 0.00396113f $X=0.036 $Y=0.234
c25 32 vss 0.00137471f $X=0.1235 $Y=0.135
c26 33 vss 0.0005087f $X=0.189 $Y=0.154
c27 34 vss 0.0013372f $X=0.351 $Y=0.1735
c28 35 vss 0.00148332f $X=0.513 $Y=0.168
c29 36 vss 0.0327809f $X=0.0215 $Y=0.189
r1 118 117 0.0462963 $w=5.4e-08 $l=2.5e-09 $layer=P_src_drn $thickness=1e-09
+ $X=0.0713 $Y=0.216 $X2=0.0685 $Y2=0.216
r2 22 117 0.231482 $w=5.4e-08 $l=1.25e-08 $layer=P_src_drn $thickness=1e-09
+ $X=0.056 $Y=0.216 $X2=0.0685 $Y2=0.216
r3 116 115 0.0462963 $w=5.4e-08 $l=2.5e-09 $layer=N_src_drn $thickness=1e-09
+ $X=0.0713 $Y=0.054 $X2=0.0685 $Y2=0.054
r4 21 115 0.231482 $w=5.4e-08 $l=1.25e-08 $layer=N_src_drn $thickness=1e-09
+ $X=0.056 $Y=0.054 $X2=0.0685 $Y2=0.054
r5 9 101 19.3796 $a=3.24e-16 $layer=V0LISD $X=0.054 $Y=0.216 $X2=0.055 $Y2=0.234
r6 8 98 19.3796 $a=3.24e-16 $layer=V0LISD $X=0.054 $Y=0.054 $X2=0.055 $Y2=0.036
r7 113 112 8.84359 $w=2.1e-08 $l=2.6e-08 $layer=Gate_1 $thickness=5.6e-08
+ $X=0.729 $Y=0.2295 $X2=0.729 $Y2=0.2035
r8 20 112 8.89461 $w=2.04902e-08 $l=2.55e-08 $layer=Gate_1 $thickness=5.6e-08
+ $X=0.729 $Y=0.178 $X2=0.729 $Y2=0.2035
r9 108 109 23.4695 $w=2.1e-08 $l=6.9e-08 $layer=Gate_1 $thickness=5.6e-08
+ $X=0.621 $Y=0.0405 $X2=0.621 $Y2=0.1095
r10 19 109 23.5205 $w=2.08102e-08 $l=6.85e-08 $layer=Gate_1 $thickness=5.6e-08
+ $X=0.621 $Y=0.178 $X2=0.621 $Y2=0.1095
r11 104 105 23.4695 $w=2.1e-08 $l=6.9e-08 $layer=Gate_1 $thickness=5.6e-08
+ $X=0.459 $Y=0.0405 $X2=0.459 $Y2=0.1095
r12 18 105 23.5205 $w=2.08102e-08 $l=6.85e-08 $layer=Gate_1 $thickness=5.6e-08
+ $X=0.459 $Y=0.178 $X2=0.459 $Y2=0.1095
r13 100 101 2.09871 $w=1.3e-08 $l=9e-09 $layer=M1 $thickness=3.6e-08 $X=0.046
+ $Y=0.234 $X2=0.055 $Y2=0.234
r14 31 100 2.3319 $w=1.3e-08 $l=1e-08 $layer=M1 $thickness=3.6e-08 $X=0.036
+ $Y=0.234 $X2=0.046 $Y2=0.234
r15 97 98 2.09871 $w=1.3e-08 $l=9e-09 $layer=M1 $thickness=3.6e-08 $X=0.046
+ $Y=0.036 $X2=0.055 $Y2=0.036
r16 30 97 2.3319 $w=1.3e-08 $l=1e-08 $layer=M1 $thickness=3.6e-08 $X=0.036
+ $Y=0.036 $X2=0.046 $Y2=0.036
r17 5 92 2.78395 $w=2.4e-08 $l=4e-09 $layer=LIG $thickness=4.8e-08 $X=0.729
+ $Y=0.178 $X2=0.725 $Y2=0.178
r18 5 20 7.42683 $w=2.2e-08 $layer=Gate_1 $thickness=5.2e-08 $X=0.729 $Y=0.178
+ $X2=0.729 $Y2=0.178
r19 4 87 10.3807 $w=2.30357e-08 $layer=LISD $thickness=3.675e-08 $X=0.621
+ $Y=0.178 $X2=0.621 $Y2=0.178
r20 4 19 7.42683 $w=2.2e-08 $layer=Gate_1 $thickness=5.2e-08 $X=0.621 $Y=0.178
+ $X2=0.621 $Y2=0.178
r21 3 83 2.78395 $w=2.4e-08 $l=5e-09 $layer=LIG $thickness=4.8e-08 $X=0.459
+ $Y=0.178 $X2=0.464 $Y2=0.178
r22 3 18 7.42683 $w=2.2e-08 $layer=Gate_1 $thickness=5.2e-08 $X=0.459 $Y=0.178
+ $X2=0.459 $Y2=0.178
r23 95 94 16.4967 $w=2.1e-08 $l=4.85e-08 $layer=Gate_1 $thickness=5.6e-08
+ $X=0.351 $Y=0.2025 $X2=0.351 $Y2=0.154
r24 17 94 6.6497 $w=2.04211e-08 $l=1.9e-08 $layer=Gate_1 $thickness=5.6e-08
+ $X=0.351 $Y=0.135 $X2=0.351 $Y2=0.154
r25 25 79 3.36447 $w=1.71023e-08 $l=2.15e-08 $layer=M1 $thickness=3.6e-08
+ $X=0.018 $Y=0.234 $X2=0.018 $Y2=0.2125
r26 25 31 2.5483 $w=1.55e-08 $l=1.8e-08 $layer=M1 $thickness=3.6e-08 $X=0.018
+ $Y=0.234 $X2=0.036 $Y2=0.234
r27 23 78 3.36447 $w=1.71023e-08 $l=2.15e-08 $layer=M1 $thickness=3.6e-08
+ $X=0.018 $Y=0.036 $X2=0.018 $Y2=0.0575
r28 23 30 2.5483 $w=1.55e-08 $l=1.8e-08 $layer=M1 $thickness=3.6e-08 $X=0.018
+ $Y=0.036 $X2=0.036 $Y2=0.036
r29 91 92 4.8113 $w=2.22e-08 $l=1.5e-09 $layer=LISD $thickness=2.7e-08
+ $X=0.7235 $Y=0.178 $X2=0.725 $Y2=0.178
r30 90 91 10.8887 $w=2.22e-08 $l=2.15e-08 $layer=LISD $thickness=2.7e-08
+ $X=0.702 $Y=0.178 $X2=0.7235 $Y2=0.178
r31 89 90 13.6742 $w=2.22e-08 $l=2.7e-08 $layer=LISD $thickness=2.7e-08
+ $X=0.675 $Y=0.178 $X2=0.702 $Y2=0.178
r32 88 89 13.6742 $w=2.22e-08 $l=2.7e-08 $layer=LISD $thickness=2.7e-08
+ $X=0.648 $Y=0.178 $X2=0.675 $Y2=0.178
r33 87 88 13.6742 $w=2.22e-08 $l=2.7e-08 $layer=LISD $thickness=2.7e-08
+ $X=0.621 $Y=0.178 $X2=0.648 $Y2=0.178
r34 86 87 13.6742 $w=2.22e-08 $l=2.7e-08 $layer=LISD $thickness=2.7e-08
+ $X=0.594 $Y=0.178 $X2=0.621 $Y2=0.178
r35 85 86 13.6742 $w=2.22e-08 $l=2.7e-08 $layer=LISD $thickness=2.7e-08
+ $X=0.567 $Y=0.178 $X2=0.594 $Y2=0.178
r36 84 85 13.6742 $w=2.22e-08 $l=2.7e-08 $layer=LISD $thickness=2.7e-08 $X=0.54
+ $Y=0.178 $X2=0.567 $Y2=0.178
r37 82 83 10.3823 $w=2.22e-08 $l=1.35e-08 $layer=LISD $thickness=2.7e-08
+ $X=0.4775 $Y=0.178 $X2=0.464 $Y2=0.178
r38 81 84 7.59679 $w=2.22e-08 $l=1.5e-08 $layer=LISD $thickness=2.7e-08
+ $X=0.525 $Y=0.178 $X2=0.54 $Y2=0.178
r39 80 81 6.07743 $w=2.22e-08 $l=1.2e-08 $layer=LISD $thickness=2.7e-08
+ $X=0.513 $Y=0.178 $X2=0.525 $Y2=0.178
r40 10 80 6.07743 $w=2.22e-08 $l=1.2e-08 $layer=LISD $thickness=2.7e-08
+ $X=0.501 $Y=0.178 $X2=0.513 $Y2=0.178
r41 10 82 11.9016 $w=2.22e-08 $l=2.35e-08 $layer=LISD $thickness=2.7e-08
+ $X=0.501 $Y=0.178 $X2=0.4775 $Y2=0.178
r42 2 72 19.3796 $a=3.24e-16 $layer=V0LIG $X=0.351 $Y=0.135 $X2=0.351 $Y2=0.135
r43 2 17 10.4265 $w=1.765e-08 $layer=LIG $thickness=5.2e-08 $X=0.351 $Y=0.135
+ $X2=0.351 $Y2=0.135
r44 29 79 3.14806 $w=1.3e-08 $l=1.35e-08 $layer=M1 $thickness=3.6e-08 $X=0.018
+ $Y=0.199 $X2=0.018 $Y2=0.2125
r45 77 78 7.11229 $w=1.3e-08 $l=3.05e-08 $layer=M1 $thickness=3.6e-08 $X=0.018
+ $Y=0.088 $X2=0.018 $Y2=0.0575
r46 76 77 10.9599 $w=1.3e-08 $l=4.7e-08 $layer=M1 $thickness=3.6e-08 $X=0.018
+ $Y=0.135 $X2=0.018 $Y2=0.088
r47 28 76 8.62802 $w=1.3e-08 $l=3.7e-08 $layer=M1 $thickness=3.6e-08 $X=0.018
+ $Y=0.172 $X2=0.018 $Y2=0.135
r48 74 80 19.3796 $a=3.24e-16 $layer=V0LISD $X=0.513 $Y=0.1845 $X2=0.513
+ $Y2=0.178
r49 35 74 3.84763 $w=1.3e-08 $l=1.65e-08 $layer=M1 $thickness=3.6e-08 $X=0.513
+ $Y=0.168 $X2=0.513 $Y2=0.1845
r50 72 73 4.78039 $w=1.3e-08 $l=2.05e-08 $layer=M1 $thickness=3.6e-08 $X=0.351
+ $Y=0.135 $X2=0.351 $Y2=0.1555
r51 34 70 3.61444 $w=1.3e-08 $l=1.55e-08 $layer=M1 $thickness=3.6e-08 $X=0.351
+ $Y=0.1735 $X2=0.351 $Y2=0.189
r52 34 73 4.19742 $w=1.3e-08 $l=1.8e-08 $layer=M1 $thickness=3.6e-08 $X=0.351
+ $Y=0.1735 $X2=0.351 $Y2=0.1555
r53 67 68 1.90199 $w=1.38333e-08 $l=9e-09 $layer=M1 $thickness=3.6e-08
+ $X=0.0255 $Y=0.189 $X2=0.0345 $Y2=0.189
r54 24 67 0.9184 $w=1.8e-08 $l=9e-09 $layer=M1 $thickness=3.6e-08 $X=0.0165
+ $Y=0.189 $X2=0.0255 $Y2=0.189
r55 24 28 2.63085 $w=1.54194e-08 $l=1.7066e-08 $layer=M1 $thickness=3.6e-08
+ $X=0.0165 $Y=0.189 $X2=0.018 $Y2=0.172
r56 24 29 0.998523 $w=1.74118e-08 $l=1.01119e-08 $layer=M1 $thickness=3.6e-08
+ $X=0.0165 $Y=0.189 $X2=0.018 $Y2=0.199
r57 65 74 19.5347 $a=3.24e-16 $layer=V1 $X=0.513 $Y=0.189 $X2=0.513 $Y2=0.1845
r58 64 65 18.8884 $w=1.3e-08 $l=8.1e-08 $layer=M2 $thickness=3.6e-08 $X=0.432
+ $Y=0.189 $X2=0.513 $Y2=0.189
r59 63 64 18.8884 $w=1.3e-08 $l=8.1e-08 $layer=M2 $thickness=3.6e-08 $X=0.351
+ $Y=0.189 $X2=0.432 $Y2=0.189
r60 63 70 19.5347 $a=3.24e-16 $layer=V1 $X=0.351 $Y=0.189 $X2=0.351 $Y2=0.189
r61 62 63 15.2739 $w=1.3e-08 $l=6.55e-08 $layer=M2 $thickness=3.6e-08 $X=0.2855
+ $Y=0.189 $X2=0.351 $Y2=0.189
r62 61 62 20.2875 $w=1.3e-08 $l=8.7e-08 $layer=M2 $thickness=3.6e-08 $X=0.1985
+ $Y=0.189 $X2=0.2855 $Y2=0.189
r63 60 61 9.211 $w=1.3e-08 $l=3.95e-08 $layer=M2 $thickness=3.6e-08 $X=0.159
+ $Y=0.189 $X2=0.1985 $Y2=0.189
r64 59 60 14.691 $w=1.3e-08 $l=6.3e-08 $layer=M2 $thickness=3.6e-08 $X=0.096
+ $Y=0.189 $X2=0.159 $Y2=0.189
r65 58 59 14.691 $w=1.3e-08 $l=6.3e-08 $layer=M2 $thickness=3.6e-08 $X=0.033
+ $Y=0.189 $X2=0.096 $Y2=0.189
r66 58 68 19.5347 $a=3.24e-16 $layer=V1 $X=0.033 $Y=0.189 $X2=0.0345 $Y2=0.189
r67 36 58 2.68168 $w=1.3e-08 $l=1.15e-08 $layer=M2 $thickness=3.6e-08 $X=0.0215
+ $Y=0.189 $X2=0.033 $Y2=0.189
r68 55 56 3.49785 $w=1.3e-08 $l=1.5e-08 $layer=M1 $thickness=3.6e-08 $X=0.159
+ $Y=0.189 $X2=0.174 $Y2=0.189
r69 55 60 19.5347 $a=3.24e-16 $layer=V1 $X=0.159 $Y=0.189 $X2=0.159 $Y2=0.189
r70 26 53 2.78392 $w=1.56471e-08 $l=1.7e-08 $layer=M1 $thickness=3.6e-08
+ $X=0.189 $Y=0.189 $X2=0.189 $Y2=0.172
r71 26 56 2.31754 $w=1.6e-08 $l=1.5e-08 $layer=M1 $thickness=3.6e-08 $X=0.189
+ $Y=0.189 $X2=0.174 $Y2=0.189
r72 33 53 4.19742 $w=1.3e-08 $l=1.8e-08 $layer=M1 $thickness=3.6e-08 $X=0.189
+ $Y=0.154 $X2=0.189 $Y2=0.172
r73 27 52 4.18063 $w=1.48e-08 $l=2.5e-08 $layer=M1 $thickness=3.6e-08 $X=0.189
+ $Y=0.135 $X2=0.164 $Y2=0.135
r74 27 33 2.78149 $w=1.76421e-08 $l=1.9e-08 $layer=M1 $thickness=3.6e-08
+ $X=0.189 $Y=0.135 $X2=0.189 $Y2=0.154
r75 51 52 4.08082 $w=1.3e-08 $l=1.75e-08 $layer=M1 $thickness=3.6e-08 $X=0.1465
+ $Y=0.135 $X2=0.164 $Y2=0.135
r76 50 51 0.46638 $w=1.3e-08 $l=2e-09 $layer=M1 $thickness=3.6e-08 $X=0.1445
+ $Y=0.135 $X2=0.1465 $Y2=0.135
r77 49 50 2.2153 $w=1.3e-08 $l=9.5e-09 $layer=M1 $thickness=3.6e-08 $X=0.135
+ $Y=0.135 $X2=0.1445 $Y2=0.135
r78 32 49 2.68168 $w=1.3e-08 $l=1.15e-08 $layer=M1 $thickness=3.6e-08 $X=0.1235
+ $Y=0.135 $X2=0.135 $Y2=0.135
r79 1 44 10.4265 $w=1.765e-08 $layer=LIG $thickness=5.2e-08 $X=0.135 $Y=0.135
+ $X2=0.135 $Y2=0.135
r80 1 49 19.3796 $a=3.24e-16 $layer=V0LIG $X=0.135 $Y=0.135 $X2=0.135 $Y2=0.135
r81 47 46 14.6259 $w=2.1e-08 $l=4.3e-08 $layer=Gate_1 $thickness=5.6e-08
+ $X=0.135 $Y=0.216 $X2=0.135 $Y2=0.173
r82 45 46 7.31297 $w=2.1e-08 $l=2.15e-08 $layer=Gate_1 $thickness=5.6e-08
+ $X=0.135 $Y=0.1515 $X2=0.135 $Y2=0.173
r83 44 45 5.79936 $w=2.03333e-08 $l=1.65e-08 $layer=Gate_1 $thickness=5.6e-08
+ $X=0.135 $Y=0.135 $X2=0.135 $Y2=0.1515
r84 43 44 5.79936 $w=2.03333e-08 $l=1.65e-08 $layer=Gate_1 $thickness=5.6e-08
+ $X=0.135 $Y=0.1185 $X2=0.135 $Y2=0.135
r85 42 43 7.31297 $w=2.1e-08 $l=2.15e-08 $layer=Gate_1 $thickness=5.6e-08
+ $X=0.135 $Y=0.097 $X2=0.135 $Y2=0.1185
r86 41 42 14.6259 $w=2.1e-08 $l=4.3e-08 $layer=Gate_1 $thickness=5.6e-08
+ $X=0.135 $Y=0.054 $X2=0.135 $Y2=0.097
r87 41 16 10.0341 $w=2.1e-08 $l=2.95e-08 $layer=Gate_1 $thickness=5.6e-08
+ $X=0.135 $Y=0.054 $X2=0.135 $Y2=0.0245
r88 9 22 1e-05 $l=2e-09 $X=0.054 $Y=0.216 $X2=0.056 $Y2=0.216
r89 8 21 1e-05 $l=2e-09 $X=0.054 $Y=0.054 $X2=0.056 $Y2=0.054
.ends

.subckt PM_DFFLQx4_ASAP7_75t_R%6 vss 26 30 61 64 67 69 19 5 6 18 17 14 12 16 13
+ 22 11 2 21 20 1 15
c1 1 vss 0.000376f $X=0.405 $Y=0.133
c2 2 vss 0.00043243f $X=0.675 $Y=0.135
c3 5 vss 0.00775841f $X=0.162 $Y=0.054
c4 6 vss 0.0075487f $X=0.162 $Y=0.216
c5 11 vss 0.00749591f $X=0.405 $Y=0.0245
c6 12 vss 0.00772515f $X=0.675 $Y=0.135
c7 13 vss 0.0325699f $X=0.1475 $Y=0.054
c8 14 vss 0.0326378f $X=0.1475 $Y=0.216
c9 15 vss 0.00308542f $X=0.243 $Y=0.036
c10 16 vss 0.00281543f $X=0.243 $Y=0.234
c11 17 vss 0.00927038f $X=0.216 $Y=0.036
c12 18 vss 0.00835507f $X=0.216 $Y=0.234
c13 19 vss 0.0072691f $X=0.243 $Y=0.135
c14 20 vss 0.000999896f $X=0.405 $Y=0.116
c15 21 vss 0.00196789f $X=0.675 $Y=0.1125
c16 22 vss 0.0193092f $X=0.2315 $Y=0.153
r1 14 6 0.231482 $w=5.4e-08 $l=1.25e-08 $layer=P_src_drn $thickness=1e-09
+ $X=0.1475 $Y=0.216 $X2=0.162 $Y2=0.216
r2 69 14 0.0462963 $w=5.4e-08 $l=2.5e-09 $layer=P_src_drn $thickness=1e-09
+ $X=0.1446 $Y=0.216 $X2=0.1475 $Y2=0.216
r3 13 5 0.231482 $w=5.4e-08 $l=1.25e-08 $layer=N_src_drn $thickness=1e-09
+ $X=0.1475 $Y=0.054 $X2=0.162 $Y2=0.054
r4 67 13 0.0462963 $w=5.4e-08 $l=2.5e-09 $layer=N_src_drn $thickness=1e-09
+ $X=0.1446 $Y=0.054 $X2=0.1475 $Y2=0.054
r5 6 58 19.3796 $a=3.24e-16 $layer=V0LISD $X=0.162 $Y=0.216 $X2=0.162 $Y2=0.234
r6 5 55 19.3796 $a=3.24e-16 $layer=V0LISD $X=0.162 $Y=0.054 $X2=0.162 $Y2=0.036
r7 64 63 16.4967 $w=2.1e-08 $l=4.85e-08 $layer=Gate_1 $thickness=5.6e-08
+ $X=0.675 $Y=0.2295 $X2=0.675 $Y2=0.181
r8 61 62 16.4967 $w=2.1e-08 $l=4.85e-08 $layer=Gate_1 $thickness=5.6e-08
+ $X=0.675 $Y=0.0405 $X2=0.675 $Y2=0.089
r9 12 62 15.8334 $w=2.07609e-08 $l=4.6e-08 $layer=Gate_1 $thickness=5.6e-08
+ $X=0.675 $Y=0.135 $X2=0.675 $Y2=0.089
r10 12 63 15.8334 $w=2.07609e-08 $l=4.6e-08 $layer=Gate_1 $thickness=5.6e-08
+ $X=0.675 $Y=0.135 $X2=0.675 $Y2=0.181
r11 58 59 5.24677 $w=1.3e-08 $l=2.25e-08 $layer=M1 $thickness=3.6e-08 $X=0.162
+ $Y=0.234 $X2=0.1845 $Y2=0.234
r12 18 59 7.34548 $w=1.3e-08 $l=3.15e-08 $layer=M1 $thickness=3.6e-08 $X=0.216
+ $Y=0.234 $X2=0.1845 $Y2=0.234
r13 55 56 5.24677 $w=1.3e-08 $l=2.25e-08 $layer=M1 $thickness=3.6e-08 $X=0.162
+ $Y=0.036 $X2=0.1845 $Y2=0.036
r14 17 56 7.34548 $w=1.3e-08 $l=3.15e-08 $layer=M1 $thickness=3.6e-08 $X=0.216
+ $Y=0.036 $X2=0.1845 $Y2=0.036
r15 2 50 19.3796 $a=3.24e-16 $layer=V0LIG $X=0.675 $Y=0.135 $X2=0.675 $Y2=0.144
r16 2 12 6.54019 $w=2.09524e-08 $layer=Gate_1 $thickness=5.21905e-08 $X=0.675
+ $Y=0.135 $X2=0.675 $Y2=0.135
r17 16 49 3.36447 $w=1.71023e-08 $l=2.15e-08 $layer=M1 $thickness=3.6e-08
+ $X=0.243 $Y=0.234 $X2=0.243 $Y2=0.2125
r18 16 18 4.64701 $w=1.46667e-08 $l=2.7e-08 $layer=M1 $thickness=3.6e-08
+ $X=0.243 $Y=0.234 $X2=0.216 $Y2=0.234
r19 15 46 3.36447 $w=1.71023e-08 $l=2.15e-08 $layer=M1 $thickness=3.6e-08
+ $X=0.243 $Y=0.036 $X2=0.243 $Y2=0.0575
r20 15 17 4.64701 $w=1.46667e-08 $l=2.7e-08 $layer=M1 $thickness=3.6e-08
+ $X=0.243 $Y=0.036 $X2=0.216 $Y2=0.036
r21 21 50 7.34548 $w=1.3e-08 $l=3.15e-08 $layer=M1 $thickness=3.6e-08 $X=0.675
+ $Y=0.1125 $X2=0.675 $Y2=0.144
r22 48 49 3.14806 $w=1.3e-08 $l=1.35e-08 $layer=M1 $thickness=3.6e-08 $X=0.243
+ $Y=0.199 $X2=0.243 $Y2=0.2125
r23 47 48 2.3319 $w=1.3e-08 $l=1e-08 $layer=M1 $thickness=3.6e-08 $X=0.243
+ $Y=0.189 $X2=0.243 $Y2=0.199
r24 45 46 7.11229 $w=1.3e-08 $l=3.05e-08 $layer=M1 $thickness=3.6e-08 $X=0.243
+ $Y=0.088 $X2=0.243 $Y2=0.0575
r25 44 45 6.52931 $w=1.3e-08 $l=2.8e-08 $layer=M1 $thickness=3.6e-08 $X=0.243
+ $Y=0.116 $X2=0.243 $Y2=0.088
r26 43 47 4.19742 $w=1.3e-08 $l=1.8e-08 $layer=M1 $thickness=3.6e-08 $X=0.243
+ $Y=0.171 $X2=0.243 $Y2=0.189
r27 42 43 4.19742 $w=1.3e-08 $l=1.8e-08 $layer=M1 $thickness=3.6e-08 $X=0.243
+ $Y=0.153 $X2=0.243 $Y2=0.171
r28 19 42 4.19742 $w=1.3e-08 $l=1.8e-08 $layer=M1 $thickness=3.6e-08 $X=0.243
+ $Y=0.135 $X2=0.243 $Y2=0.153
r29 19 44 4.43061 $w=1.3e-08 $l=1.9e-08 $layer=M1 $thickness=3.6e-08 $X=0.243
+ $Y=0.135 $X2=0.243 $Y2=0.116
r30 40 50 19.5347 $a=3.24e-16 $layer=V1 $X=0.675 $Y=0.153 $X2=0.675 $Y2=0.144
r31 39 40 18.3054 $w=1.3e-08 $l=7.85e-08 $layer=M2 $thickness=3.6e-08 $X=0.5965
+ $Y=0.153 $X2=0.675 $Y2=0.153
r32 38 39 29.3819 $w=1.3e-08 $l=1.26e-07 $layer=M2 $thickness=3.6e-08 $X=0.4705
+ $Y=0.153 $X2=0.5965 $Y2=0.153
r33 37 38 15.2739 $w=1.3e-08 $l=6.55e-08 $layer=M2 $thickness=3.6e-08 $X=0.405
+ $Y=0.153 $X2=0.4705 $Y2=0.153
r34 36 37 18.8884 $w=1.3e-08 $l=8.1e-08 $layer=M2 $thickness=3.6e-08 $X=0.324
+ $Y=0.153 $X2=0.405 $Y2=0.153
r35 35 36 18.8884 $w=1.3e-08 $l=8.1e-08 $layer=M2 $thickness=3.6e-08 $X=0.243
+ $Y=0.153 $X2=0.324 $Y2=0.153
r36 35 42 19.5347 $a=3.24e-16 $layer=V1 $X=0.243 $Y=0.153 $X2=0.243 $Y2=0.153
r37 22 35 2.68168 $w=1.3e-08 $l=1.15e-08 $layer=M2 $thickness=3.6e-08 $X=0.2315
+ $Y=0.153 $X2=0.243 $Y2=0.153
r38 33 37 19.5347 $a=3.24e-16 $layer=V1 $X=0.405 $Y=0.144 $X2=0.405 $Y2=0.153
r39 20 33 6.52931 $w=1.3e-08 $l=2.8e-08 $layer=M1 $thickness=3.6e-08 $X=0.405
+ $Y=0.116 $X2=0.405 $Y2=0.144
r40 1 28 9.2451 $w=1.7885e-08 $l=2e-09 $layer=LIG $thickness=5.24e-08 $X=0.405
+ $Y=0.133 $X2=0.405 $Y2=0.135
r41 1 33 19.3796 $a=3.24e-16 $layer=V0LIG $X=0.405 $Y=0.133 $X2=0.405 $Y2=0.144
r42 30 29 16.4967 $w=2.1e-08 $l=4.85e-08 $layer=Gate_1 $thickness=5.6e-08
+ $X=0.405 $Y=0.2295 $X2=0.405 $Y2=0.181
r43 28 29 15.8334 $w=2.07609e-08 $l=4.6e-08 $layer=Gate_1 $thickness=5.6e-08
+ $X=0.405 $Y=0.135 $X2=0.405 $Y2=0.181
r44 27 28 6.6497 $w=2.04211e-08 $l=1.9e-08 $layer=Gate_1 $thickness=5.6e-08
+ $X=0.405 $Y=0.116 $X2=0.405 $Y2=0.135
r45 26 27 16.4967 $w=2.1e-08 $l=4.85e-08 $layer=Gate_1 $thickness=5.6e-08
+ $X=0.405 $Y=0.0675 $X2=0.405 $Y2=0.116
r46 26 11 14.6259 $w=2.1e-08 $l=4.3e-08 $layer=Gate_1 $thickness=5.6e-08
+ $X=0.405 $Y=0.0675 $X2=0.405 $Y2=0.0245
.ends

.subckt PM_DFFLQx4_ASAP7_75t_R%7 vss 20 24 44 45 50 52 3 1 4 12 13 17 19 11 10
+ 18 14 16
c1 1 vss 0.0021552f $X=0.513 $Y=0.09
c2 3 vss 0.00459811f $X=0.594 $Y=0.0405
c3 4 vss 0.00838271f $X=0.594 $Y=0.2295
c4 10 vss 0.0524642f $X=0.513 $Y=0.0245
c5 11 vss 0.00398743f $X=0.5795 $Y=0.0405
c6 12 vss 0.00374465f $X=0.5795 $Y=0.2295
c7 13 vss 0.00335768f $X=0.65 $Y=0.2295
c8 14 vss 0.00052728f $X=0.594 $Y=0.09
c9 15 vss 0.00264192f $X=0.621 $Y=0.234
c10 16 vss 0.00214012f $X=0.5 $Y=0.09
c11 17 vss 0.00401641f $X=0.5965 $Y=0.234
c12 18 vss 0.00321071f $X=0.594 $Y=0.054
c13 19 vss 0.00165029f $X=0.621 $Y=0.1105
r1 52 51 0.0925926 $w=2.7e-08 $l=2.5e-09 $layer=P_src_drn $thickness=1e-09
+ $X=0.6653 $Y=0.2295 $X2=0.6625 $Y2=0.2295
r2 13 51 0.462963 $w=2.7e-08 $l=1.25e-08 $layer=P_src_drn $thickness=1e-09
+ $X=0.65 $Y=0.2295 $X2=0.6625 $Y2=0.2295
r3 12 4 0.462963 $w=2.7e-08 $l=1.25e-08 $layer=P_src_drn $thickness=1e-09
+ $X=0.5795 $Y=0.2295 $X2=0.594 $Y2=0.2295
r4 50 12 0.0925926 $w=2.7e-08 $l=2.5e-09 $layer=P_src_drn $thickness=1e-09
+ $X=0.5766 $Y=0.2295 $X2=0.5795 $Y2=0.2295
r5 47 13 12.6992 $w=2.32e-08 $l=2.7e-08 $layer=LISD $thickness=2.7e-08 $X=0.621
+ $Y=0.2295 $X2=0.65 $Y2=0.2295
r6 4 47 12.6992 $w=2.32e-08 $l=2.7e-08 $layer=LISD $thickness=2.7e-08 $X=0.594
+ $Y=0.2295 $X2=0.621 $Y2=0.2295
r7 4 17 19.3796 $a=3.24e-16 $layer=V0LISD $X=0.594 $Y=0.2295 $X2=0.5965
+ $Y2=0.234
r8 45 43 0.0925926 $w=2.7e-08 $l=2.5e-09 $layer=N_src_drn $thickness=1e-09
+ $X=0.6113 $Y=0.0405 $X2=0.6085 $Y2=0.0405
r9 3 43 0.537037 $w=2.7e-08 $l=1.45e-08 $layer=N_src_drn $thickness=1e-09
+ $X=0.594 $Y=0.0405 $X2=0.6085 $Y2=0.0405
r10 11 3 0.537037 $w=2.7e-08 $l=1.45e-08 $layer=N_src_drn $thickness=1e-09
+ $X=0.5795 $Y=0.0405 $X2=0.594 $Y2=0.0405
r11 44 11 0.0925926 $w=2.7e-08 $l=2.5e-09 $layer=N_src_drn $thickness=1e-09
+ $X=0.5766 $Y=0.0405 $X2=0.5795 $Y2=0.0405
r12 15 39 3.01468 $w=1.741e-08 $l=2e-08 $layer=M1 $thickness=3.6e-08 $X=0.621
+ $Y=0.234 $X2=0.621 $Y2=0.214
r13 15 17 4.06404 $w=1.48367e-08 $l=2.45e-08 $layer=M1 $thickness=3.6e-08
+ $X=0.621 $Y=0.234 $X2=0.5965 $Y2=0.234
r14 3 18 19.3796 $a=3.24e-16 $layer=V0LISD $X=0.594 $Y=0.0405 $X2=0.594
+ $Y2=0.054
r15 38 39 6.7625 $w=1.3e-08 $l=2.9e-08 $layer=M1 $thickness=3.6e-08 $X=0.621
+ $Y=0.185 $X2=0.621 $Y2=0.214
r16 37 38 4.43061 $w=1.3e-08 $l=1.9e-08 $layer=M1 $thickness=3.6e-08 $X=0.621
+ $Y=0.166 $X2=0.621 $Y2=0.185
r17 36 37 3.14806 $w=1.3e-08 $l=1.35e-08 $layer=M1 $thickness=3.6e-08 $X=0.621
+ $Y=0.1525 $X2=0.621 $Y2=0.166
r18 35 36 5.01358 $w=1.3e-08 $l=2.15e-08 $layer=M1 $thickness=3.6e-08 $X=0.621
+ $Y=0.131 $X2=0.621 $Y2=0.1525
r19 19 32 3.60008 $w=1.51951e-08 $l=2.05e-08 $layer=M1 $thickness=3.6e-08
+ $X=0.621 $Y=0.1105 $X2=0.621 $Y2=0.09
r20 19 35 4.78039 $w=1.3e-08 $l=2.05e-08 $layer=M1 $thickness=3.6e-08 $X=0.621
+ $Y=0.1105 $X2=0.621 $Y2=0.131
r21 18 33 4.19742 $w=1.3e-08 $l=1.8e-08 $layer=M1 $thickness=3.6e-08 $X=0.594
+ $Y=0.054 $X2=0.594 $Y2=0.072
r22 31 32 1.96775 $w=1.63333e-08 $l=1.35e-08 $layer=M1 $thickness=3.6e-08
+ $X=0.6075 $Y=0.09 $X2=0.621 $Y2=0.09
r23 14 30 1.38478 $w=1.70909e-08 $l=1.1e-08 $layer=M1 $thickness=3.6e-08
+ $X=0.594 $Y=0.09 $X2=0.583 $Y2=0.09
r24 14 31 1.96775 $w=1.63333e-08 $l=1.35e-08 $layer=M1 $thickness=3.6e-08
+ $X=0.594 $Y=0.09 $X2=0.6075 $Y2=0.09
r25 14 33 3.01711 $w=1.55e-08 $l=1.8e-08 $layer=M1 $thickness=3.6e-08 $X=0.594
+ $Y=0.09 $X2=0.594 $Y2=0.072
r26 29 30 7.34548 $w=1.3e-08 $l=3.15e-08 $layer=M1 $thickness=3.6e-08 $X=0.5515
+ $Y=0.09 $X2=0.583 $Y2=0.09
r27 28 29 8.97781 $w=1.3e-08 $l=3.85e-08 $layer=M1 $thickness=3.6e-08 $X=0.513
+ $Y=0.09 $X2=0.5515 $Y2=0.09
r28 16 28 3.03147 $w=1.3e-08 $l=1.3e-08 $layer=M1 $thickness=3.6e-08 $X=0.5
+ $Y=0.09 $X2=0.513 $Y2=0.09
r29 1 22 6.54019 $w=2.09524e-08 $layer=Gate_1 $thickness=5.21905e-08 $X=0.513
+ $Y=0.09 $X2=0.513 $Y2=0.09
r30 1 28 19.3796 $a=3.24e-16 $layer=V0LIG $X=0.513 $Y=0.09 $X2=0.513 $Y2=0.09
r31 24 23 24.1498 $w=2.1e-08 $l=7.1e-08 $layer=Gate_1 $thickness=5.6e-08
+ $X=0.513 $Y=0.2295 $X2=0.513 $Y2=0.1585
r32 22 23 23.4865 $w=2.08394e-08 $l=6.85e-08 $layer=Gate_1 $thickness=5.6e-08
+ $X=0.513 $Y=0.09 $X2=0.513 $Y2=0.1585
r33 21 22 8.18032 $w=2.05319e-08 $l=2.35e-08 $layer=Gate_1 $thickness=5.6e-08
+ $X=0.513 $Y=0.0665 $X2=0.513 $Y2=0.09
r34 20 21 8.84359 $w=2.1e-08 $l=2.6e-08 $layer=Gate_1 $thickness=5.6e-08
+ $X=0.513 $Y=0.0405 $X2=0.513 $Y2=0.0665
r35 20 10 5.44221 $w=2.1e-08 $l=1.6e-08 $layer=Gate_1 $thickness=5.6e-08
+ $X=0.513 $Y=0.0405 $X2=0.513 $Y2=0.0245
.ends

.subckt PM_DFFLQx4_ASAP7_75t_R%9 vss 19 23 35 44 9 14 18 4 3 1 17 12 15 16 11 10
c1 1 vss 0.00154114f $X=0.783 $Y=0.1055
c2 3 vss 0.00637418f $X=0.864 $Y=0.0405
c3 4 vss 0.00666295f $X=0.864 $Y=0.2295
c4 9 vss 0.0413853f $X=0.783 $Y=0.0245
c5 10 vss 0.018702f $X=0.8495 $Y=0.0405
c6 11 vss 0.0187376f $X=0.8495 $Y=0.2295
c7 12 vss 0.00283216f $X=0.783 $Y=0.036
c8 13 vss 0.00369525f $X=0.945 $Y=0.036
c9 14 vss 0.00364704f $X=0.945 $Y=0.234
c10 15 vss 0.00202176f $X=0.783 $Y=0.0705
c11 16 vss 0.0138964f $X=0.81 $Y=0.036
c12 17 vss 0.00915607f $X=0.918 $Y=0.234
c13 18 vss 0.00880786f $X=0.945 $Y=0.081
r1 11 4 0.462963 $w=2.7e-08 $l=1.25e-08 $layer=P_src_drn $thickness=1e-09
+ $X=0.8495 $Y=0.2295 $X2=0.864 $Y2=0.2295
r2 44 11 0.0925926 $w=2.7e-08 $l=2.5e-09 $layer=P_src_drn $thickness=1e-09
+ $X=0.8466 $Y=0.2295 $X2=0.8495 $Y2=0.2295
r3 4 41 19.3796 $a=3.24e-16 $layer=V0LISD $X=0.864 $Y=0.2295 $X2=0.864 $Y2=0.234
r4 41 42 5.24677 $w=1.3e-08 $l=2.25e-08 $layer=M1 $thickness=3.6e-08 $X=0.864
+ $Y=0.234 $X2=0.8865 $Y2=0.234
r5 17 42 7.34548 $w=1.3e-08 $l=3.15e-08 $layer=M1 $thickness=3.6e-08 $X=0.918
+ $Y=0.234 $X2=0.8865 $Y2=0.234
r6 14 39 6.74572 $w=1.545e-08 $l=3.6e-08 $layer=M1 $thickness=3.6e-08 $X=0.945
+ $Y=0.234 $X2=0.945 $Y2=0.198
r7 14 17 4.64701 $w=1.46667e-08 $l=2.7e-08 $layer=M1 $thickness=3.6e-08
+ $X=0.945 $Y=0.234 $X2=0.918 $Y2=0.234
r8 38 39 6.7625 $w=1.3e-08 $l=2.9e-08 $layer=M1 $thickness=3.6e-08 $X=0.945
+ $Y=0.169 $X2=0.945 $Y2=0.198
r9 37 38 5.71315 $w=1.3e-08 $l=2.45e-08 $layer=M1 $thickness=3.6e-08 $X=0.945
+ $Y=0.1445 $X2=0.945 $Y2=0.169
r10 36 37 5.82974 $w=1.3e-08 $l=2.5e-08 $layer=M1 $thickness=3.6e-08 $X=0.945
+ $Y=0.1195 $X2=0.945 $Y2=0.1445
r11 18 36 8.97781 $w=1.3e-08 $l=3.85e-08 $layer=M1 $thickness=3.6e-08 $X=0.945
+ $Y=0.081 $X2=0.945 $Y2=0.1195
r12 10 3 0.462963 $w=2.7e-08 $l=1.25e-08 $layer=N_src_drn $thickness=1e-09
+ $X=0.8495 $Y=0.0405 $X2=0.864 $Y2=0.0405
r13 35 10 0.0925926 $w=2.7e-08 $l=2.5e-09 $layer=N_src_drn $thickness=1e-09
+ $X=0.8466 $Y=0.0405 $X2=0.8495 $Y2=0.0405
r14 13 33 4.64701 $w=1.46667e-08 $l=2.7e-08 $layer=M1 $thickness=3.6e-08
+ $X=0.945 $Y=0.036 $X2=0.918 $Y2=0.036
r15 13 18 8.84443 $w=1.496e-08 $l=4.5e-08 $layer=M1 $thickness=3.6e-08 $X=0.945
+ $Y=0.036 $X2=0.945 $Y2=0.081
r16 3 31 19.3796 $a=3.24e-16 $layer=V0LISD $X=0.864 $Y=0.0405 $X2=0.864
+ $Y2=0.036
r17 32 33 6.29612 $w=1.3e-08 $l=2.7e-08 $layer=M1 $thickness=3.6e-08 $X=0.891
+ $Y=0.036 $X2=0.918 $Y2=0.036
r18 31 32 6.29612 $w=1.3e-08 $l=2.7e-08 $layer=M1 $thickness=3.6e-08 $X=0.864
+ $Y=0.036 $X2=0.891 $Y2=0.036
r19 30 31 6.29612 $w=1.3e-08 $l=2.7e-08 $layer=M1 $thickness=3.6e-08 $X=0.837
+ $Y=0.036 $X2=0.864 $Y2=0.036
r20 16 30 6.29612 $w=1.3e-08 $l=2.7e-08 $layer=M1 $thickness=3.6e-08 $X=0.81
+ $Y=0.036 $X2=0.837 $Y2=0.036
r21 12 15 6.39593 $w=1.55565e-08 $l=3.45e-08 $layer=M1 $thickness=3.6e-08
+ $X=0.783 $Y=0.036 $X2=0.783 $Y2=0.0705
r22 12 16 4.64701 $w=1.46667e-08 $l=2.7e-08 $layer=M1 $thickness=3.6e-08
+ $X=0.783 $Y=0.036 $X2=0.81 $Y2=0.036
r23 15 27 8.04505 $w=1.3e-08 $l=3.45e-08 $layer=M1 $thickness=3.6e-08 $X=0.783
+ $Y=0.0705 $X2=0.783 $Y2=0.105
r24 1 21 6.4735 $w=2.13953e-08 $layer=Gate_1 $thickness=5.22791e-08 $X=0.783
+ $Y=0.1055 $X2=0.783 $Y2=0.1055
r25 1 27 19.3796 $a=3.24e-16 $layer=V0LIG $X=0.783 $Y=0.1055 $X2=0.783 $Y2=0.105
r26 23 22 21.4287 $w=2.1e-08 $l=6.3e-08 $layer=Gate_1 $thickness=5.6e-08
+ $X=0.783 $Y=0.2295 $X2=0.783 $Y2=0.1665
r27 21 22 20.944 $w=2.08115e-08 $l=6.1e-08 $layer=Gate_1 $thickness=5.6e-08
+ $X=0.783 $Y=0.1055 $X2=0.783 $Y2=0.1665
r28 20 21 10.9099 $w=2.06349e-08 $l=3.15e-08 $layer=Gate_1 $thickness=5.6e-08
+ $X=0.783 $Y=0.074 $X2=0.783 $Y2=0.1055
r29 19 20 11.3946 $w=2.1e-08 $l=3.35e-08 $layer=Gate_1 $thickness=5.6e-08
+ $X=0.783 $Y=0.0405 $X2=0.783 $Y2=0.074
r30 19 9 5.44221 $w=2.1e-08 $l=1.6e-08 $layer=Gate_1 $thickness=5.6e-08
+ $X=0.783 $Y=0.0405 $X2=0.783 $Y2=0.0245
.ends

.subckt PM_DFFLQx4_ASAP7_75t_R%11 vss 23 27 40 43 50 53 57 61 73 74 77 78 14 18
+ 19 20 21 4 13 9 3 1 10 15 17 11 22 12
c1 1 vss 0.0174395f $X=1.107 $Y=0.136
c2 3 vss 0.00964545f $X=1.026 $Y=0.0675
c3 4 vss 0.0102658f $X=1.026 $Y=0.2025
c4 9 vss 0.0804332f $X=1.107 $Y=0.0245
c5 10 vss 0.0804618f $X=1.161 $Y=0.136
c6 11 vss 0.0807089f $X=1.215 $Y=0.136
c7 12 vss 0.0926137f $X=1.269 $Y=0.136
c8 13 vss 0.0119825f $X=1.0115 $Y=0.0675
c9 14 vss 0.0119091f $X=1.0115 $Y=0.2025
c10 15 vss 0.00279097f $X=1.089 $Y=0.036
c11 16 vss 0.000240432f $X=1.089 $Y=0.136
c12 17 vss 0.0027907f $X=1.089 $Y=0.234
c13 18 vss 0.00900769f $X=1.0145 $Y=0.036
c14 19 vss 0.00889525f $X=1.0145 $Y=0.234
c15 20 vss 0.00489315f $X=1.089 $Y=0.1245
c16 21 vss 0.00425478f $X=1.089 $Y=0.156
c17 22 vss 0.00351855f $X=1.1475 $Y=0.136
r1 78 76 0.0308642 $w=8.1e-08 $l=2.5e-09 $layer=P_src_drn $thickness=1e-09
+ $X=1.0433 $Y=0.2025 $X2=1.0405 $Y2=0.2025
r2 4 76 0.179012 $w=8.1e-08 $l=1.45e-08 $layer=P_src_drn $thickness=1e-09
+ $X=1.026 $Y=0.2025 $X2=1.0405 $Y2=0.2025
r3 14 4 0.179012 $w=8.1e-08 $l=1.45e-08 $layer=P_src_drn $thickness=1e-09
+ $X=1.0115 $Y=0.2025 $X2=1.026 $Y2=0.2025
r4 77 14 0.0308642 $w=8.1e-08 $l=2.5e-09 $layer=P_src_drn $thickness=1e-09
+ $X=1.0086 $Y=0.2025 $X2=1.0115 $Y2=0.2025
r5 74 72 0.0308642 $w=8.1e-08 $l=2.5e-09 $layer=N_src_drn $thickness=1e-09
+ $X=1.0433 $Y=0.0675 $X2=1.0405 $Y2=0.0675
r6 3 72 0.179012 $w=8.1e-08 $l=1.45e-08 $layer=N_src_drn $thickness=1e-09
+ $X=1.026 $Y=0.0675 $X2=1.0405 $Y2=0.0675
r7 13 3 0.179012 $w=8.1e-08 $l=1.45e-08 $layer=N_src_drn $thickness=1e-09
+ $X=1.0115 $Y=0.0675 $X2=1.026 $Y2=0.0675
r8 73 13 0.0308642 $w=8.1e-08 $l=2.5e-09 $layer=N_src_drn $thickness=1e-09
+ $X=1.0086 $Y=0.0675 $X2=1.0115 $Y2=0.0675
r9 4 69 19.3796 $a=3.24e-16 $layer=V0LISD $X=1.026 $Y=0.2025 $X2=1.026 $Y2=0.234
r10 3 67 19.3796 $a=3.24e-16 $layer=V0LISD $X=1.026 $Y=0.0675 $X2=1.026
+ $Y2=0.036
r11 69 70 7.34548 $w=1.3e-08 $l=3.15e-08 $layer=M1 $thickness=3.6e-08 $X=1.026
+ $Y=0.234 $X2=1.0575 $Y2=0.234
r12 19 69 2.68168 $w=1.3e-08 $l=1.15e-08 $layer=M1 $thickness=3.6e-08 $X=1.0145
+ $Y=0.234 $X2=1.026 $Y2=0.234
r13 67 68 7.34548 $w=1.3e-08 $l=3.15e-08 $layer=M1 $thickness=3.6e-08 $X=1.026
+ $Y=0.036 $X2=1.0575 $Y2=0.036
r14 18 67 2.68168 $w=1.3e-08 $l=1.15e-08 $layer=M1 $thickness=3.6e-08 $X=1.0145
+ $Y=0.036 $X2=1.026 $Y2=0.036
r15 17 66 3.24787 $w=1.72e-08 $l=2.1e-08 $layer=M1 $thickness=3.6e-08 $X=1.089
+ $Y=0.234 $X2=1.089 $Y2=0.213
r16 17 70 5.69637 $w=1.44286e-08 $l=3.15e-08 $layer=M1 $thickness=3.6e-08
+ $X=1.089 $Y=0.234 $X2=1.0575 $Y2=0.234
r17 15 64 3.24787 $w=1.72e-08 $l=2.1e-08 $layer=M1 $thickness=3.6e-08 $X=1.089
+ $Y=0.036 $X2=1.089 $Y2=0.057
r18 15 68 5.69637 $w=1.44286e-08 $l=3.15e-08 $layer=M1 $thickness=3.6e-08
+ $X=1.089 $Y=0.036 $X2=1.0575 $Y2=0.036
r19 65 66 6.7625 $w=1.3e-08 $l=2.9e-08 $layer=M1 $thickness=3.6e-08 $X=1.089
+ $Y=0.184 $X2=1.089 $Y2=0.213
r20 21 65 6.52931 $w=1.3e-08 $l=2.8e-08 $layer=M1 $thickness=3.6e-08 $X=1.089
+ $Y=0.156 $X2=1.089 $Y2=0.184
r21 63 64 8.97781 $w=1.3e-08 $l=3.85e-08 $layer=M1 $thickness=3.6e-08 $X=1.089
+ $Y=0.0955 $X2=1.089 $Y2=0.057
r22 20 63 6.7625 $w=1.3e-08 $l=2.9e-08 $layer=M1 $thickness=3.6e-08 $X=1.089
+ $Y=0.1245 $X2=1.089 $Y2=0.0955
r23 16 48 4.06646 $w=1.5e-08 $l=2.25e-08 $layer=M1 $thickness=3.6e-08 $X=1.089
+ $Y=0.136 $X2=1.1115 $Y2=0.136
r24 16 20 1.50137 $w=1.6913e-08 $l=1.15e-08 $layer=M1 $thickness=3.6e-08
+ $X=1.089 $Y=0.136 $X2=1.089 $Y2=0.1245
r25 16 21 3.48349 $w=1.525e-08 $l=2e-08 $layer=M1 $thickness=3.6e-08 $X=1.089
+ $Y=0.136 $X2=1.089 $Y2=0.156
r26 61 60 14.6259 $w=2.1e-08 $l=4.3e-08 $layer=Gate_1 $thickness=5.6e-08
+ $X=1.269 $Y=0.2025 $X2=1.269 $Y2=0.1595
r27 59 60 2.55104 $w=2.1e-08 $l=7.5e-09 $layer=Gate_1 $thickness=5.6e-08
+ $X=1.269 $Y=0.152 $X2=1.269 $Y2=0.1595
r28 57 58 14.6259 $w=2.1e-08 $l=4.3e-08 $layer=Gate_1 $thickness=5.6e-08
+ $X=1.269 $Y=0.0675 $X2=1.269 $Y2=0.1105
r29 55 58 2.89117 $w=2.1e-08 $l=8.5e-09 $layer=Gate_1 $thickness=5.6e-08
+ $X=1.269 $Y=0.119 $X2=1.269 $Y2=0.1105
r30 12 37 6.54019 $w=2.09524e-08 $layer=Gate_1 $thickness=5.21905e-08 $X=1.269
+ $Y=0.136 $X2=1.269 $Y2=0.136
r31 12 55 5.96942 $w=2.03529e-08 $l=1.7e-08 $layer=Gate_1 $thickness=5.6e-08
+ $X=1.269 $Y=0.136 $X2=1.269 $Y2=0.119
r32 12 59 5.62929 $w=2.03125e-08 $l=1.6e-08 $layer=Gate_1 $thickness=5.6e-08
+ $X=1.269 $Y=0.136 $X2=1.269 $Y2=0.152
r33 53 52 16.3266 $w=2.1e-08 $l=4.8e-08 $layer=Gate_1 $thickness=5.6e-08
+ $X=1.215 $Y=0.2025 $X2=1.215 $Y2=0.1545
r34 50 51 16.6668 $w=2.1e-08 $l=4.9e-08 $layer=Gate_1 $thickness=5.6e-08
+ $X=1.215 $Y=0.0675 $X2=1.215 $Y2=0.1165
r35 11 35 6.54019 $w=2.09524e-08 $layer=Gate_1 $thickness=5.21905e-08 $X=1.215
+ $Y=0.136 $X2=1.215 $Y2=0.136
r36 11 51 6.81977 $w=2.04359e-08 $l=1.95e-08 $layer=Gate_1 $thickness=5.6e-08
+ $X=1.215 $Y=0.136 $X2=1.215 $Y2=0.1165
r37 11 52 6.47963 $w=2.04054e-08 $l=1.85e-08 $layer=Gate_1 $thickness=5.6e-08
+ $X=1.215 $Y=0.136 $X2=1.215 $Y2=0.1545
r38 47 48 5.24677 $w=1.3e-08 $l=2.25e-08 $layer=M1 $thickness=3.6e-08 $X=1.134
+ $Y=0.136 $X2=1.1115 $Y2=0.136
r39 22 45 3.14806 $w=1.3e-08 $l=1.35e-08 $layer=M1 $thickness=3.6e-08 $X=1.1475
+ $Y=0.136 $X2=1.161 $Y2=0.136
r40 22 47 3.14806 $w=1.3e-08 $l=1.35e-08 $layer=M1 $thickness=3.6e-08 $X=1.1475
+ $Y=0.136 $X2=1.134 $Y2=0.136
r41 43 42 16.3266 $w=2.1e-08 $l=4.8e-08 $layer=Gate_1 $thickness=5.6e-08
+ $X=1.161 $Y=0.2025 $X2=1.161 $Y2=0.1545
r42 40 41 16.6668 $w=2.1e-08 $l=4.9e-08 $layer=Gate_1 $thickness=5.6e-08
+ $X=1.161 $Y=0.0675 $X2=1.161 $Y2=0.1165
r43 10 32 6.27904 $w=2.09e-08 $layer=Gate_1 $thickness=5.24e-08 $X=1.161
+ $Y=0.136 $X2=1.161 $Y2=0.136
r44 10 41 6.81977 $w=2.04359e-08 $l=1.95e-08 $layer=Gate_1 $thickness=5.6e-08
+ $X=1.161 $Y=0.136 $X2=1.161 $Y2=0.1165
r45 10 42 6.47963 $w=2.04054e-08 $l=1.85e-08 $layer=Gate_1 $thickness=5.6e-08
+ $X=1.161 $Y=0.136 $X2=1.161 $Y2=0.1545
r46 36 37 12.6539 $w=1.77815e-08 $l=2.7e-08 $layer=LIG $thickness=4.8e-08
+ $X=1.242 $Y=0.136 $X2=1.269 $Y2=0.136
r47 35 36 12.6539 $w=1.77815e-08 $l=2.7e-08 $layer=LIG $thickness=4.8e-08
+ $X=1.215 $Y=0.136 $X2=1.242 $Y2=0.136
r48 34 35 12.6539 $w=1.77815e-08 $l=2.7e-08 $layer=LIG $thickness=4.8e-08
+ $X=1.188 $Y=0.136 $X2=1.215 $Y2=0.136
r49 33 34 10.1729 $w=1.54914e-08 $l=1.75e-08 $layer=LIG $thickness=4.8e-08
+ $X=1.1705 $Y=0.136 $X2=1.188 $Y2=0.136
r50 32 33 2.48102 $w=2.2e-08 $l=9.5e-09 $layer=LIG $thickness=4.8e-08 $X=1.161
+ $Y=0.136 $X2=1.1705 $Y2=0.136
r51 32 45 19.3796 $a=3.24e-16 $layer=V0LIG $X=1.161 $Y=0.136 $X2=1.161 $Y2=0.136
r52 31 32 2.48102 $w=2.2e-08 $l=9.5e-09 $layer=LIG $thickness=4.8e-08 $X=1.1515
+ $Y=0.136 $X2=1.161 $Y2=0.136
r53 30 31 10.1729 $w=1.54914e-08 $l=1.75e-08 $layer=LIG $thickness=4.8e-08
+ $X=1.134 $Y=0.136 $X2=1.1515 $Y2=0.136
r54 1 25 6.54019 $w=2.09524e-08 $layer=Gate_1 $thickness=5.21905e-08 $X=1.107
+ $Y=0.136 $X2=1.107 $Y2=0.136
r55 1 30 12.6539 $w=1.77815e-08 $l=2.7e-08 $layer=LIG $thickness=4.8e-08
+ $X=1.107 $Y=0.136 $X2=1.134 $Y2=0.136
r56 27 26 16.3266 $w=2.1e-08 $l=4.8e-08 $layer=Gate_1 $thickness=5.6e-08
+ $X=1.107 $Y=0.2025 $X2=1.107 $Y2=0.1545
r57 25 26 6.47963 $w=2.04054e-08 $l=1.85e-08 $layer=Gate_1 $thickness=5.6e-08
+ $X=1.107 $Y=0.136 $X2=1.107 $Y2=0.1545
r58 24 25 6.81977 $w=2.04359e-08 $l=1.95e-08 $layer=Gate_1 $thickness=5.6e-08
+ $X=1.107 $Y=0.1165 $X2=1.107 $Y2=0.136
r59 23 24 16.6668 $w=2.1e-08 $l=4.9e-08 $layer=Gate_1 $thickness=5.6e-08
+ $X=1.107 $Y=0.0675 $X2=1.107 $Y2=0.1165
r60 23 9 14.6259 $w=2.1e-08 $l=4.3e-08 $layer=Gate_1 $thickness=5.6e-08
+ $X=1.107 $Y=0.0675 $X2=1.107 $Y2=0.0245
.ends

.subckt PM_DFFLQx4_ASAP7_75t_R%15 vss 7 12 1 5 4
c1 1 vss 0.00632529f $X=0.702 $Y=0.0405
c2 4 vss 0.00177532f $X=0.6875 $Y=0.0405
c3 5 vss 0.00217702f $X=0.758 $Y=0.0405
r1 12 11 0.0925926 $w=2.7e-08 $l=2.5e-09 $layer=N_src_drn $thickness=1e-09
+ $X=0.7733 $Y=0.0405 $X2=0.7705 $Y2=0.0405
r2 5 11 0.462963 $w=2.7e-08 $l=1.25e-08 $layer=N_src_drn $thickness=1e-09
+ $X=0.758 $Y=0.0405 $X2=0.7705 $Y2=0.0405
r3 9 5 8.23096 $w=2.32e-08 $l=1.75e-08 $layer=LISD $thickness=2.7e-08 $X=0.7385
+ $Y=0.0405 $X2=0.758 $Y2=0.0405
r4 8 9 7.05511 $w=2.32e-08 $l=1.5e-08 $layer=LISD $thickness=2.7e-08 $X=0.7235
+ $Y=0.0405 $X2=0.7385 $Y2=0.0405
r5 1 8 10.1123 $w=2.32e-08 $l=2.15e-08 $layer=LISD $thickness=2.7e-08 $X=0.702
+ $Y=0.0405 $X2=0.7235 $Y2=0.0405
r6 4 1 0.462963 $w=2.7e-08 $l=1.25e-08 $layer=N_src_drn $thickness=1e-09
+ $X=0.6875 $Y=0.0405 $X2=0.702 $Y2=0.0405
r7 7 4 0.0925926 $w=2.7e-08 $l=2.5e-09 $layer=N_src_drn $thickness=1e-09
+ $X=0.6846 $Y=0.0405 $X2=0.6875 $Y2=0.0405
.ends

.subckt PM_DFFLQx4_ASAP7_75t_R%10 vss 32 38 75 76 79 83 86 89 93 94 18 16 6 14
+ 24 22 23 15 5 21 2 19 27 20 28 26 11 1 17 25 29 13 12
c1 1 vss 0.00177673f $X=0.837 $Y=0.1245
c2 2 vss 0.00788434f $X=0.9895 $Y=0.136
c3 5 vss 0.00460958f $X=0.648 $Y=0.0405
c4 6 vss 0.00461961f $X=0.702 $Y=0.2295
c5 11 vss 0.0533201f $X=0.837 $Y=0.0245
c6 12 vss 0.0864184f $X=0.999 $Y=0.136
c7 13 vss 0.0812149f $X=1.053 $Y=0.136
c8 14 vss 0.00384791f $X=0.6335 $Y=0.0405
c9 15 vss 0.00396616f $X=0.6875 $Y=0.2295
c10 16 vss 0.00621614f $X=0.729 $Y=0.234
c11 17 vss 0.0026477f $X=0.729 $Y=0.036
c12 18 vss 0.000159274f $X=0.729 $Y=0.16
c13 19 vss 0.000302235f $X=0.837 $Y=0.162
c14 20 vss 0.00115468f $X=0.891 $Y=0.1575
c15 21 vss 0.00828199f $X=0.704 $Y=0.036
c16 22 vss 0.00173018f $X=0.729 $Y=0.136
c17 23 vss 0.00178915f $X=0.729 $Y=0.198
c18 24 vss 0.00229729f $X=0.81 $Y=0.162
c19 25 vss 0.000769442f $X=0.837 $Y=0.118
c20 26 vss 0.000745402f $X=0.848 $Y=0.162
c21 27 vss 0.00113789f $X=0.891 $Y=0.1305
c22 28 vss 0.00211549f $X=0.999 $Y=0.1245
c23 29 vss 0.00811011f $X=0.8795 $Y=0.153
r1 94 92 0.0925926 $w=2.7e-08 $l=2.5e-09 $layer=N_src_drn $thickness=1e-09
+ $X=0.6653 $Y=0.0405 $X2=0.6625 $Y2=0.0405
r2 5 92 0.537037 $w=2.7e-08 $l=1.45e-08 $layer=N_src_drn $thickness=1e-09
+ $X=0.648 $Y=0.0405 $X2=0.6625 $Y2=0.0405
r3 14 5 0.537037 $w=2.7e-08 $l=1.45e-08 $layer=N_src_drn $thickness=1e-09
+ $X=0.6335 $Y=0.0405 $X2=0.648 $Y2=0.0405
r4 93 14 0.0925926 $w=2.7e-08 $l=2.5e-09 $layer=N_src_drn $thickness=1e-09
+ $X=0.6306 $Y=0.0405 $X2=0.6335 $Y2=0.0405
r5 89 88 16.3266 $w=2.1e-08 $l=4.8e-08 $layer=Gate_1 $thickness=5.6e-08
+ $X=1.053 $Y=0.2025 $X2=1.053 $Y2=0.1545
r6 86 87 16.6668 $w=2.1e-08 $l=4.9e-08 $layer=Gate_1 $thickness=5.6e-08
+ $X=1.053 $Y=0.0675 $X2=1.053 $Y2=0.1165
r7 13 69 6.54019 $w=2.09524e-08 $layer=Gate_1 $thickness=5.21905e-08 $X=1.053
+ $Y=0.136 $X2=1.053 $Y2=0.136
r8 13 87 6.81977 $w=2.04359e-08 $l=1.95e-08 $layer=Gate_1 $thickness=5.6e-08
+ $X=1.053 $Y=0.136 $X2=1.053 $Y2=0.1165
r9 13 88 6.47963 $w=2.04054e-08 $l=1.85e-08 $layer=Gate_1 $thickness=5.6e-08
+ $X=1.053 $Y=0.136 $X2=1.053 $Y2=0.1545
r10 83 82 14.6259 $w=2.1e-08 $l=4.3e-08 $layer=Gate_1 $thickness=5.6e-08
+ $X=0.999 $Y=0.2025 $X2=0.999 $Y2=0.1595
r11 81 82 2.55104 $w=2.1e-08 $l=7.5e-09 $layer=Gate_1 $thickness=5.6e-08
+ $X=0.999 $Y=0.152 $X2=0.999 $Y2=0.1595
r12 79 80 14.6259 $w=2.1e-08 $l=4.3e-08 $layer=Gate_1 $thickness=5.6e-08
+ $X=0.999 $Y=0.0675 $X2=0.999 $Y2=0.1105
r13 77 80 2.89117 $w=2.1e-08 $l=8.5e-09 $layer=Gate_1 $thickness=5.6e-08
+ $X=0.999 $Y=0.119 $X2=0.999 $Y2=0.1105
r14 12 65 6.27904 $w=2.09e-08 $layer=Gate_1 $thickness=5.24e-08 $X=0.999
+ $Y=0.136 $X2=0.999 $Y2=0.136
r15 12 77 5.96942 $w=2.03529e-08 $l=1.7e-08 $layer=Gate_1 $thickness=5.6e-08
+ $X=0.999 $Y=0.136 $X2=0.999 $Y2=0.119
r16 12 81 5.62929 $w=2.03125e-08 $l=1.6e-08 $layer=Gate_1 $thickness=5.6e-08
+ $X=0.999 $Y=0.136 $X2=0.999 $Y2=0.152
r17 76 74 0.0925926 $w=2.7e-08 $l=2.5e-09 $layer=P_src_drn $thickness=1e-09
+ $X=0.7193 $Y=0.2295 $X2=0.7165 $Y2=0.2295
r18 6 74 0.537037 $w=2.7e-08 $l=1.45e-08 $layer=P_src_drn $thickness=1e-09
+ $X=0.702 $Y=0.2295 $X2=0.7165 $Y2=0.2295
r19 15 6 0.537037 $w=2.7e-08 $l=1.45e-08 $layer=P_src_drn $thickness=1e-09
+ $X=0.6875 $Y=0.2295 $X2=0.702 $Y2=0.2295
r20 75 15 0.0925926 $w=2.7e-08 $l=2.5e-09 $layer=P_src_drn $thickness=1e-09
+ $X=0.6846 $Y=0.2295 $X2=0.6875 $Y2=0.2295
r21 5 63 19.3796 $a=3.24e-16 $layer=V0LISD $X=0.648 $Y=0.0405 $X2=0.648
+ $Y2=0.036
r22 68 69 12.6539 $w=1.77815e-08 $l=2.7e-08 $layer=LIG $thickness=4.8e-08
+ $X=1.026 $Y=0.136 $X2=1.053 $Y2=0.136
r23 66 68 10.1729 $w=1.54914e-08 $l=1.75e-08 $layer=LIG $thickness=4.8e-08
+ $X=1.0085 $Y=0.136 $X2=1.026 $Y2=0.136
r24 65 66 2.48102 $w=2.2e-08 $l=9.5e-09 $layer=LIG $thickness=4.8e-08 $X=0.999
+ $Y=0.136 $X2=1.0085 $Y2=0.136
r25 2 65 2.48102 $w=2.2e-08 $l=9.5e-09 $layer=LIG $thickness=4.8e-08 $X=0.9895
+ $Y=0.136 $X2=0.999 $Y2=0.136
r26 6 56 19.3796 $a=3.24e-16 $layer=V0LISD $X=0.702 $Y=0.2295 $X2=0.702
+ $Y2=0.234
r27 63 64 3.14806 $w=1.3e-08 $l=1.35e-08 $layer=M1 $thickness=3.6e-08 $X=0.648
+ $Y=0.036 $X2=0.6615 $Y2=0.036
r28 61 64 3.14806 $w=1.3e-08 $l=1.35e-08 $layer=M1 $thickness=3.6e-08 $X=0.675
+ $Y=0.036 $X2=0.6615 $Y2=0.036
r29 60 61 2.56509 $w=1.3e-08 $l=1.1e-08 $layer=M1 $thickness=3.6e-08 $X=0.686
+ $Y=0.036 $X2=0.675 $Y2=0.036
r30 21 60 4.19742 $w=1.3e-08 $l=1.8e-08 $layer=M1 $thickness=3.6e-08 $X=0.704
+ $Y=0.036 $X2=0.686 $Y2=0.036
r31 58 65 19.3796 $a=3.24e-16 $layer=V0LIG $X=0.999 $Y=0.1445 $X2=0.999
+ $Y2=0.136
r32 28 58 4.6638 $w=1.3e-08 $l=2e-08 $layer=M1 $thickness=3.6e-08 $X=0.999
+ $Y=0.1245 $X2=0.999 $Y2=0.1445
r33 56 57 3.14806 $w=1.3e-08 $l=1.35e-08 $layer=M1 $thickness=3.6e-08 $X=0.702
+ $Y=0.234 $X2=0.7155 $Y2=0.234
r34 16 23 7.21452 $w=1.425e-08 $l=3.6e-08 $layer=M1 $thickness=3.6e-08 $X=0.729
+ $Y=0.234 $X2=0.729 $Y2=0.198
r35 16 57 1.96775 $w=1.63333e-08 $l=1.35e-08 $layer=M1 $thickness=3.6e-08
+ $X=0.729 $Y=0.234 $X2=0.7155 $Y2=0.234
r36 17 49 4.64701 $w=1.62667e-08 $l=2.7e-08 $layer=M1 $thickness=3.6e-08
+ $X=0.729 $Y=0.036 $X2=0.729 $Y2=0.063
r37 17 21 4.18063 $w=1.48e-08 $l=2.5e-08 $layer=M1 $thickness=3.6e-08 $X=0.729
+ $Y=0.036 $X2=0.704 $Y2=0.036
r38 53 58 19.5347 $a=3.24e-16 $layer=V1 $X=0.999 $Y=0.153 $X2=0.999 $Y2=0.1445
r39 52 53 12.5922 $w=1.3e-08 $l=5.4e-08 $layer=M2 $thickness=3.6e-08 $X=0.945
+ $Y=0.153 $X2=0.999 $Y2=0.153
r40 51 52 12.5922 $w=1.3e-08 $l=5.4e-08 $layer=M2 $thickness=3.6e-08 $X=0.891
+ $Y=0.153 $X2=0.945 $Y2=0.153
r41 29 51 2.68168 $w=1.3e-08 $l=1.15e-08 $layer=M2 $thickness=3.6e-08 $X=0.8795
+ $Y=0.153 $X2=0.891 $Y2=0.153
r42 50 51 39.0693 $a=1.62e-16 $layer=V1 $X=0.891 $Y=0.1485 $X2=0.891 $Y2=0.153
r43 27 50 4.19742 $w=1.3e-08 $l=1.8e-08 $layer=M1 $thickness=3.6e-08 $X=0.891
+ $Y=0.1305 $X2=0.891 $Y2=0.1485
r44 23 45 6.50021 $w=1.33448e-08 $l=2.9e-08 $layer=M1 $thickness=3.6e-08
+ $X=0.729 $Y=0.198 $X2=0.729 $Y2=0.169
r45 48 49 6.29612 $w=1.3e-08 $l=2.7e-08 $layer=M1 $thickness=3.6e-08 $X=0.729
+ $Y=0.09 $X2=0.729 $Y2=0.063
r46 47 48 4.43061 $w=1.3e-08 $l=1.9e-08 $layer=M1 $thickness=3.6e-08 $X=0.729
+ $Y=0.109 $X2=0.729 $Y2=0.09
r47 22 47 6.29612 $w=1.3e-08 $l=2.7e-08 $layer=M1 $thickness=3.6e-08 $X=0.729
+ $Y=0.136 $X2=0.729 $Y2=0.109
r48 20 46 0.9184 $w=1.8e-08 $l=9e-09 $layer=M1 $thickness=3.6e-08 $X=0.891
+ $Y=0.1575 $X2=0.891 $Y2=0.1665
r49 20 50 1.50855 $w=1.55e-08 $l=9e-09 $layer=M1 $thickness=3.6e-08 $X=0.891
+ $Y=0.1575 $X2=0.891 $Y2=0.1485
r50 20 51 39.0693 $a=1.62e-16 $layer=V1 $X=0.891 $Y=0.1575 $X2=0.891 $Y2=0.153
r51 18 45 0.9184 $w=1.8e-08 $l=9e-09 $layer=M1 $thickness=3.6e-08 $X=0.729
+ $Y=0.16 $X2=0.729 $Y2=0.169
r52 18 22 4.67854 $w=1.44583e-08 $l=2.4e-08 $layer=M1 $thickness=3.6e-08
+ $X=0.729 $Y=0.16 $X2=0.729 $Y2=0.136
r53 44 46 4.19024 $w=1.156e-08 $l=2.54018e-08 $layer=M1 $thickness=3.6e-08
+ $X=0.866 $Y=0.162 $X2=0.891 $Y2=0.1665
r54 26 44 4.19742 $w=1.3e-08 $l=1.8e-08 $layer=M1 $thickness=3.6e-08 $X=0.848
+ $Y=0.162 $X2=0.866 $Y2=0.162
r55 43 45 4.4015 $w=1.35e-08 $l=2.78927e-08 $layer=M1 $thickness=3.6e-08
+ $X=0.756 $Y=0.162 $X2=0.729 $Y2=0.169
r56 42 43 6.29612 $w=1.3e-08 $l=2.7e-08 $layer=M1 $thickness=3.6e-08 $X=0.783
+ $Y=0.162 $X2=0.756 $Y2=0.162
r57 24 42 6.29612 $w=1.3e-08 $l=2.7e-08 $layer=M1 $thickness=3.6e-08 $X=0.81
+ $Y=0.162 $X2=0.783 $Y2=0.162
r58 19 41 4.88263 $w=1.47308e-08 $l=2.6e-08 $layer=M1 $thickness=3.6e-08
+ $X=0.837 $Y=0.162 $X2=0.837 $Y2=0.136
r59 19 24 5.11582 $w=1.46667e-08 $l=2.7e-08 $layer=M1 $thickness=3.6e-08
+ $X=0.837 $Y=0.162 $X2=0.81 $Y2=0.162
r60 19 26 1.38478 $w=1.70909e-08 $l=1.1e-08 $layer=M1 $thickness=3.6e-08
+ $X=0.837 $Y=0.162 $X2=0.848 $Y2=0.162
r61 25 41 4.19742 $w=1.3e-08 $l=1.8e-08 $layer=M1 $thickness=3.6e-08 $X=0.837
+ $Y=0.118 $X2=0.837 $Y2=0.136
r62 40 41 19.3796 $a=3.24e-16 $layer=V0LIG $X=0.837 $Y=0.1355 $X2=0.837
+ $Y2=0.136
r63 1 35 4.22396 $w=1.97957e-08 $l=1.05e-08 $layer=Gate_1
+ $thickness=5.56522e-08 $X=0.837 $Y=0.1245 $X2=0.837 $Y2=0.135
r64 1 40 6.49795 $w=1.53e-08 $l=1.1e-08 $layer=LIG $thickness=4.8e-08 $X=0.837
+ $Y=0.1245 $X2=0.837 $Y2=0.1355
r65 38 37 14.6259 $w=2.1e-08 $l=4.3e-08 $layer=Gate_1 $thickness=5.6e-08
+ $X=0.837 $Y=0.2295 $X2=0.837 $Y2=0.1865
r66 36 37 11.9048 $w=2.1e-08 $l=3.5e-08 $layer=Gate_1 $thickness=5.6e-08
+ $X=0.837 $Y=0.1515 $X2=0.837 $Y2=0.1865
r67 35 36 5.79936 $w=2.03333e-08 $l=1.65e-08 $layer=Gate_1 $thickness=5.6e-08
+ $X=0.837 $Y=0.135 $X2=0.837 $Y2=0.1515
r68 34 35 5.79936 $w=2.03333e-08 $l=1.65e-08 $layer=Gate_1 $thickness=5.6e-08
+ $X=0.837 $Y=0.1185 $X2=0.837 $Y2=0.135
r69 33 34 11.9048 $w=2.1e-08 $l=3.5e-08 $layer=Gate_1 $thickness=5.6e-08
+ $X=0.837 $Y=0.0835 $X2=0.837 $Y2=0.1185
r70 32 33 14.6259 $w=2.1e-08 $l=4.3e-08 $layer=Gate_1 $thickness=5.6e-08
+ $X=0.837 $Y=0.0405 $X2=0.837 $Y2=0.0835
r71 32 11 5.44221 $w=2.1e-08 $l=1.6e-08 $layer=Gate_1 $thickness=5.6e-08
+ $X=0.837 $Y=0.0405 $X2=0.837 $Y2=0.0245
.ends

.subckt PM_DFFLQx4_ASAP7_75t_R%13 vss 7 9 4 5 1
c1 1 vss 0.00828241f $X=0.351 $Y=0.0675
c2 4 vss 0.00288478f $X=0.3095 $Y=0.0675
c3 5 vss 0.0017562f $X=0.38 $Y=0.0675
r1 9 8 0.0308642 $w=8.1e-08 $l=2.5e-09 $layer=N_src_drn $thickness=1e-09
+ $X=0.3953 $Y=0.0675 $X2=0.3925 $Y2=0.0675
r2 5 8 0.154321 $w=8.1e-08 $l=1.25e-08 $layer=N_src_drn $thickness=1e-09
+ $X=0.38 $Y=0.0675 $X2=0.3925 $Y2=0.0675
r3 4 1 0.154321 $w=8.1e-08 $l=1.25e-08 $layer=N_src_drn $thickness=1e-09
+ $X=0.3095 $Y=0.0675 $X2=0.351 $Y2=0.0675
r4 7 4 0.0308642 $w=8.1e-08 $l=2.5e-09 $layer=N_src_drn $thickness=1e-09
+ $X=0.3066 $Y=0.0675 $X2=0.3095 $Y2=0.0675
r5 1 5 1e-05 $l=2.9e-08 $X=0.351 $Y=0.0675 $X2=0.38 $Y2=0.0675
.ends

.subckt PM_DFFLQx4_ASAP7_75t_R%Q vss 35 26 27 41 42 50 51 54 55 16 3 2 4 1 18
+ 17 14 13 15
c1 1 vss 0.00721849f $X=1.134 $Y=0.0675
c2 2 vss 0.00717556f $X=1.134 $Y=0.2025
c3 3 vss 0.00853352f $X=1.242 $Y=0.0675
c4 4 vss 0.00849091f $X=1.242 $Y=0.2025
c5 13 vss 0.00435816f $X=1.1195 $Y=0.0675
c6 14 vss 0.00443023f $X=1.2275 $Y=0.0675
c7 15 vss 0.00432066f $X=1.1195 $Y=0.2025
c8 16 vss 0.00442067f $X=1.2275 $Y=0.2025
c9 17 vss 0.00289023f $X=1.134 $Y=0.054
c10 18 vss 0.00315681f $X=1.134 $Y=0.234
c11 19 vss 0.00300626f $X=1.323 $Y=0.036
c12 20 vss 0.00300626f $X=1.323 $Y=0.234
c13 21 vss 0.0152963f $X=1.159 $Y=0.036
c14 22 vss 0.0151783f $X=1.204 $Y=0.234
c15 23 vss 0.00889638f $X=1.323 $Y=0.057
r1 55 53 0.0308642 $w=8.1e-08 $l=2.5e-09 $layer=P_src_drn $thickness=1e-09
+ $X=1.1513 $Y=0.2025 $X2=1.1485 $Y2=0.2025
r2 2 53 0.179012 $w=8.1e-08 $l=1.45e-08 $layer=P_src_drn $thickness=1e-09
+ $X=1.134 $Y=0.2025 $X2=1.1485 $Y2=0.2025
r3 15 2 0.179012 $w=8.1e-08 $l=1.45e-08 $layer=P_src_drn $thickness=1e-09
+ $X=1.1195 $Y=0.2025 $X2=1.134 $Y2=0.2025
r4 54 15 0.0308642 $w=8.1e-08 $l=2.5e-09 $layer=P_src_drn $thickness=1e-09
+ $X=1.1166 $Y=0.2025 $X2=1.1195 $Y2=0.2025
r5 2 47 19.3796 $a=3.24e-16 $layer=V0LISD $X=1.134 $Y=0.2025 $X2=1.134 $Y2=0.216
r6 51 49 0.0308642 $w=8.1e-08 $l=2.5e-09 $layer=P_src_drn $thickness=1e-09
+ $X=1.2593 $Y=0.2025 $X2=1.2565 $Y2=0.2025
r7 4 49 0.179012 $w=8.1e-08 $l=1.45e-08 $layer=P_src_drn $thickness=1e-09
+ $X=1.242 $Y=0.2025 $X2=1.2565 $Y2=0.2025
r8 16 4 0.179012 $w=8.1e-08 $l=1.45e-08 $layer=P_src_drn $thickness=1e-09
+ $X=1.2275 $Y=0.2025 $X2=1.242 $Y2=0.2025
r9 50 16 0.0308642 $w=8.1e-08 $l=2.5e-09 $layer=P_src_drn $thickness=1e-09
+ $X=1.2246 $Y=0.2025 $X2=1.2275 $Y2=0.2025
r10 18 45 4.64944 $w=1.48e-08 $l=2.5e-08 $layer=M1 $thickness=3.6e-08 $X=1.134
+ $Y=0.234 $X2=1.159 $Y2=0.234
r11 18 47 3.01711 $w=1.55e-08 $l=1.8e-08 $layer=M1 $thickness=3.6e-08 $X=1.134
+ $Y=0.234 $X2=1.134 $Y2=0.216
r12 4 43 19.3796 $a=3.24e-16 $layer=V0LISD $X=1.242 $Y=0.2025 $X2=1.242
+ $Y2=0.234
r13 43 44 9.32759 $w=1.3e-08 $l=4e-08 $layer=M1 $thickness=3.6e-08 $X=1.242
+ $Y=0.234 $X2=1.282 $Y2=0.234
r14 22 43 8.86121 $w=1.3e-08 $l=3.8e-08 $layer=M1 $thickness=3.6e-08 $X=1.204
+ $Y=0.234 $X2=1.242 $Y2=0.234
r15 22 45 10.4935 $w=1.3e-08 $l=4.5e-08 $layer=M1 $thickness=3.6e-08 $X=1.204
+ $Y=0.234 $X2=1.159 $Y2=0.234
r16 20 38 2.48126 $w=1.71429e-08 $l=2.1e-08 $layer=M1 $thickness=3.6e-08
+ $X=1.323 $Y=0.234 $X2=1.323 $Y2=0.213
r17 20 44 7.66726 $w=1.56829e-08 $l=4.1e-08 $layer=M1 $thickness=3.6e-08
+ $X=1.323 $Y=0.234 $X2=1.282 $Y2=0.234
r18 42 40 0.0308642 $w=8.1e-08 $l=2.5e-09 $layer=N_src_drn $thickness=1e-09
+ $X=1.2593 $Y=0.0675 $X2=1.2565 $Y2=0.0675
r19 3 40 0.179012 $w=8.1e-08 $l=1.45e-08 $layer=N_src_drn $thickness=1e-09
+ $X=1.242 $Y=0.0675 $X2=1.2565 $Y2=0.0675
r20 14 3 0.179012 $w=8.1e-08 $l=1.45e-08 $layer=N_src_drn $thickness=1e-09
+ $X=1.2275 $Y=0.0675 $X2=1.242 $Y2=0.0675
r21 41 14 0.0308642 $w=8.1e-08 $l=2.5e-09 $layer=N_src_drn $thickness=1e-09
+ $X=1.2246 $Y=0.0675 $X2=1.2275 $Y2=0.0675
r22 37 38 6.8096 $w=1.5e-08 $l=4e-08 $layer=M1 $thickness=3.6e-08 $X=1.323
+ $Y=0.173 $X2=1.323 $Y2=0.213
r23 36 37 5.66048 $w=1.5e-08 $l=3.33e-08 $layer=M1 $thickness=3.6e-08 $X=1.323
+ $Y=0.1397 $X2=1.323 $Y2=0.173
r24 35 36 0.97888 $w=1.5e-08 $l=5.7e-09 $layer=M1 $thickness=3.6e-08 $X=1.329
+ $Y=0.134 $X2=1.323 $Y2=0.1397
r25 35 34 0.6384 $w=1.5e-08 $l=3.8e-09 $layer=M1 $thickness=3.6e-08 $X=1.329
+ $Y=0.134 $X2=1.323 $Y2=0.1302
r26 33 34 5.49024 $w=1.5e-08 $l=3.22e-08 $layer=M1 $thickness=3.6e-08 $X=1.323
+ $Y=0.098 $X2=1.323 $Y2=0.1302
r27 23 33 6.97984 $w=1.5e-08 $l=4.1e-08 $layer=M1 $thickness=3.6e-08 $X=1.323
+ $Y=0.057 $X2=1.323 $Y2=0.098
r28 3 31 19.3796 $a=3.24e-16 $layer=V0LISD $X=1.242 $Y=0.0675 $X2=1.242
+ $Y2=0.036
r29 19 32 7.66726 $w=1.56829e-08 $l=4.1e-08 $layer=M1 $thickness=3.6e-08
+ $X=1.323 $Y=0.036 $X2=1.282 $Y2=0.036
r30 19 23 2.48126 $w=1.71429e-08 $l=2.1e-08 $layer=M1 $thickness=3.6e-08
+ $X=1.323 $Y=0.036 $X2=1.323 $Y2=0.057
r31 31 32 9.32759 $w=1.3e-08 $l=4e-08 $layer=M1 $thickness=3.6e-08 $X=1.242
+ $Y=0.036 $X2=1.282 $Y2=0.036
r32 30 31 8.86121 $w=1.3e-08 $l=3.8e-08 $layer=M1 $thickness=3.6e-08 $X=1.204
+ $Y=0.036 $X2=1.242 $Y2=0.036
r33 21 29 4.64944 $w=1.48e-08 $l=2.5e-08 $layer=M1 $thickness=3.6e-08 $X=1.159
+ $Y=0.036 $X2=1.134 $Y2=0.036
r34 21 30 10.4935 $w=1.3e-08 $l=4.5e-08 $layer=M1 $thickness=3.6e-08 $X=1.159
+ $Y=0.036 $X2=1.204 $Y2=0.036
r35 17 29 3.01711 $w=1.55e-08 $l=1.8e-08 $layer=M1 $thickness=3.6e-08 $X=1.134
+ $Y=0.054 $X2=1.134 $Y2=0.036
r36 1 17 19.3796 $a=3.24e-16 $layer=V0LISD $X=1.134 $Y=0.0675 $X2=1.134
+ $Y2=0.054
r37 27 25 0.0308642 $w=8.1e-08 $l=2.5e-09 $layer=N_src_drn $thickness=1e-09
+ $X=1.1513 $Y=0.0675 $X2=1.1485 $Y2=0.0675
r38 1 25 0.179012 $w=8.1e-08 $l=1.45e-08 $layer=N_src_drn $thickness=1e-09
+ $X=1.134 $Y=0.0675 $X2=1.1485 $Y2=0.0675
r39 13 1 0.179012 $w=8.1e-08 $l=1.45e-08 $layer=N_src_drn $thickness=1e-09
+ $X=1.1195 $Y=0.0675 $X2=1.134 $Y2=0.0675
r40 26 13 0.0308642 $w=8.1e-08 $l=2.5e-09 $layer=N_src_drn $thickness=1e-09
+ $X=1.1166 $Y=0.0675 $X2=1.1195 $Y2=0.0675
.ends

* End of included file DFFLQx4_ASAP7_75t_R.pex.sp.pex

*
.subckt DFFLQx4_ASAP7_75t_CUSTOM_4_25_0_7 VSS VDD CLK D Q
*
* VSS VSS
* VDD VDD
* CLK CLK
* D D
* Q Q
*
*

M0 VSS N_M0_g N_M0_s VSS nmos_rvt L=2e-08 W=5.4e-08 nfin=2 $X=0.071 $Y=0.027
M1 N_M1_d N_M1_g VSS VSS nmos_rvt L=2e-08 W=5.4e-08 nfin=2 $X=0.125 $Y=0.027
M2 N_M2_d N_M2_g VSS VSS nmos_rvt L=2e-08 W=8.1e-08 nfin=3 $X=0.287 $Y=0.027
M3 N_M3_d N_M3_g N_M3_s VSS nmos_rvt L=2e-08 W=8.1e-08 nfin=3 $X=0.395 $Y=0.027
M4 N_M4_d N_M4_g N_M4_s VSS nmos_rvt L=2e-08 W=2.7e-08 nfin=1 $X=0.449 $Y=0.027
M5 VSS N_M5_g N_M5_s VSS nmos_rvt L=2e-08 W=2.7e-08 nfin=1 $X=0.503 $Y=0.027
M6 N_M6_d N_M6_g VSS VSS nmos_rvt L=2e-08 W=2.7e-08 nfin=1 $X=0.557 $Y=0.027
M7 N_M7_d N_M7_g N_M7_s VSS nmos_rvt L=2e-08 W=2.7e-08 nfin=1 $X=0.611 $Y=0.027
M8 N_M8_d N_M8_g N_M8_s VSS nmos_rvt L=2e-08 W=2.7e-08 nfin=1 $X=0.665 $Y=0.027
M9 VSS N_M9_g N_M9_s VSS nmos_rvt L=2e-08 W=2.7e-08 nfin=1 $X=0.773 $Y=0.027
M10 N_M10_d N_M10_g VSS VSS nmos_rvt L=2e-08 W=2.7e-08 nfin=1 $X=0.827 $Y=0.027
M11 N_M11_d N_M11_g VSS VSS nmos_rvt L=2e-08 W=8.1e-08 nfin=3 $X=0.989 $Y=0.027
M12 N_M12_d N_M12_g VSS VSS nmos_rvt L=2e-08 W=8.1e-08 nfin=3 $X=1.043 $Y=0.027
M13 N_M13_d N_M13_g VSS VSS nmos_rvt L=2e-08 W=8.1e-08 nfin=3 $X=1.097 $Y=0.027
M14 N_M14_d N_M14_g VSS VSS nmos_rvt L=2e-08 W=8.1e-08 nfin=3 $X=1.151 $Y=0.027
M15 N_M15_d N_M15_g VSS VSS nmos_rvt L=2e-08 W=8.1e-08 nfin=3 $X=1.205 $Y=0.027
M16 N_M16_d N_M16_g VSS VSS nmos_rvt L=2e-08 W=8.1e-08 nfin=3 $X=1.259 $Y=0.027
M17 VDD N_M17_g N_M17_s VDD pmos_rvt L=2e-08 W=5.4e-08 nfin=2 $X=0.071 $Y=0.189
M18 N_M18_d N_M18_g VDD VDD pmos_rvt L=2e-08 W=5.4e-08 nfin=2 $X=0.125 $Y=0.189
M19 N_M19_d N_M19_g VDD VDD pmos_rvt L=2e-08 W=8.1e-08 nfin=3 $X=0.287 $Y=0.162
M20 N_M20_d N_M20_g N_M20_s VDD pmos_rvt L=2e-08 W=8.1e-08 nfin=3 $X=0.341
+ $Y=0.162
M21 N_M21_d N_M21_g N_M21_s VDD pmos_rvt L=2e-08 W=2.7e-08 nfin=1 $X=0.395
+ $Y=0.216
M22 VDD N_M22_g N_M22_s VDD pmos_rvt L=2e-08 W=2.7e-08 nfin=1 $X=0.503 $Y=0.216
M23 N_M23_d N_M23_g VDD VDD pmos_rvt L=2e-08 W=2.7e-08 nfin=1 $X=0.557 $Y=0.216
M24 N_M24_d N_M24_g N_M24_s VDD pmos_rvt L=2e-08 W=2.7e-08 nfin=1 $X=0.665
+ $Y=0.216
M25 N_M25_d N_M25_g N_M25_s VDD pmos_rvt L=2e-08 W=2.7e-08 nfin=1 $X=0.719
+ $Y=0.216
M26 VDD N_M26_g N_M26_s VDD pmos_rvt L=2e-08 W=2.7e-08 nfin=1 $X=0.773 $Y=0.216
M27 N_M27_d N_M27_g VDD VDD pmos_rvt L=2e-08 W=2.7e-08 nfin=1 $X=0.827 $Y=0.216
M28 N_M28_d N_M28_g VDD VDD pmos_rvt L=2e-08 W=8.1e-08 nfin=3 $X=0.989 $Y=0.162
M29 N_M29_d N_M29_g VDD VDD pmos_rvt L=2e-08 W=8.1e-08 nfin=3 $X=1.043 $Y=0.162
M30 N_M30_d N_M30_g VDD VDD pmos_rvt L=2e-08 W=8.1e-08 nfin=3 $X=1.097 $Y=0.162
M31 N_M31_d N_M31_g VDD VDD pmos_rvt L=2e-08 W=8.1e-08 nfin=3 $X=1.151 $Y=0.162
M32 N_M32_d N_M32_g VDD VDD pmos_rvt L=2e-08 W=8.1e-08 nfin=3 $X=1.205 $Y=0.162
M33 N_M33_d N_M33_g VDD VDD pmos_rvt L=2e-08 W=8.1e-08 nfin=3 $X=1.259 $Y=0.162

* .include "DFFLQx4_ASAP7_75t_R.pex.sp.pxi"

* Start of included file DFFLQx4_ASAP7_75t_R.pex.sp.pxi
x_PM_DFFLQx4_ASAP7_75t_R%CLK vss CLK N_M0_g N_M17_g N_CLK_3 N_CLK_5 N_CLK_7
+ N_CLK_1 N_CLK_8 N_CLK_6 N_CLK_4 PM_DFFLQx4_ASAP7_75t_R%CLK
x_PM_DFFLQx4_ASAP7_75t_R%14 vss N_M21_d N_M22_s N_14_4 N_14_1 N_14_5
+ PM_DFFLQx4_ASAP7_75t_R%14
cc_1 N_14_4 N_4_10 0.000106089f $X=0.4175 $Y=0.2295
cc_2 N_14_1 N_4_3 0.000800105f $X=0.432 $Y=0.2295
cc_3 N_14_5 N_4_10 0.00102275f $X=0.488 $Y=0.2295
cc_4 N_14_1 N_4_18 0.00190472f $X=0.432 $Y=0.2295
cc_5 N_14_5 N_4_18 0.00655165f $X=0.488 $Y=0.2295
cc_6 N_14_4 N_4_18 0.0227223f $X=0.4175 $Y=0.2295
cc_7 N_14_4 N_6_11 0.0139038f $X=0.4175 $Y=0.2295
cc_8 N_14_5 N_7_10 0.0186213f $X=0.488 $Y=0.2295
cc_9 N_14_1 N_8_19 0.000397231f $X=0.432 $Y=0.2295
cc_10 N_14_1 N_8_17 0.000404452f $X=0.432 $Y=0.2295
cc_11 N_14_4 N_8_3 0.000508354f $X=0.4175 $Y=0.2295
cc_12 N_14_1 N_8_16 0.00259891f $X=0.432 $Y=0.2295
x_PM_DFFLQx4_ASAP7_75t_R%16 vss N_M4_d N_M5_s N_16_1 PM_DFFLQx4_ASAP7_75t_R%16
cc_13 N_16_1 N_4_18 0.00756851f $X=0.486 $Y=0.0405
cc_14 N_16_1 N_7_10 0.00767709f $X=0.486 $Y=0.0405
x_PM_DFFLQx4_ASAP7_75t_R%17 vss N_M19_d N_M20_s N_17_1 PM_DFFLQx4_ASAP7_75t_R%17
cc_15 N_17_1 N_4_17 0.0168092f $X=0.324 $Y=0.2025
cc_16 N_17_1 N_D_3 0.0166346f $X=0.324 $Y=0.2025
x_PM_DFFLQx4_ASAP7_75t_R%D vss D N_M2_g N_M19_g N_D_3 N_D_1 N_D_6 N_D_5 N_D_4
+ PM_DFFLQx4_ASAP7_75t_R%D
cc_17 N_D_3 N_4_27 9.63616e-20 $X=0.297 $Y=0.0245
cc_18 N_D_3 N_4_33 9.85815e-20 $X=0.297 $Y=0.0245
cc_19 N_D_3 N_4_34 0.000904788f $X=0.297 $Y=0.0245
cc_20 N_D_1 N_4_2 0.00227663f $X=0.297 $Y=0.135
cc_21 N_D_6 N_4_36 0.000984234f $X=0.297 $Y=0.116
cc_22 N_D_6 N_4_34 0.00426818f $X=0.297 $Y=0.116
cc_23 N_D_3 N_4_17 0.00509496f $X=0.297 $Y=0.0245
x_PM_DFFLQx4_ASAP7_75t_R%18 vss N_M25_d N_M26_s N_18_1 PM_DFFLQx4_ASAP7_75t_R%18
cc_24 N_18_1 N_4_20 0.0075837f $X=0.756 $Y=0.2295
cc_25 N_18_1 N_9_9 0.00764497f $X=0.756 $Y=0.2295
x_PM_DFFLQx4_ASAP7_75t_R%8 vss N_M6_g N_M23_g N_M3_d N_M4_s N_M20_d N_M21_s
+ N_8_10 N_8_18 N_8_13 N_8_3 N_8_19 N_8_16 N_8_11 N_8_1 N_8_20 N_8_4 N_8_12
+ N_8_17 N_8_9 N_8_14 N_8_15 PM_DFFLQx4_ASAP7_75t_R%8
cc_26 N_8_10 N_4_35 0.000133674f $X=0.4175 $Y=0.0405
cc_27 N_8_10 N_4_17 0.000138016f $X=0.4175 $Y=0.0405
cc_28 N_8_10 N_4_4 0.000168689f $X=0.4175 $Y=0.0405
cc_29 N_8_10 N_4_34 0.0001841f $X=0.4175 $Y=0.0405
cc_30 N_8_18 N_4_35 0.000222311f $X=0.459 $Y=0.114
cc_31 N_8_13 N_4_17 0.0238447f $X=0.3635 $Y=0.189
cc_32 N_8_3 N_4_34 0.00155505f $X=0.378 $Y=0.2295
cc_33 N_8_3 N_4_2 0.000303936f $X=0.378 $Y=0.2295
cc_34 N_8_19 N_4_35 0.0027163f $X=0.459 $Y=0.1525
cc_35 N_8_16 N_4_35 0.000417315f $X=0.459 $Y=0.234
cc_36 N_8_11 N_4_18 0.00542819f $X=0.4175 $Y=0.081
cc_37 N_8_1 N_4_10 0.00202323f $X=0.567 $Y=0.1215
cc_38 N_8_20 N_4_10 0.000586475f $X=0.54 $Y=0.131
cc_39 N_8_4 N_4_18 0.000614234f $X=0.432 $Y=0.0405
cc_40 N_8_12 N_4_2 0.000737022f $X=0.3635 $Y=0.2295
cc_41 N_8_19 N_4_3 0.001006f $X=0.459 $Y=0.1525
cc_42 N_8_17 N_4_34 0.00140665f $X=0.434 $Y=0.234
cc_43 N_8_17 N_4_36 0.00150295f $X=0.434 $Y=0.234
cc_44 N_8_3 N_4_17 0.0016875f $X=0.378 $Y=0.2295
cc_45 N_8_20 N_4_35 0.00319579f $X=0.54 $Y=0.131
cc_46 N_8_9 N_4_10 0.00421462f $X=0.567 $Y=0.0245
cc_47 N_8_12 N_4_17 0.00961059f $X=0.3635 $Y=0.2295
cc_48 N_8_9 N_4_19 0.0118227f $X=0.567 $Y=0.0245
cc_49 N_8_10 N_4_18 0.0308966f $X=0.4175 $Y=0.0405
cc_50 N_8_3 N_D_5 0.00040237f $X=0.378 $Y=0.2295
cc_51 N_8_17 N_D_5 0.00159246f $X=0.434 $Y=0.234
cc_52 N_8_17 N_6_20 0.000280453f $X=0.434 $Y=0.234
cc_53 N_8_19 N_6_20 0.00200151f $X=0.459 $Y=0.1525
cc_54 N_8_13 N_6_11 0.00540805f $X=0.3635 $Y=0.189
cc_55 N_8_14 N_6_20 0.0004313f $X=0.459 $Y=0.036
cc_56 N_8_4 N_6_1 0.00084257f $X=0.432 $Y=0.0405
cc_57 N_8_4 N_6_11 0.0010092f $X=0.432 $Y=0.0405
cc_58 N_8_3 N_6_11 0.00103521f $X=0.378 $Y=0.2295
cc_59 N_8_18 N_6_20 0.00104796f $X=0.459 $Y=0.114
cc_60 N_8_20 N_6_22 0.00144143f $X=0.54 $Y=0.131
cc_61 N_8_12 N_6_1 0.0016078f $X=0.3635 $Y=0.2295
cc_62 N_8_19 N_6_22 0.00219139f $X=0.459 $Y=0.1525
cc_63 N_8_15 N_6_20 0.00257847f $X=0.459 $Y=0.131
cc_64 N_8_10 N_6_11 0.00938959f $X=0.4175 $Y=0.0405
cc_65 N_8_12 N_6_11 0.010492f $X=0.3635 $Y=0.2295
cc_66 N_8_11 N_6_11 0.0443904f $X=0.4175 $Y=0.081
cc_67 N_8_9 N_7_11 0.00633579f $X=0.567 $Y=0.0245
cc_68 N_8_4 N_7_1 0.000329478f $X=0.432 $Y=0.0405
cc_69 N_8_20 N_7_14 0.000463724f $X=0.54 $Y=0.131
cc_70 N_8_20 N_7_1 0.000887798f $X=0.54 $Y=0.131
cc_71 N_8_1 N_7_16 0.000978364f $X=0.567 $Y=0.1215
cc_72 N_8_20 N_7_19 0.00100329f $X=0.54 $Y=0.131
cc_73 N_8_18 N_7_16 0.00108464f $X=0.459 $Y=0.114
cc_74 N_8_1 N_7_10 0.00111784f $X=0.567 $Y=0.1215
cc_75 N_8_9 N_7_3 0.00113449f $X=0.567 $Y=0.0245
cc_76 N_8_9 N_7_1 0.0011549f $X=0.567 $Y=0.0245
cc_77 N_8_9 N_7_12 0.00624089f $X=0.567 $Y=0.0245
cc_78 N_8_20 N_7_16 0.00668089f $X=0.54 $Y=0.131
cc_79 N_8_9 N_7_10 0.0290395f $X=0.567 $Y=0.0245
x_PM_DFFLQx4_ASAP7_75t_R%4 vss N_M1_g N_M18_g N_M20_g N_M4_g N_M7_g N_M25_g
+ N_M0_s N_M17_s N_4_23 N_4_24 N_4_26 N_4_27 N_4_9 N_4_8 N_4_33 N_4_21 N_4_22
+ N_4_32 N_4_31 N_4_1 N_4_30 N_4_36 N_4_28 N_4_16 N_4_34 N_4_2 N_4_17 N_4_4
+ N_4_5 N_4_35 N_4_3 N_4_10 N_4_18 N_4_20 N_4_19 PM_DFFLQx4_ASAP7_75t_R%4
cc_80 N_4_23 N_CLK_3 7.93955e-20 $X=0.018 $Y=0.036
cc_81 N_4_24 N_CLK_3 0.000221911f $X=0.0165 $Y=0.189
cc_82 N_4_26 N_CLK_3 0.000224634f $X=0.189 $Y=0.189
cc_83 N_4_27 N_CLK_3 0.000240257f $X=0.189 $Y=0.135
cc_84 N_4_9 N_CLK_3 0.00105993f $X=0.054 $Y=0.216
cc_85 N_4_8 N_CLK_3 0.00112714f $X=0.054 $Y=0.054
cc_86 N_4_33 N_CLK_3 0.000293586f $X=0.189 $Y=0.154
cc_87 N_4_21 N_CLK_3 0.0110378f $X=0.056 $Y=0.054
cc_88 N_4_22 N_CLK_3 0.0110339f $X=0.056 $Y=0.216
cc_89 N_4_32 N_CLK_3 0.000603004f $X=0.1235 $Y=0.135
cc_90 N_4_31 N_CLK_3 0.000684059f $X=0.036 $Y=0.234
cc_91 N_4_1 N_CLK_5 0.000785167f $X=0.135 $Y=0.135
cc_92 N_4_30 N_CLK_7 0.000863219f $X=0.036 $Y=0.036
cc_93 N_4_32 N_CLK_1 0.000880698f $X=0.1235 $Y=0.135
cc_94 N_4_31 N_CLK_8 0.00134256f $X=0.036 $Y=0.234
cc_95 N_4_36 N_CLK_5 0.00156473f $X=0.0215 $Y=0.189
cc_96 N_4_28 N_CLK_6 0.00183012f $X=0.018 $Y=0.172
cc_97 N_4_32 N_CLK_6 0.00202601f $X=0.1235 $Y=0.135
cc_98 N_4_30 N_CLK_4 0.00213502f $X=0.036 $Y=0.036
cc_99 N_4_26 N_CLK_5 0.00245511f $X=0.189 $Y=0.189
cc_100 N_4_24 N_CLK_5 0.00250974f $X=0.0165 $Y=0.189
cc_101 N_4_32 N_CLK_4 0.00318913f $X=0.1235 $Y=0.135
cc_102 N_4_1 N_CLK_1 0.0032742f $X=0.135 $Y=0.135
cc_103 N_4_16 N_CLK_3 0.0354738f $X=0.135 $Y=0.0245
x_PM_DFFLQx4_ASAP7_75t_R%6 vss N_M3_g N_M21_g N_M8_g N_M24_g N_M1_d N_M18_d
+ N_6_19 N_6_5 N_6_6 N_6_18 N_6_17 N_6_14 N_6_12 N_6_16 N_6_13 N_6_22 N_6_11
+ N_6_2 N_6_21 N_6_20 N_6_1 N_6_15 PM_DFFLQx4_ASAP7_75t_R%6
cc_104 N_6_19 N_CLK_7 0.000143281f $X=0.243 $Y=0.135
cc_105 N_6_5 N_CLK_7 0.000466899f $X=0.162 $Y=0.054
cc_106 N_6_6 N_CLK_7 0.00019453f $X=0.162 $Y=0.216
cc_107 N_6_18 N_CLK_7 0.00117928f $X=0.216 $Y=0.234
cc_108 N_6_17 N_CLK_7 0.00222765f $X=0.216 $Y=0.036
cc_109 N_6_14 N_4_8 9.35086e-20 $X=0.1475 $Y=0.216
cc_110 N_6_14 N_4_31 5.20113e-20 $X=0.1475 $Y=0.216
cc_111 N_6_14 N_4_1 5.35581e-20 $X=0.1475 $Y=0.216
cc_112 N_6_14 N_4_9 5.41537e-20 $X=0.1475 $Y=0.216
cc_113 N_6_18 N_4_24 5.83114e-20 $X=0.216 $Y=0.234
cc_114 N_6_5 N_4_28 7.46344e-20 $X=0.162 $Y=0.054
cc_115 N_6_5 N_4_16 0.000765077f $X=0.162 $Y=0.054
cc_116 N_6_17 N_4_30 0.000148448f $X=0.216 $Y=0.036
cc_117 N_6_12 N_4_4 0.000190372f $X=0.675 $Y=0.135
cc_118 N_6_16 N_4_26 0.000229425f $X=0.243 $Y=0.234
cc_119 N_6_12 N_4_5 0.000244854f $X=0.675 $Y=0.135
cc_120 N_6_18 N_4_26 0.00461521f $X=0.216 $Y=0.234
cc_121 N_6_13 N_4_16 0.0110842f $X=0.1475 $Y=0.054
cc_122 N_6_22 N_4_35 0.000886896f $X=0.2315 $Y=0.153
cc_123 N_6_5 N_4_1 0.000398553f $X=0.162 $Y=0.054
cc_124 N_6_6 N_4_26 0.00042788f $X=0.162 $Y=0.216
cc_125 N_6_11 N_4_3 0.000469405f $X=0.405 $Y=0.0245
cc_126 N_6_2 N_4_10 0.00244952f $X=0.675 $Y=0.135
cc_127 N_6_21 N_4_10 0.00050147f $X=0.675 $Y=0.1125
cc_128 N_6_22 N_4_34 0.000514487f $X=0.2315 $Y=0.153
cc_129 N_6_17 N_4_27 0.00055977f $X=0.216 $Y=0.036
cc_130 N_6_20 N_4_36 0.000561126f $X=0.405 $Y=0.116
cc_131 N_6_19 N_4_36 0.00069675f $X=0.243 $Y=0.135
cc_132 N_6_5 N_4_32 0.000849161f $X=0.162 $Y=0.054
cc_133 N_6_1 N_4_2 0.00244003f $X=0.405 $Y=0.133
cc_134 N_6_19 N_4_33 0.000975834f $X=0.243 $Y=0.135
cc_135 N_6_6 N_4_16 0.00111465f $X=0.162 $Y=0.216
cc_136 N_6_20 N_4_34 0.00305483f $X=0.405 $Y=0.116
cc_137 N_6_11 N_4_18 0.00330642f $X=0.405 $Y=0.0245
cc_138 N_6_19 N_4_27 0.00343117f $X=0.243 $Y=0.135
cc_139 N_6_12 N_4_10 0.00375614f $X=0.675 $Y=0.135
cc_140 N_6_12 N_4_20 0.00552826f $X=0.675 $Y=0.135
cc_141 N_6_11 N_4_17 0.00683922f $X=0.405 $Y=0.0245
cc_142 N_6_12 N_4_19 0.0171396f $X=0.675 $Y=0.135
cc_143 N_6_22 N_4_36 0.0253229f $X=0.2315 $Y=0.153
cc_144 N_6_14 N_4_16 0.0391787f $X=0.1475 $Y=0.216
cc_145 N_6_16 N_D_5 0.00102181f $X=0.243 $Y=0.234
cc_146 N_6_22 N_D_6 0.001116f $X=0.2315 $Y=0.153
cc_147 N_6_15 N_D_4 0.00126396f $X=0.243 $Y=0.036
cc_148 N_6_19 N_D_6 0.00810225f $X=0.243 $Y=0.135
x_PM_DFFLQx4_ASAP7_75t_R%7 vss N_M5_g N_M22_g N_M6_d N_M7_s N_M23_d N_M24_s
+ N_7_3 N_7_1 N_7_4 N_7_12 N_7_13 N_7_17 N_7_19 N_7_11 N_7_10 N_7_18 N_7_14
+ N_7_16 PM_DFFLQx4_ASAP7_75t_R%7
cc_149 N_7_3 N_4_3 0.000104964f $X=0.594 $Y=0.0405
cc_150 N_7_3 N_4_35 0.000248954f $X=0.594 $Y=0.0405
cc_151 N_7_3 N_4_10 0.000337308f $X=0.594 $Y=0.0405
cc_152 N_7_1 N_4_18 0.000694141f $X=0.513 $Y=0.09
cc_153 N_7_4 N_4_10 0.00652176f $X=0.594 $Y=0.2295
cc_154 N_7_12 N_4_19 0.00763052f $X=0.5795 $Y=0.2295
cc_155 N_7_13 N_4_19 0.00766482f $X=0.65 $Y=0.2295
cc_156 N_7_17 N_4_35 0.000342067f $X=0.5965 $Y=0.234
cc_157 N_7_17 N_4_10 0.000479534f $X=0.5965 $Y=0.234
cc_158 N_7_4 N_4_4 0.000871237f $X=0.594 $Y=0.2295
cc_159 N_7_19 N_4_10 0.00163986f $X=0.621 $Y=0.1105
cc_160 N_7_4 N_4_19 0.00229355f $X=0.594 $Y=0.2295
cc_161 N_7_11 N_4_19 0.00629449f $X=0.5795 $Y=0.0405
cc_162 N_7_10 N_4_18 0.01371f $X=0.513 $Y=0.0245
cc_163 N_7_3 N_4_19 0.0291213f $X=0.594 $Y=0.0405
cc_164 N_7_13 N_6_21 0.000154464f $X=0.65 $Y=0.2295
cc_165 N_7_13 N_6_22 0.000213192f $X=0.65 $Y=0.2295
cc_166 N_7_19 N_6_2 0.000561187f $X=0.621 $Y=0.1105
cc_167 N_7_18 N_6_21 0.000255642f $X=0.594 $Y=0.054
cc_168 N_7_19 N_6_21 0.00453428f $X=0.621 $Y=0.1105
cc_169 N_7_14 N_6_21 0.000751376f $X=0.594 $Y=0.09
cc_170 N_7_16 N_6_22 0.00272402f $X=0.5 $Y=0.09
cc_171 N_7_13 N_6_12 0.0155769f $X=0.65 $Y=0.2295
x_PM_DFFLQx4_ASAP7_75t_R%9 vss N_M9_g N_M26_g N_M10_d N_M27_d N_9_9 N_9_14
+ N_9_18 N_9_4 N_9_3 N_9_1 N_9_17 N_9_12 N_9_15 N_9_16 N_9_11 N_9_10
+ PM_DFFLQx4_ASAP7_75t_R%9
cc_172 N_9_9 N_4_10 0.000207783f $X=0.783 $Y=0.0245
cc_173 N_9_9 N_4_5 0.000410438f $X=0.783 $Y=0.0245
cc_174 N_9_9 N_4_20 0.0128917f $X=0.783 $Y=0.0245
x_PM_DFFLQx4_ASAP7_75t_R%11 vss N_M13_g N_M30_g N_M14_g N_M31_g N_M15_g N_M32_g
+ N_M16_g N_M33_g N_M11_d N_M12_d N_M28_d N_M29_d N_11_14 N_11_18 N_11_19
+ N_11_20 N_11_21 N_11_4 N_11_13 N_11_9 N_11_3 N_11_1 N_11_10 N_11_15 N_11_17
+ N_11_11 N_11_22 N_11_12 PM_DFFLQx4_ASAP7_75t_R%11
cc_175 N_11_14 N_10_13 0.0591183f $X=1.0115 $Y=0.2025
cc_176 N_11_14 N_10_2 0.00614197f $X=1.0115 $Y=0.2025
cc_177 N_11_14 N_10_28 0.00033503f $X=1.0115 $Y=0.2025
cc_178 N_11_18 N_10_28 0.000443201f $X=1.0145 $Y=0.036
cc_179 N_11_19 N_10_28 0.000475936f $X=1.0145 $Y=0.234
cc_180 N_11_20 N_10_2 0.000482763f $X=1.089 $Y=0.1245
cc_181 N_11_21 N_10_2 0.000588306f $X=1.089 $Y=0.156
cc_182 N_11_4 N_10_2 0.000629649f $X=1.026 $Y=0.2025
cc_183 N_11_19 N_10_29 0.000699516f $X=1.0145 $Y=0.234
cc_184 N_11_13 N_10_13 0.0114744f $X=1.0115 $Y=0.0675
cc_185 N_11_4 N_10_28 0.00115414f $X=1.026 $Y=0.2025
cc_186 N_11_9 N_10_13 0.00175093f $X=1.107 $Y=0.0245
cc_187 N_11_3 N_10_13 0.00175098f $X=1.026 $Y=0.0675
cc_188 N_11_4 N_10_13 0.00190878f $X=1.026 $Y=0.2025
cc_189 N_11_13 N_10_12 0.018837f $X=1.0115 $Y=0.0675
cc_190 N_11_14 N_10_12 0.0496111f $X=1.0115 $Y=0.2025
x_PM_DFFLQx4_ASAP7_75t_R%15 vss N_M8_d N_M9_s N_15_1 N_15_5 N_15_4
+ PM_DFFLQx4_ASAP7_75t_R%15
cc_191 N_15_1 N_4_20 0.000699534f $X=0.702 $Y=0.0405
cc_192 N_15_5 N_4_20 0.00667193f $X=0.758 $Y=0.0405
cc_193 N_15_4 N_4_20 0.0257324f $X=0.6875 $Y=0.0405
cc_194 N_15_4 N_6_12 0.0148658f $X=0.6875 $Y=0.0405
cc_195 N_15_1 N_9_9 0.000886654f $X=0.702 $Y=0.0405
cc_196 N_15_5 N_9_9 0.0149494f $X=0.758 $Y=0.0405
cc_197 N_15_1 N_10_14 0.000319165f $X=0.702 $Y=0.0405
cc_198 N_15_1 N_10_21 0.000417678f $X=0.702 $Y=0.0405
cc_199 N_15_1 N_10_22 0.000546458f $X=0.702 $Y=0.0405
cc_200 N_15_4 N_10_5 0.000557441f $X=0.6875 $Y=0.0405
cc_201 N_15_1 N_10_17 0.00237587f $X=0.702 $Y=0.0405
x_PM_DFFLQx4_ASAP7_75t_R%10 vss N_M10_g N_M27_g N_M24_d N_M25_s N_M11_g N_M28_g
+ N_M12_g N_M29_g N_M7_d N_M8_s N_10_18 N_10_16 N_10_6 N_10_14 N_10_24 N_10_22
+ N_10_23 N_10_15 N_10_5 N_10_21 N_10_2 N_10_19 N_10_27 N_10_20 N_10_28 N_10_26
+ N_10_11 N_10_1 N_10_17 N_10_25 N_10_29 N_10_13 N_10_12
+ PM_DFFLQx4_ASAP7_75t_R%10
cc_202 N_10_18 N_4_10 0.000194235f $X=0.729 $Y=0.16
cc_203 N_10_16 N_4_10 0.000205714f $X=0.729 $Y=0.234
cc_204 N_10_6 N_4_10 0.000209205f $X=0.702 $Y=0.2295
cc_205 N_10_14 N_4_19 0.00657233f $X=0.6335 $Y=0.0405
cc_206 N_10_24 N_4_5 0.000358043f $X=0.81 $Y=0.162
cc_207 N_10_22 N_4_10 0.000479195f $X=0.729 $Y=0.136
cc_208 N_10_23 N_4_10 0.000564991f $X=0.729 $Y=0.198
cc_209 N_10_6 N_4_20 0.000929901f $X=0.702 $Y=0.2295
cc_210 N_10_15 N_4_5 0.00131971f $X=0.6875 $Y=0.2295
cc_211 N_10_15 N_4_10 0.00211574f $X=0.6875 $Y=0.2295
cc_212 N_10_5 N_4_19 0.00946297f $X=0.648 $Y=0.0405
cc_213 N_10_15 N_4_20 0.0166976f $X=0.6875 $Y=0.2295
cc_214 N_10_5 N_6_22 0.000116286f $X=0.648 $Y=0.0405
cc_215 N_10_24 N_6_21 0.000128191f $X=0.81 $Y=0.162
cc_216 N_10_6 N_6_12 0.000136627f $X=0.702 $Y=0.2295
cc_217 N_10_15 N_6_12 0.00644126f $X=0.6875 $Y=0.2295
cc_218 N_10_14 N_6_12 0.00654164f $X=0.6335 $Y=0.0405
cc_219 N_10_16 N_6_21 0.000372398f $X=0.729 $Y=0.234
cc_220 N_10_22 N_6_21 0.00414507f $X=0.729 $Y=0.136
cc_221 N_10_23 N_6_21 0.000502311f $X=0.729 $Y=0.198
cc_222 N_10_5 N_6_2 0.000506838f $X=0.648 $Y=0.0405
cc_223 N_10_18 N_6_21 0.000510042f $X=0.729 $Y=0.16
cc_224 N_10_22 N_6_2 0.000528325f $X=0.729 $Y=0.136
cc_225 N_10_21 N_6_21 0.00059559f $X=0.704 $Y=0.036
cc_226 N_10_21 N_6_22 0.00100761f $X=0.704 $Y=0.036
cc_227 N_10_5 N_6_12 0.0187773f $X=0.648 $Y=0.0405
cc_228 N_10_16 N_7_3 0.000187116f $X=0.729 $Y=0.234
cc_229 N_10_15 N_7_3 0.00043998f $X=0.6875 $Y=0.2295
cc_230 N_10_14 N_7_11 0.000477045f $X=0.6335 $Y=0.0405
cc_231 N_10_16 N_7_4 0.000263775f $X=0.729 $Y=0.234
cc_232 N_10_6 N_7_4 0.000711693f $X=0.702 $Y=0.2295
cc_233 N_10_16 N_7_19 0.000565186f $X=0.729 $Y=0.234
cc_234 N_10_15 N_7_4 0.000574823f $X=0.6875 $Y=0.2295
cc_235 N_10_21 N_7_18 0.000596151f $X=0.704 $Y=0.036
cc_236 N_10_21 N_7_14 0.00152352f $X=0.704 $Y=0.036
cc_237 N_10_5 N_7_3 0.00350541f $X=0.648 $Y=0.0405
cc_238 N_10_2 N_9_9 0.000177797f $X=0.9895 $Y=0.136
cc_239 N_10_19 N_9_9 0.000212886f $X=0.837 $Y=0.162
cc_240 N_10_27 N_9_9 0.000229167f $X=0.891 $Y=0.1305
cc_241 N_10_20 N_9_14 0.000238481f $X=0.891 $Y=0.1575
cc_242 N_10_28 N_9_18 0.00613256f $X=0.999 $Y=0.1245
cc_243 N_10_2 N_9_18 0.000366746f $X=0.9895 $Y=0.136
cc_244 N_10_26 N_9_4 0.000372271f $X=0.848 $Y=0.162
cc_245 N_10_20 N_9_18 0.00127277f $X=0.891 $Y=0.1575
cc_246 N_10_11 N_9_3 0.000396596f $X=0.837 $Y=0.0245
cc_247 N_10_11 N_9_4 0.000538516f $X=0.837 $Y=0.0245
cc_248 N_10_1 N_9_1 0.000606584f $X=0.837 $Y=0.1245
cc_249 N_10_26 N_9_17 0.000689645f $X=0.848 $Y=0.162
cc_250 N_10_17 N_9_12 0.000791346f $X=0.729 $Y=0.036
cc_251 N_10_25 N_9_15 0.000831811f $X=0.837 $Y=0.118
cc_252 N_10_22 N_9_1 0.00097353f $X=0.729 $Y=0.136
cc_253 N_10_1 N_9_9 0.00109115f $X=0.837 $Y=0.1245
cc_254 N_10_27 N_9_16 0.00112138f $X=0.891 $Y=0.1305
cc_255 N_10_11 N_9_1 0.00118356f $X=0.837 $Y=0.0245
cc_256 N_10_20 N_9_17 0.00120374f $X=0.891 $Y=0.1575
cc_257 N_10_27 N_9_18 0.00135282f $X=0.891 $Y=0.1305
cc_258 N_10_24 N_9_15 0.0014095f $X=0.81 $Y=0.162
cc_259 N_10_29 N_9_18 0.00177276f $X=0.8795 $Y=0.153
cc_260 N_10_11 N_9_11 0.00655455f $X=0.837 $Y=0.0245
cc_261 N_10_11 N_9_10 0.0065307f $X=0.837 $Y=0.0245
cc_262 N_10_22 N_9_15 0.00457643f $X=0.729 $Y=0.136
cc_263 N_10_11 N_9_9 0.0307605f $X=0.837 $Y=0.0245
x_PM_DFFLQx4_ASAP7_75t_R%13 vss N_M2_d N_M3_s N_13_4 N_13_5 N_13_1
+ PM_DFFLQx4_ASAP7_75t_R%13
cc_264 N_13_4 N_4_34 0.000183325f $X=0.3095 $Y=0.0675
cc_265 N_13_4 N_4_2 0.00193951f $X=0.3095 $Y=0.0675
cc_266 N_13_4 N_4_17 0.0721698f $X=0.3095 $Y=0.0675
cc_267 N_13_4 N_D_6 0.000705735f $X=0.3095 $Y=0.0675
cc_268 N_13_4 N_D_3 0.0356698f $X=0.3095 $Y=0.0675
cc_269 N_13_5 N_6_20 0.000277373f $X=0.38 $Y=0.0675
cc_270 N_13_5 N_6_1 0.000625669f $X=0.38 $Y=0.0675
cc_271 N_13_5 N_6_11 0.0342422f $X=0.38 $Y=0.0675
cc_272 N_13_1 N_8_11 0.000586211f $X=0.351 $Y=0.0675
cc_273 N_13_1 N_8_4 0.00106466f $X=0.351 $Y=0.0675
cc_274 N_13_1 N_8_10 0.00260605f $X=0.351 $Y=0.0675
x_PM_DFFLQx4_ASAP7_75t_R%Q vss Q N_M13_d N_M14_d N_M15_d N_M16_d N_M32_d
+ N_M33_d N_M30_d N_M31_d N_Q_16 N_Q_3 N_Q_2 N_Q_4 N_Q_1 N_Q_18 N_Q_17 N_Q_14
+ N_Q_13 N_Q_15 PM_DFFLQx4_ASAP7_75t_R%Q
cc_275 N_Q_16 N_11_1 0.0107167f $X=1.2275 $Y=0.2025
cc_276 N_Q_16 N_11_21 0.000607748f $X=1.2275 $Y=0.2025
cc_277 N_Q_16 N_11_20 0.000608063f $X=1.2275 $Y=0.2025
cc_278 N_Q_16 N_11_10 0.0016379f $X=1.2275 $Y=0.2025
cc_279 N_Q_16 N_11_15 0.000981293f $X=1.2275 $Y=0.2025
cc_280 N_Q_16 N_11_17 0.000990233f $X=1.2275 $Y=0.2025
cc_281 N_Q_3 N_11_11 0.0015716f $X=1.242 $Y=0.0675
cc_282 N_Q_2 N_11_22 0.00161993f $X=1.134 $Y=0.2025
cc_283 N_Q_4 N_11_11 0.00166384f $X=1.242 $Y=0.2025
cc_284 N_Q_1 N_11_10 0.00200608f $X=1.134 $Y=0.0675
cc_285 N_Q_2 N_11_10 0.00207915f $X=1.134 $Y=0.2025
cc_286 N_Q_18 N_11_21 0.00229514f $X=1.134 $Y=0.234
cc_287 N_Q_17 N_11_20 0.00233414f $X=1.134 $Y=0.054
cc_288 N_Q_14 N_11_12 0.0102799f $X=1.2275 $Y=0.0675
cc_289 N_Q_13 N_11_10 0.0180597f $X=1.1195 $Y=0.0675
cc_290 N_Q_14 N_11_11 0.0542992f $X=1.2275 $Y=0.0675
cc_291 N_Q_16 N_11_11 0.0182403f $X=1.2275 $Y=0.2025
cc_292 N_Q_15 N_11_9 0.0182531f $X=1.1195 $Y=0.2025
cc_293 N_Q_13 N_11_9 0.0462247f $X=1.1195 $Y=0.0675
cc_294 N_Q_15 N_11_10 0.0463766f $X=1.1195 $Y=0.2025
cc_295 N_Q_16 N_11_12 0.0496881f $X=1.2275 $Y=0.2025

* End of included file DFFLQx4_ASAP7_75t_R.pex.sp.pxi
.ends

* Design:	MAJIxp5_ASAP7_75t_R
* Created:	"Thu Nov14 2024"
* Vendor:	"Mentor Graphics Corporation"
* Program:	"Calibre xACT 3D"
* Version:	"v2023.3_29.15"
* Corner Name: typical_25
* Nominal Temperature: 25C
* Circuit Temperature: 25C
*
* Integrated TICER reduction is not enabled.
* SHORT DELAY THRESHOLD: 2e-14
* Fill Mode: GF
* PEX REDUCE CC ABSOLUTE : disabled
* PEX REDUCE CC RATIO : disabled
* Delta transform mode : 344834

.subckt PM_MAJIXP5_ASAP7_75T_R%VSS vss 13 15 10 11 17 51 4 1 5
c1 1 vss 0.0205243f $X=0.09751 $Y=0.0
c2 4 vss 0.000315317f $X=0.108 $Y=0.0085
c3 5 vss 0.00267611f $X=0.324 $Y=0.0
c4 10 vss 0.00784528f $X=0.0906 $Y=0.06751
c5 11 vss 0.0304529f $X=0.3067 $Y=0.06751
c6 15 vss 0.00592455f $X=0.1891 $Y=0.0
r1 1 23 4.91914 $l=1.05e-08 $layer=LIG $X=0.09751 $Y=0.0 $X2=0.108 $Y2=0.0
r2 4 18 5.54939 $l=9.5e-09 $layer=LISD $X=0.108 $Y=0.0085 $X2=0.108 $Y2=0.018
r3 4 20 3.80936 $l=8.5e-09 $layer=LISD $X=0.108 $Y=0.0085 $X2=0.108 $Y2=0.0
r4 5 30 3.51728 $l=0 $layer=LISD $X=0.324 $Y=0.0 $X2=0.324 $Y2=0.0
r5 5 36 19.38 $l=1.8e-08 $layer=V0LISD $X=0.324 $Y=0.0 $X2=0.324 $Y2=0.0
r6 5 39 3.80936 $l=8.5e-09 $layer=LISD $X=0.324 $Y=0.0 $X2=0.324 $Y2=0.0085
r7 10 16 0.209877 $l=1.7e-08 $layer=N_src_drn $X=0.0906 $Y=0.06751 $X2=0.108
+ $Y2=0.06751
r8 11 41 0.154321 $l=1.25e-08 $layer=N_src_drn $X=0.3067 $Y=0.06751 $X2=0.324
+ $Y2=0.06751
r9 15 33 8.38604 $l=3.63e-08 $layer=M1 $X=0.1891 $Y=0.0 $X2=0.1526 $Y2=0.0
r10 15 35 14.6322 $l=6.32e-08 $layer=M1 $X=0.1891 $Y=0.0 $X2=0.2522 $Y2=0.0
r11 17 16 0.209877 $l=1.7e-08 $layer=N_src_drn $X=0.1255 $Y=0.06751 $X2=0.108
+ $Y2=0.06751
r12 18 16 28.9152 $l=4.95e-08 $layer=LISD $X=0.108 $Y=0.018 $X2=0.108
+ $Y2=0.06751
r13 20 21 3.51728 $l=0 $layer=LISD $X=0.108 $Y=0.0 $X2=0.108 $Y2=0.0
r14 20 32 19.38 $l=1.8e-08 $layer=V0LISD $X=0.108 $Y=0.0 $X2=0.108 $Y2=0.0
r15 21 24 0.702734 $l=1.05e-08 $layer=LIG $X=0.108 $Y=0.0 $X2=0.1185 $Y2=0.0
r16 21 23 4.21641 $l=0 $layer=LIG $X=0.108 $Y=0.0 $X2=0.108 $Y2=0.0
r17 23 24 4.91914 $l=1.05e-08 $layer=LIG $X=0.108 $Y=0.0 $X2=0.1185 $Y2=0.0
r18 23 32 28.9688 $l=1.6e-08 $layer=V0LIG $X=0.108 $Y=0.0 $X2=0.108 $Y2=0.0
r19 24 26 222.489 $l=9.75e-08 $layer=LIG $X=0.1185 $Y=0.0 $X2=0.216 $Y2=0.0
r20 26 27 222.489 $l=9.75e-08 $layer=LIG $X=0.216 $Y=0.0 $X2=0.3134 $Y2=0.0
r21 27 28 4.91914 $l=1.05e-08 $layer=LIG $X=0.3134 $Y=0.0 $X2=0.324 $Y2=0.0
r22 28 30 4.21641 $l=0 $layer=LIG $X=0.324 $Y=0.0 $X2=0.324 $Y2=0.0
r23 28 36 28.9688 $l=1.6e-08 $layer=V0LIG $X=0.324 $Y=0.0 $X2=0.324 $Y2=0.0
r24 32 33 10.3524 $l=4.47e-08 $layer=M1 $X=0.108 $Y=0.0 $X2=0.1526 $Y2=0.0
r25 35 36 16.5986 $l=7.18e-08 $layer=M1 $X=0.2522 $Y=0.0 $X2=0.324 $Y2=0.0
r26 39 40 5.54939 $l=9.5e-09 $layer=LISD $X=0.324 $Y=0.0085 $X2=0.324 $Y2=0.018
r27 40 41 28.9152 $l=4.95e-08 $layer=LISD $X=0.324 $Y=0.018 $X2=0.324
+ $Y2=0.06751
.ends

.subckt PM_MAJIXP5_ASAP7_75T_R%C vss 5 3 4 11 24 1
c1 1 vss 0.00165469f $X=0.081 $Y=0.1351
c2 4 vss 0.00857676f $X=0.1351 $Y=0.06751
c3 5 vss 0.000283345f $X=0.108 $Y=0.1149
r1 1 9 4.6849 $l=0 $layer=LIG $X=0.081 $Y=0.1351 $X2=0.081 $Y2=0.1351
r2 1 14 43.9596 $l=2.7e-08 $layer=LIG $X=0.081 $Y=0.1351 $X2=0.108 $Y2=0.1351
r3 3 7 10.1531 $l=2.98e-08 $layer=Gate_1 $X=0.081 $Y=0.06751 $X2=0.081
+ $Y2=0.09729
r4 4 22 10.1531 $l=2.98e-08 $layer=Gate_1 $X=0.1351 $Y=0.06751 $X2=0.1351
+ $Y2=0.09729
r5 5 18 5.72564 $l=2.47e-08 $layer=M1 $X=0.108 $Y=0.1149 $X2=0.108 $Y2=0.1396
r6 7 8 12.9422 $l=3.77e-08 $layer=Gate_1 $X=0.081 $Y=0.09729 $X2=0.081
+ $Y2=0.1351
r7 8 9 2.85714 $l=0 $layer=Gate_1 $X=0.081 $Y=0.1351 $X2=0.081 $Y2=0.1351
r8 8 10 12.9422 $l=3.76e-08 $layer=Gate_1 $X=0.081 $Y=0.1351 $X2=0.081
+ $Y2=0.1725
r9 11 10 10.1531 $l=2.99e-08 $layer=Gate_1 $X=0.081 $Y=0.2025 $X2=0.081
+ $Y2=0.1725
r10 14 15 43.9596 $l=2.7e-08 $layer=LIG $X=0.108 $Y=0.1351 $X2=0.1351 $Y2=0.1351
r11 14 18 28.9688 $l=1.6e-08 $layer=V0LIG $X=0.108 $Y=0.1351 $X2=0.108
+ $Y2=0.1396
r12 15 21 4.6849 $l=0 $layer=LIG $X=0.1351 $Y=0.1351 $X2=0.1351 $Y2=0.1351
r13 19 21 2.85714 $l=0 $layer=Gate_1 $X=0.1351 $Y=0.1351 $X2=0.1351 $Y2=0.1351
r14 19 22 12.9422 $l=3.77e-08 $layer=Gate_1 $X=0.1351 $Y=0.1351 $X2=0.1351
+ $Y2=0.09729
r15 19 23 12.9422 $l=3.76e-08 $layer=Gate_1 $X=0.1351 $Y=0.1351 $X2=0.1351
+ $Y2=0.1725
r16 24 23 10.1531 $l=2.99e-08 $layer=Gate_1 $X=0.1351 $Y=0.2025 $X2=0.1351
+ $Y2=0.1725
.ends

.subckt PM_MAJIXP5_ASAP7_75T_R%VDD vss 12 13 10 11 15 45 5 4 1
c1 1 vss 0.0203118f $X=0.09751 $Y=0.27
c2 4 vss 0.000822095f $X=0.108 $Y=0.2025
c3 5 vss 0.00264826f $X=0.324 $Y=0.27
c4 10 vss 0.00795981f $X=0.0906 $Y=0.2025
c5 11 vss 0.0305969f $X=0.3067 $Y=0.2025
c6 13 vss 0.00468331f $X=0.1891 $Y=0.27
r1 1 21 4.91914 $l=1.05e-08 $layer=LIG $X=0.09751 $Y=0.27 $X2=0.108 $Y2=0.27
r2 4 16 28.9152 $l=4.95e-08 $layer=LISD $X=0.108 $Y=0.2025 $X2=0.108 $Y2=0.252
r3 5 28 3.51728 $l=0 $layer=LISD $X=0.324 $Y=0.27 $X2=0.324 $Y2=0.27
r4 5 34 19.38 $l=1.8e-08 $layer=V0LISD $X=0.324 $Y=0.27 $X2=0.324 $Y2=0.27
r5 5 38 3.80936 $l=8.5e-09 $layer=LISD $X=0.324 $Y=0.27 $X2=0.324 $Y2=0.2616
r6 10 4 0.209877 $l=1.7e-08 $layer=P_src_drn $X=0.0906 $Y=0.2025 $X2=0.108
+ $Y2=0.2025
r7 11 36 0.154321 $l=1.25e-08 $layer=P_src_drn $X=0.3067 $Y=0.2025 $X2=0.324
+ $Y2=0.2025
r8 13 31 8.38604 $l=3.63e-08 $layer=M1 $X=0.1891 $Y=0.27 $X2=0.1526 $Y2=0.27
r9 13 33 14.6322 $l=6.32e-08 $layer=M1 $X=0.1891 $Y=0.27 $X2=0.2522 $Y2=0.27
r10 15 4 0.209877 $l=1.7e-08 $layer=P_src_drn $X=0.1255 $Y=0.2025 $X2=0.108
+ $Y2=0.2025
r11 16 17 5.54939 $l=9.5e-09 $layer=LISD $X=0.108 $Y=0.252 $X2=0.108 $Y2=0.2616
r12 17 18 3.80936 $l=8.5e-09 $layer=LISD $X=0.108 $Y=0.2616 $X2=0.108 $Y2=0.27
r13 18 19 3.51728 $l=0 $layer=LISD $X=0.108 $Y=0.27 $X2=0.108 $Y2=0.27
r14 18 30 19.38 $l=1.8e-08 $layer=V0LISD $X=0.108 $Y=0.27 $X2=0.108 $Y2=0.27
r15 19 22 0.702734 $l=1.05e-08 $layer=LIG $X=0.108 $Y=0.27 $X2=0.1185 $Y2=0.27
r16 19 21 4.21641 $l=0 $layer=LIG $X=0.108 $Y=0.27 $X2=0.108 $Y2=0.27
r17 21 22 4.91914 $l=1.05e-08 $layer=LIG $X=0.108 $Y=0.27 $X2=0.1185 $Y2=0.27
r18 21 30 28.9688 $l=1.6e-08 $layer=V0LIG $X=0.108 $Y=0.27 $X2=0.108 $Y2=0.27
r19 22 24 222.489 $l=9.75e-08 $layer=LIG $X=0.1185 $Y=0.27 $X2=0.216 $Y2=0.27
r20 24 25 222.489 $l=9.75e-08 $layer=LIG $X=0.216 $Y=0.27 $X2=0.3134 $Y2=0.27
r21 25 26 4.91914 $l=1.05e-08 $layer=LIG $X=0.3134 $Y=0.27 $X2=0.324 $Y2=0.27
r22 26 28 4.21641 $l=0 $layer=LIG $X=0.324 $Y=0.27 $X2=0.324 $Y2=0.27
r23 26 34 28.9688 $l=1.6e-08 $layer=V0LIG $X=0.324 $Y=0.27 $X2=0.324 $Y2=0.27
r24 30 31 10.3524 $l=4.47e-08 $layer=M1 $X=0.108 $Y=0.27 $X2=0.1526 $Y2=0.27
r25 33 34 16.5986 $l=7.18e-08 $layer=M1 $X=0.2522 $Y=0.27 $X2=0.324 $Y2=0.27
r26 36 37 28.9152 $l=4.95e-08 $layer=LISD $X=0.324 $Y=0.2025 $X2=0.324 $Y2=0.252
r27 37 38 5.54939 $l=9.5e-09 $layer=LISD $X=0.324 $Y=0.252 $X2=0.324 $Y2=0.2616
.ends

.subckt PM_MAJIXP5_ASAP7_75T_R%B vss 7 5 6 17 36 1 2 8 9
c1 1 vss 0.00108466f $X=0.1891 $Y=0.1351
c2 2 vss 0.00280368f $X=0.2971 $Y=0.1351
c3 6 vss 0.00263882f $X=0.2971 $Y=0.06751
c4 7 vss 0.000529564f $X=0.1891 $Y=0.1149
c5 8 vss 0.000650005f $X=0.2971 $Y=0.1204
c6 9 vss 0.0043921f $X=0.1776 $Y=0.1351
r1 1 15 4.6849 $l=0 $layer=LIG $X=0.1891 $Y=0.1351 $X2=0.1891 $Y2=0.1351
r2 1 22 28.9688 $l=1.6e-08 $layer=V0LIG $X=0.1891 $Y=0.1351 $X2=0.1891
+ $Y2=0.1396
r3 2 33 4.6849 $l=0 $layer=LIG $X=0.2971 $Y=0.1351 $X2=0.2971 $Y2=0.1351
r4 2 27 28.9688 $l=1.6e-08 $layer=V0LIG $X=0.2971 $Y=0.1351 $X2=0.2971
+ $Y2=0.1351
r5 5 13 10.1531 $l=2.98e-08 $layer=Gate_1 $X=0.1891 $Y=0.06751 $X2=0.1891
+ $Y2=0.09729
r6 6 34 10.1531 $l=2.98e-08 $layer=Gate_1 $X=0.2971 $Y=0.06751 $X2=0.2971
+ $Y2=0.09729
r7 7 22 5.72564 $l=2.47e-08 $layer=M1 $X=0.1891 $Y=0.1149 $X2=0.1891 $Y2=0.1396
r8 8 27 3.37755 $l=1.46e-08 $layer=M1 $X=0.2971 $Y=0.1204 $X2=0.2971 $Y2=0.1351
r9 9 23 2.6604 $l=1.15e-08 $layer=M2 $X=0.1776 $Y=0.1351 $X2=0.1891 $Y2=0.1351
r10 13 14 12.9422 $l=3.77e-08 $layer=Gate_1 $X=0.1891 $Y=0.09729 $X2=0.1891
+ $Y2=0.1351
r11 14 15 2.85714 $l=0 $layer=Gate_1 $X=0.1891 $Y=0.1351 $X2=0.1891 $Y2=0.1351
r12 14 16 12.9422 $l=3.76e-08 $layer=Gate_1 $X=0.1891 $Y=0.1351 $X2=0.1891
+ $Y2=0.1725
r13 17 16 10.1531 $l=2.99e-08 $layer=Gate_1 $X=0.1891 $Y=0.2025 $X2=0.1891
+ $Y2=0.1725
r14 22 23 19.38 $l=1.8e-08 $layer=V1 $X=0.1891 $Y=0.1396 $X2=0.1891 $Y2=0.1351
r15 23 24 12.4923 $l=5.4e-08 $layer=M2 $X=0.1891 $Y=0.1351 $X2=0.2431 $Y2=0.1351
r16 24 25 12.4923 $l=5.4e-08 $layer=M2 $X=0.2431 $Y=0.1351 $X2=0.2971 $Y2=0.1351
r17 25 27 19.38 $l=1.8e-08 $layer=V1 $X=0.2971 $Y=0.1351 $X2=0.2971 $Y2=0.1351
r18 31 33 2.85714 $l=0 $layer=Gate_1 $X=0.2971 $Y=0.1351 $X2=0.2971 $Y2=0.1351
r19 31 34 12.9422 $l=3.77e-08 $layer=Gate_1 $X=0.2971 $Y=0.1351 $X2=0.2971
+ $Y2=0.09729
r20 31 35 12.9422 $l=3.76e-08 $layer=Gate_1 $X=0.2971 $Y=0.1351 $X2=0.2971
+ $Y2=0.1725
r21 36 35 10.1531 $l=2.99e-08 $layer=Gate_1 $X=0.2971 $Y=0.2025 $X2=0.2971
+ $Y2=0.1725
.ends

.subckt PM_MAJIXP5_ASAP7_75T_R%A vss 4 3 10 1
c1 1 vss 0.0026649f $X=0.2431 $Y=0.1351
c2 4 vss 0.00031853f $X=0.2431 $Y=0.1149
r1 1 8 4.6849 $l=0 $layer=LIG $X=0.2431 $Y=0.1351 $X2=0.2431 $Y2=0.1351
r2 1 15 28.9688 $l=1.6e-08 $layer=V0LIG $X=0.2431 $Y=0.1351 $X2=0.2431
+ $Y2=0.1396
r3 3 6 10.1531 $l=2.98e-08 $layer=Gate_1 $X=0.2431 $Y=0.06751 $X2=0.2431
+ $Y2=0.09729
r4 4 15 5.72564 $l=2.47e-08 $layer=M1 $X=0.2431 $Y=0.1149 $X2=0.2431 $Y2=0.1396
r5 6 7 12.9422 $l=3.77e-08 $layer=Gate_1 $X=0.2431 $Y=0.09729 $X2=0.2431
+ $Y2=0.1351
r6 7 8 2.85714 $l=0 $layer=Gate_1 $X=0.2431 $Y=0.1351 $X2=0.2431 $Y2=0.1351
r7 7 9 12.9422 $l=3.76e-08 $layer=Gate_1 $X=0.2431 $Y=0.1351 $X2=0.2431
+ $Y2=0.1725
r8 10 9 10.1531 $l=2.99e-08 $layer=Gate_1 $X=0.2431 $Y=0.2025 $X2=0.2431
+ $Y2=0.1725
.ends

.subckt PM_MAJIXP5_ASAP7_75T_R%NET3 vss 7 8 22 1 9 2
c1 1 vss 0.00241519f $X=0.054 $Y=0.18
c2 2 vss 0.000608485f $X=0.27 $Y=0.18
c3 7 vss 0.0277054f $X=0.0714 $Y=0.2025
c4 8 vss 0.00314599f $X=0.2527 $Y=0.2025
c5 9 vss 0.000627909f $X=0.054 $Y=0.198
r1 1 11 10.573 $l=1.81e-08 $layer=LISD $X=0.054 $Y=0.18 $X2=0.054 $Y2=0.198
r2 2 17 10.573 $l=1.81e-08 $layer=LISD $X=0.27 $Y=0.18 $X2=0.27 $Y2=0.198
r3 7 10 0.154321 $l=1.25e-08 $layer=P_src_drn $X=0.0714 $Y=0.2025 $X2=0.05851
+ $Y2=0.2025
r4 8 19 0.209877 $l=1.7e-08 $layer=P_src_drn $X=0.2527 $Y=0.2025 $X2=0.27
+ $Y2=0.2025
r5 9 15 24.9846 $l=1.08e-07 $layer=M1 $X=0.054 $Y=0.198 $X2=0.162 $Y2=0.198
r6 9 11 19.38 $l=1.8e-08 $layer=V0LISD $X=0.054 $Y=0.198 $X2=0.054 $Y2=0.198
r7 11 12 1.31433 $l=2.2e-09 $layer=LISD $X=0.054 $Y=0.198 $X2=0.054 $Y2=0.2001
r8 12 10 1.31433 $l=2.3e-09 $layer=LISD $X=0.054 $Y=0.2001 $X2=0.05851
+ $Y2=0.2025
r9 15 16 24.9846 $l=1.08e-07 $layer=M1 $X=0.162 $Y=0.198 $X2=0.27 $Y2=0.198
r10 16 17 19.38 $l=1.8e-08 $layer=V0LISD $X=0.27 $Y=0.198 $X2=0.27 $Y2=0.198
r11 17 18 1.31433 $l=2.2e-09 $layer=LISD $X=0.27 $Y=0.198 $X2=0.27 $Y2=0.2001
r12 18 19 1.31433 $l=2.3e-09 $layer=LISD $X=0.27 $Y=0.2001 $X2=0.27 $Y2=0.2025
r13 22 19 0.209877 $l=1.7e-08 $layer=P_src_drn $X=0.2875 $Y=0.2025 $X2=0.27
+ $Y2=0.2025
.ends

.subckt PM_MAJIXP5_ASAP7_75T_R%NET1 vss 7 8 26 13 1 2 10 11 9 12
c1 1 vss 0.00249306f $X=0.054 $Y=0.04711
c2 2 vss 0.000719682f $X=0.27 $Y=0.0299
c3 7 vss 0.0277786f $X=0.0714 $Y=0.06751
c4 8 vss 0.00344238f $X=0.2527 $Y=0.06751
c5 9 vss 0.000364452f $X=0.162 $Y=0.036
c6 10 vss 8.62605e-20 $X=0.162 $Y=0.072
c7 11 vss 0.00117364f $X=0.054 $Y=0.072
c8 12 vss 0.000155648f $X=0.162 $Y=0.054
r1 1 14 11.8874 $l=2.04e-08 $layer=LISD $X=0.054 $Y=0.04711 $X2=0.05851
+ $Y2=0.06751
r2 2 21 3.56329 $l=6.1e-09 $layer=LISD $X=0.27 $Y=0.0299 $X2=0.27 $Y2=0.036
r3 7 14 0.154321 $l=1.25e-08 $layer=N_src_drn $X=0.0714 $Y=0.06751 $X2=0.05851
+ $Y2=0.06751
r4 8 23 0.209877 $l=1.7e-08 $layer=N_src_drn $X=0.2527 $Y=0.06751 $X2=0.27
+ $Y2=0.06751
r5 9 12 2.52808 $l=1.8e-08 $layer=M1 $X=0.162 $Y=0.036 $X2=0.162 $Y2=0.054
r6 9 13 10.8563 $l=5.4e-08 $layer=M1 $X=0.162 $Y=0.036 $X2=0.216 $Y2=0.036
r7 10 19 10.8563 $l=5.4e-08 $layer=M1 $X=0.162 $Y=0.072 $X2=0.108 $Y2=0.072
r8 10 12 2.52808 $l=1.8e-08 $layer=M1 $X=0.162 $Y=0.072 $X2=0.162 $Y2=0.054
r9 11 19 12.4923 $l=5.4e-08 $layer=M1 $X=0.054 $Y=0.072 $X2=0.108 $Y2=0.072
r10 11 17 19.38 $l=1.8e-08 $layer=V0LISD $X=0.054 $Y=0.072 $X2=0.054 $Y2=0.072
r11 13 20 12.4923 $l=5.4e-08 $layer=M1 $X=0.216 $Y=0.036 $X2=0.27 $Y2=0.036
r12 14 16 1.31433 $l=2.2e-09 $layer=LISD $X=0.05851 $Y=0.06751 $X2=0.054
+ $Y2=0.06969
r13 16 17 1.31433 $l=2.3e-09 $layer=LISD $X=0.054 $Y=0.06969 $X2=0.054 $Y2=0.072
r14 20 21 19.38 $l=1.8e-08 $layer=V0LISD $X=0.27 $Y=0.036 $X2=0.27 $Y2=0.036
r15 21 22 9.2003 $l=1.57e-08 $layer=LISD $X=0.27 $Y=0.036 $X2=0.27 $Y2=0.05169
r16 22 23 9.2003 $l=1.58e-08 $layer=LISD $X=0.27 $Y=0.05169 $X2=0.27 $Y2=0.06751
r17 26 23 0.209877 $l=1.7e-08 $layer=N_src_drn $X=0.2875 $Y=0.06751 $X2=0.27
+ $Y2=0.06751
.ends

.subckt PM_MAJIXP5_ASAP7_75T_R%Y vss 15 7 8 17 33 1 12 9 11 2 10 14 13
c1 1 vss 0.000270231f $X=0.216 $Y=0.04711
c2 2 vss 0.000619732f $X=0.216 $Y=0.1821
c3 7 vss 0.00406019f $X=0.1987 $Y=0.06751
c4 8 vss 0.00176171f $X=0.1987 $Y=0.2025
c5 9 vss 0.000585094f $X=0.3511 $Y=0.198
c6 10 vss 0.000160616f $X=0.324 $Y=0.234
c7 11 vss 0.000375625f $X=0.3511 $Y=0.072
c8 14 vss 7.32749e-20 $X=0.324 $Y=0.216
c9 15 vss 0.00120538f $X=0.3511 $Y=0.1149
r1 1 16 11.8874 $l=2.04e-08 $layer=LISD $X=0.216 $Y=0.04711 $X2=0.216
+ $Y2=0.06751
r2 2 28 11.8874 $l=2.04e-08 $layer=LISD $X=0.216 $Y=0.1821 $X2=0.216 $Y2=0.2025
r3 7 16 0.209877 $l=1.7e-08 $layer=N_src_drn $X=0.1987 $Y=0.06751 $X2=0.216
+ $Y2=0.06751
r4 8 28 0.209877 $l=1.7e-08 $layer=P_src_drn $X=0.1987 $Y=0.2025 $X2=0.216
+ $Y2=0.2025
r5 9 24 9.41282 $l=4.58e-08 $layer=M1 $X=0.3511 $Y=0.198 $X2=0.3511 $Y2=0.1521
r6 9 25 1.95214 $l=1.35e-08 $layer=M1 $X=0.3511 $Y=0.198 $X2=0.3374 $Y2=0.198
r7 10 14 2.52808 $l=1.8e-08 $layer=M1 $X=0.324 $Y=0.234 $X2=0.324 $Y2=0.216
r8 10 27 10.8563 $l=5.4e-08 $layer=M1 $X=0.324 $Y=0.234 $X2=0.27 $Y2=0.234
r9 11 22 13.9794 $l=6.75e-08 $layer=M1 $X=0.3511 $Y=0.072 $X2=0.2834 $Y2=0.072
r10 11 23 4.32095 $l=2.57e-08 $layer=M1 $X=0.3511 $Y=0.072 $X2=0.3511 $Y2=0.0977
r11 12 22 15.6154 $l=6.75e-08 $layer=M1 $X=0.216 $Y=0.072 $X2=0.2834 $Y2=0.072
r12 12 20 19.38 $l=1.8e-08 $layer=V0LISD $X=0.216 $Y=0.072 $X2=0.216 $Y2=0.072
r13 13 27 12.4923 $l=5.4e-08 $layer=M1 $X=0.216 $Y=0.234 $X2=0.27 $Y2=0.234
r14 13 30 19.38 $l=1.8e-08 $layer=V0LISD $X=0.216 $Y=0.234 $X2=0.216 $Y2=0.234
r15 14 26 2.99316 $l=1.8e-08 $layer=M1 $X=0.324 $Y=0.216 $X2=0.324 $Y2=0.198
r16 15 23 3.9906 $l=1.73e-08 $layer=M1 $X=0.3511 $Y=0.1149 $X2=0.3511 $Y2=0.0977
r17 15 24 8.61738 $l=3.72e-08 $layer=M1 $X=0.3511 $Y=0.1149 $X2=0.3511
+ $Y2=0.1521
r18 17 16 0.209877 $l=1.7e-08 $layer=N_src_drn $X=0.2335 $Y=0.06751 $X2=0.216
+ $Y2=0.06751
r19 16 19 1.31433 $l=2.2e-09 $layer=LISD $X=0.216 $Y=0.06751 $X2=0.216
+ $Y2=0.06969
r20 19 20 1.31433 $l=2.3e-09 $layer=LISD $X=0.216 $Y=0.06969 $X2=0.216 $Y2=0.072
r21 25 26 1.95214 $l=1.35e-08 $layer=M1 $X=0.3374 $Y=0.198 $X2=0.324 $Y2=0.198
r22 28 29 9.2003 $l=1.57e-08 $layer=LISD $X=0.216 $Y=0.2025 $X2=0.216 $Y2=0.2181
r23 29 30 9.2003 $l=1.58e-08 $layer=LISD $X=0.216 $Y=0.2181 $X2=0.216 $Y2=0.234
r24 33 28 0.209877 $l=1.7e-08 $layer=P_src_drn $X=0.2335 $Y=0.2025 $X2=0.216
+ $Y2=0.2025
.ends

.subckt PM_MAJIXP5_ASAP7_75T_R%NET17 vss 1 3
c1 1 vss 0.00229641f $X=0.1447 $Y=0.06751
r1 1 2 0.209877 $l=1.7e-08 $layer=N_src_drn $X=0.1447 $Y=0.06751 $X2=0.162
+ $Y2=0.06751
r2 3 2 0.209877 $l=1.7e-08 $layer=N_src_drn $X=0.1795 $Y=0.06751 $X2=0.162
+ $Y2=0.06751
.ends

.subckt PM_MAJIXP5_ASAP7_75T_R%NET16 vss 1 3
c1 1 vss 0.00229559f $X=0.1447 $Y=0.2025
r1 1 2 0.209877 $l=1.7e-08 $layer=P_src_drn $X=0.1447 $Y=0.2025 $X2=0.162
+ $Y2=0.2025
r2 3 2 0.209877 $l=1.7e-08 $layer=P_src_drn $X=0.1795 $Y=0.2025 $X2=0.162
+ $Y2=0.2025
.ends

*
.SUBCKT MAJIxp5_ASAP7_75t_R VSS C VDD B A Y
*
* VSS VSS
* C C
* VDD VDD
* B B
* A A
* Y Y
*
*

MM2 N_MM2_d N_MM2_g N_MM2_s N_MM1_b nmos_rvt L=2e-08 W=8.1e-08 nfin=3
MM4 N_MM4_d N_MM4_g N_MM4_s N_MM1_b nmos_rvt L=2e-08 W=8.1e-08 nfin=3
MM3 N_MM3_d N_MM3_g N_MM3_s N_MM1_b nmos_rvt L=2e-08 W=8.1e-08 nfin=3
MM0 N_MM0_d N_MM0_g N_MM0_s N_MM1_b nmos_rvt L=2e-08 W=8.1e-08 nfin=3
MM1 N_MM1_d N_MM1_g N_MM1_s N_MM1_b nmos_rvt L=2e-08 W=8.1e-08 nfin=3
MM7 N_MM7_d N_MM7_g N_MM7_s N_MM8_b pmos_rvt L=2e-08 W=8.1e-08 nfin=3
MM9 N_MM9_d N_MM9_g N_MM9_s N_MM8_b pmos_rvt L=2e-08 W=8.1e-08 nfin=3
MM8 N_MM8_d N_MM8_g N_MM8_s N_MM8_b pmos_rvt L=2e-08 W=8.1e-08 nfin=3
MM5 N_MM5_d N_MM5_g N_MM5_s N_MM8_b pmos_rvt L=2e-08 W=8.1e-08 nfin=3
MM6 N_MM6_d N_MM6_g N_MM6_s N_MM8_b pmos_rvt L=2e-08 W=8.1e-08 nfin=3

x_PM_MAJIXP5_ASAP7_75T_R%VSS vss VSS VSS N_MM2_s N_MM1_s N_MM4_s N_MM1_b
+ N_VSS_4 N_VSS_1 N_VSS_5 PM_MAJIXP5_ASAP7_75T_R%VSS
x_PM_MAJIXP5_ASAP7_75T_R%C vss C N_MM2_g N_MM4_g N_MM7_g N_MM9_g N_C_1
+ PM_MAJIXP5_ASAP7_75T_R%C
cc_1 N_MM4_G N_VSS_1 0.00218826f $X=0.1351 $Y=0.06751
cc_2 N_MM2_G N_VSS_1 6.49625e-21 $X=0.081 $Y=0.06751
cc_3 N_C_1 N_VSS_4 0.000263746f $X=0.081 $Y=0.1351
cc_4 N_MM2_G N_VSS_4 0.00218746f $X=0.081 $Y=0.06751
cc_5 C N_VSS_4 0.000348139f $X=0.108 $Y=0.1149
cc_6 N_C_1 N_MM2_S 0.00191999f $X=0.081 $Y=0.1351
cc_7 N_MM2_G N_MM2_S 0.0569882f $X=0.081 $Y=0.06751
cc_8 N_MM4_G N_MM2_S 0.0205922f $X=0.1351 $Y=0.06751
x_PM_MAJIXP5_ASAP7_75T_R%VDD vss VDD VDD N_MM7_s N_MM6_s N_MM9_s N_MM8_b
+ N_VDD_5 N_VDD_4 N_VDD_1 PM_MAJIXP5_ASAP7_75T_R%VDD
cc_9 VDD N_VSS_4 0.000225332f $X=0.1891 $Y=0.27
cc_10 N_MM6_S N_VSS_5 8.77021e-20 $X=0.3067 $Y=0.2025
cc_11 N_VDD_5 N_MM1_S 8.90585e-20 $X=0.324 $Y=0.27
cc_12 N_VDD_4 VSS 0.000277473f $X=0.108 $Y=0.2025
cc_13 N_MM7_S N_C_1 0.00191998f $X=0.0906 $Y=0.2025
cc_14 N_VDD_4 N_C_1 0.000263858f $X=0.108 $Y=0.2025
cc_15 N_VDD_1 N_MM2_G 8.74453e-21 $X=0.09751 $Y=0.27
cc_16 N_VDD_4 N_MM2_G 0.00218882f $X=0.108 $Y=0.2025
cc_17 N_MM7_S N_MM2_G 0.0549203f $X=0.0906 $Y=0.2025
cc_18 N_VDD_1 N_MM4_G 0.002394f $X=0.09751 $Y=0.27
cc_19 N_MM7_S N_MM4_G 0.0226119f $X=0.0906 $Y=0.2025
cc_20 N_VDD_4 C 0.000351647f $X=0.108 $Y=0.2025
x_PM_MAJIXP5_ASAP7_75T_R%B vss B N_MM3_g N_MM1_g N_MM8_g N_MM6_g N_B_1 N_B_2
+ N_B_8 N_B_9 PM_MAJIXP5_ASAP7_75T_R%B
cc_21 N_MM3_G N_VSS_1 0.00289958f $X=0.1891 $Y=0.06751
cc_22 N_B_1 N_VSS_4 3.44968e-20 $X=0.1891 $Y=0.1351
cc_23 N_MM3_G N_VSS_4 8.181e-20 $X=0.1891 $Y=0.06751
cc_24 B N_VSS_4 0.000123134f $X=0.1891 $Y=0.1149
cc_25 N_B_2 N_VSS_5 0.000210716f $X=0.2971 $Y=0.1351
cc_26 N_MM1_G N_VSS_5 0.00101056f $X=0.2971 $Y=0.06751
cc_27 N_B_8 N_VSS_5 0.000231308f $X=0.2971 $Y=0.1204
cc_28 N_B_1 N_MM2_S 9.24835e-20 $X=0.1891 $Y=0.1351
cc_29 N_MM3_G N_MM2_S 0.00157824f $X=0.1891 $Y=0.06751
cc_30 N_B_2 N_MM1_S 0.00058269f $X=0.2971 $Y=0.1351
cc_31 N_MM1_G N_MM1_S 0.0387462f $X=0.2971 $Y=0.06751
cc_32 N_MM3_G VSS 0.000648396f $X=0.1891 $Y=0.06751
cc_33 N_B_9 VSS 0.00058994f $X=0.1776 $Y=0.1351
cc_34 N_B_1 N_C_1 0.00170686f $X=0.1891 $Y=0.1351
cc_35 B N_C_1 0.0005994f $X=0.1891 $Y=0.1149
cc_36 N_MM3_G N_MM4_G 0.00627584f $X=0.1891 $Y=0.06751
cc_37 B C 0.000698072f $X=0.1891 $Y=0.1149
cc_38 N_B_9 C 0.000204529f $X=0.1776 $Y=0.1351
cc_39 N_MM3_G N_VDD_1 0.00284511f $X=0.1891 $Y=0.06751
cc_40 N_B_1 N_VDD_4 3.58817e-20 $X=0.1891 $Y=0.1351
cc_41 N_MM3_G N_VDD_4 8.75602e-20 $X=0.1891 $Y=0.06751
cc_42 B N_VDD_4 0.000138843f $X=0.1891 $Y=0.1149
cc_43 N_B_2 N_VDD_5 0.000228108f $X=0.2971 $Y=0.1351
cc_44 N_MM1_G N_VDD_5 0.000922199f $X=0.2971 $Y=0.06751
cc_45 N_B_8 N_VDD_5 0.000125983f $X=0.2971 $Y=0.1204
cc_46 N_B_1 N_MM7_S 9.14508e-20 $X=0.1891 $Y=0.1351
cc_47 N_MM3_G N_MM7_S 0.00158487f $X=0.1891 $Y=0.06751
cc_48 N_B_2 N_MM6_S 0.000608777f $X=0.2971 $Y=0.1351
cc_49 N_MM1_G N_MM6_S 0.0387925f $X=0.2971 $Y=0.06751
cc_50 N_MM3_G VDD 0.000630801f $X=0.1891 $Y=0.06751
cc_51 N_B_9 VDD 0.000589348f $X=0.1776 $Y=0.1351
x_PM_MAJIXP5_ASAP7_75T_R%A vss A N_MM0_g N_MM5_g N_A_1 PM_MAJIXP5_ASAP7_75T_R%A
cc_52 N_MM0_G N_VSS_1 0.00125689f $X=0.2431 $Y=0.06751
cc_53 N_MM0_G N_MM1_S 0.00103908f $X=0.2431 $Y=0.06751
cc_54 N_MM0_G N_VDD_1 0.00103485f $X=0.2431 $Y=0.06751
cc_55 N_MM0_G N_MM6_S 0.00103888f $X=0.2431 $Y=0.06751
cc_56 N_A_1 N_B_1 0.00233739f $X=0.2431 $Y=0.1351
cc_57 N_A_1 N_B_2 0.00125034f $X=0.2431 $Y=0.1351
cc_58 N_MM0_G N_MM3_G 0.0048675f $X=0.2431 $Y=0.06751
cc_59 N_MM0_G N_MM1_G 0.00158546f $X=0.2431 $Y=0.06751
cc_60 A B 0.00330186f $X=0.2431 $Y=0.1149
cc_61 A N_B_8 0.000814261f $X=0.2431 $Y=0.1149
cc_62 A N_B_9 0.000762367f $X=0.2431 $Y=0.1149
x_PM_MAJIXP5_ASAP7_75T_R%NET3 vss N_MM7_d N_MM5_s N_MM6_d N_NET3_1 N_NET3_9
+ N_NET3_2 PM_MAJIXP5_ASAP7_75T_R%NET3
cc_63 N_NET3_1 N_VSS_4 2.38456e-20 $X=0.054 $Y=0.18
cc_64 N_NET3_9 N_VSS_4 0.000204386f $X=0.054 $Y=0.198
cc_65 N_NET3_1 N_MM2_S 0.000175542f $X=0.054 $Y=0.18
cc_66 N_NET3_2 VSS 0.000160074f $X=0.27 $Y=0.18
cc_67 N_MM7_D N_C_1 0.00101543f $X=0.0714 $Y=0.2025
cc_68 N_NET3_1 N_C_1 0.000277787f $X=0.054 $Y=0.18
cc_69 N_NET3_1 N_MM2_G 0.000820654f $X=0.054 $Y=0.18
cc_70 N_MM7_D N_MM2_G 0.0377341f $X=0.0714 $Y=0.2025
cc_71 N_NET3_1 C 0.000134243f $X=0.054 $Y=0.18
cc_72 N_NET3_9 C 0.00317046f $X=0.054 $Y=0.198
cc_73 N_MM5_S N_VDD_1 0.00476643f $X=0.2527 $Y=0.2025
cc_74 N_NET3_1 N_VDD_1 0.000163926f $X=0.054 $Y=0.18
cc_75 N_NET3_2 N_VDD_1 3.04169e-20 $X=0.27 $Y=0.18
cc_76 N_NET3_1 N_VDD_4 0.00634914f $X=0.054 $Y=0.18
cc_77 N_NET3_2 N_VDD_5 0.00400766f $X=0.27 $Y=0.18
cc_78 N_MM7_D N_MM7_S 0.00217791f $X=0.0714 $Y=0.2025
cc_79 N_MM5_S N_MM6_S 0.00202533f $X=0.2527 $Y=0.2025
cc_80 N_NET3_9 VDD 0.00658517f $X=0.054 $Y=0.198
cc_81 N_MM5_S N_B_1 7.94298e-20 $X=0.2527 $Y=0.2025
cc_82 N_MM5_S N_B_2 0.00117036f $X=0.2527 $Y=0.2025
cc_83 N_NET3_9 N_B_1 0.000168514f $X=0.054 $Y=0.198
cc_84 N_NET3_2 N_B_2 0.000326881f $X=0.27 $Y=0.18
cc_85 N_NET3_1 N_MM3_G 1.25396e-20 $X=0.054 $Y=0.18
cc_86 N_NET3_2 N_MM1_G 0.000772188f $X=0.27 $Y=0.18
cc_87 N_MM5_S N_MM1_G 0.0374081f $X=0.2527 $Y=0.2025
cc_88 N_NET3_9 B 0.00372755f $X=0.054 $Y=0.198
cc_89 N_NET3_2 N_B_8 0.000366917f $X=0.27 $Y=0.18
cc_90 N_NET3_9 N_B_8 0.00039091f $X=0.054 $Y=0.198
cc_91 N_NET3_9 N_B_9 0.000659438f $X=0.054 $Y=0.198
cc_92 N_MM5_S N_A_1 0.000596261f $X=0.2527 $Y=0.2025
cc_93 N_NET3_2 N_A_1 0.000315528f $X=0.27 $Y=0.18
cc_94 N_NET3_2 N_MM0_G 0.000773341f $X=0.27 $Y=0.18
cc_95 N_MM5_S N_MM0_G 0.0374638f $X=0.2527 $Y=0.2025
cc_96 N_NET3_2 A 0.000257233f $X=0.27 $Y=0.18
cc_97 N_NET3_9 A 0.00212825f $X=0.054 $Y=0.198
x_PM_MAJIXP5_ASAP7_75T_R%NET1 vss N_MM2_d N_MM0_s N_MM1_d N_NET1_13 N_NET1_1
+ N_NET1_2 N_NET1_10 N_NET1_11 N_NET1_9 N_NET1_12 PM_MAJIXP5_ASAP7_75T_R%NET1
cc_98 N_NET1_13 N_VSS_1 0.00557808f $X=0.216 $Y=0.036
cc_99 N_NET1_1 N_VSS_1 0.00019489f $X=0.054 $Y=0.04711
cc_100 N_NET1_2 N_VSS_1 8.53579e-20 $X=0.27 $Y=0.0299
cc_101 N_NET1_1 N_VSS_4 0.00638127f $X=0.054 $Y=0.04711
cc_102 N_NET1_10 N_VSS_4 3.1476e-20 $X=0.162 $Y=0.072
cc_103 N_NET1_11 N_VSS_4 0.00247045f $X=0.054 $Y=0.072
cc_104 N_NET1_2 N_VSS_5 0.00390196f $X=0.27 $Y=0.0299
cc_105 N_MM2_D N_MM2_S 0.0022466f $X=0.0714 $Y=0.06751
cc_106 N_MM0_S N_MM1_S 0.00191806f $X=0.2527 $Y=0.06751
cc_107 N_NET1_2 VSS 0.00113808f $X=0.27 $Y=0.0299
cc_108 N_NET1_9 VSS 0.00144426f $X=0.162 $Y=0.036
cc_109 N_NET1_10 VSS 0.000192802f $X=0.162 $Y=0.072
cc_110 N_NET1_12 VSS 0.000309423f $X=0.162 $Y=0.054
cc_111 N_NET1_13 VSS 0.0116852f $X=0.216 $Y=0.036
cc_112 N_MM2_D N_C_1 0.00101537f $X=0.0714 $Y=0.06751
cc_113 N_NET1_1 N_C_1 0.000276934f $X=0.054 $Y=0.04711
cc_114 N_NET1_1 N_MM2_G 0.000820654f $X=0.054 $Y=0.04711
cc_115 N_MM2_D N_MM2_G 0.0377561f $X=0.0714 $Y=0.06751
cc_116 N_NET1_1 C 0.000134243f $X=0.054 $Y=0.04711
cc_117 N_NET1_9 C 3.11513e-20 $X=0.162 $Y=0.036
cc_118 N_NET1_10 C 0.000226475f $X=0.162 $Y=0.072
cc_119 N_NET1_11 C 0.00291098f $X=0.054 $Y=0.072
cc_120 N_NET1_12 C 5.08599e-20 $X=0.162 $Y=0.054
cc_121 N_NET1_1 N_VDD_4 2.38456e-20 $X=0.054 $Y=0.04711
cc_122 N_NET1_11 N_VDD_4 0.000123589f $X=0.054 $Y=0.072
cc_123 N_NET1_1 N_MM7_S 0.000175542f $X=0.054 $Y=0.04711
cc_124 N_NET1_2 VDD 0.00016911f $X=0.27 $Y=0.0299
cc_125 N_MM0_S N_B_1 5.62067e-20 $X=0.2527 $Y=0.06751
cc_126 N_NET1_10 N_B_1 0.000119177f $X=0.162 $Y=0.072
cc_127 N_NET1_2 N_B_2 0.000192434f $X=0.27 $Y=0.0299
cc_128 N_NET1_1 N_MM3_G 1.25396e-20 $X=0.054 $Y=0.04711
cc_129 N_NET1_2 N_MM1_G 0.000929622f $X=0.27 $Y=0.0299
cc_130 N_MM0_S N_MM1_G 0.0373992f $X=0.2527 $Y=0.06751
cc_131 N_NET1_9 B 0.00011304f $X=0.162 $Y=0.036
cc_132 N_NET1_10 B 0.00150279f $X=0.162 $Y=0.072
cc_133 N_NET1_11 B 0.000548642f $X=0.054 $Y=0.072
cc_134 N_NET1_12 B 0.000174695f $X=0.162 $Y=0.054
cc_135 N_NET1_13 B 0.00034381f $X=0.216 $Y=0.036
cc_136 N_NET1_2 N_B_8 0.000180209f $X=0.27 $Y=0.0299
cc_137 N_NET1_13 N_B_9 0.000439601f $X=0.216 $Y=0.036
cc_138 N_NET1_13 N_B_8 1.59743e-20 $X=0.216 $Y=0.036
cc_139 N_MM0_S N_A_1 0.000570207f $X=0.2527 $Y=0.06751
cc_140 N_NET1_2 N_A_1 0.000263368f $X=0.27 $Y=0.0299
cc_141 N_NET1_2 N_MM0_G 0.00085779f $X=0.27 $Y=0.0299
cc_142 N_MM0_S N_MM0_G 0.0374395f $X=0.2527 $Y=0.06751
cc_143 N_NET1_2 A 0.000270633f $X=0.27 $Y=0.0299
cc_144 N_NET1_10 A 3.43961e-20 $X=0.162 $Y=0.072
cc_145 N_NET1_1 N_NET3_1 0.000267039f $X=0.054 $Y=0.04711
cc_146 N_MM2_D N_NET3_1 0.000180931f $X=0.0714 $Y=0.06751
cc_147 N_NET1_11 N_NET3_1 0.000251033f $X=0.054 $Y=0.072
cc_148 N_NET1_1 N_MM7_D 0.000180931f $X=0.054 $Y=0.04711
cc_149 N_NET1_2 N_MM5_S 6.18274e-20 $X=0.27 $Y=0.0299
cc_150 N_NET1_10 N_NET3_9 0.000314334f $X=0.162 $Y=0.072
x_PM_MAJIXP5_ASAP7_75T_R%Y vss Y N_MM3_d N_MM8_d N_MM0_d N_MM5_d N_Y_1 N_Y_12
+ N_Y_9 N_Y_11 N_Y_2 N_Y_10 N_Y_14 N_Y_13 PM_MAJIXP5_ASAP7_75T_R%Y
cc_151 N_Y_1 N_VSS_1 0.00140523f $X=0.216 $Y=0.04711
cc_152 N_MM3_D N_VSS_1 0.00369015f $X=0.1987 $Y=0.06751
cc_153 N_Y_12 N_VSS_1 0.000105948f $X=0.216 $Y=0.072
cc_154 N_MM3_D N_VSS_4 0.00038583f $X=0.1987 $Y=0.06751
cc_155 N_Y_9 N_VSS_5 3.36144e-20 $X=0.3511 $Y=0.198
cc_156 N_Y_11 N_VSS_5 0.00076962f $X=0.3511 $Y=0.072
cc_157 N_Y_12 N_VSS_5 0.00173283f $X=0.216 $Y=0.072
cc_158 Y N_VSS_5 0.000894604f $X=0.3511 $Y=0.1149
cc_159 N_Y_1 N_VSS_4 3.50192e-20 $X=0.216 $Y=0.04711
cc_160 N_Y_1 VSS 0.00166544f $X=0.216 $Y=0.04711
cc_161 N_Y_12 VSS 0.00160293f $X=0.216 $Y=0.072
cc_162 N_Y_1 N_C_1 7.37172e-20 $X=0.216 $Y=0.04711
cc_163 N_MM8_D N_C_1 0.000333164f $X=0.1987 $Y=0.2025
cc_164 N_Y_1 N_MM4_G 0.000129048f $X=0.216 $Y=0.04711
cc_165 N_Y_2 N_MM4_G 9.79165e-20 $X=0.216 $Y=0.1821
cc_166 N_Y_1 C 8.14022e-20 $X=0.216 $Y=0.04711
cc_167 N_Y_2 N_VDD_1 0.00160232f $X=0.216 $Y=0.1821
cc_168 N_MM8_D N_VDD_1 0.0041993f $X=0.1987 $Y=0.2025
cc_169 N_Y_10 N_VDD_1 0.000307088f $X=0.324 $Y=0.234
cc_170 N_MM8_D N_VDD_4 0.00038583f $X=0.1987 $Y=0.2025
cc_171 N_Y_9 N_VDD_5 0.00109212f $X=0.3511 $Y=0.198
cc_172 N_Y_11 N_VDD_5 6.72104e-20 $X=0.3511 $Y=0.072
cc_173 N_Y_14 N_VDD_5 0.00184962f $X=0.324 $Y=0.216
cc_174 Y N_VDD_5 0.000872003f $X=0.3511 $Y=0.1149
cc_175 N_Y_2 N_VDD_4 1.86021e-20 $X=0.216 $Y=0.1821
cc_176 N_Y_10 N_VDD_5 0.000417428f $X=0.324 $Y=0.234
cc_177 N_Y_2 VDD 0.00105415f $X=0.216 $Y=0.1821
cc_178 N_Y_10 VDD 0.00152475f $X=0.324 $Y=0.234
cc_179 N_Y_13 VDD 0.010339f $X=0.216 $Y=0.234
cc_180 N_Y_14 VDD 0.000419693f $X=0.324 $Y=0.216
cc_181 N_MM8_D N_B_1 0.00131896f $X=0.1987 $Y=0.2025
cc_182 N_Y_1 N_B_1 0.000539805f $X=0.216 $Y=0.04711
cc_183 Y N_B_2 0.000530297f $X=0.3511 $Y=0.1149
cc_184 N_Y_1 N_MM3_G 0.00110896f $X=0.216 $Y=0.04711
cc_185 N_Y_2 N_MM3_G 0.00111347f $X=0.216 $Y=0.1821
cc_186 N_MM3_D N_MM3_G 0.0186459f $X=0.1987 $Y=0.06751
cc_187 N_MM8_D N_MM3_G 0.0577383f $X=0.1987 $Y=0.2025
cc_188 N_Y_1 B 0.000378174f $X=0.216 $Y=0.04711
cc_189 N_Y_12 B 0.000756007f $X=0.216 $Y=0.072
cc_190 N_Y_9 N_B_8 0.000571401f $X=0.3511 $Y=0.198
cc_191 N_Y_10 N_B_8 8.671e-20 $X=0.324 $Y=0.234
cc_192 N_Y_11 N_B_8 0.000164006f $X=0.3511 $Y=0.072
cc_193 N_Y_12 N_B_8 0.00208655f $X=0.216 $Y=0.072
cc_194 N_Y_13 N_B_8 0.000294162f $X=0.216 $Y=0.234
cc_195 N_Y_14 N_B_8 0.000116554f $X=0.324 $Y=0.216
cc_196 Y N_B_8 0.00411652f $X=0.3511 $Y=0.1149
cc_197 N_Y_12 N_B_9 0.00125128f $X=0.216 $Y=0.072
cc_198 N_MM8_D N_A_1 0.00117036f $X=0.1987 $Y=0.2025
cc_199 N_Y_1 N_A_1 0.000616789f $X=0.216 $Y=0.04711
cc_200 N_Y_1 N_MM0_G 0.00079776f $X=0.216 $Y=0.04711
cc_201 N_Y_2 N_MM0_G 0.00075218f $X=0.216 $Y=0.1821
cc_202 N_MM3_D N_MM0_G 0.0184398f $X=0.1987 $Y=0.06751
cc_203 N_MM8_D N_MM0_G 0.0564308f $X=0.1987 $Y=0.2025
cc_204 N_Y_1 A 0.000260358f $X=0.216 $Y=0.04711
cc_205 N_Y_9 A 6.85906e-20 $X=0.3511 $Y=0.198
cc_206 N_Y_12 A 0.00244738f $X=0.216 $Y=0.072
cc_207 N_Y_14 A 2.34031e-20 $X=0.324 $Y=0.216
cc_208 N_Y_2 N_NET3_2 0.00370399f $X=0.216 $Y=0.1821
cc_209 N_Y_13 N_NET3_2 0.000792865f $X=0.216 $Y=0.234
cc_210 N_MM8_D N_MM5_S 0.00124789f $X=0.1987 $Y=0.2025
cc_211 N_Y_2 N_NET3_9 0.000724336f $X=0.216 $Y=0.1821
cc_212 N_Y_9 N_NET3_9 0.000406617f $X=0.3511 $Y=0.198
cc_213 N_Y_10 N_NET3_9 5.19971e-20 $X=0.324 $Y=0.234
cc_214 N_Y_13 N_NET3_9 0.00786573f $X=0.216 $Y=0.234
cc_215 N_Y_14 N_NET3_9 0.000162153f $X=0.324 $Y=0.216
cc_216 Y N_NET3_9 0.000172f $X=0.3511 $Y=0.1149
cc_217 N_Y_1 N_NET1_2 0.00363864f $X=0.216 $Y=0.04711
cc_218 Y N_NET1_2 7.62211e-20 $X=0.3511 $Y=0.1149
cc_219 N_Y_12 N_NET1_2 0.000755199f $X=0.216 $Y=0.072
cc_220 N_MM3_D N_MM0_S 0.00124502f $X=0.1987 $Y=0.06751
cc_221 N_Y_12 N_NET1_9 9.30208e-20 $X=0.216 $Y=0.072
cc_222 N_Y_12 N_NET1_10 0.000358122f $X=0.216 $Y=0.072
cc_223 N_Y_12 N_NET1_11 0.00013294f $X=0.216 $Y=0.072
cc_224 N_Y_12 N_NET1_12 0.000181018f $X=0.216 $Y=0.072
cc_225 N_Y_1 N_NET1_13 0.000803896f $X=0.216 $Y=0.04711
cc_226 N_Y_11 N_NET1_13 8.5915e-20 $X=0.3511 $Y=0.072
cc_227 N_Y_12 N_NET1_13 0.00755547f $X=0.216 $Y=0.072
x_PM_MAJIXP5_ASAP7_75T_R%NET17 vss N_MM4_d N_MM3_s PM_MAJIXP5_ASAP7_75T_R%NET17
cc_228 N_MM4_D N_MM2_S 0.000256507f $X=0.1447 $Y=0.06751
cc_229 N_MM4_D N_MM4_G 0.018714f $X=0.1447 $Y=0.06751
cc_230 N_MM4_D N_B_1 1.71871e-20 $X=0.1447 $Y=0.06751
cc_231 N_MM4_D N_MM3_G 0.0187405f $X=0.1447 $Y=0.06751
x_PM_MAJIXP5_ASAP7_75T_R%NET16 vss N_MM9_d N_MM8_s PM_MAJIXP5_ASAP7_75T_R%NET16
cc_232 N_MM9_D N_MM4_G 0.0187142f $X=0.1447 $Y=0.2025
cc_233 N_MM9_D N_MM7_S 0.000257257f $X=0.1447 $Y=0.2025
cc_234 N_MM9_D N_B_1 1.73522e-20 $X=0.1447 $Y=0.2025
cc_235 N_MM9_D N_MM3_G 0.01874f $X=0.1447 $Y=0.2025

.ENDS
*

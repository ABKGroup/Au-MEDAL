* Design:	MAJx3_ASAP7_75t_R
* Created:	"Thu Nov14 2024"
* Vendor:	"Mentor Graphics Corporation"
* Program:	"Calibre xACT 3D"
* Version:	"v2023.3_29.15"
* Corner Name: typical_25
* Nominal Temperature: 25C
* Circuit Temperature: 25C
*
* Integrated TICER reduction is not enabled.
* SHORT DELAY THRESHOLD: 2e-14
* Fill Mode: GF
* PEX REDUCE CC ABSOLUTE : disabled
* PEX REDUCE CC RATIO : disabled
* Delta transform mode : 344834

.subckt PM_MAJX3_ASAP7_75T_R%VSS vss 18 20 14 15 16 22 59 61 76 5 1 6 7
c1 1 vss 0.0219594f $X=0.09751 $Y=0.0
c2 5 vss 0.000243075f $X=0.108 $Y=0.0085
c3 6 vss 0.000983602f $X=0.324 $Y=0.0
c4 7 vss 0.000246994f $X=0.432 $Y=0.0
c5 14 vss 0.00598392f $X=0.0906 $Y=0.06751
c6 15 vss 0.00599706f $X=0.3067 $Y=0.06751
c7 16 vss 0.00597839f $X=0.4147 $Y=0.06751
c8 20 vss 0.0057793f $X=0.27 $Y=0.0
r1 1 28 4.91914 $l=1.05e-08 $layer=LIG $X=0.09751 $Y=0.0 $X2=0.108 $Y2=0.0
r2 5 23 5.54939 $l=9.5e-09 $layer=LISD $X=0.108 $Y=0.0085 $X2=0.108 $Y2=0.018
r3 5 25 3.80936 $l=8.5e-09 $layer=LISD $X=0.108 $Y=0.0085 $X2=0.108 $Y2=0.0
r4 6 35 3.51728 $l=0 $layer=LISD $X=0.324 $Y=0.0 $X2=0.324 $Y2=0.0
r5 6 46 19.38 $l=1.8e-08 $layer=V0LISD $X=0.324 $Y=0.0 $X2=0.324 $Y2=0.0
r6 6 51 3.80936 $l=8.5e-09 $layer=LISD $X=0.324 $Y=0.0 $X2=0.324 $Y2=0.0085
r7 7 40 3.51728 $l=0 $layer=LISD $X=0.432 $Y=0.0 $X2=0.432 $Y2=0.0
r8 7 48 19.38 $l=1.8e-08 $layer=V0LISD $X=0.432 $Y=0.0 $X2=0.432 $Y2=0.0
r9 7 55 3.80936 $l=8.5e-09 $layer=LISD $X=0.432 $Y=0.0 $X2=0.432 $Y2=0.0085
r10 14 21 0.209877 $l=1.7e-08 $layer=N_src_drn $X=0.0906 $Y=0.06751 $X2=0.108
+ $Y2=0.06751
r11 15 53 0.209877 $l=1.7e-08 $layer=N_src_drn $X=0.3067 $Y=0.06751 $X2=0.324
+ $Y2=0.06751
r12 16 57 0.209877 $l=1.7e-08 $layer=N_src_drn $X=0.4147 $Y=0.06751 $X2=0.432
+ $Y2=0.06751
r13 20 43 17.7553 $l=7.68e-08 $layer=M1 $X=0.27 $Y=0.0 $X2=0.1932 $Y2=0.0
r14 20 45 5.26296 $l=2.27e-08 $layer=M1 $X=0.27 $Y=0.0 $X2=0.2928 $Y2=0.0
r15 22 21 0.209877 $l=1.7e-08 $layer=N_src_drn $X=0.1255 $Y=0.06751 $X2=0.108
+ $Y2=0.06751
r16 23 21 28.9152 $l=4.95e-08 $layer=LISD $X=0.108 $Y=0.018 $X2=0.108
+ $Y2=0.06751
r17 25 26 3.51728 $l=0 $layer=LISD $X=0.108 $Y=0.0 $X2=0.108 $Y2=0.0
r18 25 42 19.38 $l=1.8e-08 $layer=V0LISD $X=0.108 $Y=0.0 $X2=0.108 $Y2=0.0
r19 26 29 0.702734 $l=1.05e-08 $layer=LIG $X=0.108 $Y=0.0 $X2=0.1185 $Y2=0.0
r20 26 28 4.21641 $l=0 $layer=LIG $X=0.108 $Y=0.0 $X2=0.108 $Y2=0.0
r21 28 29 4.91914 $l=1.05e-08 $layer=LIG $X=0.108 $Y=0.0 $X2=0.1185 $Y2=0.0
r22 28 42 28.9688 $l=1.6e-08 $layer=V0LIG $X=0.108 $Y=0.0 $X2=0.108 $Y2=0.0
r23 29 31 222.489 $l=9.75e-08 $layer=LIG $X=0.1185 $Y=0.0 $X2=0.216 $Y2=0.0
r24 31 32 222.489 $l=9.75e-08 $layer=LIG $X=0.216 $Y=0.0 $X2=0.3134 $Y2=0.0
r25 32 33 4.91914 $l=1.05e-08 $layer=LIG $X=0.3134 $Y=0.0 $X2=0.324 $Y2=0.0
r26 33 34 4.91914 $l=1.05e-08 $layer=LIG $X=0.324 $Y=0.0 $X2=0.3345 $Y2=0.0
r27 33 35 4.21641 $l=0 $layer=LIG $X=0.324 $Y=0.0 $X2=0.324 $Y2=0.0
r28 33 46 28.9688 $l=1.6e-08 $layer=V0LIG $X=0.324 $Y=0.0 $X2=0.324 $Y2=0.0
r29 34 36 97.7343 $l=4.35e-08 $layer=LIG $X=0.3345 $Y=0.0 $X2=0.378 $Y2=0.0
r30 36 37 97.7343 $l=4.35e-08 $layer=LIG $X=0.378 $Y=0.0 $X2=0.4214 $Y2=0.0
r31 37 38 4.91914 $l=1.05e-08 $layer=LIG $X=0.4214 $Y=0.0 $X2=0.432 $Y2=0.0
r32 38 40 4.21641 $l=0 $layer=LIG $X=0.432 $Y=0.0 $X2=0.432 $Y2=0.0
r33 38 48 28.9688 $l=1.6e-08 $layer=V0LIG $X=0.432 $Y=0.0 $X2=0.432 $Y2=0.0
r34 42 43 19.7217 $l=8.52e-08 $layer=M1 $X=0.108 $Y=0.0 $X2=0.1932 $Y2=0.0
r35 45 46 7.22934 $l=3.13e-08 $layer=M1 $X=0.2928 $Y=0.0 $X2=0.324 $Y2=0.0
r36 46 47 12.4923 $l=5.4e-08 $layer=M1 $X=0.324 $Y=0.0 $X2=0.378 $Y2=0.0
r37 47 48 12.4923 $l=5.4e-08 $layer=M1 $X=0.378 $Y=0.0 $X2=0.432 $Y2=0.0
r38 51 52 5.54939 $l=9.5e-09 $layer=LISD $X=0.324 $Y=0.0085 $X2=0.324 $Y2=0.018
r39 52 53 28.9152 $l=4.95e-08 $layer=LISD $X=0.324 $Y=0.018 $X2=0.324
+ $Y2=0.06751
r40 55 56 5.54939 $l=9.5e-09 $layer=LISD $X=0.432 $Y=0.0085 $X2=0.432 $Y2=0.018
r41 56 57 28.9152 $l=4.95e-08 $layer=LISD $X=0.432 $Y=0.018 $X2=0.432
+ $Y2=0.06751
r42 59 53 0.209877 $l=1.7e-08 $layer=N_src_drn $X=0.3415 $Y=0.06751 $X2=0.324
+ $Y2=0.06751
r43 61 57 0.209877 $l=1.7e-08 $layer=N_src_drn $X=0.4495 $Y=0.06751 $X2=0.432
+ $Y2=0.06751
.ends

.subckt PM_MAJX3_ASAP7_75T_R%C vss 5 3 4 11 24 1
c1 1 vss 0.00156948f $X=0.081 $Y=0.1351
c2 3 vss 0.00887332f $X=0.081 $Y=0.06751
c3 5 vss 0.000250977f $X=0.108 $Y=0.1149
r1 1 9 4.6849 $l=0 $layer=LIG $X=0.081 $Y=0.1351 $X2=0.081 $Y2=0.1351
r2 1 14 43.9596 $l=2.7e-08 $layer=LIG $X=0.081 $Y=0.1351 $X2=0.108 $Y2=0.1351
r3 3 7 10.1531 $l=2.98e-08 $layer=Gate_1 $X=0.081 $Y=0.06751 $X2=0.081
+ $Y2=0.09729
r4 4 22 10.1531 $l=2.98e-08 $layer=Gate_1 $X=0.1351 $Y=0.06751 $X2=0.1351
+ $Y2=0.09729
r5 5 18 5.72564 $l=2.47e-08 $layer=M1 $X=0.108 $Y=0.1149 $X2=0.108 $Y2=0.1396
r6 7 8 12.9422 $l=3.77e-08 $layer=Gate_1 $X=0.081 $Y=0.09729 $X2=0.081
+ $Y2=0.1351
r7 8 9 2.85714 $l=0 $layer=Gate_1 $X=0.081 $Y=0.1351 $X2=0.081 $Y2=0.1351
r8 8 10 12.9422 $l=3.76e-08 $layer=Gate_1 $X=0.081 $Y=0.1351 $X2=0.081
+ $Y2=0.1725
r9 11 10 10.1531 $l=2.99e-08 $layer=Gate_1 $X=0.081 $Y=0.2025 $X2=0.081
+ $Y2=0.1725
r10 14 15 43.9596 $l=2.7e-08 $layer=LIG $X=0.108 $Y=0.1351 $X2=0.1351 $Y2=0.1351
r11 14 18 28.9688 $l=1.6e-08 $layer=V0LIG $X=0.108 $Y=0.1351 $X2=0.108
+ $Y2=0.1396
r12 15 21 4.6849 $l=0 $layer=LIG $X=0.1351 $Y=0.1351 $X2=0.1351 $Y2=0.1351
r13 19 21 2.85714 $l=0 $layer=Gate_1 $X=0.1351 $Y=0.1351 $X2=0.1351 $Y2=0.1351
r14 19 22 12.9422 $l=3.77e-08 $layer=Gate_1 $X=0.1351 $Y=0.1351 $X2=0.1351
+ $Y2=0.09729
r15 19 23 12.9422 $l=3.76e-08 $layer=Gate_1 $X=0.1351 $Y=0.1351 $X2=0.1351
+ $Y2=0.1725
r16 24 23 10.1531 $l=2.99e-08 $layer=Gate_1 $X=0.1351 $Y=0.2025 $X2=0.1351
+ $Y2=0.1725
.ends

.subckt PM_MAJX3_ASAP7_75T_R%VDD vss 17 18 14 15 16 20 57 59 66 70 6 5 1 7
c1 1 vss 0.0217649f $X=0.3134 $Y=0.27
c2 5 vss 0.000240284f $X=0.108 $Y=0.27
c3 6 vss 0.000960685f $X=0.324 $Y=0.2025
c4 7 vss 0.000244026f $X=0.432 $Y=0.27
c5 14 vss 0.00591202f $X=0.0906 $Y=0.2025
c6 15 vss 0.005925f $X=0.3067 $Y=0.2025
c7 16 vss 0.00590655f $X=0.4147 $Y=0.2025
c8 18 vss 0.00567276f $X=0.27 $Y=0.27
r1 1 26 4.91914 $l=1.05e-08 $layer=LIG $X=0.3134 $Y=0.27 $X2=0.324 $Y2=0.27
r2 1 28 222.489 $l=9.75e-08 $layer=LIG $X=0.3134 $Y=0.27 $X2=0.216 $Y2=0.27
r3 5 32 3.51728 $l=0 $layer=LISD $X=0.108 $Y=0.27 $X2=0.108 $Y2=0.27
r4 5 40 19.38 $l=1.8e-08 $layer=V0LISD $X=0.108 $Y=0.27 $X2=0.108 $Y2=0.27
r5 5 50 3.80936 $l=8.5e-09 $layer=LISD $X=0.108 $Y=0.27 $X2=0.108 $Y2=0.2616
r6 6 21 28.9152 $l=4.95e-08 $layer=LISD $X=0.324 $Y=0.2025 $X2=0.324 $Y2=0.252
r7 7 38 3.51728 $l=0 $layer=LISD $X=0.432 $Y=0.27 $X2=0.432 $Y2=0.27
r8 7 46 19.38 $l=1.8e-08 $layer=V0LISD $X=0.432 $Y=0.27 $X2=0.432 $Y2=0.27
r9 7 54 3.80936 $l=8.5e-09 $layer=LISD $X=0.432 $Y=0.27 $X2=0.432 $Y2=0.2616
r10 14 48 0.209877 $l=1.7e-08 $layer=P_src_drn $X=0.0906 $Y=0.2025 $X2=0.108
+ $Y2=0.2025
r11 15 6 0.209877 $l=1.7e-08 $layer=P_src_drn $X=0.3067 $Y=0.2025 $X2=0.324
+ $Y2=0.2025
r12 16 52 0.209877 $l=1.7e-08 $layer=P_src_drn $X=0.4147 $Y=0.2025 $X2=0.432
+ $Y2=0.2025
r13 18 41 17.7553 $l=7.68e-08 $layer=M1 $X=0.27 $Y=0.27 $X2=0.1932 $Y2=0.27
r14 18 43 5.26296 $l=2.27e-08 $layer=M1 $X=0.27 $Y=0.27 $X2=0.2928 $Y2=0.27
r15 20 6 0.209877 $l=1.7e-08 $layer=P_src_drn $X=0.3415 $Y=0.2025 $X2=0.324
+ $Y2=0.2025
r16 21 22 5.54939 $l=9.5e-09 $layer=LISD $X=0.324 $Y=0.252 $X2=0.324 $Y2=0.2616
r17 22 23 3.80936 $l=8.5e-09 $layer=LISD $X=0.324 $Y=0.2616 $X2=0.324 $Y2=0.27
r18 23 24 3.51728 $l=0 $layer=LISD $X=0.324 $Y=0.27 $X2=0.324 $Y2=0.27
r19 23 44 19.38 $l=1.8e-08 $layer=V0LISD $X=0.324 $Y=0.27 $X2=0.324 $Y2=0.27
r20 24 27 0.702734 $l=1.05e-08 $layer=LIG $X=0.324 $Y=0.27 $X2=0.3345 $Y2=0.27
r21 24 26 4.21641 $l=0 $layer=LIG $X=0.324 $Y=0.27 $X2=0.324 $Y2=0.27
r22 26 27 4.91914 $l=1.05e-08 $layer=LIG $X=0.324 $Y=0.27 $X2=0.3345 $Y2=0.27
r23 26 44 28.9688 $l=1.6e-08 $layer=V0LIG $X=0.324 $Y=0.27 $X2=0.324 $Y2=0.27
r24 27 34 97.7343 $l=4.35e-08 $layer=LIG $X=0.3345 $Y=0.27 $X2=0.378 $Y2=0.27
r25 28 31 222.489 $l=9.75e-08 $layer=LIG $X=0.216 $Y=0.27 $X2=0.1185 $Y2=0.27
r26 30 31 4.91914 $l=1.05e-08 $layer=LIG $X=0.108 $Y=0.27 $X2=0.1185 $Y2=0.27
r27 30 32 4.21641 $l=0 $layer=LIG $X=0.108 $Y=0.27 $X2=0.108 $Y2=0.27
r28 30 40 28.9688 $l=1.6e-08 $layer=V0LIG $X=0.108 $Y=0.27 $X2=0.108 $Y2=0.27
r29 34 35 97.7343 $l=4.35e-08 $layer=LIG $X=0.378 $Y=0.27 $X2=0.4214 $Y2=0.27
r30 35 36 4.91914 $l=1.05e-08 $layer=LIG $X=0.4214 $Y=0.27 $X2=0.432 $Y2=0.27
r31 36 38 4.21641 $l=0 $layer=LIG $X=0.432 $Y=0.27 $X2=0.432 $Y2=0.27
r32 36 46 28.9688 $l=1.6e-08 $layer=V0LIG $X=0.432 $Y=0.27 $X2=0.432 $Y2=0.27
r33 40 41 19.7217 $l=8.52e-08 $layer=M1 $X=0.108 $Y=0.27 $X2=0.1932 $Y2=0.27
r34 43 44 7.22934 $l=3.13e-08 $layer=M1 $X=0.2928 $Y=0.27 $X2=0.324 $Y2=0.27
r35 44 45 12.4923 $l=5.4e-08 $layer=M1 $X=0.324 $Y=0.27 $X2=0.378 $Y2=0.27
r36 45 46 12.4923 $l=5.4e-08 $layer=M1 $X=0.378 $Y=0.27 $X2=0.432 $Y2=0.27
r37 48 49 28.9152 $l=4.95e-08 $layer=LISD $X=0.108 $Y=0.2025 $X2=0.108 $Y2=0.252
r38 49 50 5.54939 $l=9.5e-09 $layer=LISD $X=0.108 $Y=0.252 $X2=0.108 $Y2=0.2616
r39 52 53 28.9152 $l=4.95e-08 $layer=LISD $X=0.432 $Y=0.2025 $X2=0.432 $Y2=0.252
r40 53 54 5.54939 $l=9.5e-09 $layer=LISD $X=0.432 $Y=0.252 $X2=0.432 $Y2=0.2616
r41 57 48 0.209877 $l=1.7e-08 $layer=P_src_drn $X=0.1255 $Y=0.2025 $X2=0.108
+ $Y2=0.2025
r42 59 52 0.209877 $l=1.7e-08 $layer=P_src_drn $X=0.4495 $Y=0.2025 $X2=0.432
+ $Y2=0.2025
.ends

.subckt PM_MAJX3_ASAP7_75T_R%B vss 7 5 6 17 36 1 2 8 9
c1 1 vss 0.00150341f $X=0.1891 $Y=0.1351
c2 2 vss 0.00127244f $X=0.2971 $Y=0.1351
c3 5 vss 0.00230592f $X=0.1891 $Y=0.06751
c4 7 vss 0.000437495f $X=0.1891 $Y=0.1149
c5 8 vss 0.000478345f $X=0.2971 $Y=0.1204
c6 9 vss 0.003333f $X=0.1776 $Y=0.1351
r1 1 15 4.6849 $l=0 $layer=LIG $X=0.1891 $Y=0.1351 $X2=0.1891 $Y2=0.1351
r2 1 22 28.9688 $l=1.6e-08 $layer=V0LIG $X=0.1891 $Y=0.1351 $X2=0.1891
+ $Y2=0.1396
r3 2 33 4.6849 $l=0 $layer=LIG $X=0.2971 $Y=0.1351 $X2=0.2971 $Y2=0.1351
r4 2 27 28.9688 $l=1.6e-08 $layer=V0LIG $X=0.2971 $Y=0.1351 $X2=0.2971
+ $Y2=0.1351
r5 5 13 10.1531 $l=2.98e-08 $layer=Gate_1 $X=0.1891 $Y=0.06751 $X2=0.1891
+ $Y2=0.09729
r6 6 34 10.1531 $l=2.98e-08 $layer=Gate_1 $X=0.2971 $Y=0.06751 $X2=0.2971
+ $Y2=0.09729
r7 7 22 5.72564 $l=2.47e-08 $layer=M1 $X=0.1891 $Y=0.1149 $X2=0.1891 $Y2=0.1396
r8 8 27 3.37755 $l=1.46e-08 $layer=M1 $X=0.2971 $Y=0.1204 $X2=0.2971 $Y2=0.1351
r9 9 23 2.6604 $l=1.15e-08 $layer=M2 $X=0.1776 $Y=0.1351 $X2=0.1891 $Y2=0.1351
r10 13 14 12.9422 $l=3.77e-08 $layer=Gate_1 $X=0.1891 $Y=0.09729 $X2=0.1891
+ $Y2=0.1351
r11 14 15 2.85714 $l=0 $layer=Gate_1 $X=0.1891 $Y=0.1351 $X2=0.1891 $Y2=0.1351
r12 14 16 12.9422 $l=3.76e-08 $layer=Gate_1 $X=0.1891 $Y=0.1351 $X2=0.1891
+ $Y2=0.1725
r13 17 16 10.1531 $l=2.99e-08 $layer=Gate_1 $X=0.1891 $Y=0.2025 $X2=0.1891
+ $Y2=0.1725
r14 22 23 19.38 $l=1.8e-08 $layer=V1 $X=0.1891 $Y=0.1396 $X2=0.1891 $Y2=0.1351
r15 23 24 12.4923 $l=5.4e-08 $layer=M2 $X=0.1891 $Y=0.1351 $X2=0.2431 $Y2=0.1351
r16 24 25 12.4923 $l=5.4e-08 $layer=M2 $X=0.2431 $Y=0.1351 $X2=0.2971 $Y2=0.1351
r17 25 27 19.38 $l=1.8e-08 $layer=V1 $X=0.2971 $Y=0.1351 $X2=0.2971 $Y2=0.1351
r18 31 33 2.85714 $l=0 $layer=Gate_1 $X=0.2971 $Y=0.1351 $X2=0.2971 $Y2=0.1351
r19 31 34 12.9422 $l=3.77e-08 $layer=Gate_1 $X=0.2971 $Y=0.1351 $X2=0.2971
+ $Y2=0.09729
r20 31 35 12.9422 $l=3.76e-08 $layer=Gate_1 $X=0.2971 $Y=0.1351 $X2=0.2971
+ $Y2=0.1725
r21 36 35 10.1531 $l=2.99e-08 $layer=Gate_1 $X=0.2971 $Y=0.2025 $X2=0.2971
+ $Y2=0.1725
.ends

.subckt PM_MAJX3_ASAP7_75T_R%A vss 4 3 10 1
c1 1 vss 0.00294076f $X=0.2431 $Y=0.1351
c2 4 vss 0.000522948f $X=0.2431 $Y=0.1149
r1 1 8 4.6849 $l=0 $layer=LIG $X=0.2431 $Y=0.1351 $X2=0.2431 $Y2=0.1351
r2 1 15 28.9688 $l=1.6e-08 $layer=V0LIG $X=0.2431 $Y=0.1351 $X2=0.2431
+ $Y2=0.1396
r3 3 6 10.1531 $l=2.98e-08 $layer=Gate_1 $X=0.2431 $Y=0.06751 $X2=0.2431
+ $Y2=0.09729
r4 4 15 5.72564 $l=2.47e-08 $layer=M1 $X=0.2431 $Y=0.1149 $X2=0.2431 $Y2=0.1396
r5 6 7 12.9422 $l=3.77e-08 $layer=Gate_1 $X=0.2431 $Y=0.09729 $X2=0.2431
+ $Y2=0.1351
r6 7 8 2.85714 $l=0 $layer=Gate_1 $X=0.2431 $Y=0.1351 $X2=0.2431 $Y2=0.1351
r7 7 9 12.9422 $l=3.76e-08 $layer=Gate_1 $X=0.2431 $Y=0.1351 $X2=0.2431
+ $Y2=0.1725
r8 10 9 10.1531 $l=2.99e-08 $layer=Gate_1 $X=0.2431 $Y=0.2025 $X2=0.2431
+ $Y2=0.1725
.ends

.subckt PM_MAJX3_ASAP7_75T_R%MAJI vss 9 10 11 12 13 24 39 46 59 61 3 16 1 14 18
+ 4 17 15
c1 1 vss 0.00152777f $X=0.3415 $Y=0.1351
c2 3 vss 0.000533204f $X=0.216 $Y=0.04711
c3 4 vss 0.000724889f $X=0.216 $Y=0.18
c4 9 vss 0.00526601f $X=0.3511 $Y=0.06751
c5 10 vss 6.74015e-20 $X=0.4051 $Y=0.06751
c6 12 vss 0.00481007f $X=0.1987 $Y=0.06751
c7 13 vss 0.00226381f $X=0.1987 $Y=0.2025
c8 14 vss 0.000124568f $X=0.3511 $Y=0.072
c9 15 vss 0.000121544f $X=0.3511 $Y=0.198
c10 17 vss 0.000421461f $X=0.216 $Y=0.198
r1 1 26 4.45065 $l=9.5e-09 $layer=LIG $X=0.3415 $Y=0.1351 $X2=0.3511 $Y2=0.1351
r2 3 50 11.8874 $l=2.04e-08 $layer=LISD $X=0.216 $Y=0.04711 $X2=0.216
+ $Y2=0.06751
r3 4 54 10.573 $l=1.81e-08 $layer=LISD $X=0.216 $Y=0.18 $X2=0.216 $Y2=0.198
r4 9 20 10.1531 $l=2.98e-08 $layer=Gate_1 $X=0.3511 $Y=0.06751 $X2=0.3511
+ $Y2=0.09729
r5 10 37 10.1531 $l=2.98e-08 $layer=Gate_1 $X=0.4051 $Y=0.06751 $X2=0.4051
+ $Y2=0.09729
r6 11 44 10.1531 $l=2.98e-08 $layer=Gate_1 $X=0.4591 $Y=0.06751 $X2=0.4591
+ $Y2=0.09729
r7 12 50 0.209877 $l=1.7e-08 $layer=N_src_drn $X=0.1987 $Y=0.06751 $X2=0.216
+ $Y2=0.06751
r8 13 56 0.209877 $l=1.7e-08 $layer=P_src_drn $X=0.1987 $Y=0.2025 $X2=0.216
+ $Y2=0.2025
r9 14 18 12.9383 $l=6.3e-08 $layer=M1 $X=0.3511 $Y=0.072 $X2=0.3511 $Y2=0.1351
r10 14 48 13.9794 $l=6.75e-08 $layer=M1 $X=0.3511 $Y=0.072 $X2=0.2834 $Y2=0.072
r11 15 18 12.9383 $l=6.3e-08 $layer=M1 $X=0.3511 $Y=0.198 $X2=0.3511 $Y2=0.1351
r12 15 49 13.9794 $l=6.75e-08 $layer=M1 $X=0.3511 $Y=0.198 $X2=0.2834 $Y2=0.198
r13 16 48 15.6154 $l=6.75e-08 $layer=M1 $X=0.216 $Y=0.072 $X2=0.2834 $Y2=0.072
r14 16 52 19.38 $l=1.8e-08 $layer=V0LISD $X=0.216 $Y=0.072 $X2=0.216 $Y2=0.072
r15 17 49 15.6154 $l=6.75e-08 $layer=M1 $X=0.216 $Y=0.198 $X2=0.2834 $Y2=0.198
r16 17 54 19.38 $l=1.8e-08 $layer=V0LISD $X=0.216 $Y=0.198 $X2=0.216 $Y2=0.198
r17 18 26 28.9688 $l=1.6e-08 $layer=V0LIG $X=0.3511 $Y=0.1351 $X2=0.3511
+ $Y2=0.1351
r18 20 21 12.9422 $l=3.77e-08 $layer=Gate_1 $X=0.3511 $Y=0.09729 $X2=0.3511
+ $Y2=0.1351
r19 21 22 2.85714 $l=0 $layer=Gate_1 $X=0.3511 $Y=0.1351 $X2=0.3511 $Y2=0.1351
r20 21 23 12.9422 $l=3.76e-08 $layer=Gate_1 $X=0.3511 $Y=0.1351 $X2=0.3511
+ $Y2=0.1725
r21 22 27 0.234245 $l=9.5e-09 $layer=LIG $X=0.3511 $Y=0.1351 $X2=0.3604
+ $Y2=0.1351
r22 22 26 4.21641 $l=0 $layer=LIG $X=0.3511 $Y=0.1351 $X2=0.3511 $Y2=0.1351
r23 24 23 10.1531 $l=2.99e-08 $layer=Gate_1 $X=0.3511 $Y=0.2025 $X2=0.3511
+ $Y2=0.1725
r24 26 27 4.45065 $l=9.5e-09 $layer=LIG $X=0.3511 $Y=0.1351 $X2=0.3604
+ $Y2=0.1351
r25 27 29 39.5089 $l=1.75e-08 $layer=LIG $X=0.3604 $Y=0.1351 $X2=0.378
+ $Y2=0.1351
r26 29 30 43.9596 $l=2.7e-08 $layer=LIG $X=0.378 $Y=0.1351 $X2=0.4051 $Y2=0.1351
r27 30 36 4.6849 $l=0 $layer=LIG $X=0.4051 $Y=0.1351 $X2=0.4051 $Y2=0.1351
r28 30 31 43.9596 $l=2.7e-08 $layer=LIG $X=0.4051 $Y=0.1351 $X2=0.432 $Y2=0.1351
r29 31 32 43.9596 $l=2.7e-08 $layer=LIG $X=0.432 $Y=0.1351 $X2=0.4591 $Y2=0.1351
r30 32 43 4.6849 $l=0 $layer=LIG $X=0.4591 $Y=0.1351 $X2=0.4591 $Y2=0.1351
r31 34 36 2.85714 $l=0 $layer=Gate_1 $X=0.4051 $Y=0.1351 $X2=0.4051 $Y2=0.1351
r32 34 37 12.9422 $l=3.77e-08 $layer=Gate_1 $X=0.4051 $Y=0.1351 $X2=0.4051
+ $Y2=0.09729
r33 34 38 12.9422 $l=3.76e-08 $layer=Gate_1 $X=0.4051 $Y=0.1351 $X2=0.4051
+ $Y2=0.1725
r34 39 38 10.1531 $l=2.99e-08 $layer=Gate_1 $X=0.4051 $Y=0.2025 $X2=0.4051
+ $Y2=0.1725
r35 41 43 2.85714 $l=0 $layer=Gate_1 $X=0.4591 $Y=0.1351 $X2=0.4591 $Y2=0.1351
r36 41 44 12.9422 $l=3.77e-08 $layer=Gate_1 $X=0.4591 $Y=0.1351 $X2=0.4591
+ $Y2=0.09729
r37 41 45 12.9422 $l=3.76e-08 $layer=Gate_1 $X=0.4591 $Y=0.1351 $X2=0.4591
+ $Y2=0.1725
r38 46 45 10.1531 $l=2.99e-08 $layer=Gate_1 $X=0.4591 $Y=0.2025 $X2=0.4591
+ $Y2=0.1725
r39 50 51 1.31433 $l=2.2e-09 $layer=LISD $X=0.216 $Y=0.06751 $X2=0.216
+ $Y2=0.06969
r40 51 52 1.31433 $l=2.3e-09 $layer=LISD $X=0.216 $Y=0.06969 $X2=0.216 $Y2=0.072
r41 54 55 1.31433 $l=2.2e-09 $layer=LISD $X=0.216 $Y=0.198 $X2=0.216 $Y2=0.2001
r42 55 56 1.31433 $l=2.3e-09 $layer=LISD $X=0.216 $Y=0.2001 $X2=0.216 $Y2=0.2025
r43 59 50 0.209877 $l=1.7e-08 $layer=N_src_drn $X=0.2335 $Y=0.06751 $X2=0.216
+ $Y2=0.06751
r44 61 56 0.209877 $l=1.7e-08 $layer=P_src_drn $X=0.2335 $Y=0.2025 $X2=0.216
+ $Y2=0.2025
.ends

.subckt PM_MAJX3_ASAP7_75T_R%NET1 vss 7 8 26 2 1 10 11 9 12 13
c1 1 vss 0.00243023f $X=0.054 $Y=0.04711
c2 2 vss 0.00041185f $X=0.27 $Y=0.0299
c3 7 vss 0.0277972f $X=0.0714 $Y=0.06751
c4 8 vss 0.00343519f $X=0.2527 $Y=0.06751
c5 9 vss 0.00036441f $X=0.162 $Y=0.036
c6 10 vss 0.00015322f $X=0.162 $Y=0.072
c7 11 vss 0.00118537f $X=0.054 $Y=0.072
c8 12 vss 0.000155599f $X=0.162 $Y=0.054
r1 1 14 11.8874 $l=2.04e-08 $layer=LISD $X=0.054 $Y=0.04711 $X2=0.05851
+ $Y2=0.06751
r2 2 21 3.56329 $l=6.1e-09 $layer=LISD $X=0.27 $Y=0.0299 $X2=0.27 $Y2=0.036
r3 7 14 0.154321 $l=1.25e-08 $layer=N_src_drn $X=0.0714 $Y=0.06751 $X2=0.05851
+ $Y2=0.06751
r4 8 23 0.209877 $l=1.7e-08 $layer=N_src_drn $X=0.2527 $Y=0.06751 $X2=0.27
+ $Y2=0.06751
r5 9 12 2.52808 $l=1.8e-08 $layer=M1 $X=0.162 $Y=0.036 $X2=0.162 $Y2=0.054
r6 9 13 10.8563 $l=5.4e-08 $layer=M1 $X=0.162 $Y=0.036 $X2=0.216 $Y2=0.036
r7 10 19 10.8563 $l=5.4e-08 $layer=M1 $X=0.162 $Y=0.072 $X2=0.108 $Y2=0.072
r8 10 12 2.52808 $l=1.8e-08 $layer=M1 $X=0.162 $Y=0.072 $X2=0.162 $Y2=0.054
r9 11 19 12.4923 $l=5.4e-08 $layer=M1 $X=0.054 $Y=0.072 $X2=0.108 $Y2=0.072
r10 11 17 19.38 $l=1.8e-08 $layer=V0LISD $X=0.054 $Y=0.072 $X2=0.054 $Y2=0.072
r11 13 20 12.4923 $l=5.4e-08 $layer=M1 $X=0.216 $Y=0.036 $X2=0.27 $Y2=0.036
r12 14 16 1.31433 $l=2.2e-09 $layer=LISD $X=0.05851 $Y=0.06751 $X2=0.054
+ $Y2=0.06969
r13 16 17 1.31433 $l=2.3e-09 $layer=LISD $X=0.054 $Y=0.06969 $X2=0.054 $Y2=0.072
r14 20 21 19.38 $l=1.8e-08 $layer=V0LISD $X=0.27 $Y=0.036 $X2=0.27 $Y2=0.036
r15 21 22 9.2003 $l=1.57e-08 $layer=LISD $X=0.27 $Y=0.036 $X2=0.27 $Y2=0.05169
r16 22 23 9.2003 $l=1.58e-08 $layer=LISD $X=0.27 $Y=0.05169 $X2=0.27 $Y2=0.06751
r17 26 23 0.209877 $l=1.7e-08 $layer=N_src_drn $X=0.2875 $Y=0.06751 $X2=0.27
+ $Y2=0.06751
.ends

.subckt PM_MAJX3_ASAP7_75T_R%NET3 vss 7 8 15 1 11 9 10 12 2 13
c1 1 vss 0.00241854f $X=0.054 $Y=0.18
c2 2 vss 0.000400122f $X=0.27 $Y=0.1821
c3 7 vss 0.0278452f $X=0.0714 $Y=0.2025
c4 8 vss 0.00333709f $X=0.2527 $Y=0.2025
c5 9 vss 0.000148792f $X=0.162 $Y=0.198
c6 10 vss 0.000354033f $X=0.162 $Y=0.234
c7 11 vss 0.00116013f $X=0.054 $Y=0.198
c8 12 vss 0.000151168f $X=0.162 $Y=0.216
r1 1 22 10.573 $l=1.81e-08 $layer=LISD $X=0.054 $Y=0.18 $X2=0.054 $Y2=0.198
r2 2 14 11.8874 $l=2.04e-08 $layer=LISD $X=0.27 $Y=0.1821 $X2=0.27 $Y2=0.2025
r3 7 24 0.154321 $l=1.25e-08 $layer=P_src_drn $X=0.0714 $Y=0.2025 $X2=0.054
+ $Y2=0.2025
r4 8 14 0.209877 $l=1.7e-08 $layer=P_src_drn $X=0.2527 $Y=0.2025 $X2=0.27
+ $Y2=0.2025
r5 9 12 2.52808 $l=1.8e-08 $layer=M1 $X=0.162 $Y=0.198 $X2=0.162 $Y2=0.216
r6 9 21 10.8563 $l=5.4e-08 $layer=M1 $X=0.162 $Y=0.198 $X2=0.108 $Y2=0.198
r7 10 13 10.8563 $l=5.4e-08 $layer=M1 $X=0.162 $Y=0.234 $X2=0.216 $Y2=0.234
r8 10 12 2.52808 $l=1.8e-08 $layer=M1 $X=0.162 $Y=0.234 $X2=0.162 $Y2=0.216
r9 11 21 12.4923 $l=5.4e-08 $layer=M1 $X=0.054 $Y=0.198 $X2=0.108 $Y2=0.198
r10 11 22 19.38 $l=1.8e-08 $layer=V0LISD $X=0.054 $Y=0.198 $X2=0.054 $Y2=0.198
r11 13 20 12.4923 $l=5.4e-08 $layer=M1 $X=0.216 $Y=0.234 $X2=0.27 $Y2=0.234
r12 15 14 0.209877 $l=1.7e-08 $layer=P_src_drn $X=0.2875 $Y=0.2025 $X2=0.27
+ $Y2=0.2025
r13 14 17 9.2003 $l=1.57e-08 $layer=LISD $X=0.27 $Y=0.2025 $X2=0.27 $Y2=0.2181
r14 17 18 9.2003 $l=1.58e-08 $layer=LISD $X=0.27 $Y=0.2181 $X2=0.27 $Y2=0.234
r15 18 20 19.38 $l=1.8e-08 $layer=V0LISD $X=0.27 $Y=0.234 $X2=0.27 $Y2=0.234
r16 22 23 1.31433 $l=2.2e-09 $layer=LISD $X=0.054 $Y=0.198 $X2=0.054 $Y2=0.2001
r17 23 24 1.31433 $l=2.3e-09 $layer=LISD $X=0.054 $Y=0.2001 $X2=0.054 $Y2=0.2025
.ends

.subckt PM_MAJX3_ASAP7_75T_R%Y vss 21 13 14 15 16 27 45 1 17 3 19 20 22 23 24
+ 25 4 2 18
c1 1 vss 0.000535231f $X=0.378 $Y=0.0299
c2 2 vss 0.000628516f $X=0.378 $Y=0.1821
c3 3 vss 0.00211505f $X=0.486 $Y=0.04711
c4 4 vss 0.00211505f $X=0.486 $Y=0.18
c5 13 vss 0.00415116f $X=0.3607 $Y=0.06751
c6 14 vss 0.028273f $X=0.4687 $Y=0.06751
c7 15 vss 0.00188871f $X=0.3607 $Y=0.2025
c8 16 vss 0.0269599f $X=0.4687 $Y=0.2025
c9 20 vss 0.000252529f $X=0.486 $Y=0.1351
c10 21 vss 0.000388032f $X=0.4051 $Y=0.1149
c11 22 vss 0.000391024f $X=0.4051 $Y=0.1845
c12 23 vss 0.000202412f $X=0.4454 $Y=0.1351
c13 24 vss 0.000589316f $X=0.486 $Y=0.072
c14 25 vss 0.000587324f $X=0.486 $Y=0.1665
r1 1 28 3.56329 $l=6.1e-09 $layer=LISD $X=0.378 $Y=0.0299 $X2=0.378 $Y2=0.036
r2 2 38 11.8874 $l=2.04e-08 $layer=LISD $X=0.378 $Y=0.1821 $X2=0.378 $Y2=0.2025
r3 3 46 11.8874 $l=2.04e-08 $layer=LISD $X=0.486 $Y=0.04711 $X2=0.486
+ $Y2=0.06751
r4 4 50 10.573 $l=1.81e-08 $layer=LISD $X=0.486 $Y=0.18 $X2=0.486 $Y2=0.198
r5 13 26 0.209877 $l=1.7e-08 $layer=N_src_drn $X=0.3607 $Y=0.06751 $X2=0.378
+ $Y2=0.06751
r6 14 46 0.154321 $l=1.25e-08 $layer=N_src_drn $X=0.4687 $Y=0.06751 $X2=0.486
+ $Y2=0.06751
r7 15 38 0.209877 $l=1.7e-08 $layer=P_src_drn $X=0.3607 $Y=0.2025 $X2=0.378
+ $Y2=0.2025
r8 16 52 0.154321 $l=1.25e-08 $layer=P_src_drn $X=0.4687 $Y=0.2025 $X2=0.486
+ $Y2=0.2025
r9 17 32 3.12308 $l=1.35e-08 $layer=M1 $X=0.378 $Y=0.036 $X2=0.3914 $Y2=0.036
r10 17 28 19.38 $l=1.8e-08 $layer=V0LISD $X=0.378 $Y=0.036 $X2=0.378 $Y2=0.036
r11 18 22 9.81526 $l=4.95e-08 $layer=M1 $X=0.4051 $Y=0.234 $X2=0.4051 $Y2=0.1845
r12 18 37 1.48705 $l=1.35e-08 $layer=M1 $X=0.4051 $Y=0.234 $X2=0.3914 $Y2=0.234
r13 19 35 2.12564 $l=1.43e-08 $layer=M1 $X=0.4051 $Y=0.1351 $X2=0.4051
+ $Y2=0.1207
r14 19 22 10.2803 $l=4.95e-08 $layer=M1 $X=0.4051 $Y=0.1351 $X2=0.4051
+ $Y2=0.1845
r15 19 23 8.19829 $l=4.05e-08 $layer=M1 $X=0.4051 $Y=0.1351 $X2=0.4454
+ $Y2=0.1351
r16 20 23 8.19829 $l=4.05e-08 $layer=M1 $X=0.486 $Y=0.1351 $X2=0.4454 $Y2=0.1351
r17 20 42 6.11624 $l=3.15e-08 $layer=M1 $X=0.486 $Y=0.1351 $X2=0.486 $Y2=0.1034
r18 20 25 6.11624 $l=3.15e-08 $layer=M1 $X=0.486 $Y=0.1351 $X2=0.486 $Y2=0.1665
r19 21 34 8.1547 $l=3.53e-08 $layer=M1 $X=0.4051 $Y=0.1149 $X2=0.4051 $Y2=0.0797
r20 21 35 1.3302 $l=5.7e-09 $layer=M1 $X=0.4051 $Y=0.1149 $X2=0.4051 $Y2=0.1207
r21 24 42 7.28718 $l=3.15e-08 $layer=M1 $X=0.486 $Y=0.072 $X2=0.486 $Y2=0.1034
r22 24 48 19.38 $l=1.8e-08 $layer=V0LISD $X=0.486 $Y=0.072 $X2=0.486 $Y2=0.072
r23 25 43 7.28718 $l=3.15e-08 $layer=M1 $X=0.486 $Y=0.1665 $X2=0.486 $Y2=0.198
r24 27 26 0.209877 $l=1.7e-08 $layer=N_src_drn $X=0.3955 $Y=0.06751 $X2=0.378
+ $Y2=0.06751
r25 28 29 9.2003 $l=1.57e-08 $layer=LISD $X=0.378 $Y=0.036 $X2=0.378 $Y2=0.05169
r26 29 26 9.2003 $l=1.58e-08 $layer=LISD $X=0.378 $Y=0.05169 $X2=0.378
+ $Y2=0.06751
r27 32 33 1.48705 $l=1.35e-08 $layer=M1 $X=0.3914 $Y=0.036 $X2=0.4051 $Y2=0.036
r28 33 34 8.48506 $l=4.37e-08 $layer=M1 $X=0.4051 $Y=0.036 $X2=0.4051 $Y2=0.0797
r29 36 37 3.12308 $l=1.35e-08 $layer=M1 $X=0.378 $Y=0.234 $X2=0.3914 $Y2=0.234
r30 36 40 19.38 $l=1.8e-08 $layer=V0LISD $X=0.378 $Y=0.234 $X2=0.378 $Y2=0.234
r31 38 39 9.2003 $l=1.57e-08 $layer=LISD $X=0.378 $Y=0.2025 $X2=0.378 $Y2=0.2181
r32 39 40 9.2003 $l=1.58e-08 $layer=LISD $X=0.378 $Y=0.2181 $X2=0.378 $Y2=0.234
r33 43 50 19.38 $l=1.8e-08 $layer=V0LISD $X=0.486 $Y=0.198 $X2=0.486 $Y2=0.198
r34 45 38 0.209877 $l=1.7e-08 $layer=P_src_drn $X=0.3955 $Y=0.2025 $X2=0.378
+ $Y2=0.2025
r35 46 47 1.31433 $l=2.2e-09 $layer=LISD $X=0.486 $Y=0.06751 $X2=0.486
+ $Y2=0.06969
r36 47 48 1.31433 $l=2.3e-09 $layer=LISD $X=0.486 $Y=0.06969 $X2=0.486 $Y2=0.072
r37 50 51 1.31433 $l=2.2e-09 $layer=LISD $X=0.486 $Y=0.198 $X2=0.486 $Y2=0.2001
r38 51 52 1.31433 $l=2.3e-09 $layer=LISD $X=0.486 $Y=0.2001 $X2=0.486 $Y2=0.2025
.ends

.subckt PM_MAJX3_ASAP7_75T_R%NET17 vss 1 3
c1 1 vss 0.0022963f $X=0.1447 $Y=0.06751
r1 1 2 0.209877 $l=1.7e-08 $layer=N_src_drn $X=0.1447 $Y=0.06751 $X2=0.162
+ $Y2=0.06751
r2 3 2 0.209877 $l=1.7e-08 $layer=N_src_drn $X=0.1795 $Y=0.06751 $X2=0.162
+ $Y2=0.06751
.ends

.subckt PM_MAJX3_ASAP7_75T_R%NET16 vss 1 3
c1 1 vss 0.00229666f $X=0.1447 $Y=0.2025
r1 1 2 0.209877 $l=1.7e-08 $layer=P_src_drn $X=0.1447 $Y=0.2025 $X2=0.162
+ $Y2=0.2025
r2 3 2 0.209877 $l=1.7e-08 $layer=P_src_drn $X=0.1795 $Y=0.2025 $X2=0.162
+ $Y2=0.2025
.ends

*
.SUBCKT MAJx3_ASAP7_75t_R VSS C VDD B A Y
*
* VSS VSS
* C C
* VDD VDD
* B B
* A A
* Y Y
*
*

MM2 N_MM2_d N_MM2_g N_MM2_s N_MM10@2_b nmos_rvt L=2e-08 W=8.1e-08 nfin=3
MM4 N_MM4_d N_MM4_g N_MM4_s N_MM10@2_b nmos_rvt L=2e-08 W=8.1e-08 nfin=3
MM3 N_MM3_d N_MM3_g N_MM3_s N_MM10@2_b nmos_rvt L=2e-08 W=8.1e-08 nfin=3
MM0 N_MM0_d N_MM0_g N_MM0_s N_MM10@2_b nmos_rvt L=2e-08 W=8.1e-08 nfin=3
MM1 N_MM1_d N_MM1_g N_MM1_s N_MM10@2_b nmos_rvt L=2e-08 W=8.1e-08 nfin=3
MM10 N_MM10_d N_MM10_g N_MM10_s N_MM10@2_b nmos_rvt L=2e-08 W=8.1e-08 nfin=3
MM10@3 N_MM10@3_d N_MM10@3_g N_MM10@3_s N_MM10@2_b nmos_rvt L=2e-08 W=8.1e-08
+ nfin=3
MM10@2 N_MM10@2_d N_MM10@2_g N_MM10@2_s N_MM10@2_b nmos_rvt L=2e-08 W=8.1e-08
+ nfin=3
MM7 N_MM7_d N_MM7_g N_MM7_s N_MM5_b pmos_rvt L=2e-08 W=8.1e-08 nfin=3
MM9 N_MM9_d N_MM9_g N_MM9_s N_MM5_b pmos_rvt L=2e-08 W=8.1e-08 nfin=3
MM8 N_MM8_d N_MM8_g N_MM8_s N_MM5_b pmos_rvt L=2e-08 W=8.1e-08 nfin=3
MM5 N_MM5_d N_MM5_g N_MM5_s N_MM5_b pmos_rvt L=2e-08 W=8.1e-08 nfin=3
MM6 N_MM6_d N_MM6_g N_MM6_s N_MM5_b pmos_rvt L=2e-08 W=8.1e-08 nfin=3
MM11 N_MM11_d N_MM11_g N_MM11_s N_MM5_b pmos_rvt L=2e-08 W=8.1e-08 nfin=3
MM11@3 N_MM11@3_d N_MM11@3_g N_MM11@3_s N_MM5_b pmos_rvt L=2e-08 W=8.1e-08
+ nfin=3
MM11@2 N_MM11@2_d N_MM11@2_g N_MM11@2_s N_MM5_b pmos_rvt L=2e-08 W=8.1e-08
+ nfin=3

x_PM_MAJX3_ASAP7_75T_R%VSS vss VSS VSS N_MM2_s N_MM1_s N_MM10@3_s N_MM4_s
+ N_MM10_s N_MM10@2_s N_MM10@2_b N_VSS_5 N_VSS_1 N_VSS_6 N_VSS_7
+ PM_MAJX3_ASAP7_75T_R%VSS
x_PM_MAJX3_ASAP7_75T_R%C vss C N_MM2_g N_MM4_g N_MM7_g N_MM9_g N_C_1
+ PM_MAJX3_ASAP7_75T_R%C
cc_1 N_MM4_G N_VSS_1 0.00236102f $X=0.1351 $Y=0.06751
cc_2 N_C_1 N_VSS_5 0.000263737f $X=0.081 $Y=0.1351
cc_3 N_MM4_G N_VSS_5 0.00220105f $X=0.1351 $Y=0.06751
cc_4 C N_VSS_5 0.0003492f $X=0.108 $Y=0.1149
cc_5 N_C_1 N_MM2_S 0.00191999f $X=0.081 $Y=0.1351
cc_6 N_MM2_G N_MM2_S 0.0199371f $X=0.081 $Y=0.06751
cc_7 N_MM4_G N_MM2_S 0.0575616f $X=0.1351 $Y=0.06751
x_PM_MAJX3_ASAP7_75T_R%VDD vss VDD VDD N_MM7_s N_MM6_s N_MM11@3_s N_MM11_s
+ N_MM9_s N_MM11@2_s N_MM5_b N_MM5_b N_VDD_6 N_VDD_5 N_VDD_1 N_VDD_7
+ PM_MAJX3_ASAP7_75T_R%VDD
cc_8 VDD N_VSS_6 0.000304132f $X=0.27 $Y=0.27
cc_9 N_VDD_6 VSS 0.000303549f $X=0.324 $Y=0.2025
cc_10 N_MM7_S N_C_1 0.00191994f $X=0.0906 $Y=0.2025
cc_11 N_VDD_5 N_C_1 0.000263653f $X=0.108 $Y=0.27
cc_12 N_MM7_S N_MM2_G 0.0219515f $X=0.0906 $Y=0.2025
cc_13 N_VDD_1 N_MM4_G 0.00236102f $X=0.3134 $Y=0.27
cc_14 N_VDD_5 N_MM4_G 0.00220105f $X=0.108 $Y=0.27
cc_15 N_MM7_S N_MM4_G 0.0555479f $X=0.0906 $Y=0.2025
cc_16 N_VDD_5 C 0.000349245f $X=0.108 $Y=0.27
x_PM_MAJX3_ASAP7_75T_R%B vss B N_MM3_g N_MM1_g N_MM8_g N_MM6_g N_B_1 N_B_2
+ N_B_8 N_B_9 PM_MAJX3_ASAP7_75T_R%B
cc_17 N_MM1_G N_VSS_1 0.00263551f $X=0.2971 $Y=0.06751
cc_18 N_B_1 N_VSS_5 3.43303e-20 $X=0.1891 $Y=0.1351
cc_19 N_MM3_G N_VSS_5 8.60765e-20 $X=0.1891 $Y=0.06751
cc_20 B N_VSS_5 0.000121617f $X=0.1891 $Y=0.1149
cc_21 N_B_2 N_VSS_6 0.000184985f $X=0.2971 $Y=0.1351
cc_22 N_MM1_G N_VSS_6 0.000809856f $X=0.2971 $Y=0.06751
cc_23 N_B_8 N_VSS_6 0.000200411f $X=0.2971 $Y=0.1204
cc_24 N_B_1 N_MM2_S 9.26526e-20 $X=0.1891 $Y=0.1351
cc_25 N_MM3_G N_MM2_S 0.00158269f $X=0.1891 $Y=0.06751
cc_26 N_B_2 N_MM1_S 0.000565944f $X=0.2971 $Y=0.1351
cc_27 N_MM1_G N_MM1_S 0.0383659f $X=0.2971 $Y=0.06751
cc_28 N_MM1_G VSS 0.000691121f $X=0.2971 $Y=0.06751
cc_29 N_B_9 VSS 0.000569019f $X=0.1776 $Y=0.1351
cc_30 N_B_1 N_C_1 0.00170224f $X=0.1891 $Y=0.1351
cc_31 B N_C_1 0.000606541f $X=0.1891 $Y=0.1149
cc_32 N_MM3_G N_MM4_G 0.00627329f $X=0.1891 $Y=0.06751
cc_33 B C 0.000688143f $X=0.1891 $Y=0.1149
cc_34 N_B_9 C 0.000191726f $X=0.1776 $Y=0.1351
cc_35 N_MM1_G N_VDD_1 0.00263551f $X=0.2971 $Y=0.06751
cc_36 N_B_1 N_VDD_5 3.43488e-20 $X=0.1891 $Y=0.1351
cc_37 N_MM3_G N_VDD_5 8.19823e-20 $X=0.1891 $Y=0.06751
cc_38 B N_VDD_5 0.000121679f $X=0.1891 $Y=0.1149
cc_39 N_B_2 N_VDD_6 0.000201396f $X=0.2971 $Y=0.1351
cc_40 N_MM1_G N_VDD_6 0.000803137f $X=0.2971 $Y=0.06751
cc_41 N_B_8 N_VDD_6 0.000159863f $X=0.2971 $Y=0.1204
cc_42 N_B_1 N_MM7_S 9.25561e-20 $X=0.1891 $Y=0.1351
cc_43 N_MM3_G N_MM7_S 0.00158115f $X=0.1891 $Y=0.06751
cc_44 N_B_2 N_MM6_S 0.000567736f $X=0.2971 $Y=0.1351
cc_45 N_MM1_G N_MM6_S 0.0383679f $X=0.2971 $Y=0.06751
cc_46 N_MM1_G VDD 0.000691997f $X=0.2971 $Y=0.06751
cc_47 N_B_9 VDD 0.000570214f $X=0.1776 $Y=0.1351
x_PM_MAJX3_ASAP7_75T_R%A vss A N_MM0_g N_MM5_g N_A_1 PM_MAJX3_ASAP7_75T_R%A
cc_48 N_MM0_G N_VSS_1 0.00120242f $X=0.2431 $Y=0.06751
cc_49 N_MM0_G N_MM1_S 0.00103915f $X=0.2431 $Y=0.06751
cc_50 N_MM0_G N_VDD_1 0.00120242f $X=0.2431 $Y=0.06751
cc_51 N_MM0_G N_MM6_S 0.00103906f $X=0.2431 $Y=0.06751
cc_52 N_A_1 N_B_1 0.00078644f $X=0.2431 $Y=0.1351
cc_53 N_A_1 N_B_2 0.0023602f $X=0.2431 $Y=0.1351
cc_54 N_MM0_G N_MM3_G 0.00162473f $X=0.2431 $Y=0.06751
cc_55 N_MM0_G N_MM1_G 0.00481052f $X=0.2431 $Y=0.06751
cc_56 A B 0.000893597f $X=0.2431 $Y=0.1149
cc_57 A N_B_8 0.00349528f $X=0.2431 $Y=0.1149
cc_58 A N_B_9 0.000721783f $X=0.2431 $Y=0.1149
x_PM_MAJX3_ASAP7_75T_R%MAJI vss N_MM10_g N_MM10@3_g N_MM10@2_g N_MM3_d N_MM8_d
+ N_MM11_g N_MM11@3_g N_MM11@2_g N_MM0_d N_MM5_d N_MAJI_3 N_MAJI_16 N_MAJI_1
+ N_MAJI_14 N_MAJI_18 N_MAJI_4 N_MAJI_17 N_MAJI_15 PM_MAJX3_ASAP7_75T_R%MAJI
cc_59 N_MAJI_3 N_VSS_1 0.00138142f $X=0.216 $Y=0.04711
cc_60 N_MM3_D N_VSS_1 0.00665306f $X=0.1987 $Y=0.06751
cc_61 N_MAJI_16 N_VSS_1 9.05197e-20 $X=0.216 $Y=0.072
cc_62 N_MM10@2_G N_VSS_1 7.38123e-21 $X=0.4591 $Y=0.06751
cc_63 N_MM3_D N_VSS_5 0.00038636f $X=0.1987 $Y=0.06751
cc_64 N_MAJI_1 N_VSS_6 0.000209376f $X=0.3415 $Y=0.1351
cc_65 N_MM10_G N_VSS_6 0.00189357f $X=0.3511 $Y=0.06751
cc_66 N_MAJI_14 N_VSS_6 0.000420993f $X=0.3511 $Y=0.072
cc_67 N_MAJI_18 N_VSS_6 0.000386547f $X=0.3511 $Y=0.1351
cc_68 N_MM10@2_G N_VSS_7 0.00153558f $X=0.4591 $Y=0.06751
cc_69 N_MAJI_3 N_VSS_5 3.50374e-20 $X=0.216 $Y=0.04711
cc_70 N_MAJI_16 N_VSS_6 0.000114414f $X=0.216 $Y=0.072
cc_71 N_MM10_G N_MM1_S 0.0384355f $X=0.3511 $Y=0.06751
cc_72 N_MAJI_1 N_MM10@3_S 0.00250386f $X=0.3415 $Y=0.1351
cc_73 N_MM10@3_G N_MM10@3_S 0.0200146f $X=0.4051 $Y=0.06751
cc_74 N_MM10@2_G N_MM10@3_S 0.0568286f $X=0.4591 $Y=0.06751
cc_75 N_MAJI_3 VSS 0.000204474f $X=0.216 $Y=0.04711
cc_76 N_MAJI_16 VSS 0.00268362f $X=0.216 $Y=0.072
cc_77 N_MAJI_3 N_C_1 7.51273e-20 $X=0.216 $Y=0.04711
cc_78 N_MAJI_4 N_C_1 3.66439e-20 $X=0.216 $Y=0.18
cc_79 N_MM8_D N_C_1 0.000333128f $X=0.1987 $Y=0.2025
cc_80 N_MAJI_3 N_MM4_G 0.000122928f $X=0.216 $Y=0.04711
cc_81 N_MAJI_4 N_MM4_G 0.000122928f $X=0.216 $Y=0.18
cc_82 N_MAJI_3 C 8.99821e-20 $X=0.216 $Y=0.04711
cc_83 N_MAJI_4 N_VDD_1 0.00138142f $X=0.216 $Y=0.18
cc_84 N_MM8_D N_VDD_1 0.00665243f $X=0.1987 $Y=0.2025
cc_85 N_MAJI_17 N_VDD_1 8.6836e-20 $X=0.216 $Y=0.198
cc_86 N_MM10@2_G N_VDD_1 7.38123e-21 $X=0.4591 $Y=0.06751
cc_87 N_MM8_D N_VDD_5 0.00038636f $X=0.1987 $Y=0.2025
cc_88 N_MAJI_1 N_VDD_6 0.00021078f $X=0.3415 $Y=0.1351
cc_89 N_MM10_G N_VDD_6 0.00193189f $X=0.3511 $Y=0.06751
cc_90 N_MAJI_15 N_VDD_6 0.000422145f $X=0.3511 $Y=0.198
cc_91 N_MAJI_18 N_VDD_6 0.000399422f $X=0.3511 $Y=0.1351
cc_92 N_MM10@2_G N_VDD_7 0.00153558f $X=0.4591 $Y=0.06751
cc_93 N_MAJI_4 N_VDD_5 3.50374e-20 $X=0.216 $Y=0.18
cc_94 N_MAJI_17 N_VDD_6 0.000120236f $X=0.216 $Y=0.198
cc_95 N_MM10_G N_MM6_S 0.0384408f $X=0.3511 $Y=0.06751
cc_96 N_MAJI_1 N_MM11@3_S 0.00250426f $X=0.3415 $Y=0.1351
cc_97 N_MM10@3_G N_MM11@3_S 0.0200152f $X=0.4051 $Y=0.06751
cc_98 N_MM10@2_G N_MM11@3_S 0.0568285f $X=0.4591 $Y=0.06751
cc_99 N_MAJI_4 VDD 0.000204474f $X=0.216 $Y=0.18
cc_100 N_MAJI_17 VDD 0.00274537f $X=0.216 $Y=0.198
cc_101 N_MM8_D N_B_1 0.00134029f $X=0.1987 $Y=0.2025
cc_102 N_MAJI_1 N_B_2 0.00185162f $X=0.3415 $Y=0.1351
cc_103 N_MAJI_3 N_B_1 0.000609691f $X=0.216 $Y=0.04711
cc_104 N_MAJI_3 N_MM3_G 0.0011053f $X=0.216 $Y=0.04711
cc_105 N_MAJI_4 N_MM3_G 0.0011053f $X=0.216 $Y=0.18
cc_106 N_MM3_D N_MM3_G 0.0186235f $X=0.1987 $Y=0.06751
cc_107 N_MM8_D N_MM3_G 0.0577097f $X=0.1987 $Y=0.2025
cc_108 N_MM10_G N_MM1_G 0.00326052f $X=0.3511 $Y=0.06751
cc_109 N_MAJI_3 B 0.000378248f $X=0.216 $Y=0.04711
cc_110 N_MAJI_4 B 0.000378248f $X=0.216 $Y=0.18
cc_111 N_MAJI_16 B 0.00111254f $X=0.216 $Y=0.072
cc_112 N_MAJI_14 N_B_8 0.000143344f $X=0.3511 $Y=0.072
cc_113 N_MAJI_15 N_B_8 0.000134201f $X=0.3511 $Y=0.198
cc_114 N_MAJI_16 N_B_8 0.00206913f $X=0.216 $Y=0.072
cc_115 N_MAJI_17 N_B_8 0.00170082f $X=0.216 $Y=0.198
cc_116 N_MAJI_18 N_B_8 0.00399909f $X=0.3511 $Y=0.1351
cc_117 N_MAJI_16 N_B_9 0.0012983f $X=0.216 $Y=0.072
cc_118 N_MM8_D N_A_1 0.00113555f $X=0.1987 $Y=0.2025
cc_119 N_MAJI_1 N_A_1 3.59051e-20 $X=0.3415 $Y=0.1351
cc_120 N_MAJI_3 N_A_1 0.000680154f $X=0.216 $Y=0.04711
cc_121 N_MAJI_3 N_MM0_G 0.00080185f $X=0.216 $Y=0.04711
cc_122 N_MAJI_4 N_MM0_G 0.00080185f $X=0.216 $Y=0.18
cc_123 N_MM3_D N_MM0_G 0.0184181f $X=0.1987 $Y=0.06751
cc_124 N_MM8_D N_MM0_G 0.0564357f $X=0.1987 $Y=0.2025
cc_125 N_MAJI_3 A 0.000260354f $X=0.216 $Y=0.04711
cc_126 N_MAJI_4 A 0.000260354f $X=0.216 $Y=0.18
cc_127 N_MAJI_16 A 0.00318183f $X=0.216 $Y=0.072
cc_128 N_MAJI_17 A 0.00102202f $X=0.216 $Y=0.198
x_PM_MAJX3_ASAP7_75T_R%NET1 vss N_MM2_d N_MM0_s N_MM1_d N_NET1_2 N_NET1_1
+ N_NET1_10 N_NET1_11 N_NET1_9 N_NET1_12 N_NET1_13 PM_MAJX3_ASAP7_75T_R%NET1
cc_129 N_NET1_2 N_VSS_1 0.00554403f $X=0.27 $Y=0.0299
cc_130 N_NET1_1 N_VSS_1 0.000194873f $X=0.054 $Y=0.04711
cc_131 N_NET1_1 N_VSS_5 0.00638208f $X=0.054 $Y=0.04711
cc_132 N_NET1_10 N_VSS_5 3.1454e-20 $X=0.162 $Y=0.072
cc_133 N_NET1_11 N_VSS_5 0.0024982f $X=0.054 $Y=0.072
cc_134 N_NET1_2 N_VSS_6 0.0038878f $X=0.27 $Y=0.0299
cc_135 N_MM2_D N_MM2_S 0.00222288f $X=0.0714 $Y=0.06751
cc_136 N_MM0_S N_MM1_S 0.00189472f $X=0.2527 $Y=0.06751
cc_137 N_NET1_2 VSS 0.00108665f $X=0.27 $Y=0.0299
cc_138 N_NET1_9 VSS 0.00144429f $X=0.162 $Y=0.036
cc_139 N_NET1_10 VSS 0.000192723f $X=0.162 $Y=0.072
cc_140 N_NET1_12 VSS 0.000309332f $X=0.162 $Y=0.054
cc_141 N_NET1_13 VSS 0.0118086f $X=0.216 $Y=0.036
cc_142 N_MM2_D N_C_1 0.00101539f $X=0.0714 $Y=0.06751
cc_143 N_NET1_1 N_C_1 0.000276922f $X=0.054 $Y=0.04711
cc_144 N_NET1_1 N_MM2_G 0.000820686f $X=0.054 $Y=0.04711
cc_145 N_MM2_D N_MM2_G 0.0377725f $X=0.0714 $Y=0.06751
cc_146 N_NET1_1 C 0.000134015f $X=0.054 $Y=0.04711
cc_147 N_NET1_9 C 3.11575e-20 $X=0.162 $Y=0.036
cc_148 N_NET1_10 C 0.000226546f $X=0.162 $Y=0.072
cc_149 N_NET1_11 C 0.00293494f $X=0.054 $Y=0.072
cc_150 N_NET1_12 C 5.08478e-20 $X=0.162 $Y=0.054
cc_151 N_NET1_1 N_VDD_5 2.382e-20 $X=0.054 $Y=0.04711
cc_152 N_NET1_11 N_VDD_5 0.000123191f $X=0.054 $Y=0.072
cc_153 N_NET1_1 N_MM7_S 0.000175526f $X=0.054 $Y=0.04711
cc_154 N_MM0_S N_B_1 5.6236e-20 $X=0.2527 $Y=0.06751
cc_155 N_MM0_S N_B_2 0.000566914f $X=0.2527 $Y=0.06751
cc_156 N_NET1_10 N_B_1 0.000119308f $X=0.162 $Y=0.072
cc_157 N_NET1_2 N_B_2 0.000190515f $X=0.27 $Y=0.0299
cc_158 N_NET1_1 N_MM3_G 1.23409e-20 $X=0.054 $Y=0.04711
cc_159 N_NET1_2 N_MM1_G 0.000927213f $X=0.27 $Y=0.0299
cc_160 N_MM0_S N_MM1_G 0.0374415f $X=0.2527 $Y=0.06751
cc_161 N_NET1_9 B 0.000113004f $X=0.162 $Y=0.036
cc_162 N_NET1_10 B 0.00149539f $X=0.162 $Y=0.072
cc_163 N_NET1_11 B 0.000451509f $X=0.054 $Y=0.072
cc_164 N_NET1_12 B 0.000174634f $X=0.162 $Y=0.054
cc_165 N_NET1_13 B 0.000363701f $X=0.216 $Y=0.036
cc_166 N_NET1_2 N_B_8 0.000178573f $X=0.27 $Y=0.0299
cc_167 N_NET1_13 N_B_9 0.000416603f $X=0.216 $Y=0.036
cc_168 N_NET1_13 N_B_8 1.39304e-20 $X=0.216 $Y=0.036
cc_169 N_MM0_S N_A_1 0.000565963f $X=0.2527 $Y=0.06751
cc_170 N_NET1_2 N_A_1 0.000270595f $X=0.27 $Y=0.0299
cc_171 N_NET1_2 N_MM0_G 0.000860551f $X=0.27 $Y=0.0299
cc_172 N_MM0_S N_MM0_G 0.0374328f $X=0.2527 $Y=0.06751
cc_173 N_NET1_2 A 0.000246862f $X=0.27 $Y=0.0299
cc_174 N_NET1_10 A 3.4355e-20 $X=0.162 $Y=0.072
cc_175 N_NET1_2 N_MAJI_3 0.00360728f $X=0.27 $Y=0.0299
cc_176 N_NET1_13 N_MAJI_3 0.000804198f $X=0.216 $Y=0.036
cc_177 N_MM0_S N_MM3_D 0.00126735f $X=0.2527 $Y=0.06751
cc_178 N_NET1_13 N_MAJI_14 7.12078e-20 $X=0.216 $Y=0.036
cc_179 N_NET1_2 N_MAJI_16 0.000740567f $X=0.27 $Y=0.0299
cc_180 N_NET1_9 N_MAJI_16 9.29977e-20 $X=0.162 $Y=0.036
cc_181 N_NET1_10 N_MAJI_16 0.000359159f $X=0.162 $Y=0.072
cc_182 N_NET1_11 N_MAJI_16 0.000217098f $X=0.054 $Y=0.072
cc_183 N_NET1_12 N_MAJI_16 0.000181022f $X=0.162 $Y=0.054
cc_184 N_NET1_13 N_MAJI_16 0.00753361f $X=0.216 $Y=0.036
cc_185 N_NET1_2 N_MAJI_18 5.25839e-20 $X=0.27 $Y=0.0299
x_PM_MAJX3_ASAP7_75T_R%NET3 vss N_MM7_d N_MM5_s N_MM6_d N_NET3_1 N_NET3_11
+ N_NET3_9 N_NET3_10 N_NET3_12 N_NET3_2 N_NET3_13 PM_MAJX3_ASAP7_75T_R%NET3
cc_186 N_NET3_1 N_VSS_5 2.382e-20 $X=0.054 $Y=0.18
cc_187 N_NET3_11 N_VSS_5 0.000123191f $X=0.054 $Y=0.198
cc_188 N_NET3_1 N_MM2_S 0.000175526f $X=0.054 $Y=0.18
cc_189 N_MM7_D N_C_1 0.00101545f $X=0.0714 $Y=0.2025
cc_190 N_NET3_1 N_C_1 0.000276999f $X=0.054 $Y=0.18
cc_191 N_NET3_1 N_MM2_G 0.000820686f $X=0.054 $Y=0.18
cc_192 N_MM7_D N_MM2_G 0.0377588f $X=0.0714 $Y=0.2025
cc_193 N_NET3_1 C 0.000134015f $X=0.054 $Y=0.18
cc_194 N_NET3_9 C 0.000226546f $X=0.162 $Y=0.198
cc_195 N_NET3_10 C 3.11575e-20 $X=0.162 $Y=0.234
cc_196 N_NET3_11 C 0.00293494f $X=0.054 $Y=0.198
cc_197 N_NET3_12 C 5.08478e-20 $X=0.162 $Y=0.216
cc_198 N_NET3_2 N_VDD_1 0.00595742f $X=0.27 $Y=0.1821
cc_199 N_NET3_1 N_VDD_1 0.000194873f $X=0.054 $Y=0.18
cc_200 N_NET3_1 N_VDD_5 0.00638028f $X=0.054 $Y=0.18
cc_201 N_NET3_9 N_VDD_5 3.1454e-20 $X=0.162 $Y=0.198
cc_202 N_NET3_11 N_VDD_5 0.0024982f $X=0.054 $Y=0.198
cc_203 N_NET3_2 N_VDD_6 0.00381862f $X=0.27 $Y=0.1821
cc_204 N_MM7_D N_MM7_S 0.00219469f $X=0.0714 $Y=0.2025
cc_205 N_MM5_S N_MM6_S 0.0018952f $X=0.2527 $Y=0.2025
cc_206 N_NET3_2 VDD 0.00108665f $X=0.27 $Y=0.1821
cc_207 N_NET3_9 VDD 0.000192723f $X=0.162 $Y=0.198
cc_208 N_NET3_10 VDD 0.00144429f $X=0.162 $Y=0.234
cc_209 N_NET3_12 VDD 0.000309332f $X=0.162 $Y=0.216
cc_210 N_NET3_13 VDD 0.0117465f $X=0.216 $Y=0.234
cc_211 N_MM5_S N_B_1 5.62303e-20 $X=0.2527 $Y=0.2025
cc_212 N_MM5_S N_B_2 0.000568633f $X=0.2527 $Y=0.2025
cc_213 N_NET3_9 N_B_1 0.000119403f $X=0.162 $Y=0.198
cc_214 N_NET3_2 N_B_2 0.000209408f $X=0.27 $Y=0.1821
cc_215 N_NET3_1 N_MM3_G 1.23409e-20 $X=0.054 $Y=0.18
cc_216 N_NET3_2 N_MM1_G 0.000869993f $X=0.27 $Y=0.1821
cc_217 N_MM5_S N_MM1_G 0.0374406f $X=0.2527 $Y=0.2025
cc_218 N_NET3_9 B 0.0014956f $X=0.162 $Y=0.198
cc_219 N_NET3_10 B 0.000113004f $X=0.162 $Y=0.234
cc_220 N_NET3_11 B 0.000451509f $X=0.054 $Y=0.198
cc_221 N_NET3_12 B 0.000174634f $X=0.162 $Y=0.216
cc_222 N_NET3_13 B 0.000356948f $X=0.216 $Y=0.234
cc_223 N_NET3_2 N_B_8 9.99937e-20 $X=0.27 $Y=0.1821
cc_224 N_NET3_13 N_B_9 0.000418554f $X=0.216 $Y=0.234
cc_225 N_NET3_13 N_B_8 1.59026e-20 $X=0.216 $Y=0.234
cc_226 N_MM5_S N_A_1 0.000567736f $X=0.2527 $Y=0.2025
cc_227 N_NET3_2 N_A_1 0.000272928f $X=0.27 $Y=0.1821
cc_228 N_NET3_2 N_MM0_G 0.000868981f $X=0.27 $Y=0.1821
cc_229 N_MM5_S N_MM0_G 0.0374274f $X=0.2527 $Y=0.2025
cc_230 N_NET3_2 A 0.000254775f $X=0.27 $Y=0.1821
cc_231 N_NET3_9 A 3.4355e-20 $X=0.162 $Y=0.198
cc_232 N_NET3_2 N_MAJI_4 0.00364312f $X=0.27 $Y=0.1821
cc_233 N_NET3_13 N_MAJI_4 0.000804198f $X=0.216 $Y=0.234
cc_234 N_MM5_S N_MM8_D 0.00126995f $X=0.2527 $Y=0.2025
cc_235 N_NET3_13 N_MAJI_15 7.14357e-20 $X=0.216 $Y=0.234
cc_236 N_NET3_2 N_MAJI_17 0.000740567f $X=0.27 $Y=0.1821
cc_237 N_NET3_9 N_MAJI_17 0.000359159f $X=0.162 $Y=0.198
cc_238 N_NET3_10 N_MAJI_17 9.29977e-20 $X=0.162 $Y=0.234
cc_239 N_NET3_11 N_MAJI_17 0.000195207f $X=0.054 $Y=0.198
cc_240 N_NET3_12 N_MAJI_17 0.000181022f $X=0.162 $Y=0.216
cc_241 N_NET3_13 N_MAJI_17 0.00747018f $X=0.216 $Y=0.234
cc_242 N_NET3_2 N_MAJI_18 5.83412e-20 $X=0.27 $Y=0.1821
cc_243 N_NET3_1 N_NET1_1 0.000266817f $X=0.054 $Y=0.18
cc_244 N_MM7_D N_NET1_1 0.000180959f $X=0.0714 $Y=0.2025
cc_245 N_NET3_11 N_NET1_1 0.000257271f $X=0.054 $Y=0.198
cc_246 N_NET3_1 N_MM2_D 0.000180959f $X=0.054 $Y=0.18
cc_247 N_NET3_1 N_NET1_11 0.000257271f $X=0.054 $Y=0.18
x_PM_MAJX3_ASAP7_75T_R%Y vss Y N_MM10_d N_MM10@2_d N_MM11_d N_MM11@2_d
+ N_MM10@3_d N_MM11@3_d N_Y_1 N_Y_17 N_Y_3 N_Y_19 N_Y_20 N_Y_22 N_Y_23 N_Y_24
+ N_Y_25 N_Y_4 N_Y_2 N_Y_18 PM_MAJX3_ASAP7_75T_R%Y
cc_248 N_MM10_D N_VSS_1 0.0049178f $X=0.3607 $Y=0.06751
cc_249 N_Y_1 N_VSS_1 8.42209e-20 $X=0.378 $Y=0.0299
cc_250 N_Y_17 N_VSS_1 0.000258763f $X=0.378 $Y=0.036
cc_251 N_Y_1 N_VSS_6 0.0015389f $X=0.378 $Y=0.0299
cc_252 N_Y_1 N_VSS_7 0.00335291f $X=0.378 $Y=0.0299
cc_253 N_Y_3 N_VSS_7 0.00752725f $X=0.486 $Y=0.04711
cc_254 N_Y_19 N_VSS_7 1.66138e-20 $X=0.4051 $Y=0.1351
cc_255 N_Y_20 N_VSS_7 5.87963e-20 $X=0.486 $Y=0.1351
cc_256 Y N_VSS_7 0.00118582f $X=0.4051 $Y=0.1149
cc_257 N_Y_22 N_VSS_7 5.21239e-20 $X=0.4051 $Y=0.1845
cc_258 N_Y_23 N_VSS_7 0.000294319f $X=0.4454 $Y=0.1351
cc_259 N_Y_24 N_VSS_7 0.00093791f $X=0.486 $Y=0.072
cc_260 N_Y_25 N_VSS_7 0.000127938f $X=0.486 $Y=0.1665
cc_261 N_Y_17 N_VSS_7 0.00036463f $X=0.378 $Y=0.036
cc_262 N_MM10_D N_MM1_S 0.000559457f $X=0.3607 $Y=0.06751
cc_263 N_Y_4 N_MM10@3_S 6.78944e-20 $X=0.486 $Y=0.18
cc_264 N_MM10_D N_MM10@3_S 0.00188248f $X=0.3607 $Y=0.06751
cc_265 N_MM10@2_D N_MM10@3_S 0.00274853f $X=0.4687 $Y=0.06751
cc_266 N_Y_1 VSS 0.00128211f $X=0.378 $Y=0.0299
cc_267 N_Y_17 VSS 0.00729146f $X=0.378 $Y=0.036
cc_268 N_MM11_D N_VDD_1 0.0049178f $X=0.3607 $Y=0.2025
cc_269 N_Y_2 N_VDD_1 8.51115e-20 $X=0.378 $Y=0.1821
cc_270 N_Y_18 N_VDD_1 0.000258763f $X=0.4051 $Y=0.234
cc_271 N_Y_2 N_VDD_6 0.00153361f $X=0.378 $Y=0.1821
cc_272 N_Y_2 N_VDD_7 0.00335291f $X=0.378 $Y=0.1821
cc_273 N_Y_4 N_VDD_7 0.00752725f $X=0.486 $Y=0.18
cc_274 N_Y_19 N_VDD_7 1.7432e-20 $X=0.4051 $Y=0.1351
cc_275 N_Y_20 N_VDD_7 5.61951e-20 $X=0.486 $Y=0.1351
cc_276 Y N_VDD_7 5.21249e-20 $X=0.4051 $Y=0.1149
cc_277 N_Y_22 N_VDD_7 0.0011967f $X=0.4051 $Y=0.1845
cc_278 N_Y_23 N_VDD_7 0.000294506f $X=0.4454 $Y=0.1351
cc_279 N_Y_24 N_VDD_7 0.00012436f $X=0.486 $Y=0.072
cc_280 N_Y_25 N_VDD_7 0.000990998f $X=0.486 $Y=0.1665
cc_281 N_Y_18 N_VDD_7 0.00036463f $X=0.4051 $Y=0.234
cc_282 N_MM11_D N_MM6_S 0.000559804f $X=0.3607 $Y=0.2025
cc_283 N_Y_3 N_MM11@3_S 6.78944e-20 $X=0.486 $Y=0.04711
cc_284 N_MM11_D N_MM11@3_S 0.00188348f $X=0.3607 $Y=0.2025
cc_285 N_MM11@2_D N_MM11@3_S 0.00272379f $X=0.4687 $Y=0.2025
cc_286 N_Y_2 VDD 0.00128211f $X=0.378 $Y=0.1821
cc_287 N_Y_18 VDD 0.007262f $X=0.4051 $Y=0.234
cc_288 N_Y_1 N_B_2 4.64557e-20 $X=0.378 $Y=0.0299
cc_289 N_Y_1 N_B_8 0.000109504f $X=0.378 $Y=0.0299
cc_290 N_Y_17 N_B_8 8.1344e-20 $X=0.378 $Y=0.036
cc_291 N_Y_18 N_B_8 8.31494e-20 $X=0.4051 $Y=0.234
cc_292 N_Y_19 N_B_8 0.000125937f $X=0.4051 $Y=0.1351
cc_293 N_Y_20 N_B_8 1.70538e-20 $X=0.486 $Y=0.1351
cc_294 Y N_B_8 0.00012818f $X=0.4051 $Y=0.1149
cc_295 N_Y_22 N_B_8 0.000125165f $X=0.4051 $Y=0.1845
cc_296 N_Y_23 N_B_8 6.97666e-20 $X=0.4454 $Y=0.1351
cc_297 N_Y_24 N_B_8 4.30757e-20 $X=0.486 $Y=0.072
cc_298 N_Y_19 N_B_9 0.000367133f $X=0.4051 $Y=0.1351
cc_299 N_Y_3 N_MAJI_1 3.64865e-20 $X=0.486 $Y=0.04711
cc_300 N_Y_4 N_MAJI_1 3.64865e-20 $X=0.486 $Y=0.18
cc_301 N_MM11_D N_MAJI_1 0.00611656f $X=0.3607 $Y=0.2025
cc_302 N_Y_20 N_MAJI_1 5.05563e-20 $X=0.486 $Y=0.1351
cc_303 N_Y_23 N_MAJI_1 0.000600002f $X=0.4454 $Y=0.1351
cc_304 N_Y_24 N_MAJI_1 0.00016317f $X=0.486 $Y=0.072
cc_305 N_Y_25 N_MAJI_1 0.000166805f $X=0.486 $Y=0.1665
cc_306 N_Y_1 N_MAJI_1 0.000646458f $X=0.378 $Y=0.0299
cc_307 N_MM11_D N_MM10_G 0.0379488f $X=0.3607 $Y=0.2025
cc_308 N_Y_1 N_MM10@3_G 0.0019589f $X=0.378 $Y=0.0299
cc_309 N_Y_2 N_MM10@3_G 0.0019589f $X=0.378 $Y=0.1821
cc_310 N_MM10_D N_MM10@3_G 0.0370799f $X=0.3607 $Y=0.06751
cc_311 N_MM11_D N_MM10@3_G 0.0749617f $X=0.3607 $Y=0.2025
cc_312 N_Y_3 N_MM10@2_G 0.000651016f $X=0.486 $Y=0.04711
cc_313 N_Y_4 N_MM10@2_G 0.000651016f $X=0.486 $Y=0.18
cc_314 N_MM10@2_D N_MM10@2_G 0.0187437f $X=0.4687 $Y=0.06751
cc_315 N_MM11@2_D N_MM10@2_G 0.0567446f $X=0.4687 $Y=0.2025
cc_316 N_Y_1 N_MAJI_14 0.000304362f $X=0.378 $Y=0.0299
cc_317 N_Y_17 N_MAJI_14 0.00173595f $X=0.378 $Y=0.036
cc_318 N_Y_2 N_MAJI_15 0.000304362f $X=0.378 $Y=0.1821
cc_319 N_Y_18 N_MAJI_15 0.00175667f $X=0.4051 $Y=0.234
cc_320 N_Y_17 N_MAJI_16 0.000420871f $X=0.378 $Y=0.036
cc_321 N_Y_18 N_MAJI_17 0.000431852f $X=0.4051 $Y=0.234
cc_322 N_Y_19 N_MAJI_18 0.0033111f $X=0.4051 $Y=0.1351
cc_323 Y N_MAJI_18 0.00143906f $X=0.4051 $Y=0.1149
cc_324 N_Y_22 N_MAJI_18 0.00145511f $X=0.4051 $Y=0.1845
cc_325 N_Y_1 N_NET1_2 0.000143023f $X=0.378 $Y=0.0299
cc_326 N_MM10_D N_NET1_2 8.48076e-20 $X=0.3607 $Y=0.06751
cc_327 N_Y_1 N_MM0_S 5.89745e-20 $X=0.378 $Y=0.0299
cc_328 N_Y_17 N_NET1_13 2.73405e-20 $X=0.378 $Y=0.036
cc_329 N_Y_2 N_NET3_2 0.000143023f $X=0.378 $Y=0.1821
cc_330 N_MM11_D N_NET3_2 9.96007e-20 $X=0.3607 $Y=0.2025
cc_331 N_Y_2 N_MM5_S 5.89745e-20 $X=0.378 $Y=0.1821
cc_332 N_Y_18 N_NET3_13 2.73405e-20 $X=0.4051 $Y=0.234
x_PM_MAJX3_ASAP7_75T_R%NET17 vss N_MM4_d N_MM3_s PM_MAJX3_ASAP7_75T_R%NET17
cc_333 N_MM4_D N_MM2_S 0.000256465f $X=0.1447 $Y=0.06751
cc_334 N_MM4_D N_MM4_G 0.0187197f $X=0.1447 $Y=0.06751
cc_335 N_MM4_D N_B_1 1.71622e-20 $X=0.1447 $Y=0.06751
cc_336 N_MM4_D N_MM3_G 0.0187349f $X=0.1447 $Y=0.06751
x_PM_MAJX3_ASAP7_75T_R%NET16 vss N_MM9_d N_MM8_s PM_MAJX3_ASAP7_75T_R%NET16
cc_337 N_MM9_D N_MM4_G 0.0187196f $X=0.1447 $Y=0.2025
cc_338 N_MM9_D N_MM7_S 0.000256435f $X=0.1447 $Y=0.2025
cc_339 N_MM9_D N_B_1 1.71554e-20 $X=0.1447 $Y=0.2025
cc_340 N_MM9_D N_MM3_G 0.0187348f $X=0.1447 $Y=0.2025

.ENDS
*

.subckt PM_DHLx2_ASAP7_75t_R%CLK vss 18 9 15 3 1 6 5 7 8 4
c1 1 vss 0.00392574f $X=0.081 $Y=0.135
c2 3 vss 0.0687989f $X=0.081 $Y=0.0245
c3 4 vss 0.00205295f $X=0.081 $Y=0.099
c4 5 vss 0.00189343f $X=0.081 $Y=0.171
c5 6 vss 0.00105845f $X=0.081 $Y=0.135
c6 7 vss 0.00441067f $X=0.108 $Y=0.063
c7 8 vss 0.00429314f $X=0.108 $Y=0.1935
r1 8 24 1.35805 $w=2.83333e-08 $l=2.25e-08 $layer=M1 $thickness=3.6e-08
+ $X=0.108 $Y=0.1935 $X2=0.108 $Y2=0.171
r2 7 22 4.50612 $w=2.06667e-08 $l=3.6e-08 $layer=M1 $thickness=3.6e-08 $X=0.108
+ $Y=0.063 $X2=0.108 $Y2=0.099
r3 23 24 0.502848 $w=3.43333e-08 $l=1.35e-08 $layer=M1 $thickness=3.6e-08
+ $X=0.0945 $Y=0.171 $X2=0.108 $Y2=0.171
r4 5 20 1.35805 $w=2.83333e-08 $l=2.25e-08 $layer=M1 $thickness=3.6e-08
+ $X=0.081 $Y=0.171 $X2=0.081 $Y2=0.1485
r5 5 23 0.502848 $w=3.43333e-08 $l=1.35e-08 $layer=M1 $thickness=3.6e-08
+ $X=0.081 $Y=0.171 $X2=0.0945 $Y2=0.171
r6 21 22 0.502848 $w=3.43333e-08 $l=1.35e-08 $layer=M1 $thickness=3.6e-08
+ $X=0.0945 $Y=0.099 $X2=0.108 $Y2=0.099
r7 4 17 0.483592 $w=3.42308e-08 $l=1.87e-08 $layer=M1 $thickness=3.6e-08
+ $X=0.081 $Y=0.099 $X2=0.081 $Y2=0.1177
r8 4 21 0.502848 $w=3.43333e-08 $l=1.35e-08 $layer=M1 $thickness=3.6e-08
+ $X=0.081 $Y=0.099 $X2=0.0945 $Y2=0.099
r9 18 19 0.874462 $w=1.3e-08 $l=3.7e-09 $layer=M1 $thickness=3.6e-08 $X=0.08
+ $Y=0.119 $X2=0.081 $Y2=0.1227
r10 18 17 0.291487 $w=1.3e-08 $l=1.3e-09 $layer=M1 $thickness=3.6e-08 $X=0.08
+ $Y=0.119 $X2=0.081 $Y2=0.1177
r11 6 19 2.85657 $w=1.3e-08 $l=1.23e-08 $layer=M1 $thickness=3.6e-08 $X=0.081
+ $Y=0.135 $X2=0.081 $Y2=0.1227
r12 6 20 3.14806 $w=1.3e-08 $l=1.35e-08 $layer=M1 $thickness=3.6e-08 $X=0.081
+ $Y=0.135 $X2=0.081 $Y2=0.1485
r13 1 12 10.4265 $w=1.765e-08 $layer=LIG $thickness=5.2e-08 $X=0.081 $Y=0.135
+ $X2=0.081 $Y2=0.135
r14 1 6 19.3796 $a=3.24e-16 $layer=V0LIG $X=0.081 $Y=0.135 $X2=0.081 $Y2=0.135
r15 15 14 14.6259 $w=2.1e-08 $l=4.3e-08 $layer=Gate_1 $thickness=5.6e-08
+ $X=0.081 $Y=0.216 $X2=0.081 $Y2=0.173
r16 13 14 7.31297 $w=2.1e-08 $l=2.15e-08 $layer=Gate_1 $thickness=5.6e-08
+ $X=0.081 $Y=0.1515 $X2=0.081 $Y2=0.173
r17 12 13 5.79936 $w=2.03333e-08 $l=1.65e-08 $layer=Gate_1 $thickness=5.6e-08
+ $X=0.081 $Y=0.135 $X2=0.081 $Y2=0.1515
r18 11 12 5.79936 $w=2.03333e-08 $l=1.65e-08 $layer=Gate_1 $thickness=5.6e-08
+ $X=0.081 $Y=0.1185 $X2=0.081 $Y2=0.135
r19 10 11 7.31297 $w=2.1e-08 $l=2.15e-08 $layer=Gate_1 $thickness=5.6e-08
+ $X=0.081 $Y=0.097 $X2=0.081 $Y2=0.1185
r20 9 10 14.6259 $w=2.1e-08 $l=4.3e-08 $layer=Gate_1 $thickness=5.6e-08
+ $X=0.081 $Y=0.054 $X2=0.081 $Y2=0.097
r21 9 3 10.0341 $w=2.1e-08 $l=2.95e-08 $layer=Gate_1 $thickness=5.6e-08
+ $X=0.081 $Y=0.054 $X2=0.081 $Y2=0.0245
.ends

.subckt PM_DHLx2_ASAP7_75t_R%D vss 16 6 12 5 1 3 4
c1 1 vss 0.00511743f $X=0.297 $Y=0.1345
c2 3 vss 0.091919f $X=0.297 $Y=0.0245
c3 4 vss 0.00568866f $X=0.297 $Y=0.036
c4 5 vss 0.00901917f $X=0.297 $Y=0.0755
r1 4 5 8.03069 $w=1.41392e-08 $l=3.95e-08 $layer=M1 $thickness=3.6e-08 $X=0.297
+ $Y=0.036 $X2=0.297 $Y2=0.0755
r2 17 18 3.14806 $w=1.3e-08 $l=1.35e-08 $layer=M1 $thickness=3.6e-08 $X=0.297
+ $Y=0.1215 $X2=0.297 $Y2=0.135
r3 16 17 1.16595 $w=1.3e-08 $l=5e-09 $layer=M1 $thickness=3.6e-08 $X=0.297
+ $Y=0.1165 $X2=0.297 $Y2=0.1215
r4 16 15 1.28254 $w=1.3e-08 $l=5.5e-09 $layer=M1 $thickness=3.6e-08 $X=0.297
+ $Y=0.1165 $X2=0.297 $Y2=0.111
r5 5 15 8.27824 $w=1.3e-08 $l=3.55e-08 $layer=M1 $thickness=3.6e-08 $X=0.297
+ $Y=0.0755 $X2=0.297 $Y2=0.111
r6 1 9 10.1312 $w=1.77047e-08 $l=5e-10 $layer=LIG $thickness=5.2093e-08
+ $X=0.297 $Y=0.1345 $X2=0.297 $Y2=0.135
r7 1 18 19.3796 $a=3.24e-16 $layer=V0LIG $X=0.297 $Y=0.1345 $X2=0.297 $Y2=0.135
r8 12 11 14.6259 $w=2.1e-08 $l=4.3e-08 $layer=Gate_1 $thickness=5.6e-08
+ $X=0.297 $Y=0.2025 $X2=0.297 $Y2=0.1595
r9 10 11 2.7211 $w=2.1e-08 $l=8e-09 $layer=Gate_1 $thickness=5.6e-08 $X=0.297
+ $Y=0.1515 $X2=0.297 $Y2=0.1595
r10 9 10 5.79936 $w=2.03333e-08 $l=1.65e-08 $layer=Gate_1 $thickness=5.6e-08
+ $X=0.297 $Y=0.135 $X2=0.297 $Y2=0.1515
r11 8 9 5.79936 $w=2.03333e-08 $l=1.65e-08 $layer=Gate_1 $thickness=5.6e-08
+ $X=0.297 $Y=0.1185 $X2=0.297 $Y2=0.135
r12 7 8 2.7211 $w=2.1e-08 $l=8e-09 $layer=Gate_1 $thickness=5.6e-08 $X=0.297
+ $Y=0.1105 $X2=0.297 $Y2=0.1185
r13 6 7 14.6259 $w=2.1e-08 $l=4.3e-08 $layer=Gate_1 $thickness=5.6e-08 $X=0.297
+ $Y=0.0675 $X2=0.297 $Y2=0.1105
r14 6 3 14.6259 $w=2.1e-08 $l=4.3e-08 $layer=Gate_1 $thickness=5.6e-08 $X=0.297
+ $Y=0.0675 $X2=0.297 $Y2=0.0245
.ends

.subckt PM_DHLx2_ASAP7_75t_R%Q vss 23 16 17 33 34 7 1 8 2 13
c1 1 vss 0.00873501f $X=0.756 $Y=0.0675
c2 2 vss 0.00898104f $X=0.756 $Y=0.2025
c3 7 vss 0.00443112f $X=0.7415 $Y=0.0675
c4 8 vss 0.00451096f $X=0.7415 $Y=0.2025
c5 9 vss 0.00241029f $X=0.841 $Y=0.045
c6 10 vss 0.00240947f $X=0.841 $Y=0.225
c7 11 vss 0.0073568f $X=0.812 $Y=0.225
c8 12 vss 0.00735895f $X=0.7445 $Y=0.045
c9 13 vss 0.00660294f $X=0.841 $Y=0.072
r1 34 32 0.0308642 $w=8.1e-08 $l=2.5e-09 $layer=P_src_drn $thickness=1e-09
+ $X=0.7733 $Y=0.2025 $X2=0.7705 $Y2=0.2025
r2 2 32 0.179012 $w=8.1e-08 $l=1.45e-08 $layer=P_src_drn $thickness=1e-09
+ $X=0.756 $Y=0.2025 $X2=0.7705 $Y2=0.2025
r3 8 2 0.179012 $w=8.1e-08 $l=1.45e-08 $layer=P_src_drn $thickness=1e-09
+ $X=0.7415 $Y=0.2025 $X2=0.756 $Y2=0.2025
r4 33 8 0.0308642 $w=8.1e-08 $l=2.5e-09 $layer=P_src_drn $thickness=1e-09
+ $X=0.7386 $Y=0.2025 $X2=0.7415 $Y2=0.2025
r5 2 28 19.3796 $a=3.24e-16 $layer=V0LISD $X=0.756 $Y=0.2025 $X2=0.756 $Y2=0.225
r6 28 29 3.14806 $w=1.3e-08 $l=1.35e-08 $layer=M1 $thickness=3.6e-08 $X=0.756
+ $Y=0.225 $X2=0.7695 $Y2=0.225
r7 26 29 3.14806 $w=1.3e-08 $l=1.35e-08 $layer=M1 $thickness=3.6e-08 $X=0.783
+ $Y=0.225 $X2=0.7695 $Y2=0.225
r8 11 26 6.7625 $w=1.3e-08 $l=2.9e-08 $layer=M1 $thickness=3.6e-08 $X=0.812
+ $Y=0.225 $X2=0.783 $Y2=0.225
r9 10 25 6.16274 $w=1.56328e-08 $l=3.35e-08 $layer=M1 $thickness=3.6e-08
+ $X=0.841 $Y=0.225 $X2=0.841 $Y2=0.1915
r10 10 11 5.11339 $w=1.45517e-08 $l=2.9e-08 $layer=M1 $thickness=3.6e-08
+ $X=0.841 $Y=0.225 $X2=0.812 $Y2=0.225
r11 24 25 11.6012 $w=1.3e-08 $l=4.98e-08 $layer=M1 $thickness=3.6e-08 $X=0.841
+ $Y=0.1417 $X2=0.841 $Y2=0.1915
r12 23 24 6.00464 $w=1.3e-08 $l=2.57e-08 $layer=M1 $thickness=3.6e-08 $X=0.841
+ $Y=0.116 $X2=0.841 $Y2=0.1417
r13 23 22 3.08976 $w=1.3e-08 $l=1.33e-08 $layer=M1 $thickness=3.6e-08 $X=0.841
+ $Y=0.116 $X2=0.841 $Y2=0.1027
r14 13 22 7.17059 $w=1.3e-08 $l=3.07e-08 $layer=M1 $thickness=3.6e-08 $X=0.841
+ $Y=0.072 $X2=0.841 $Y2=0.1027
r15 9 21 5.11339 $w=1.45517e-08 $l=2.9e-08 $layer=M1 $thickness=3.6e-08
+ $X=0.841 $Y=0.045 $X2=0.812 $Y2=0.045
r16 9 13 4.64701 $w=1.62667e-08 $l=2.7e-08 $layer=M1 $thickness=3.6e-08
+ $X=0.841 $Y=0.045 $X2=0.841 $Y2=0.072
r17 20 21 6.7625 $w=1.3e-08 $l=2.9e-08 $layer=M1 $thickness=3.6e-08 $X=0.783
+ $Y=0.045 $X2=0.812 $Y2=0.045
r18 19 20 3.14806 $w=1.3e-08 $l=1.35e-08 $layer=M1 $thickness=3.6e-08 $X=0.7695
+ $Y=0.045 $X2=0.783 $Y2=0.045
r19 18 19 3.14806 $w=1.3e-08 $l=1.35e-08 $layer=M1 $thickness=3.6e-08 $X=0.756
+ $Y=0.045 $X2=0.7695 $Y2=0.045
r20 12 18 2.68168 $w=1.3e-08 $l=1.15e-08 $layer=M1 $thickness=3.6e-08 $X=0.7445
+ $Y=0.045 $X2=0.756 $Y2=0.045
r21 1 18 19.3796 $a=3.24e-16 $layer=V0LISD $X=0.756 $Y=0.0675 $X2=0.756
+ $Y2=0.045
r22 17 15 0.0308642 $w=8.1e-08 $l=2.5e-09 $layer=N_src_drn $thickness=1e-09
+ $X=0.7733 $Y=0.0675 $X2=0.7705 $Y2=0.0675
r23 1 15 0.179012 $w=8.1e-08 $l=1.45e-08 $layer=N_src_drn $thickness=1e-09
+ $X=0.756 $Y=0.0675 $X2=0.7705 $Y2=0.0675
r24 7 1 0.179012 $w=8.1e-08 $l=1.45e-08 $layer=N_src_drn $thickness=1e-09
+ $X=0.7415 $Y=0.0675 $X2=0.756 $Y2=0.0675
r25 16 7 0.0308642 $w=8.1e-08 $l=2.5e-09 $layer=N_src_drn $thickness=1e-09
+ $X=0.7386 $Y=0.0675 $X2=0.7415 $Y2=0.0675
.ends

.subckt PM_DHLx2_ASAP7_75t_R%10 vss 7 9 4 5 1
c1 1 vss 0.00821076f $X=0.351 $Y=0.0675
c2 4 vss 0.00285659f $X=0.3095 $Y=0.0675
c3 5 vss 0.00175747f $X=0.38 $Y=0.0675
r1 9 8 0.0308642 $w=8.1e-08 $l=2.5e-09 $layer=N_src_drn $thickness=1e-09
+ $X=0.3953 $Y=0.0675 $X2=0.3925 $Y2=0.0675
r2 5 8 0.154321 $w=8.1e-08 $l=1.25e-08 $layer=N_src_drn $thickness=1e-09
+ $X=0.38 $Y=0.0675 $X2=0.3925 $Y2=0.0675
r3 4 1 0.154321 $w=8.1e-08 $l=1.25e-08 $layer=N_src_drn $thickness=1e-09
+ $X=0.3095 $Y=0.0675 $X2=0.351 $Y2=0.0675
r4 7 4 0.0308642 $w=8.1e-08 $l=2.5e-09 $layer=N_src_drn $thickness=1e-09
+ $X=0.3066 $Y=0.0675 $X2=0.3095 $Y2=0.0675
r5 1 5 1e-05 $l=2.9e-08 $X=0.351 $Y=0.0675 $X2=0.38 $Y2=0.0675
.ends

.subckt PM_DHLx2_ASAP7_75t_R%4 vss 38 44 93 104 108 110 20 22 7 6 23 18 17 30 1
+ 28 25 33 27 29 14 24 2 15 31 3 16 8 32
c1 1 vss 0.00340263f $X=0.134 $Y=0.135
c2 2 vss 0.000358858f $X=0.351 $Y=0.1235
c3 3 vss 0.000122766f $X=0.459 $Y=0.179
c4 6 vss 0.0079701f $X=0.054 $Y=0.054
c5 7 vss 0.00787985f $X=0.054 $Y=0.216
c6 8 vss 0.0093538f $X=0.501 $Y=0.179
c7 14 vss 0.0686485f $X=0.135 $Y=0.0245
c8 15 vss 0.00781574f $X=0.351 $Y=0.0725
c9 16 vss 0.00637453f $X=0.459 $Y=0.179
c10 17 vss 0.0311842f $X=0.056 $Y=0.054
c11 18 vss 0.0311241f $X=0.056 $Y=0.216
c12 19 vss 0.00364731f $X=0.018 $Y=0.036
c13 20 vss 0.00258345f $X=0.0165 $Y=0.189
c14 21 vss 0.00351811f $X=0.018 $Y=0.234
c15 22 vss 0.00123887f $X=0.189 $Y=0.189
c16 23 vss 0.000601659f $X=0.189 $Y=0.135
c17 24 vss 0.00126242f $X=0.351 $Y=0.198
c18 25 vss 0.00893543f $X=0.018 $Y=0.1665
c19 26 vss 0.00200221f $X=0.018 $Y=0.2115
c20 27 vss 0.00468488f $X=0.036 $Y=0.036
c21 28 vss 0.00383151f $X=0.036 $Y=0.234
c22 29 vss 0.000785041f $X=0.1405 $Y=0.135
c23 30 vss 0.000500062f $X=0.189 $Y=0.1485
c24 31 vss 0.00113889f $X=0.351 $Y=0.1755
c25 32 vss 0.00178878f $X=0.513 $Y=0.1675
c26 33 vss 0.0233248f $X=0.0215 $Y=0.189
r1 110 109 0.0462963 $w=5.4e-08 $l=2.5e-09 $layer=P_src_drn $thickness=1e-09
+ $X=0.0713 $Y=0.216 $X2=0.0685 $Y2=0.216
r2 18 109 0.231482 $w=5.4e-08 $l=1.25e-08 $layer=P_src_drn $thickness=1e-09
+ $X=0.056 $Y=0.216 $X2=0.0685 $Y2=0.216
r3 108 107 0.0462963 $w=5.4e-08 $l=2.5e-09 $layer=N_src_drn $thickness=1e-09
+ $X=0.0713 $Y=0.054 $X2=0.0685 $Y2=0.054
r4 17 107 0.231482 $w=5.4e-08 $l=1.25e-08 $layer=N_src_drn $thickness=1e-09
+ $X=0.056 $Y=0.054 $X2=0.0685 $Y2=0.054
r5 7 101 19.3796 $a=3.24e-16 $layer=V0LISD $X=0.054 $Y=0.216 $X2=0.055 $Y2=0.234
r6 6 98 19.3796 $a=3.24e-16 $layer=V0LISD $X=0.054 $Y=0.054 $X2=0.055 $Y2=0.036
r7 104 105 23.4695 $w=2.1e-08 $l=6.9e-08 $layer=Gate_1 $thickness=5.6e-08
+ $X=0.459 $Y=0.0405 $X2=0.459 $Y2=0.1095
r8 16 105 23.8777 $w=2.07986e-08 $l=6.95e-08 $layer=Gate_1 $thickness=5.6e-08
+ $X=0.459 $Y=0.179 $X2=0.459 $Y2=0.1095
r9 100 101 2.09871 $w=1.3e-08 $l=9e-09 $layer=M1 $thickness=3.6e-08 $X=0.046
+ $Y=0.234 $X2=0.055 $Y2=0.234
r10 28 100 2.3319 $w=1.3e-08 $l=1e-08 $layer=M1 $thickness=3.6e-08 $X=0.036
+ $Y=0.234 $X2=0.046 $Y2=0.234
r11 97 98 2.09871 $w=1.3e-08 $l=9e-09 $layer=M1 $thickness=3.6e-08 $X=0.046
+ $Y=0.036 $X2=0.055 $Y2=0.036
r12 27 97 2.3319 $w=1.3e-08 $l=1e-08 $layer=M1 $thickness=3.6e-08 $X=0.036
+ $Y=0.036 $X2=0.046 $Y2=0.036
r13 3 86 5.67512 $w=2.4e-08 $l=5e-09 $layer=LISD $thickness=4.02632e-08
+ $X=0.459 $Y=0.179 $X2=0.464 $Y2=0.179
r14 3 16 7.56983 $w=2.18462e-08 $layer=Gate_1 $thickness=5.23077e-08 $X=0.459
+ $Y=0.179 $X2=0.459 $Y2=0.179
r15 93 92 16.6668 $w=2.1e-08 $l=4.9e-08 $layer=Gate_1 $thickness=5.6e-08
+ $X=0.351 $Y=0.2025 $X2=0.351 $Y2=0.1535
r16 91 92 6.81977 $w=2.04359e-08 $l=1.95e-08 $layer=Gate_1 $thickness=5.6e-08
+ $X=0.351 $Y=0.134 $X2=0.351 $Y2=0.1535
r17 15 91 21.1056 $w=2.08211e-08 $l=6.15e-08 $layer=Gate_1 $thickness=5.6e-08
+ $X=0.351 $Y=0.0725 $X2=0.351 $Y2=0.134
r18 21 26 3.59766 $w=1.692e-08 $l=2.25e-08 $layer=M1 $thickness=3.6e-08
+ $X=0.018 $Y=0.234 $X2=0.018 $Y2=0.2115
r19 21 28 2.5483 $w=1.55e-08 $l=1.8e-08 $layer=M1 $thickness=3.6e-08 $X=0.018
+ $Y=0.234 $X2=0.036 $Y2=0.234
r20 19 81 4.64701 $w=1.62667e-08 $l=2.7e-08 $layer=M1 $thickness=3.6e-08
+ $X=0.018 $Y=0.036 $X2=0.018 $Y2=0.063
r21 19 27 2.5483 $w=1.55e-08 $l=1.8e-08 $layer=M1 $thickness=3.6e-08 $X=0.018
+ $Y=0.036 $X2=0.036 $Y2=0.036
r22 85 86 11.0623 $w=2.14976e-08 $l=2.05e-08 $layer=LISD $thickness=2.7e-08
+ $X=0.4845 $Y=0.179 $X2=0.464 $Y2=0.179
r23 8 83 7.07284 $w=2.02e-08 $l=1.2e-08 $layer=LISD $thickness=2.7e-08 $X=0.501
+ $Y=0.179 $X2=0.513 $Y2=0.179
r24 8 85 9.72516 $w=2.02e-08 $l=1.65e-08 $layer=LISD $thickness=2.7e-08
+ $X=0.501 $Y=0.179 $X2=0.4845 $Y2=0.179
r25 82 91 10.1312 $w=1.77047e-08 $l=5e-10 $layer=LIG $thickness=5.2093e-08
+ $X=0.351 $Y=0.1345 $X2=0.351 $Y2=0.134
r26 2 82 6.49795 $w=1.53e-08 $l=1.1e-08 $layer=LIG $thickness=4.8e-08 $X=0.351
+ $Y=0.1235 $X2=0.351 $Y2=0.1345
r27 2 15 17.4723 $w=2.09441e-08 $l=5.1e-08 $layer=Gate_1 $thickness=5.59216e-08
+ $X=0.351 $Y=0.1235 $X2=0.351 $Y2=0.0725
r28 80 81 8.39483 $w=1.3e-08 $l=3.6e-08 $layer=M1 $thickness=3.6e-08 $X=0.018
+ $Y=0.099 $X2=0.018 $Y2=0.063
r29 79 80 8.39483 $w=1.3e-08 $l=3.6e-08 $layer=M1 $thickness=3.6e-08 $X=0.018
+ $Y=0.135 $X2=0.018 $Y2=0.099
r30 25 79 7.34548 $w=1.3e-08 $l=3.15e-08 $layer=M1 $thickness=3.6e-08 $X=0.018
+ $Y=0.1665 $X2=0.018 $Y2=0.135
r31 77 83 19.3796 $a=3.24e-16 $layer=V0LISD $X=0.513 $Y=0.1845 $X2=0.513
+ $Y2=0.179
r32 32 77 3.96423 $w=1.3e-08 $l=1.7e-08 $layer=M1 $thickness=3.6e-08 $X=0.513
+ $Y=0.1675 $X2=0.513 $Y2=0.1845
r33 75 76 5.36336 $w=1.3e-08 $l=2.3e-08 $layer=M1 $thickness=3.6e-08 $X=0.351
+ $Y=0.134 $X2=0.351 $Y2=0.157
r34 75 82 19.3796 $a=3.24e-16 $layer=V0LIG $X=0.351 $Y=0.134 $X2=0.351
+ $Y2=0.1345
r35 31 73 2.09871 $w=1.3e-08 $l=9e-09 $layer=M1 $thickness=3.6e-08 $X=0.351
+ $Y=0.1755 $X2=0.351 $Y2=0.1845
r36 31 76 4.31401 $w=1.3e-08 $l=1.85e-08 $layer=M1 $thickness=3.6e-08 $X=0.351
+ $Y=0.1755 $X2=0.351 $Y2=0.157
r37 24 62 39.0693 $a=1.62e-16 $layer=V1 $X=0.351 $Y=0.198 $X2=0.351 $Y2=0.189
r38 24 73 1.96775 $w=1.63333e-08 $l=1.35e-08 $layer=M1 $thickness=3.6e-08
+ $X=0.351 $Y=0.198 $X2=0.351 $Y2=0.1845
r39 68 69 1.90199 $w=1.38333e-08 $l=9e-09 $layer=M1 $thickness=3.6e-08
+ $X=0.0255 $Y=0.189 $X2=0.0345 $Y2=0.189
r40 20 68 0.9184 $w=1.8e-08 $l=9e-09 $layer=M1 $thickness=3.6e-08 $X=0.0165
+ $Y=0.189 $X2=0.0255 $Y2=0.189
r41 20 25 3.9134 $w=1.47857e-08 $l=2.25499e-08 $layer=M1 $thickness=3.6e-08
+ $X=0.0165 $Y=0.189 $X2=0.018 $Y2=0.1665
r42 20 26 3.9134 $w=1.47857e-08 $l=2.25499e-08 $layer=M1 $thickness=3.6e-08
+ $X=0.0165 $Y=0.189 $X2=0.018 $Y2=0.2115
r43 66 77 19.5347 $a=3.24e-16 $layer=V1 $X=0.513 $Y=0.189 $X2=0.513 $Y2=0.1845
r44 65 66 8.39483 $w=1.3e-08 $l=3.6e-08 $layer=M2 $thickness=3.6e-08 $X=0.477
+ $Y=0.189 $X2=0.513 $Y2=0.189
r45 64 65 10.4935 $w=1.3e-08 $l=4.5e-08 $layer=M2 $thickness=3.6e-08 $X=0.432
+ $Y=0.189 $X2=0.477 $Y2=0.189
r46 63 64 10.4935 $w=1.3e-08 $l=4.5e-08 $layer=M2 $thickness=3.6e-08 $X=0.387
+ $Y=0.189 $X2=0.432 $Y2=0.189
r47 62 63 8.39483 $w=1.3e-08 $l=3.6e-08 $layer=M2 $thickness=3.6e-08 $X=0.351
+ $Y=0.189 $X2=0.387 $Y2=0.189
r48 62 73 39.0693 $a=1.62e-16 $layer=V1 $X=0.351 $Y=0.189 $X2=0.351 $Y2=0.1845
r49 61 62 15.2739 $w=1.3e-08 $l=6.55e-08 $layer=M2 $thickness=3.6e-08 $X=0.2855
+ $Y=0.189 $X2=0.351 $Y2=0.189
r50 60 61 19.9377 $w=1.3e-08 $l=8.55e-08 $layer=M2 $thickness=3.6e-08 $X=0.2
+ $Y=0.189 $X2=0.2855 $Y2=0.189
r51 59 60 8.86121 $w=1.3e-08 $l=3.8e-08 $layer=M2 $thickness=3.6e-08 $X=0.162
+ $Y=0.189 $X2=0.2 $Y2=0.189
r52 58 59 15.0407 $w=1.3e-08 $l=6.45e-08 $layer=M2 $thickness=3.6e-08 $X=0.0975
+ $Y=0.189 $X2=0.162 $Y2=0.189
r53 57 58 15.0407 $w=1.3e-08 $l=6.45e-08 $layer=M2 $thickness=3.6e-08 $X=0.033
+ $Y=0.189 $X2=0.0975 $Y2=0.189
r54 57 69 19.5347 $a=3.24e-16 $layer=V1 $X=0.033 $Y=0.189 $X2=0.0345 $Y2=0.189
r55 33 57 2.68168 $w=1.3e-08 $l=1.15e-08 $layer=M2 $thickness=3.6e-08 $X=0.0215
+ $Y=0.189 $X2=0.033 $Y2=0.189
r56 55 56 3.14806 $w=1.3e-08 $l=1.35e-08 $layer=M1 $thickness=3.6e-08 $X=0.162
+ $Y=0.189 $X2=0.1755 $Y2=0.189
r57 55 59 19.5347 $a=3.24e-16 $layer=V1 $X=0.162 $Y=0.189 $X2=0.162 $Y2=0.189
r58 22 53 4.06646 $w=1.5e-08 $l=2.25e-08 $layer=M1 $thickness=3.6e-08 $X=0.189
+ $Y=0.189 $X2=0.189 $Y2=0.1665
r59 22 56 1.96775 $w=1.63333e-08 $l=1.35e-08 $layer=M1 $thickness=3.6e-08
+ $X=0.189 $Y=0.189 $X2=0.1755 $Y2=0.189
r60 30 53 4.19742 $w=1.3e-08 $l=1.8e-08 $layer=M1 $thickness=3.6e-08 $X=0.189
+ $Y=0.1485 $X2=0.189 $Y2=0.1665
r61 23 52 2.6649 $w=1.54324e-08 $l=1.85e-08 $layer=M1 $thickness=3.6e-08
+ $X=0.189 $Y=0.135 $X2=0.1705 $Y2=0.135
r62 23 30 1.49895 $w=1.95333e-08 $l=1.35e-08 $layer=M1 $thickness=3.6e-08
+ $X=0.189 $Y=0.135 $X2=0.189 $Y2=0.1485
r63 51 52 3.73104 $w=1.3e-08 $l=1.6e-08 $layer=M1 $thickness=3.6e-08 $X=0.1545
+ $Y=0.135 $X2=0.1705 $Y2=0.135
r64 50 51 2.09871 $w=1.3e-08 $l=9e-09 $layer=M1 $thickness=3.6e-08 $X=0.1455
+ $Y=0.135 $X2=0.1545 $Y2=0.135
r65 29 50 1.16595 $w=1.3e-08 $l=5e-09 $layer=M1 $thickness=3.6e-08 $X=0.1405
+ $Y=0.135 $X2=0.1455 $Y2=0.135
r66 48 51 19.3796 $a=3.24e-16 $layer=V0LIG $X=0.153 $Y=0.135 $X2=0.1545
+ $Y2=0.135
r67 46 48 4.98695 $w=1.60444e-08 $l=9e-09 $layer=LIG $thickness=4.8e-08
+ $X=0.144 $Y=0.135 $X2=0.153 $Y2=0.135
r68 1 46 2.6116 $w=2.2e-08 $l=1e-08 $layer=LIG $thickness=4.8e-08 $X=0.134
+ $Y=0.135 $X2=0.144 $Y2=0.135
r69 1 41 6.27904 $w=2.09e-08 $l=1e-09 $layer=Gate_1 $thickness=5.24e-08
+ $X=0.134 $Y=0.135 $X2=0.135 $Y2=0.135
r70 44 43 14.6259 $w=2.1e-08 $l=4.3e-08 $layer=Gate_1 $thickness=5.6e-08
+ $X=0.135 $Y=0.216 $X2=0.135 $Y2=0.173
r71 42 43 7.31297 $w=2.1e-08 $l=2.15e-08 $layer=Gate_1 $thickness=5.6e-08
+ $X=0.135 $Y=0.1515 $X2=0.135 $Y2=0.173
r72 41 42 5.79936 $w=2.03333e-08 $l=1.65e-08 $layer=Gate_1 $thickness=5.6e-08
+ $X=0.135 $Y=0.135 $X2=0.135 $Y2=0.1515
r73 41 46 4.18976 $w=2.01667e-08 $l=9e-09 $layer=Gate_1 $thickness=5.53333e-08
+ $X=0.135 $Y=0.135 $X2=0.144 $Y2=0.135
r74 40 41 5.79936 $w=2.03333e-08 $l=1.65e-08 $layer=Gate_1 $thickness=5.6e-08
+ $X=0.135 $Y=0.1185 $X2=0.135 $Y2=0.135
r75 39 40 7.31297 $w=2.1e-08 $l=2.15e-08 $layer=Gate_1 $thickness=5.6e-08
+ $X=0.135 $Y=0.097 $X2=0.135 $Y2=0.1185
r76 38 39 14.6259 $w=2.1e-08 $l=4.3e-08 $layer=Gate_1 $thickness=5.6e-08
+ $X=0.135 $Y=0.054 $X2=0.135 $Y2=0.097
r77 38 14 10.0341 $w=2.1e-08 $l=2.95e-08 $layer=Gate_1 $thickness=5.6e-08
+ $X=0.135 $Y=0.054 $X2=0.135 $Y2=0.0245
r78 7 18 1e-05 $l=2e-09 $X=0.054 $Y=0.216 $X2=0.056 $Y2=0.216
r79 6 17 1e-05 $l=2e-09 $X=0.054 $Y=0.054 $X2=0.056 $Y2=0.054
.ends

.subckt PM_DHLx2_ASAP7_75t_R%6 vss 21 25 50 52 3 15 14 11 10 4 9 18 17 16 1 12
c1 1 vss 0.000388197f $X=0.405 $Y=0.132
c2 3 vss 0.00759163f $X=0.162 $Y=0.054
c3 4 vss 0.00741103f $X=0.162 $Y=0.216
c4 9 vss 0.00738993f $X=0.405 $Y=0.0245
c5 10 vss 0.0321945f $X=0.1475 $Y=0.054
c6 11 vss 0.0319487f $X=0.1475 $Y=0.216
c7 12 vss 0.00307547f $X=0.243 $Y=0.036
c8 13 vss 0.00302226f $X=0.243 $Y=0.2305
c9 14 vss 0.00938104f $X=0.216 $Y=0.036
c10 15 vss 0.00843485f $X=0.216 $Y=0.234
c11 16 vss 0.00721796f $X=0.243 $Y=0.135
c12 17 vss 0.000953578f $X=0.405 $Y=0.1155
c13 18 vss 0.00652146f $X=0.2315 $Y=0.153
r1 11 4 0.231482 $w=5.4e-08 $l=1.25e-08 $layer=P_src_drn $thickness=1e-09
+ $X=0.1475 $Y=0.216 $X2=0.162 $Y2=0.216
r2 52 11 0.0462963 $w=5.4e-08 $l=2.5e-09 $layer=P_src_drn $thickness=1e-09
+ $X=0.1446 $Y=0.216 $X2=0.1475 $Y2=0.216
r3 10 3 0.231482 $w=5.4e-08 $l=1.25e-08 $layer=N_src_drn $thickness=1e-09
+ $X=0.1475 $Y=0.054 $X2=0.162 $Y2=0.054
r4 50 10 0.0462963 $w=5.4e-08 $l=2.5e-09 $layer=N_src_drn $thickness=1e-09
+ $X=0.1446 $Y=0.054 $X2=0.1475 $Y2=0.054
r5 4 47 19.3796 $a=3.24e-16 $layer=V0LISD $X=0.162 $Y=0.216 $X2=0.162 $Y2=0.234
r6 3 44 19.3796 $a=3.24e-16 $layer=V0LISD $X=0.162 $Y=0.054 $X2=0.162 $Y2=0.036
r7 47 48 5.24677 $w=1.3e-08 $l=2.25e-08 $layer=M1 $thickness=3.6e-08 $X=0.162
+ $Y=0.234 $X2=0.1845 $Y2=0.234
r8 15 48 7.34548 $w=1.3e-08 $l=3.15e-08 $layer=M1 $thickness=3.6e-08 $X=0.216
+ $Y=0.234 $X2=0.1845 $Y2=0.234
r9 44 45 5.24677 $w=1.3e-08 $l=2.25e-08 $layer=M1 $thickness=3.6e-08 $X=0.162
+ $Y=0.036 $X2=0.1845 $Y2=0.036
r10 14 45 7.34548 $w=1.3e-08 $l=3.15e-08 $layer=M1 $thickness=3.6e-08 $X=0.216
+ $Y=0.036 $X2=0.1845 $Y2=0.036
r11 13 41 3.70931 $w=1.44474e-08 $l=1.9e-08 $layer=M1 $thickness=3.6e-08
+ $X=0.243 $Y=0.2305 $X2=0.243 $Y2=0.2115
r12 13 15 4.75866 $w=1.41702e-08 $l=2.72259e-08 $layer=M1 $thickness=3.6e-08
+ $X=0.243 $Y=0.2305 $X2=0.216 $Y2=0.234
r13 12 39 4.64701 $w=1.62667e-08 $l=2.7e-08 $layer=M1 $thickness=3.6e-08
+ $X=0.243 $Y=0.036 $X2=0.243 $Y2=0.063
r14 12 14 4.64701 $w=1.46667e-08 $l=2.7e-08 $layer=M1 $thickness=3.6e-08
+ $X=0.243 $Y=0.036 $X2=0.216 $Y2=0.036
r15 40 41 5.24677 $w=1.3e-08 $l=2.25e-08 $layer=M1 $thickness=3.6e-08 $X=0.243
+ $Y=0.189 $X2=0.243 $Y2=0.2115
r16 38 39 8.39483 $w=1.3e-08 $l=3.6e-08 $layer=M1 $thickness=3.6e-08 $X=0.243
+ $Y=0.099 $X2=0.243 $Y2=0.063
r17 37 38 5.24677 $w=1.3e-08 $l=2.25e-08 $layer=M1 $thickness=3.6e-08 $X=0.243
+ $Y=0.1215 $X2=0.243 $Y2=0.099
r18 36 40 4.19742 $w=1.3e-08 $l=1.8e-08 $layer=M1 $thickness=3.6e-08 $X=0.243
+ $Y=0.171 $X2=0.243 $Y2=0.189
r19 35 36 4.19742 $w=1.3e-08 $l=1.8e-08 $layer=M1 $thickness=3.6e-08 $X=0.243
+ $Y=0.153 $X2=0.243 $Y2=0.171
r20 16 35 4.19742 $w=1.3e-08 $l=1.8e-08 $layer=M1 $thickness=3.6e-08 $X=0.243
+ $Y=0.135 $X2=0.243 $Y2=0.153
r21 16 37 3.14806 $w=1.3e-08 $l=1.35e-08 $layer=M1 $thickness=3.6e-08 $X=0.243
+ $Y=0.135 $X2=0.243 $Y2=0.1215
r22 33 34 18.8884 $w=1.3e-08 $l=8.1e-08 $layer=M2 $thickness=3.6e-08 $X=0.324
+ $Y=0.153 $X2=0.405 $Y2=0.153
r23 32 33 18.8884 $w=1.3e-08 $l=8.1e-08 $layer=M2 $thickness=3.6e-08 $X=0.243
+ $Y=0.153 $X2=0.324 $Y2=0.153
r24 32 35 19.5347 $a=3.24e-16 $layer=V1 $X=0.243 $Y=0.153 $X2=0.243 $Y2=0.153
r25 18 32 2.68168 $w=1.3e-08 $l=1.15e-08 $layer=M2 $thickness=3.6e-08 $X=0.2315
+ $Y=0.153 $X2=0.243 $Y2=0.153
r26 30 34 19.5347 $a=3.24e-16 $layer=V1 $X=0.405 $Y=0.153 $X2=0.405 $Y2=0.153
r27 29 30 2.2153 $w=1.3e-08 $l=9.5e-09 $layer=M1 $thickness=3.6e-08 $X=0.405
+ $Y=0.1435 $X2=0.405 $Y2=0.153
r28 28 29 2.2153 $w=1.3e-08 $l=9.5e-09 $layer=M1 $thickness=3.6e-08 $X=0.405
+ $Y=0.134 $X2=0.405 $Y2=0.1435
r29 17 28 4.31401 $w=1.3e-08 $l=1.85e-08 $layer=M1 $thickness=3.6e-08 $X=0.405
+ $Y=0.1155 $X2=0.405 $Y2=0.134
r30 1 23 9.2451 $w=1.7885e-08 $l=2e-09 $layer=LIG $thickness=5.24e-08 $X=0.405
+ $Y=0.132 $X2=0.405 $Y2=0.134
r31 1 28 19.3796 $a=3.24e-16 $layer=V0LIG $X=0.405 $Y=0.132 $X2=0.405 $Y2=0.134
r32 25 24 16.6668 $w=2.1e-08 $l=4.9e-08 $layer=Gate_1 $thickness=5.6e-08
+ $X=0.405 $Y=0.2295 $X2=0.405 $Y2=0.1805
r33 23 24 16.0035 $w=2.07634e-08 $l=4.65e-08 $layer=Gate_1 $thickness=5.6e-08
+ $X=0.405 $Y=0.134 $X2=0.405 $Y2=0.1805
r34 22 23 6.47963 $w=2.04054e-08 $l=1.85e-08 $layer=Gate_1 $thickness=5.6e-08
+ $X=0.405 $Y=0.1155 $X2=0.405 $Y2=0.134
r35 21 22 16.3266 $w=2.1e-08 $l=4.8e-08 $layer=Gate_1 $thickness=5.6e-08
+ $X=0.405 $Y=0.0675 $X2=0.405 $Y2=0.1155
r36 21 9 14.6259 $w=2.1e-08 $l=4.3e-08 $layer=Gate_1 $thickness=5.6e-08
+ $X=0.405 $Y=0.0675 $X2=0.405 $Y2=0.0245
.ends

.subckt PM_DHLx2_ASAP7_75t_R%7 vss 18 22 42 48 9 13 4 17 3 16 12 1 11 10 15
c1 1 vss 0.00266937f $X=0.513 $Y=0.082
c2 3 vss 0.00628804f $X=0.594 $Y=0.0405
c3 4 vss 0.00612835f $X=0.594 $Y=0.2295
c4 9 vss 0.0407258f $X=0.513 $Y=0.0245
c5 10 vss 0.0190049f $X=0.5795 $Y=0.0405
c6 11 vss 0.0187361f $X=0.5795 $Y=0.2295
c7 12 vss 0.00291575f $X=0.513 $Y=0.036
c8 13 vss 0.00642515f $X=0.621 $Y=0.234
c9 14 vss 0.00317675f $X=0.621 $Y=0.0315
c10 15 vss 0.00134862f $X=0.513 $Y=0.059
c11 16 vss 0.00823601f $X=0.5515 $Y=0.036
c12 17 vss 0.0071533f $X=0.621 $Y=0.0495
r1 11 4 0.462963 $w=2.7e-08 $l=1.25e-08 $layer=P_src_drn $thickness=1e-09
+ $X=0.5795 $Y=0.2295 $X2=0.594 $Y2=0.2295
r2 48 11 0.0925926 $w=2.7e-08 $l=2.5e-09 $layer=P_src_drn $thickness=1e-09
+ $X=0.5766 $Y=0.2295 $X2=0.5795 $Y2=0.2295
r3 4 44 19.3796 $a=3.24e-16 $layer=V0LISD $X=0.594 $Y=0.2295 $X2=0.594 $Y2=0.234
r4 44 45 3.14806 $w=1.3e-08 $l=1.35e-08 $layer=M1 $thickness=3.6e-08 $X=0.594
+ $Y=0.234 $X2=0.6075 $Y2=0.234
r5 13 40 1.96775 $w=1.63333e-08 $l=1.35e-08 $layer=M1 $thickness=3.6e-08
+ $X=0.621 $Y=0.234 $X2=0.621 $Y2=0.2205
r6 13 45 1.96775 $w=1.63333e-08 $l=1.35e-08 $layer=M1 $thickness=3.6e-08
+ $X=0.621 $Y=0.234 $X2=0.6075 $Y2=0.234
r7 10 3 0.462963 $w=2.7e-08 $l=1.25e-08 $layer=N_src_drn $thickness=1e-09
+ $X=0.5795 $Y=0.0405 $X2=0.594 $Y2=0.0405
r8 42 10 0.0925926 $w=2.7e-08 $l=2.5e-09 $layer=N_src_drn $thickness=1e-09
+ $X=0.5766 $Y=0.0405 $X2=0.5795 $Y2=0.0405
r9 39 40 2.09871 $w=1.3e-08 $l=9e-09 $layer=M1 $thickness=3.6e-08 $X=0.621
+ $Y=0.2115 $X2=0.621 $Y2=0.2205
r10 38 39 5.71315 $w=1.3e-08 $l=2.45e-08 $layer=M1 $thickness=3.6e-08 $X=0.621
+ $Y=0.187 $X2=0.621 $Y2=0.2115
r11 37 38 5.01358 $w=1.3e-08 $l=2.15e-08 $layer=M1 $thickness=3.6e-08 $X=0.621
+ $Y=0.1655 $X2=0.621 $Y2=0.187
r12 36 37 3.26466 $w=1.3e-08 $l=1.4e-08 $layer=M1 $thickness=3.6e-08 $X=0.621
+ $Y=0.1515 $X2=0.621 $Y2=0.1655
r13 35 36 5.01358 $w=1.3e-08 $l=2.15e-08 $layer=M1 $thickness=3.6e-08 $X=0.621
+ $Y=0.13 $X2=0.621 $Y2=0.1515
r14 34 35 5.01358 $w=1.3e-08 $l=2.15e-08 $layer=M1 $thickness=3.6e-08 $X=0.621
+ $Y=0.1085 $X2=0.621 $Y2=0.13
r15 33 34 3.61444 $w=1.3e-08 $l=1.55e-08 $layer=M1 $thickness=3.6e-08 $X=0.621
+ $Y=0.093 $X2=0.621 $Y2=0.1085
r16 32 33 4.89699 $w=1.3e-08 $l=2.1e-08 $layer=M1 $thickness=3.6e-08 $X=0.621
+ $Y=0.072 $X2=0.621 $Y2=0.093
r17 17 31 1.50855 $w=1.55e-08 $l=9e-09 $layer=M1 $thickness=3.6e-08 $X=0.621
+ $Y=0.0495 $X2=0.621 $Y2=0.0405
r18 17 32 5.24677 $w=1.3e-08 $l=2.25e-08 $layer=M1 $thickness=3.6e-08 $X=0.621
+ $Y=0.0495 $X2=0.621 $Y2=0.072
r19 3 29 19.3796 $a=3.24e-16 $layer=V0LISD $X=0.594 $Y=0.0405 $X2=0.594
+ $Y2=0.036
r20 14 30 1.50855 $w=1.55e-08 $l=1.42302e-08 $layer=M1 $thickness=3.6e-08
+ $X=0.621 $Y=0.0315 $X2=0.6075 $Y2=0.036
r21 14 31 0.9184 $w=1.8e-08 $l=9e-09 $layer=M1 $thickness=3.6e-08 $X=0.621
+ $Y=0.0315 $X2=0.621 $Y2=0.0405
r22 29 30 3.14806 $w=1.3e-08 $l=1.35e-08 $layer=M1 $thickness=3.6e-08 $X=0.594
+ $Y=0.036 $X2=0.6075 $Y2=0.036
r23 28 29 2.56509 $w=1.3e-08 $l=1.1e-08 $layer=M1 $thickness=3.6e-08 $X=0.583
+ $Y=0.036 $X2=0.594 $Y2=0.036
r24 16 28 7.34548 $w=1.3e-08 $l=3.15e-08 $layer=M1 $thickness=3.6e-08 $X=0.5515
+ $Y=0.036 $X2=0.583 $Y2=0.036
r25 12 15 3.71425 $w=1.68348e-08 $l=2.3e-08 $layer=M1 $thickness=3.6e-08
+ $X=0.513 $Y=0.036 $X2=0.513 $Y2=0.059
r26 12 16 7.32869 $w=1.41688e-08 $l=3.85e-08 $layer=M1 $thickness=3.6e-08
+ $X=0.513 $Y=0.036 $X2=0.5515 $Y2=0.036
r27 15 26 5.36336 $w=1.3e-08 $l=2.3e-08 $layer=M1 $thickness=3.6e-08 $X=0.513
+ $Y=0.059 $X2=0.513 $Y2=0.082
r28 1 20 6.54019 $w=2.09524e-08 $layer=Gate_1 $thickness=5.21905e-08 $X=0.513
+ $Y=0.082 $X2=0.513 $Y2=0.082
r29 1 26 19.3796 $a=3.24e-16 $layer=V0LIG $X=0.513 $Y=0.082 $X2=0.513 $Y2=0.082
r30 22 21 25.5104 $w=2.1e-08 $l=7.5e-08 $layer=Gate_1 $thickness=5.6e-08
+ $X=0.513 $Y=0.2295 $X2=0.513 $Y2=0.1545
r31 20 21 24.8471 $w=2.08483e-08 $l=7.25e-08 $layer=Gate_1 $thickness=5.6e-08
+ $X=0.513 $Y=0.082 $X2=0.513 $Y2=0.1545
r32 19 20 6.81977 $w=2.04359e-08 $l=1.95e-08 $layer=Gate_1 $thickness=5.6e-08
+ $X=0.513 $Y=0.0625 $X2=0.513 $Y2=0.082
r33 18 19 7.48304 $w=2.1e-08 $l=2.2e-08 $layer=Gate_1 $thickness=5.6e-08
+ $X=0.513 $Y=0.0405 $X2=0.513 $Y2=0.0625
r34 18 9 5.44221 $w=2.1e-08 $l=1.6e-08 $layer=Gate_1 $thickness=5.6e-08
+ $X=0.513 $Y=0.0405 $X2=0.513 $Y2=0.0245
.ends

.subckt PM_DHLx2_ASAP7_75t_R%8 vss 34 40 81 84 88 92 96 100 103 106 16 18 7 19
+ 25 22 17 1 26 27 8 30 23 13 24 21 2 28 20 29 3 15 14
c1 1 vss 0.00117539f $X=0.567 $Y=0.124
c2 2 vss 0.0046993f $X=0.729 $Y=0.136
c3 3 vss 0.00443426f $X=0.783 $Y=0.136
c4 7 vss 0.00584343f $X=0.378 $Y=0.2295
c5 8 vss 0.00479f $X=0.432 $Y=0.0405
c6 13 vss 0.0506371f $X=0.567 $Y=0.0245
c7 14 vss 0.0843297f $X=0.729 $Y=0.136
c8 15 vss 0.0838842f $X=0.783 $Y=0.136
c9 16 vss 0.0030341f $X=0.4175 $Y=0.0405
c10 17 vss 0.00162134f $X=0.4175 $Y=0.081
c11 18 vss 0.00319779f $X=0.3635 $Y=0.2295
c12 19 vss 0.0016851f $X=0.3635 $Y=0.189
c13 20 vss 0.00270059f $X=0.459 $Y=0.036
c14 21 vss 4.36827e-20 $X=0.459 $Y=0.13
c15 22 vss 0.00274848f $X=0.459 $Y=0.234
c16 23 vss 0.00744089f $X=0.432 $Y=0.234
c17 24 vss 0.00404649f $X=0.432 $Y=0.036
c18 25 vss 0.00128134f $X=0.459 $Y=0.1135
c19 26 vss 0.000679514f $X=0.459 $Y=0.1415
c20 27 vss 0.00100245f $X=0.54 $Y=0.13
c21 28 vss 0.00329408f $X=0.729 $Y=0.1085
c22 29 vss 0.00265174f $X=0.783 $Y=0.1085
c23 30 vss 0.0115523f $X=0.459 $Y=0.153
r1 19 7 0.231482 $w=5.4e-08 $l=1.25e-08 $layer=P_src_drn $thickness=1e-09
+ $X=0.3635 $Y=0.189 $X2=0.378 $Y2=0.2295
r2 106 105 0.0925926 $w=2.7e-08 $l=2.5e-09 $layer=P_src_drn $thickness=1e-09
+ $X=0.3953 $Y=0.2295 $X2=0.3925 $Y2=0.2295
r3 104 105 0.166667 $w=2.7e-08 $l=4.5e-09 $layer=P_src_drn $thickness=1e-09
+ $X=0.388 $Y=0.2295 $X2=0.3925 $Y2=0.2295
r4 7 104 0.444445 $w=2.7e-08 $l=1.2e-08 $layer=P_src_drn $thickness=1e-09
+ $X=0.378 $Y=0.2295 $X2=0.388 $Y2=0.2295
r5 18 7 0.462963 $w=2.7e-08 $l=1.25e-08 $layer=P_src_drn $thickness=1e-09
+ $X=0.3635 $Y=0.2295 $X2=0.378 $Y2=0.2295
r6 103 18 0.0925926 $w=2.7e-08 $l=2.5e-09 $layer=P_src_drn $thickness=1e-09
+ $X=0.3606 $Y=0.2025 $X2=0.3635 $Y2=0.2295
r7 100 99 14.6259 $w=2.1e-08 $l=4.3e-08 $layer=Gate_1 $thickness=5.6e-08
+ $X=0.783 $Y=0.2025 $X2=0.783 $Y2=0.1595
r8 98 99 2.55104 $w=2.1e-08 $l=7.5e-09 $layer=Gate_1 $thickness=5.6e-08
+ $X=0.783 $Y=0.152 $X2=0.783 $Y2=0.1595
r9 96 97 14.6259 $w=2.1e-08 $l=4.3e-08 $layer=Gate_1 $thickness=5.6e-08
+ $X=0.783 $Y=0.0675 $X2=0.783 $Y2=0.1105
r10 94 97 2.89117 $w=2.1e-08 $l=8.5e-09 $layer=Gate_1 $thickness=5.6e-08
+ $X=0.783 $Y=0.119 $X2=0.783 $Y2=0.1105
r11 15 94 5.96942 $w=2.03529e-08 $l=1.7e-08 $layer=Gate_1 $thickness=5.6e-08
+ $X=0.783 $Y=0.136 $X2=0.783 $Y2=0.119
r12 15 98 5.62929 $w=2.03125e-08 $l=1.6e-08 $layer=Gate_1 $thickness=5.6e-08
+ $X=0.783 $Y=0.136 $X2=0.783 $Y2=0.152
r13 92 91 14.6259 $w=2.1e-08 $l=4.3e-08 $layer=Gate_1 $thickness=5.6e-08
+ $X=0.729 $Y=0.2025 $X2=0.729 $Y2=0.1595
r14 90 91 2.55104 $w=2.1e-08 $l=7.5e-09 $layer=Gate_1 $thickness=5.6e-08
+ $X=0.729 $Y=0.152 $X2=0.729 $Y2=0.1595
r15 88 89 14.6259 $w=2.1e-08 $l=4.3e-08 $layer=Gate_1 $thickness=5.6e-08
+ $X=0.729 $Y=0.0675 $X2=0.729 $Y2=0.1105
r16 86 89 2.89117 $w=2.1e-08 $l=8.5e-09 $layer=Gate_1 $thickness=5.6e-08
+ $X=0.729 $Y=0.119 $X2=0.729 $Y2=0.1105
r17 14 86 5.96942 $w=2.03529e-08 $l=1.7e-08 $layer=Gate_1 $thickness=5.6e-08
+ $X=0.729 $Y=0.136 $X2=0.729 $Y2=0.119
r18 14 90 5.62929 $w=2.03125e-08 $l=1.6e-08 $layer=Gate_1 $thickness=5.6e-08
+ $X=0.729 $Y=0.136 $X2=0.729 $Y2=0.152
r19 17 72 0.231482 $w=5.4e-08 $l=1.25e-08 $layer=N_src_drn $thickness=1e-09
+ $X=0.4175 $Y=0.081 $X2=0.432 $Y2=0.081
r20 84 83 0.0925926 $w=2.7e-08 $l=2.5e-09 $layer=N_src_drn $thickness=1e-09
+ $X=0.4493 $Y=0.0405 $X2=0.4465 $Y2=0.0405
r21 82 83 0.166667 $w=2.7e-08 $l=4.5e-09 $layer=N_src_drn $thickness=1e-09
+ $X=0.442 $Y=0.0405 $X2=0.4465 $Y2=0.0405
r22 72 82 0.444445 $w=2.7e-08 $l=1.2e-08 $layer=N_src_drn $thickness=1e-09
+ $X=0.432 $Y=0.081 $X2=0.442 $Y2=0.0405
r23 16 72 0.462963 $w=2.7e-08 $l=1.25e-08 $layer=N_src_drn $thickness=1e-09
+ $X=0.4175 $Y=0.0405 $X2=0.432 $Y2=0.081
r24 81 16 0.0925926 $w=2.7e-08 $l=2.5e-09 $layer=N_src_drn $thickness=1e-09
+ $X=0.4146 $Y=0.0675 $X2=0.4175 $Y2=0.0405
r25 7 71 19.3796 $a=3.24e-16 $layer=V0LISD $X=0.378 $Y=0.2295 $X2=0.374
+ $Y2=0.234
r26 3 65 19.3796 $a=3.24e-16 $layer=V0LIG $X=0.783 $Y=0.136 $X2=0.783 $Y2=0.1445
r27 3 15 6.54019 $w=2.09524e-08 $layer=Gate_1 $thickness=5.21905e-08 $X=0.783
+ $Y=0.136 $X2=0.783 $Y2=0.136
r28 2 63 19.3796 $a=3.24e-16 $layer=V0LIG $X=0.729 $Y=0.136 $X2=0.729 $Y2=0.1445
r29 2 14 6.54019 $w=2.09524e-08 $layer=Gate_1 $thickness=5.21905e-08 $X=0.729
+ $Y=0.136 $X2=0.729 $Y2=0.136
r30 8 24 19.3796 $a=3.24e-16 $layer=V0LISD $X=0.432 $Y=0.0405 $X2=0.432
+ $Y2=0.036
r31 8 72 23.8708 $w=2.02e-08 $l=4.05e-08 $layer=LISD $thickness=2.7e-08
+ $X=0.432 $Y=0.0405 $X2=0.432 $Y2=0.081
r32 68 69 1.98211 $w=1.3e-08 $l=8.5e-09 $layer=M1 $thickness=3.6e-08 $X=0.383
+ $Y=0.234 $X2=0.3915 $Y2=0.234
r33 68 71 2.09871 $w=1.3e-08 $l=9e-09 $layer=M1 $thickness=3.6e-08 $X=0.383
+ $Y=0.234 $X2=0.374 $Y2=0.234
r34 67 69 3.14806 $w=1.3e-08 $l=1.35e-08 $layer=M1 $thickness=3.6e-08 $X=0.405
+ $Y=0.234 $X2=0.3915 $Y2=0.234
r35 23 67 6.29612 $w=1.3e-08 $l=2.7e-08 $layer=M1 $thickness=3.6e-08 $X=0.432
+ $Y=0.234 $X2=0.405 $Y2=0.234
r36 29 65 8.39483 $w=1.3e-08 $l=3.6e-08 $layer=M1 $thickness=3.6e-08 $X=0.783
+ $Y=0.1085 $X2=0.783 $Y2=0.1445
r37 28 63 8.39483 $w=1.3e-08 $l=3.6e-08 $layer=M1 $thickness=3.6e-08 $X=0.729
+ $Y=0.1085 $X2=0.729 $Y2=0.1445
r38 22 56 2.5483 $w=1.79e-08 $l=1.8e-08 $layer=M1 $thickness=3.6e-08 $X=0.459
+ $Y=0.234 $X2=0.459 $Y2=0.216
r39 22 23 4.64701 $w=1.46667e-08 $l=2.7e-08 $layer=M1 $thickness=3.6e-08
+ $X=0.459 $Y=0.234 $X2=0.432 $Y2=0.234
r40 61 65 19.5347 $a=3.24e-16 $layer=V1 $X=0.783 $Y=0.153 $X2=0.783 $Y2=0.1445
r41 60 61 6.29612 $w=1.3e-08 $l=2.7e-08 $layer=M2 $thickness=3.6e-08 $X=0.756
+ $Y=0.153 $X2=0.783 $Y2=0.153
r42 59 60 6.29612 $w=1.3e-08 $l=2.7e-08 $layer=M2 $thickness=3.6e-08 $X=0.729
+ $Y=0.153 $X2=0.756 $Y2=0.153
r43 59 63 19.5347 $a=3.24e-16 $layer=V1 $X=0.729 $Y=0.153 $X2=0.729 $Y2=0.1445
r44 58 59 24.6015 $w=1.3e-08 $l=1.055e-07 $layer=M2 $thickness=3.6e-08
+ $X=0.6235 $Y=0.153 $X2=0.729 $Y2=0.153
r45 57 58 29.3819 $w=1.3e-08 $l=1.26e-07 $layer=M2 $thickness=3.6e-08 $X=0.4975
+ $Y=0.153 $X2=0.6235 $Y2=0.153
r46 30 57 8.97781 $w=1.3e-08 $l=3.85e-08 $layer=M2 $thickness=3.6e-08 $X=0.459
+ $Y=0.153 $X2=0.4975 $Y2=0.153
r47 30 51 19.5347 $a=3.24e-16 $layer=V1 $X=0.459 $Y=0.153 $X2=0.459 $Y2=0.153
r48 20 50 6.39593 $w=1.55565e-08 $l=3.45e-08 $layer=M1 $thickness=3.6e-08
+ $X=0.459 $Y=0.036 $X2=0.459 $Y2=0.0705
r49 20 24 4.64701 $w=1.46667e-08 $l=2.7e-08 $layer=M1 $thickness=3.6e-08
+ $X=0.459 $Y=0.036 $X2=0.432 $Y2=0.036
r50 55 56 4.19742 $w=1.3e-08 $l=1.8e-08 $layer=M1 $thickness=3.6e-08 $X=0.459
+ $Y=0.198 $X2=0.459 $Y2=0.216
r51 54 55 4.19742 $w=1.3e-08 $l=1.8e-08 $layer=M1 $thickness=3.6e-08 $X=0.459
+ $Y=0.18 $X2=0.459 $Y2=0.198
r52 53 54 2.91487 $w=1.3e-08 $l=1.25e-08 $layer=M1 $thickness=3.6e-08 $X=0.459
+ $Y=0.1675 $X2=0.459 $Y2=0.18
r53 52 53 1.04935 $w=1.3e-08 $l=4.5e-09 $layer=M1 $thickness=3.6e-08 $X=0.459
+ $Y=0.163 $X2=0.459 $Y2=0.1675
r54 51 52 2.3319 $w=1.3e-08 $l=1e-08 $layer=M1 $thickness=3.6e-08 $X=0.459
+ $Y=0.153 $X2=0.459 $Y2=0.163
r55 26 51 2.68168 $w=1.3e-08 $l=1.15e-08 $layer=M1 $thickness=3.6e-08 $X=0.459
+ $Y=0.1415 $X2=0.459 $Y2=0.153
r56 49 50 7.11229 $w=1.3e-08 $l=3.05e-08 $layer=M1 $thickness=3.6e-08 $X=0.459
+ $Y=0.101 $X2=0.459 $Y2=0.0705
r57 25 49 2.91487 $w=1.3e-08 $l=1.25e-08 $layer=M1 $thickness=3.6e-08 $X=0.459
+ $Y=0.1135 $X2=0.459 $Y2=0.101
r58 21 47 5.11582 $w=1.46667e-08 $l=2.7e-08 $layer=M1 $thickness=3.6e-08
+ $X=0.459 $Y=0.13 $X2=0.486 $Y2=0.13
r59 21 25 2.66732 $w=1.57273e-08 $l=1.65e-08 $layer=M1 $thickness=3.6e-08
+ $X=0.459 $Y=0.13 $X2=0.459 $Y2=0.1135
r60 21 26 1.50137 $w=1.6913e-08 $l=1.15e-08 $layer=M1 $thickness=3.6e-08
+ $X=0.459 $Y=0.13 $X2=0.459 $Y2=0.1415
r61 46 47 6.29612 $w=1.3e-08 $l=2.7e-08 $layer=M1 $thickness=3.6e-08 $X=0.513
+ $Y=0.13 $X2=0.486 $Y2=0.13
r62 27 44 6.29612 $w=1.3e-08 $l=2.7e-08 $layer=M1 $thickness=3.6e-08 $X=0.54
+ $Y=0.13 $X2=0.567 $Y2=0.13
r63 27 46 6.29612 $w=1.3e-08 $l=2.7e-08 $layer=M1 $thickness=3.6e-08 $X=0.54
+ $Y=0.13 $X2=0.513 $Y2=0.13
r64 43 44 19.3796 $a=3.24e-16 $layer=V0LIG $X=0.567 $Y=0.133 $X2=0.567 $Y2=0.13
r65 1 37 4.51932 $w=1.96083e-08 $l=6e-09 $layer=Gate_1 $thickness=5.53333e-08
+ $X=0.567 $Y=0.124 $X2=0.567 $Y2=0.13
r66 1 42 1.77217 $w=1.53e-08 $l=3e-09 $layer=LIG $thickness=4.8e-08 $X=0.567
+ $Y=0.124 $X2=0.567 $Y2=0.121
r67 1 43 5.31651 $w=1.53e-08 $l=9e-09 $layer=LIG $thickness=4.8e-08 $X=0.567
+ $Y=0.124 $X2=0.567 $Y2=0.133
r68 40 39 14.6259 $w=2.1e-08 $l=4.3e-08 $layer=Gate_1 $thickness=5.6e-08
+ $X=0.567 $Y=0.2295 $X2=0.567 $Y2=0.1865
r69 38 39 12.7552 $w=2.1e-08 $l=3.75e-08 $layer=Gate_1 $thickness=5.6e-08
+ $X=0.567 $Y=0.149 $X2=0.567 $Y2=0.1865
r70 37 38 6.6497 $w=2.04211e-08 $l=1.9e-08 $layer=Gate_1 $thickness=5.6e-08
+ $X=0.567 $Y=0.13 $X2=0.567 $Y2=0.149
r71 37 42 5.11004 $w=1.92769e-08 $l=9e-09 $layer=Gate_1 $thickness=5.47692e-08
+ $X=0.567 $Y=0.13 $X2=0.567 $Y2=0.121
r72 36 37 4.94901 $w=2.02143e-08 $l=1.4e-08 $layer=Gate_1 $thickness=5.6e-08
+ $X=0.567 $Y=0.116 $X2=0.567 $Y2=0.13
r73 35 36 11.0545 $w=2.1e-08 $l=3.25e-08 $layer=Gate_1 $thickness=5.6e-08
+ $X=0.567 $Y=0.0835 $X2=0.567 $Y2=0.116
r74 34 35 14.6259 $w=2.1e-08 $l=4.3e-08 $layer=Gate_1 $thickness=5.6e-08
+ $X=0.567 $Y=0.0405 $X2=0.567 $Y2=0.0835
r75 34 13 5.44221 $w=2.1e-08 $l=1.6e-08 $layer=Gate_1 $thickness=5.6e-08
+ $X=0.567 $Y=0.0405 $X2=0.567 $Y2=0.0245
.ends

.subckt PM_DHLx2_ASAP7_75t_R%11 vss 7 12 4 1 5
c1 1 vss 0.0062588f $X=0.432 $Y=0.2295
c2 4 vss 0.0017618f $X=0.4175 $Y=0.2295
c3 5 vss 0.00215171f $X=0.488 $Y=0.2295
r1 12 11 0.0925926 $w=2.7e-08 $l=2.5e-09 $layer=P_src_drn $thickness=1e-09
+ $X=0.5033 $Y=0.2295 $X2=0.5005 $Y2=0.2295
r2 5 11 0.462963 $w=2.7e-08 $l=1.25e-08 $layer=P_src_drn $thickness=1e-09
+ $X=0.488 $Y=0.2295 $X2=0.5005 $Y2=0.2295
r3 9 5 9.64198 $w=2.32e-08 $l=2.05e-08 $layer=LISD $thickness=2.7e-08 $X=0.4655
+ $Y=0.2295 $X2=0.488 $Y2=0.2295
r4 8 9 7.05511 $w=2.32e-08 $l=1.5e-08 $layer=LISD $thickness=2.7e-08 $X=0.4505
+ $Y=0.2295 $X2=0.4655 $Y2=0.2295
r5 1 8 8.7013 $w=2.32e-08 $l=1.85e-08 $layer=LISD $thickness=2.7e-08 $X=0.432
+ $Y=0.2295 $X2=0.4505 $Y2=0.2295
r6 4 1 0.462963 $w=2.7e-08 $l=1.25e-08 $layer=P_src_drn $thickness=1e-09
+ $X=0.4175 $Y=0.2295 $X2=0.432 $Y2=0.2295
r7 7 4 0.0925926 $w=2.7e-08 $l=2.5e-09 $layer=P_src_drn $thickness=1e-09
+ $X=0.4146 $Y=0.2295 $X2=0.4175 $Y2=0.2295
.ends

.subckt PM_DHLx2_ASAP7_75t_R%13 vss 2 3 1
c1 1 vss 0.00076382f $X=0.324 $Y=0.2025
r1 2 1 0.209877 $w=8.1e-08 $l=1.7e-08 $layer=P_src_drn $thickness=1e-09
+ $X=0.3066 $Y=0.2025 $X2=0.324 $Y2=0.2025
r2 3 1 0.209877 $w=8.1e-08 $l=1.7e-08 $layer=P_src_drn $thickness=1e-09
+ $X=0.3413 $Y=0.2025 $X2=0.324 $Y2=0.2025
.ends

.subckt PM_DHLx2_ASAP7_75t_R%12 vss 2 3 1
c1 1 vss 0.000562229f $X=0.486 $Y=0.0405
r1 2 1 0.62963 $w=2.7e-08 $l=1.7e-08 $layer=N_src_drn $thickness=1e-09
+ $X=0.4686 $Y=0.0405 $X2=0.486 $Y2=0.0405
r2 3 1 0.62963 $w=2.7e-08 $l=1.7e-08 $layer=N_src_drn $thickness=1e-09
+ $X=0.5033 $Y=0.0405 $X2=0.486 $Y2=0.0405
.ends

* End of included file DHLx2_ASAP7_75t_R.pex.sp.pex

*
.subckt DHLx2_ASAP7_75t_CUSTOM_4_25_0_7 VSS VDD CLK D Q
*
* VSS VSS
* VDD VDD
* CLK CLK
* D D
* Q Q
*
*

M0 VSS N_M0_g N_M0_s VSS nmos_rvt L=2e-08 W=5.4e-08 nfin=2 $X=0.071 $Y=0.027
M1 N_M1_d N_M1_g VSS VSS nmos_rvt L=2e-08 W=5.4e-08 nfin=2 $X=0.125 $Y=0.027
M2 N_M2_d N_M2_g VSS VSS nmos_rvt L=2e-08 W=8.1e-08 nfin=3 $X=0.287 $Y=0.027
M3 N_M3_d N_M3_g N_M3_s VSS nmos_rvt L=2e-08 W=8.1e-08 nfin=3 $X=0.395 $Y=0.027
M4 N_M4_d N_M4_g N_M4_s VSS nmos_rvt L=2e-08 W=2.7e-08 nfin=1 $X=0.449 $Y=0.027
M5 VSS N_M5_g N_M5_s VSS nmos_rvt L=2e-08 W=2.7e-08 nfin=1 $X=0.503 $Y=0.027
M6 N_M6_d N_M6_g VSS VSS nmos_rvt L=2e-08 W=2.7e-08 nfin=1 $X=0.557 $Y=0.027
M7 N_M7_d N_M7_g VSS VSS nmos_rvt L=2e-08 W=8.1e-08 nfin=3 $X=0.719 $Y=0.027
M8 N_M8_d N_M8_g VSS VSS nmos_rvt L=2e-08 W=8.1e-08 nfin=3 $X=0.773 $Y=0.027
M9 VDD N_M9_g N_M9_s VDD pmos_rvt L=2e-08 W=5.4e-08 nfin=2 $X=0.071 $Y=0.189
M10 N_M10_d N_M10_g VDD VDD pmos_rvt L=2e-08 W=5.4e-08 nfin=2 $X=0.125 $Y=0.189
M11 N_M11_d N_M11_g VDD VDD pmos_rvt L=2e-08 W=8.1e-08 nfin=3 $X=0.287 $Y=0.162
M12 N_M12_d N_M12_g N_M12_s VDD pmos_rvt L=2e-08 W=8.1e-08 nfin=3 $X=0.341
+ $Y=0.162
M13 N_M13_d N_M13_g N_M13_s VDD pmos_rvt L=2e-08 W=2.7e-08 nfin=1 $X=0.395
+ $Y=0.216
M14 VDD N_M14_g N_M14_s VDD pmos_rvt L=2e-08 W=2.7e-08 nfin=1 $X=0.503 $Y=0.216
M15 N_M15_d N_M15_g VDD VDD pmos_rvt L=2e-08 W=2.7e-08 nfin=1 $X=0.557 $Y=0.216
M16 N_M16_d N_M16_g VDD VDD pmos_rvt L=2e-08 W=8.1e-08 nfin=3 $X=0.719 $Y=0.162
M17 N_M17_d N_M17_g VDD VDD pmos_rvt L=2e-08 W=8.1e-08 nfin=3 $X=0.773 $Y=0.162

* .include "DHLx2_ASAP7_75t_R.pex.sp.pxi"

* Start of included file DHLx2_ASAP7_75t_R.pex.sp.pxi
x_PM_DHLx2_ASAP7_75t_R%CLK vss CLK N_M0_g N_M9_g N_CLK_3 N_CLK_1 N_CLK_6
+ N_CLK_5 N_CLK_7 N_CLK_8 N_CLK_4 PM_DHLx2_ASAP7_75t_R%CLK
x_PM_DHLx2_ASAP7_75t_R%D vss D N_M2_g N_M11_g N_D_5 N_D_1 N_D_3 N_D_4
+ PM_DHLx2_ASAP7_75t_R%D
cc_1 N_D_5 N_4_23 9.51963e-20 $X=0.297 $Y=0.0755
cc_2 N_D_5 N_4_30 9.57057e-20 $X=0.297 $Y=0.0755
cc_3 N_D_5 N_4_24 0.000606855f $X=0.297 $Y=0.0755
cc_4 N_D_5 N_4_2 0.000833146f $X=0.297 $Y=0.0755
cc_5 N_D_5 N_4_33 0.000866247f $X=0.297 $Y=0.0755
cc_6 N_D_1 N_4_2 0.00134709f $X=0.297 $Y=0.1345
cc_7 N_D_3 N_4_15 0.00494765f $X=0.297 $Y=0.0245
cc_8 N_D_5 N_4_31 0.00516987f $X=0.297 $Y=0.0755
x_PM_DHLx2_ASAP7_75t_R%Q vss Q N_M7_d N_M8_d N_M16_d N_M17_d N_Q_7 N_Q_1 N_Q_8
+ N_Q_2 N_Q_13 PM_DHLx2_ASAP7_75t_R%Q
cc_9 N_Q_7 N_8_28 0.000577422f $X=0.7415 $Y=0.0675
cc_10 N_Q_7 N_8_2 0.00170108f $X=0.7415 $Y=0.0675
cc_11 N_Q_7 N_8_29 0.00290621f $X=0.7415 $Y=0.0675
cc_12 N_Q_7 N_8_3 0.000586107f $X=0.7415 $Y=0.0675
cc_13 N_Q_7 N_8_15 0.000839541f $X=0.7415 $Y=0.0675
cc_14 N_Q_7 N_8_30 0.00109446f $X=0.7415 $Y=0.0675
cc_15 N_Q_1 N_8_28 0.00136284f $X=0.756 $Y=0.0675
cc_16 N_Q_8 N_8_3 0.00143552f $X=0.7415 $Y=0.2025
cc_17 N_Q_2 N_8_15 0.00178019f $X=0.756 $Y=0.2025
cc_18 N_Q_1 N_8_15 0.00199191f $X=0.756 $Y=0.0675
cc_19 N_Q_13 N_8_29 0.00524071f $X=0.841 $Y=0.072
cc_20 N_Q_8 N_8_15 0.0659804f $X=0.7415 $Y=0.2025
cc_21 N_Q_7 N_8_14 0.0673935f $X=0.7415 $Y=0.0675
x_PM_DHLx2_ASAP7_75t_R%10 vss N_M2_d N_M3_s N_10_4 N_10_5 N_10_1
+ PM_DHLx2_ASAP7_75t_R%10
cc_22 N_10_4 N_4_2 0.00195015f $X=0.3095 $Y=0.0675
cc_23 N_10_4 N_4_31 0.000459665f $X=0.3095 $Y=0.0675
cc_24 N_10_4 N_4_15 0.0729317f $X=0.3095 $Y=0.0675
cc_25 N_10_4 N_D_3 0.0363805f $X=0.3095 $Y=0.0675
cc_26 N_10_5 N_6_1 0.000658054f $X=0.38 $Y=0.0675
cc_27 N_10_5 N_6_9 0.0347628f $X=0.38 $Y=0.0675
cc_28 N_10_1 N_8_8 0.00124688f $X=0.351 $Y=0.0675
cc_29 N_10_1 N_8_17 0.000609136f $X=0.351 $Y=0.0675
cc_30 N_10_1 N_8_16 0.00251422f $X=0.351 $Y=0.0675
x_PM_DHLx2_ASAP7_75t_R%4 vss N_M1_g N_M10_g N_M12_g N_M4_g N_M0_s N_M9_s N_4_20
+ N_4_22 N_4_7 N_4_6 N_4_23 N_4_18 N_4_17 N_4_30 N_4_1 N_4_28 N_4_25 N_4_33
+ N_4_27 N_4_29 N_4_14 N_4_24 N_4_2 N_4_15 N_4_31 N_4_3 N_4_16 N_4_8 N_4_32
+ PM_DHLx2_ASAP7_75t_R%4
cc_31 N_4_20 N_CLK_3 0.000194589f $X=0.0165 $Y=0.189
cc_32 N_4_22 N_CLK_3 0.000211358f $X=0.189 $Y=0.189
cc_33 N_4_7 N_CLK_3 0.00102899f $X=0.054 $Y=0.216
cc_34 N_4_6 N_CLK_3 0.00107588f $X=0.054 $Y=0.054
cc_35 N_4_23 N_CLK_3 0.000282182f $X=0.189 $Y=0.135
cc_36 N_4_18 N_CLK_3 0.0110371f $X=0.056 $Y=0.216
cc_37 N_4_17 N_CLK_3 0.0111039f $X=0.056 $Y=0.054
cc_38 N_4_30 N_CLK_3 0.000364378f $X=0.189 $Y=0.1485
cc_39 N_4_1 N_CLK_3 0.000553865f $X=0.134 $Y=0.135
cc_40 N_4_28 N_CLK_3 0.000589585f $X=0.036 $Y=0.234
cc_41 N_4_1 N_CLK_1 0.00360115f $X=0.134 $Y=0.135
cc_42 N_4_25 N_CLK_6 0.0010989f $X=0.018 $Y=0.1665
cc_43 N_4_22 N_CLK_5 0.00157299f $X=0.189 $Y=0.189
cc_44 N_4_33 N_CLK_5 0.00162478f $X=0.0215 $Y=0.189
cc_45 N_4_27 N_CLK_7 0.00185043f $X=0.036 $Y=0.036
cc_46 N_4_22 N_CLK_8 0.00225059f $X=0.189 $Y=0.189
cc_47 N_4_29 N_CLK_4 0.00267156f $X=0.1405 $Y=0.135
cc_48 N_4_20 N_CLK_5 0.00282939f $X=0.0165 $Y=0.189
cc_49 N_4_25 N_CLK_4 0.00293271f $X=0.018 $Y=0.1665
cc_50 N_4_14 N_CLK_3 0.035637f $X=0.135 $Y=0.0245
x_PM_DHLx2_ASAP7_75t_R%6 vss N_M3_g N_M13_g N_M1_d N_M10_d N_6_3 N_6_15 N_6_14
+ N_6_11 N_6_10 N_6_4 N_6_9 N_6_18 N_6_17 N_6_16 N_6_1 N_6_12
+ PM_DHLx2_ASAP7_75t_R%6
cc_51 N_6_3 N_CLK_7 0.000264236f $X=0.162 $Y=0.054
cc_52 N_6_15 N_CLK_7 0.00101638f $X=0.216 $Y=0.234
cc_53 N_6_14 N_CLK_7 0.00284989f $X=0.216 $Y=0.036
cc_54 N_6_11 N_4_7 5.51297e-20 $X=0.1475 $Y=0.216
cc_55 N_6_11 N_4_6 5.76364e-20 $X=0.1475 $Y=0.216
cc_56 N_6_11 N_4_25 0.000178671f $X=0.1475 $Y=0.216
cc_57 N_6_11 N_4_22 0.000254129f $X=0.1475 $Y=0.216
cc_58 N_6_15 N_4_22 0.00450665f $X=0.216 $Y=0.234
cc_59 N_6_10 N_4_14 0.0111222f $X=0.1475 $Y=0.054
cc_60 N_6_4 N_4_22 0.000401379f $X=0.162 $Y=0.216
cc_61 N_6_4 N_4_1 0.000408307f $X=0.162 $Y=0.216
cc_62 N_6_9 N_4_3 0.000495195f $X=0.405 $Y=0.0245
cc_63 N_6_18 N_4_24 0.000511976f $X=0.2315 $Y=0.153
cc_64 N_6_17 N_4_24 0.000533852f $X=0.405 $Y=0.1155
cc_65 N_6_16 N_4_29 0.00053794f $X=0.243 $Y=0.135
cc_66 N_6_14 N_4_23 0.000608637f $X=0.216 $Y=0.036
cc_67 N_6_17 N_4_33 0.000696941f $X=0.405 $Y=0.1155
cc_68 N_6_16 N_4_33 0.000725925f $X=0.243 $Y=0.135
cc_69 N_6_3 N_4_14 0.000796617f $X=0.162 $Y=0.054
cc_70 N_6_1 N_4_2 0.00240527f $X=0.405 $Y=0.132
cc_71 N_6_11 N_4_1 0.000932409f $X=0.1475 $Y=0.216
cc_72 N_6_16 N_4_30 0.000968826f $X=0.243 $Y=0.135
cc_73 N_6_4 N_4_14 0.00121251f $X=0.162 $Y=0.216
cc_74 N_6_9 N_4_15 0.00163008f $X=0.405 $Y=0.0245
cc_75 N_6_16 N_4_23 0.0035143f $X=0.243 $Y=0.135
cc_76 N_6_17 N_4_31 0.00365187f $X=0.405 $Y=0.1155
cc_77 N_6_9 N_4_16 0.00857408f $X=0.405 $Y=0.0245
cc_78 N_6_18 N_4_33 0.0169532f $X=0.2315 $Y=0.153
cc_79 N_6_11 N_4_14 0.0389363f $X=0.1475 $Y=0.216
cc_80 N_6_18 N_D_5 0.0010178f $X=0.2315 $Y=0.153
cc_81 N_6_12 N_D_4 0.00125974f $X=0.243 $Y=0.036
cc_82 N_6_16 N_D_5 0.00828018f $X=0.243 $Y=0.135
x_PM_DHLx2_ASAP7_75t_R%7 vss N_M5_g N_M14_g N_M6_d N_M15_d N_7_9 N_7_13 N_7_4
+ N_7_17 N_7_3 N_7_16 N_7_12 N_7_1 N_7_11 N_7_10 N_7_15 PM_DHLx2_ASAP7_75t_R%7
cc_83 N_7_9 N_4_3 0.000171771f $X=0.513 $Y=0.0245
cc_84 N_7_9 N_4_8 0.005455f $X=0.513 $Y=0.0245
cc_85 N_7_9 N_4_32 0.000335326f $X=0.513 $Y=0.0245
cc_86 N_7_13 N_4_8 0.000456596f $X=0.621 $Y=0.234
cc_87 N_7_4 N_4_8 0.000785152f $X=0.594 $Y=0.2295
cc_88 N_7_17 N_4_8 0.0013512f $X=0.621 $Y=0.0495
cc_89 N_7_9 N_4_16 0.0142525f $X=0.513 $Y=0.0245
x_PM_DHLx2_ASAP7_75t_R%8 vss N_M6_g N_M15_g N_M3_d N_M4_s N_M7_g N_M16_g N_M8_g
+ N_M17_g N_M12_d N_M13_s N_8_16 N_8_18 N_8_7 N_8_19 N_8_25 N_8_22 N_8_17 N_8_1
+ N_8_26 N_8_27 N_8_8 N_8_30 N_8_23 N_8_13 N_8_24 N_8_21 N_8_2 N_8_28 N_8_20
+ N_8_29 N_8_3 N_8_15 N_8_14 PM_DHLx2_ASAP7_75t_R%8
cc_90 N_8_16 N_4_32 0.000121492f $X=0.4175 $Y=0.0405
cc_91 N_8_16 N_4_24 0.000133481f $X=0.4175 $Y=0.0405
cc_92 N_8_18 N_4_15 0.010075f $X=0.3635 $Y=0.2295
cc_93 N_8_7 N_4_2 0.000235203f $X=0.378 $Y=0.2295
cc_94 N_8_19 N_4_15 0.0244272f $X=0.3635 $Y=0.189
cc_95 N_8_25 N_4_32 0.000270473f $X=0.459 $Y=0.1135
cc_96 N_8_7 N_4_24 0.000423785f $X=0.378 $Y=0.2295
cc_97 N_8_22 N_4_32 0.000433496f $X=0.459 $Y=0.234
cc_98 N_8_17 N_4_16 0.0055869f $X=0.4175 $Y=0.081
cc_99 N_8_7 N_4_31 0.000506244f $X=0.378 $Y=0.2295
cc_100 N_8_1 N_4_8 0.00163f $X=0.567 $Y=0.124
cc_101 N_8_26 N_4_33 0.000602899f $X=0.459 $Y=0.1415
cc_102 N_8_27 N_4_8 0.00063682f $X=0.54 $Y=0.13
cc_103 N_8_8 N_4_16 0.000657216f $X=0.432 $Y=0.0405
cc_104 N_8_18 N_4_2 0.000707287f $X=0.3635 $Y=0.2295
cc_105 N_8_30 N_4_32 0.00091456f $X=0.459 $Y=0.153
cc_106 N_8_26 N_4_3 0.00103352f $X=0.459 $Y=0.1415
cc_107 N_8_27 N_4_32 0.00160658f $X=0.54 $Y=0.13
cc_108 N_8_7 N_4_15 0.00184122f $X=0.378 $Y=0.2295
cc_109 N_8_23 N_4_24 0.00366862f $X=0.432 $Y=0.234
cc_110 N_8_30 N_4_33 0.00410935f $X=0.459 $Y=0.153
cc_111 N_8_26 N_4_32 0.00467625f $X=0.459 $Y=0.1415
cc_112 N_8_23 N_4_33 0.00515048f $X=0.432 $Y=0.234
cc_113 N_8_13 N_4_8 0.0063119f $X=0.567 $Y=0.0245
cc_114 N_8_16 N_4_16 0.0318991f $X=0.4175 $Y=0.0405
cc_115 N_8_18 N_6_9 0.0109695f $X=0.3635 $Y=0.2295
cc_116 N_8_23 N_6_9 0.000242595f $X=0.432 $Y=0.234
cc_117 N_8_24 N_6_17 0.000273138f $X=0.432 $Y=0.036
cc_118 N_8_19 N_6_9 0.00558983f $X=0.3635 $Y=0.189
cc_119 N_8_30 N_6_18 0.000638544f $X=0.459 $Y=0.153
cc_120 N_8_23 N_6_18 0.000758385f $X=0.432 $Y=0.234
cc_121 N_8_25 N_6_17 0.000763148f $X=0.459 $Y=0.1135
cc_122 N_8_8 N_6_1 0.000810369f $X=0.432 $Y=0.0405
cc_123 N_8_26 N_6_17 0.00212536f $X=0.459 $Y=0.1415
cc_124 N_8_7 N_6_9 0.00100719f $X=0.378 $Y=0.2295
cc_125 N_8_8 N_6_9 0.00105088f $X=0.432 $Y=0.0405
cc_126 N_8_16 N_6_1 0.0016639f $X=0.4175 $Y=0.0405
cc_127 N_8_21 N_6_17 0.00278134f $X=0.459 $Y=0.13
cc_128 N_8_16 N_6_9 0.00963153f $X=0.4175 $Y=0.0405
cc_129 N_8_17 N_6_9 0.0455579f $X=0.4175 $Y=0.081
cc_130 N_8_2 N_7_9 8.87084e-20 $X=0.729 $Y=0.136
cc_131 N_8_28 N_7_9 9.43936e-20 $X=0.729 $Y=0.1085
cc_132 N_8_27 N_7_9 0.000232521f $X=0.54 $Y=0.13
cc_133 N_8_8 N_7_9 0.000388919f $X=0.432 $Y=0.0405
cc_134 N_8_13 N_7_3 0.000418972f $X=0.567 $Y=0.0245
cc_135 N_8_28 N_7_17 0.000425043f $X=0.729 $Y=0.1085
cc_136 N_8_30 N_7_13 0.000491849f $X=0.459 $Y=0.153
cc_137 N_8_27 N_7_16 0.000626536f $X=0.54 $Y=0.13
cc_138 N_8_1 N_7_17 0.000812169f $X=0.567 $Y=0.124
cc_139 N_8_20 N_7_12 0.000859998f $X=0.459 $Y=0.036
cc_140 N_8_1 N_7_9 0.000943605f $X=0.567 $Y=0.124
cc_141 N_8_27 N_7_1 0.000984482f $X=0.54 $Y=0.13
cc_142 N_8_13 N_7_1 0.00106086f $X=0.567 $Y=0.0245
cc_143 N_8_13 N_7_11 0.00639423f $X=0.567 $Y=0.0245
cc_144 N_8_13 N_7_10 0.00655344f $X=0.567 $Y=0.0245
cc_145 N_8_30 N_7_17 0.00255289f $X=0.459 $Y=0.153
cc_146 N_8_27 N_7_15 0.0029186f $X=0.54 $Y=0.13
cc_147 N_8_25 N_7_15 0.00343826f $X=0.459 $Y=0.1135
cc_148 N_8_27 N_7_17 0.0039447f $X=0.54 $Y=0.13
cc_149 N_8_13 N_7_9 0.030771f $X=0.567 $Y=0.0245
x_PM_DHLx2_ASAP7_75t_R%11 vss N_M13_d N_M14_s N_11_4 N_11_1 N_11_5
+ PM_DHLx2_ASAP7_75t_R%11
cc_150 N_11_4 N_4_32 0.000137189f $X=0.4175 $Y=0.2295
cc_151 N_11_1 N_4_3 0.00100663f $X=0.432 $Y=0.2295
cc_152 N_11_5 N_4_8 0.00107295f $X=0.488 $Y=0.2295
cc_153 N_11_1 N_4_16 0.00204886f $X=0.432 $Y=0.2295
cc_154 N_11_5 N_4_16 0.00694687f $X=0.488 $Y=0.2295
cc_155 N_11_4 N_4_16 0.024127f $X=0.4175 $Y=0.2295
cc_156 N_11_4 N_6_9 0.0150254f $X=0.4175 $Y=0.2295
cc_157 N_11_5 N_7_9 0.0144589f $X=0.488 $Y=0.2295
cc_158 N_11_1 N_8_19 0.000295599f $X=0.432 $Y=0.2295
cc_159 N_11_1 N_8_26 0.000398966f $X=0.432 $Y=0.2295
cc_160 N_11_1 N_8_23 0.000423184f $X=0.432 $Y=0.2295
cc_161 N_11_4 N_8_7 0.000524261f $X=0.4175 $Y=0.2295
cc_162 N_11_1 N_8_22 0.00209589f $X=0.432 $Y=0.2295
x_PM_DHLx2_ASAP7_75t_R%13 vss N_M11_d N_M12_s N_13_1 PM_DHLx2_ASAP7_75t_R%13
cc_163 N_13_1 N_4_15 0.0168469f $X=0.324 $Y=0.2025
cc_164 N_13_1 N_D_3 0.0166722f $X=0.324 $Y=0.2025
x_PM_DHLx2_ASAP7_75t_R%12 vss N_M4_d N_M5_s N_12_1 PM_DHLx2_ASAP7_75t_R%12
cc_165 N_12_1 N_4_16 0.00757347f $X=0.486 $Y=0.0405
cc_166 N_12_1 N_7_9 0.00767407f $X=0.486 $Y=0.0405

* End of included file DHLx2_ASAP7_75t_R.pex.sp.pxi
.ends

.subckt PM_ICGx1_ASAP7_75t_R%GCLK vss 20 15 25 7 12 11 8 13
c1 1 vss 0.00834329f $X=0.918 $Y=0.0675
c2 2 vss 0.00819476f $X=0.918 $Y=0.2025
c3 7 vss 0.0380802f $X=0.9035 $Y=0.0675
c4 8 vss 0.0381006f $X=0.9035 $Y=0.2025
c5 9 vss 0.0027144f $X=0.945 $Y=0.036
c6 10 vss 0.00273764f $X=0.945 $Y=0.234
c7 11 vss 0.00571911f $X=0.9045 $Y=0.036
c8 12 vss 0.00358663f $X=0.918 $Y=0.234
c9 13 vss 0.00461402f $X=0.945 $Y=0.054
r1 8 2 0.154321 $w=8.1e-08 $l=1.25e-08 $layer=P_src_drn $thickness=1e-09
+ $X=0.9035 $Y=0.2025 $X2=0.918 $Y2=0.2025
r2 25 8 0.0308642 $w=8.1e-08 $l=2.5e-09 $layer=P_src_drn $thickness=1e-09
+ $X=0.9006 $Y=0.2025 $X2=0.9035 $Y2=0.2025
r3 2 12 19.3796 $a=3.24e-16 $layer=V0LISD $X=0.918 $Y=0.2025 $X2=0.918 $Y2=0.234
r4 10 22 2.6649 $w=1.77676e-08 $l=1.85e-08 $layer=M1 $thickness=3.6e-08
+ $X=0.945 $Y=0.234 $X2=0.945 $Y2=0.2155
r5 10 12 4.64701 $w=1.46667e-08 $l=2.7e-08 $layer=M1 $thickness=3.6e-08
+ $X=0.945 $Y=0.234 $X2=0.918 $Y2=0.234
r6 21 22 6.8208 $w=1.3e-08 $l=2.93e-08 $layer=M1 $thickness=3.6e-08 $X=0.945
+ $Y=0.1862 $X2=0.945 $Y2=0.2155
r7 20 21 4.72209 $w=1.3e-08 $l=2.02e-08 $layer=M1 $thickness=3.6e-08 $X=0.945
+ $Y=0.166 $X2=0.945 $Y2=0.1862
r8 20 19 12.0676 $w=1.3e-08 $l=5.18e-08 $layer=M1 $thickness=3.6e-08 $X=0.945
+ $Y=0.166 $X2=0.945 $Y2=0.1142
r9 13 19 14.0497 $w=1.3e-08 $l=6.02e-08 $layer=M1 $thickness=3.6e-08 $X=0.945
+ $Y=0.054 $X2=0.945 $Y2=0.1142
r10 9 17 1.49895 $w=1.63333e-08 $l=1.35e-08 $layer=M1 $thickness=3.6e-08
+ $X=0.945 $Y=0.036 $X2=0.9315 $Y2=0.036
r11 9 13 2.5483 $w=1.79e-08 $l=1.8e-08 $layer=M1 $thickness=3.6e-08 $X=0.945
+ $Y=0.036 $X2=0.945 $Y2=0.054
r12 16 17 3.14806 $w=1.3e-08 $l=1.35e-08 $layer=M1 $thickness=3.6e-08 $X=0.918
+ $Y=0.036 $X2=0.9315 $Y2=0.036
r13 11 16 3.14806 $w=1.3e-08 $l=1.35e-08 $layer=M1 $thickness=3.6e-08 $X=0.9045
+ $Y=0.036 $X2=0.918 $Y2=0.036
r14 1 16 19.3796 $a=3.24e-16 $layer=V0LISD $X=0.918 $Y=0.0675 $X2=0.918
+ $Y2=0.036
r15 7 1 0.154321 $w=8.1e-08 $l=1.25e-08 $layer=N_src_drn $thickness=1e-09
+ $X=0.9035 $Y=0.0675 $X2=0.918 $Y2=0.0675
r16 15 7 0.0308642 $w=8.1e-08 $l=2.5e-09 $layer=N_src_drn $thickness=1e-09
+ $X=0.9006 $Y=0.0675 $X2=0.9035 $Y2=0.0675
.ends

.subckt PM_ICGx1_ASAP7_75t_R%SE vss 13 5 9 3 4 1
c1 1 vss 0.00405714f $X=0.135 $Y=0.135
c2 3 vss 0.0941565f $X=0.135 $Y=0.0245
c3 4 vss 0.00326927f $X=0.135 $Y=0.0972
r1 14 15 2.3902 $w=1.3e-08 $l=1.03e-08 $layer=M1 $thickness=3.6e-08 $X=0.135
+ $Y=0.1267 $X2=0.135 $Y2=0.137
r2 13 14 0.408082 $w=1.3e-08 $l=1.7e-09 $layer=M1 $thickness=3.6e-08 $X=0.135
+ $Y=0.125 $X2=0.135 $Y2=0.1267
r3 13 4 6.47102 $w=1.3e-08 $l=2.78e-08 $layer=M1 $thickness=3.6e-08 $X=0.135
+ $Y=0.125 $X2=0.135 $Y2=0.0972
r4 1 7 6.54019 $w=2.09524e-08 $layer=Gate_1 $thickness=5.21905e-08 $X=0.135
+ $Y=0.135 $X2=0.135 $Y2=0.135
r5 1 15 19.3796 $a=3.24e-16 $layer=V0LIG $X=0.135 $Y=0.135 $X2=0.135 $Y2=0.137
r6 9 8 16.4967 $w=2.1e-08 $l=4.85e-08 $layer=Gate_1 $thickness=5.6e-08 $X=0.135
+ $Y=0.216 $X2=0.135 $Y2=0.1675
r7 7 8 11.2416 $w=2.06615e-08 $l=3.25e-08 $layer=Gate_1 $thickness=5.6e-08
+ $X=0.135 $Y=0.135 $X2=0.135 $Y2=0.1675
r8 6 7 11.2416 $w=2.06615e-08 $l=3.25e-08 $layer=Gate_1 $thickness=5.6e-08
+ $X=0.135 $Y=0.1025 $X2=0.135 $Y2=0.135
r9 5 6 16.4967 $w=2.1e-08 $l=4.85e-08 $layer=Gate_1 $thickness=5.6e-08 $X=0.135
+ $Y=0.054 $X2=0.135 $Y2=0.1025
r10 5 3 10.0341 $w=2.1e-08 $l=2.95e-08 $layer=Gate_1 $thickness=5.6e-08
+ $X=0.135 $Y=0.054 $X2=0.135 $Y2=0.0245
.ends

.subckt PM_ICGx1_ASAP7_75t_R%18 vss 2 3 1
c1 1 vss 0.00667596f $X=0.108 $Y=0.216
r1 2 1 0.314815 $w=5.4e-08 $l=1.7e-08 $layer=P_src_drn $thickness=1e-09
+ $X=0.0906 $Y=0.216 $X2=0.108 $Y2=0.216
r2 3 1 0.314815 $w=5.4e-08 $l=1.7e-08 $layer=P_src_drn $thickness=1e-09
+ $X=0.1253 $Y=0.216 $X2=0.108 $Y2=0.216
.ends

.subckt PM_ICGx1_ASAP7_75t_R%CLK vss 60 27 31 41 44 75 79 93 98 23 1 10 19 17
+ 15 20 16 8 12 21 2 3 11 22 18 4 14 13
c1 1 vss 0.00051476f $X=0.243 $Y=0.1335
c2 2 vss 0.000209731f $X=0.352 $Y=0.1335
c3 3 vss 0.00578893f $X=0.621 $Y=0.135
c4 4 vss 0.00557903f $X=0.783 $Y=0.162
c5 8 vss 0.00219168f $X=0.393 $Y=0.1335
c6 10 vss 0.00738017f $X=0.243 $Y=0.1335
c7 11 vss 0.00615171f $X=0.351 $Y=0.1335
c8 12 vss 0.0974743f $X=0.621 $Y=0.135
c9 13 vss 0.0346956f $X=0.729 $Y=0.162
c10 14 vss 0.0346392f $X=0.783 $Y=0.0245
c11 15 vss 0.000510964f $X=0.405 $Y=0.153
c12 16 vss 0.000833389f $X=0.423 $Y=0.153
c13 17 vss 0.000716531f $X=0.621 $Y=0.187
c14 18 vss 0.000631349f $X=0.756 $Y=0.183
c15 19 vss 0.00359834f $X=0.243 $Y=0.1215
c16 20 vss 0.0019342f $X=0.621 $Y=0.1545
c17 21 vss 0.00561215f $X=0.7175 $Y=0.187
c18 22 vss 0.00152279f $X=0.756 $Y=0.1445
c19 23 vss 0.0381097f $X=0.597 $Y=0.153
r1 98 99 16.3266 $w=2.1e-08 $l=4.8e-08 $layer=Gate_1 $thickness=5.6e-08
+ $X=0.351 $Y=0.0405 $X2=0.351 $Y2=0.0885
r2 11 95 3.75002 $w=2e-08 $layer=Gate_1 $thickness=5.6e-08 $X=0.351 $Y=0.1335
+ $X2=0.351 $Y2=0.1335
r3 11 99 15.4848 $w=2.07667e-08 $l=4.5e-08 $layer=Gate_1 $thickness=5.6e-08
+ $X=0.351 $Y=0.1335 $X2=0.351 $Y2=0.0885
r4 2 90 3.16825 $w=2.1e-08 $l=3.5e-09 $layer=LIG $thickness=4.8e-08 $X=0.352
+ $Y=0.1335 $X2=0.3555 $Y2=0.1335
r5 2 95 3.16825 $w=2.1e-08 $l=1e-09 $layer=LIG $thickness=4.8e-08 $X=0.352
+ $Y=0.1335 $X2=0.351 $Y2=0.1335
r6 93 92 16.8368 $w=2.1e-08 $l=4.95e-08 $layer=Gate_1 $thickness=5.6e-08
+ $X=0.243 $Y=0.2025 $X2=0.243 $Y2=0.153
r7 10 92 6.81127 $w=2.04615e-08 $l=1.95e-08 $layer=Gate_1 $thickness=5.6e-08
+ $X=0.243 $Y=0.1335 $X2=0.243 $Y2=0.153
r8 89 90 4.91375 $w=2.12e-08 $l=1.5e-09 $layer=LISD $thickness=2.7e-08 $X=0.357
+ $Y=0.1335 $X2=0.3555 $Y2=0.1335
r9 88 89 11.4654 $w=2.12e-08 $l=2.1e-08 $layer=LISD $thickness=2.7e-08 $X=0.378
+ $Y=0.1335 $X2=0.357 $Y2=0.1335
r10 8 86 6.55166 $w=2.12e-08 $l=1.2e-08 $layer=LISD $thickness=2.7e-08 $X=0.393
+ $Y=0.1335 $X2=0.405 $Y2=0.1335
r11 8 88 8.18958 $w=2.12e-08 $l=1.5e-08 $layer=LISD $thickness=2.7e-08 $X=0.393
+ $Y=0.1335 $X2=0.378 $Y2=0.1335
r12 1 68 19.3796 $a=3.24e-16 $layer=V0LIG $X=0.243 $Y=0.1335 $X2=0.243 $Y2=0.133
r13 1 10 6.63025 $w=2.04878e-08 $layer=Gate_1 $thickness=5.20976e-08 $X=0.243
+ $Y=0.1335 $X2=0.243 $Y2=0.1335
r14 82 83 2.2153 $w=1.3e-08 $l=9.5e-09 $layer=M1 $thickness=3.6e-08 $X=0.405
+ $Y=0.134 $X2=0.405 $Y2=0.1435
r15 82 86 19.3796 $a=3.24e-16 $layer=V0LISD $X=0.405 $Y=0.134 $X2=0.405
+ $Y2=0.1335
r16 15 16 3.01711 $w=1.55e-08 $l=1.8e-08 $layer=M1 $thickness=3.6e-08 $X=0.405
+ $Y=0.153 $X2=0.423 $Y2=0.153
r17 15 83 1.03499 $w=1.77368e-08 $l=9.5e-09 $layer=M1 $thickness=3.6e-08
+ $X=0.405 $Y=0.153 $X2=0.405 $Y2=0.1435
r18 79 78 14.6259 $w=2.1e-08 $l=4.3e-08 $layer=Gate_1 $thickness=5.6e-08
+ $X=0.621 $Y=0.2025 $X2=0.621 $Y2=0.1595
r19 77 78 2.7211 $w=2.1e-08 $l=8e-09 $layer=Gate_1 $thickness=5.6e-08 $X=0.621
+ $Y=0.1515 $X2=0.621 $Y2=0.1595
r20 75 76 14.6259 $w=2.1e-08 $l=4.3e-08 $layer=Gate_1 $thickness=5.6e-08
+ $X=0.621 $Y=0.0675 $X2=0.621 $Y2=0.1105
r21 73 76 2.7211 $w=2.1e-08 $l=8e-09 $layer=Gate_1 $thickness=5.6e-08 $X=0.621
+ $Y=0.1185 $X2=0.621 $Y2=0.1105
r22 12 73 5.79936 $w=2.03333e-08 $l=1.65e-08 $layer=Gate_1 $thickness=5.6e-08
+ $X=0.621 $Y=0.135 $X2=0.621 $Y2=0.1185
r23 12 77 5.79936 $w=2.03333e-08 $l=1.65e-08 $layer=Gate_1 $thickness=5.6e-08
+ $X=0.621 $Y=0.135 $X2=0.621 $Y2=0.1515
r24 69 70 2.3319 $w=1.3e-08 $l=1e-08 $layer=M1 $thickness=3.6e-08 $X=0.243
+ $Y=0.143 $X2=0.243 $Y2=0.153
r25 68 69 2.3319 $w=1.3e-08 $l=1e-08 $layer=M1 $thickness=3.6e-08 $X=0.243
+ $Y=0.133 $X2=0.243 $Y2=0.143
r26 19 68 2.68168 $w=1.3e-08 $l=1.15e-08 $layer=M1 $thickness=3.6e-08 $X=0.243
+ $Y=0.1215 $X2=0.243 $Y2=0.133
r27 16 58 19.5347 $a=3.24e-16 $layer=V1 $X=0.423 $Y=0.153 $X2=0.423 $Y2=0.153
r28 3 52 19.3796 $a=3.24e-16 $layer=V0LIG $X=0.621 $Y=0.135 $X2=0.621 $Y2=0.133
r29 3 12 6.54019 $w=2.09524e-08 $layer=Gate_1 $thickness=5.21905e-08 $X=0.621
+ $Y=0.135 $X2=0.621 $Y2=0.135
r30 63 64 7.22888 $w=1.3e-08 $l=3.1e-08 $layer=M2 $thickness=3.6e-08 $X=0.243
+ $Y=0.153 $X2=0.274 $Y2=0.153
r31 63 70 19.5347 $a=3.24e-16 $layer=V1 $X=0.243 $Y=0.153 $X2=0.243 $Y2=0.153
r32 60 61 1.10765 $w=1.3e-08 $l=4.7e-09 $layer=M2 $thickness=3.6e-08 $X=0.573
+ $Y=0.154 $X2=0.5777 $Y2=0.153
r33 60 59 16.4982 $w=1.3e-08 $l=7.08e-08 $layer=M2 $thickness=3.6e-08 $X=0.573
+ $Y=0.154 $X2=0.5022 $Y2=0.153
r34 58 59 18.4803 $w=1.3e-08 $l=7.92e-08 $layer=M2 $thickness=3.6e-08 $X=0.423
+ $Y=0.153 $X2=0.5022 $Y2=0.153
r35 57 58 15.8569 $w=1.3e-08 $l=6.8e-08 $layer=M2 $thickness=3.6e-08 $X=0.355
+ $Y=0.153 $X2=0.423 $Y2=0.153
r36 57 64 18.8884 $w=1.3e-08 $l=8.1e-08 $layer=M2 $thickness=3.6e-08 $X=0.355
+ $Y=0.153 $X2=0.274 $Y2=0.153
r37 23 55 5.59655 $w=1.3e-08 $l=2.4e-08 $layer=M2 $thickness=3.6e-08 $X=0.597
+ $Y=0.153 $X2=0.621 $Y2=0.153
r38 23 61 4.4889 $w=1.3e-08 $l=1.93e-08 $layer=M2 $thickness=3.6e-08 $X=0.597
+ $Y=0.153 $X2=0.5777 $Y2=0.153
r39 53 54 0.582974 $w=1.3e-08 $l=2.5e-09 $layer=M1 $thickness=3.6e-08 $X=0.621
+ $Y=0.143 $X2=0.621 $Y2=0.1455
r40 52 53 2.3319 $w=1.3e-08 $l=1e-08 $layer=M1 $thickness=3.6e-08 $X=0.621
+ $Y=0.133 $X2=0.621 $Y2=0.143
r41 20 50 3.61444 $w=1.3e-08 $l=1.55e-08 $layer=M1 $thickness=3.6e-08 $X=0.621
+ $Y=0.1545 $X2=0.621 $Y2=0.17
r42 20 54 2.09871 $w=1.3e-08 $l=9e-09 $layer=M1 $thickness=3.6e-08 $X=0.621
+ $Y=0.1545 $X2=0.621 $Y2=0.1455
r43 20 55 19.5347 $a=3.24e-16 $layer=V1 $X=0.621 $Y=0.1545 $X2=0.621 $Y2=0.153
r44 17 49 4.64701 $w=1.46667e-08 $l=2.7e-08 $layer=M1 $thickness=3.6e-08
+ $X=0.621 $Y=0.187 $X2=0.648 $Y2=0.187
r45 17 50 2.31511 $w=1.81882e-08 $l=1.7e-08 $layer=M1 $thickness=3.6e-08
+ $X=0.621 $Y=0.187 $X2=0.621 $Y2=0.17
r46 48 49 6.29612 $w=1.3e-08 $l=2.7e-08 $layer=M1 $thickness=3.6e-08 $X=0.675
+ $Y=0.187 $X2=0.648 $Y2=0.187
r47 47 48 2.56509 $w=1.3e-08 $l=1.1e-08 $layer=M1 $thickness=3.6e-08 $X=0.686
+ $Y=0.187 $X2=0.675 $Y2=0.187
r48 21 47 7.34548 $w=1.3e-08 $l=3.15e-08 $layer=M1 $thickness=3.6e-08 $X=0.7175
+ $Y=0.187 $X2=0.686 $Y2=0.187
r49 18 39 1.32639 $w=1.59412e-08 $l=8.5e-09 $layer=M1 $thickness=3.6e-08
+ $X=0.756 $Y=0.183 $X2=0.756 $Y2=0.1745
r50 18 21 7.38932 $w=1.37246e-08 $l=3.87072e-08 $layer=M1 $thickness=3.6e-08
+ $X=0.756 $Y=0.183 $X2=0.7175 $Y2=0.187
r51 44 43 11.9048 $w=2.1e-08 $l=3.5e-08 $layer=Gate_1 $thickness=5.6e-08
+ $X=0.729 $Y=0.216 $X2=0.729 $Y2=0.181
r52 41 42 21.0886 $w=2.1e-08 $l=6.2e-08 $layer=Gate_1 $thickness=5.6e-08
+ $X=0.729 $Y=0.0675 $X2=0.729 $Y2=0.1295
r53 13 34 6.54019 $w=2.09524e-08 $layer=Gate_1 $thickness=5.21905e-08 $X=0.729
+ $Y=0.162 $X2=0.729 $Y2=0.162
r54 13 42 11.2416 $w=2.06615e-08 $l=3.25e-08 $layer=Gate_1 $thickness=5.6e-08
+ $X=0.729 $Y=0.162 $X2=0.729 $Y2=0.1295
r55 13 43 6.6497 $w=2.04211e-08 $l=1.9e-08 $layer=Gate_1 $thickness=5.6e-08
+ $X=0.729 $Y=0.162 $X2=0.729 $Y2=0.181
r56 38 39 2.91487 $w=1.3e-08 $l=1.25e-08 $layer=M1 $thickness=3.6e-08 $X=0.756
+ $Y=0.162 $X2=0.756 $Y2=0.1745
r57 37 38 2.79828 $w=1.3e-08 $l=1.2e-08 $layer=M1 $thickness=3.6e-08 $X=0.756
+ $Y=0.15 $X2=0.756 $Y2=0.162
r58 22 37 1.28254 $w=1.3e-08 $l=5.5e-09 $layer=M1 $thickness=3.6e-08 $X=0.756
+ $Y=0.1445 $X2=0.756 $Y2=0.15
r59 33 34 12.6539 $w=1.77815e-08 $l=2.7e-08 $layer=LIG $thickness=4.8e-08
+ $X=0.756 $Y=0.162 $X2=0.729 $Y2=0.162
r60 33 38 19.3796 $a=3.24e-16 $layer=V0LIG $X=0.756 $Y=0.162 $X2=0.756 $Y2=0.162
r61 4 29 6.54019 $w=2.09524e-08 $layer=Gate_1 $thickness=5.21905e-08 $X=0.783
+ $Y=0.162 $X2=0.783 $Y2=0.162
r62 4 33 12.6539 $w=1.77815e-08 $l=2.7e-08 $layer=LIG $thickness=4.8e-08
+ $X=0.783 $Y=0.162 $X2=0.756 $Y2=0.162
r63 31 30 11.9048 $w=2.1e-08 $l=3.5e-08 $layer=Gate_1 $thickness=5.6e-08
+ $X=0.783 $Y=0.216 $X2=0.783 $Y2=0.181
r64 29 30 6.6497 $w=2.04211e-08 $l=1.9e-08 $layer=Gate_1 $thickness=5.6e-08
+ $X=0.783 $Y=0.162 $X2=0.783 $Y2=0.181
r65 28 29 11.2416 $w=2.06615e-08 $l=3.25e-08 $layer=Gate_1 $thickness=5.6e-08
+ $X=0.783 $Y=0.1295 $X2=0.783 $Y2=0.162
r66 27 28 21.0886 $w=2.1e-08 $l=6.2e-08 $layer=Gate_1 $thickness=5.6e-08
+ $X=0.783 $Y=0.0675 $X2=0.783 $Y2=0.1295
r67 27 14 14.6259 $w=2.1e-08 $l=4.3e-08 $layer=Gate_1 $thickness=5.6e-08
+ $X=0.783 $Y=0.0675 $X2=0.783 $Y2=0.0245
.ends

.subckt PM_ICGx1_ASAP7_75t_R%7 vss 20 24 53 55 11 15 3 16 17 1 10 14 12 13 4 9
c1 1 vss 0.000374122f $X=0.297 $Y=0.1335
c2 3 vss 0.00674253f $X=0.594 $Y=0.0605
c3 4 vss 0.00837971f $X=0.594 $Y=0.2295
c4 9 vss 0.00769065f $X=0.297 $Y=0.0245
c5 10 vss 0.0454493f $X=0.596 $Y=0.0675
c6 11 vss 0.0453231f $X=0.596 $Y=0.2025
c7 12 vss 0.000742285f $X=0.2945 $Y=0.189
c8 13 vss 0.00136985f $X=0.568 $Y=0.086
c9 14 vss 0.00593421f $X=0.568 $Y=0.232
c10 15 vss 0.00284947f $X=0.297 $Y=0.0955
c11 16 vss 0.00190625f $X=0.568 $Y=0.148
c12 17 vss 0.0152413f $X=0.2985 $Y=0.189
r1 55 54 0.0308642 $w=8.1e-08 $l=2.5e-09 $layer=P_src_drn $thickness=1e-09
+ $X=0.6113 $Y=0.2025 $X2=0.6085 $Y2=0.2025
r2 11 54 0.154321 $w=8.1e-08 $l=1.25e-08 $layer=P_src_drn $thickness=1e-09
+ $X=0.596 $Y=0.2025 $X2=0.6085 $Y2=0.2025
r3 53 52 0.0308642 $w=8.1e-08 $l=2.5e-09 $layer=N_src_drn $thickness=1e-09
+ $X=0.6113 $Y=0.0675 $X2=0.6085 $Y2=0.0675
r4 10 52 0.154321 $w=8.1e-08 $l=1.25e-08 $layer=N_src_drn $thickness=1e-09
+ $X=0.596 $Y=0.0675 $X2=0.6085 $Y2=0.0675
r5 4 48 19.3796 $a=3.24e-16 $layer=V0LISD $X=0.594 $Y=0.2295 $X2=0.594 $Y2=0.232
r6 4 11 23.8708 $w=2.02e-08 $l=4.05e-08 $layer=LISD $thickness=2.7e-08 $X=0.594
+ $Y=0.2295 $X2=0.596 $Y2=0.2025
r7 3 45 19.3796 $a=3.24e-16 $layer=V0LISD $X=0.594 $Y=0.0605 $X2=0.594 $Y2=0.086
r8 47 48 3.03147 $w=1.3e-08 $l=1.3e-08 $layer=M1 $thickness=3.6e-08 $X=0.581
+ $Y=0.232 $X2=0.594 $Y2=0.232
r9 14 43 1.03499 $w=1.77368e-08 $l=9.5e-09 $layer=M1 $thickness=3.6e-08
+ $X=0.568 $Y=0.232 $X2=0.568 $Y2=0.2225
r10 14 47 1.85116 $w=1.64615e-08 $l=1.3e-08 $layer=M1 $thickness=3.6e-08
+ $X=0.568 $Y=0.232 $X2=0.581 $Y2=0.232
r11 44 45 3.03147 $w=1.3e-08 $l=1.3e-08 $layer=M1 $thickness=3.6e-08 $X=0.581
+ $Y=0.086 $X2=0.594 $Y2=0.086
r12 13 40 3.36689 $w=1.53077e-08 $l=1.95e-08 $layer=M1 $thickness=3.6e-08
+ $X=0.568 $Y=0.086 $X2=0.568 $Y2=0.1055
r13 13 44 1.85116 $w=1.64615e-08 $l=1.3e-08 $layer=M1 $thickness=3.6e-08
+ $X=0.568 $Y=0.086 $X2=0.581 $Y2=0.086
r14 42 43 2.91487 $w=1.3e-08 $l=1.25e-08 $layer=M1 $thickness=3.6e-08 $X=0.568
+ $Y=0.21 $X2=0.568 $Y2=0.2225
r15 41 42 3.03147 $w=1.3e-08 $l=1.3e-08 $layer=M1 $thickness=3.6e-08 $X=0.568
+ $Y=0.197 $X2=0.568 $Y2=0.21
r16 39 41 2.09871 $w=1.3e-08 $l=9e-09 $layer=M1 $thickness=3.6e-08 $X=0.568
+ $Y=0.188 $X2=0.568 $Y2=0.197
r17 16 39 9.32759 $w=1.3e-08 $l=4e-08 $layer=M1 $thickness=3.6e-08 $X=0.568
+ $Y=0.148 $X2=0.568 $Y2=0.188
r18 16 40 9.91056 $w=1.3e-08 $l=4.25e-08 $layer=M1 $thickness=3.6e-08 $X=0.568
+ $Y=0.148 $X2=0.568 $Y2=0.1055
r19 37 39 19.5347 $a=3.24e-16 $layer=V1 $X=0.568 $Y=0.189 $X2=0.568 $Y2=0.188
r20 36 37 30.0815 $w=1.3e-08 $l=1.29e-07 $layer=M2 $thickness=3.6e-08 $X=0.439
+ $Y=0.189 $X2=0.568 $Y2=0.189
r21 35 36 30.0815 $w=1.3e-08 $l=1.29e-07 $layer=M2 $thickness=3.6e-08 $X=0.31
+ $Y=0.189 $X2=0.439 $Y2=0.189
r22 17 35 2.68168 $w=1.3e-08 $l=1.15e-08 $layer=M2 $thickness=3.6e-08 $X=0.2985
+ $Y=0.189 $X2=0.31 $Y2=0.189
r23 33 35 19.5347 $a=3.24e-16 $layer=V1 $X=0.3145 $Y=0.189 $X2=0.31 $Y2=0.189
r24 32 33 1.51573 $w=1.3e-08 $l=6.5e-09 $layer=M1 $thickness=3.6e-08 $X=0.308
+ $Y=0.189 $X2=0.3145 $Y2=0.189
r25 31 32 0.721491 $w=1.57778e-08 $l=4.5e-09 $layer=M1 $thickness=3.6e-08
+ $X=0.3035 $Y=0.189 $X2=0.308 $Y2=0.189
r26 12 31 0.9184 $w=1.8e-08 $l=9e-09 $layer=M1 $thickness=3.6e-08 $X=0.2945
+ $Y=0.189 $X2=0.3035 $Y2=0.189
r27 30 31 4.68572 $w=1.35814e-08 $l=2.87446e-08 $layer=M1 $thickness=3.6e-08
+ $X=0.297 $Y=0.161 $X2=0.3035 $Y2=0.189
r28 29 30 6.52931 $w=1.3e-08 $l=2.8e-08 $layer=M1 $thickness=3.6e-08 $X=0.297
+ $Y=0.133 $X2=0.297 $Y2=0.161
r29 28 29 2.68168 $w=1.3e-08 $l=1.15e-08 $layer=M1 $thickness=3.6e-08 $X=0.297
+ $Y=0.1215 $X2=0.297 $Y2=0.133
r30 15 28 6.06293 $w=1.3e-08 $l=2.6e-08 $layer=M1 $thickness=3.6e-08 $X=0.297
+ $Y=0.0955 $X2=0.297 $Y2=0.1215
r31 1 22 6.63025 $w=2.04878e-08 $layer=Gate_1 $thickness=5.20976e-08 $X=0.297
+ $Y=0.1335 $X2=0.297 $Y2=0.1335
r32 1 29 19.3796 $a=3.24e-16 $layer=V0LIG $X=0.297 $Y=0.1335 $X2=0.297 $Y2=0.133
r33 24 23 16.8368 $w=2.1e-08 $l=4.95e-08 $layer=Gate_1 $thickness=5.6e-08
+ $X=0.297 $Y=0.2295 $X2=0.297 $Y2=0.18
r34 22 23 15.995 $w=2.07742e-08 $l=4.65e-08 $layer=Gate_1 $thickness=5.6e-08
+ $X=0.297 $Y=0.1335 $X2=0.297 $Y2=0.18
r35 21 22 6.30106 $w=2.04167e-08 $l=1.8e-08 $layer=Gate_1 $thickness=5.6e-08
+ $X=0.297 $Y=0.1155 $X2=0.297 $Y2=0.1335
r36 20 21 16.3266 $w=2.1e-08 $l=4.8e-08 $layer=Gate_1 $thickness=5.6e-08
+ $X=0.297 $Y=0.0675 $X2=0.297 $Y2=0.1155
r37 20 9 14.6259 $w=2.1e-08 $l=4.3e-08 $layer=Gate_1 $thickness=5.6e-08
+ $X=0.297 $Y=0.0675 $X2=0.297 $Y2=0.0245
r38 3 10 1e-05 $l=7.28011e-09 $X=0.594 $Y=0.0605 $X2=0.596 $Y2=0.0675
.ends

.subckt PM_ICGx1_ASAP7_75t_R%8 vss 16 20 44 50 9 1 14 15 12 13 4 11 3 10
c1 1 vss 0.00261859f $X=0.396 $Y=0.082
c2 3 vss 0.00737164f $X=0.486 $Y=0.0635
c3 4 vss 0.00604723f $X=0.486 $Y=0.2295
c4 9 vss 0.0591313f $X=0.405 $Y=0.0245
c5 10 vss 0.0218363f $X=0.4715 $Y=0.0405
c6 11 vss 0.0223501f $X=0.4715 $Y=0.2295
c7 12 vss 0.00646836f $X=0.5125 $Y=0.233
c8 13 vss 0.00060869f $X=0.5125 $Y=0.082
c9 14 vss 0.00270099f $X=0.3965 $Y=0.082
c10 15 vss 0.0018795f $X=0.5125 $Y=0.093
r1 11 4 0.462963 $w=2.7e-08 $l=1.25e-08 $layer=P_src_drn $thickness=1e-09
+ $X=0.4715 $Y=0.2295 $X2=0.486 $Y2=0.2295
r2 50 11 0.0925926 $w=2.7e-08 $l=2.5e-09 $layer=P_src_drn $thickness=1e-09
+ $X=0.4686 $Y=0.2295 $X2=0.4715 $Y2=0.2295
r3 4 46 19.3796 $a=3.24e-16 $layer=V0LISD $X=0.486 $Y=0.2295 $X2=0.486 $Y2=0.233
r4 46 47 3.03147 $w=1.3e-08 $l=1.3e-08 $layer=M1 $thickness=3.6e-08 $X=0.486
+ $Y=0.233 $X2=0.499 $Y2=0.233
r5 12 42 1.06916 $w=1.78e-08 $l=9.5e-09 $layer=M1 $thickness=3.6e-08 $X=0.5125
+ $Y=0.233 $X2=0.5125 $Y2=0.2235
r6 12 47 1.90218 $w=1.65185e-08 $l=1.35e-08 $layer=M1 $thickness=3.6e-08
+ $X=0.5125 $Y=0.233 $X2=0.499 $Y2=0.233
r7 10 35 0.462963 $w=2.7e-08 $l=1.25e-08 $layer=N_src_drn $thickness=1e-09
+ $X=0.4715 $Y=0.0405 $X2=0.486 $Y2=0.0405
r8 44 10 0.0925926 $w=2.7e-08 $l=2.5e-09 $layer=N_src_drn $thickness=1e-09
+ $X=0.4686 $Y=0.0405 $X2=0.4715 $Y2=0.0405
r9 41 42 2.49333 $w=1.4e-08 $l=1.25e-08 $layer=M1 $thickness=3.6e-08 $X=0.5125
+ $Y=0.211 $X2=0.5125 $Y2=0.2235
r10 40 41 4.1888 $w=1.4e-08 $l=2.1e-08 $layer=M1 $thickness=3.6e-08 $X=0.5125
+ $Y=0.19 $X2=0.5125 $Y2=0.211
r11 39 40 3.69013 $w=1.4e-08 $l=1.85e-08 $layer=M1 $thickness=3.6e-08 $X=0.5125
+ $Y=0.1715 $X2=0.5125 $Y2=0.19
r12 38 39 3.69013 $w=1.4e-08 $l=1.85e-08 $layer=M1 $thickness=3.6e-08 $X=0.5125
+ $Y=0.153 $X2=0.5125 $Y2=0.1715
r13 37 38 4.1888 $w=1.4e-08 $l=2.1e-08 $layer=M1 $thickness=3.6e-08 $X=0.5125
+ $Y=0.132 $X2=0.5125 $Y2=0.153
r14 36 37 4.88693 $w=1.4e-08 $l=2.45e-08 $layer=M1 $thickness=3.6e-08 $X=0.5125
+ $Y=0.1075 $X2=0.5125 $Y2=0.132
r15 15 36 2.89227 $w=1.4e-08 $l=1.45e-08 $layer=M1 $thickness=3.6e-08 $X=0.5125
+ $Y=0.093 $X2=0.5125 $Y2=0.1075
r16 3 33 10.904 $w=2.02e-08 $l=1.85e-08 $layer=LISD $thickness=2.7e-08 $X=0.486
+ $Y=0.0635 $X2=0.486 $Y2=0.082
r17 3 35 13.5563 $w=2.02e-08 $l=2.3e-08 $layer=LISD $thickness=2.7e-08 $X=0.486
+ $Y=0.0635 $X2=0.486 $Y2=0.0405
r18 13 32 1.37684 $w=2.03185e-08 $l=1.35e-08 $layer=M1 $thickness=3.6e-08
+ $X=0.5125 $Y=0.082 $X2=0.499 $Y2=0.082
r19 13 15 0.843012 $w=1.80909e-08 $l=1.1e-08 $layer=M1 $thickness=3.6e-08
+ $X=0.5125 $Y=0.082 $X2=0.5125 $Y2=0.093
r20 31 32 3.03147 $w=1.3e-08 $l=1.3e-08 $layer=M1 $thickness=3.6e-08 $X=0.486
+ $Y=0.082 $X2=0.499 $Y2=0.082
r21 31 33 19.3796 $a=3.24e-16 $layer=V0LISD $X=0.486 $Y=0.082 $X2=0.486
+ $Y2=0.082
r22 30 31 2.56509 $w=1.3e-08 $l=1.1e-08 $layer=M1 $thickness=3.6e-08 $X=0.475
+ $Y=0.082 $X2=0.486 $Y2=0.082
r23 29 30 3.49785 $w=1.3e-08 $l=1.5e-08 $layer=M1 $thickness=3.6e-08 $X=0.46
+ $Y=0.082 $X2=0.475 $Y2=0.082
r24 28 29 6.7625 $w=1.3e-08 $l=2.9e-08 $layer=M1 $thickness=3.6e-08 $X=0.431
+ $Y=0.082 $X2=0.46 $Y2=0.082
r25 27 28 3.84763 $w=1.3e-08 $l=1.65e-08 $layer=M1 $thickness=3.6e-08 $X=0.4145
+ $Y=0.082 $X2=0.431 $Y2=0.082
r26 25 27 2.09871 $w=1.3e-08 $l=9e-09 $layer=M1 $thickness=3.6e-08 $X=0.4055
+ $Y=0.082 $X2=0.4145 $Y2=0.082
r27 14 25 2.09871 $w=1.3e-08 $l=9e-09 $layer=M1 $thickness=3.6e-08 $X=0.3965
+ $Y=0.082 $X2=0.4055 $Y2=0.082
r28 22 25 19.3796 $a=3.24e-16 $layer=V0LIG $X=0.406 $Y=0.082 $X2=0.4055
+ $Y2=0.082
r29 1 22 2.6116 $w=2.2e-08 $l=1e-08 $layer=LIG $thickness=4.8e-08 $X=0.396
+ $Y=0.082 $X2=0.406 $Y2=0.082
r30 20 19 25.5104 $w=2.1e-08 $l=7.5e-08 $layer=Gate_1 $thickness=5.6e-08
+ $X=0.405 $Y=0.2295 $X2=0.405 $Y2=0.1545
r31 18 19 24.8471 $w=2.08483e-08 $l=7.25e-08 $layer=Gate_1 $thickness=5.6e-08
+ $X=0.405 $Y=0.082 $X2=0.405 $Y2=0.1545
r32 18 22 6.27904 $w=2.09e-08 $l=1e-09 $layer=Gate_1 $thickness=5.24e-08
+ $X=0.405 $Y=0.082 $X2=0.406 $Y2=0.082
r33 17 18 6.81977 $w=2.04359e-08 $l=1.95e-08 $layer=Gate_1 $thickness=5.6e-08
+ $X=0.405 $Y=0.0625 $X2=0.405 $Y2=0.082
r34 16 17 7.48304 $w=2.1e-08 $l=2.2e-08 $layer=Gate_1 $thickness=5.6e-08
+ $X=0.405 $Y=0.0405 $X2=0.405 $Y2=0.0625
r35 16 9 5.44221 $w=2.1e-08 $l=1.6e-08 $layer=Gate_1 $thickness=5.6e-08
+ $X=0.405 $Y=0.0405 $X2=0.405 $Y2=0.0245
.ends

.subckt PM_ICGx1_ASAP7_75t_R%10 vss 23 29 47 48 56 57 60 61 13 3 19 5 4 14 15
+ 20 16 1 22 12 18 17
c1 1 vss 0.00357136f $X=0.891 $Y=0.1355
c2 3 vss 0.00753271f $X=0.702 $Y=0.216
c3 4 vss 0.00471854f $X=0.756 $Y=0.0675
c4 5 vss 0.00716877f $X=0.81 $Y=0.216
c5 12 vss 0.101492f $X=0.891 $Y=0.0245
c6 13 vss 0.00275303f $X=0.7415 $Y=0.0675
c7 14 vss 0.00385034f $X=0.6875 $Y=0.216
c8 15 vss 0.00385435f $X=0.7955 $Y=0.216
c9 16 vss 0.00346964f $X=0.837 $Y=0.192
c10 17 vss 0.00071798f $X=0.891 $Y=0.072
c11 18 vss 0.000645888f $X=0.891 $Y=0.197
c12 19 vss 0.0114164f $X=0.783 $Y=0.231
c13 20 vss 0.00563652f $X=0.8805 $Y=0.072
c14 21 vss 0.00139591f $X=0.864 $Y=0.197
c15 22 vss 0.00161739f $X=0.891 $Y=0.113
r1 61 59 0.0462963 $w=5.4e-08 $l=2.5e-09 $layer=P_src_drn $thickness=1e-09
+ $X=0.7193 $Y=0.216 $X2=0.7165 $Y2=0.216
r2 3 59 0.268519 $w=5.4e-08 $l=1.45e-08 $layer=P_src_drn $thickness=1e-09
+ $X=0.702 $Y=0.216 $X2=0.7165 $Y2=0.216
r3 14 3 0.268519 $w=5.4e-08 $l=1.45e-08 $layer=P_src_drn $thickness=1e-09
+ $X=0.6875 $Y=0.216 $X2=0.702 $Y2=0.216
r4 60 14 0.0462963 $w=5.4e-08 $l=2.5e-09 $layer=P_src_drn $thickness=1e-09
+ $X=0.6846 $Y=0.216 $X2=0.6875 $Y2=0.216
r5 57 55 0.0462963 $w=5.4e-08 $l=2.5e-09 $layer=P_src_drn $thickness=1e-09
+ $X=0.8273 $Y=0.216 $X2=0.8245 $Y2=0.216
r6 5 55 0.268519 $w=5.4e-08 $l=1.45e-08 $layer=P_src_drn $thickness=1e-09
+ $X=0.81 $Y=0.216 $X2=0.8245 $Y2=0.216
r7 15 5 0.268519 $w=5.4e-08 $l=1.45e-08 $layer=P_src_drn $thickness=1e-09
+ $X=0.7955 $Y=0.216 $X2=0.81 $Y2=0.216
r8 56 15 0.0462963 $w=5.4e-08 $l=2.5e-09 $layer=P_src_drn $thickness=1e-09
+ $X=0.7926 $Y=0.216 $X2=0.7955 $Y2=0.216
r9 3 52 19.3796 $a=3.24e-16 $layer=V0LISD $X=0.702 $Y=0.216 $X2=0.702 $Y2=0.231
r10 5 49 19.3796 $a=3.24e-16 $layer=V0LISD $X=0.81 $Y=0.216 $X2=0.81 $Y2=0.231
r11 52 53 8.39483 $w=1.3e-08 $l=3.6e-08 $layer=M1 $thickness=3.6e-08 $X=0.702
+ $Y=0.231 $X2=0.738 $Y2=0.231
r12 49 50 3.14806 $w=1.3e-08 $l=1.35e-08 $layer=M1 $thickness=3.6e-08 $X=0.81
+ $Y=0.231 $X2=0.8235 $Y2=0.231
r13 19 49 6.29612 $w=1.3e-08 $l=2.7e-08 $layer=M1 $thickness=3.6e-08 $X=0.783
+ $Y=0.231 $X2=0.81 $Y2=0.231
r14 19 53 10.4935 $w=1.3e-08 $l=4.5e-08 $layer=M1 $thickness=3.6e-08 $X=0.783
+ $Y=0.231 $X2=0.738 $Y2=0.231
r15 47 46 0.0308642 $w=8.1e-08 $l=2.5e-09 $layer=N_src_drn $thickness=1e-09
+ $X=0.7733 $Y=0.0675 $X2=0.7705 $Y2=0.0675
r16 4 46 0.179012 $w=8.1e-08 $l=1.45e-08 $layer=N_src_drn $thickness=1e-09
+ $X=0.756 $Y=0.0675 $X2=0.7705 $Y2=0.0675
r17 13 4 0.179012 $w=8.1e-08 $l=1.45e-08 $layer=N_src_drn $thickness=1e-09
+ $X=0.7415 $Y=0.0675 $X2=0.756 $Y2=0.0675
r18 48 13 0.0308642 $w=8.1e-08 $l=2.5e-09 $layer=N_src_drn $thickness=1e-09
+ $X=0.7386 $Y=0.0675 $X2=0.7415 $Y2=0.0675
r19 43 50 1.20242 $w=1.425e-08 $l=1.54434e-08 $layer=M1 $thickness=3.6e-08
+ $X=0.837 $Y=0.2235 $X2=0.8235 $Y2=0.231
r20 42 43 2.01858 $w=1.37895e-08 $l=9.5e-09 $layer=M1 $thickness=3.6e-08
+ $X=0.837 $Y=0.214 $X2=0.837 $Y2=0.2235
r21 41 42 2.37574 $w=1.49231e-08 $l=1.3e-08 $layer=M1 $thickness=3.6e-08
+ $X=0.837 $Y=0.201 $X2=0.837 $Y2=0.214
r22 16 21 4.60559 $w=1.39091e-08 $l=2.74591e-08 $layer=M1 $thickness=3.6e-08
+ $X=0.837 $Y=0.192 $X2=0.864 $Y2=0.197
r23 16 41 0.9184 $w=1.8e-08 $l=9e-09 $layer=M1 $thickness=3.6e-08 $X=0.837
+ $Y=0.192 $X2=0.837 $Y2=0.201
r24 4 39 19.3796 $a=3.24e-16 $layer=V0LISD $X=0.756 $Y=0.0675 $X2=0.756
+ $Y2=0.072
r25 39 40 9.44419 $w=1.3e-08 $l=4.05e-08 $layer=M1 $thickness=3.6e-08 $X=0.756
+ $Y=0.072 $X2=0.7965 $Y2=0.072
r26 37 40 9.44419 $w=1.3e-08 $l=4.05e-08 $layer=M1 $thickness=3.6e-08 $X=0.837
+ $Y=0.072 $X2=0.7965 $Y2=0.072
r27 36 37 5.94634 $w=1.3e-08 $l=2.55e-08 $layer=M1 $thickness=3.6e-08 $X=0.8625
+ $Y=0.072 $X2=0.837 $Y2=0.072
r28 20 36 4.19742 $w=1.3e-08 $l=1.8e-08 $layer=M1 $thickness=3.6e-08 $X=0.8805
+ $Y=0.072 $X2=0.8625 $Y2=0.072
r29 18 35 5.22999 $w=1.59898e-08 $l=2.95e-08 $layer=M1 $thickness=3.6e-08
+ $X=0.891 $Y=0.197 $X2=0.891 $Y2=0.1675
r30 18 21 4.64701 $w=1.46667e-08 $l=2.7e-08 $layer=M1 $thickness=3.6e-08
+ $X=0.891 $Y=0.197 $X2=0.864 $Y2=0.197
r31 17 34 2.5483 $w=1.79e-08 $l=1.8e-08 $layer=M1 $thickness=3.6e-08 $X=0.891
+ $Y=0.072 $X2=0.891 $Y2=0.09
r32 17 20 0.79938 $w=1.72857e-08 $l=1.05e-08 $layer=M1 $thickness=3.6e-08
+ $X=0.891 $Y=0.072 $X2=0.8805 $Y2=0.072
r33 33 35 5.01358 $w=1.3e-08 $l=2.15e-08 $layer=M1 $thickness=3.6e-08 $X=0.891
+ $Y=0.146 $X2=0.891 $Y2=0.1675
r34 32 33 2.3319 $w=1.3e-08 $l=1e-08 $layer=M1 $thickness=3.6e-08 $X=0.891
+ $Y=0.136 $X2=0.891 $Y2=0.146
r35 22 32 5.36336 $w=1.3e-08 $l=2.3e-08 $layer=M1 $thickness=3.6e-08 $X=0.891
+ $Y=0.113 $X2=0.891 $Y2=0.136
r36 22 34 5.36336 $w=1.3e-08 $l=2.3e-08 $layer=M1 $thickness=3.6e-08 $X=0.891
+ $Y=0.113 $X2=0.891 $Y2=0.09
r37 1 26 10.1312 $w=1.77047e-08 $l=5e-10 $layer=LIG $thickness=5.2093e-08
+ $X=0.891 $Y=0.1355 $X2=0.891 $Y2=0.136
r38 1 32 19.3796 $a=3.24e-16 $layer=V0LIG $X=0.891 $Y=0.1355 $X2=0.891 $Y2=0.136
r39 29 28 14.6259 $w=2.1e-08 $l=4.3e-08 $layer=Gate_1 $thickness=5.6e-08
+ $X=0.891 $Y=0.2025 $X2=0.891 $Y2=0.1595
r40 27 28 2.55104 $w=2.1e-08 $l=7.5e-09 $layer=Gate_1 $thickness=5.6e-08
+ $X=0.891 $Y=0.152 $X2=0.891 $Y2=0.1595
r41 26 27 5.62929 $w=2.03125e-08 $l=1.6e-08 $layer=Gate_1 $thickness=5.6e-08
+ $X=0.891 $Y=0.136 $X2=0.891 $Y2=0.152
r42 25 26 5.96942 $w=2.03529e-08 $l=1.7e-08 $layer=Gate_1 $thickness=5.6e-08
+ $X=0.891 $Y=0.119 $X2=0.891 $Y2=0.136
r43 24 25 2.89117 $w=2.1e-08 $l=8.5e-09 $layer=Gate_1 $thickness=5.6e-08
+ $X=0.891 $Y=0.1105 $X2=0.891 $Y2=0.119
r44 23 24 14.6259 $w=2.1e-08 $l=4.3e-08 $layer=Gate_1 $thickness=5.6e-08
+ $X=0.891 $Y=0.0675 $X2=0.891 $Y2=0.1105
r45 23 12 14.6259 $w=2.1e-08 $l=4.3e-08 $layer=Gate_1 $thickness=5.6e-08
+ $X=0.891 $Y=0.0675 $X2=0.891 $Y2=0.0245
.ends

.subckt PM_ICGx1_ASAP7_75t_R%12 vss 7 9 4 5 1
c1 1 vss 0.00824249f $X=0.243 $Y=0.0675
c2 4 vss 0.00291931f $X=0.2015 $Y=0.0675
c3 5 vss 0.00176338f $X=0.272 $Y=0.0675
r1 9 8 0.0308642 $w=8.1e-08 $l=2.5e-09 $layer=N_src_drn $thickness=1e-09
+ $X=0.2873 $Y=0.0675 $X2=0.2845 $Y2=0.0675
r2 5 8 0.154321 $w=8.1e-08 $l=1.25e-08 $layer=N_src_drn $thickness=1e-09
+ $X=0.272 $Y=0.0675 $X2=0.2845 $Y2=0.0675
r3 4 1 0.154321 $w=8.1e-08 $l=1.25e-08 $layer=N_src_drn $thickness=1e-09
+ $X=0.2015 $Y=0.0675 $X2=0.243 $Y2=0.0675
r4 7 4 0.0308642 $w=8.1e-08 $l=2.5e-09 $layer=N_src_drn $thickness=1e-09
+ $X=0.1986 $Y=0.0675 $X2=0.2015 $Y2=0.0675
r5 1 5 1e-05 $l=2.9e-08 $X=0.243 $Y=0.0675 $X2=0.272 $Y2=0.0675
.ends

.subckt PM_ICGx1_ASAP7_75t_R%13 vss 6 7 3 1
c1 1 vss 0.00453779f $X=0.216 $Y=0.2025
c2 3 vss 0.00305712f $X=0.2015 $Y=0.2025
r1 7 5 0.0308642 $w=8.1e-08 $l=2.5e-09 $layer=P_src_drn $thickness=1e-09
+ $X=0.2333 $Y=0.2025 $X2=0.2305 $Y2=0.2025
r2 1 5 0.179012 $w=8.1e-08 $l=1.45e-08 $layer=P_src_drn $thickness=1e-09
+ $X=0.216 $Y=0.2025 $X2=0.2305 $Y2=0.2025
r3 3 1 0.179012 $w=8.1e-08 $l=1.45e-08 $layer=P_src_drn $thickness=1e-09
+ $X=0.2015 $Y=0.2025 $X2=0.216 $Y2=0.2025
r4 6 3 0.0308642 $w=8.1e-08 $l=2.5e-09 $layer=P_src_drn $thickness=1e-09
+ $X=0.1986 $Y=0.2025 $X2=0.2015 $Y2=0.2025
.ends

.subckt PM_ICGx1_ASAP7_75t_R%14 vss 7 12 5 1 4
c1 1 vss 0.00606784f $X=0.324 $Y=0.2295
c2 4 vss 0.00168641f $X=0.3095 $Y=0.2295
c3 5 vss 0.0020788f $X=0.38 $Y=0.2295
r1 12 11 0.0925926 $w=2.7e-08 $l=2.5e-09 $layer=P_src_drn $thickness=1e-09
+ $X=0.3953 $Y=0.2295 $X2=0.3925 $Y2=0.2295
r2 5 11 0.462963 $w=2.7e-08 $l=1.25e-08 $layer=P_src_drn $thickness=1e-09
+ $X=0.38 $Y=0.2295 $X2=0.3925 $Y2=0.2295
r3 9 5 9.87715 $w=2.32e-08 $l=2.1e-08 $layer=LISD $thickness=2.7e-08 $X=0.357
+ $Y=0.2295 $X2=0.38 $Y2=0.2295
r4 8 9 7.05511 $w=2.32e-08 $l=1.5e-08 $layer=LISD $thickness=2.7e-08 $X=0.342
+ $Y=0.2295 $X2=0.357 $Y2=0.2295
r5 1 8 8.46613 $w=2.32e-08 $l=1.8e-08 $layer=LISD $thickness=2.7e-08 $X=0.324
+ $Y=0.2295 $X2=0.342 $Y2=0.2295
r6 4 1 0.462963 $w=2.7e-08 $l=1.25e-08 $layer=P_src_drn $thickness=1e-09
+ $X=0.3095 $Y=0.2295 $X2=0.324 $Y2=0.2295
r7 7 4 0.0925926 $w=2.7e-08 $l=2.5e-09 $layer=P_src_drn $thickness=1e-09
+ $X=0.3066 $Y=0.2295 $X2=0.3095 $Y2=0.2295
.ends

.subckt PM_ICGx1_ASAP7_75t_R%15 vss 6 7 3 1
c1 1 vss 0.00266305f $X=0.378 $Y=0.0405
c2 3 vss 0.0021466f $X=0.3635 $Y=0.0405
r1 7 5 0.0925926 $w=2.7e-08 $l=2.5e-09 $layer=N_src_drn $thickness=1e-09
+ $X=0.3953 $Y=0.0405 $X2=0.3925 $Y2=0.0405
r2 1 5 0.537037 $w=2.7e-08 $l=1.45e-08 $layer=N_src_drn $thickness=1e-09
+ $X=0.378 $Y=0.0405 $X2=0.3925 $Y2=0.0405
r3 3 1 0.537037 $w=2.7e-08 $l=1.45e-08 $layer=N_src_drn $thickness=1e-09
+ $X=0.3635 $Y=0.0405 $X2=0.378 $Y2=0.0405
r4 6 3 0.0925926 $w=2.7e-08 $l=2.5e-09 $layer=N_src_drn $thickness=1e-09
+ $X=0.3606 $Y=0.0405 $X2=0.3635 $Y2=0.0405
.ends

.subckt PM_ICGx1_ASAP7_75t_R%16__2 vss 2 3 1
c1 1 vss 0.000765294f $X=0.702 $Y=0.0675
r1 2 1 0.209877 $w=8.1e-08 $l=1.7e-08 $layer=N_src_drn $thickness=1e-09
+ $X=0.6846 $Y=0.0675 $X2=0.702 $Y2=0.0675
r2 3 1 0.209877 $w=8.1e-08 $l=1.7e-08 $layer=N_src_drn $thickness=1e-09
+ $X=0.7193 $Y=0.0675 $X2=0.702 $Y2=0.0675
.ends

.subckt PM_ICGx1_ASAP7_75t_R%17 vss 2 3 1
c1 1 vss 0.000751824f $X=0.81 $Y=0.0675
r1 2 1 0.209877 $w=8.1e-08 $l=1.7e-08 $layer=N_src_drn $thickness=1e-09
+ $X=0.7926 $Y=0.0675 $X2=0.81 $Y2=0.0675
r2 3 1 0.209877 $w=8.1e-08 $l=1.7e-08 $layer=N_src_drn $thickness=1e-09
+ $X=0.8273 $Y=0.0675 $X2=0.81 $Y2=0.0675
.ends

.subckt PM_ICGx1_ASAP7_75t_R%9 vss 34 38 60 63 84 87 101 104 112 115 16 26 23
+ 22 29 18 21 27 24 33 7 19 25 3 1 31 32 17 28 30 13 8 2 14 15
c1 1 vss 0.00290423f $X=0.459 $Y=0.19
c2 2 vss 0.00413009f $X=0.675 $Y=0.135
c3 3 vss 0.00401537f $X=0.837 $Y=0.135
c4 7 vss 0.00482225f $X=0.27 $Y=0.2295
c5 8 vss 0.00429462f $X=0.324 $Y=0.0405
c6 13 vss 0.0499911f $X=0.459 $Y=0.19
c7 14 vss 0.093842f $X=0.675 $Y=0.135
c8 15 vss 0.0954574f $X=0.837 $Y=0.0245
c9 16 vss 0.00218816f $X=0.3095 $Y=0.0405
c10 17 vss 0.000899763f $X=0.3095 $Y=0.081
c11 18 vss 0.00214072f $X=0.2555 $Y=0.2295
c12 19 vss 0.000889631f $X=0.2555 $Y=0.189
c13 20 vss 0.00204215f $X=0.358 $Y=0.036
c14 21 vss 0.000124509f $X=0.358 $Y=0.1895
c15 22 vss 0.00254389f $X=0.358 $Y=0.2235
c16 23 vss 0.00312446f $X=0.675 $Y=0.036
c17 24 vss 0.000753684f $X=0.675 $Y=0.1075
c18 25 vss 0.00125392f $X=0.837 $Y=0.1205
c19 26 vss 0.00766154f $X=0.3365 $Y=0.232
c20 27 vss 0.00400962f $X=0.3285 $Y=0.036
c21 28 vss 0.000904656f $X=0.358 $Y=0.0585
c22 29 vss 0.000436122f $X=0.358 $Y=0.211
c23 30 vss 0.0267663f $X=0.648 $Y=0.036
c24 31 vss 0.00198421f $X=0.3795 $Y=0.19
c25 32 vss 0.00216109f $X=0.675 $Y=0.097
c26 33 vss 0.00201306f $X=0.7965 $Y=0.108
r1 19 110 0.231482 $w=5.4e-08 $l=1.25e-08 $layer=P_src_drn $thickness=1e-09
+ $X=0.2555 $Y=0.189 $X2=0.27 $Y2=0.189
r2 115 114 0.0925926 $w=2.7e-08 $l=2.5e-09 $layer=P_src_drn $thickness=1e-09
+ $X=0.2873 $Y=0.2295 $X2=0.2845 $Y2=0.2295
r3 113 114 0.166667 $w=2.7e-08 $l=4.5e-09 $layer=P_src_drn $thickness=1e-09
+ $X=0.28 $Y=0.2295 $X2=0.2845 $Y2=0.2295
r4 110 113 0.444445 $w=2.7e-08 $l=1.2e-08 $layer=P_src_drn $thickness=1e-09
+ $X=0.27 $Y=0.189 $X2=0.28 $Y2=0.2295
r5 18 110 0.462963 $w=2.7e-08 $l=1.25e-08 $layer=P_src_drn $thickness=1e-09
+ $X=0.2555 $Y=0.2295 $X2=0.27 $Y2=0.189
r6 112 18 0.0925926 $w=2.7e-08 $l=2.5e-09 $layer=P_src_drn $thickness=1e-09
+ $X=0.2526 $Y=0.2025 $X2=0.2555 $Y2=0.2295
r7 7 108 19.3796 $a=3.24e-16 $layer=V0LISD $X=0.27 $Y=0.2295 $X2=0.27 $Y2=0.232
r8 7 110 23.8708 $w=2.02e-08 $l=4.05e-08 $layer=LISD $thickness=2.7e-08 $X=0.27
+ $Y=0.2295 $X2=0.27 $Y2=0.189
r9 108 109 3.14806 $w=1.3e-08 $l=1.35e-08 $layer=M1 $thickness=3.6e-08 $X=0.27
+ $Y=0.232 $X2=0.2835 $Y2=0.232
r10 106 109 5.24677 $w=1.3e-08 $l=2.25e-08 $layer=M1 $thickness=3.6e-08
+ $X=0.306 $Y=0.232 $X2=0.2835 $Y2=0.232
r11 26 106 7.11229 $w=1.3e-08 $l=3.05e-08 $layer=M1 $thickness=3.6e-08
+ $X=0.3365 $Y=0.232 $X2=0.306 $Y2=0.232
r12 104 103 7.31297 $w=2.1e-08 $l=2.15e-08 $layer=Gate_1 $thickness=5.6e-08
+ $X=0.459 $Y=0.2295 $X2=0.459 $Y2=0.208
r13 101 102 14.6259 $w=2.1e-08 $l=4.3e-08 $layer=Gate_1 $thickness=5.6e-08
+ $X=0.459 $Y=0.0405 $X2=0.459 $Y2=0.0835
r14 99 102 17.5171 $w=2.1e-08 $l=5.15e-08 $layer=Gate_1 $thickness=5.6e-08
+ $X=0.459 $Y=0.135 $X2=0.459 $Y2=0.0835
r15 98 99 11.3946 $w=2.1e-08 $l=3.35e-08 $layer=Gate_1 $thickness=5.6e-08
+ $X=0.459 $Y=0.1685 $X2=0.459 $Y2=0.135
r16 13 98 7.48304 $w=2.05349e-08 $l=2.15e-08 $layer=Gate_1 $thickness=5.6e-08
+ $X=0.459 $Y=0.19 $X2=0.459 $Y2=0.1685
r17 13 103 6.29255 $w=2.04444e-08 $l=1.8e-08 $layer=Gate_1 $thickness=5.6e-08
+ $X=0.459 $Y=0.19 $X2=0.459 $Y2=0.208
r18 22 29 2.8493 $w=1.32e-08 $l=1.25e-08 $layer=M1 $thickness=3.6e-08 $X=0.358
+ $Y=0.2235 $X2=0.358 $Y2=0.211
r19 22 26 2.96589 $w=1.31923e-08 $l=2.31193e-08 $layer=M1 $thickness=3.6e-08
+ $X=0.358 $Y=0.2235 $X2=0.3365 $Y2=0.232
r20 1 93 19.3796 $a=3.24e-16 $layer=V0LIG $X=0.459 $Y=0.19 $X2=0.459 $Y2=0.19
r21 1 13 6.74717 $w=2e-08 $layer=Gate_1 $thickness=5.2e-08 $X=0.459 $Y=0.19
+ $X2=0.459 $Y2=0.19
r22 29 82 2.8493 $w=1.32e-08 $l=1.25e-08 $layer=M1 $thickness=3.6e-08 $X=0.358
+ $Y=0.211 $X2=0.358 $Y2=0.1985
r23 92 93 2.44849 $w=1.3e-08 $l=1.05e-08 $layer=M1 $thickness=3.6e-08 $X=0.4485
+ $Y=0.19 $X2=0.459 $Y2=0.19
r24 91 92 4.19742 $w=1.3e-08 $l=1.8e-08 $layer=M1 $thickness=3.6e-08 $X=0.4305
+ $Y=0.19 $X2=0.4485 $Y2=0.19
r25 90 91 5.94634 $w=1.3e-08 $l=2.55e-08 $layer=M1 $thickness=3.6e-08 $X=0.405
+ $Y=0.19 $X2=0.4305 $Y2=0.19
r26 89 90 2.56509 $w=1.3e-08 $l=1.1e-08 $layer=M1 $thickness=3.6e-08 $X=0.394
+ $Y=0.19 $X2=0.405 $Y2=0.19
r27 31 89 3.38125 $w=1.3e-08 $l=1.45e-08 $layer=M1 $thickness=3.6e-08 $X=0.3795
+ $Y=0.19 $X2=0.394 $Y2=0.19
r28 17 80 0.231482 $w=5.4e-08 $l=1.25e-08 $layer=N_src_drn $thickness=1e-09
+ $X=0.3095 $Y=0.081 $X2=0.324 $Y2=0.074
r29 87 86 0.0925926 $w=2.7e-08 $l=2.5e-09 $layer=N_src_drn $thickness=1e-09
+ $X=0.3413 $Y=0.0405 $X2=0.3385 $Y2=0.0405
r30 85 86 0.166667 $w=2.7e-08 $l=4.5e-09 $layer=N_src_drn $thickness=1e-09
+ $X=0.334 $Y=0.0405 $X2=0.3385 $Y2=0.0405
r31 80 85 0.444445 $w=2.7e-08 $l=1.2e-08 $layer=N_src_drn $thickness=1e-09
+ $X=0.324 $Y=0.074 $X2=0.334 $Y2=0.0405
r32 16 80 0.462963 $w=2.7e-08 $l=1.25e-08 $layer=N_src_drn $thickness=1e-09
+ $X=0.3095 $Y=0.0405 $X2=0.324 $Y2=0.074
r33 84 16 0.0925926 $w=2.7e-08 $l=2.5e-09 $layer=N_src_drn $thickness=1e-09
+ $X=0.3066 $Y=0.0675 $X2=0.3095 $Y2=0.0405
r34 21 79 0.983973 $w=1.77222e-08 $l=9e-09 $layer=M1 $thickness=3.6e-08
+ $X=0.358 $Y=0.1895 $X2=0.358 $Y2=0.1805
r35 21 82 0.9184 $w=1.8e-08 $l=9e-09 $layer=M1 $thickness=3.6e-08 $X=0.358
+ $Y=0.1895 $X2=0.358 $Y2=0.1985
r36 21 31 3.78225 $w=1.50238e-08 $l=2.15058e-08 $layer=M1 $thickness=3.6e-08
+ $X=0.358 $Y=0.1895 $X2=0.3795 $Y2=0.19
r37 8 73 19.3796 $a=3.24e-16 $layer=V0LISD $X=0.324 $Y=0.0405 $X2=0.3195
+ $Y2=0.036
r38 8 80 19.745 $w=2.02e-08 $l=3.35e-08 $layer=LISD $thickness=2.7e-08 $X=0.324
+ $Y=0.0405 $X2=0.324 $Y2=0.074
r39 78 79 2.2153 $w=1.3e-08 $l=9.5e-09 $layer=M1 $thickness=3.6e-08 $X=0.358
+ $Y=0.171 $X2=0.358 $Y2=0.1805
r40 77 78 6.99569 $w=1.3e-08 $l=3e-08 $layer=M1 $thickness=3.6e-08 $X=0.358
+ $Y=0.141 $X2=0.358 $Y2=0.171
r41 76 77 8.27824 $w=1.3e-08 $l=3.55e-08 $layer=M1 $thickness=3.6e-08 $X=0.358
+ $Y=0.1055 $X2=0.358 $Y2=0.141
r42 75 76 5.47996 $w=1.3e-08 $l=2.35e-08 $layer=M1 $thickness=3.6e-08 $X=0.358
+ $Y=0.082 $X2=0.358 $Y2=0.1055
r43 74 75 2.2153 $w=1.3e-08 $l=9.5e-09 $layer=M1 $thickness=3.6e-08 $X=0.358
+ $Y=0.0725 $X2=0.358 $Y2=0.082
r44 28 74 3.26466 $w=1.3e-08 $l=1.4e-08 $layer=M1 $thickness=3.6e-08 $X=0.358
+ $Y=0.0585 $X2=0.358 $Y2=0.0725
r45 27 71 2.91487 $w=1.3e-08 $l=1.25e-08 $layer=M1 $thickness=3.6e-08 $X=0.3285
+ $Y=0.036 $X2=0.341 $Y2=0.036
r46 27 73 2.09871 $w=1.3e-08 $l=9e-09 $layer=M1 $thickness=3.6e-08 $X=0.3285
+ $Y=0.036 $X2=0.3195 $Y2=0.036
r47 20 70 3.83327 $w=1.5093e-08 $l=2.15e-08 $layer=M1 $thickness=3.6e-08
+ $X=0.358 $Y=0.036 $X2=0.3795 $Y2=0.036
r48 20 71 2.78392 $w=1.56471e-08 $l=1.7e-08 $layer=M1 $thickness=3.6e-08
+ $X=0.358 $Y=0.036 $X2=0.341 $Y2=0.036
r49 20 28 4.06646 $w=1.5e-08 $l=2.25e-08 $layer=M1 $thickness=3.6e-08 $X=0.358
+ $Y=0.036 $X2=0.358 $Y2=0.0585
r50 69 70 18.0722 $w=1.3e-08 $l=7.75e-08 $layer=M1 $thickness=3.6e-08 $X=0.457
+ $Y=0.036 $X2=0.3795 $Y2=0.036
r51 68 69 19.4713 $w=1.3e-08 $l=8.35e-08 $layer=M1 $thickness=3.6e-08 $X=0.5405
+ $Y=0.036 $X2=0.457 $Y2=0.036
r52 67 68 10.1438 $w=1.3e-08 $l=4.35e-08 $layer=M1 $thickness=3.6e-08 $X=0.584
+ $Y=0.036 $X2=0.5405 $Y2=0.036
r53 66 67 6.17953 $w=1.3e-08 $l=2.65e-08 $layer=M1 $thickness=3.6e-08 $X=0.6105
+ $Y=0.036 $X2=0.584 $Y2=0.036
r54 65 66 2.44849 $w=1.3e-08 $l=1.05e-08 $layer=M1 $thickness=3.6e-08 $X=0.621
+ $Y=0.036 $X2=0.6105 $Y2=0.036
r55 30 65 6.29612 $w=1.3e-08 $l=2.7e-08 $layer=M1 $thickness=3.6e-08 $X=0.648
+ $Y=0.036 $X2=0.621 $Y2=0.036
r56 63 62 16.4967 $w=2.1e-08 $l=4.85e-08 $layer=Gate_1 $thickness=5.6e-08
+ $X=0.675 $Y=0.216 $X2=0.675 $Y2=0.1675
r57 60 61 16.4967 $w=2.1e-08 $l=4.85e-08 $layer=Gate_1 $thickness=5.6e-08
+ $X=0.675 $Y=0.0675 $X2=0.675 $Y2=0.116
r58 14 61 6.6497 $w=2.04211e-08 $l=1.9e-08 $layer=Gate_1 $thickness=5.6e-08
+ $X=0.675 $Y=0.135 $X2=0.675 $Y2=0.116
r59 14 62 11.2416 $w=2.06615e-08 $l=3.25e-08 $layer=Gate_1 $thickness=5.6e-08
+ $X=0.675 $Y=0.135 $X2=0.675 $Y2=0.1675
r60 23 56 2.5483 $w=1.79e-08 $l=1.8e-08 $layer=M1 $thickness=3.6e-08 $X=0.675
+ $Y=0.036 $X2=0.675 $Y2=0.054
r61 23 30 4.64701 $w=1.46667e-08 $l=2.7e-08 $layer=M1 $thickness=3.6e-08
+ $X=0.675 $Y=0.036 $X2=0.648 $Y2=0.036
r62 2 50 19.3796 $a=3.24e-16 $layer=V0LIG $X=0.675 $Y=0.135 $X2=0.675 $Y2=0.133
r63 2 14 6.54019 $w=2.09524e-08 $layer=Gate_1 $thickness=5.21905e-08 $X=0.675
+ $Y=0.135 $X2=0.675 $Y2=0.135
r64 55 56 3.26466 $w=1.3e-08 $l=1.4e-08 $layer=M1 $thickness=3.6e-08 $X=0.675
+ $Y=0.068 $X2=0.675 $Y2=0.054
r65 54 55 1.63233 $w=1.3e-08 $l=7e-09 $layer=M1 $thickness=3.6e-08 $X=0.675
+ $Y=0.075 $X2=0.675 $Y2=0.068
r66 53 54 0.932759 $w=1.3e-08 $l=4e-09 $layer=M1 $thickness=3.6e-08 $X=0.675
+ $Y=0.079 $X2=0.675 $Y2=0.075
r67 52 53 2.09871 $w=1.3e-08 $l=9e-09 $layer=M1 $thickness=3.6e-08 $X=0.675
+ $Y=0.088 $X2=0.675 $Y2=0.079
r68 32 52 2.09871 $w=1.3e-08 $l=9e-09 $layer=M1 $thickness=3.6e-08 $X=0.675
+ $Y=0.097 $X2=0.675 $Y2=0.088
r69 49 50 2.91487 $w=1.3e-08 $l=1.25e-08 $layer=M1 $thickness=3.6e-08 $X=0.675
+ $Y=0.1205 $X2=0.675 $Y2=0.133
r70 48 49 0.867186 $w=1.3625e-08 $l=4e-09 $layer=M1 $thickness=3.6e-08 $X=0.675
+ $Y=0.1165 $X2=0.675 $Y2=0.1205
r71 24 48 0.9184 $w=1.8e-08 $l=9e-09 $layer=M1 $thickness=3.6e-08 $X=0.675
+ $Y=0.1075 $X2=0.675 $Y2=0.1165
r72 24 32 1.33376 $w=1.70476e-08 $l=1.05e-08 $layer=M1 $thickness=3.6e-08
+ $X=0.675 $Y=0.1075 $X2=0.675 $Y2=0.097
r73 47 48 6.81353 $w=1.30847e-08 $l=3.89391e-08 $layer=M1 $thickness=3.6e-08
+ $X=0.713 $Y=0.108 $X2=0.675 $Y2=0.1165
r74 46 47 7.34548 $w=1.3e-08 $l=3.15e-08 $layer=M1 $thickness=3.6e-08 $X=0.7445
+ $Y=0.108 $X2=0.713 $Y2=0.108
r75 45 46 2.68168 $w=1.3e-08 $l=1.15e-08 $layer=M1 $thickness=3.6e-08 $X=0.756
+ $Y=0.108 $X2=0.7445 $Y2=0.108
r76 33 43 8.26388 $w=1.41111e-08 $l=4.05e-08 $layer=M1 $thickness=3.6e-08
+ $X=0.7965 $Y=0.108 $X2=0.837 $Y2=0.108
r77 33 45 9.44419 $w=1.3e-08 $l=4.05e-08 $layer=M1 $thickness=3.6e-08 $X=0.7965
+ $Y=0.108 $X2=0.756 $Y2=0.108
r78 25 42 2.91487 $w=1.3e-08 $l=1.25e-08 $layer=M1 $thickness=3.6e-08 $X=0.837
+ $Y=0.1205 $X2=0.837 $Y2=0.133
r79 25 43 1.73456 $w=1.66e-08 $l=1.25e-08 $layer=M1 $thickness=3.6e-08 $X=0.837
+ $Y=0.1205 $X2=0.837 $Y2=0.108
r80 3 36 6.54019 $w=2.09524e-08 $layer=Gate_1 $thickness=5.21905e-08 $X=0.837
+ $Y=0.135 $X2=0.837 $Y2=0.135
r81 3 42 19.3796 $a=3.24e-16 $layer=V0LIG $X=0.837 $Y=0.135 $X2=0.837 $Y2=0.133
r82 38 37 16.4967 $w=2.1e-08 $l=4.85e-08 $layer=Gate_1 $thickness=5.6e-08
+ $X=0.837 $Y=0.216 $X2=0.837 $Y2=0.1675
r83 36 37 11.2416 $w=2.06615e-08 $l=3.25e-08 $layer=Gate_1 $thickness=5.6e-08
+ $X=0.837 $Y=0.135 $X2=0.837 $Y2=0.1675
r84 35 36 6.6497 $w=2.04211e-08 $l=1.9e-08 $layer=Gate_1 $thickness=5.6e-08
+ $X=0.837 $Y=0.116 $X2=0.837 $Y2=0.135
r85 34 35 16.4967 $w=2.1e-08 $l=4.85e-08 $layer=Gate_1 $thickness=5.6e-08
+ $X=0.837 $Y=0.0675 $X2=0.837 $Y2=0.116
r86 34 15 14.6259 $w=2.1e-08 $l=4.3e-08 $layer=Gate_1 $thickness=5.6e-08
+ $X=0.837 $Y=0.0675 $X2=0.837 $Y2=0.0245
.ends

.subckt PM_ICGx1_ASAP7_75t_R%5 vss 17 21 45 46 48 16 15 4 11 3 14 10 1 9
c1 1 vss 0.00347413f $X=0.189 $Y=0.134
c2 3 vss 0.00751428f $X=0.054 $Y=0.216
c3 4 vss 0.00832246f $X=0.108 $Y=0.054
c4 9 vss 0.107188f $X=0.189 $Y=0.0245
c5 10 vss 0.006679f $X=0.0935 $Y=0.054
c6 11 vss 0.0315343f $X=0.056 $Y=0.216
c7 12 vss 0.00327277f $X=0.189 $Y=0.036
c8 13 vss 0.00335016f $X=0.189 $Y=0.2325
c9 14 vss 0.0175832f $X=0.162 $Y=0.233
c10 15 vss 0.0110104f $X=0.162 $Y=0.036
c11 16 vss 0.00661134f $X=0.189 $Y=0.0955
r1 48 47 0.0462963 $w=5.4e-08 $l=2.5e-09 $layer=P_src_drn $thickness=1e-09
+ $X=0.0713 $Y=0.216 $X2=0.0685 $Y2=0.216
r2 11 47 0.231482 $w=5.4e-08 $l=1.25e-08 $layer=P_src_drn $thickness=1e-09
+ $X=0.056 $Y=0.216 $X2=0.0685 $Y2=0.216
r3 46 44 0.0462963 $w=5.4e-08 $l=2.5e-09 $layer=N_src_drn $thickness=1e-09
+ $X=0.1253 $Y=0.054 $X2=0.1225 $Y2=0.054
r4 4 44 0.268519 $w=5.4e-08 $l=1.45e-08 $layer=N_src_drn $thickness=1e-09
+ $X=0.108 $Y=0.054 $X2=0.1225 $Y2=0.054
r5 10 4 0.268519 $w=5.4e-08 $l=1.45e-08 $layer=N_src_drn $thickness=1e-09
+ $X=0.0935 $Y=0.054 $X2=0.108 $Y2=0.054
r6 45 10 0.0462963 $w=5.4e-08 $l=2.5e-09 $layer=N_src_drn $thickness=1e-09
+ $X=0.0906 $Y=0.054 $X2=0.0935 $Y2=0.054
r7 3 41 19.3796 $a=3.24e-16 $layer=V0LISD $X=0.054 $Y=0.216 $X2=0.054 $Y2=0.233
r8 4 34 19.3796 $a=3.24e-16 $layer=V0LISD $X=0.108 $Y=0.054 $X2=0.108 $Y2=0.036
r9 41 42 3.14806 $w=1.3e-08 $l=1.35e-08 $layer=M1 $thickness=3.6e-08 $X=0.054
+ $Y=0.233 $X2=0.0675 $Y2=0.233
r10 39 42 3.14806 $w=1.3e-08 $l=1.35e-08 $layer=M1 $thickness=3.6e-08 $X=0.081
+ $Y=0.233 $X2=0.0675 $Y2=0.233
r11 38 39 6.29612 $w=1.3e-08 $l=2.7e-08 $layer=M1 $thickness=3.6e-08 $X=0.108
+ $Y=0.233 $X2=0.081 $Y2=0.233
r12 37 38 6.29612 $w=1.3e-08 $l=2.7e-08 $layer=M1 $thickness=3.6e-08 $X=0.135
+ $Y=0.233 $X2=0.108 $Y2=0.233
r13 14 37 6.29612 $w=1.3e-08 $l=2.7e-08 $layer=M1 $thickness=3.6e-08 $X=0.162
+ $Y=0.233 $X2=0.135 $Y2=0.233
r14 34 35 3.14806 $w=1.3e-08 $l=1.35e-08 $layer=M1 $thickness=3.6e-08 $X=0.108
+ $Y=0.036 $X2=0.1215 $Y2=0.036
r15 32 35 3.14806 $w=1.3e-08 $l=1.35e-08 $layer=M1 $thickness=3.6e-08 $X=0.135
+ $Y=0.036 $X2=0.1215 $Y2=0.036
r16 15 32 6.29612 $w=1.3e-08 $l=2.7e-08 $layer=M1 $thickness=3.6e-08 $X=0.162
+ $Y=0.036 $X2=0.135 $Y2=0.036
r17 13 30 0.983973 $w=1.77222e-08 $l=9e-09 $layer=M1 $thickness=3.6e-08
+ $X=0.189 $Y=0.2325 $X2=0.189 $Y2=0.2235
r18 13 14 5.06479 $w=1.46038e-08 $l=2.70046e-08 $layer=M1 $thickness=3.6e-08
+ $X=0.189 $Y=0.2325 $X2=0.162 $Y2=0.233
r19 12 25 3.36447 $w=1.71023e-08 $l=2.15e-08 $layer=M1 $thickness=3.6e-08
+ $X=0.189 $Y=0.036 $X2=0.189 $Y2=0.0575
r20 12 15 4.64701 $w=1.46667e-08 $l=2.7e-08 $layer=M1 $thickness=3.6e-08
+ $X=0.189 $Y=0.036 $X2=0.162 $Y2=0.036
r21 29 30 2.91487 $w=1.3e-08 $l=1.25e-08 $layer=M1 $thickness=3.6e-08 $X=0.189
+ $Y=0.211 $X2=0.189 $Y2=0.2235
r22 28 29 2.91487 $w=1.3e-08 $l=1.25e-08 $layer=M1 $thickness=3.6e-08 $X=0.189
+ $Y=0.1985 $X2=0.189 $Y2=0.211
r23 27 28 1.74892 $w=1.3e-08 $l=7.5e-09 $layer=M1 $thickness=3.6e-08 $X=0.189
+ $Y=0.191 $X2=0.189 $Y2=0.1985
r24 26 27 9.211 $w=1.3e-08 $l=3.95e-08 $layer=M1 $thickness=3.6e-08 $X=0.189
+ $Y=0.1515 $X2=0.189 $Y2=0.191
r25 24 25 3.14806 $w=1.3e-08 $l=1.35e-08 $layer=M1 $thickness=3.6e-08 $X=0.189
+ $Y=0.071 $X2=0.189 $Y2=0.0575
r26 16 24 5.71315 $w=1.3e-08 $l=2.45e-08 $layer=M1 $thickness=3.6e-08 $X=0.189
+ $Y=0.0955 $X2=0.189 $Y2=0.071
r27 16 26 13.0586 $w=1.3e-08 $l=5.6e-08 $layer=M1 $thickness=3.6e-08 $X=0.189
+ $Y=0.0955 $X2=0.189 $Y2=0.1515
r28 1 19 9.83583 $w=1.77619e-08 $l=1e-09 $layer=LIG $thickness=5.21905e-08
+ $X=0.189 $Y=0.134 $X2=0.189 $Y2=0.135
r29 1 26 19.3796 $a=3.24e-16 $layer=V0LIG $X=0.189 $Y=0.134 $X2=0.189 $Y2=0.1515
r30 21 20 16.4967 $w=2.1e-08 $l=4.85e-08 $layer=Gate_1 $thickness=5.6e-08
+ $X=0.189 $Y=0.2025 $X2=0.189 $Y2=0.154
r31 19 20 6.6497 $w=2.04211e-08 $l=1.9e-08 $layer=Gate_1 $thickness=5.6e-08
+ $X=0.189 $Y=0.135 $X2=0.189 $Y2=0.154
r32 18 19 6.6497 $w=2.04211e-08 $l=1.9e-08 $layer=Gate_1 $thickness=5.6e-08
+ $X=0.189 $Y=0.116 $X2=0.189 $Y2=0.135
r33 17 18 16.4967 $w=2.1e-08 $l=4.85e-08 $layer=Gate_1 $thickness=5.6e-08
+ $X=0.189 $Y=0.0675 $X2=0.189 $Y2=0.116
r34 17 9 14.6259 $w=2.1e-08 $l=4.3e-08 $layer=Gate_1 $thickness=5.6e-08
+ $X=0.189 $Y=0.0675 $X2=0.189 $Y2=0.0245
r35 3 11 1e-05 $l=2e-09 $X=0.054 $Y=0.216 $X2=0.056 $Y2=0.216
.ends

.subckt PM_ICGx1_ASAP7_75t_R%ENA vss 15 5 11 1 4 3
c1 1 vss 0.00297912f $X=0.081 $Y=0.135
c2 3 vss 0.0423152f $X=0.081 $Y=0.0245
c3 4 vss 0.00958069f $X=0.081 $Y=0.0972
r1 16 17 2.3902 $w=1.3e-08 $l=1.03e-08 $layer=M1 $thickness=3.6e-08 $X=0.081
+ $Y=0.1267 $X2=0.081 $Y2=0.137
r2 15 16 0.408082 $w=1.3e-08 $l=1.7e-09 $layer=M1 $thickness=3.6e-08 $X=0.082
+ $Y=0.125 $X2=0.081 $Y2=0.1267
r3 15 4 6.47102 $w=1.3e-08 $l=2.78e-08 $layer=M1 $thickness=3.6e-08 $X=0.082
+ $Y=0.125 $X2=0.081 $Y2=0.0972
r4 1 8 6.54019 $w=2.09524e-08 $layer=Gate_1 $thickness=5.21905e-08 $X=0.081
+ $Y=0.135 $X2=0.081 $Y2=0.135
r5 1 17 19.3796 $a=3.24e-16 $layer=V0LIG $X=0.081 $Y=0.135 $X2=0.081 $Y2=0.137
r6 11 10 14.6259 $w=2.1e-08 $l=4.3e-08 $layer=Gate_1 $thickness=5.6e-08
+ $X=0.081 $Y=0.216 $X2=0.081 $Y2=0.173
r7 9 10 7.31297 $w=2.1e-08 $l=2.15e-08 $layer=Gate_1 $thickness=5.6e-08
+ $X=0.081 $Y=0.1515 $X2=0.081 $Y2=0.173
r8 8 9 5.79936 $w=2.03333e-08 $l=1.65e-08 $layer=Gate_1 $thickness=5.6e-08
+ $X=0.081 $Y=0.135 $X2=0.081 $Y2=0.1515
r9 7 8 5.79936 $w=2.03333e-08 $l=1.65e-08 $layer=Gate_1 $thickness=5.6e-08
+ $X=0.081 $Y=0.1185 $X2=0.081 $Y2=0.135
r10 6 7 7.31297 $w=2.1e-08 $l=2.15e-08 $layer=Gate_1 $thickness=5.6e-08
+ $X=0.081 $Y=0.097 $X2=0.081 $Y2=0.1185
r11 5 6 14.6259 $w=2.1e-08 $l=4.3e-08 $layer=Gate_1 $thickness=5.6e-08 $X=0.081
+ $Y=0.054 $X2=0.081 $Y2=0.097
r12 5 3 10.0341 $w=2.1e-08 $l=2.95e-08 $layer=Gate_1 $thickness=5.6e-08
+ $X=0.081 $Y=0.054 $X2=0.081 $Y2=0.0245
.ends

* End of included file ICGx1_ASAP7_75t_R.pex.sp.pex

*
.subckt ICGx1_ASAP7_75t_CUSTOM_4_25_0_7 VSS VDD ENA SE CLK GCLK
*
* VSS VSS
* VDD VDD
* ENA ENA
* SE SE
* CLK CLK
* GCLK GCLK
*
*

M0 N_M0_d N_M0_g VSS VSS nmos_rvt L=2e-08 W=5.4e-08 nfin=2 $X=0.071 $Y=0.027
M1 VSS N_M1_g N_M1_s VSS nmos_rvt L=2e-08 W=5.4e-08 nfin=2 $X=0.125 $Y=0.027
M2 N_M2_d N_M2_g VSS VSS nmos_rvt L=2e-08 W=8.1e-08 nfin=3 $X=0.179 $Y=0.027
M3 N_M3_d N_M3_g N_M3_s VSS nmos_rvt L=2e-08 W=8.1e-08 nfin=3 $X=0.287 $Y=0.027
M4 N_M4_d N_M4_g N_M4_s VSS nmos_rvt L=2e-08 W=2.7e-08 nfin=1 $X=0.341 $Y=0.027
M5 VSS N_M5_g N_M5_s VSS nmos_rvt L=2e-08 W=2.7e-08 nfin=1 $X=0.395 $Y=0.027
M6 N_M6_d N_M6_g VSS VSS nmos_rvt L=2e-08 W=2.7e-08 nfin=1 $X=0.449 $Y=0.027
M7 VSS N_M7_g N_M7_s VSS nmos_rvt L=2e-08 W=8.1e-08 nfin=3 $X=0.611 $Y=0.027
M8 VSS N_M8_g N_M8_s VSS nmos_rvt L=2e-08 W=8.1e-08 nfin=3 $X=0.665 $Y=0.027
M9 N_M9_d N_M9_g N_M9_s VSS nmos_rvt L=2e-08 W=8.1e-08 nfin=3 $X=0.719 $Y=0.027
M10 N_M10_d N_M10_g N_M10_s VSS nmos_rvt L=2e-08 W=8.1e-08 nfin=3 $X=0.773
+ $Y=0.027
M11 VSS N_M11_g N_M11_s VSS nmos_rvt L=2e-08 W=8.1e-08 nfin=3 $X=0.827 $Y=0.027
M12 N_M12_d N_M12_g VSS VSS nmos_rvt L=2e-08 W=8.1e-08 nfin=3 $X=0.881 $Y=0.027
M13 N_M13_d N_M13_g N_M13_s VDD pmos_rvt L=2e-08 W=5.4e-08 nfin=2 $X=0.071
+ $Y=0.189
M14 VDD N_M14_g N_M14_s VDD pmos_rvt L=2e-08 W=5.4e-08 nfin=2 $X=0.125 $Y=0.189
M15 N_M15_d N_M15_g VDD VDD pmos_rvt L=2e-08 W=8.1e-08 nfin=3 $X=0.179 $Y=0.162
M16 N_M16_d N_M16_g N_M16_s VDD pmos_rvt L=2e-08 W=8.1e-08 nfin=3 $X=0.233
+ $Y=0.162
M17 N_M17_d N_M17_g N_M17_s VDD pmos_rvt L=2e-08 W=2.7e-08 nfin=1 $X=0.287
+ $Y=0.216
M18 VDD N_M18_g N_M18_s VDD pmos_rvt L=2e-08 W=2.7e-08 nfin=1 $X=0.395 $Y=0.216
M19 N_M19_d N_M19_g VDD VDD pmos_rvt L=2e-08 W=2.7e-08 nfin=1 $X=0.449 $Y=0.216
M20 VDD N_M20_g N_M20_s VDD pmos_rvt L=2e-08 W=8.1e-08 nfin=3 $X=0.611 $Y=0.162
M21 N_M21_d N_M21_g VDD VDD pmos_rvt L=2e-08 W=5.4e-08 nfin=2 $X=0.665 $Y=0.189
M22 VDD N_M22_g N_M22_s VDD pmos_rvt L=2e-08 W=5.4e-08 nfin=2 $X=0.719 $Y=0.189
M23 VDD N_M23_g N_M23_s VDD pmos_rvt L=2e-08 W=5.4e-08 nfin=2 $X=0.773 $Y=0.189
M24 N_M24_d N_M24_g VDD VDD pmos_rvt L=2e-08 W=5.4e-08 nfin=2 $X=0.827 $Y=0.189
M25 N_M25_d N_M25_g VDD VDD pmos_rvt L=2e-08 W=8.1e-08 nfin=3 $X=0.881 $Y=0.162

* .include "ICGx1_ASAP7_75t_R.pex.sp.pxi"

* Start of included file ICGx1_ASAP7_75t_R.pex.sp.pxi
x_PM_ICGx1_ASAP7_75t_R%GCLK vss GCLK N_M12_d N_M25_d N_GCLK_7 N_GCLK_12
+ N_GCLK_11 N_GCLK_8 N_GCLK_13 PM_ICGx1_ASAP7_75t_R%GCLK
cc_1 N_GCLK_7 N_10_1 0.00238891f $X=0.9035 $Y=0.0675
cc_2 N_GCLK_7 N_10_20 0.000856468f $X=0.9035 $Y=0.0675
cc_3 N_GCLK_12 N_10_18 0.00215736f $X=0.918 $Y=0.234
cc_4 N_GCLK_11 N_10_17 0.00298296f $X=0.9045 $Y=0.036
cc_5 N_GCLK_8 N_10_12 0.0148977f $X=0.9035 $Y=0.2025
cc_6 N_GCLK_13 N_10_22 0.00552158f $X=0.945 $Y=0.054
cc_7 N_GCLK_7 N_10_12 0.0597621f $X=0.9035 $Y=0.0675
x_PM_ICGx1_ASAP7_75t_R%SE vss SE N_M1_g N_M14_g N_SE_3 N_SE_4 N_SE_1
+ PM_ICGx1_ASAP7_75t_R%SE
cc_8 N_SE_3 N_ENA_1 0.00152447f $X=0.135 $Y=0.0245
cc_9 N_SE_4 N_ENA_4 0.00464095f $X=0.135 $Y=0.0972
cc_10 N_SE_3 N_ENA_3 0.0125602f $X=0.135 $Y=0.0245
x_PM_ICGx1_ASAP7_75t_R%18 vss N_M13_d N_M14_s N_18_1 PM_ICGx1_ASAP7_75t_R%18
cc_11 N_18_1 N_ENA_3 0.0126058f $X=0.108 $Y=0.216
cc_12 N_18_1 N_SE_3 0.00566026f $X=0.108 $Y=0.216
x_PM_ICGx1_ASAP7_75t_R%CLK vss CLK N_M10_g N_M23_g N_M9_g N_M22_g N_M7_g
+ N_M20_g N_M16_g N_M4_g N_CLK_23 N_CLK_1 N_CLK_10 N_CLK_19 N_CLK_17 N_CLK_15
+ N_CLK_20 N_CLK_16 N_CLK_8 N_CLK_12 N_CLK_21 N_CLK_2 N_CLK_3 N_CLK_11 N_CLK_22
+ N_CLK_18 N_CLK_4 N_CLK_14 N_CLK_13 PM_ICGx1_ASAP7_75t_R%CLK
cc_13 N_CLK_23 N_5_16 0.000623816f $X=0.597 $Y=0.153
cc_14 N_CLK_1 N_5_1 0.00186185f $X=0.243 $Y=0.1335
cc_15 N_CLK_10 N_5_9 0.0032263f $X=0.243 $Y=0.1335
cc_16 N_CLK_19 N_5_16 0.0046035f $X=0.243 $Y=0.1215
x_PM_ICGx1_ASAP7_75t_R%7 vss N_M3_g N_M17_g N_M7_s N_M20_s N_7_11 N_7_15 N_7_3
+ N_7_16 N_7_17 N_7_1 N_7_10 N_7_14 N_7_12 N_7_13 N_7_4 N_7_9
+ PM_ICGx1_ASAP7_75t_R%7
cc_17 N_7_11 N_CLK_17 0.00035076f $X=0.596 $Y=0.2025
cc_18 N_7_11 N_CLK_23 0.000159649f $X=0.596 $Y=0.2025
cc_19 N_7_11 N_CLK_15 0.000164452f $X=0.596 $Y=0.2025
cc_20 N_7_15 N_CLK_19 0.00395981f $X=0.297 $Y=0.0955
cc_21 N_7_3 N_CLK_20 0.000312186f $X=0.594 $Y=0.0605
cc_22 N_7_16 N_CLK_20 0.00444891f $X=0.568 $Y=0.148
cc_23 N_7_17 N_CLK_16 0.000390719f $X=0.2985 $Y=0.189
cc_24 N_7_1 N_CLK_8 0.000400544f $X=0.297 $Y=0.1335
cc_25 N_7_10 N_CLK_12 0.0153137f $X=0.596 $Y=0.0675
cc_26 N_7_14 N_CLK_21 0.000438211f $X=0.568 $Y=0.232
cc_27 N_7_12 N_CLK_19 0.000456454f $X=0.2945 $Y=0.189
cc_28 N_7_12 N_CLK_23 0.000585213f $X=0.2945 $Y=0.189
cc_29 N_7_1 N_CLK_2 0.000585351f $X=0.297 $Y=0.1335
cc_30 N_7_16 N_CLK_23 0.000631809f $X=0.568 $Y=0.148
cc_31 N_7_3 N_CLK_3 0.000806492f $X=0.594 $Y=0.0605
cc_32 N_7_1 N_CLK_1 0.0025008f $X=0.297 $Y=0.1335
cc_33 N_7_3 N_CLK_12 0.000943874f $X=0.594 $Y=0.0605
cc_34 N_7_13 N_CLK_20 0.000976986f $X=0.568 $Y=0.086
cc_35 N_7_4 N_CLK_12 0.00135412f $X=0.594 $Y=0.2295
cc_36 N_7_9 N_CLK_10 0.00162492f $X=0.297 $Y=0.0245
cc_37 N_7_14 N_CLK_17 0.00172918f $X=0.568 $Y=0.232
cc_38 N_7_11 N_CLK_3 0.00175707f $X=0.596 $Y=0.2025
cc_39 N_7_9 N_CLK_11 0.00881453f $X=0.297 $Y=0.0245
cc_40 N_7_17 N_CLK_23 0.0236402f $X=0.2985 $Y=0.189
cc_41 N_7_11 N_CLK_12 0.0427685f $X=0.596 $Y=0.2025
x_PM_ICGx1_ASAP7_75t_R%8 vss N_M5_g N_M18_g N_M6_d N_M19_d N_8_9 N_8_1 N_8_14
+ N_8_15 N_8_12 N_8_13 N_8_4 N_8_11 N_8_3 N_8_10 PM_ICGx1_ASAP7_75t_R%8
cc_42 N_8_9 N_CLK_20 8.51921e-20 $X=0.405 $Y=0.0245
cc_43 N_8_9 N_CLK_16 0.000324887f $X=0.405 $Y=0.0245
cc_44 N_8_9 N_CLK_23 0.000173783f $X=0.405 $Y=0.0245
cc_45 N_8_9 N_CLK_8 0.00285646f $X=0.405 $Y=0.0245
cc_46 N_8_9 N_CLK_15 0.000466423f $X=0.405 $Y=0.0245
cc_47 N_8_1 N_CLK_8 0.00141587f $X=0.396 $Y=0.082
cc_48 N_8_14 N_CLK_16 0.000642637f $X=0.3965 $Y=0.082
cc_49 N_8_14 N_CLK_23 0.00157105f $X=0.3965 $Y=0.082
cc_50 N_8_15 N_CLK_23 0.00157823f $X=0.5125 $Y=0.093
cc_51 N_8_14 N_CLK_15 0.00248415f $X=0.3965 $Y=0.082
cc_52 N_8_9 N_CLK_11 0.0127696f $X=0.405 $Y=0.0245
cc_53 N_8_15 N_7_13 0.000228667f $X=0.5125 $Y=0.093
cc_54 N_8_15 N_7_3 0.000280756f $X=0.5125 $Y=0.093
cc_55 N_8_15 N_7_4 0.000292444f $X=0.5125 $Y=0.093
cc_56 N_8_12 N_7_14 0.000806226f $X=0.5125 $Y=0.233
cc_57 N_8_13 N_7_13 0.000937378f $X=0.5125 $Y=0.082
cc_58 N_8_12 N_7_17 0.00155743f $X=0.5125 $Y=0.233
cc_59 N_8_15 N_7_16 0.00631366f $X=0.5125 $Y=0.093
x_PM_ICGx1_ASAP7_75t_R%10 vss N_M12_g N_M25_g N_M10_s N_M9_s N_M23_s N_M24_d
+ N_M21_d N_M22_s N_10_13 N_10_3 N_10_19 N_10_5 N_10_4 N_10_14 N_10_15 N_10_20
+ N_10_16 N_10_1 N_10_22 N_10_12 N_10_18 N_10_17 PM_ICGx1_ASAP7_75t_R%10
cc_60 N_10_13 N_CLK_18 0.000386341f $X=0.7415 $Y=0.0675
cc_61 N_10_13 N_CLK_4 0.000124812f $X=0.7415 $Y=0.0675
cc_62 N_10_13 N_CLK_13 0.035446f $X=0.7415 $Y=0.0675
cc_63 N_10_13 N_CLK_22 0.000400861f $X=0.7415 $Y=0.0675
cc_64 N_10_3 N_CLK_21 0.000421158f $X=0.702 $Y=0.216
cc_65 N_10_3 N_CLK_4 0.000438723f $X=0.702 $Y=0.216
cc_66 N_10_19 N_CLK_22 0.000467279f $X=0.783 $Y=0.231
cc_67 N_10_5 N_CLK_14 0.000760457f $X=0.81 $Y=0.216
cc_68 N_10_3 N_CLK_13 0.00114534f $X=0.702 $Y=0.216
cc_69 N_10_4 N_CLK_14 0.00141691f $X=0.756 $Y=0.0675
cc_70 N_10_19 N_CLK_21 0.00247527f $X=0.783 $Y=0.231
cc_71 N_10_14 N_CLK_4 0.00249043f $X=0.6875 $Y=0.216
cc_72 N_10_19 N_CLK_18 0.00366981f $X=0.783 $Y=0.231
cc_73 N_10_15 N_CLK_14 0.0106476f $X=0.7955 $Y=0.216
cc_74 N_10_14 N_CLK_13 0.0109074f $X=0.6875 $Y=0.216
cc_75 N_10_13 N_CLK_14 0.0644356f $X=0.7415 $Y=0.0675
cc_76 N_10_14 N_9_25 0.000551741f $X=0.6875 $Y=0.216
cc_77 N_10_14 N_9_24 0.000132989f $X=0.6875 $Y=0.216
cc_78 N_10_14 N_9_23 0.000135419f $X=0.6875 $Y=0.216
cc_79 N_10_14 N_9_2 0.000148965f $X=0.6875 $Y=0.216
cc_80 N_10_14 N_9_15 0.000613762f $X=0.6875 $Y=0.216
cc_81 N_10_3 N_9_14 0.000354391f $X=0.702 $Y=0.216
cc_82 N_10_20 N_9_32 0.000384984f $X=0.8805 $Y=0.072
cc_83 N_10_5 N_9_15 0.000390183f $X=0.81 $Y=0.216
cc_84 N_10_16 N_9_25 0.000474067f $X=0.837 $Y=0.192
cc_85 N_10_4 N_9_33 0.00196944f $X=0.756 $Y=0.0675
cc_86 N_10_20 N_9_25 0.00131421f $X=0.8805 $Y=0.072
cc_87 N_10_1 N_9_3 0.00283837f $X=0.891 $Y=0.1355
cc_88 N_10_22 N_9_25 0.00243839f $X=0.891 $Y=0.113
cc_89 N_10_15 N_9_15 0.0104836f $X=0.7955 $Y=0.216
cc_90 N_10_20 N_9_33 0.00889788f $X=0.8805 $Y=0.072
cc_91 N_10_12 N_9_15 0.0172359f $X=0.891 $Y=0.0245
cc_92 N_10_14 N_9_14 0.0254481f $X=0.6875 $Y=0.216
x_PM_ICGx1_ASAP7_75t_R%12 vss N_M2_d N_M3_s N_12_4 N_12_5 N_12_1
+ PM_ICGx1_ASAP7_75t_R%12
cc_93 N_12_4 N_5_16 0.000779146f $X=0.2015 $Y=0.0675
cc_94 N_12_4 N_5_9 0.0358976f $X=0.2015 $Y=0.0675
cc_95 N_12_4 N_CLK_19 0.000254815f $X=0.2015 $Y=0.0675
cc_96 N_12_4 N_CLK_1 0.00205374f $X=0.2015 $Y=0.0675
cc_97 N_12_4 N_CLK_10 0.0727254f $X=0.2015 $Y=0.0675
cc_98 N_12_5 N_7_15 0.000612851f $X=0.272 $Y=0.0675
cc_99 N_12_5 N_7_1 0.000677455f $X=0.272 $Y=0.0675
cc_100 N_12_5 N_7_9 0.0349019f $X=0.272 $Y=0.0675
cc_101 N_12_1 N_9_8 0.00118173f $X=0.243 $Y=0.0675
cc_102 N_12_1 N_9_17 0.000592461f $X=0.243 $Y=0.0675
cc_103 N_12_1 N_9_16 0.00198185f $X=0.243 $Y=0.0675
x_PM_ICGx1_ASAP7_75t_R%13 vss N_M15_d N_M16_s N_13_3 N_13_1
+ PM_ICGx1_ASAP7_75t_R%13
cc_104 N_13_3 N_5_1 0.000618121f $X=0.2015 $Y=0.2025
cc_105 N_13_3 N_5_9 0.0346912f $X=0.2015 $Y=0.2025
cc_106 N_13_3 N_CLK_19 0.000321709f $X=0.2015 $Y=0.2025
cc_107 N_13_3 N_CLK_1 0.000533234f $X=0.2015 $Y=0.2025
cc_108 N_13_3 N_CLK_10 0.0332212f $X=0.2015 $Y=0.2025
cc_109 N_13_1 N_9_18 0.000524381f $X=0.216 $Y=0.2025
cc_110 N_13_1 N_9_19 0.000566081f $X=0.216 $Y=0.2025
cc_111 N_13_1 N_9_7 0.00255099f $X=0.216 $Y=0.2025
x_PM_ICGx1_ASAP7_75t_R%14 vss N_M17_d N_M18_s N_14_5 N_14_1 N_14_4
+ PM_ICGx1_ASAP7_75t_R%14
cc_112 N_14_5 N_CLK_2 0.00015527f $X=0.38 $Y=0.2295
cc_113 N_14_1 N_CLK_11 0.000765918f $X=0.324 $Y=0.2295
cc_114 N_14_4 N_CLK_11 0.00642877f $X=0.3095 $Y=0.2295
cc_115 N_14_5 N_CLK_11 0.0251792f $X=0.38 $Y=0.2295
cc_116 N_14_4 N_7_9 0.0147042f $X=0.3095 $Y=0.2295
cc_117 N_14_5 N_8_9 0.0161347f $X=0.38 $Y=0.2295
cc_118 N_14_1 N_9_28 0.000138413f $X=0.324 $Y=0.2295
cc_119 N_14_1 N_9_29 0.000212675f $X=0.324 $Y=0.2295
cc_120 N_14_1 N_9_31 0.000254356f $X=0.324 $Y=0.2295
cc_121 N_14_4 N_9_18 0.00027878f $X=0.3095 $Y=0.2295
cc_122 N_14_4 N_9_19 0.000308749f $X=0.3095 $Y=0.2295
cc_123 N_14_1 N_9_26 0.000456231f $X=0.324 $Y=0.2295
cc_124 N_14_4 N_9_7 0.000509692f $X=0.3095 $Y=0.2295
cc_125 N_14_1 N_9_22 0.00252069f $X=0.324 $Y=0.2295
x_PM_ICGx1_ASAP7_75t_R%15 vss N_M4_d N_M5_s N_15_3 N_15_1
+ PM_ICGx1_ASAP7_75t_R%15
cc_126 N_15_3 N_CLK_11 0.0133171f $X=0.3635 $Y=0.0405
cc_127 N_15_3 N_8_9 0.0176993f $X=0.3635 $Y=0.0405
cc_128 N_15_1 N_9_28 0.000146417f $X=0.378 $Y=0.0405
cc_129 N_15_1 N_9_30 0.000230405f $X=0.378 $Y=0.0405
cc_130 N_15_1 N_9_16 0.00026117f $X=0.378 $Y=0.0405
cc_131 N_15_1 N_9_17 0.000308577f $X=0.378 $Y=0.0405
cc_132 N_15_1 N_9_8 0.0016851f $X=0.378 $Y=0.0405
x_PM_ICGx1_ASAP7_75t_R%16__2 vss N_M8_s N_M9_d N_16__2_1
+ PM_ICGx1_ASAP7_75t_R%16__2
cc_133 N_16__2_1 N_CLK_13 0.0169501f $X=0.702 $Y=0.0675
cc_134 N_16__2_1 N_9_14 0.0169255f $X=0.702 $Y=0.0675
x_PM_ICGx1_ASAP7_75t_R%17 vss N_M10_d N_M11_s N_17_1 PM_ICGx1_ASAP7_75t_R%17
cc_135 N_17_1 N_CLK_14 0.0169659f $X=0.81 $Y=0.0675
cc_136 N_17_1 N_9_15 0.0169233f $X=0.81 $Y=0.0675
x_PM_ICGx1_ASAP7_75t_R%9 vss N_M11_g N_M24_g N_M8_g N_M21_g N_M3_d N_M4_s
+ N_M6_g N_M19_g N_M16_d N_M17_s N_9_16 N_9_26 N_9_23 N_9_22 N_9_29 N_9_18
+ N_9_21 N_9_27 N_9_24 N_9_33 N_9_7 N_9_19 N_9_25 N_9_3 N_9_1 N_9_31 N_9_32
+ N_9_17 N_9_28 N_9_30 N_9_13 N_9_8 N_9_2 N_9_14 N_9_15 PM_ICGx1_ASAP7_75t_R%9
cc_137 N_9_16 N_CLK_22 5.60707e-20 $X=0.3095 $Y=0.0405
cc_138 N_9_26 N_CLK_19 0.000531568f $X=0.3365 $Y=0.232
cc_139 N_9_23 N_CLK_20 6.78246e-20 $X=0.675 $Y=0.036
cc_140 N_9_22 N_CLK_15 7.44761e-20 $X=0.358 $Y=0.2235
cc_141 N_9_29 N_CLK_15 8.98816e-20 $X=0.358 $Y=0.211
cc_142 N_9_18 N_CLK_10 0.00979303f $X=0.2555 $Y=0.2295
cc_143 N_9_21 N_CLK_15 0.000173868f $X=0.358 $Y=0.1895
cc_144 N_9_27 N_CLK_11 0.000202109f $X=0.3285 $Y=0.036
cc_145 N_9_24 N_CLK_20 0.00328813f $X=0.675 $Y=0.1075
cc_146 N_9_33 N_CLK_18 0.000208148f $X=0.7965 $Y=0.108
cc_147 N_9_7 N_CLK_19 0.000996385f $X=0.27 $Y=0.2295
cc_148 N_9_19 N_CLK_10 0.0241895f $X=0.2555 $Y=0.189
cc_149 N_9_25 N_CLK_4 0.000264088f $X=0.837 $Y=0.1205
cc_150 N_9_3 N_CLK_4 0.00027285f $X=0.837 $Y=0.135
cc_151 N_9_7 N_CLK_1 0.000272921f $X=0.27 $Y=0.2295
cc_152 N_9_1 N_CLK_8 0.000351617f $X=0.459 $Y=0.19
cc_153 N_9_33 N_CLK_4 0.000391601f $X=0.7965 $Y=0.108
cc_154 N_9_31 N_CLK_16 0.00490264f $X=0.3795 $Y=0.19
cc_155 N_9_32 N_CLK_20 0.000414668f $X=0.675 $Y=0.097
cc_156 N_9_1 N_CLK_16 0.000426476f $X=0.459 $Y=0.19
cc_157 N_9_17 N_CLK_11 0.00558743f $X=0.3095 $Y=0.081
cc_158 N_9_28 N_CLK_8 0.00261529f $X=0.358 $Y=0.0585
cc_159 N_9_18 N_CLK_1 0.000597196f $X=0.2555 $Y=0.2295
cc_160 N_9_3 N_CLK_14 0.000621895f $X=0.837 $Y=0.135
cc_161 N_9_30 N_CLK_23 0.000795227f $X=0.648 $Y=0.036
cc_162 N_9_13 N_CLK_8 0.000851751f $X=0.459 $Y=0.19
cc_163 N_9_8 N_CLK_11 0.000910586f $X=0.324 $Y=0.0405
cc_164 N_9_16 N_CLK_2 0.000934678f $X=0.3095 $Y=0.0405
cc_165 N_9_7 N_CLK_10 0.00114763f $X=0.27 $Y=0.2295
cc_166 N_9_31 N_CLK_15 0.00120323f $X=0.3795 $Y=0.19
cc_167 N_9_2 N_CLK_3 0.00344077f $X=0.675 $Y=0.135
cc_168 N_9_24 N_CLK_21 0.0013967f $X=0.675 $Y=0.1075
cc_169 N_9_14 N_CLK_4 0.00200764f $X=0.675 $Y=0.135
cc_170 N_9_31 N_CLK_23 0.00229443f $X=0.3795 $Y=0.19
cc_171 N_9_33 N_CLK_22 0.00355613f $X=0.7965 $Y=0.108
cc_172 N_9_14 N_CLK_13 0.00368134f $X=0.675 $Y=0.135
cc_173 N_9_28 N_CLK_15 0.00390437f $X=0.358 $Y=0.0585
cc_174 N_9_14 N_CLK_12 0.0068988f $X=0.675 $Y=0.135
cc_175 N_9_15 N_CLK_14 0.00704616f $X=0.837 $Y=0.0245
cc_176 N_9_16 N_CLK_11 0.0314291f $X=0.3095 $Y=0.0405
cc_177 N_9_1 N_7_9 0.000198409f $X=0.459 $Y=0.19
cc_178 N_9_33 N_7_9 0.000116344f $X=0.7965 $Y=0.108
cc_179 N_9_16 N_7_9 0.00982812f $X=0.3095 $Y=0.0405
cc_180 N_9_18 N_7_9 0.0109432f $X=0.2555 $Y=0.2295
cc_181 N_9_7 N_7_9 0.00147397f $X=0.27 $Y=0.2295
cc_182 N_9_8 N_7_15 0.000187312f $X=0.324 $Y=0.0405
cc_183 N_9_24 N_7_13 0.000228503f $X=0.675 $Y=0.1075
cc_184 N_9_22 N_7_12 0.000242719f $X=0.358 $Y=0.2235
cc_185 N_9_32 N_7_13 0.000264458f $X=0.675 $Y=0.097
cc_186 N_9_30 N_7_3 0.00112818f $X=0.648 $Y=0.036
cc_187 N_9_19 N_7_9 0.00556697f $X=0.2555 $Y=0.189
cc_188 N_9_27 N_7_15 0.000456588f $X=0.3285 $Y=0.036
cc_189 N_9_31 N_7_16 0.000483656f $X=0.3795 $Y=0.19
cc_190 N_9_26 N_7_12 0.00454108f $X=0.3365 $Y=0.232
cc_191 N_9_29 N_7_12 0.000521177f $X=0.358 $Y=0.211
cc_192 N_9_21 N_7_12 0.000638606f $X=0.358 $Y=0.1895
cc_193 N_9_8 N_7_1 0.000659636f $X=0.324 $Y=0.0405
cc_194 N_9_8 N_7_9 0.00131132f $X=0.324 $Y=0.0405
cc_195 N_9_16 N_7_1 0.00154615f $X=0.3095 $Y=0.0405
cc_196 N_9_31 N_7_17 0.00336179f $X=0.3795 $Y=0.19
cc_197 N_9_30 N_7_13 0.00412494f $X=0.648 $Y=0.036
cc_198 N_9_28 N_7_15 0.00457793f $X=0.358 $Y=0.0585
cc_199 N_9_17 N_7_9 0.0453363f $X=0.3095 $Y=0.081
cc_200 N_9_8 N_8_9 0.000271759f $X=0.324 $Y=0.0405
cc_201 N_9_1 N_8_9 0.000375515f $X=0.459 $Y=0.19
cc_202 N_9_30 N_8_9 0.000378543f $X=0.648 $Y=0.036
cc_203 N_9_13 N_8_1 0.000671617f $X=0.459 $Y=0.19
cc_204 N_9_30 N_8_1 0.000730946f $X=0.648 $Y=0.036
cc_205 N_9_1 N_8_4 0.00157746f $X=0.459 $Y=0.19
cc_206 N_9_1 N_8_11 0.00124276f $X=0.459 $Y=0.19
cc_207 N_9_28 N_8_14 0.00132735f $X=0.358 $Y=0.0585
cc_208 N_9_31 N_8_15 0.00153361f $X=0.3795 $Y=0.19
cc_209 N_9_13 N_8_3 0.00164165f $X=0.459 $Y=0.19
cc_210 N_9_31 N_8_12 0.00219337f $X=0.3795 $Y=0.19
cc_211 N_9_13 N_8_10 0.00636915f $X=0.459 $Y=0.19
cc_212 N_9_13 N_8_11 0.00663383f $X=0.459 $Y=0.19
cc_213 N_9_30 N_8_14 0.00360234f $X=0.648 $Y=0.036
cc_214 N_9_30 N_8_13 0.00509595f $X=0.648 $Y=0.036
cc_215 N_9_13 N_8_9 0.0302529f $X=0.459 $Y=0.19
x_PM_ICGx1_ASAP7_75t_R%5 vss N_M2_g N_M15_g N_M0_d N_M1_s N_M13_s N_5_16 N_5_15
+ N_5_4 N_5_11 N_5_3 N_5_14 N_5_10 N_5_1 N_5_9 PM_ICGx1_ASAP7_75t_R%5
cc_216 N_5_16 N_ENA_3 0.000425538f $X=0.189 $Y=0.0955
cc_217 N_5_15 N_ENA_4 0.000636119f $X=0.162 $Y=0.036
cc_218 N_5_4 N_ENA_3 0.000690733f $X=0.108 $Y=0.054
cc_219 N_5_11 N_ENA_1 0.000728847f $X=0.056 $Y=0.216
cc_220 N_5_3 N_ENA_3 0.00108554f $X=0.054 $Y=0.216
cc_221 N_5_14 N_ENA_4 0.00131644f $X=0.162 $Y=0.233
cc_222 N_5_4 N_ENA_4 0.00296341f $X=0.108 $Y=0.054
cc_223 N_5_11 N_ENA_3 0.0108834f $X=0.056 $Y=0.216
cc_224 N_5_10 N_ENA_3 0.0404347f $X=0.0935 $Y=0.054
cc_225 N_5_1 N_SE_3 0.00092113f $X=0.189 $Y=0.134
cc_226 N_5_15 N_SE_4 0.000964796f $X=0.162 $Y=0.036
cc_227 N_5_14 N_SE_4 0.00116369f $X=0.162 $Y=0.233
cc_228 N_5_1 N_SE_1 0.00133585f $X=0.189 $Y=0.134
cc_229 N_5_10 N_SE_3 0.0104705f $X=0.0935 $Y=0.054
cc_230 N_5_16 N_SE_4 0.0069705f $X=0.189 $Y=0.0955
cc_231 N_5_9 N_SE_3 0.0140639f $X=0.189 $Y=0.0245
x_PM_ICGx1_ASAP7_75t_R%ENA vss ENA N_M0_g N_M13_g N_ENA_1 N_ENA_4 N_ENA_3
+ PM_ICGx1_ASAP7_75t_R%ENA

* End of included file ICGx1_ASAP7_75t_R.pex.sp.pxi
.ends

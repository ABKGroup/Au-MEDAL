.subckt PM_SDFLx4_ASAP7_75t_R%CLK vss 16 6 12 3 4 1 5
c1 1 vss 0.00376316f $X=0.081 $Y=0.135
c2 3 vss 0.0902433f $X=0.081 $Y=0.0245
c3 4 vss 0.00165733f $X=0.081 $Y=0.072
c4 5 vss 0.00366454f $X=0.081 $Y=0.117
r1 4 15 3.48349 $w=1.525e-08 $l=2e-08 $layer=M1 $thickness=3.6e-08 $X=0.081
+ $Y=0.072 $X2=0.081 $Y2=0.092
r2 14 15 3.14806 $w=1.3e-08 $l=1.35e-08 $layer=M1 $thickness=3.6e-08 $X=0.081
+ $Y=0.1055 $X2=0.081 $Y2=0.092
r3 5 14 2.68168 $w=1.3e-08 $l=1.15e-08 $layer=M1 $thickness=3.6e-08 $X=0.081
+ $Y=0.117 $X2=0.081 $Y2=0.1055
r4 16 5 4.19742 $w=1.3e-08 $l=1.8e-08 $layer=M1 $thickness=3.6e-08 $X=0.081
+ $Y=0.1345 $X2=0.081 $Y2=0.117
r5 1 9 10.4265 $w=1.765e-08 $layer=LIG $thickness=5.2e-08 $X=0.081 $Y=0.135
+ $X2=0.081 $Y2=0.135
r6 16 1 19.3796 $a=3.24e-16 $layer=V0LIG $X=0.081 $Y=0.1345 $X2=0.081 $Y2=0.135
r7 12 11 14.6259 $w=2.1e-08 $l=4.3e-08 $layer=Gate_1 $thickness=5.6e-08
+ $X=0.081 $Y=0.2025 $X2=0.081 $Y2=0.1595
r8 10 11 2.7211 $w=2.1e-08 $l=8e-09 $layer=Gate_1 $thickness=5.6e-08 $X=0.081
+ $Y=0.1515 $X2=0.081 $Y2=0.1595
r9 9 10 5.79936 $w=2.03333e-08 $l=1.65e-08 $layer=Gate_1 $thickness=5.6e-08
+ $X=0.081 $Y=0.135 $X2=0.081 $Y2=0.1515
r10 8 9 5.79936 $w=2.03333e-08 $l=1.65e-08 $layer=Gate_1 $thickness=5.6e-08
+ $X=0.081 $Y=0.1185 $X2=0.081 $Y2=0.135
r11 7 8 2.7211 $w=2.1e-08 $l=8e-09 $layer=Gate_1 $thickness=5.6e-08 $X=0.081
+ $Y=0.1105 $X2=0.081 $Y2=0.1185
r12 6 7 14.6259 $w=2.1e-08 $l=4.3e-08 $layer=Gate_1 $thickness=5.6e-08 $X=0.081
+ $Y=0.0675 $X2=0.081 $Y2=0.1105
r13 6 3 14.6259 $w=2.1e-08 $l=4.3e-08 $layer=Gate_1 $thickness=5.6e-08 $X=0.081
+ $Y=0.0675 $X2=0.081 $Y2=0.0245
.ends

.subckt PM_SDFLx4_ASAP7_75t_R%7 vss 20 24 42 44 10 14 11 4 1 13 3 15 12 17 19 9
+ 18
c1 1 vss 0.00414127f $X=0.513 $Y=0.135
c2 3 vss 0.00873693f $X=0.324 $Y=0.0675
c3 4 vss 0.00823944f $X=0.324 $Y=0.2025
c4 9 vss 0.101474f $X=0.513 $Y=0.0245
c5 10 vss 0.0397445f $X=0.3095 $Y=0.0675
c6 11 vss 0.0398217f $X=0.3095 $Y=0.2025
c7 12 vss 0.00669069f $X=0.351 $Y=0.036
c8 13 vss 0.0054882f $X=0.351 $Y=0.234
c9 14 vss 0.000366684f $X=0.351 $Y=0.072
c10 15 vss 0.00272398f $X=0.513 $Y=0.072
c11 16 vss 0.000619676f $X=0.351 $Y=0.054
c12 17 vss 0.00189902f $X=0.351 $Y=0.09
c13 18 vss 0.0108182f $X=0.486 $Y=0.072
c14 19 vss 0.00306192f $X=0.513 $Y=0.1125
r1 11 4 0.154321 $w=8.1e-08 $l=1.25e-08 $layer=P_src_drn $thickness=1e-09
+ $X=0.3095 $Y=0.2025 $X2=0.324 $Y2=0.2025
r2 44 11 0.0308642 $w=8.1e-08 $l=2.5e-09 $layer=P_src_drn $thickness=1e-09
+ $X=0.3066 $Y=0.2025 $X2=0.3095 $Y2=0.2025
r3 10 3 0.154321 $w=8.1e-08 $l=1.25e-08 $layer=N_src_drn $thickness=1e-09
+ $X=0.3095 $Y=0.0675 $X2=0.324 $Y2=0.0675
r4 42 10 0.0308642 $w=8.1e-08 $l=2.5e-09 $layer=N_src_drn $thickness=1e-09
+ $X=0.3066 $Y=0.0675 $X2=0.3095 $Y2=0.0675
r5 4 39 19.3796 $a=3.24e-16 $layer=V0LISD $X=0.324 $Y=0.2025 $X2=0.324 $Y2=0.234
r6 3 36 19.3796 $a=3.24e-16 $layer=V0LISD $X=0.324 $Y=0.0675 $X2=0.324 $Y2=0.036
r7 39 40 3.14806 $w=1.3e-08 $l=1.35e-08 $layer=M1 $thickness=3.6e-08 $X=0.324
+ $Y=0.234 $X2=0.3375 $Y2=0.234
r8 13 34 10.3626 $w=1.39091e-08 $l=4.95e-08 $layer=M1 $thickness=3.6e-08
+ $X=0.351 $Y=0.234 $X2=0.351 $Y2=0.1845
r9 13 40 1.96775 $w=1.63333e-08 $l=1.35e-08 $layer=M1 $thickness=3.6e-08
+ $X=0.351 $Y=0.234 $X2=0.3375 $Y2=0.234
r10 36 37 3.14806 $w=1.3e-08 $l=1.35e-08 $layer=M1 $thickness=3.6e-08 $X=0.324
+ $Y=0.036 $X2=0.3375 $Y2=0.036
r11 12 16 3.01711 $w=1.55e-08 $l=1.8e-08 $layer=M1 $thickness=3.6e-08 $X=0.351
+ $Y=0.036 $X2=0.351 $Y2=0.054
r12 12 37 1.96775 $w=1.63333e-08 $l=1.35e-08 $layer=M1 $thickness=3.6e-08
+ $X=0.351 $Y=0.036 $X2=0.3375 $Y2=0.036
r13 33 34 11.5429 $w=1.3e-08 $l=4.95e-08 $layer=M1 $thickness=3.6e-08 $X=0.351
+ $Y=0.135 $X2=0.351 $Y2=0.1845
r14 32 33 5.24677 $w=1.3e-08 $l=2.25e-08 $layer=M1 $thickness=3.6e-08 $X=0.351
+ $Y=0.1125 $X2=0.351 $Y2=0.135
r15 17 32 5.24677 $w=1.3e-08 $l=2.25e-08 $layer=M1 $thickness=3.6e-08 $X=0.351
+ $Y=0.09 $X2=0.351 $Y2=0.1125
r16 14 31 3.01711 $w=1.55e-08 $l=1.8e-08 $layer=M1 $thickness=3.6e-08 $X=0.351
+ $Y=0.072 $X2=0.369 $Y2=0.072
r17 14 16 3.01711 $w=1.55e-08 $l=1.8e-08 $layer=M1 $thickness=3.6e-08 $X=0.351
+ $Y=0.072 $X2=0.351 $Y2=0.054
r18 14 17 3.01711 $w=1.55e-08 $l=1.8e-08 $layer=M1 $thickness=3.6e-08 $X=0.351
+ $Y=0.072 $X2=0.351 $Y2=0.09
r19 30 31 6.7625 $w=1.3e-08 $l=2.9e-08 $layer=M1 $thickness=3.6e-08 $X=0.398
+ $Y=0.072 $X2=0.369 $Y2=0.072
r20 29 30 10.4935 $w=1.3e-08 $l=4.5e-08 $layer=M1 $thickness=3.6e-08 $X=0.443
+ $Y=0.072 $X2=0.398 $Y2=0.072
r21 18 29 10.0272 $w=1.3e-08 $l=4.3e-08 $layer=M1 $thickness=3.6e-08 $X=0.486
+ $Y=0.072 $X2=0.443 $Y2=0.072
r22 15 28 2.5483 $w=1.79e-08 $l=1.8e-08 $layer=M1 $thickness=3.6e-08 $X=0.513
+ $Y=0.072 $X2=0.513 $Y2=0.09
r23 15 18 4.64701 $w=1.46667e-08 $l=2.7e-08 $layer=M1 $thickness=3.6e-08
+ $X=0.513 $Y=0.072 $X2=0.486 $Y2=0.072
r24 19 26 5.24677 $w=1.3e-08 $l=2.25e-08 $layer=M1 $thickness=3.6e-08 $X=0.513
+ $Y=0.1125 $X2=0.513 $Y2=0.135
r25 19 28 5.24677 $w=1.3e-08 $l=2.25e-08 $layer=M1 $thickness=3.6e-08 $X=0.513
+ $Y=0.1125 $X2=0.513 $Y2=0.09
r26 1 22 10.4265 $w=1.765e-08 $layer=LIG $thickness=5.2e-08 $X=0.513 $Y=0.135
+ $X2=0.513 $Y2=0.135
r27 1 26 19.3796 $a=3.24e-16 $layer=V0LIG $X=0.513 $Y=0.135 $X2=0.513 $Y2=0.135
r28 24 23 16.4967 $w=2.1e-08 $l=4.85e-08 $layer=Gate_1 $thickness=5.6e-08
+ $X=0.513 $Y=0.2025 $X2=0.513 $Y2=0.154
r29 22 23 6.6497 $w=2.04211e-08 $l=1.9e-08 $layer=Gate_1 $thickness=5.6e-08
+ $X=0.513 $Y=0.135 $X2=0.513 $Y2=0.154
r30 21 22 6.6497 $w=2.04211e-08 $l=1.9e-08 $layer=Gate_1 $thickness=5.6e-08
+ $X=0.513 $Y=0.116 $X2=0.513 $Y2=0.135
r31 20 21 16.4967 $w=2.1e-08 $l=4.85e-08 $layer=Gate_1 $thickness=5.6e-08
+ $X=0.513 $Y=0.0675 $X2=0.513 $Y2=0.116
r32 20 9 14.6259 $w=2.1e-08 $l=4.3e-08 $layer=Gate_1 $thickness=5.6e-08
+ $X=0.513 $Y=0.0675 $X2=0.513 $Y2=0.0245
.ends

.subckt PM_SDFLx4_ASAP7_75t_R%SI vss 19 13 17 4 12 3 1 8 7
c1 1 vss 0.00452521f $X=0.621 $Y=0.135
c2 3 vss 0.0641998f $X=0.621 $Y=0.0245
c3 4 vss 0.0019426f $X=0.621 $Y=0.115
c4 5 vss 0.00378036f $X=0.648 $Y=0.072
c5 6 vss 0.00417157f $X=0.702 $Y=0.036
c6 7 vss 0.00141313f $X=0.702 $Y=0.0665
c7 8 vss 0.00115495f $X=0.621 $Y=0.125
c8 9 vss 0.00177611f $X=0.648 $Y=0.0935
c9 10 vss 0.00321438f $X=0.6595 $Y=0.072
c10 11 vss 0.00170838f $X=0.702 $Y=0.054
c11 12 vss 0.0068292f $X=0.7245 $Y=0.036
r1 6 11 2.5483 $w=1.79e-08 $l=1.8e-08 $layer=M1 $thickness=3.6e-08 $X=0.702
+ $Y=0.036 $X2=0.702 $Y2=0.054
r2 6 12 3.59766 $w=1.5e-08 $l=2.25e-08 $layer=M1 $thickness=3.6e-08 $X=0.702
+ $Y=0.036 $X2=0.7245 $Y2=0.036
r3 7 24 1.40651 $w=1.51875e-08 $l=1.45774e-08 $layer=M1 $thickness=3.6e-08
+ $X=0.702 $Y=0.0665 $X2=0.6885 $Y2=0.072
r4 7 11 2.45586 $w=1.44e-08 $l=1.25e-08 $layer=M1 $thickness=3.6e-08 $X=0.702
+ $Y=0.0665 $X2=0.702 $Y2=0.054
r5 23 24 3.61444 $w=1.3e-08 $l=1.55e-08 $layer=M1 $thickness=3.6e-08 $X=0.673
+ $Y=0.072 $X2=0.6885 $Y2=0.072
r6 10 23 3.14806 $w=1.3e-08 $l=1.35e-08 $layer=M1 $thickness=3.6e-08 $X=0.6595
+ $Y=0.072 $X2=0.673 $Y2=0.072
r7 5 9 3.36447 $w=1.71023e-08 $l=2.15e-08 $layer=M1 $thickness=3.6e-08 $X=0.648
+ $Y=0.072 $X2=0.648 $Y2=0.0935
r8 5 10 1.03257 $w=1.6913e-08 $l=1.15e-08 $layer=M1 $thickness=3.6e-08 $X=0.648
+ $Y=0.072 $X2=0.6595 $Y2=0.072
r9 9 22 3.83327 $w=1.5093e-08 $l=2.15e-08 $layer=M1 $thickness=3.6e-08 $X=0.648
+ $Y=0.0935 $X2=0.648 $Y2=0.115
r10 21 22 1.96775 $w=1.63333e-08 $l=1.35e-08 $layer=M1 $thickness=3.6e-08
+ $X=0.6345 $Y=0.115 $X2=0.648 $Y2=0.115
r11 4 8 1.15159 $w=1.75e-08 $l=1e-08 $layer=M1 $thickness=3.6e-08 $X=0.621
+ $Y=0.115 $X2=0.621 $Y2=0.125
r12 4 21 1.96775 $w=1.63333e-08 $l=1.35e-08 $layer=M1 $thickness=3.6e-08
+ $X=0.621 $Y=0.115 $X2=0.6345 $Y2=0.115
r13 19 8 2.3319 $w=1.3e-08 $l=1e-08 $layer=M1 $thickness=3.6e-08 $X=0.621
+ $Y=0.1345 $X2=0.621 $Y2=0.125
r14 1 15 10.4265 $w=1.765e-08 $layer=LIG $thickness=5.2e-08 $X=0.621 $Y=0.135
+ $X2=0.621 $Y2=0.135
r15 19 1 19.3796 $a=3.24e-16 $layer=V0LIG $X=0.621 $Y=0.1345 $X2=0.621 $Y2=0.135
r16 17 16 16.4967 $w=2.1e-08 $l=4.85e-08 $layer=Gate_1 $thickness=5.6e-08
+ $X=0.621 $Y=0.2025 $X2=0.621 $Y2=0.154
r17 15 16 6.6497 $w=2.04211e-08 $l=1.9e-08 $layer=Gate_1 $thickness=5.6e-08
+ $X=0.621 $Y=0.135 $X2=0.621 $Y2=0.154
r18 14 15 6.6497 $w=2.04211e-08 $l=1.9e-08 $layer=Gate_1 $thickness=5.6e-08
+ $X=0.621 $Y=0.116 $X2=0.621 $Y2=0.135
r19 13 14 16.4967 $w=2.1e-08 $l=4.85e-08 $layer=Gate_1 $thickness=5.6e-08
+ $X=0.621 $Y=0.0675 $X2=0.621 $Y2=0.116
r20 13 3 14.6259 $w=2.1e-08 $l=4.3e-08 $layer=Gate_1 $thickness=5.6e-08
+ $X=0.621 $Y=0.0675 $X2=0.621 $Y2=0.0245
.ends

.subckt PM_SDFLx4_ASAP7_75t_R%15 vss 15 34 35 37 11 2 13 1 10 12 3
c1 1 vss 0.00632649f $X=0.432 $Y=0.2025
c2 2 vss 0.00535092f $X=0.54 $Y=0.2025
c3 3 vss 0.00339999f $X=0.648 $Y=0.2025
c4 10 vss 0.0365166f $X=0.434 $Y=0.2025
c5 11 vss 0.00314097f $X=0.5255 $Y=0.2025
c6 12 vss 0.00201587f $X=0.6335 $Y=0.2025
c7 13 vss 0.00500482f $X=0.432 $Y=0.198
r1 12 3 0.154321 $w=8.1e-08 $l=1.25e-08 $layer=P_src_drn $thickness=1e-09
+ $X=0.6335 $Y=0.2025 $X2=0.648 $Y2=0.2025
r2 37 12 0.0308642 $w=8.1e-08 $l=2.5e-09 $layer=P_src_drn $thickness=1e-09
+ $X=0.6306 $Y=0.2025 $X2=0.6335 $Y2=0.2025
r3 35 33 0.0308642 $w=8.1e-08 $l=2.5e-09 $layer=P_src_drn $thickness=1e-09
+ $X=0.5573 $Y=0.2025 $X2=0.5545 $Y2=0.2025
r4 2 33 0.179012 $w=8.1e-08 $l=1.45e-08 $layer=P_src_drn $thickness=1e-09
+ $X=0.54 $Y=0.2025 $X2=0.5545 $Y2=0.2025
r5 11 2 0.179012 $w=8.1e-08 $l=1.45e-08 $layer=P_src_drn $thickness=1e-09
+ $X=0.5255 $Y=0.2025 $X2=0.54 $Y2=0.2025
r6 34 11 0.0308642 $w=8.1e-08 $l=2.5e-09 $layer=P_src_drn $thickness=1e-09
+ $X=0.5226 $Y=0.2025 $X2=0.5255 $Y2=0.2025
r7 3 30 19.3796 $a=3.24e-16 $layer=V0LISD $X=0.648 $Y=0.2025 $X2=0.648 $Y2=0.198
r8 2 22 19.3796 $a=3.24e-16 $layer=V0LISD $X=0.54 $Y=0.2025 $X2=0.54 $Y2=0.198
r9 29 30 3.14806 $w=1.3e-08 $l=1.35e-08 $layer=M1 $thickness=3.6e-08 $X=0.6345
+ $Y=0.198 $X2=0.648 $Y2=0.198
r10 28 29 3.14806 $w=1.3e-08 $l=1.35e-08 $layer=M1 $thickness=3.6e-08 $X=0.621
+ $Y=0.198 $X2=0.6345 $Y2=0.198
r11 27 28 3.61444 $w=1.3e-08 $l=1.55e-08 $layer=M1 $thickness=3.6e-08 $X=0.6055
+ $Y=0.198 $X2=0.621 $Y2=0.198
r12 26 27 3.73104 $w=1.3e-08 $l=1.6e-08 $layer=M1 $thickness=3.6e-08 $X=0.5895
+ $Y=0.198 $X2=0.6055 $Y2=0.198
r13 25 26 2.68168 $w=1.3e-08 $l=1.15e-08 $layer=M1 $thickness=3.6e-08 $X=0.578
+ $Y=0.198 $X2=0.5895 $Y2=0.198
r14 24 25 2.56509 $w=1.3e-08 $l=1.1e-08 $layer=M1 $thickness=3.6e-08 $X=0.567
+ $Y=0.198 $X2=0.578 $Y2=0.198
r15 23 24 3.14806 $w=1.3e-08 $l=1.35e-08 $layer=M1 $thickness=3.6e-08 $X=0.5535
+ $Y=0.198 $X2=0.567 $Y2=0.198
r16 22 23 3.14806 $w=1.3e-08 $l=1.35e-08 $layer=M1 $thickness=3.6e-08 $X=0.54
+ $Y=0.198 $X2=0.5535 $Y2=0.198
r17 21 22 3.14806 $w=1.3e-08 $l=1.35e-08 $layer=M1 $thickness=3.6e-08 $X=0.5265
+ $Y=0.198 $X2=0.54 $Y2=0.198
r18 20 21 3.14806 $w=1.3e-08 $l=1.35e-08 $layer=M1 $thickness=3.6e-08 $X=0.513
+ $Y=0.198 $X2=0.5265 $Y2=0.198
r19 19 20 6.29612 $w=1.3e-08 $l=2.7e-08 $layer=M1 $thickness=3.6e-08 $X=0.486
+ $Y=0.198 $X2=0.513 $Y2=0.198
r20 18 19 5.24677 $w=1.3e-08 $l=2.25e-08 $layer=M1 $thickness=3.6e-08 $X=0.4635
+ $Y=0.198 $X2=0.486 $Y2=0.198
r21 17 18 2.09871 $w=1.3e-08 $l=9e-09 $layer=M1 $thickness=3.6e-08 $X=0.4545
+ $Y=0.198 $X2=0.4635 $Y2=0.198
r22 16 17 2.09871 $w=1.3e-08 $l=9e-09 $layer=M1 $thickness=3.6e-08 $X=0.4455
+ $Y=0.198 $X2=0.4545 $Y2=0.198
r23 13 16 3.14806 $w=1.3e-08 $l=1.35e-08 $layer=M1 $thickness=3.6e-08 $X=0.432
+ $Y=0.198 $X2=0.4455 $Y2=0.198
r24 1 13 19.3796 $a=3.24e-16 $layer=V0LISD $X=0.432 $Y=0.2025 $X2=0.432
+ $Y2=0.198
r25 15 14 0.0308642 $w=8.1e-08 $l=2.5e-09 $layer=P_src_drn $thickness=1e-09
+ $X=0.4493 $Y=0.2025 $X2=0.4465 $Y2=0.2025
r26 10 14 0.154321 $w=8.1e-08 $l=1.25e-08 $layer=P_src_drn $thickness=1e-09
+ $X=0.434 $Y=0.2025 $X2=0.4465 $Y2=0.2025
r27 1 10 1e-05 $l=2e-09 $X=0.432 $Y=0.2025 $X2=0.434 $Y2=0.2025
.ends

.subckt PM_SDFLx4_ASAP7_75t_R%16 vss 12 13 24 8 2 7 1 9
c1 1 vss 0.0041311f $X=0.594 $Y=0.2025
c2 2 vss 0.00509219f $X=0.756 $Y=0.2025
c3 7 vss 0.00199874f $X=0.5795 $Y=0.2025
c4 8 vss 0.0361914f $X=0.758 $Y=0.2025
c5 9 vss 0.0150555f $X=0.5825 $Y=0.234
r1 24 23 0.0308642 $w=8.1e-08 $l=2.5e-09 $layer=P_src_drn $thickness=1e-09
+ $X=0.7733 $Y=0.2025 $X2=0.7705 $Y2=0.2025
r2 8 23 0.154321 $w=8.1e-08 $l=1.25e-08 $layer=P_src_drn $thickness=1e-09
+ $X=0.758 $Y=0.2025 $X2=0.7705 $Y2=0.2025
r3 2 21 19.3796 $a=3.24e-16 $layer=V0LISD $X=0.756 $Y=0.2025 $X2=0.756 $Y2=0.234
r4 20 21 3.14806 $w=1.3e-08 $l=1.35e-08 $layer=M1 $thickness=3.6e-08 $X=0.7425
+ $Y=0.234 $X2=0.756 $Y2=0.234
r5 19 20 4.19742 $w=1.3e-08 $l=1.8e-08 $layer=M1 $thickness=3.6e-08 $X=0.7245
+ $Y=0.234 $X2=0.7425 $Y2=0.234
r6 18 19 4.19742 $w=1.3e-08 $l=1.8e-08 $layer=M1 $thickness=3.6e-08 $X=0.7065
+ $Y=0.234 $X2=0.7245 $Y2=0.234
r7 17 18 3.14806 $w=1.3e-08 $l=1.35e-08 $layer=M1 $thickness=3.6e-08 $X=0.693
+ $Y=0.234 $X2=0.7065 $Y2=0.234
r8 16 17 4.6638 $w=1.3e-08 $l=2e-08 $layer=M1 $thickness=3.6e-08 $X=0.673
+ $Y=0.234 $X2=0.693 $Y2=0.234
r9 15 16 9.44419 $w=1.3e-08 $l=4.05e-08 $layer=M1 $thickness=3.6e-08 $X=0.6325
+ $Y=0.234 $X2=0.673 $Y2=0.234
r10 14 15 8.97781 $w=1.3e-08 $l=3.85e-08 $layer=M1 $thickness=3.6e-08 $X=0.594
+ $Y=0.234 $X2=0.6325 $Y2=0.234
r11 9 14 2.68168 $w=1.3e-08 $l=1.15e-08 $layer=M1 $thickness=3.6e-08 $X=0.5825
+ $Y=0.234 $X2=0.594 $Y2=0.234
r12 1 14 19.3796 $a=3.24e-16 $layer=V0LISD $X=0.594 $Y=0.2025 $X2=0.594
+ $Y2=0.234
r13 13 11 0.0308642 $w=8.1e-08 $l=2.5e-09 $layer=P_src_drn $thickness=1e-09
+ $X=0.6113 $Y=0.2025 $X2=0.6085 $Y2=0.2025
r14 1 11 0.179012 $w=8.1e-08 $l=1.45e-08 $layer=P_src_drn $thickness=1e-09
+ $X=0.594 $Y=0.2025 $X2=0.6085 $Y2=0.2025
r15 7 1 0.179012 $w=8.1e-08 $l=1.45e-08 $layer=P_src_drn $thickness=1e-09
+ $X=0.5795 $Y=0.2025 $X2=0.594 $Y2=0.2025
r16 12 7 0.0308642 $w=8.1e-08 $l=2.5e-09 $layer=P_src_drn $thickness=1e-09
+ $X=0.5766 $Y=0.2025 $X2=0.5795 $Y2=0.2025
r17 2 8 1e-05 $l=2e-09 $X=0.756 $Y=0.2025 $X2=0.758 $Y2=0.2025
.ends

.subckt PM_SDFLx4_ASAP7_75t_R%18 vss 7 9 4 5 1
c1 1 vss 0.00883749f $X=0.837 $Y=0.0675
c2 4 vss 0.00177119f $X=0.7955 $Y=0.0675
c3 5 vss 0.00300989f $X=0.866 $Y=0.0675
r1 9 8 0.0308642 $w=8.1e-08 $l=2.5e-09 $layer=N_src_drn $thickness=1e-09
+ $X=0.8813 $Y=0.0675 $X2=0.8785 $Y2=0.0675
r2 5 8 0.154321 $w=8.1e-08 $l=1.25e-08 $layer=N_src_drn $thickness=1e-09
+ $X=0.866 $Y=0.0675 $X2=0.8785 $Y2=0.0675
r3 4 1 0.154321 $w=8.1e-08 $l=1.25e-08 $layer=N_src_drn $thickness=1e-09
+ $X=0.7955 $Y=0.0675 $X2=0.837 $Y2=0.0675
r4 7 4 0.0308642 $w=8.1e-08 $l=2.5e-09 $layer=N_src_drn $thickness=1e-09
+ $X=0.7926 $Y=0.0675 $X2=0.7955 $Y2=0.0675
r5 1 5 1e-05 $l=2.9e-08 $X=0.837 $Y=0.0675 $X2=0.866 $Y2=0.0675
.ends

.subckt PM_SDFLx4_ASAP7_75t_R%19 vss 6 7 3 1
c1 1 vss 0.00436275f $X=0.864 $Y=0.2025
c2 3 vss 0.00301377f $X=0.8495 $Y=0.2025
r1 7 5 0.0308642 $w=8.1e-08 $l=2.5e-09 $layer=P_src_drn $thickness=1e-09
+ $X=0.8813 $Y=0.2025 $X2=0.8785 $Y2=0.2025
r2 1 5 0.179012 $w=8.1e-08 $l=1.45e-08 $layer=P_src_drn $thickness=1e-09
+ $X=0.864 $Y=0.2025 $X2=0.8785 $Y2=0.2025
r3 3 1 0.179012 $w=8.1e-08 $l=1.45e-08 $layer=P_src_drn $thickness=1e-09
+ $X=0.8495 $Y=0.2025 $X2=0.864 $Y2=0.2025
r4 6 3 0.0308642 $w=8.1e-08 $l=2.5e-09 $layer=P_src_drn $thickness=1e-09
+ $X=0.8466 $Y=0.2025 $X2=0.8495 $Y2=0.2025
.ends

.subckt PM_SDFLx4_ASAP7_75t_R%23 vss 2 3 1
c1 1 vss 0.00083174f $X=1.188 $Y=0.0675
r1 2 1 0.209877 $w=8.1e-08 $l=1.7e-08 $layer=N_src_drn $thickness=1e-09
+ $X=1.1706 $Y=0.0675 $X2=1.188 $Y2=0.0675
r2 3 1 0.209877 $w=8.1e-08 $l=1.7e-08 $layer=N_src_drn $thickness=1e-09
+ $X=1.2053 $Y=0.0675 $X2=1.188 $Y2=0.0675
.ends

.subckt PM_SDFLx4_ASAP7_75t_R%11 vss 23 27 45 46 54 56 12 3 13 19 4 18 22 11 15
+ 14 21 10 1
c1 1 vss 0.00331787f $X=0.945 $Y=0.135
c2 3 vss 0.0109767f $X=0.729 $Y=0.0675
c3 4 vss 0.00297869f $X=0.81 $Y=0.2025
c4 10 vss 0.0840788f $X=0.945 $Y=0.0245
c5 11 vss 0.0374415f $X=0.6875 $Y=0.0675
c6 12 vss 0.0363075f $X=0.758 $Y=0.0675
c7 13 vss 0.00252422f $X=0.7955 $Y=0.2025
c8 14 vss 0.000525844f $X=0.747 $Y=0.198
c9 15 vss 0.000187998f $X=0.81 $Y=0.198
c10 16 vss 0.00246773f $X=0.81 $Y=0.234
c11 17 vss 0.00302836f $X=0.945 $Y=0.234
c12 18 vss 0.000696415f $X=0.747 $Y=0.178
c13 19 vss 0.000869321f $X=0.7965 $Y=0.198
c14 20 vss 0.000238975f $X=0.81 $Y=0.216
c15 21 vss 0.010467f $X=0.918 $Y=0.234
c16 22 vss 0.00256481f $X=0.945 $Y=0.116
r1 56 55 0.0308642 $w=8.1e-08 $l=2.5e-09 $layer=N_src_drn $thickness=1e-09
+ $X=0.7733 $Y=0.0675 $X2=0.7705 $Y2=0.0675
r2 12 55 0.154321 $w=8.1e-08 $l=1.25e-08 $layer=N_src_drn $thickness=1e-09
+ $X=0.758 $Y=0.0675 $X2=0.7705 $Y2=0.0675
r3 11 3 0.154321 $w=8.1e-08 $l=1.25e-08 $layer=N_src_drn $thickness=1e-09
+ $X=0.6875 $Y=0.0675 $X2=0.729 $Y2=0.0675
r4 54 11 0.0308642 $w=8.1e-08 $l=2.5e-09 $layer=N_src_drn $thickness=1e-09
+ $X=0.6846 $Y=0.0675 $X2=0.6875 $Y2=0.0675
r5 3 50 19.3796 $a=3.24e-16 $layer=V0LISD $X=0.729 $Y=0.0675 $X2=0.747 $Y2=0.09
r6 50 51 2.91487 $w=1.3e-08 $l=1.25e-08 $layer=M1 $thickness=3.6e-08 $X=0.747
+ $Y=0.09 $X2=0.747 $Y2=0.1025
r7 49 51 2.56509 $w=1.3e-08 $l=1.1e-08 $layer=M1 $thickness=3.6e-08 $X=0.747
+ $Y=0.1135 $X2=0.747 $Y2=0.1025
r8 48 49 6.7625 $w=1.3e-08 $l=2.9e-08 $layer=M1 $thickness=3.6e-08 $X=0.747
+ $Y=0.1425 $X2=0.747 $Y2=0.1135
r9 47 48 5.36336 $w=1.3e-08 $l=2.3e-08 $layer=M1 $thickness=3.6e-08 $X=0.747
+ $Y=0.1655 $X2=0.747 $Y2=0.1425
r10 18 47 2.91487 $w=1.3e-08 $l=1.25e-08 $layer=M1 $thickness=3.6e-08 $X=0.747
+ $Y=0.178 $X2=0.747 $Y2=0.1655
r11 14 42 1.73214 $w=1.61034e-08 $l=1.45e-08 $layer=M1 $thickness=3.6e-08
+ $X=0.747 $Y=0.198 $X2=0.7615 $Y2=0.198
r12 14 18 3.01468 $w=1.741e-08 $l=2e-08 $layer=M1 $thickness=3.6e-08 $X=0.747
+ $Y=0.198 $X2=0.747 $Y2=0.178
r13 46 44 0.0308642 $w=8.1e-08 $l=2.5e-09 $layer=P_src_drn $thickness=1e-09
+ $X=0.8273 $Y=0.2025 $X2=0.8245 $Y2=0.2025
r14 4 44 0.179012 $w=8.1e-08 $l=1.45e-08 $layer=P_src_drn $thickness=1e-09
+ $X=0.81 $Y=0.2025 $X2=0.8245 $Y2=0.2025
r15 13 4 0.179012 $w=8.1e-08 $l=1.45e-08 $layer=P_src_drn $thickness=1e-09
+ $X=0.7955 $Y=0.2025 $X2=0.81 $Y2=0.2025
r16 45 13 0.0308642 $w=8.1e-08 $l=2.5e-09 $layer=P_src_drn $thickness=1e-09
+ $X=0.7926 $Y=0.2025 $X2=0.7955 $Y2=0.2025
r17 41 42 1.63233 $w=1.3e-08 $l=7e-09 $layer=M1 $thickness=3.6e-08 $X=0.7685
+ $Y=0.198 $X2=0.7615 $Y2=0.198
r18 40 41 0.816164 $w=1.3e-08 $l=3.5e-09 $layer=M1 $thickness=3.6e-08 $X=0.772
+ $Y=0.198 $X2=0.7685 $Y2=0.198
r19 39 40 2.56509 $w=1.3e-08 $l=1.1e-08 $layer=M1 $thickness=3.6e-08 $X=0.783
+ $Y=0.198 $X2=0.772 $Y2=0.198
r20 19 39 3.14806 $w=1.3e-08 $l=1.35e-08 $layer=M1 $thickness=3.6e-08 $X=0.7965
+ $Y=0.198 $X2=0.783 $Y2=0.198
r21 4 20 19.3796 $a=3.24e-16 $layer=V0LISD $X=0.81 $Y=0.2025 $X2=0.81 $Y2=0.216
r22 15 20 2.5483 $w=1.79e-08 $l=1.8e-08 $layer=M1 $thickness=3.6e-08 $X=0.81
+ $Y=0.198 $X2=0.81 $Y2=0.216
r23 15 19 1.49895 $w=1.63333e-08 $l=1.35e-08 $layer=M1 $thickness=3.6e-08
+ $X=0.81 $Y=0.198 $X2=0.7965 $Y2=0.198
r24 16 38 1.49895 $w=1.63333e-08 $l=1.35e-08 $layer=M1 $thickness=3.6e-08
+ $X=0.81 $Y=0.234 $X2=0.8235 $Y2=0.234
r25 16 20 2.5483 $w=1.79e-08 $l=1.8e-08 $layer=M1 $thickness=3.6e-08 $X=0.81
+ $Y=0.234 $X2=0.81 $Y2=0.216
r26 37 38 3.14806 $w=1.3e-08 $l=1.35e-08 $layer=M1 $thickness=3.6e-08 $X=0.837
+ $Y=0.234 $X2=0.8235 $Y2=0.234
r27 36 37 6.29612 $w=1.3e-08 $l=2.7e-08 $layer=M1 $thickness=3.6e-08 $X=0.864
+ $Y=0.234 $X2=0.837 $Y2=0.234
r28 35 36 6.29612 $w=1.3e-08 $l=2.7e-08 $layer=M1 $thickness=3.6e-08 $X=0.891
+ $Y=0.234 $X2=0.864 $Y2=0.234
r29 21 35 6.29612 $w=1.3e-08 $l=2.7e-08 $layer=M1 $thickness=3.6e-08 $X=0.918
+ $Y=0.234 $X2=0.891 $Y2=0.234
r30 17 34 3.36447 $w=1.71023e-08 $l=2.15e-08 $layer=M1 $thickness=3.6e-08
+ $X=0.945 $Y=0.234 $X2=0.945 $Y2=0.2125
r31 17 21 4.64701 $w=1.46667e-08 $l=2.7e-08 $layer=M1 $thickness=3.6e-08
+ $X=0.945 $Y=0.234 $X2=0.918 $Y2=0.234
r32 33 34 4.19742 $w=1.3e-08 $l=1.8e-08 $layer=M1 $thickness=3.6e-08 $X=0.945
+ $Y=0.1945 $X2=0.945 $Y2=0.2125
r33 32 33 3.84763 $w=1.3e-08 $l=1.65e-08 $layer=M1 $thickness=3.6e-08 $X=0.945
+ $Y=0.178 $X2=0.945 $Y2=0.1945
r34 31 32 2.91487 $w=1.3e-08 $l=1.25e-08 $layer=M1 $thickness=3.6e-08 $X=0.945
+ $Y=0.1655 $X2=0.945 $Y2=0.178
r35 30 31 2.68168 $w=1.3e-08 $l=1.15e-08 $layer=M1 $thickness=3.6e-08 $X=0.945
+ $Y=0.154 $X2=0.945 $Y2=0.1655
r36 29 30 4.43061 $w=1.3e-08 $l=1.9e-08 $layer=M1 $thickness=3.6e-08 $X=0.945
+ $Y=0.135 $X2=0.945 $Y2=0.154
r37 22 29 4.43061 $w=1.3e-08 $l=1.9e-08 $layer=M1 $thickness=3.6e-08 $X=0.945
+ $Y=0.116 $X2=0.945 $Y2=0.135
r38 1 25 10.4265 $w=1.765e-08 $layer=LIG $thickness=5.2e-08 $X=0.945 $Y=0.135
+ $X2=0.945 $Y2=0.135
r39 1 29 19.3796 $a=3.24e-16 $layer=V0LIG $X=0.945 $Y=0.135 $X2=0.945 $Y2=0.135
r40 27 26 16.4967 $w=2.1e-08 $l=4.85e-08 $layer=Gate_1 $thickness=5.6e-08
+ $X=0.945 $Y=0.2025 $X2=0.945 $Y2=0.154
r41 25 26 6.6497 $w=2.04211e-08 $l=1.9e-08 $layer=Gate_1 $thickness=5.6e-08
+ $X=0.945 $Y=0.135 $X2=0.945 $Y2=0.154
r42 24 25 6.6497 $w=2.04211e-08 $l=1.9e-08 $layer=Gate_1 $thickness=5.6e-08
+ $X=0.945 $Y=0.116 $X2=0.945 $Y2=0.135
r43 23 24 16.4967 $w=2.1e-08 $l=4.85e-08 $layer=Gate_1 $thickness=5.6e-08
+ $X=0.945 $Y=0.0675 $X2=0.945 $Y2=0.116
r44 23 10 14.6259 $w=2.1e-08 $l=4.3e-08 $layer=Gate_1 $thickness=5.6e-08
+ $X=0.945 $Y=0.0675 $X2=0.945 $Y2=0.0245
r45 3 12 1e-05 $l=2.9e-08 $X=0.729 $Y=0.0675 $X2=0.758 $Y2=0.0675
.ends

.subckt PM_SDFLx4_ASAP7_75t_R%4 vss 33 37 65 68 72 76 87 89 8 7 25 19 1 17 21
+ 24 22 28 13 23 16 26 2 27 3 15 14
c1 1 vss 0.00377431f $X=0.135 $Y=0.135
c2 2 vss 0.000491435f $X=0.783 $Y=0.135
c3 3 vss 0.000129692f $X=1.107 $Y=0.135
c4 7 vss 0.0087972f $X=0.054 $Y=0.0675
c5 8 vss 0.00906877f $X=0.054 $Y=0.2025
c6 13 vss 0.0870268f $X=0.135 $Y=0.135
c7 14 vss 0.00836679f $X=0.783 $Y=0.135
c8 15 vss 0.00699793f $X=1.107 $Y=0.0245
c9 16 vss 0.0426183f $X=0.056 $Y=0.0675
c10 17 vss 0.0426441f $X=0.056 $Y=0.2025
c11 18 vss 0.00375573f $X=0.018 $Y=0.036
c12 19 vss 0.00217332f $X=0.0165 $Y=0.117
c13 20 vss 0.00375619f $X=0.018 $Y=0.234
c14 21 vss 0.00444871f $X=0.018 $Y=0.0945
c15 22 vss 0.00662968f $X=0.018 $Y=0.163
c16 23 vss 0.00681192f $X=0.036 $Y=0.036
c17 24 vss 0.00472477f $X=0.036 $Y=0.234
c18 25 vss 0.00285314f $X=0.135 $Y=0.1055
c19 26 vss 0.00136061f $X=0.783 $Y=0.089
c20 27 vss 0.00186589f $X=1.107 $Y=0.107
c21 28 vss 0.0373982f $X=0.6775 $Y=0.117
r1 89 88 0.0308642 $w=8.1e-08 $l=2.5e-09 $layer=P_src_drn $thickness=1e-09
+ $X=0.0713 $Y=0.2025 $X2=0.0685 $Y2=0.2025
r2 17 88 0.154321 $w=8.1e-08 $l=1.25e-08 $layer=P_src_drn $thickness=1e-09
+ $X=0.056 $Y=0.2025 $X2=0.0685 $Y2=0.2025
r3 87 86 0.0308642 $w=8.1e-08 $l=2.5e-09 $layer=N_src_drn $thickness=1e-09
+ $X=0.0713 $Y=0.0675 $X2=0.0685 $Y2=0.0675
r4 16 86 0.154321 $w=8.1e-08 $l=1.25e-08 $layer=N_src_drn $thickness=1e-09
+ $X=0.056 $Y=0.0675 $X2=0.0685 $Y2=0.0675
r5 8 84 19.3796 $a=3.24e-16 $layer=V0LISD $X=0.054 $Y=0.2025 $X2=0.055 $Y2=0.234
r6 7 79 19.3796 $a=3.24e-16 $layer=V0LISD $X=0.054 $Y=0.0675 $X2=0.055 $Y2=0.036
r7 83 84 2.09871 $w=1.3e-08 $l=9e-09 $layer=M1 $thickness=3.6e-08 $X=0.046
+ $Y=0.234 $X2=0.055 $Y2=0.234
r8 24 83 2.3319 $w=1.3e-08 $l=1e-08 $layer=M1 $thickness=3.6e-08 $X=0.036
+ $Y=0.234 $X2=0.046 $Y2=0.234
r9 78 79 2.09871 $w=1.3e-08 $l=9e-09 $layer=M1 $thickness=3.6e-08 $X=0.046
+ $Y=0.036 $X2=0.055 $Y2=0.036
r10 23 78 2.3319 $w=1.3e-08 $l=1e-08 $layer=M1 $thickness=3.6e-08 $X=0.036
+ $Y=0.036 $X2=0.046 $Y2=0.036
r11 76 75 14.6259 $w=2.1e-08 $l=4.3e-08 $layer=Gate_1 $thickness=5.6e-08
+ $X=0.135 $Y=0.2025 $X2=0.135 $Y2=0.1595
r12 74 75 2.7211 $w=2.1e-08 $l=8e-09 $layer=Gate_1 $thickness=5.6e-08 $X=0.135
+ $Y=0.1515 $X2=0.135 $Y2=0.1595
r13 72 73 14.6259 $w=2.1e-08 $l=4.3e-08 $layer=Gate_1 $thickness=5.6e-08
+ $X=0.135 $Y=0.0675 $X2=0.135 $Y2=0.1105
r14 70 73 2.7211 $w=2.1e-08 $l=8e-09 $layer=Gate_1 $thickness=5.6e-08 $X=0.135
+ $Y=0.1185 $X2=0.135 $Y2=0.1105
r15 13 70 5.79936 $w=2.03333e-08 $l=1.65e-08 $layer=Gate_1 $thickness=5.6e-08
+ $X=0.135 $Y=0.135 $X2=0.135 $Y2=0.1185
r16 13 74 5.79936 $w=2.03333e-08 $l=1.65e-08 $layer=Gate_1 $thickness=5.6e-08
+ $X=0.135 $Y=0.135 $X2=0.135 $Y2=0.1515
r17 20 63 3.36447 $w=1.71023e-08 $l=2.15e-08 $layer=M1 $thickness=3.6e-08
+ $X=0.018 $Y=0.234 $X2=0.018 $Y2=0.2125
r18 20 24 2.5483 $w=1.55e-08 $l=1.8e-08 $layer=M1 $thickness=3.6e-08 $X=0.018
+ $Y=0.234 $X2=0.036 $Y2=0.234
r19 18 62 2.5483 $w=1.79e-08 $l=1.8e-08 $layer=M1 $thickness=3.6e-08 $X=0.018
+ $Y=0.036 $X2=0.018 $Y2=0.054
r20 18 23 2.5483 $w=1.55e-08 $l=1.8e-08 $layer=M1 $thickness=3.6e-08 $X=0.018
+ $Y=0.036 $X2=0.036 $Y2=0.036
r21 68 67 16.4967 $w=2.1e-08 $l=4.85e-08 $layer=Gate_1 $thickness=5.6e-08
+ $X=0.783 $Y=0.2025 $X2=0.783 $Y2=0.154
r22 65 66 16.4967 $w=2.1e-08 $l=4.85e-08 $layer=Gate_1 $thickness=5.6e-08
+ $X=0.783 $Y=0.0675 $X2=0.783 $Y2=0.116
r23 14 66 6.6497 $w=2.04211e-08 $l=1.9e-08 $layer=Gate_1 $thickness=5.6e-08
+ $X=0.783 $Y=0.135 $X2=0.783 $Y2=0.116
r24 14 67 6.6497 $w=2.04211e-08 $l=1.9e-08 $layer=Gate_1 $thickness=5.6e-08
+ $X=0.783 $Y=0.135 $X2=0.783 $Y2=0.154
r25 1 59 19.3796 $a=3.24e-16 $layer=V0LIG $X=0.135 $Y=0.135 $X2=0.135 $Y2=0.126
r26 1 13 10.4265 $w=1.765e-08 $layer=LIG $thickness=5.2e-08 $X=0.135 $Y=0.135
+ $X2=0.135 $Y2=0.135
r27 22 63 11.5429 $w=1.3e-08 $l=4.95e-08 $layer=M1 $thickness=3.6e-08 $X=0.018
+ $Y=0.163 $X2=0.018 $Y2=0.2125
r28 61 62 4.19742 $w=1.3e-08 $l=1.8e-08 $layer=M1 $thickness=3.6e-08 $X=0.018
+ $Y=0.072 $X2=0.018 $Y2=0.054
r29 21 61 5.24677 $w=1.3e-08 $l=2.25e-08 $layer=M1 $thickness=3.6e-08 $X=0.018
+ $Y=0.0945 $X2=0.018 $Y2=0.072
r30 2 54 19.3796 $a=3.24e-16 $layer=V0LIG $X=0.783 $Y=0.135 $X2=0.783 $Y2=0.126
r31 2 14 10.4265 $w=1.765e-08 $layer=LIG $thickness=5.2e-08 $X=0.783 $Y=0.135
+ $X2=0.783 $Y2=0.135
r32 25 59 4.78039 $w=1.3e-08 $l=2.05e-08 $layer=M1 $thickness=3.6e-08 $X=0.135
+ $Y=0.1055 $X2=0.135 $Y2=0.126
r33 56 57 1.90199 $w=1.38333e-08 $l=9e-09 $layer=M1 $thickness=3.6e-08
+ $X=0.0255 $Y=0.117 $X2=0.0345 $Y2=0.117
r34 19 56 0.9184 $w=1.8e-08 $l=9e-09 $layer=M1 $thickness=3.6e-08 $X=0.0165
+ $Y=0.117 $X2=0.0255 $Y2=0.117
r35 19 21 3.9134 $w=1.47857e-08 $l=2.25499e-08 $layer=M1 $thickness=3.6e-08
+ $X=0.0165 $Y=0.117 $X2=0.018 $Y2=0.0945
r36 19 22 9.39335 $w=1.38427e-08 $l=4.60245e-08 $layer=M1 $thickness=3.6e-08
+ $X=0.0165 $Y=0.117 $X2=0.018 $Y2=0.163
r37 26 54 8.62802 $w=1.3e-08 $l=3.7e-08 $layer=M1 $thickness=3.6e-08 $X=0.783
+ $Y=0.089 $X2=0.783 $Y2=0.126
r38 52 53 5.71315 $w=1.3e-08 $l=2.45e-08 $layer=M2 $thickness=3.6e-08 $X=0.135
+ $Y=0.117 $X2=0.1595 $Y2=0.117
r39 52 59 19.5347 $a=3.24e-16 $layer=V1 $X=0.135 $Y=0.117 $X2=0.135 $Y2=0.126
r40 51 52 11.8927 $w=1.3e-08 $l=5.1e-08 $layer=M2 $thickness=3.6e-08 $X=0.084
+ $Y=0.117 $X2=0.135 $Y2=0.117
r41 50 51 11.8927 $w=1.3e-08 $l=5.1e-08 $layer=M2 $thickness=3.6e-08 $X=0.033
+ $Y=0.117 $X2=0.084 $Y2=0.117
r42 50 57 19.5347 $a=3.24e-16 $layer=V1 $X=0.033 $Y=0.117 $X2=0.0345 $Y2=0.117
r43 48 53 9.91056 $w=1.3e-08 $l=4.25e-08 $layer=M2 $thickness=3.6e-08 $X=0.202
+ $Y=0.117 $X2=0.1595 $Y2=0.117
r44 47 48 47.3375 $w=1.3e-08 $l=2.03e-07 $layer=M2 $thickness=3.6e-08 $X=0.405
+ $Y=0.117 $X2=0.202 $Y2=0.117
r45 44 45 37.7767 $w=1.3e-08 $l=1.62e-07 $layer=M2 $thickness=3.6e-08 $X=0.945
+ $Y=0.117 $X2=1.107 $Y2=0.117
r46 43 44 37.7767 $w=1.3e-08 $l=1.62e-07 $layer=M2 $thickness=3.6e-08 $X=0.783
+ $Y=0.117 $X2=0.945 $Y2=0.117
r47 43 54 19.5347 $a=3.24e-16 $layer=V1 $X=0.783 $Y=0.117 $X2=0.783 $Y2=0.126
r48 28 43 24.6015 $w=1.3e-08 $l=1.055e-07 $layer=M2 $thickness=3.6e-08
+ $X=0.6775 $Y=0.117 $X2=0.783 $Y2=0.117
r49 28 47 63.5442 $w=1.3e-08 $l=2.725e-07 $layer=M2 $thickness=3.6e-08
+ $X=0.6775 $Y=0.117 $X2=0.405 $Y2=0.117
r50 39 45 19.5347 $a=3.24e-16 $layer=V1 $X=1.107 $Y=0.126 $X2=1.107 $Y2=0.117
r51 27 39 4.43061 $w=1.3e-08 $l=1.9e-08 $layer=M1 $thickness=3.6e-08 $X=1.107
+ $Y=0.107 $X2=1.107 $Y2=0.126
r52 3 35 10.4265 $w=1.765e-08 $layer=LIG $thickness=5.2e-08 $X=1.107 $Y=0.135
+ $X2=1.107 $Y2=0.135
r53 3 39 19.3796 $a=3.24e-16 $layer=V0LIG $X=1.107 $Y=0.135 $X2=1.107 $Y2=0.126
r54 37 36 16.4967 $w=2.1e-08 $l=4.85e-08 $layer=Gate_1 $thickness=5.6e-08
+ $X=1.107 $Y=0.2025 $X2=1.107 $Y2=0.154
r55 35 36 6.6497 $w=2.04211e-08 $l=1.9e-08 $layer=Gate_1 $thickness=5.6e-08
+ $X=1.107 $Y=0.135 $X2=1.107 $Y2=0.154
r56 34 35 6.6497 $w=2.04211e-08 $l=1.9e-08 $layer=Gate_1 $thickness=5.6e-08
+ $X=1.107 $Y=0.116 $X2=1.107 $Y2=0.135
r57 33 34 16.4967 $w=2.1e-08 $l=4.85e-08 $layer=Gate_1 $thickness=5.6e-08
+ $X=1.107 $Y=0.0675 $X2=1.107 $Y2=0.116
r58 33 15 14.6259 $w=2.1e-08 $l=4.3e-08 $layer=Gate_1 $thickness=5.6e-08
+ $X=1.107 $Y=0.0675 $X2=1.107 $Y2=0.0245
r59 8 17 1e-05 $l=2e-09 $X=0.054 $Y=0.2025 $X2=0.056 $Y2=0.2025
r60 7 16 1e-05 $l=2e-09 $X=0.054 $Y=0.0675 $X2=0.056 $Y2=0.0675
.ends

.subckt PM_SDFLx4_ASAP7_75t_R%9 vss 35 80 85 89 92 94 24 10 21 9 23 1 20 22 28
+ 4 25 19 26 27 3 29 2 17 16 18 15
c1 1 vss 0.00359421f $X=0.6745 $Y=0.135
c2 2 vss 0.00033072f $X=0.837 $Y=0.135
c3 3 vss 0.00032428f $X=1.053 $Y=0.135
c4 4 vss 0.000521643f $X=1.161 $Y=0.135
c5 9 vss 0.00847701f $X=0.162 $Y=0.0675
c6 10 vss 0.00891618f $X=0.162 $Y=0.2025
c7 15 vss 0.0582626f $X=0.675 $Y=0.135
c8 16 vss 0.006899f $X=0.837 $Y=0.135
c9 17 vss 0.0175404f $X=1.053 $Y=0.135
c10 18 vss 0.00780683f $X=1.161 $Y=0.0245
c11 19 vss 0.0454527f $X=0.1475 $Y=0.0675
c12 20 vss 0.0454633f $X=0.1475 $Y=0.2025
c13 21 vss 0.00591663f $X=0.189 $Y=0.234
c14 22 vss 0.00289398f $X=0.189 $Y=0.036
c15 23 vss 0.00593795f $X=0.1505 $Y=0.036
c16 24 vss 0.0045894f $X=0.189 $Y=0.1235
c17 25 vss 0.000584897f $X=0.693 $Y=0.125
c18 26 vss 0.00192541f $X=0.837 $Y=0.098
c19 27 vss 0.00209725f $X=1.053 $Y=0.116
c20 28 vss 0.00204339f $X=1.161 $Y=0.116
c21 29 vss 0.040206f $X=1.1365 $Y=0.153
r1 19 9 0.154321 $w=8.1e-08 $l=1.25e-08 $layer=N_src_drn $thickness=1e-09
+ $X=0.1475 $Y=0.0675 $X2=0.162 $Y2=0.0675
r2 94 19 0.0308642 $w=8.1e-08 $l=2.5e-09 $layer=N_src_drn $thickness=1e-09
+ $X=0.1446 $Y=0.0675 $X2=0.1475 $Y2=0.0675
r3 20 10 0.154321 $w=8.1e-08 $l=1.25e-08 $layer=P_src_drn $thickness=1e-09
+ $X=0.1475 $Y=0.2025 $X2=0.162 $Y2=0.2025
r4 92 20 0.0308642 $w=8.1e-08 $l=2.5e-09 $layer=P_src_drn $thickness=1e-09
+ $X=0.1446 $Y=0.2025 $X2=0.1475 $Y2=0.2025
r5 9 75 19.3796 $a=3.24e-16 $layer=V0LISD $X=0.162 $Y=0.0675 $X2=0.162 $Y2=0.036
r6 89 88 16.4967 $w=2.1e-08 $l=4.85e-08 $layer=Gate_1 $thickness=5.6e-08
+ $X=1.053 $Y=0.2025 $X2=1.053 $Y2=0.154
r7 17 88 6.6497 $w=2.04211e-08 $l=1.9e-08 $layer=Gate_1 $thickness=5.6e-08
+ $X=1.053 $Y=0.135 $X2=1.053 $Y2=0.154
r8 85 84 16.4967 $w=2.1e-08 $l=4.85e-08 $layer=Gate_1 $thickness=5.6e-08
+ $X=0.837 $Y=0.2025 $X2=0.837 $Y2=0.154
r9 16 84 6.6497 $w=2.04211e-08 $l=1.9e-08 $layer=Gate_1 $thickness=5.6e-08
+ $X=0.837 $Y=0.135 $X2=0.837 $Y2=0.154
r10 80 81 16.4967 $w=2.1e-08 $l=4.85e-08 $layer=Gate_1 $thickness=5.6e-08
+ $X=0.675 $Y=0.0675 $X2=0.675 $Y2=0.116
r11 15 81 6.6497 $w=2.04211e-08 $l=1.9e-08 $layer=Gate_1 $thickness=5.6e-08
+ $X=0.675 $Y=0.135 $X2=0.675 $Y2=0.116
r12 10 70 19.3796 $a=3.24e-16 $layer=V0LISD $X=0.162 $Y=0.2025 $X2=0.162
+ $Y2=0.234
r13 75 76 3.14806 $w=1.3e-08 $l=1.35e-08 $layer=M1 $thickness=3.6e-08 $X=0.162
+ $Y=0.036 $X2=0.1755 $Y2=0.036
r14 23 75 2.68168 $w=1.3e-08 $l=1.15e-08 $layer=M1 $thickness=3.6e-08 $X=0.1505
+ $Y=0.036 $X2=0.162 $Y2=0.036
r15 3 66 19.3796 $a=3.24e-16 $layer=V0LIG $X=1.053 $Y=0.135 $X2=1.053 $Y2=0.144
r16 3 17 10.4265 $w=1.765e-08 $layer=LIG $thickness=5.2e-08 $X=1.053 $Y=0.135
+ $X2=1.053 $Y2=0.135
r17 2 63 19.3796 $a=3.24e-16 $layer=V0LIG $X=0.837 $Y=0.135 $X2=0.837 $Y2=0.144
r18 2 16 10.4265 $w=1.765e-08 $layer=LIG $thickness=5.2e-08 $X=0.837 $Y=0.135
+ $X2=0.837 $Y2=0.135
r19 72 74 5.15173 $w=1.56722e-08 $l=9e-09 $layer=LIG $thickness=4.8e-08
+ $X=0.6845 $Y=0.135 $X2=0.6935 $Y2=0.135
r20 1 72 2.6116 $w=2.2e-08 $l=1e-08 $layer=LIG $thickness=4.8e-08 $X=0.6745
+ $Y=0.135 $X2=0.6845 $Y2=0.135
r21 1 15 6.40962 $w=2.09268e-08 $l=5e-10 $layer=Gate_1 $thickness=5.22927e-08
+ $X=0.6745 $Y=0.135 $X2=0.675 $Y2=0.135
r22 70 71 3.14806 $w=1.3e-08 $l=1.35e-08 $layer=M1 $thickness=3.6e-08 $X=0.162
+ $Y=0.234 $X2=0.1755 $Y2=0.234
r23 21 58 3.83327 $w=1.5093e-08 $l=2.15e-08 $layer=M1 $thickness=3.6e-08
+ $X=0.189 $Y=0.234 $X2=0.189 $Y2=0.2125
r24 21 71 1.96775 $w=1.63333e-08 $l=1.35e-08 $layer=M1 $thickness=3.6e-08
+ $X=0.189 $Y=0.234 $X2=0.1755 $Y2=0.234
r25 22 57 2.5483 $w=1.79e-08 $l=1.8e-08 $layer=M1 $thickness=3.6e-08 $X=0.189
+ $Y=0.036 $X2=0.189 $Y2=0.054
r26 22 76 1.49895 $w=1.63333e-08 $l=1.35e-08 $layer=M1 $thickness=3.6e-08
+ $X=0.189 $Y=0.036 $X2=0.1755 $Y2=0.036
r27 27 66 6.52931 $w=1.3e-08 $l=2.8e-08 $layer=M1 $thickness=3.6e-08 $X=1.053
+ $Y=0.116 $X2=1.053 $Y2=0.144
r28 26 63 10.7267 $w=1.3e-08 $l=4.6e-08 $layer=M1 $thickness=3.6e-08 $X=0.837
+ $Y=0.098 $X2=0.837 $Y2=0.144
r29 59 74 19.3796 $a=3.24e-16 $layer=V0LIG $X=0.693 $Y=0.144 $X2=0.6935
+ $Y2=0.135
r30 25 59 4.43061 $w=1.3e-08 $l=1.9e-08 $layer=M1 $thickness=3.6e-08 $X=0.693
+ $Y=0.125 $X2=0.693 $Y2=0.144
r31 56 57 4.19742 $w=1.3e-08 $l=1.8e-08 $layer=M1 $thickness=3.6e-08 $X=0.189
+ $Y=0.072 $X2=0.189 $Y2=0.054
r32 55 56 4.6638 $w=1.3e-08 $l=2e-08 $layer=M1 $thickness=3.6e-08 $X=0.189
+ $Y=0.092 $X2=0.189 $Y2=0.072
r33 54 58 7.34548 $w=1.3e-08 $l=3.15e-08 $layer=M1 $thickness=3.6e-08 $X=0.189
+ $Y=0.181 $X2=0.189 $Y2=0.2125
r34 53 54 6.52931 $w=1.3e-08 $l=2.8e-08 $layer=M1 $thickness=3.6e-08 $X=0.189
+ $Y=0.153 $X2=0.189 $Y2=0.181
r35 24 53 6.8791 $w=1.3e-08 $l=2.95e-08 $layer=M1 $thickness=3.6e-08 $X=0.189
+ $Y=0.1235 $X2=0.189 $Y2=0.153
r36 24 55 7.34548 $w=1.3e-08 $l=3.15e-08 $layer=M1 $thickness=3.6e-08 $X=0.189
+ $Y=0.1235 $X2=0.189 $Y2=0.092
r37 51 52 8.97781 $w=1.3e-08 $l=3.85e-08 $layer=M2 $thickness=3.6e-08 $X=1.053
+ $Y=0.153 $X2=1.0915 $Y2=0.153
r38 51 66 19.5347 $a=3.24e-16 $layer=V1 $X=1.053 $Y=0.153 $X2=1.053 $Y2=0.144
r39 50 51 25.1845 $w=1.3e-08 $l=1.08e-07 $layer=M2 $thickness=3.6e-08 $X=0.945
+ $Y=0.153 $X2=1.053 $Y2=0.153
r40 49 50 25.1845 $w=1.3e-08 $l=1.08e-07 $layer=M2 $thickness=3.6e-08 $X=0.837
+ $Y=0.153 $X2=0.945 $Y2=0.153
r41 49 63 19.5347 $a=3.24e-16 $layer=V1 $X=0.837 $Y=0.153 $X2=0.837 $Y2=0.144
r42 48 49 16.7897 $w=1.3e-08 $l=7.2e-08 $layer=M2 $thickness=3.6e-08 $X=0.765
+ $Y=0.153 $X2=0.837 $Y2=0.153
r43 47 48 16.7897 $w=1.3e-08 $l=7.2e-08 $layer=M2 $thickness=3.6e-08 $X=0.693
+ $Y=0.153 $X2=0.765 $Y2=0.153
r44 47 59 19.5347 $a=3.24e-16 $layer=V1 $X=0.693 $Y=0.153 $X2=0.693 $Y2=0.144
r45 46 47 58.7638 $w=1.3e-08 $l=2.52e-07 $layer=M2 $thickness=3.6e-08 $X=0.441
+ $Y=0.153 $X2=0.693 $Y2=0.153
r46 45 46 58.7638 $w=1.3e-08 $l=2.52e-07 $layer=M2 $thickness=3.6e-08 $X=0.189
+ $Y=0.153 $X2=0.441 $Y2=0.153
r47 45 53 19.5347 $a=3.24e-16 $layer=V1 $X=0.189 $Y=0.153 $X2=0.189 $Y2=0.153
r48 29 42 5.71315 $w=1.3e-08 $l=2.45e-08 $layer=M2 $thickness=3.6e-08 $X=1.1365
+ $Y=0.153 $X2=1.161 $Y2=0.153
r49 29 52 10.4935 $w=1.3e-08 $l=4.5e-08 $layer=M2 $thickness=3.6e-08 $X=1.1365
+ $Y=0.153 $X2=1.0915 $Y2=0.153
r50 39 42 19.5347 $a=3.24e-16 $layer=V1 $X=1.161 $Y=0.144 $X2=1.161 $Y2=0.153
r51 28 39 6.52931 $w=1.3e-08 $l=2.8e-08 $layer=M1 $thickness=3.6e-08 $X=1.161
+ $Y=0.116 $X2=1.161 $Y2=0.144
r52 4 37 10.4265 $w=1.765e-08 $layer=LIG $thickness=5.2e-08 $X=1.161 $Y=0.135
+ $X2=1.161 $Y2=0.135
r53 4 39 19.3796 $a=3.24e-16 $layer=V0LIG $X=1.161 $Y=0.135 $X2=1.161 $Y2=0.144
r54 36 37 6.6497 $w=2.04211e-08 $l=1.9e-08 $layer=Gate_1 $thickness=5.6e-08
+ $X=1.161 $Y=0.116 $X2=1.161 $Y2=0.135
r55 35 36 16.4967 $w=2.1e-08 $l=4.85e-08 $layer=Gate_1 $thickness=5.6e-08
+ $X=1.161 $Y=0.0675 $X2=1.161 $Y2=0.116
r56 35 18 14.6259 $w=2.1e-08 $l=4.3e-08 $layer=Gate_1 $thickness=5.6e-08
+ $X=1.161 $Y=0.0675 $X2=1.161 $Y2=0.0245
.ends

.subckt PM_SDFLx4_ASAP7_75t_R%10 vss 19 23 38 40 42 44 13 3 18 17 15 1 5 4 11
+ 12 14
c1 1 vss 0.00349397f $X=0.891 $Y=0.135
c2 3 vss 0.019056f $X=0.968 $Y=0.0675
c3 4 vss 0.0106594f $X=0.999 $Y=0.2025
c4 5 vss 0.00299225f $X=0.9985 $Y=0.135
c5 11 vss 0.0803843f $X=0.891 $Y=0.0245
c6 12 vss 0.0381035f $X=0.9575 $Y=0.0675
c7 13 vss 0.00276574f $X=1.082 $Y=0.0675
c8 14 vss 0.037846f $X=0.9575 $Y=0.2025
c9 15 vss 0.0364333f $X=1.028 $Y=0.2025
c10 16 vss 0.00128642f $X=0.891 $Y=0.0755
c11 17 vss 0.00118389f $X=0.891 $Y=0.116
c12 18 vss 0.0040323f $X=0.918 $Y=0.072
r1 44 43 0.0308642 $w=8.1e-08 $l=2.5e-09 $layer=P_src_drn $thickness=1e-09
+ $X=1.0433 $Y=0.2025 $X2=1.0405 $Y2=0.2025
r2 15 43 0.154321 $w=8.1e-08 $l=1.25e-08 $layer=P_src_drn $thickness=1e-09
+ $X=1.028 $Y=0.2025 $X2=1.0405 $Y2=0.2025
r3 14 4 0.154321 $w=8.1e-08 $l=1.25e-08 $layer=P_src_drn $thickness=1e-09
+ $X=0.9575 $Y=0.2025 $X2=0.999 $Y2=0.2025
r4 42 14 0.0308642 $w=8.1e-08 $l=2.5e-09 $layer=P_src_drn $thickness=1e-09
+ $X=0.9546 $Y=0.2025 $X2=0.9575 $Y2=0.2025
r5 4 5 8.98133 $w=6.1e-08 $l=6.75018e-08 $layer=LISD $thickness=2.7e-08
+ $X=0.999 $Y=0.2025 $X2=0.9985 $Y2=0.135
r6 40 39 0.0308642 $w=8.1e-08 $l=2.5e-09 $layer=N_src_drn $thickness=1e-09
+ $X=1.0973 $Y=0.0675 $X2=1.0945 $Y2=0.0675
r7 13 39 0.154321 $w=8.1e-08 $l=1.25e-08 $layer=N_src_drn $thickness=1e-09
+ $X=1.082 $Y=0.0675 $X2=1.0945 $Y2=0.0675
r8 5 33 6.79656 $w=5.73824e-08 $l=6.76184e-08 $layer=LISD $thickness=2.7e-08
+ $X=0.9985 $Y=0.135 $X2=1.0025 $Y2=0.0675
r9 12 3 0.154321 $w=8.1e-08 $l=1.25e-08 $layer=N_src_drn $thickness=1e-09
+ $X=0.9575 $Y=0.0675 $X2=0.968 $Y2=0.0675
r10 38 12 0.0308642 $w=8.1e-08 $l=2.5e-09 $layer=N_src_drn $thickness=1e-09
+ $X=0.9546 $Y=0.0675 $X2=0.9575 $Y2=0.0675
r11 35 13 2.35445 $w=7.72e-08 $l=2.7e-08 $layer=LISD $thickness=2.7e-08
+ $X=1.053 $Y=0.0675 $X2=1.082 $Y2=0.0675
r12 34 35 2.04924 $w=7.72e-08 $l=2.35e-08 $layer=LISD $thickness=2.7e-08
+ $X=1.0295 $Y=0.0675 $X2=1.053 $Y2=0.0675
r13 33 34 2.26219 $w=7.98037e-08 $l=2.7e-08 $layer=LISD $thickness=2.7e-08
+ $X=1.0025 $Y=0.0675 $X2=1.0295 $Y2=0.0675
r14 32 33 1.84983 $w=8.1e-08 $l=2.25e-08 $layer=LISD $thickness=2.7e-08 $X=0.98
+ $Y=0.0675 $X2=1.0025 $Y2=0.0675
r15 3 31 19.3796 $a=3.24e-16 $layer=V0LISD $X=0.968 $Y=0.0675 $X2=0.972
+ $Y2=0.072
r16 3 32 1.02647 $w=7.84667e-08 $l=1.2e-08 $layer=LISD $thickness=2.7e-08
+ $X=0.968 $Y=0.0675 $X2=0.98 $Y2=0.0675
r17 30 31 3.14806 $w=1.3e-08 $l=1.35e-08 $layer=M1 $thickness=3.6e-08 $X=0.9585
+ $Y=0.072 $X2=0.972 $Y2=0.072
r18 29 30 3.14806 $w=1.3e-08 $l=1.35e-08 $layer=M1 $thickness=3.6e-08 $X=0.945
+ $Y=0.072 $X2=0.9585 $Y2=0.072
r19 18 29 6.29612 $w=1.3e-08 $l=2.7e-08 $layer=M1 $thickness=3.6e-08 $X=0.918
+ $Y=0.072 $X2=0.945 $Y2=0.072
r20 16 27 3.47612 $w=1.45278e-08 $l=1.8e-08 $layer=M1 $thickness=3.6e-08
+ $X=0.891 $Y=0.0755 $X2=0.891 $Y2=0.0935
r21 16 18 4.75866 $w=1.41702e-08 $l=2.72259e-08 $layer=M1 $thickness=3.6e-08
+ $X=0.891 $Y=0.0755 $X2=0.918 $Y2=0.072
r22 17 25 4.43061 $w=1.3e-08 $l=1.9e-08 $layer=M1 $thickness=3.6e-08 $X=0.891
+ $Y=0.116 $X2=0.891 $Y2=0.135
r23 17 27 5.24677 $w=1.3e-08 $l=2.25e-08 $layer=M1 $thickness=3.6e-08 $X=0.891
+ $Y=0.116 $X2=0.891 $Y2=0.0935
r24 1 21 10.4265 $w=1.765e-08 $layer=LIG $thickness=5.2e-08 $X=0.891 $Y=0.135
+ $X2=0.891 $Y2=0.135
r25 1 25 19.3796 $a=3.24e-16 $layer=V0LIG $X=0.891 $Y=0.135 $X2=0.891 $Y2=0.135
r26 23 22 16.4967 $w=2.1e-08 $l=4.85e-08 $layer=Gate_1 $thickness=5.6e-08
+ $X=0.891 $Y=0.2025 $X2=0.891 $Y2=0.154
r27 21 22 6.6497 $w=2.04211e-08 $l=1.9e-08 $layer=Gate_1 $thickness=5.6e-08
+ $X=0.891 $Y=0.135 $X2=0.891 $Y2=0.154
r28 20 21 6.6497 $w=2.04211e-08 $l=1.9e-08 $layer=Gate_1 $thickness=5.6e-08
+ $X=0.891 $Y=0.116 $X2=0.891 $Y2=0.135
r29 19 20 16.4967 $w=2.1e-08 $l=4.85e-08 $layer=Gate_1 $thickness=5.6e-08
+ $X=0.891 $Y=0.0675 $X2=0.891 $Y2=0.116
r30 19 11 14.6259 $w=2.1e-08 $l=4.3e-08 $layer=Gate_1 $thickness=5.6e-08
+ $X=0.891 $Y=0.0675 $X2=0.891 $Y2=0.0245
r31 4 15 1e-05 $l=2.9e-08 $X=0.999 $Y=0.2025 $X2=1.028 $Y2=0.2025
.ends

.subckt PM_SDFLx4_ASAP7_75t_R%12 vss 18 22 33 37 9 1 15 10 17 4 3 14 13 11 16 12
c1 1 vss 0.00375633f $X=1.215 $Y=0.135
c2 3 vss 0.0117158f $X=1.3055 $Y=0.0675
c3 4 vss 0.0068921f $X=1.296 $Y=0.2025
c4 9 vss 0.082627f $X=1.215 $Y=0.0245
c5 10 vss 0.0395261f $X=1.2815 $Y=0.0675
c6 11 vss 0.04069f $X=1.2815 $Y=0.2025
c7 12 vss 0.000595406f $X=1.215 $Y=0.191
c8 13 vss 0.000965363f $X=1.323 $Y=0.09
c9 14 vss 0.000470263f $X=1.323 $Y=0.191
c10 15 vss 0.00166035f $X=1.215 $Y=0.135
c11 16 vss 0.00225287f $X=1.233 $Y=0.191
c12 17 vss 0.00163628f $X=1.323 $Y=0.163
r1 10 3 0.154321 $w=8.1e-08 $l=1.25e-08 $layer=N_src_drn $thickness=1e-09
+ $X=1.2815 $Y=0.0675 $X2=1.3055 $Y2=0.0675
r2 37 10 0.0308642 $w=8.1e-08 $l=2.5e-09 $layer=N_src_drn $thickness=1e-09
+ $X=1.2786 $Y=0.0675 $X2=1.2815 $Y2=0.0675
r3 3 34 19.3796 $a=3.24e-16 $layer=V0LISD $X=1.3055 $Y=0.0675 $X2=1.296 $Y2=0.09
r4 34 35 3.14806 $w=1.3e-08 $l=1.35e-08 $layer=M1 $thickness=3.6e-08 $X=1.296
+ $Y=0.09 $X2=1.3095 $Y2=0.09
r5 13 31 4.06646 $w=1.5e-08 $l=2.25e-08 $layer=M1 $thickness=3.6e-08 $X=1.323
+ $Y=0.09 $X2=1.323 $Y2=0.1125
r6 13 35 1.96775 $w=1.63333e-08 $l=1.35e-08 $layer=M1 $thickness=3.6e-08
+ $X=1.323 $Y=0.09 $X2=1.3095 $Y2=0.09
r7 11 4 0.154321 $w=8.1e-08 $l=1.25e-08 $layer=P_src_drn $thickness=1e-09
+ $X=1.2815 $Y=0.2025 $X2=1.296 $Y2=0.2025
r8 33 11 0.0308642 $w=8.1e-08 $l=2.5e-09 $layer=P_src_drn $thickness=1e-09
+ $X=1.2786 $Y=0.2025 $X2=1.2815 $Y2=0.2025
r9 30 31 5.24677 $w=1.3e-08 $l=2.25e-08 $layer=M1 $thickness=3.6e-08 $X=1.323
+ $Y=0.135 $X2=1.323 $Y2=0.1125
r10 17 30 6.52931 $w=1.3e-08 $l=2.8e-08 $layer=M1 $thickness=3.6e-08 $X=1.323
+ $Y=0.163 $X2=1.323 $Y2=0.135
r11 4 28 19.3796 $a=3.24e-16 $layer=V0LISD $X=1.296 $Y=0.2025 $X2=1.296
+ $Y2=0.191
r12 14 29 1.49895 $w=1.63333e-08 $l=1.35e-08 $layer=M1 $thickness=3.6e-08
+ $X=1.323 $Y=0.191 $X2=1.3095 $Y2=0.191
r13 14 17 4.8802 $w=1.615e-08 $l=2.8e-08 $layer=M1 $thickness=3.6e-08 $X=1.323
+ $Y=0.191 $X2=1.323 $Y2=0.163
r14 28 29 3.14806 $w=1.3e-08 $l=1.35e-08 $layer=M1 $thickness=3.6e-08 $X=1.296
+ $Y=0.191 $X2=1.3095 $Y2=0.191
r15 27 28 2.56509 $w=1.3e-08 $l=1.1e-08 $layer=M1 $thickness=3.6e-08 $X=1.285
+ $Y=0.191 $X2=1.296 $Y2=0.191
r16 26 27 5.24677 $w=1.3e-08 $l=2.25e-08 $layer=M1 $thickness=3.6e-08 $X=1.2625
+ $Y=0.191 $X2=1.285 $Y2=0.191
r17 16 26 6.8791 $w=1.3e-08 $l=2.95e-08 $layer=M1 $thickness=3.6e-08 $X=1.233
+ $Y=0.191 $X2=1.2625 $Y2=0.191
r18 12 25 4.8802 $w=1.615e-08 $l=2.8e-08 $layer=M1 $thickness=3.6e-08 $X=1.215
+ $Y=0.191 $X2=1.215 $Y2=0.163
r19 12 16 2.5483 $w=1.55e-08 $l=1.8e-08 $layer=M1 $thickness=3.6e-08 $X=1.215
+ $Y=0.191 $X2=1.233 $Y2=0.191
r20 15 25 6.52931 $w=1.3e-08 $l=2.8e-08 $layer=M1 $thickness=3.6e-08 $X=1.215
+ $Y=0.135 $X2=1.215 $Y2=0.163
r21 1 20 10.4265 $w=1.765e-08 $layer=LIG $thickness=5.2e-08 $X=1.215 $Y=0.135
+ $X2=1.215 $Y2=0.135
r22 1 15 19.3796 $a=3.24e-16 $layer=V0LIG $X=1.215 $Y=0.135 $X2=1.215 $Y2=0.135
r23 22 21 16.4967 $w=2.1e-08 $l=4.85e-08 $layer=Gate_1 $thickness=5.6e-08
+ $X=1.215 $Y=0.2025 $X2=1.215 $Y2=0.154
r24 20 21 6.6497 $w=2.04211e-08 $l=1.9e-08 $layer=Gate_1 $thickness=5.6e-08
+ $X=1.215 $Y=0.135 $X2=1.215 $Y2=0.154
r25 19 20 6.6497 $w=2.04211e-08 $l=1.9e-08 $layer=Gate_1 $thickness=5.6e-08
+ $X=1.215 $Y=0.116 $X2=1.215 $Y2=0.135
r26 18 19 16.4967 $w=2.1e-08 $l=4.85e-08 $layer=Gate_1 $thickness=5.6e-08
+ $X=1.215 $Y=0.0675 $X2=1.215 $Y2=0.116
r27 18 9 14.6259 $w=2.1e-08 $l=4.3e-08 $layer=Gate_1 $thickness=5.6e-08
+ $X=1.215 $Y=0.0675 $X2=1.215 $Y2=0.0245
.ends

.subckt PM_SDFLx4_ASAP7_75t_R%20 vss 7 9 4 5 1
c1 1 vss 0.00742518f $X=1.161 $Y=0.2025
c2 4 vss 0.00175365f $X=1.1195 $Y=0.2025
c3 5 vss 0.00289114f $X=1.19 $Y=0.2025
r1 9 8 0.0308642 $w=8.1e-08 $l=2.5e-09 $layer=P_src_drn $thickness=1e-09
+ $X=1.2053 $Y=0.2025 $X2=1.2025 $Y2=0.2025
r2 5 8 0.154321 $w=8.1e-08 $l=1.25e-08 $layer=P_src_drn $thickness=1e-09
+ $X=1.19 $Y=0.2025 $X2=1.2025 $Y2=0.2025
r3 4 1 0.154321 $w=8.1e-08 $l=1.25e-08 $layer=P_src_drn $thickness=1e-09
+ $X=1.1195 $Y=0.2025 $X2=1.161 $Y2=0.2025
r4 7 4 0.0308642 $w=8.1e-08 $l=2.5e-09 $layer=P_src_drn $thickness=1e-09
+ $X=1.1166 $Y=0.2025 $X2=1.1195 $Y2=0.2025
r5 1 5 1e-05 $l=2.9e-08 $X=1.161 $Y=0.2025 $X2=1.19 $Y2=0.2025
.ends

.subckt PM_SDFLx4_ASAP7_75t_R%13 vss 30 36 57 58 86 90 93 96 99 102 106 110 114
+ 115 16 6 23 17 5 24 28 25 19 21 1 11 26 27 20 22 2 14 13 29 15 12
c1 1 vss 0.00369747f $X=1.269 $Y=0.135
c2 2 vss 0.0192326f $X=1.4215 $Y=0.135
c3 5 vss 0.00427508f $X=1.08 $Y=0.2025
c4 6 vss 0.00512837f $X=1.134 $Y=0.0675
c5 11 vss 0.0892163f $X=1.269 $Y=0.0245
c6 12 vss 0.0891143f $X=1.431 $Y=0.135
c7 13 vss 0.080546f $X=1.485 $Y=0.135
c8 14 vss 0.0811018f $X=1.539 $Y=0.135
c9 15 vss 0.0886841f $X=1.593 $Y=0.135
c10 16 vss 0.00832168f $X=1.1195 $Y=0.0675
c11 17 vss 0.00683735f $X=1.0655 $Y=0.2025
c12 18 vss 0.00229477f $X=1.251 $Y=0.036
c13 19 vss 0.000578324f $X=1.251 $Y=0.135
c14 20 vss 0.00329842f $X=1.377 $Y=0.036
c15 21 vss 0.000391765f $X=1.377 $Y=0.135
c16 22 vss 0.00328384f $X=1.377 $Y=0.234
c17 23 vss 0.031743f $X=1.35 $Y=0.234
c18 24 vss 0.0134525f $X=1.233 $Y=0.036
c19 25 vss 0.00285371f $X=1.251 $Y=0.116
c20 26 vss 0.0110628f $X=1.2715 $Y=0.036
c21 27 vss 0.00449867f $X=1.377 $Y=0.063
c22 28 vss 0.00473417f $X=1.377 $Y=0.172
c23 29 vss 0.0037698f $X=1.404 $Y=0.135
r1 115 113 0.0308642 $w=8.1e-08 $l=2.5e-09 $layer=P_src_drn $thickness=1e-09
+ $X=1.0973 $Y=0.2025 $X2=1.0945 $Y2=0.2025
r2 5 113 0.179012 $w=8.1e-08 $l=1.45e-08 $layer=P_src_drn $thickness=1e-09
+ $X=1.08 $Y=0.2025 $X2=1.0945 $Y2=0.2025
r3 17 5 0.179012 $w=8.1e-08 $l=1.45e-08 $layer=P_src_drn $thickness=1e-09
+ $X=1.0655 $Y=0.2025 $X2=1.08 $Y2=0.2025
r4 114 17 0.0308642 $w=8.1e-08 $l=2.5e-09 $layer=P_src_drn $thickness=1e-09
+ $X=1.0626 $Y=0.2025 $X2=1.0655 $Y2=0.2025
r5 5 81 19.3796 $a=3.24e-16 $layer=V0LISD $X=1.08 $Y=0.2025 $X2=1.08 $Y2=0.234
r6 110 109 14.6259 $w=2.1e-08 $l=4.3e-08 $layer=Gate_1 $thickness=5.6e-08
+ $X=1.593 $Y=0.2025 $X2=1.593 $Y2=0.1595
r7 108 109 2.7211 $w=2.1e-08 $l=8e-09 $layer=Gate_1 $thickness=5.6e-08 $X=1.593
+ $Y=0.1515 $X2=1.593 $Y2=0.1595
r8 106 107 14.6259 $w=2.1e-08 $l=4.3e-08 $layer=Gate_1 $thickness=5.6e-08
+ $X=1.593 $Y=0.0675 $X2=1.593 $Y2=0.1105
r9 104 107 2.7211 $w=2.1e-08 $l=8e-09 $layer=Gate_1 $thickness=5.6e-08 $X=1.593
+ $Y=0.1185 $X2=1.593 $Y2=0.1105
r10 15 73 6.54019 $w=2.09524e-08 $layer=Gate_1 $thickness=5.21905e-08 $X=1.593
+ $Y=0.135 $X2=1.593 $Y2=0.135
r11 15 104 5.79936 $w=2.03333e-08 $l=1.65e-08 $layer=Gate_1 $thickness=5.6e-08
+ $X=1.593 $Y=0.135 $X2=1.593 $Y2=0.1185
r12 15 108 5.79936 $w=2.03333e-08 $l=1.65e-08 $layer=Gate_1 $thickness=5.6e-08
+ $X=1.593 $Y=0.135 $X2=1.593 $Y2=0.1515
r13 102 101 16.4967 $w=2.1e-08 $l=4.85e-08 $layer=Gate_1 $thickness=5.6e-08
+ $X=1.539 $Y=0.2025 $X2=1.539 $Y2=0.154
r14 99 100 16.4967 $w=2.1e-08 $l=4.85e-08 $layer=Gate_1 $thickness=5.6e-08
+ $X=1.539 $Y=0.0675 $X2=1.539 $Y2=0.116
r15 14 71 6.54019 $w=2.09524e-08 $layer=Gate_1 $thickness=5.21905e-08 $X=1.539
+ $Y=0.135 $X2=1.539 $Y2=0.135
r16 14 100 6.6497 $w=2.04211e-08 $l=1.9e-08 $layer=Gate_1 $thickness=5.6e-08
+ $X=1.539 $Y=0.135 $X2=1.539 $Y2=0.116
r17 14 101 6.6497 $w=2.04211e-08 $l=1.9e-08 $layer=Gate_1 $thickness=5.6e-08
+ $X=1.539 $Y=0.135 $X2=1.539 $Y2=0.154
r18 96 95 16.4967 $w=2.1e-08 $l=4.85e-08 $layer=Gate_1 $thickness=5.6e-08
+ $X=1.485 $Y=0.2025 $X2=1.485 $Y2=0.154
r19 93 94 16.4967 $w=2.1e-08 $l=4.85e-08 $layer=Gate_1 $thickness=5.6e-08
+ $X=1.485 $Y=0.0675 $X2=1.485 $Y2=0.116
r20 13 69 6.54019 $w=2.09524e-08 $layer=Gate_1 $thickness=5.21905e-08 $X=1.485
+ $Y=0.135 $X2=1.485 $Y2=0.135
r21 13 94 6.6497 $w=2.04211e-08 $l=1.9e-08 $layer=Gate_1 $thickness=5.6e-08
+ $X=1.485 $Y=0.135 $X2=1.485 $Y2=0.116
r22 13 95 6.6497 $w=2.04211e-08 $l=1.9e-08 $layer=Gate_1 $thickness=5.6e-08
+ $X=1.485 $Y=0.135 $X2=1.485 $Y2=0.154
r23 90 89 14.6259 $w=2.1e-08 $l=4.3e-08 $layer=Gate_1 $thickness=5.6e-08
+ $X=1.431 $Y=0.2025 $X2=1.431 $Y2=0.1595
r24 88 89 2.7211 $w=2.1e-08 $l=8e-09 $layer=Gate_1 $thickness=5.6e-08 $X=1.431
+ $Y=0.1515 $X2=1.431 $Y2=0.1595
r25 86 87 14.6259 $w=2.1e-08 $l=4.3e-08 $layer=Gate_1 $thickness=5.6e-08
+ $X=1.431 $Y=0.0675 $X2=1.431 $Y2=0.1105
r26 84 87 2.7211 $w=2.1e-08 $l=8e-09 $layer=Gate_1 $thickness=5.6e-08 $X=1.431
+ $Y=0.1185 $X2=1.431 $Y2=0.1105
r27 12 65 6.27904 $w=2.09e-08 $layer=Gate_1 $thickness=5.24e-08 $X=1.431
+ $Y=0.135 $X2=1.431 $Y2=0.135
r28 12 84 5.79936 $w=2.03333e-08 $l=1.65e-08 $layer=Gate_1 $thickness=5.6e-08
+ $X=1.431 $Y=0.135 $X2=1.431 $Y2=0.1185
r29 12 88 5.79936 $w=2.03333e-08 $l=1.65e-08 $layer=Gate_1 $thickness=5.6e-08
+ $X=1.431 $Y=0.135 $X2=1.431 $Y2=0.1515
r30 81 82 3.14806 $w=1.3e-08 $l=1.35e-08 $layer=M1 $thickness=3.6e-08 $X=1.08
+ $Y=0.234 $X2=1.0935 $Y2=0.234
r31 79 82 3.14806 $w=1.3e-08 $l=1.35e-08 $layer=M1 $thickness=3.6e-08 $X=1.107
+ $Y=0.234 $X2=1.0935 $Y2=0.234
r32 78 79 6.29612 $w=1.3e-08 $l=2.7e-08 $layer=M1 $thickness=3.6e-08 $X=1.134
+ $Y=0.234 $X2=1.107 $Y2=0.234
r33 77 78 6.29612 $w=1.3e-08 $l=2.7e-08 $layer=M1 $thickness=3.6e-08 $X=1.161
+ $Y=0.234 $X2=1.134 $Y2=0.234
r34 76 77 6.29612 $w=1.3e-08 $l=2.7e-08 $layer=M1 $thickness=3.6e-08 $X=1.188
+ $Y=0.234 $X2=1.161 $Y2=0.234
r35 75 76 18.8884 $w=1.3e-08 $l=8.1e-08 $layer=M1 $thickness=3.6e-08 $X=1.269
+ $Y=0.234 $X2=1.188 $Y2=0.234
r36 23 75 18.8884 $w=1.3e-08 $l=8.1e-08 $layer=M1 $thickness=3.6e-08 $X=1.35
+ $Y=0.234 $X2=1.269 $Y2=0.234
r37 72 73 12.6539 $w=1.77815e-08 $l=2.7e-08 $layer=LIG $thickness=4.8e-08
+ $X=1.566 $Y=0.135 $X2=1.593 $Y2=0.135
r38 71 72 12.6539 $w=1.77815e-08 $l=2.7e-08 $layer=LIG $thickness=4.8e-08
+ $X=1.539 $Y=0.135 $X2=1.566 $Y2=0.135
r39 70 71 12.6539 $w=1.77815e-08 $l=2.7e-08 $layer=LIG $thickness=4.8e-08
+ $X=1.512 $Y=0.135 $X2=1.539 $Y2=0.135
r40 69 70 12.6539 $w=1.77815e-08 $l=2.7e-08 $layer=LIG $thickness=4.8e-08
+ $X=1.485 $Y=0.135 $X2=1.512 $Y2=0.135
r41 68 69 12.6539 $w=1.77815e-08 $l=2.7e-08 $layer=LIG $thickness=4.8e-08
+ $X=1.458 $Y=0.135 $X2=1.485 $Y2=0.135
r42 66 68 10.1729 $w=1.54914e-08 $l=1.75e-08 $layer=LIG $thickness=4.8e-08
+ $X=1.4405 $Y=0.135 $X2=1.458 $Y2=0.135
r43 65 66 2.48102 $w=2.2e-08 $l=9.5e-09 $layer=LIG $thickness=4.8e-08 $X=1.431
+ $Y=0.135 $X2=1.4405 $Y2=0.135
r44 2 65 2.48102 $w=2.2e-08 $l=9.5e-09 $layer=LIG $thickness=4.8e-08 $X=1.4215
+ $Y=0.135 $X2=1.431 $Y2=0.135
r45 22 61 3.36447 $w=1.71023e-08 $l=2.15e-08 $layer=M1 $thickness=3.6e-08
+ $X=1.377 $Y=0.234 $X2=1.377 $Y2=0.2125
r46 22 23 4.64701 $w=1.46667e-08 $l=2.7e-08 $layer=M1 $thickness=3.6e-08
+ $X=1.377 $Y=0.234 $X2=1.35 $Y2=0.234
r47 62 65 19.3796 $a=3.24e-16 $layer=V0LIG $X=1.431 $Y=0.135 $X2=1.431 $Y2=0.135
r48 29 62 6.29612 $w=1.3e-08 $l=2.7e-08 $layer=M1 $thickness=3.6e-08 $X=1.404
+ $Y=0.135 $X2=1.431 $Y2=0.135
r49 28 61 9.44419 $w=1.3e-08 $l=4.05e-08 $layer=M1 $thickness=3.6e-08 $X=1.377
+ $Y=0.172 $X2=1.377 $Y2=0.2125
r50 21 60 4.06646 $w=1.5e-08 $l=2.25e-08 $layer=M1 $thickness=3.6e-08 $X=1.377
+ $Y=0.135 $X2=1.377 $Y2=0.1125
r51 21 28 7.44771 $w=1.42162e-08 $l=3.7e-08 $layer=M1 $thickness=3.6e-08
+ $X=1.377 $Y=0.135 $X2=1.377 $Y2=0.172
r52 21 29 5.11582 $w=1.46667e-08 $l=2.7e-08 $layer=M1 $thickness=3.6e-08
+ $X=1.377 $Y=0.135 $X2=1.404 $Y2=0.135
r53 59 60 5.24677 $w=1.3e-08 $l=2.25e-08 $layer=M1 $thickness=3.6e-08 $X=1.377
+ $Y=0.09 $X2=1.377 $Y2=0.1125
r54 27 59 6.29612 $w=1.3e-08 $l=2.7e-08 $layer=M1 $thickness=3.6e-08 $X=1.377
+ $Y=0.063 $X2=1.377 $Y2=0.09
r55 58 56 0.0308642 $w=8.1e-08 $l=2.5e-09 $layer=N_src_drn $thickness=1e-09
+ $X=1.1513 $Y=0.0675 $X2=1.1485 $Y2=0.0675
r56 6 56 0.179012 $w=8.1e-08 $l=1.45e-08 $layer=N_src_drn $thickness=1e-09
+ $X=1.134 $Y=0.0675 $X2=1.1485 $Y2=0.0675
r57 16 6 0.179012 $w=8.1e-08 $l=1.45e-08 $layer=N_src_drn $thickness=1e-09
+ $X=1.1195 $Y=0.0675 $X2=1.134 $Y2=0.0675
r58 57 16 0.0308642 $w=8.1e-08 $l=2.5e-09 $layer=N_src_drn $thickness=1e-09
+ $X=1.1166 $Y=0.0675 $X2=1.1195 $Y2=0.0675
r59 20 54 4.64701 $w=1.46667e-08 $l=2.7e-08 $layer=M1 $thickness=3.6e-08
+ $X=1.377 $Y=0.036 $X2=1.35 $Y2=0.036
r60 20 27 4.64701 $w=1.62667e-08 $l=2.7e-08 $layer=M1 $thickness=3.6e-08
+ $X=1.377 $Y=0.036 $X2=1.377 $Y2=0.063
r61 6 49 19.3796 $a=3.24e-16 $layer=V0LISD $X=1.134 $Y=0.0675 $X2=1.134
+ $Y2=0.036
r62 53 54 9.44419 $w=1.3e-08 $l=4.05e-08 $layer=M1 $thickness=3.6e-08 $X=1.3095
+ $Y=0.036 $X2=1.35 $Y2=0.036
r63 52 53 5.71315 $w=1.3e-08 $l=2.45e-08 $layer=M1 $thickness=3.6e-08 $X=1.285
+ $Y=0.036 $X2=1.3095 $Y2=0.036
r64 26 52 3.14806 $w=1.3e-08 $l=1.35e-08 $layer=M1 $thickness=3.6e-08 $X=1.2715
+ $Y=0.036 $X2=1.285 $Y2=0.036
r65 49 50 3.14806 $w=1.3e-08 $l=1.35e-08 $layer=M1 $thickness=3.6e-08 $X=1.134
+ $Y=0.036 $X2=1.1475 $Y2=0.036
r66 47 50 3.14806 $w=1.3e-08 $l=1.35e-08 $layer=M1 $thickness=3.6e-08 $X=1.161
+ $Y=0.036 $X2=1.1475 $Y2=0.036
r67 46 47 6.29612 $w=1.3e-08 $l=2.7e-08 $layer=M1 $thickness=3.6e-08 $X=1.188
+ $Y=0.036 $X2=1.161 $Y2=0.036
r68 45 46 6.29612 $w=1.3e-08 $l=2.7e-08 $layer=M1 $thickness=3.6e-08 $X=1.215
+ $Y=0.036 $X2=1.188 $Y2=0.036
r69 24 45 4.19742 $w=1.3e-08 $l=1.8e-08 $layer=M1 $thickness=3.6e-08 $X=1.233
+ $Y=0.036 $X2=1.215 $Y2=0.036
r70 18 44 3.01711 $w=1.55e-08 $l=1.8e-08 $layer=M1 $thickness=3.6e-08 $X=1.251
+ $Y=0.036 $X2=1.251 $Y2=0.054
r71 18 24 3.01711 $w=1.55e-08 $l=1.8e-08 $layer=M1 $thickness=3.6e-08 $X=1.251
+ $Y=0.036 $X2=1.233 $Y2=0.036
r72 18 26 3.60008 $w=1.51951e-08 $l=2.05e-08 $layer=M1 $thickness=3.6e-08
+ $X=1.251 $Y=0.036 $X2=1.2715 $Y2=0.036
r73 43 44 2.91487 $w=1.3e-08 $l=1.25e-08 $layer=M1 $thickness=3.6e-08 $X=1.251
+ $Y=0.0665 $X2=1.251 $Y2=0.054
r74 42 43 2.09871 $w=1.3e-08 $l=9e-09 $layer=M1 $thickness=3.6e-08 $X=1.251
+ $Y=0.0755 $X2=1.251 $Y2=0.0665
r75 41 42 3.38125 $w=1.3e-08 $l=1.45e-08 $layer=M1 $thickness=3.6e-08 $X=1.251
+ $Y=0.09 $X2=1.251 $Y2=0.0755
r76 40 41 2.91487 $w=1.3e-08 $l=1.25e-08 $layer=M1 $thickness=3.6e-08 $X=1.251
+ $Y=0.1025 $X2=1.251 $Y2=0.09
r77 25 40 3.14806 $w=1.3e-08 $l=1.35e-08 $layer=M1 $thickness=3.6e-08 $X=1.251
+ $Y=0.116 $X2=1.251 $Y2=0.1025
r78 19 38 3.01711 $w=1.55e-08 $l=1.8e-08 $layer=M1 $thickness=3.6e-08 $X=1.251
+ $Y=0.135 $X2=1.269 $Y2=0.135
r79 19 25 3.2503 $w=1.53684e-08 $l=1.9e-08 $layer=M1 $thickness=3.6e-08
+ $X=1.251 $Y=0.135 $X2=1.251 $Y2=0.116
r80 1 33 10.4265 $w=1.765e-08 $layer=LIG $thickness=5.2e-08 $X=1.269 $Y=0.135
+ $X2=1.269 $Y2=0.135
r81 1 38 19.3796 $a=3.24e-16 $layer=V0LIG $X=1.269 $Y=0.135 $X2=1.269 $Y2=0.135
r82 36 35 14.6259 $w=2.1e-08 $l=4.3e-08 $layer=Gate_1 $thickness=5.6e-08
+ $X=1.269 $Y=0.2025 $X2=1.269 $Y2=0.1595
r83 34 35 2.7211 $w=2.1e-08 $l=8e-09 $layer=Gate_1 $thickness=5.6e-08 $X=1.269
+ $Y=0.1515 $X2=1.269 $Y2=0.1595
r84 33 34 5.79936 $w=2.03333e-08 $l=1.65e-08 $layer=Gate_1 $thickness=5.6e-08
+ $X=1.269 $Y=0.135 $X2=1.269 $Y2=0.1515
r85 32 33 5.79936 $w=2.03333e-08 $l=1.65e-08 $layer=Gate_1 $thickness=5.6e-08
+ $X=1.269 $Y=0.1185 $X2=1.269 $Y2=0.135
r86 31 32 2.7211 $w=2.1e-08 $l=8e-09 $layer=Gate_1 $thickness=5.6e-08 $X=1.269
+ $Y=0.1105 $X2=1.269 $Y2=0.1185
r87 30 31 14.6259 $w=2.1e-08 $l=4.3e-08 $layer=Gate_1 $thickness=5.6e-08
+ $X=1.269 $Y=0.0675 $X2=1.269 $Y2=0.1105
r88 30 11 14.6259 $w=2.1e-08 $l=4.3e-08 $layer=Gate_1 $thickness=5.6e-08
+ $X=1.269 $Y=0.0675 $X2=1.269 $Y2=0.0245
.ends

.subckt PM_SDFLx4_ASAP7_75t_R%QN vss 31 24 25 35 36 44 45 48 49 13 3 4 1 2 15
+ 14 16
c1 1 vss 0.00856512f $X=1.458 $Y=0.0675
c2 2 vss 0.00862504f $X=1.458 $Y=0.2025
c3 3 vss 0.00853737f $X=1.566 $Y=0.0675
c4 4 vss 0.00853737f $X=1.566 $Y=0.2025
c5 13 vss 0.00439216f $X=1.4435 $Y=0.0675
c6 14 vss 0.00431169f $X=1.5515 $Y=0.0675
c7 15 vss 0.00438795f $X=1.4435 $Y=0.2025
c8 16 vss 0.00430862f $X=1.5515 $Y=0.2025
c9 17 vss 0.00298983f $X=1.6465 $Y=0.036
c10 18 vss 0.00298983f $X=1.6465 $Y=0.234
c11 19 vss 0.0182026f $X=1.4455 $Y=0.036
c12 20 vss 0.0182675f $X=1.448 $Y=0.234
c13 21 vss 0.00879744f $X=1.6465 $Y=0.0855
r1 49 47 0.0308642 $w=8.1e-08 $l=2.5e-09 $layer=P_src_drn $thickness=1e-09
+ $X=1.5833 $Y=0.2025 $X2=1.5805 $Y2=0.2025
r2 4 47 0.179012 $w=8.1e-08 $l=1.45e-08 $layer=P_src_drn $thickness=1e-09
+ $X=1.566 $Y=0.2025 $X2=1.5805 $Y2=0.2025
r3 16 4 0.179012 $w=8.1e-08 $l=1.45e-08 $layer=P_src_drn $thickness=1e-09
+ $X=1.5515 $Y=0.2025 $X2=1.566 $Y2=0.2025
r4 48 16 0.0308642 $w=8.1e-08 $l=2.5e-09 $layer=P_src_drn $thickness=1e-09
+ $X=1.5486 $Y=0.2025 $X2=1.5515 $Y2=0.2025
r5 45 43 0.0308642 $w=8.1e-08 $l=2.5e-09 $layer=P_src_drn $thickness=1e-09
+ $X=1.4753 $Y=0.2025 $X2=1.4725 $Y2=0.2025
r6 2 43 0.179012 $w=8.1e-08 $l=1.45e-08 $layer=P_src_drn $thickness=1e-09
+ $X=1.458 $Y=0.2025 $X2=1.4725 $Y2=0.2025
r7 15 2 0.179012 $w=8.1e-08 $l=1.45e-08 $layer=P_src_drn $thickness=1e-09
+ $X=1.4435 $Y=0.2025 $X2=1.458 $Y2=0.2025
r8 44 15 0.0308642 $w=8.1e-08 $l=2.5e-09 $layer=P_src_drn $thickness=1e-09
+ $X=1.4406 $Y=0.2025 $X2=1.4435 $Y2=0.2025
r9 4 39 19.3796 $a=3.24e-16 $layer=V0LISD $X=1.566 $Y=0.2025 $X2=1.566 $Y2=0.234
r10 2 37 19.3796 $a=3.24e-16 $layer=V0LISD $X=1.458 $Y=0.2025 $X2=1.458
+ $Y2=0.234
r11 39 40 9.32759 $w=1.3e-08 $l=4e-08 $layer=M1 $thickness=3.6e-08 $X=1.566
+ $Y=0.234 $X2=1.606 $Y2=0.234
r12 38 39 12.5922 $w=1.3e-08 $l=5.4e-08 $layer=M1 $thickness=3.6e-08 $X=1.512
+ $Y=0.234 $X2=1.566 $Y2=0.234
r13 37 38 12.5922 $w=1.3e-08 $l=5.4e-08 $layer=M1 $thickness=3.6e-08 $X=1.458
+ $Y=0.234 $X2=1.512 $Y2=0.234
r14 20 37 2.3319 $w=1.3e-08 $l=1e-08 $layer=M1 $thickness=3.6e-08 $X=1.448
+ $Y=0.234 $X2=1.458 $Y2=0.234
r15 18 32 8.52248 $w=1.49091e-08 $l=4.95e-08 $layer=M1 $thickness=3.6e-08
+ $X=1.6465 $Y=0.234 $X2=1.6465 $Y2=0.1845
r16 18 40 7.67296 $w=1.54395e-08 $l=4.05e-08 $layer=M1 $thickness=3.6e-08
+ $X=1.6465 $Y=0.234 $X2=1.606 $Y2=0.234
r17 36 34 0.0308642 $w=8.1e-08 $l=2.5e-09 $layer=N_src_drn $thickness=1e-09
+ $X=1.5833 $Y=0.0675 $X2=1.5805 $Y2=0.0675
r18 3 34 0.179012 $w=8.1e-08 $l=1.45e-08 $layer=N_src_drn $thickness=1e-09
+ $X=1.566 $Y=0.0675 $X2=1.5805 $Y2=0.0675
r19 14 3 0.179012 $w=8.1e-08 $l=1.45e-08 $layer=N_src_drn $thickness=1e-09
+ $X=1.5515 $Y=0.0675 $X2=1.566 $Y2=0.0675
r20 35 14 0.0308642 $w=8.1e-08 $l=2.5e-09 $layer=N_src_drn $thickness=1e-09
+ $X=1.5486 $Y=0.0675 $X2=1.5515 $Y2=0.0675
r21 31 32 9.8736 $w=1.4e-08 $l=4.95e-08 $layer=M1 $thickness=3.6e-08 $X=1.646
+ $Y=0.1345 $X2=1.6465 $Y2=0.1845
r22 31 21 9.8736 $w=1.4e-08 $l=4.95e-08 $layer=M1 $thickness=3.6e-08 $X=1.646
+ $Y=0.1345 $X2=1.6465 $Y2=0.0855
r23 3 29 19.3796 $a=3.24e-16 $layer=V0LISD $X=1.566 $Y=0.0675 $X2=1.566
+ $Y2=0.036
r24 17 30 7.67296 $w=1.54395e-08 $l=4.05e-08 $layer=M1 $thickness=3.6e-08
+ $X=1.6465 $Y=0.036 $X2=1.606 $Y2=0.036
r25 17 21 8.52248 $w=1.49091e-08 $l=4.95e-08 $layer=M1 $thickness=3.6e-08
+ $X=1.6465 $Y=0.036 $X2=1.6465 $Y2=0.0855
r26 29 30 9.32759 $w=1.3e-08 $l=4e-08 $layer=M1 $thickness=3.6e-08 $X=1.566
+ $Y=0.036 $X2=1.606 $Y2=0.036
r27 28 29 12.5922 $w=1.3e-08 $l=5.4e-08 $layer=M1 $thickness=3.6e-08 $X=1.512
+ $Y=0.036 $X2=1.566 $Y2=0.036
r28 27 28 12.5922 $w=1.3e-08 $l=5.4e-08 $layer=M1 $thickness=3.6e-08 $X=1.458
+ $Y=0.036 $X2=1.512 $Y2=0.036
r29 26 27 2.3319 $w=1.3e-08 $l=1e-08 $layer=M1 $thickness=3.6e-08 $X=1.448
+ $Y=0.036 $X2=1.458 $Y2=0.036
r30 19 26 0.582974 $w=1.3e-08 $l=2.5e-09 $layer=M1 $thickness=3.6e-08 $X=1.4455
+ $Y=0.036 $X2=1.448 $Y2=0.036
r31 1 27 19.3796 $a=3.24e-16 $layer=V0LISD $X=1.458 $Y=0.0675 $X2=1.458
+ $Y2=0.036
r32 25 23 0.0308642 $w=8.1e-08 $l=2.5e-09 $layer=N_src_drn $thickness=1e-09
+ $X=1.4753 $Y=0.0675 $X2=1.4725 $Y2=0.0675
r33 1 23 0.179012 $w=8.1e-08 $l=1.45e-08 $layer=N_src_drn $thickness=1e-09
+ $X=1.458 $Y=0.0675 $X2=1.4725 $Y2=0.0675
r34 13 1 0.179012 $w=8.1e-08 $l=1.45e-08 $layer=N_src_drn $thickness=1e-09
+ $X=1.4435 $Y=0.0675 $X2=1.458 $Y2=0.0675
r35 24 13 0.0308642 $w=8.1e-08 $l=2.5e-09 $layer=N_src_drn $thickness=1e-09
+ $X=1.4406 $Y=0.0675 $X2=1.4435 $Y2=0.0675
.ends

.subckt PM_SDFLx4_ASAP7_75t_R%D vss 19 11 17 6 1 4 5 10 3 8 7 9
c1 1 vss 0.00517826f $X=0.459 $Y=0.135
c2 3 vss 0.108433f $X=0.459 $Y=0.0245
c3 4 vss 0.000923843f $X=0.387 $Y=0.108
c4 5 vss 0.00260587f $X=0.387 $Y=0.234
c5 6 vss 0.000783725f $X=0.459 $Y=0.108
c6 7 vss 0.0022152f $X=0.387 $Y=0.1405
c7 8 vss 0.0020136f $X=0.4365 $Y=0.108
c8 9 vss 0.00737448f $X=0.4095 $Y=0.234
c9 10 vss 0.000789062f $X=0.459 $Y=0.1215
r1 5 24 2.5483 $w=1.79e-08 $l=1.8e-08 $layer=M1 $thickness=3.6e-08 $X=0.387
+ $Y=0.234 $X2=0.387 $Y2=0.216
r2 5 9 3.59766 $w=1.5e-08 $l=2.25e-08 $layer=M1 $thickness=3.6e-08 $X=0.387
+ $Y=0.234 $X2=0.4095 $Y2=0.234
r3 23 24 4.19742 $w=1.3e-08 $l=1.8e-08 $layer=M1 $thickness=3.6e-08 $X=0.387
+ $Y=0.198 $X2=0.387 $Y2=0.216
r4 22 23 5.01358 $w=1.3e-08 $l=2.15e-08 $layer=M1 $thickness=3.6e-08 $X=0.387
+ $Y=0.1765 $X2=0.387 $Y2=0.198
r5 7 22 8.39483 $w=1.3e-08 $l=3.6e-08 $layer=M1 $thickness=3.6e-08 $X=0.387
+ $Y=0.1405 $X2=0.387 $Y2=0.1765
r6 4 21 3.59766 $w=1.5e-08 $l=2.25e-08 $layer=M1 $thickness=3.6e-08 $X=0.387
+ $Y=0.108 $X2=0.4095 $Y2=0.108
r7 4 7 5.92955 $w=1.57138e-08 $l=3.25e-08 $layer=M1 $thickness=3.6e-08 $X=0.387
+ $Y=0.108 $X2=0.387 $Y2=0.1405
r8 8 21 6.29612 $w=1.3e-08 $l=2.7e-08 $layer=M1 $thickness=3.6e-08 $X=0.4365
+ $Y=0.108 $X2=0.4095 $Y2=0.108
r9 6 10 1.49895 $w=1.95333e-08 $l=1.35e-08 $layer=M1 $thickness=3.6e-08
+ $X=0.459 $Y=0.108 $X2=0.459 $Y2=0.1215
r10 6 8 3.59766 $w=1.5e-08 $l=2.25e-08 $layer=M1 $thickness=3.6e-08 $X=0.459
+ $Y=0.108 $X2=0.4365 $Y2=0.108
r11 19 10 3.14806 $w=1.3e-08 $l=1.35e-08 $layer=M1 $thickness=3.6e-08 $X=0.459
+ $Y=0.1345 $X2=0.459 $Y2=0.1215
r12 1 14 10.4265 $w=1.765e-08 $layer=LIG $thickness=5.2e-08 $X=0.459 $Y=0.135
+ $X2=0.459 $Y2=0.135
r13 19 1 19.3796 $a=3.24e-16 $layer=V0LIG $X=0.459 $Y=0.1345 $X2=0.459 $Y2=0.135
r14 17 16 14.6259 $w=2.1e-08 $l=4.3e-08 $layer=Gate_1 $thickness=5.6e-08
+ $X=0.459 $Y=0.2025 $X2=0.459 $Y2=0.1595
r15 15 16 2.7211 $w=2.1e-08 $l=8e-09 $layer=Gate_1 $thickness=5.6e-08 $X=0.459
+ $Y=0.1515 $X2=0.459 $Y2=0.1595
r16 14 15 5.79936 $w=2.03333e-08 $l=1.65e-08 $layer=Gate_1 $thickness=5.6e-08
+ $X=0.459 $Y=0.135 $X2=0.459 $Y2=0.1515
r17 13 14 5.79936 $w=2.03333e-08 $l=1.65e-08 $layer=Gate_1 $thickness=5.6e-08
+ $X=0.459 $Y=0.1185 $X2=0.459 $Y2=0.135
r18 12 13 2.7211 $w=2.1e-08 $l=8e-09 $layer=Gate_1 $thickness=5.6e-08 $X=0.459
+ $Y=0.1105 $X2=0.459 $Y2=0.1185
r19 11 12 14.6259 $w=2.1e-08 $l=4.3e-08 $layer=Gate_1 $thickness=5.6e-08
+ $X=0.459 $Y=0.0675 $X2=0.459 $Y2=0.1105
r20 11 3 14.6259 $w=2.1e-08 $l=4.3e-08 $layer=Gate_1 $thickness=5.6e-08
+ $X=0.459 $Y=0.0675 $X2=0.459 $Y2=0.0245
.ends

.subckt PM_SDFLx4_ASAP7_75t_R%SE vss 30 18 24 46 49 8 12 13 10 11 14 15 7 5 1 2
+ 9 6
c1 1 vss 0.00969859f $X=0.288 $Y=0.135
c2 2 vss 0.00272435f $X=0.567 $Y=0.135
c3 5 vss 0.0939273f $X=0.297 $Y=0.0245
c4 6 vss 0.0651309f $X=0.567 $Y=0.135
c5 7 vss 0.00573595f $X=0.243 $Y=0.036
c6 8 vss 0.000362366f $X=0.243 $Y=0.135
c7 9 vss 0.00608475f $X=0.243 $Y=0.234
c8 10 vss 0.0063106f $X=0.567 $Y=0.072
c9 11 vss 0.00278117f $X=0.243 $Y=0.0585
c10 12 vss 0.0033014f $X=0.243 $Y=0.1845
c11 13 vss 0.000637049f $X=0.2615 $Y=0.135
c12 14 vss 0.00135521f $X=0.567 $Y=0.0855
c13 15 vss 0.0172685f $X=0.2315 $Y=0.081
r1 49 48 16.4967 $w=2.1e-08 $l=4.85e-08 $layer=Gate_1 $thickness=5.6e-08
+ $X=0.567 $Y=0.2025 $X2=0.567 $Y2=0.154
r2 46 47 16.4967 $w=2.1e-08 $l=4.85e-08 $layer=Gate_1 $thickness=5.6e-08
+ $X=0.567 $Y=0.0675 $X2=0.567 $Y2=0.116
r3 6 47 6.6497 $w=2.04211e-08 $l=1.9e-08 $layer=Gate_1 $thickness=5.6e-08
+ $X=0.567 $Y=0.135 $X2=0.567 $Y2=0.116
r4 6 48 6.6497 $w=2.04211e-08 $l=1.9e-08 $layer=Gate_1 $thickness=5.6e-08
+ $X=0.567 $Y=0.135 $X2=0.567 $Y2=0.154
r5 2 43 19.3796 $a=3.24e-16 $layer=V0LIG $X=0.567 $Y=0.135 $X2=0.567 $Y2=0.135
r6 2 6 10.4265 $w=1.765e-08 $layer=LIG $thickness=5.2e-08 $X=0.567 $Y=0.135
+ $X2=0.567 $Y2=0.135
r7 42 43 2.3319 $w=1.3e-08 $l=1e-08 $layer=M1 $thickness=3.6e-08 $X=0.567
+ $Y=0.125 $X2=0.567 $Y2=0.135
r8 41 42 2.3319 $w=1.3e-08 $l=1e-08 $layer=M1 $thickness=3.6e-08 $X=0.567
+ $Y=0.115 $X2=0.567 $Y2=0.125
r9 40 41 3.96423 $w=1.3e-08 $l=1.7e-08 $layer=M1 $thickness=3.6e-08 $X=0.567
+ $Y=0.098 $X2=0.567 $Y2=0.115
r10 14 40 2.91487 $w=1.3e-08 $l=1.25e-08 $layer=M1 $thickness=3.6e-08 $X=0.567
+ $Y=0.0855 $X2=0.567 $Y2=0.098
r11 14 36 39.0693 $a=1.62e-16 $layer=V1 $X=0.567 $Y=0.0855 $X2=0.567 $Y2=0.081
r12 10 36 39.0693 $a=1.62e-16 $layer=V1 $X=0.567 $Y=0.072 $X2=0.567 $Y2=0.081
r13 10 14 1.96775 $w=1.63333e-08 $l=1.35e-08 $layer=M1 $thickness=3.6e-08
+ $X=0.567 $Y=0.072 $X2=0.567 $Y2=0.0855
r14 9 12 10.3626 $w=1.39091e-08 $l=4.95e-08 $layer=M1 $thickness=3.6e-08
+ $X=0.243 $Y=0.234 $X2=0.243 $Y2=0.1845
r15 35 36 37.7767 $w=1.3e-08 $l=1.62e-07 $layer=M2 $thickness=3.6e-08 $X=0.405
+ $Y=0.081 $X2=0.567 $Y2=0.081
r16 34 35 37.7767 $w=1.3e-08 $l=1.62e-07 $layer=M2 $thickness=3.6e-08 $X=0.243
+ $Y=0.081 $X2=0.405 $Y2=0.081
r17 15 34 2.68168 $w=1.3e-08 $l=1.15e-08 $layer=M2 $thickness=3.6e-08 $X=0.2315
+ $Y=0.081 $X2=0.243 $Y2=0.081
r18 7 11 4.06646 $w=1.5e-08 $l=2.25e-08 $layer=M1 $thickness=3.6e-08 $X=0.243
+ $Y=0.036 $X2=0.243 $Y2=0.0585
r19 31 32 6.29612 $w=1.3e-08 $l=2.7e-08 $layer=M1 $thickness=3.6e-08 $X=0.243
+ $Y=0.081 $X2=0.243 $Y2=0.108
r20 31 34 19.5347 $a=3.24e-16 $layer=V1 $X=0.243 $Y=0.081 $X2=0.243 $Y2=0.081
r21 11 31 5.24677 $w=1.3e-08 $l=2.25e-08 $layer=M1 $thickness=3.6e-08 $X=0.243
+ $Y=0.0585 $X2=0.243 $Y2=0.081
r22 8 13 3.1337 $w=1.54324e-08 $l=1.85e-08 $layer=M1 $thickness=3.6e-08
+ $X=0.243 $Y=0.135 $X2=0.2615 $Y2=0.135
r23 8 32 5.11582 $w=1.46667e-08 $l=2.7e-08 $layer=M1 $thickness=3.6e-08
+ $X=0.243 $Y=0.135 $X2=0.243 $Y2=0.108
r24 8 12 10.3626 $w=1.39091e-08 $l=4.95e-08 $layer=M1 $thickness=3.6e-08
+ $X=0.243 $Y=0.135 $X2=0.243 $Y2=0.1845
r25 30 13 4.31401 $w=1.3e-08 $l=1.85e-08 $layer=M1 $thickness=3.6e-08 $X=0.278
+ $Y=0.1345 $X2=0.2615 $Y2=0.135
r26 30 28 19.3796 $a=3.24e-16 $layer=V0LIG $X=0.278 $Y=0.1345 $X2=0.279
+ $Y2=0.135
r27 1 26 2.6116 $w=2.2e-08 $l=1e-08 $layer=LIG $thickness=4.8e-08 $X=0.288
+ $Y=0.135 $X2=0.298 $Y2=0.135
r28 1 28 4.98695 $w=1.60444e-08 $l=9e-09 $layer=LIG $thickness=4.8e-08 $X=0.288
+ $Y=0.135 $X2=0.279 $Y2=0.135
r29 24 23 14.6259 $w=2.1e-08 $l=4.3e-08 $layer=Gate_1 $thickness=5.6e-08
+ $X=0.297 $Y=0.2025 $X2=0.297 $Y2=0.1595
r30 22 23 2.72111 $w=2.1e-08 $l=8e-09 $layer=Gate_1 $thickness=5.6e-08 $X=0.297
+ $Y=0.1515 $X2=0.297 $Y2=0.1595
r31 21 22 5.79936 $w=2.03333e-08 $l=1.65e-08 $layer=Gate_1 $thickness=5.6e-08
+ $X=0.297 $Y=0.135 $X2=0.297 $Y2=0.1515
r32 21 26 6.27904 $w=2.09e-08 $l=1e-09 $layer=Gate_1 $thickness=5.24e-08
+ $X=0.297 $Y=0.135 $X2=0.298 $Y2=0.135
r33 20 21 5.79936 $w=2.03333e-08 $l=1.65e-08 $layer=Gate_1 $thickness=5.6e-08
+ $X=0.297 $Y=0.1185 $X2=0.297 $Y2=0.135
r34 19 20 2.72111 $w=2.1e-08 $l=8e-09 $layer=Gate_1 $thickness=5.6e-08 $X=0.297
+ $Y=0.1105 $X2=0.297 $Y2=0.1185
r35 18 19 14.6259 $w=2.1e-08 $l=4.3e-08 $layer=Gate_1 $thickness=5.6e-08
+ $X=0.297 $Y=0.0675 $X2=0.297 $Y2=0.1105
r36 18 5 14.6259 $w=2.1e-08 $l=4.3e-08 $layer=Gate_1 $thickness=5.6e-08
+ $X=0.297 $Y=0.0675 $X2=0.297 $Y2=0.0245
.ends

* End of included file SDFLx4_ASAP7_75t_R.pex.sp.pex

*
.subckt SDFLx4_ASAP7_75t_CUSTOM_4_25_0_7 VSS VDD CLK SE D SI QN
*
* VSS VSS
* VDD VDD
* CLK CLK
* SE SE
* D D
* SI SI
* QN QN
*
*

M0 VSS N_M0_g N_M0_s VSS nmos_rvt L=2e-08 W=8.1e-08 nfin=3 $X=0.071 $Y=0.027
M1 N_M1_d N_M1_g VSS VSS nmos_rvt L=2e-08 W=8.1e-08 nfin=3 $X=0.125 $Y=0.027
M2 N_M2_d N_M2_g VSS VSS nmos_rvt L=2e-08 W=8.1e-08 nfin=3 $X=0.287 $Y=0.027
M3 noxref_21 N_M3_g noxref_14 VSS nmos_rvt L=2e-08 W=8.1e-08 nfin=3 $X=0.449
+ $Y=0.027
M4 VSS N_M4_g noxref_21 VSS nmos_rvt L=2e-08 W=8.1e-08 nfin=3 $X=0.503 $Y=0.027
M5 noxref_22 N_M5_g VSS VSS nmos_rvt L=2e-08 W=8.1e-08 nfin=3 $X=0.557 $Y=0.027
M6 noxref_14 N_M6_g noxref_22 VSS nmos_rvt L=2e-08 W=8.1e-08 nfin=3 $X=0.611
+ $Y=0.027
M7 N_M7_d N_M7_g noxref_14 VSS nmos_rvt L=2e-08 W=8.1e-08 nfin=3 $X=0.665
+ $Y=0.027
M8 N_M8_d N_M8_g N_M8_s VSS nmos_rvt L=2e-08 W=8.1e-08 nfin=3 $X=0.773 $Y=0.027
M9 VSS N_M9_g N_M9_s VSS nmos_rvt L=2e-08 W=8.1e-08 nfin=3 $X=0.881 $Y=0.027
M10 N_M10_d N_M10_g VSS VSS nmos_rvt L=2e-08 W=8.1e-08 nfin=3 $X=0.935 $Y=0.027
M11 N_M11_d N_M11_g N_M11_s VSS nmos_rvt L=2e-08 W=8.1e-08 nfin=3 $X=1.097
+ $Y=0.027
M12 N_M12_d N_M12_g N_M12_s VSS nmos_rvt L=2e-08 W=8.1e-08 nfin=3 $X=1.151
+ $Y=0.027
M13 VSS N_M13_g N_M13_s VSS nmos_rvt L=2e-08 W=8.1e-08 nfin=3 $X=1.205 $Y=0.027
M14 N_M14_d N_M14_g VSS VSS nmos_rvt L=2e-08 W=8.1e-08 nfin=3 $X=1.259 $Y=0.027
M15 N_M15_d N_M15_g VSS VSS nmos_rvt L=2e-08 W=8.1e-08 nfin=3 $X=1.421 $Y=0.027
M16 N_M16_d N_M16_g VSS VSS nmos_rvt L=2e-08 W=8.1e-08 nfin=3 $X=1.475 $Y=0.027
M17 N_M17_d N_M17_g VSS VSS nmos_rvt L=2e-08 W=8.1e-08 nfin=3 $X=1.529 $Y=0.027
M18 N_M18_d N_M18_g VSS VSS nmos_rvt L=2e-08 W=8.1e-08 nfin=3 $X=1.583 $Y=0.027
M19 VDD N_M19_g N_M19_s VDD pmos_rvt L=2e-08 W=8.1e-08 nfin=3 $X=0.071 $Y=0.162
M20 N_M20_d N_M20_g VDD VDD pmos_rvt L=2e-08 W=8.1e-08 nfin=3 $X=0.125 $Y=0.162
M21 N_M21_d N_M21_g VDD VDD pmos_rvt L=2e-08 W=8.1e-08 nfin=3 $X=0.287 $Y=0.162
M22 VDD N_M22_g N_M22_s VDD pmos_rvt L=2e-08 W=8.1e-08 nfin=3 $X=0.449 $Y=0.162
M23 N_M23_d N_M23_g VDD VDD pmos_rvt L=2e-08 W=8.1e-08 nfin=3 $X=0.503 $Y=0.162
M24 N_M24_d N_M24_g N_M24_s VDD pmos_rvt L=2e-08 W=8.1e-08 nfin=3 $X=0.557
+ $Y=0.162
M25 N_M25_d N_M25_g N_M25_s VDD pmos_rvt L=2e-08 W=8.1e-08 nfin=3 $X=0.611
+ $Y=0.162
M26 N_M26_d N_M26_g N_M26_s VDD pmos_rvt L=2e-08 W=8.1e-08 nfin=3 $X=0.773
+ $Y=0.162
M27 N_M27_d N_M27_g N_M27_s VDD pmos_rvt L=2e-08 W=8.1e-08 nfin=3 $X=0.827
+ $Y=0.162
M28 VDD N_M28_g N_M28_s VDD pmos_rvt L=2e-08 W=8.1e-08 nfin=3 $X=0.881 $Y=0.162
M29 N_M29_d N_M29_g VDD VDD pmos_rvt L=2e-08 W=8.1e-08 nfin=3 $X=0.935 $Y=0.162
M30 N_M30_d N_M30_g N_M30_s VDD pmos_rvt L=2e-08 W=8.1e-08 nfin=3 $X=1.043
+ $Y=0.162
M31 N_M31_d N_M31_g N_M31_s VDD pmos_rvt L=2e-08 W=8.1e-08 nfin=3 $X=1.097
+ $Y=0.162
M32 VDD N_M32_g N_M32_s VDD pmos_rvt L=2e-08 W=8.1e-08 nfin=3 $X=1.205 $Y=0.162
M33 N_M33_d N_M33_g VDD VDD pmos_rvt L=2e-08 W=8.1e-08 nfin=3 $X=1.259 $Y=0.162
M34 N_M34_d N_M34_g VDD VDD pmos_rvt L=2e-08 W=8.1e-08 nfin=3 $X=1.421 $Y=0.162
M35 N_M35_d N_M35_g VDD VDD pmos_rvt L=2e-08 W=8.1e-08 nfin=3 $X=1.475 $Y=0.162
M36 N_M36_d N_M36_g VDD VDD pmos_rvt L=2e-08 W=8.1e-08 nfin=3 $X=1.529 $Y=0.162
M37 N_M37_d N_M37_g VDD VDD pmos_rvt L=2e-08 W=8.1e-08 nfin=3 $X=1.583 $Y=0.162

* .include "SDFLx4_ASAP7_75t_R.pex.sp.pxi"

* Start of included file SDFLx4_ASAP7_75t_R.pex.sp.pxi
x_PM_SDFLx4_ASAP7_75t_R%CLK vss CLK N_M0_g N_M19_g N_CLK_3 N_CLK_4 N_CLK_1
+ N_CLK_5 PM_SDFLx4_ASAP7_75t_R%CLK
x_PM_SDFLx4_ASAP7_75t_R%7 vss N_M4_g N_M23_g N_M2_d N_M21_d N_7_10 N_7_14
+ N_7_11 N_7_4 N_7_1 N_7_13 N_7_3 N_7_15 N_7_12 N_7_17 N_7_19 N_7_9 N_7_18
+ PM_SDFLx4_ASAP7_75t_R%7
cc_1 N_7_10 N_SE_7 0.000182219f $X=0.3095 $Y=0.0675
cc_2 N_7_10 N_SE_15 0.000267243f $X=0.3095 $Y=0.0675
cc_3 N_7_10 N_SE_12 0.000295516f $X=0.3095 $Y=0.0675
cc_4 N_7_10 N_SE_11 0.000322056f $X=0.3095 $Y=0.0675
cc_5 N_7_14 N_SE_15 0.000365159f $X=0.351 $Y=0.072
cc_6 N_7_11 N_SE_5 0.0152572f $X=0.3095 $Y=0.2025
cc_7 N_7_4 N_SE_1 0.000554258f $X=0.324 $Y=0.2025
cc_8 N_7_1 N_SE_2 0.00165903f $X=0.513 $Y=0.135
cc_9 N_7_13 N_SE_9 0.00088707f $X=0.351 $Y=0.234
cc_10 N_7_4 N_SE_5 0.000976582f $X=0.324 $Y=0.2025
cc_11 N_7_3 N_SE_5 0.0010002f $X=0.324 $Y=0.0675
cc_12 N_7_15 N_SE_10 0.00113729f $X=0.513 $Y=0.072
cc_13 N_7_12 N_SE_7 0.00128304f $X=0.351 $Y=0.036
cc_14 N_7_17 N_SE_13 0.00187559f $X=0.351 $Y=0.09
cc_15 N_7_10 N_SE_1 0.00211007f $X=0.3095 $Y=0.0675
cc_16 N_7_19 N_SE_14 0.00262482f $X=0.513 $Y=0.1125
cc_17 N_7_9 N_SE_6 0.00315808f $X=0.513 $Y=0.0245
cc_18 N_7_18 N_SE_15 0.00400494f $X=0.486 $Y=0.072
cc_19 N_7_10 N_SE_5 0.0538178f $X=0.3095 $Y=0.0675
cc_20 N_7_1 N_D_1 0.00127839f $X=0.513 $Y=0.135
cc_21 N_7_18 N_D_6 0.00128032f $X=0.486 $Y=0.072
cc_22 N_7_18 N_D_4 0.00146809f $X=0.486 $Y=0.072
cc_23 N_7_13 N_D_5 0.00149379f $X=0.351 $Y=0.234
cc_24 N_7_19 N_D_10 0.00153398f $X=0.513 $Y=0.1125
cc_25 N_7_9 N_D_3 0.00508604f $X=0.513 $Y=0.0245
cc_26 N_7_18 N_D_8 0.00526203f $X=0.486 $Y=0.072
cc_27 N_7_17 N_D_7 0.00981304f $X=0.351 $Y=0.09
x_PM_SDFLx4_ASAP7_75t_R%SI vss SI N_M6_g N_M25_g N_SI_4 N_SI_12 N_SI_3 N_SI_1
+ N_SI_8 N_SI_7 PM_SDFLx4_ASAP7_75t_R%SI
cc_28 N_SI_4 N_4_26 0.000109372f $X=0.621 $Y=0.115
cc_29 N_SI_12 N_4_26 0.00109756f $X=0.7245 $Y=0.036
cc_30 N_SI_4 N_4_28 0.00330107f $X=0.621 $Y=0.115
cc_31 N_SI_3 N_SE_10 0.000298231f $X=0.621 $Y=0.0245
cc_32 N_SI_3 N_SE_14 0.000640243f $X=0.621 $Y=0.0245
cc_33 N_SI_1 N_SE_2 0.00200318f $X=0.621 $Y=0.135
cc_34 N_SI_4 N_SE_10 0.00148224f $X=0.621 $Y=0.115
cc_35 N_SI_4 N_SE_14 0.00151479f $X=0.621 $Y=0.115
cc_36 N_SI_3 N_SE_6 0.00548036f $X=0.621 $Y=0.0245
x_PM_SDFLx4_ASAP7_75t_R%15 vss N_M22_s N_M23_d N_M24_s N_M25_d N_15_11 N_15_2
+ N_15_13 N_15_1 N_15_10 N_15_12 N_15_3 PM_SDFLx4_ASAP7_75t_R%15
cc_37 N_15_11 N_SE_2 0.000710301f $X=0.5255 $Y=0.2025
cc_38 N_15_2 N_SE_6 0.000757831f $X=0.54 $Y=0.2025
cc_39 N_15_13 N_SE_14 0.00210209f $X=0.432 $Y=0.198
cc_40 N_15_11 N_SE_6 0.0335764f $X=0.5255 $Y=0.2025
cc_41 N_15_1 N_D_9 0.00109679f $X=0.432 $Y=0.2025
cc_42 N_15_13 N_D_7 0.001223f $X=0.432 $Y=0.198
cc_43 N_15_1 N_D_3 0.001858f $X=0.432 $Y=0.2025
cc_44 N_15_13 N_D_9 0.00221973f $X=0.432 $Y=0.198
cc_45 N_15_13 N_D_10 0.00450611f $X=0.432 $Y=0.198
cc_46 N_15_10 N_D_3 0.0348748f $X=0.434 $Y=0.2025
cc_47 N_15_1 N_7_18 0.000459788f $X=0.432 $Y=0.2025
cc_48 N_15_11 N_7_1 0.0006808f $X=0.5255 $Y=0.2025
cc_49 N_15_2 N_7_9 0.000794639f $X=0.54 $Y=0.2025
cc_50 N_15_13 N_7_19 0.00225121f $X=0.432 $Y=0.198
cc_51 N_15_11 N_7_9 0.0346536f $X=0.5255 $Y=0.2025
cc_52 N_15_12 N_SI_1 0.000700206f $X=0.6335 $Y=0.2025
cc_53 N_15_3 N_SI_3 0.000817026f $X=0.648 $Y=0.2025
cc_54 N_15_13 N_SI_8 0.00209417f $X=0.432 $Y=0.198
cc_55 N_15_12 N_SI_3 0.0340108f $X=0.6335 $Y=0.2025
cc_56 N_15_12 N_9_1 0.00107724f $X=0.6335 $Y=0.2025
cc_57 N_15_12 N_9_25 0.000648109f $X=0.6335 $Y=0.2025
cc_58 N_15_3 N_9_15 0.0010689f $X=0.648 $Y=0.2025
cc_59 N_15_13 N_9_29 0.00388626f $X=0.432 $Y=0.198
cc_60 N_15_12 N_9_15 0.0363235f $X=0.6335 $Y=0.2025
x_PM_SDFLx4_ASAP7_75t_R%16 vss N_M24_d N_M25_s N_M26_s N_16_8 N_16_2 N_16_7
+ N_16_1 N_16_9 PM_SDFLx4_ASAP7_75t_R%16
cc_61 N_16_8 N_4_2 0.000870429f $X=0.758 $Y=0.2025
cc_62 N_16_2 N_4_14 0.000782267f $X=0.756 $Y=0.2025
cc_63 N_16_8 N_4_14 0.0334591f $X=0.758 $Y=0.2025
cc_64 N_16_7 N_SE_2 0.00068773f $X=0.5795 $Y=0.2025
cc_65 N_16_1 N_SE_6 0.000775722f $X=0.594 $Y=0.2025
cc_66 N_16_7 N_SE_6 0.0337539f $X=0.5795 $Y=0.2025
cc_67 N_16_1 N_SI_3 0.000774722f $X=0.594 $Y=0.2025
cc_68 N_16_7 N_SI_3 0.0344737f $X=0.5795 $Y=0.2025
cc_69 N_16_9 N_9_1 0.000548181f $X=0.5825 $Y=0.234
cc_70 N_16_9 N_9_16 0.000376568f $X=0.5825 $Y=0.234
cc_71 N_16_9 N_9_29 0.000599404f $X=0.5825 $Y=0.234
cc_72 N_16_9 N_9_25 0.00166783f $X=0.5825 $Y=0.234
cc_73 N_16_8 N_11_13 0.00131072f $X=0.758 $Y=0.2025
cc_74 N_16_2 N_11_18 0.000604441f $X=0.756 $Y=0.2025
cc_75 N_16_2 N_11_19 0.000618842f $X=0.756 $Y=0.2025
cc_76 N_16_9 N_11_19 0.00101993f $X=0.5825 $Y=0.234
cc_77 N_16_9 N_11_14 0.00331574f $X=0.5825 $Y=0.234
cc_78 N_16_2 N_11_4 0.00452129f $X=0.756 $Y=0.2025
cc_79 N_16_7 N_15_12 0.000642521f $X=0.5795 $Y=0.2025
cc_80 N_16_1 N_15_13 0.000833029f $X=0.594 $Y=0.2025
cc_81 N_16_7 N_15_11 0.00119111f $X=0.5795 $Y=0.2025
cc_82 N_16_1 N_15_3 0.00177037f $X=0.594 $Y=0.2025
cc_83 N_16_1 N_15_2 0.00394857f $X=0.594 $Y=0.2025
cc_84 N_16_9 N_15_13 0.00979447f $X=0.5825 $Y=0.234
x_PM_SDFLx4_ASAP7_75t_R%18 vss N_M8_d N_M9_s N_18_4 N_18_5 N_18_1
+ PM_SDFLx4_ASAP7_75t_R%18
cc_85 N_18_4 N_4_26 0.000441754f $X=0.7955 $Y=0.0675
cc_86 N_18_4 N_4_2 0.000622099f $X=0.7955 $Y=0.0675
cc_87 N_18_4 N_4_14 0.0341117f $X=0.7955 $Y=0.0675
cc_88 N_18_5 N_9_2 0.00180763f $X=0.866 $Y=0.0675
cc_89 N_18_5 N_9_26 0.00101673f $X=0.866 $Y=0.0675
cc_90 N_18_5 N_9_16 0.0734613f $X=0.866 $Y=0.0675
cc_91 N_18_5 N_10_11 0.0350073f $X=0.866 $Y=0.0675
cc_92 N_18_1 N_11_3 0.00107664f $X=0.837 $Y=0.0675
cc_93 N_18_1 N_11_12 0.00271373f $X=0.837 $Y=0.0675
x_PM_SDFLx4_ASAP7_75t_R%19 vss N_M27_d N_M28_s N_19_3 N_19_1
+ PM_SDFLx4_ASAP7_75t_R%19
cc_94 N_19_3 N_9_2 0.000753235f $X=0.8495 $Y=0.2025
cc_95 N_19_3 N_9_26 0.000175786f $X=0.8495 $Y=0.2025
cc_96 N_19_3 N_9_16 0.0325385f $X=0.8495 $Y=0.2025
cc_97 N_19_3 N_10_1 0.00203653f $X=0.8495 $Y=0.2025
cc_98 N_19_3 N_10_11 0.0328815f $X=0.8495 $Y=0.2025
cc_99 N_19_1 N_11_13 0.000598125f $X=0.864 $Y=0.2025
cc_100 N_19_1 N_11_21 0.000670543f $X=0.864 $Y=0.2025
cc_101 N_19_1 N_11_4 0.00389208f $X=0.864 $Y=0.2025
x_PM_SDFLx4_ASAP7_75t_R%23 vss N_M12_d N_M13_s N_23_1 PM_SDFLx4_ASAP7_75t_R%23
cc_102 N_23_1 N_9_18 0.0168266f $X=1.188 $Y=0.0675
cc_103 N_23_1 N_12_9 0.0166598f $X=1.188 $Y=0.0675
x_PM_SDFLx4_ASAP7_75t_R%11 vss N_M10_g N_M29_g N_M26_d N_M27_s N_M7_d N_M8_s
+ N_11_12 N_11_3 N_11_13 N_11_19 N_11_4 N_11_18 N_11_22 N_11_11 N_11_15 N_11_14
+ N_11_21 N_11_10 N_11_1 PM_SDFLx4_ASAP7_75t_R%11
cc_104 N_11_12 N_4_26 0.000681755f $X=0.758 $Y=0.0675
cc_105 N_11_3 N_4_26 0.000408759f $X=0.729 $Y=0.0675
cc_106 N_11_13 N_4_14 0.0152794f $X=0.7955 $Y=0.2025
cc_107 N_11_3 N_4_28 0.00048874f $X=0.729 $Y=0.0675
cc_108 N_11_19 N_4_26 0.000661829f $X=0.7965 $Y=0.198
cc_109 N_11_4 N_4_14 0.000824965f $X=0.81 $Y=0.2025
cc_110 N_11_18 N_4_2 0.00088982f $X=0.747 $Y=0.178
cc_111 N_11_3 N_4_14 0.00118874f $X=0.729 $Y=0.0675
cc_112 N_11_12 N_4_2 0.00156033f $X=0.758 $Y=0.0675
cc_113 N_11_22 N_4_28 0.0016452f $X=0.945 $Y=0.116
cc_114 N_11_18 N_4_26 0.00771117f $X=0.747 $Y=0.178
cc_115 N_11_12 N_4_14 0.0532754f $X=0.758 $Y=0.0675
cc_116 N_11_3 N_SI_7 0.00222994f $X=0.729 $Y=0.0675
cc_117 N_11_18 N_SI_12 0.00140895f $X=0.747 $Y=0.178
cc_118 N_11_18 N_SI_7 0.0035765f $X=0.747 $Y=0.178
cc_119 N_11_11 N_9_29 0.000313691f $X=0.6875 $Y=0.0675
cc_120 N_11_11 N_9_26 0.00042436f $X=0.6875 $Y=0.0675
cc_121 N_11_11 N_9_25 0.000202592f $X=0.6875 $Y=0.0675
cc_122 N_11_3 N_9_25 0.000232807f $X=0.729 $Y=0.0675
cc_123 N_11_22 N_9_27 0.000265519f $X=0.945 $Y=0.116
cc_124 N_11_15 N_9_26 0.00102155f $X=0.81 $Y=0.198
cc_125 N_11_4 N_9_2 0.000327092f $X=0.81 $Y=0.2025
cc_126 N_11_14 N_9_25 0.000360303f $X=0.747 $Y=0.198
cc_127 N_11_13 N_9_16 0.0344636f $X=0.7955 $Y=0.2025
cc_128 N_11_19 N_9_26 0.000517474f $X=0.7965 $Y=0.198
cc_129 N_11_3 N_9_1 0.000663302f $X=0.729 $Y=0.0675
cc_130 N_11_13 N_9_2 0.000673901f $X=0.7955 $Y=0.2025
cc_131 N_11_21 N_9_26 0.000744719f $X=0.918 $Y=0.234
cc_132 N_11_4 N_9_16 0.000886861f $X=0.81 $Y=0.2025
cc_133 N_11_4 N_9_26 0.00106337f $X=0.81 $Y=0.2025
cc_134 N_11_3 N_9_15 0.0013661f $X=0.729 $Y=0.0675
cc_135 N_11_11 N_9_1 0.00177138f $X=0.6875 $Y=0.0675
cc_136 N_11_18 N_9_25 0.0030053f $X=0.747 $Y=0.178
cc_137 N_11_22 N_9_29 0.00427093f $X=0.945 $Y=0.116
cc_138 N_11_11 N_9_15 0.0349076f $X=0.6875 $Y=0.0675
cc_139 N_11_10 N_10_12 0.015152f $X=0.945 $Y=0.0245
cc_140 N_11_1 N_10_1 0.00044797f $X=0.945 $Y=0.135
cc_141 N_11_10 N_10_3 0.000777212f $X=0.945 $Y=0.0245
cc_142 N_11_22 N_10_18 0.000955052f $X=0.945 $Y=0.116
cc_143 N_11_1 N_10_5 0.00235965f $X=0.945 $Y=0.135
cc_144 N_11_10 N_10_11 0.00166065f $X=0.945 $Y=0.0245
cc_145 N_11_10 N_10_4 0.00171398f $X=0.945 $Y=0.0245
cc_146 N_11_1 N_10_14 0.00252484f $X=0.945 $Y=0.135
cc_147 N_11_22 N_10_17 0.00502557f $X=0.945 $Y=0.116
cc_148 N_11_10 N_10_14 0.0556902f $X=0.945 $Y=0.0245
x_PM_SDFLx4_ASAP7_75t_R%4 vss N_M11_g N_M31_g N_M8_g N_M26_g N_M1_g N_M20_g
+ N_M0_s N_M19_s N_4_8 N_4_7 N_4_25 N_4_19 N_4_1 N_4_17 N_4_21 N_4_24 N_4_22
+ N_4_28 N_4_13 N_4_23 N_4_16 N_4_26 N_4_2 N_4_27 N_4_3 N_4_15 N_4_14
+ PM_SDFLx4_ASAP7_75t_R%4
cc_149 N_4_8 N_CLK_3 0.00143528f $X=0.054 $Y=0.2025
cc_150 N_4_7 N_CLK_3 0.00147115f $X=0.054 $Y=0.0675
cc_151 N_4_25 N_CLK_3 0.000234385f $X=0.135 $Y=0.1055
cc_152 N_4_19 N_CLK_3 0.000252001f $X=0.0165 $Y=0.117
cc_153 N_4_1 N_CLK_3 0.000957991f $X=0.135 $Y=0.135
cc_154 N_4_17 N_CLK_3 0.0153075f $X=0.056 $Y=0.2025
cc_155 N_4_21 N_CLK_3 0.000422606f $X=0.018 $Y=0.0945
cc_156 N_4_24 N_CLK_3 0.000455827f $X=0.036 $Y=0.234
cc_157 N_4_22 N_CLK_3 0.000936411f $X=0.018 $Y=0.163
cc_158 N_4_28 N_CLK_4 0.0011192f $X=0.6775 $Y=0.117
cc_159 N_4_7 N_CLK_1 0.00118568f $X=0.054 $Y=0.0675
cc_160 N_4_13 N_CLK_3 0.00168337f $X=0.135 $Y=0.135
cc_161 N_4_25 N_CLK_5 0.00187073f $X=0.135 $Y=0.1055
cc_162 N_4_17 N_CLK_1 0.00219442f $X=0.056 $Y=0.2025
cc_163 N_4_23 N_CLK_4 0.00379888f $X=0.036 $Y=0.036
cc_164 N_4_19 N_CLK_5 0.00691793f $X=0.0165 $Y=0.117
cc_165 N_4_16 N_CLK_3 0.0552178f $X=0.056 $Y=0.0675
x_PM_SDFLx4_ASAP7_75t_R%9 vss N_M12_g N_M7_g N_M27_g N_M30_g N_M20_d N_M1_d
+ N_9_24 N_9_10 N_9_21 N_9_9 N_9_23 N_9_1 N_9_20 N_9_22 N_9_28 N_9_4 N_9_25
+ N_9_19 N_9_26 N_9_27 N_9_3 N_9_29 N_9_2 N_9_17 N_9_16 N_9_18 N_9_15
+ PM_SDFLx4_ASAP7_75t_R%9
cc_166 N_9_24 N_CLK_4 0.000221024f $X=0.189 $Y=0.1235
cc_167 N_9_10 N_CLK_4 0.000638677f $X=0.162 $Y=0.2025
cc_168 N_9_21 N_CLK_4 7.7156e-20 $X=0.189 $Y=0.234
cc_169 N_9_9 N_CLK_4 9.65302e-20 $X=0.162 $Y=0.0675
cc_170 N_9_23 N_CLK_4 0.00118491f $X=0.1505 $Y=0.036
cc_171 N_9_21 N_4_28 4.69869e-20 $X=0.189 $Y=0.234
cc_172 N_9_1 N_4_28 5.23191e-20 $X=0.6745 $Y=0.135
cc_173 N_9_23 N_4_7 6.60088e-20 $X=0.1505 $Y=0.036
cc_174 N_9_21 N_4_8 6.9712e-20 $X=0.189 $Y=0.234
cc_175 N_9_21 N_4_22 7.20351e-20 $X=0.189 $Y=0.234
cc_176 N_9_20 N_4_8 8.32099e-20 $X=0.1475 $Y=0.2025
cc_177 N_9_22 N_4_25 8.35392e-20 $X=0.189 $Y=0.036
cc_178 N_9_1 N_4_2 9.9183e-20 $X=0.6745 $Y=0.135
cc_179 N_9_21 N_4_24 0.00010297f $X=0.189 $Y=0.234
cc_180 N_9_9 N_4_13 0.00126937f $X=0.162 $Y=0.0675
cc_181 N_9_28 N_4_27 0.0016758f $X=1.161 $Y=0.116
cc_182 N_9_10 N_4_25 0.000258787f $X=0.162 $Y=0.2025
cc_183 N_9_4 N_4_3 0.00191667f $X=1.161 $Y=0.135
cc_184 N_9_24 N_4_25 0.00651692f $X=0.189 $Y=0.1235
cc_185 N_9_25 N_4_28 0.00082279f $X=0.693 $Y=0.125
cc_186 N_9_20 N_4_13 0.0153335f $X=0.1475 $Y=0.2025
cc_187 N_9_19 N_4_13 0.0534332f $X=0.1475 $Y=0.0675
cc_188 N_9_26 N_4_28 0.000510237f $X=0.837 $Y=0.098
cc_189 N_9_27 N_4_28 0.000531995f $X=1.053 $Y=0.116
cc_190 N_9_3 N_4_3 0.00162095f $X=1.053 $Y=0.135
cc_191 N_9_29 N_4_26 0.000564931f $X=1.1365 $Y=0.153
cc_192 N_9_24 N_4_28 0.000627334f $X=0.189 $Y=0.1235
cc_193 N_9_21 N_4_25 0.000671806f $X=0.189 $Y=0.234
cc_194 N_9_10 N_4_1 0.000739617f $X=0.162 $Y=0.2025
cc_195 N_9_29 N_4_27 0.000779872f $X=1.1365 $Y=0.153
cc_196 N_9_2 N_4_2 0.00196675f $X=0.837 $Y=0.135
cc_197 N_9_23 N_4_23 0.000978121f $X=0.1505 $Y=0.036
cc_198 N_9_10 N_4_13 0.00132529f $X=0.162 $Y=0.2025
cc_199 N_9_17 N_4_15 0.00142792f $X=1.053 $Y=0.135
cc_200 N_9_20 N_4_1 0.00164101f $X=0.1475 $Y=0.2025
cc_201 N_9_16 N_4_14 0.00326666f $X=0.837 $Y=0.135
cc_202 N_9_26 N_4_26 0.0039363f $X=0.837 $Y=0.098
cc_203 N_9_18 N_4_15 0.00483705f $X=1.161 $Y=0.0245
cc_204 N_9_27 N_4_27 0.00508182f $X=1.053 $Y=0.116
cc_205 N_9_29 N_4_28 0.0684029f $X=1.1365 $Y=0.153
cc_206 N_9_24 N_SE_15 0.00017822f $X=0.189 $Y=0.1235
cc_207 N_9_23 N_SE_15 0.000159445f $X=0.1505 $Y=0.036
cc_208 N_9_10 N_SE_12 0.000196641f $X=0.162 $Y=0.2025
cc_209 N_9_24 N_SE_12 0.00251307f $X=0.189 $Y=0.1235
cc_210 N_9_9 N_SE_11 0.000215072f $X=0.162 $Y=0.0675
cc_211 N_9_24 N_SE_11 0.00183963f $X=0.189 $Y=0.1235
cc_212 N_9_29 N_SE_13 0.000504873f $X=1.1365 $Y=0.153
cc_213 N_9_29 N_SE_14 0.000529556f $X=1.1365 $Y=0.153
cc_214 N_9_22 N_SE_7 0.000860457f $X=0.189 $Y=0.036
cc_215 N_9_21 N_SE_9 0.00110086f $X=0.189 $Y=0.234
cc_216 N_9_24 N_SE_8 0.00385691f $X=0.189 $Y=0.1235
cc_217 N_9_29 N_SE_15 0.00418108f $X=1.1365 $Y=0.153
cc_218 N_9_29 N_D_10 0.00353307f $X=1.1365 $Y=0.153
cc_219 N_9_24 N_7_17 9.83921e-20 $X=0.189 $Y=0.1235
cc_220 N_9_29 N_7_17 0.00403109f $X=1.1365 $Y=0.153
cc_221 N_9_29 N_SI_3 0.000103004f $X=1.1365 $Y=0.153
cc_222 N_9_26 N_SI_3 0.0001202f $X=0.837 $Y=0.098
cc_223 N_9_25 N_SI_3 0.00104769f $X=0.693 $Y=0.125
cc_224 N_9_1 N_SI_1 0.00164804f $X=0.6745 $Y=0.135
cc_225 N_9_1 N_SI_4 0.000514131f $X=0.6745 $Y=0.135
cc_226 N_9_29 N_SI_8 0.00133252f $X=1.1365 $Y=0.153
cc_227 N_9_25 N_SI_4 0.00184482f $X=0.693 $Y=0.125
cc_228 N_9_15 N_SI_3 0.00332557f $X=0.675 $Y=0.135
x_PM_SDFLx4_ASAP7_75t_R%10 vss N_M9_g N_M28_g N_M10_d N_M11_s N_M29_d N_M30_s
+ N_10_13 N_10_3 N_10_18 N_10_17 N_10_15 N_10_1 N_10_5 N_10_4 N_10_11 N_10_12
+ N_10_14 PM_SDFLx4_ASAP7_75t_R%10
cc_229 N_10_13 N_4_26 0.000148575f $X=1.082 $Y=0.0675
cc_230 N_10_13 N_4_3 0.00101626f $X=1.082 $Y=0.0675
cc_231 N_10_13 N_4_28 0.000270606f $X=1.082 $Y=0.0675
cc_232 N_10_3 N_4_27 0.000709292f $X=0.968 $Y=0.0675
cc_233 N_10_18 N_4_28 0.000894252f $X=0.918 $Y=0.072
cc_234 N_10_3 N_4_15 0.00136329f $X=0.968 $Y=0.0675
cc_235 N_10_17 N_4_28 0.00259094f $X=0.891 $Y=0.116
cc_236 N_10_13 N_4_15 0.0345507f $X=1.082 $Y=0.0675
cc_237 N_10_15 N_9_27 8.68371e-20 $X=1.028 $Y=0.2025
cc_238 N_10_15 N_9_26 0.000566055f $X=1.028 $Y=0.2025
cc_239 N_10_15 N_9_29 0.000262865f $X=1.028 $Y=0.2025
cc_240 N_10_1 N_9_2 0.00125509f $X=0.891 $Y=0.135
cc_241 N_10_13 N_9_17 0.0171941f $X=1.082 $Y=0.0675
cc_242 N_10_17 N_9_29 0.000842112f $X=0.891 $Y=0.116
cc_243 N_10_3 N_9_3 0.0035404f $X=0.968 $Y=0.0675
cc_244 N_10_5 N_9_3 0.00131921f $X=0.9985 $Y=0.135
cc_245 N_10_4 N_9_17 0.00153332f $X=0.999 $Y=0.2025
cc_246 N_10_4 N_9_27 0.0015912f $X=0.999 $Y=0.2025
cc_247 N_10_11 N_9_16 0.00324004f $X=0.891 $Y=0.0245
cc_248 N_10_17 N_9_26 0.00340408f $X=0.891 $Y=0.116
cc_249 N_10_3 N_9_17 0.00403887f $X=0.968 $Y=0.0675
cc_250 N_10_15 N_9_17 0.0559089f $X=1.028 $Y=0.2025
x_PM_SDFLx4_ASAP7_75t_R%12 vss N_M13_g N_M32_g N_M33_d N_M14_d N_12_9 N_12_1
+ N_12_15 N_12_10 N_12_17 N_12_4 N_12_3 N_12_14 N_12_13 N_12_11 N_12_16 N_12_12
+ PM_SDFLx4_ASAP7_75t_R%12
cc_251 N_12_9 N_9_28 0.000955221f $X=1.215 $Y=0.0245
cc_252 N_12_9 N_9_29 0.000342108f $X=1.215 $Y=0.0245
cc_253 N_12_9 N_9_4 0.000721058f $X=1.215 $Y=0.0245
cc_254 N_12_1 N_9_4 0.00128148f $X=1.215 $Y=0.135
cc_255 N_12_15 N_9_28 0.00310116f $X=1.215 $Y=0.135
cc_256 N_12_9 N_9_18 0.00506687f $X=1.215 $Y=0.0245
x_PM_SDFLx4_ASAP7_75t_R%20 vss N_M31_d N_M32_s N_20_4 N_20_5 N_20_1
+ PM_SDFLx4_ASAP7_75t_R%20
cc_257 N_20_4 N_4_27 0.000191381f $X=1.1195 $Y=0.2025
cc_258 N_20_4 N_4_3 0.000621059f $X=1.1195 $Y=0.2025
cc_259 N_20_4 N_4_15 0.0338282f $X=1.1195 $Y=0.2025
cc_260 N_20_4 N_9_4 0.00181521f $X=1.1195 $Y=0.2025
cc_261 N_20_4 N_9_28 0.00090335f $X=1.1195 $Y=0.2025
cc_262 N_20_4 N_9_18 0.0731883f $X=1.1195 $Y=0.2025
cc_263 N_20_5 N_12_9 0.0351016f $X=1.19 $Y=0.2025
cc_264 N_20_1 N_13_17 0.00115144f $X=1.161 $Y=0.2025
cc_265 N_20_1 N_13_5 0.00104846f $X=1.161 $Y=0.2025
cc_266 N_20_1 N_13_23 0.00429686f $X=1.161 $Y=0.2025
x_PM_SDFLx4_ASAP7_75t_R%13 vss N_M14_g N_M33_g N_M11_d N_M12_s N_M15_g N_M34_g
+ N_M16_g N_M35_g N_M17_g N_M36_g N_M18_g N_M37_g N_M30_d N_M31_s N_13_16
+ N_13_6 N_13_23 N_13_17 N_13_5 N_13_24 N_13_28 N_13_25 N_13_19 N_13_21 N_13_1
+ N_13_11 N_13_26 N_13_27 N_13_20 N_13_22 N_13_2 N_13_14 N_13_13 N_13_29
+ N_13_15 N_13_12 PM_SDFLx4_ASAP7_75t_R%13
cc_267 N_13_16 N_4_28 7.84609e-20 $X=1.1195 $Y=0.0675
cc_268 N_13_16 N_4_27 9.87103e-20 $X=1.1195 $Y=0.0675
cc_269 N_13_6 N_4_27 0.0019167f $X=1.134 $Y=0.0675
cc_270 N_13_23 N_4_27 0.000367417f $X=1.35 $Y=0.234
cc_271 N_13_23 N_4_28 0.000377816f $X=1.35 $Y=0.234
cc_272 N_13_6 N_4_3 0.000438555f $X=1.134 $Y=0.0675
cc_273 N_13_17 N_4_15 0.0153152f $X=1.0655 $Y=0.2025
cc_274 N_13_5 N_4_15 0.000910608f $X=1.08 $Y=0.2025
cc_275 N_13_24 N_4_27 0.000975738f $X=1.233 $Y=0.036
cc_276 N_13_6 N_4_15 0.00113599f $X=1.134 $Y=0.0675
cc_277 N_13_16 N_4_3 0.00130701f $X=1.1195 $Y=0.0675
cc_278 N_13_16 N_4_15 0.0537624f $X=1.1195 $Y=0.0675
cc_279 N_13_16 N_9_28 0.000254555f $X=1.1195 $Y=0.0675
cc_280 N_13_6 N_9_18 0.00131998f $X=1.134 $Y=0.0675
cc_281 N_13_28 N_9_28 0.000148114f $X=1.377 $Y=0.172
cc_282 N_13_23 N_9_28 0.00277044f $X=1.35 $Y=0.234
cc_283 N_13_25 N_9_28 0.000193201f $X=1.251 $Y=0.116
cc_284 N_13_5 N_9_3 0.000212749f $X=1.08 $Y=0.2025
cc_285 N_13_19 N_9_28 0.000237145f $X=1.251 $Y=0.135
cc_286 N_13_5 N_9_27 0.00136231f $X=1.08 $Y=0.2025
cc_287 N_13_6 N_9_4 0.000386391f $X=1.134 $Y=0.0675
cc_288 N_13_17 N_9_17 0.0343744f $X=1.0655 $Y=0.2025
cc_289 N_13_17 N_9_3 0.000655234f $X=1.0655 $Y=0.2025
cc_290 N_13_24 N_9_28 0.00066648f $X=1.233 $Y=0.036
cc_291 N_13_16 N_9_4 0.000821724f $X=1.1195 $Y=0.0675
cc_292 N_13_23 N_9_29 0.00108387f $X=1.35 $Y=0.234
cc_293 N_13_5 N_9_17 0.00131406f $X=1.08 $Y=0.2025
cc_294 N_13_6 N_9_28 0.0019318f $X=1.134 $Y=0.0675
cc_295 N_13_16 N_9_18 0.0349533f $X=1.1195 $Y=0.0675
cc_296 N_13_6 N_10_3 0.00126447f $X=1.134 $Y=0.0675
cc_297 N_13_5 N_10_3 0.000179045f $X=1.08 $Y=0.2025
cc_298 N_13_24 N_10_3 0.000196051f $X=1.233 $Y=0.036
cc_299 N_13_17 N_10_3 0.000560581f $X=1.0655 $Y=0.2025
cc_300 N_13_16 N_10_13 0.00119383f $X=1.1195 $Y=0.0675
cc_301 N_13_17 N_10_15 0.000595759f $X=1.0655 $Y=0.2025
cc_302 N_13_5 N_10_4 0.00113121f $X=1.08 $Y=0.2025
cc_303 N_13_17 N_10_4 0.00136322f $X=1.0655 $Y=0.2025
cc_304 N_13_16 N_10_3 0.00207366f $X=1.1195 $Y=0.0675
cc_305 N_13_6 N_12_10 0.000233561f $X=1.134 $Y=0.0675
cc_306 N_13_24 N_12_10 0.00042233f $X=1.233 $Y=0.036
cc_307 N_13_21 N_12_17 0.000522072f $X=1.377 $Y=0.135
cc_308 N_13_23 N_12_4 0.000605319f $X=1.35 $Y=0.234
cc_309 N_13_19 N_12_1 0.000621183f $X=1.251 $Y=0.135
cc_310 N_13_1 N_12_1 0.000675377f $X=1.269 $Y=0.135
cc_311 N_13_25 N_12_3 0.000937384f $X=1.251 $Y=0.116
cc_312 N_13_1 N_12_3 0.00123309f $X=1.269 $Y=0.135
cc_313 N_13_28 N_12_14 0.00130609f $X=1.377 $Y=0.172
cc_314 N_13_23 N_12_14 0.00136353f $X=1.35 $Y=0.234
cc_315 N_13_11 N_12_4 0.00174953f $X=1.269 $Y=0.0245
cc_316 N_13_11 N_12_9 0.00191156f $X=1.269 $Y=0.0245
cc_317 N_13_26 N_12_13 0.00198396f $X=1.2715 $Y=0.036
cc_318 N_13_1 N_12_11 0.0022089f $X=1.269 $Y=0.135
cc_319 N_13_27 N_12_13 0.00232657f $X=1.377 $Y=0.063
cc_320 N_13_25 N_12_15 0.00238098f $X=1.251 $Y=0.116
cc_321 N_13_11 N_12_3 0.00247663f $X=1.269 $Y=0.0245
cc_322 N_13_19 N_12_17 0.00277814f $X=1.251 $Y=0.135
cc_323 N_13_19 N_12_13 0.00302517f $X=1.251 $Y=0.135
cc_324 N_13_23 N_12_16 0.00303023f $X=1.35 $Y=0.234
cc_325 N_13_19 N_12_15 0.00362688f $X=1.251 $Y=0.135
cc_326 N_13_11 N_12_11 0.0149912f $X=1.269 $Y=0.0245
cc_327 N_13_23 N_12_12 0.0053964f $X=1.35 $Y=0.234
cc_328 N_13_11 N_12_10 0.055948f $X=1.269 $Y=0.0245
x_PM_SDFLx4_ASAP7_75t_R%QN vss QN N_M15_d N_M16_d N_M17_d N_M18_d N_M34_d
+ N_M35_d N_M36_d N_M37_d N_QN_13 N_QN_3 N_QN_4 N_QN_1 N_QN_2 N_QN_15 N_QN_14
+ N_QN_16 PM_SDFLx4_ASAP7_75t_R%QN
cc_329 N_QN_13 N_13_26 0.000104401f $X=1.4435 $Y=0.0675
cc_330 N_QN_13 N_13_20 0.000146998f $X=1.4435 $Y=0.0675
cc_331 N_QN_13 N_13_22 0.000147072f $X=1.4435 $Y=0.0675
cc_332 N_QN_13 N_13_28 0.000406078f $X=1.4435 $Y=0.0675
cc_333 N_QN_13 N_13_2 0.000961212f $X=1.4435 $Y=0.0675
cc_334 N_QN_13 N_13_27 0.000446272f $X=1.4435 $Y=0.0675
cc_335 N_QN_13 N_13_14 0.00336084f $X=1.4435 $Y=0.0675
cc_336 N_QN_13 N_13_13 0.0379337f $X=1.4435 $Y=0.0675
cc_337 N_QN_13 N_13_29 0.00090999f $X=1.4435 $Y=0.0675
cc_338 N_QN_3 N_13_15 0.00162015f $X=1.566 $Y=0.0675
cc_339 N_QN_4 N_13_15 0.00162015f $X=1.566 $Y=0.2025
cc_340 N_QN_1 N_13_12 0.00191102f $X=1.458 $Y=0.0675
cc_341 N_QN_2 N_13_12 0.00191102f $X=1.458 $Y=0.2025
cc_342 N_QN_15 N_13_2 0.00992906f $X=1.4435 $Y=0.2025
cc_343 N_QN_15 N_13_12 0.0281558f $X=1.4435 $Y=0.2025
cc_344 N_QN_14 N_13_15 0.0102817f $X=1.5515 $Y=0.0675
cc_345 N_QN_16 N_13_14 0.0102819f $X=1.5515 $Y=0.2025
cc_346 N_QN_16 N_13_15 0.054459f $X=1.5515 $Y=0.2025
cc_347 N_QN_14 N_13_14 0.0546416f $X=1.5515 $Y=0.0675
cc_348 N_QN_13 N_13_12 0.0646195f $X=1.4435 $Y=0.0675
x_PM_SDFLx4_ASAP7_75t_R%D vss D N_M3_g N_M22_g N_D_6 N_D_1 N_D_4 N_D_5 N_D_10
+ N_D_3 N_D_8 N_D_7 N_D_9 PM_SDFLx4_ASAP7_75t_R%D
cc_349 N_D_6 N_4_28 0.00247509f $X=0.459 $Y=0.108
x_PM_SDFLx4_ASAP7_75t_R%SE vss SE N_M2_g N_M21_g N_M5_g N_M24_g N_SE_8 N_SE_12
+ N_SE_13 N_SE_10 N_SE_11 N_SE_14 N_SE_15 N_SE_7 N_SE_5 N_SE_1 N_SE_2 N_SE_9
+ N_SE_6 PM_SDFLx4_ASAP7_75t_R%SE
cc_350 N_SE_8 N_4_28 0.000169554f $X=0.243 $Y=0.135
cc_351 N_SE_12 N_4_25 0.000225275f $X=0.243 $Y=0.1845
cc_352 N_SE_13 N_4_28 0.000367523f $X=0.2615 $Y=0.135
cc_353 N_SE_10 N_4_28 0.000418561f $X=0.567 $Y=0.072
cc_354 N_SE_11 N_4_28 0.000973707f $X=0.243 $Y=0.0585
cc_355 N_SE_14 N_4_28 0.00050645f $X=0.567 $Y=0.0855
cc_356 N_SE_15 N_4_28 0.0272832f $X=0.2315 $Y=0.081

* End of included file SDFLx4_ASAP7_75t_R.pex.sp.pxi
.ends

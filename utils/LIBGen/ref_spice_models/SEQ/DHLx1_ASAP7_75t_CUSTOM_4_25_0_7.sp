.subckt PM_DHLx1_ASAP7_75t_R%12 vss 2 3 1
c1 1 vss 0.000538837f $X=0.486 $Y=0.0405
r1 2 1 0.62963 $w=2.7e-08 $l=1.7e-08 $layer=N_src_drn $thickness=1e-09
+ $X=0.4686 $Y=0.0405 $X2=0.486 $Y2=0.0405
r2 3 1 0.62963 $w=2.7e-08 $l=1.7e-08 $layer=N_src_drn $thickness=1e-09
+ $X=0.5033 $Y=0.0405 $X2=0.486 $Y2=0.0405
.ends

.subckt PM_DHLx1_ASAP7_75t_R%D vss 16 6 12 5 1 3 4
c1 1 vss 0.00510695f $X=0.297 $Y=0.1345
c2 3 vss 0.0917954f $X=0.297 $Y=0.0245
c3 4 vss 0.0056508f $X=0.297 $Y=0.036
c4 5 vss 0.00900313f $X=0.297 $Y=0.0755
r1 4 5 8.03069 $w=1.41392e-08 $l=3.95e-08 $layer=M1 $thickness=3.6e-08 $X=0.297
+ $Y=0.036 $X2=0.297 $Y2=0.0755
r2 17 18 3.14806 $w=1.3e-08 $l=1.35e-08 $layer=M1 $thickness=3.6e-08 $X=0.297
+ $Y=0.1215 $X2=0.297 $Y2=0.135
r3 16 17 1.16595 $w=1.3e-08 $l=5e-09 $layer=M1 $thickness=3.6e-08 $X=0.297
+ $Y=0.1165 $X2=0.297 $Y2=0.1215
r4 16 15 1.28254 $w=1.3e-08 $l=5.5e-09 $layer=M1 $thickness=3.6e-08 $X=0.297
+ $Y=0.1165 $X2=0.297 $Y2=0.111
r5 5 15 8.27824 $w=1.3e-08 $l=3.55e-08 $layer=M1 $thickness=3.6e-08 $X=0.297
+ $Y=0.0755 $X2=0.297 $Y2=0.111
r6 1 9 10.1312 $w=1.77047e-08 $l=5e-10 $layer=LIG $thickness=5.2093e-08
+ $X=0.297 $Y=0.1345 $X2=0.297 $Y2=0.135
r7 1 18 19.3796 $a=3.24e-16 $layer=V0LIG $X=0.297 $Y=0.1345 $X2=0.297 $Y2=0.135
r8 12 11 14.6259 $w=2.1e-08 $l=4.3e-08 $layer=Gate_1 $thickness=5.6e-08
+ $X=0.297 $Y=0.2025 $X2=0.297 $Y2=0.1595
r9 10 11 2.7211 $w=2.1e-08 $l=8e-09 $layer=Gate_1 $thickness=5.6e-08 $X=0.297
+ $Y=0.1515 $X2=0.297 $Y2=0.1595
r10 9 10 5.79936 $w=2.03333e-08 $l=1.65e-08 $layer=Gate_1 $thickness=5.6e-08
+ $X=0.297 $Y=0.135 $X2=0.297 $Y2=0.1515
r11 8 9 5.79936 $w=2.03333e-08 $l=1.65e-08 $layer=Gate_1 $thickness=5.6e-08
+ $X=0.297 $Y=0.1185 $X2=0.297 $Y2=0.135
r12 7 8 2.7211 $w=2.1e-08 $l=8e-09 $layer=Gate_1 $thickness=5.6e-08 $X=0.297
+ $Y=0.1105 $X2=0.297 $Y2=0.1185
r13 6 7 14.6259 $w=2.1e-08 $l=4.3e-08 $layer=Gate_1 $thickness=5.6e-08 $X=0.297
+ $Y=0.0675 $X2=0.297 $Y2=0.1105
r14 6 3 14.6259 $w=2.1e-08 $l=4.3e-08 $layer=Gate_1 $thickness=5.6e-08 $X=0.297
+ $Y=0.0675 $X2=0.297 $Y2=0.0245
.ends

.subckt PM_DHLx1_ASAP7_75t_R%13 vss 2 3 1
c1 1 vss 0.000770653f $X=0.324 $Y=0.2025
r1 2 1 0.209877 $w=8.1e-08 $l=1.7e-08 $layer=P_src_drn $thickness=1e-09
+ $X=0.3066 $Y=0.2025 $X2=0.324 $Y2=0.2025
r2 3 1 0.209877 $w=8.1e-08 $l=1.7e-08 $layer=P_src_drn $thickness=1e-09
+ $X=0.3413 $Y=0.2025 $X2=0.324 $Y2=0.2025
.ends

.subckt PM_DHLx1_ASAP7_75t_R%4 vss 40 92 101 103 106 110 20 22 7 6 23 18 17 30
+ 1 28 25 29 33 27 14 24 2 15 31 3 16 8 32
c1 1 vss 0.00344003f $X=0.153 $Y=0.135
c2 2 vss 0.000358707f $X=0.351 $Y=0.1235
c3 3 vss 0.000122586f $X=0.459 $Y=0.179
c4 6 vss 0.00796922f $X=0.054 $Y=0.054
c5 7 vss 0.00787897f $X=0.054 $Y=0.216
c6 8 vss 0.0093527f $X=0.501 $Y=0.179
c7 14 vss 0.0686462f $X=0.135 $Y=0.135
c8 15 vss 0.0078153f $X=0.351 $Y=0.0725
c9 16 vss 0.00637161f $X=0.459 $Y=0.179
c10 17 vss 0.0311206f $X=0.056 $Y=0.054
c11 18 vss 0.0311778f $X=0.056 $Y=0.216
c12 19 vss 0.0036501f $X=0.018 $Y=0.036
c13 20 vss 0.00258358f $X=0.0165 $Y=0.189
c14 21 vss 0.00351663f $X=0.018 $Y=0.234
c15 22 vss 0.00123865f $X=0.1505 $Y=0.189
c16 23 vss 0.000601358f $X=0.189 $Y=0.135
c17 24 vss 0.00126229f $X=0.351 $Y=0.198
c18 25 vss 0.00894117f $X=0.018 $Y=0.1665
c19 26 vss 0.00200166f $X=0.018 $Y=0.2115
c20 27 vss 0.00468359f $X=0.036 $Y=0.036
c21 28 vss 0.00383138f $X=0.036 $Y=0.234
c22 29 vss 0.000784726f $X=0.1545 $Y=0.135
c23 30 vss 0.000499913f $X=0.189 $Y=0.1665
c24 31 vss 0.00113346f $X=0.351 $Y=0.1155
c25 32 vss 0.00178846f $X=0.513 $Y=0.1675
c26 33 vss 0.0234114f $X=0.2855 $Y=0.189
r1 110 109 14.6259 $w=2.1e-08 $l=4.3e-08 $layer=Gate_1 $thickness=5.6e-08
+ $X=0.135 $Y=0.216 $X2=0.135 $Y2=0.173
r2 108 109 7.31297 $w=2.1e-08 $l=2.15e-08 $layer=Gate_1 $thickness=5.6e-08
+ $X=0.135 $Y=0.1515 $X2=0.135 $Y2=0.173
r3 106 107 14.6259 $w=2.1e-08 $l=4.3e-08 $layer=Gate_1 $thickness=5.6e-08
+ $X=0.135 $Y=0.054 $X2=0.135 $Y2=0.097
r4 104 107 7.31297 $w=2.1e-08 $l=2.15e-08 $layer=Gate_1 $thickness=5.6e-08
+ $X=0.135 $Y=0.1185 $X2=0.135 $Y2=0.097
r5 14 98 3.9286 $w=2e-08 $layer=Gate_1 $thickness=5.6e-08 $X=0.135 $Y=0.135
+ $X2=0.135 $Y2=0.135
r6 14 104 5.79936 $w=2.03333e-08 $l=1.65e-08 $layer=Gate_1 $thickness=5.6e-08
+ $X=0.135 $Y=0.135 $X2=0.135 $Y2=0.1185
r7 14 108 5.79936 $w=2.03333e-08 $l=1.65e-08 $layer=Gate_1 $thickness=5.6e-08
+ $X=0.135 $Y=0.135 $X2=0.135 $Y2=0.1515
r8 103 102 0.0462963 $w=5.4e-08 $l=2.5e-09 $layer=P_src_drn $thickness=1e-09
+ $X=0.0713 $Y=0.216 $X2=0.0685 $Y2=0.216
r9 18 102 0.231482 $w=5.4e-08 $l=1.25e-08 $layer=P_src_drn $thickness=1e-09
+ $X=0.056 $Y=0.216 $X2=0.0685 $Y2=0.216
r10 101 100 0.0462963 $w=5.4e-08 $l=2.5e-09 $layer=N_src_drn $thickness=1e-09
+ $X=0.0713 $Y=0.054 $X2=0.0685 $Y2=0.054
r11 17 100 0.231482 $w=5.4e-08 $l=1.25e-08 $layer=N_src_drn $thickness=1e-09
+ $X=0.056 $Y=0.054 $X2=0.0685 $Y2=0.054
r12 96 97 2.6116 $w=2.2e-08 $l=1e-08 $layer=LIG $thickness=4.8e-08 $X=0.134
+ $Y=0.135 $X2=0.144 $Y2=0.135
r13 96 98 2.35044 $w=2.2e-08 $l=1e-09 $layer=LIG $thickness=4.8e-08 $X=0.134
+ $Y=0.135 $X2=0.135 $Y2=0.135
r14 1 29 19.3796 $a=3.24e-16 $layer=V0LIG $X=0.153 $Y=0.135 $X2=0.1545 $Y2=0.135
r15 1 97 4.98695 $w=1.60444e-08 $l=9e-09 $layer=LIG $thickness=4.8e-08 $X=0.153
+ $Y=0.135 $X2=0.144 $Y2=0.135
r16 7 86 19.3796 $a=3.24e-16 $layer=V0LISD $X=0.054 $Y=0.216 $X2=0.055 $Y2=0.234
r17 6 83 19.3796 $a=3.24e-16 $layer=V0LISD $X=0.054 $Y=0.054 $X2=0.055 $Y2=0.036
r18 92 93 23.4695 $w=2.1e-08 $l=6.9e-08 $layer=Gate_1 $thickness=5.6e-08
+ $X=0.459 $Y=0.0405 $X2=0.459 $Y2=0.1095
r19 16 93 23.8777 $w=2.07986e-08 $l=6.95e-08 $layer=Gate_1 $thickness=5.6e-08
+ $X=0.459 $Y=0.179 $X2=0.459 $Y2=0.1095
r20 29 88 3.73104 $w=1.3e-08 $l=1.6e-08 $layer=M1 $thickness=3.6e-08 $X=0.1545
+ $Y=0.135 $X2=0.1705 $Y2=0.135
r21 85 86 2.09871 $w=1.3e-08 $l=9e-09 $layer=M1 $thickness=3.6e-08 $X=0.046
+ $Y=0.234 $X2=0.055 $Y2=0.234
r22 28 85 2.3319 $w=1.3e-08 $l=1e-08 $layer=M1 $thickness=3.6e-08 $X=0.036
+ $Y=0.234 $X2=0.046 $Y2=0.234
r23 82 83 2.09871 $w=1.3e-08 $l=9e-09 $layer=M1 $thickness=3.6e-08 $X=0.046
+ $Y=0.036 $X2=0.055 $Y2=0.036
r24 27 82 2.3319 $w=1.3e-08 $l=1e-08 $layer=M1 $thickness=3.6e-08 $X=0.036
+ $Y=0.036 $X2=0.046 $Y2=0.036
r25 3 75 5.67512 $w=2.4e-08 $l=5e-09 $layer=LISD $thickness=4.02632e-08
+ $X=0.459 $Y=0.179 $X2=0.464 $Y2=0.179
r26 3 16 7.56983 $w=2.18462e-08 $layer=Gate_1 $thickness=5.23077e-08 $X=0.459
+ $Y=0.179 $X2=0.459 $Y2=0.179
r27 23 71 1.49895 $w=1.95333e-08 $l=1.35e-08 $layer=M1 $thickness=3.6e-08
+ $X=0.189 $Y=0.135 $X2=0.189 $Y2=0.1485
r28 23 88 2.6649 $w=1.54324e-08 $l=1.85e-08 $layer=M1 $thickness=3.6e-08
+ $X=0.189 $Y=0.135 $X2=0.1705 $Y2=0.135
r29 21 26 3.59766 $w=1.692e-08 $l=2.25e-08 $layer=M1 $thickness=3.6e-08
+ $X=0.018 $Y=0.234 $X2=0.018 $Y2=0.2115
r30 21 28 2.5483 $w=1.55e-08 $l=1.8e-08 $layer=M1 $thickness=3.6e-08 $X=0.018
+ $Y=0.234 $X2=0.036 $Y2=0.234
r31 19 70 4.64701 $w=1.62667e-08 $l=2.7e-08 $layer=M1 $thickness=3.6e-08
+ $X=0.018 $Y=0.036 $X2=0.018 $Y2=0.063
r32 19 27 2.5483 $w=1.55e-08 $l=1.8e-08 $layer=M1 $thickness=3.6e-08 $X=0.018
+ $Y=0.036 $X2=0.036 $Y2=0.036
r33 74 75 11.0623 $w=2.14976e-08 $l=2.05e-08 $layer=LISD $thickness=2.7e-08
+ $X=0.4845 $Y=0.179 $X2=0.464 $Y2=0.179
r34 8 72 7.07284 $w=2.02e-08 $l=1.2e-08 $layer=LISD $thickness=2.7e-08 $X=0.501
+ $Y=0.179 $X2=0.513 $Y2=0.179
r35 8 74 9.72516 $w=2.02e-08 $l=1.65e-08 $layer=LISD $thickness=2.7e-08
+ $X=0.501 $Y=0.179 $X2=0.4845 $Y2=0.179
r36 30 65 4.06646 $w=1.5e-08 $l=2.25e-08 $layer=M1 $thickness=3.6e-08 $X=0.189
+ $Y=0.1665 $X2=0.189 $Y2=0.189
r37 30 71 4.19742 $w=1.3e-08 $l=1.8e-08 $layer=M1 $thickness=3.6e-08 $X=0.189
+ $Y=0.1665 $X2=0.189 $Y2=0.1485
r38 69 70 8.39483 $w=1.3e-08 $l=3.6e-08 $layer=M1 $thickness=3.6e-08 $X=0.018
+ $Y=0.099 $X2=0.018 $Y2=0.063
r39 68 69 8.39483 $w=1.3e-08 $l=3.6e-08 $layer=M1 $thickness=3.6e-08 $X=0.018
+ $Y=0.135 $X2=0.018 $Y2=0.099
r40 25 68 7.34548 $w=1.3e-08 $l=3.15e-08 $layer=M1 $thickness=3.6e-08 $X=0.018
+ $Y=0.1665 $X2=0.018 $Y2=0.135
r41 66 72 19.3796 $a=3.24e-16 $layer=V0LISD $X=0.513 $Y=0.1845 $X2=0.513
+ $Y2=0.179
r42 32 66 3.96423 $w=1.3e-08 $l=1.7e-08 $layer=M1 $thickness=3.6e-08 $X=0.513
+ $Y=0.1675 $X2=0.513 $Y2=0.1845
r43 64 65 1.96775 $w=1.63333e-08 $l=1.35e-08 $layer=M1 $thickness=3.6e-08
+ $X=0.1755 $Y=0.189 $X2=0.189 $Y2=0.189
r44 63 64 3.14806 $w=1.3e-08 $l=1.35e-08 $layer=M1 $thickness=3.6e-08 $X=0.162
+ $Y=0.189 $X2=0.1755 $Y2=0.189
r45 22 63 2.68168 $w=1.3e-08 $l=1.15e-08 $layer=M1 $thickness=3.6e-08 $X=0.1505
+ $Y=0.189 $X2=0.162 $Y2=0.189
r46 60 61 1.90199 $w=1.38333e-08 $l=9e-09 $layer=M1 $thickness=3.6e-08
+ $X=0.0255 $Y=0.189 $X2=0.0345 $Y2=0.189
r47 20 60 0.9184 $w=1.8e-08 $l=9e-09 $layer=M1 $thickness=3.6e-08 $X=0.0165
+ $Y=0.189 $X2=0.0255 $Y2=0.189
r48 20 25 3.9134 $w=1.47857e-08 $l=2.25499e-08 $layer=M1 $thickness=3.6e-08
+ $X=0.0165 $Y=0.189 $X2=0.018 $Y2=0.1665
r49 20 26 3.9134 $w=1.47857e-08 $l=2.25499e-08 $layer=M1 $thickness=3.6e-08
+ $X=0.0165 $Y=0.189 $X2=0.018 $Y2=0.2115
r50 58 66 19.5347 $a=3.24e-16 $layer=V1 $X=0.513 $Y=0.189 $X2=0.513 $Y2=0.1845
r51 57 58 8.39483 $w=1.3e-08 $l=3.6e-08 $layer=M2 $thickness=3.6e-08 $X=0.477
+ $Y=0.189 $X2=0.513 $Y2=0.189
r52 56 57 10.4935 $w=1.3e-08 $l=4.5e-08 $layer=M2 $thickness=3.6e-08 $X=0.432
+ $Y=0.189 $X2=0.477 $Y2=0.189
r53 54 55 8.86121 $w=1.3e-08 $l=3.8e-08 $layer=M2 $thickness=3.6e-08 $X=0.162
+ $Y=0.189 $X2=0.2 $Y2=0.189
r54 54 63 19.5347 $a=3.24e-16 $layer=V1 $X=0.162 $Y=0.189 $X2=0.162 $Y2=0.189
r55 53 54 15.0407 $w=1.3e-08 $l=6.45e-08 $layer=M2 $thickness=3.6e-08 $X=0.0975
+ $Y=0.189 $X2=0.162 $Y2=0.189
r56 52 53 15.0407 $w=1.3e-08 $l=6.45e-08 $layer=M2 $thickness=3.6e-08 $X=0.033
+ $Y=0.189 $X2=0.0975 $Y2=0.189
r57 52 61 19.5347 $a=3.24e-16 $layer=V1 $X=0.033 $Y=0.189 $X2=0.0345 $Y2=0.189
r58 50 56 10.4935 $w=1.3e-08 $l=4.5e-08 $layer=M2 $thickness=3.6e-08 $X=0.387
+ $Y=0.189 $X2=0.432 $Y2=0.189
r59 49 50 8.39483 $w=1.3e-08 $l=3.6e-08 $layer=M2 $thickness=3.6e-08 $X=0.351
+ $Y=0.189 $X2=0.387 $Y2=0.189
r60 33 49 15.2739 $w=1.3e-08 $l=6.55e-08 $layer=M2 $thickness=3.6e-08 $X=0.2855
+ $Y=0.189 $X2=0.351 $Y2=0.189
r61 33 55 19.9377 $w=1.3e-08 $l=8.55e-08 $layer=M2 $thickness=3.6e-08 $X=0.2855
+ $Y=0.189 $X2=0.2 $Y2=0.189
r62 24 46 1.96775 $w=1.63333e-08 $l=1.35e-08 $layer=M1 $thickness=3.6e-08
+ $X=0.351 $Y=0.198 $X2=0.351 $Y2=0.1845
r63 24 49 39.0693 $a=1.62e-16 $layer=V1 $X=0.351 $Y=0.198 $X2=0.351 $Y2=0.189
r64 46 49 39.0693 $a=1.62e-16 $layer=V1 $X=0.351 $Y=0.1845 $X2=0.351 $Y2=0.189
r65 45 46 2.09871 $w=1.3e-08 $l=9e-09 $layer=M1 $thickness=3.6e-08 $X=0.351
+ $Y=0.1755 $X2=0.351 $Y2=0.1845
r66 44 45 4.31401 $w=1.3e-08 $l=1.85e-08 $layer=M1 $thickness=3.6e-08 $X=0.351
+ $Y=0.157 $X2=0.351 $Y2=0.1755
r67 43 44 5.36336 $w=1.3e-08 $l=2.3e-08 $layer=M1 $thickness=3.6e-08 $X=0.351
+ $Y=0.134 $X2=0.351 $Y2=0.157
r68 31 43 4.31401 $w=1.3e-08 $l=1.85e-08 $layer=M1 $thickness=3.6e-08 $X=0.351
+ $Y=0.1155 $X2=0.351 $Y2=0.134
r69 42 43 19.3796 $a=3.24e-16 $layer=V0LIG $X=0.351 $Y=0.1345 $X2=0.351
+ $Y2=0.134
r70 2 38 4.22396 $w=1.97957e-08 $l=1.05e-08 $layer=Gate_1
+ $thickness=5.56522e-08 $X=0.351 $Y=0.1235 $X2=0.351 $Y2=0.134
r71 2 42 6.49795 $w=1.53e-08 $l=1.1e-08 $layer=LIG $thickness=4.8e-08 $X=0.351
+ $Y=0.1235 $X2=0.351 $Y2=0.1345
r72 40 39 16.6668 $w=2.1e-08 $l=4.9e-08 $layer=Gate_1 $thickness=5.6e-08
+ $X=0.351 $Y=0.2025 $X2=0.351 $Y2=0.1535
r73 38 39 6.81977 $w=2.04359e-08 $l=1.95e-08 $layer=Gate_1 $thickness=5.6e-08
+ $X=0.351 $Y=0.134 $X2=0.351 $Y2=0.1535
r74 15 38 21.1056 $w=2.08211e-08 $l=6.15e-08 $layer=Gate_1 $thickness=5.6e-08
+ $X=0.351 $Y=0.0725 $X2=0.351 $Y2=0.134
r75 7 18 1e-05 $l=2e-09 $X=0.054 $Y=0.216 $X2=0.056 $Y2=0.216
r76 6 17 1e-05 $l=2e-09 $X=0.054 $Y=0.054 $X2=0.056 $Y2=0.054
.ends

.subckt PM_DHLx1_ASAP7_75t_R%Q vss 17 13 25 7 11 8
c1 1 vss 0.00935834f $X=0.756 $Y=0.0675
c2 2 vss 0.00891885f $X=0.756 $Y=0.2025
c3 7 vss 0.0385043f $X=0.7415 $Y=0.0675
c4 8 vss 0.0384501f $X=0.7415 $Y=0.2025
c5 9 vss 0.00639042f $X=0.7445 $Y=0.036
c6 10 vss 0.00637967f $X=0.783 $Y=0.234
c7 11 vss 0.00579655f $X=0.783 $Y=0.0627
r1 8 2 0.154321 $w=8.1e-08 $l=1.25e-08 $layer=P_src_drn $thickness=1e-09
+ $X=0.7415 $Y=0.2025 $X2=0.756 $Y2=0.2025
r2 25 8 0.0308642 $w=8.1e-08 $l=2.5e-09 $layer=P_src_drn $thickness=1e-09
+ $X=0.7386 $Y=0.2025 $X2=0.7415 $Y2=0.2025
r3 2 22 19.3796 $a=3.24e-16 $layer=V0LISD $X=0.756 $Y=0.2025 $X2=0.756 $Y2=0.234
r4 22 23 3.14806 $w=1.3e-08 $l=1.35e-08 $layer=M1 $thickness=3.6e-08 $X=0.756
+ $Y=0.234 $X2=0.7695 $Y2=0.234
r5 10 20 7.6809 $w=1.41842e-08 $l=3.8e-08 $layer=M1 $thickness=3.6e-08 $X=0.783
+ $Y=0.234 $X2=0.783 $Y2=0.196
r6 10 23 1.96775 $w=1.63333e-08 $l=1.35e-08 $layer=M1 $thickness=3.6e-08
+ $X=0.783 $Y=0.234 $X2=0.7695 $Y2=0.234
r7 19 20 12.0093 $w=1.3e-08 $l=5.15e-08 $layer=M1 $thickness=3.6e-08 $X=0.783
+ $Y=0.1445 $X2=0.783 $Y2=0.196
r8 18 19 9.96886 $w=1.3e-08 $l=4.28e-08 $layer=M1 $thickness=3.6e-08 $X=0.783
+ $Y=0.1017 $X2=0.783 $Y2=0.1445
r9 17 18 4.83869 $w=1.3e-08 $l=2.07e-08 $layer=M1 $thickness=3.6e-08 $X=0.783
+ $Y=0.081 $X2=0.783 $Y2=0.1017
r10 17 11 4.25571 $w=1.3e-08 $l=1.83e-08 $layer=M1 $thickness=3.6e-08 $X=0.783
+ $Y=0.081 $X2=0.783 $Y2=0.0627
r11 11 16 5.05752 $w=1.46822e-08 $l=2.67e-08 $layer=M1 $thickness=3.6e-08
+ $X=0.783 $Y=0.0627 $X2=0.783 $Y2=0.036
r12 15 16 1.96775 $w=1.63333e-08 $l=1.35e-08 $layer=M1 $thickness=3.6e-08
+ $X=0.7695 $Y=0.036 $X2=0.783 $Y2=0.036
r13 14 15 3.14806 $w=1.3e-08 $l=1.35e-08 $layer=M1 $thickness=3.6e-08 $X=0.756
+ $Y=0.036 $X2=0.7695 $Y2=0.036
r14 9 14 2.68168 $w=1.3e-08 $l=1.15e-08 $layer=M1 $thickness=3.6e-08 $X=0.7445
+ $Y=0.036 $X2=0.756 $Y2=0.036
r15 1 14 19.3796 $a=3.24e-16 $layer=V0LISD $X=0.756 $Y=0.0675 $X2=0.756
+ $Y2=0.036
r16 7 1 0.154321 $w=8.1e-08 $l=1.25e-08 $layer=N_src_drn $thickness=1e-09
+ $X=0.7415 $Y=0.0675 $X2=0.756 $Y2=0.0675
r17 13 7 0.0308642 $w=8.1e-08 $l=2.5e-09 $layer=N_src_drn $thickness=1e-09
+ $X=0.7386 $Y=0.0675 $X2=0.7415 $Y2=0.0675
.ends

.subckt PM_DHLx1_ASAP7_75t_R%10 vss 7 9 4 5 1
c1 1 vss 0.0082106f $X=0.351 $Y=0.0675
c2 4 vss 0.00285961f $X=0.3095 $Y=0.0675
c3 5 vss 0.00175907f $X=0.38 $Y=0.0675
r1 9 8 0.0308642 $w=8.1e-08 $l=2.5e-09 $layer=N_src_drn $thickness=1e-09
+ $X=0.3953 $Y=0.0675 $X2=0.3925 $Y2=0.0675
r2 5 8 0.154321 $w=8.1e-08 $l=1.25e-08 $layer=N_src_drn $thickness=1e-09
+ $X=0.38 $Y=0.0675 $X2=0.3925 $Y2=0.0675
r3 4 1 0.154321 $w=8.1e-08 $l=1.25e-08 $layer=N_src_drn $thickness=1e-09
+ $X=0.3095 $Y=0.0675 $X2=0.351 $Y2=0.0675
r4 7 4 0.0308642 $w=8.1e-08 $l=2.5e-09 $layer=N_src_drn $thickness=1e-09
+ $X=0.3066 $Y=0.0675 $X2=0.3095 $Y2=0.0675
r5 1 5 1e-05 $l=2.9e-08 $X=0.351 $Y=0.0675 $X2=0.38 $Y2=0.0675
.ends

.subckt PM_DHLx1_ASAP7_75t_R%11 vss 7 12 4 1 5
c1 1 vss 0.00626136f $X=0.432 $Y=0.2295
c2 4 vss 0.00175079f $X=0.4175 $Y=0.2295
c3 5 vss 0.00215259f $X=0.488 $Y=0.2295
r1 12 11 0.0925926 $w=2.7e-08 $l=2.5e-09 $layer=P_src_drn $thickness=1e-09
+ $X=0.5033 $Y=0.2295 $X2=0.5005 $Y2=0.2295
r2 5 11 0.462963 $w=2.7e-08 $l=1.25e-08 $layer=P_src_drn $thickness=1e-09
+ $X=0.488 $Y=0.2295 $X2=0.5005 $Y2=0.2295
r3 9 5 9.64198 $w=2.32e-08 $l=2.05e-08 $layer=LISD $thickness=2.7e-08 $X=0.4655
+ $Y=0.2295 $X2=0.488 $Y2=0.2295
r4 8 9 7.05511 $w=2.32e-08 $l=1.5e-08 $layer=LISD $thickness=2.7e-08 $X=0.4505
+ $Y=0.2295 $X2=0.4655 $Y2=0.2295
r5 1 8 8.7013 $w=2.32e-08 $l=1.85e-08 $layer=LISD $thickness=2.7e-08 $X=0.432
+ $Y=0.2295 $X2=0.4505 $Y2=0.2295
r6 4 1 0.462963 $w=2.7e-08 $l=1.25e-08 $layer=P_src_drn $thickness=1e-09
+ $X=0.4175 $Y=0.2295 $X2=0.432 $Y2=0.2295
r7 7 4 0.0925926 $w=2.7e-08 $l=2.5e-09 $layer=P_src_drn $thickness=1e-09
+ $X=0.4146 $Y=0.2295 $X2=0.4175 $Y2=0.2295
.ends

.subckt PM_DHLx1_ASAP7_75t_R%6 vss 21 25 50 52 3 15 14 11 10 4 9 18 17 16 1 12
c1 1 vss 0.000384201f $X=0.405 $Y=0.132
c2 3 vss 0.00758985f $X=0.162 $Y=0.054
c3 4 vss 0.00740952f $X=0.162 $Y=0.216
c4 9 vss 0.00737208f $X=0.405 $Y=0.0245
c5 10 vss 0.0319354f $X=0.1475 $Y=0.054
c6 11 vss 0.0321166f $X=0.1475 $Y=0.216
c7 12 vss 0.00307375f $X=0.243 $Y=0.036
c8 13 vss 0.00302099f $X=0.243 $Y=0.2305
c9 14 vss 0.00935839f $X=0.216 $Y=0.036
c10 15 vss 0.00842131f $X=0.216 $Y=0.234
c11 16 vss 0.00720246f $X=0.243 $Y=0.135
c12 17 vss 0.00112768f $X=0.405 $Y=0.1155
c13 18 vss 0.00652692f $X=0.2315 $Y=0.153
r1 11 4 0.231482 $w=5.4e-08 $l=1.25e-08 $layer=P_src_drn $thickness=1e-09
+ $X=0.1475 $Y=0.216 $X2=0.162 $Y2=0.216
r2 52 11 0.0462963 $w=5.4e-08 $l=2.5e-09 $layer=P_src_drn $thickness=1e-09
+ $X=0.1446 $Y=0.216 $X2=0.1475 $Y2=0.216
r3 10 3 0.231482 $w=5.4e-08 $l=1.25e-08 $layer=N_src_drn $thickness=1e-09
+ $X=0.1475 $Y=0.054 $X2=0.162 $Y2=0.054
r4 50 10 0.0462963 $w=5.4e-08 $l=2.5e-09 $layer=N_src_drn $thickness=1e-09
+ $X=0.1446 $Y=0.054 $X2=0.1475 $Y2=0.054
r5 4 47 19.3796 $a=3.24e-16 $layer=V0LISD $X=0.162 $Y=0.216 $X2=0.162 $Y2=0.234
r6 3 44 19.3796 $a=3.24e-16 $layer=V0LISD $X=0.162 $Y=0.054 $X2=0.162 $Y2=0.036
r7 47 48 5.24677 $w=1.3e-08 $l=2.25e-08 $layer=M1 $thickness=3.6e-08 $X=0.162
+ $Y=0.234 $X2=0.1845 $Y2=0.234
r8 15 48 7.34548 $w=1.3e-08 $l=3.15e-08 $layer=M1 $thickness=3.6e-08 $X=0.216
+ $Y=0.234 $X2=0.1845 $Y2=0.234
r9 44 45 5.24677 $w=1.3e-08 $l=2.25e-08 $layer=M1 $thickness=3.6e-08 $X=0.162
+ $Y=0.036 $X2=0.1845 $Y2=0.036
r10 14 45 7.34548 $w=1.3e-08 $l=3.15e-08 $layer=M1 $thickness=3.6e-08 $X=0.216
+ $Y=0.036 $X2=0.1845 $Y2=0.036
r11 13 41 3.70931 $w=1.44474e-08 $l=1.9e-08 $layer=M1 $thickness=3.6e-08
+ $X=0.243 $Y=0.2305 $X2=0.243 $Y2=0.2115
r12 13 15 4.75866 $w=1.41702e-08 $l=2.72259e-08 $layer=M1 $thickness=3.6e-08
+ $X=0.243 $Y=0.2305 $X2=0.216 $Y2=0.234
r13 12 39 4.64701 $w=1.62667e-08 $l=2.7e-08 $layer=M1 $thickness=3.6e-08
+ $X=0.243 $Y=0.036 $X2=0.243 $Y2=0.063
r14 12 14 4.64701 $w=1.46667e-08 $l=2.7e-08 $layer=M1 $thickness=3.6e-08
+ $X=0.243 $Y=0.036 $X2=0.216 $Y2=0.036
r15 40 41 5.24677 $w=1.3e-08 $l=2.25e-08 $layer=M1 $thickness=3.6e-08 $X=0.243
+ $Y=0.189 $X2=0.243 $Y2=0.2115
r16 38 39 8.39483 $w=1.3e-08 $l=3.6e-08 $layer=M1 $thickness=3.6e-08 $X=0.243
+ $Y=0.099 $X2=0.243 $Y2=0.063
r17 37 38 5.24677 $w=1.3e-08 $l=2.25e-08 $layer=M1 $thickness=3.6e-08 $X=0.243
+ $Y=0.1215 $X2=0.243 $Y2=0.099
r18 36 40 4.19742 $w=1.3e-08 $l=1.8e-08 $layer=M1 $thickness=3.6e-08 $X=0.243
+ $Y=0.171 $X2=0.243 $Y2=0.189
r19 35 36 4.19742 $w=1.3e-08 $l=1.8e-08 $layer=M1 $thickness=3.6e-08 $X=0.243
+ $Y=0.153 $X2=0.243 $Y2=0.171
r20 16 35 4.19742 $w=1.3e-08 $l=1.8e-08 $layer=M1 $thickness=3.6e-08 $X=0.243
+ $Y=0.135 $X2=0.243 $Y2=0.153
r21 16 37 3.14806 $w=1.3e-08 $l=1.35e-08 $layer=M1 $thickness=3.6e-08 $X=0.243
+ $Y=0.135 $X2=0.243 $Y2=0.1215
r22 33 34 18.8884 $w=1.3e-08 $l=8.1e-08 $layer=M2 $thickness=3.6e-08 $X=0.324
+ $Y=0.153 $X2=0.405 $Y2=0.153
r23 32 33 18.8884 $w=1.3e-08 $l=8.1e-08 $layer=M2 $thickness=3.6e-08 $X=0.243
+ $Y=0.153 $X2=0.324 $Y2=0.153
r24 32 35 19.5347 $a=3.24e-16 $layer=V1 $X=0.243 $Y=0.153 $X2=0.243 $Y2=0.153
r25 18 32 2.68168 $w=1.3e-08 $l=1.15e-08 $layer=M2 $thickness=3.6e-08 $X=0.2315
+ $Y=0.153 $X2=0.243 $Y2=0.153
r26 30 34 19.5347 $a=3.24e-16 $layer=V1 $X=0.405 $Y=0.153 $X2=0.405 $Y2=0.153
r27 29 30 2.2153 $w=1.3e-08 $l=9.5e-09 $layer=M1 $thickness=3.6e-08 $X=0.405
+ $Y=0.1435 $X2=0.405 $Y2=0.153
r28 28 29 2.2153 $w=1.3e-08 $l=9.5e-09 $layer=M1 $thickness=3.6e-08 $X=0.405
+ $Y=0.134 $X2=0.405 $Y2=0.1435
r29 17 28 4.31401 $w=1.3e-08 $l=1.85e-08 $layer=M1 $thickness=3.6e-08 $X=0.405
+ $Y=0.1155 $X2=0.405 $Y2=0.134
r30 1 23 9.2451 $w=1.7885e-08 $l=2e-09 $layer=LIG $thickness=5.24e-08 $X=0.405
+ $Y=0.132 $X2=0.405 $Y2=0.134
r31 1 28 19.3796 $a=3.24e-16 $layer=V0LIG $X=0.405 $Y=0.132 $X2=0.405 $Y2=0.134
r32 25 24 16.6668 $w=2.1e-08 $l=4.9e-08 $layer=Gate_1 $thickness=5.6e-08
+ $X=0.405 $Y=0.2295 $X2=0.405 $Y2=0.1805
r33 23 24 16.0035 $w=2.07634e-08 $l=4.65e-08 $layer=Gate_1 $thickness=5.6e-08
+ $X=0.405 $Y=0.134 $X2=0.405 $Y2=0.1805
r34 22 23 6.47963 $w=2.04054e-08 $l=1.85e-08 $layer=Gate_1 $thickness=5.6e-08
+ $X=0.405 $Y=0.1155 $X2=0.405 $Y2=0.134
r35 21 22 16.3266 $w=2.1e-08 $l=4.8e-08 $layer=Gate_1 $thickness=5.6e-08
+ $X=0.405 $Y=0.0675 $X2=0.405 $Y2=0.1155
r36 21 9 14.6259 $w=2.1e-08 $l=4.3e-08 $layer=Gate_1 $thickness=5.6e-08
+ $X=0.405 $Y=0.0675 $X2=0.405 $Y2=0.0245
.ends

.subckt PM_DHLx1_ASAP7_75t_R%8 vss 29 35 70 73 77 81 84 87 13 5 16 22 19 14 1
+ 23 24 6 15 26 20 11 21 18 2 25 17 12
c1 1 vss 0.0011047f $X=0.567 $Y=0.124
c2 2 vss 0.00486578f $X=0.729 $Y=0.136
c3 5 vss 0.00578471f $X=0.378 $Y=0.2295
c4 6 vss 0.00473416f $X=0.432 $Y=0.0405
c5 11 vss 0.0504316f $X=0.567 $Y=0.0245
c6 12 vss 0.0838892f $X=0.729 $Y=0.136
c7 13 vss 0.00248735f $X=0.4175 $Y=0.0405
c8 14 vss 0.000959209f $X=0.4175 $Y=0.081
c9 15 vss 0.00273637f $X=0.3635 $Y=0.2295
c10 16 vss 0.00101902f $X=0.3635 $Y=0.189
c11 17 vss 0.00265995f $X=0.459 $Y=0.036
c12 18 vss 2.2797e-20 $X=0.459 $Y=0.13
c13 19 vss 0.00271542f $X=0.459 $Y=0.234
c14 20 vss 0.00728764f $X=0.432 $Y=0.234
c15 21 vss 0.00391451f $X=0.432 $Y=0.036
c16 22 vss 0.00111145f $X=0.459 $Y=0.1135
c17 23 vss 0.000661551f $X=0.459 $Y=0.1415
c18 24 vss 0.000949589f $X=0.54 $Y=0.13
c19 25 vss 0.00246083f $X=0.729 $Y=0.1245
c20 26 vss 0.00731833f $X=0.459 $Y=0.153
r1 16 5 0.231482 $w=5.4e-08 $l=1.25e-08 $layer=P_src_drn $thickness=1e-09
+ $X=0.3635 $Y=0.189 $X2=0.378 $Y2=0.2295
r2 87 86 0.0925926 $w=2.7e-08 $l=2.5e-09 $layer=P_src_drn $thickness=1e-09
+ $X=0.3953 $Y=0.2295 $X2=0.3925 $Y2=0.2295
r3 85 86 0.166667 $w=2.7e-08 $l=4.5e-09 $layer=P_src_drn $thickness=1e-09
+ $X=0.388 $Y=0.2295 $X2=0.3925 $Y2=0.2295
r4 5 85 0.444445 $w=2.7e-08 $l=1.2e-08 $layer=P_src_drn $thickness=1e-09
+ $X=0.378 $Y=0.2295 $X2=0.388 $Y2=0.2295
r5 15 5 0.462963 $w=2.7e-08 $l=1.25e-08 $layer=P_src_drn $thickness=1e-09
+ $X=0.3635 $Y=0.2295 $X2=0.378 $Y2=0.2295
r6 84 15 0.0925926 $w=2.7e-08 $l=2.5e-09 $layer=P_src_drn $thickness=1e-09
+ $X=0.3606 $Y=0.2025 $X2=0.3635 $Y2=0.2295
r7 81 80 14.6259 $w=2.1e-08 $l=4.3e-08 $layer=Gate_1 $thickness=5.6e-08
+ $X=0.729 $Y=0.2025 $X2=0.729 $Y2=0.1595
r8 79 80 2.55104 $w=2.1e-08 $l=7.5e-09 $layer=Gate_1 $thickness=5.6e-08
+ $X=0.729 $Y=0.152 $X2=0.729 $Y2=0.1595
r9 77 78 14.6259 $w=2.1e-08 $l=4.3e-08 $layer=Gate_1 $thickness=5.6e-08
+ $X=0.729 $Y=0.0675 $X2=0.729 $Y2=0.1105
r10 75 78 2.89117 $w=2.1e-08 $l=8.5e-09 $layer=Gate_1 $thickness=5.6e-08
+ $X=0.729 $Y=0.119 $X2=0.729 $Y2=0.1105
r11 12 75 5.96942 $w=2.03529e-08 $l=1.7e-08 $layer=Gate_1 $thickness=5.6e-08
+ $X=0.729 $Y=0.136 $X2=0.729 $Y2=0.119
r12 12 79 5.62929 $w=2.03125e-08 $l=1.6e-08 $layer=Gate_1 $thickness=5.6e-08
+ $X=0.729 $Y=0.136 $X2=0.729 $Y2=0.152
r13 14 63 0.231482 $w=5.4e-08 $l=1.25e-08 $layer=N_src_drn $thickness=1e-09
+ $X=0.4175 $Y=0.081 $X2=0.432 $Y2=0.081
r14 73 72 0.0925926 $w=2.7e-08 $l=2.5e-09 $layer=N_src_drn $thickness=1e-09
+ $X=0.4493 $Y=0.0405 $X2=0.4465 $Y2=0.0405
r15 71 72 0.166667 $w=2.7e-08 $l=4.5e-09 $layer=N_src_drn $thickness=1e-09
+ $X=0.442 $Y=0.0405 $X2=0.4465 $Y2=0.0405
r16 63 71 0.444445 $w=2.7e-08 $l=1.2e-08 $layer=N_src_drn $thickness=1e-09
+ $X=0.432 $Y=0.081 $X2=0.442 $Y2=0.0405
r17 13 63 0.462963 $w=2.7e-08 $l=1.25e-08 $layer=N_src_drn $thickness=1e-09
+ $X=0.4175 $Y=0.0405 $X2=0.432 $Y2=0.081
r18 70 13 0.0925926 $w=2.7e-08 $l=2.5e-09 $layer=N_src_drn $thickness=1e-09
+ $X=0.4146 $Y=0.0675 $X2=0.4175 $Y2=0.0405
r19 5 62 19.3796 $a=3.24e-16 $layer=V0LISD $X=0.378 $Y=0.2295 $X2=0.374
+ $Y2=0.234
r20 2 56 19.3796 $a=3.24e-16 $layer=V0LIG $X=0.729 $Y=0.136 $X2=0.729 $Y2=0.1445
r21 2 12 6.54019 $w=2.09524e-08 $layer=Gate_1 $thickness=5.21905e-08 $X=0.729
+ $Y=0.136 $X2=0.729 $Y2=0.136
r22 6 21 19.3796 $a=3.24e-16 $layer=V0LISD $X=0.432 $Y=0.0405 $X2=0.432
+ $Y2=0.036
r23 6 63 23.8708 $w=2.02e-08 $l=4.05e-08 $layer=LISD $thickness=2.7e-08
+ $X=0.432 $Y=0.0405 $X2=0.432 $Y2=0.081
r24 59 60 1.98211 $w=1.3e-08 $l=8.5e-09 $layer=M1 $thickness=3.6e-08 $X=0.383
+ $Y=0.234 $X2=0.3915 $Y2=0.234
r25 59 62 2.09871 $w=1.3e-08 $l=9e-09 $layer=M1 $thickness=3.6e-08 $X=0.383
+ $Y=0.234 $X2=0.374 $Y2=0.234
r26 58 60 3.14806 $w=1.3e-08 $l=1.35e-08 $layer=M1 $thickness=3.6e-08 $X=0.405
+ $Y=0.234 $X2=0.3915 $Y2=0.234
r27 20 58 6.29612 $w=1.3e-08 $l=2.7e-08 $layer=M1 $thickness=3.6e-08 $X=0.432
+ $Y=0.234 $X2=0.405 $Y2=0.234
r28 25 56 4.6638 $w=1.3e-08 $l=2e-08 $layer=M1 $thickness=3.6e-08 $X=0.729
+ $Y=0.1245 $X2=0.729 $Y2=0.1445
r29 19 51 2.5483 $w=1.79e-08 $l=1.8e-08 $layer=M1 $thickness=3.6e-08 $X=0.459
+ $Y=0.234 $X2=0.459 $Y2=0.216
r30 19 20 4.64701 $w=1.46667e-08 $l=2.7e-08 $layer=M1 $thickness=3.6e-08
+ $X=0.459 $Y=0.234 $X2=0.432 $Y2=0.234
r31 54 56 19.5347 $a=3.24e-16 $layer=V1 $X=0.729 $Y=0.153 $X2=0.729 $Y2=0.1445
r32 53 54 24.6015 $w=1.3e-08 $l=1.055e-07 $layer=M2 $thickness=3.6e-08
+ $X=0.6235 $Y=0.153 $X2=0.729 $Y2=0.153
r33 52 53 29.3819 $w=1.3e-08 $l=1.26e-07 $layer=M2 $thickness=3.6e-08 $X=0.4975
+ $Y=0.153 $X2=0.6235 $Y2=0.153
r34 26 52 8.97781 $w=1.3e-08 $l=3.85e-08 $layer=M2 $thickness=3.6e-08 $X=0.459
+ $Y=0.153 $X2=0.4975 $Y2=0.153
r35 26 46 19.5347 $a=3.24e-16 $layer=V1 $X=0.459 $Y=0.153 $X2=0.459 $Y2=0.153
r36 17 45 6.39593 $w=1.55565e-08 $l=3.45e-08 $layer=M1 $thickness=3.6e-08
+ $X=0.459 $Y=0.036 $X2=0.459 $Y2=0.0705
r37 17 21 4.64701 $w=1.46667e-08 $l=2.7e-08 $layer=M1 $thickness=3.6e-08
+ $X=0.459 $Y=0.036 $X2=0.432 $Y2=0.036
r38 50 51 4.19742 $w=1.3e-08 $l=1.8e-08 $layer=M1 $thickness=3.6e-08 $X=0.459
+ $Y=0.198 $X2=0.459 $Y2=0.216
r39 49 50 4.19742 $w=1.3e-08 $l=1.8e-08 $layer=M1 $thickness=3.6e-08 $X=0.459
+ $Y=0.18 $X2=0.459 $Y2=0.198
r40 48 49 2.91487 $w=1.3e-08 $l=1.25e-08 $layer=M1 $thickness=3.6e-08 $X=0.459
+ $Y=0.1675 $X2=0.459 $Y2=0.18
r41 47 48 1.04935 $w=1.3e-08 $l=4.5e-09 $layer=M1 $thickness=3.6e-08 $X=0.459
+ $Y=0.163 $X2=0.459 $Y2=0.1675
r42 46 47 2.3319 $w=1.3e-08 $l=1e-08 $layer=M1 $thickness=3.6e-08 $X=0.459
+ $Y=0.153 $X2=0.459 $Y2=0.163
r43 23 46 2.68168 $w=1.3e-08 $l=1.15e-08 $layer=M1 $thickness=3.6e-08 $X=0.459
+ $Y=0.1415 $X2=0.459 $Y2=0.153
r44 44 45 7.11229 $w=1.3e-08 $l=3.05e-08 $layer=M1 $thickness=3.6e-08 $X=0.459
+ $Y=0.101 $X2=0.459 $Y2=0.0705
r45 22 44 2.91487 $w=1.3e-08 $l=1.25e-08 $layer=M1 $thickness=3.6e-08 $X=0.459
+ $Y=0.1135 $X2=0.459 $Y2=0.101
r46 18 42 5.11582 $w=1.46667e-08 $l=2.7e-08 $layer=M1 $thickness=3.6e-08
+ $X=0.459 $Y=0.13 $X2=0.486 $Y2=0.13
r47 18 22 2.66732 $w=1.57273e-08 $l=1.65e-08 $layer=M1 $thickness=3.6e-08
+ $X=0.459 $Y=0.13 $X2=0.459 $Y2=0.1135
r48 18 23 1.50137 $w=1.6913e-08 $l=1.15e-08 $layer=M1 $thickness=3.6e-08
+ $X=0.459 $Y=0.13 $X2=0.459 $Y2=0.1415
r49 41 42 6.29612 $w=1.3e-08 $l=2.7e-08 $layer=M1 $thickness=3.6e-08 $X=0.513
+ $Y=0.13 $X2=0.486 $Y2=0.13
r50 24 39 6.29612 $w=1.3e-08 $l=2.7e-08 $layer=M1 $thickness=3.6e-08 $X=0.54
+ $Y=0.13 $X2=0.567 $Y2=0.13
r51 24 41 6.29612 $w=1.3e-08 $l=2.7e-08 $layer=M1 $thickness=3.6e-08 $X=0.54
+ $Y=0.13 $X2=0.513 $Y2=0.13
r52 38 39 19.3796 $a=3.24e-16 $layer=V0LIG $X=0.567 $Y=0.133 $X2=0.567 $Y2=0.13
r53 1 32 4.51932 $w=1.96083e-08 $l=6e-09 $layer=Gate_1 $thickness=5.53333e-08
+ $X=0.567 $Y=0.124 $X2=0.567 $Y2=0.13
r54 1 37 1.77217 $w=1.53e-08 $l=3e-09 $layer=LIG $thickness=4.8e-08 $X=0.567
+ $Y=0.124 $X2=0.567 $Y2=0.121
r55 1 38 5.31651 $w=1.53e-08 $l=9e-09 $layer=LIG $thickness=4.8e-08 $X=0.567
+ $Y=0.124 $X2=0.567 $Y2=0.133
r56 35 34 14.6259 $w=2.1e-08 $l=4.3e-08 $layer=Gate_1 $thickness=5.6e-08
+ $X=0.567 $Y=0.2295 $X2=0.567 $Y2=0.1865
r57 33 34 12.7552 $w=2.1e-08 $l=3.75e-08 $layer=Gate_1 $thickness=5.6e-08
+ $X=0.567 $Y=0.149 $X2=0.567 $Y2=0.1865
r58 32 33 6.6497 $w=2.04211e-08 $l=1.9e-08 $layer=Gate_1 $thickness=5.6e-08
+ $X=0.567 $Y=0.13 $X2=0.567 $Y2=0.149
r59 32 37 5.11004 $w=1.92769e-08 $l=9e-09 $layer=Gate_1 $thickness=5.47692e-08
+ $X=0.567 $Y=0.13 $X2=0.567 $Y2=0.121
r60 31 32 4.94901 $w=2.02143e-08 $l=1.4e-08 $layer=Gate_1 $thickness=5.6e-08
+ $X=0.567 $Y=0.116 $X2=0.567 $Y2=0.13
r61 30 31 11.0545 $w=2.1e-08 $l=3.25e-08 $layer=Gate_1 $thickness=5.6e-08
+ $X=0.567 $Y=0.0835 $X2=0.567 $Y2=0.116
r62 29 30 14.6259 $w=2.1e-08 $l=4.3e-08 $layer=Gate_1 $thickness=5.6e-08
+ $X=0.567 $Y=0.0405 $X2=0.567 $Y2=0.0835
r63 29 11 5.44221 $w=2.1e-08 $l=1.6e-08 $layer=Gate_1 $thickness=5.6e-08
+ $X=0.567 $Y=0.0405 $X2=0.567 $Y2=0.0245
.ends

.subckt PM_DHLx1_ASAP7_75t_R%CLK vss 18 9 15 3 1 6 5 4 8 7
c1 1 vss 0.00393822f $X=0.081 $Y=0.135
c2 3 vss 0.0688051f $X=0.081 $Y=0.0245
c3 4 vss 0.00205918f $X=0.081 $Y=0.099
c4 5 vss 0.00193315f $X=0.081 $Y=0.171
c5 6 vss 0.00106469f $X=0.081 $Y=0.135
c6 7 vss 0.00441691f $X=0.108 $Y=0.063
c7 8 vss 0.00429938f $X=0.108 $Y=0.1935
r1 8 24 1.35805 $w=2.83333e-08 $l=2.25e-08 $layer=M1 $thickness=3.6e-08
+ $X=0.108 $Y=0.1935 $X2=0.108 $Y2=0.171
r2 7 22 4.50612 $w=2.06667e-08 $l=3.6e-08 $layer=M1 $thickness=3.6e-08 $X=0.108
+ $Y=0.063 $X2=0.108 $Y2=0.099
r3 23 24 0.502848 $w=3.43333e-08 $l=1.35e-08 $layer=M1 $thickness=3.6e-08
+ $X=0.0945 $Y=0.171 $X2=0.108 $Y2=0.171
r4 5 20 1.35805 $w=2.83333e-08 $l=2.25e-08 $layer=M1 $thickness=3.6e-08
+ $X=0.081 $Y=0.171 $X2=0.081 $Y2=0.1485
r5 5 23 0.502848 $w=3.43333e-08 $l=1.35e-08 $layer=M1 $thickness=3.6e-08
+ $X=0.081 $Y=0.171 $X2=0.0945 $Y2=0.171
r6 21 22 0.502848 $w=3.43333e-08 $l=1.35e-08 $layer=M1 $thickness=3.6e-08
+ $X=0.0945 $Y=0.099 $X2=0.108 $Y2=0.099
r7 4 17 0.483592 $w=3.42308e-08 $l=1.87e-08 $layer=M1 $thickness=3.6e-08
+ $X=0.081 $Y=0.099 $X2=0.081 $Y2=0.1177
r8 4 21 0.502848 $w=3.43333e-08 $l=1.35e-08 $layer=M1 $thickness=3.6e-08
+ $X=0.081 $Y=0.099 $X2=0.0945 $Y2=0.099
r9 18 19 0.874462 $w=1.3e-08 $l=3.7e-09 $layer=M1 $thickness=3.6e-08 $X=0.08
+ $Y=0.119 $X2=0.081 $Y2=0.1227
r10 18 17 0.291487 $w=1.3e-08 $l=1.3e-09 $layer=M1 $thickness=3.6e-08 $X=0.08
+ $Y=0.119 $X2=0.081 $Y2=0.1177
r11 6 19 2.85657 $w=1.3e-08 $l=1.23e-08 $layer=M1 $thickness=3.6e-08 $X=0.081
+ $Y=0.135 $X2=0.081 $Y2=0.1227
r12 6 20 3.14806 $w=1.3e-08 $l=1.35e-08 $layer=M1 $thickness=3.6e-08 $X=0.081
+ $Y=0.135 $X2=0.081 $Y2=0.1485
r13 1 12 10.4265 $w=1.765e-08 $layer=LIG $thickness=5.2e-08 $X=0.081 $Y=0.135
+ $X2=0.081 $Y2=0.135
r14 1 6 19.3796 $a=3.24e-16 $layer=V0LIG $X=0.081 $Y=0.135 $X2=0.081 $Y2=0.135
r15 15 14 14.6259 $w=2.1e-08 $l=4.3e-08 $layer=Gate_1 $thickness=5.6e-08
+ $X=0.081 $Y=0.216 $X2=0.081 $Y2=0.173
r16 13 14 7.31297 $w=2.1e-08 $l=2.15e-08 $layer=Gate_1 $thickness=5.6e-08
+ $X=0.081 $Y=0.1515 $X2=0.081 $Y2=0.173
r17 12 13 5.79936 $w=2.03333e-08 $l=1.65e-08 $layer=Gate_1 $thickness=5.6e-08
+ $X=0.081 $Y=0.135 $X2=0.081 $Y2=0.1515
r18 11 12 5.79936 $w=2.03333e-08 $l=1.65e-08 $layer=Gate_1 $thickness=5.6e-08
+ $X=0.081 $Y=0.1185 $X2=0.081 $Y2=0.135
r19 10 11 7.31297 $w=2.1e-08 $l=2.15e-08 $layer=Gate_1 $thickness=5.6e-08
+ $X=0.081 $Y=0.097 $X2=0.081 $Y2=0.1185
r20 9 10 14.6259 $w=2.1e-08 $l=4.3e-08 $layer=Gate_1 $thickness=5.6e-08
+ $X=0.081 $Y=0.054 $X2=0.081 $Y2=0.097
r21 9 3 10.0341 $w=2.1e-08 $l=2.95e-08 $layer=Gate_1 $thickness=5.6e-08
+ $X=0.081 $Y=0.054 $X2=0.081 $Y2=0.0245
.ends

.subckt PM_DHLx1_ASAP7_75t_R%7 vss 18 22 39 45 9 13 4 17 1 3 16 12 11 10 15
c1 1 vss 0.00268249f $X=0.513 $Y=0.082
c2 3 vss 0.00629023f $X=0.594 $Y=0.0405
c3 4 vss 0.00614093f $X=0.594 $Y=0.2295
c4 9 vss 0.040761f $X=0.513 $Y=0.0245
c5 10 vss 0.0191004f $X=0.5795 $Y=0.0405
c6 11 vss 0.0187245f $X=0.5795 $Y=0.2295
c7 12 vss 0.00292107f $X=0.513 $Y=0.036
c8 13 vss 0.00649754f $X=0.621 $Y=0.234
c9 14 vss 0.00329194f $X=0.621 $Y=0.036
c10 15 vss 0.00143173f $X=0.513 $Y=0.059
c11 16 vss 0.00831017f $X=0.5515 $Y=0.036
c12 17 vss 0.00680001f $X=0.621 $Y=0.0705
r1 11 4 0.462963 $w=2.7e-08 $l=1.25e-08 $layer=P_src_drn $thickness=1e-09
+ $X=0.5795 $Y=0.2295 $X2=0.594 $Y2=0.2295
r2 45 11 0.0925926 $w=2.7e-08 $l=2.5e-09 $layer=P_src_drn $thickness=1e-09
+ $X=0.5766 $Y=0.2295 $X2=0.5795 $Y2=0.2295
r3 4 41 19.3796 $a=3.24e-16 $layer=V0LISD $X=0.594 $Y=0.2295 $X2=0.594 $Y2=0.234
r4 41 42 3.14806 $w=1.3e-08 $l=1.35e-08 $layer=M1 $thickness=3.6e-08 $X=0.594
+ $Y=0.234 $X2=0.6075 $Y2=0.234
r5 13 37 3.01711 $w=1.55e-08 $l=1.8e-08 $layer=M1 $thickness=3.6e-08 $X=0.621
+ $Y=0.234 $X2=0.621 $Y2=0.216
r6 13 42 1.96775 $w=1.63333e-08 $l=1.35e-08 $layer=M1 $thickness=3.6e-08
+ $X=0.621 $Y=0.234 $X2=0.6075 $Y2=0.234
r7 10 3 0.462963 $w=2.7e-08 $l=1.25e-08 $layer=N_src_drn $thickness=1e-09
+ $X=0.5795 $Y=0.0405 $X2=0.594 $Y2=0.0405
r8 39 10 0.0925926 $w=2.7e-08 $l=2.5e-09 $layer=N_src_drn $thickness=1e-09
+ $X=0.5766 $Y=0.0405 $X2=0.5795 $Y2=0.0405
r9 36 37 6.7625 $w=1.3e-08 $l=2.9e-08 $layer=M1 $thickness=3.6e-08 $X=0.621
+ $Y=0.187 $X2=0.621 $Y2=0.216
r10 35 36 5.01358 $w=1.3e-08 $l=2.15e-08 $layer=M1 $thickness=3.6e-08 $X=0.621
+ $Y=0.1655 $X2=0.621 $Y2=0.187
r11 34 35 3.26466 $w=1.3e-08 $l=1.4e-08 $layer=M1 $thickness=3.6e-08 $X=0.621
+ $Y=0.1515 $X2=0.621 $Y2=0.1655
r12 33 34 4.89699 $w=1.3e-08 $l=2.1e-08 $layer=M1 $thickness=3.6e-08 $X=0.621
+ $Y=0.1305 $X2=0.621 $Y2=0.1515
r13 32 33 2.09871 $w=1.3e-08 $l=9e-09 $layer=M1 $thickness=3.6e-08 $X=0.621
+ $Y=0.1215 $X2=0.621 $Y2=0.1305
r14 31 32 3.03147 $w=1.3e-08 $l=1.3e-08 $layer=M1 $thickness=3.6e-08 $X=0.621
+ $Y=0.1085 $X2=0.621 $Y2=0.1215
r15 17 31 8.86121 $w=1.3e-08 $l=3.8e-08 $layer=M1 $thickness=3.6e-08 $X=0.621
+ $Y=0.0705 $X2=0.621 $Y2=0.1085
r16 3 29 19.3796 $a=3.24e-16 $layer=V0LISD $X=0.594 $Y=0.0405 $X2=0.594
+ $Y2=0.036
r17 14 30 1.49895 $w=1.63333e-08 $l=1.35e-08 $layer=M1 $thickness=3.6e-08
+ $X=0.621 $Y=0.036 $X2=0.6075 $Y2=0.036
r18 14 17 6.39593 $w=1.55565e-08 $l=3.45e-08 $layer=M1 $thickness=3.6e-08
+ $X=0.621 $Y=0.036 $X2=0.621 $Y2=0.0705
r19 29 30 3.14806 $w=1.3e-08 $l=1.35e-08 $layer=M1 $thickness=3.6e-08 $X=0.594
+ $Y=0.036 $X2=0.6075 $Y2=0.036
r20 28 29 2.56509 $w=1.3e-08 $l=1.1e-08 $layer=M1 $thickness=3.6e-08 $X=0.583
+ $Y=0.036 $X2=0.594 $Y2=0.036
r21 16 28 7.34548 $w=1.3e-08 $l=3.15e-08 $layer=M1 $thickness=3.6e-08 $X=0.5515
+ $Y=0.036 $X2=0.583 $Y2=0.036
r22 12 15 3.71425 $w=1.68348e-08 $l=2.3e-08 $layer=M1 $thickness=3.6e-08
+ $X=0.513 $Y=0.036 $X2=0.513 $Y2=0.059
r23 12 16 7.32869 $w=1.41688e-08 $l=3.85e-08 $layer=M1 $thickness=3.6e-08
+ $X=0.513 $Y=0.036 $X2=0.5515 $Y2=0.036
r24 15 26 5.36336 $w=1.3e-08 $l=2.3e-08 $layer=M1 $thickness=3.6e-08 $X=0.513
+ $Y=0.059 $X2=0.513 $Y2=0.082
r25 1 20 6.54019 $w=2.09524e-08 $layer=Gate_1 $thickness=5.21905e-08 $X=0.513
+ $Y=0.082 $X2=0.513 $Y2=0.082
r26 1 26 19.3796 $a=3.24e-16 $layer=V0LIG $X=0.513 $Y=0.082 $X2=0.513 $Y2=0.082
r27 22 21 25.5104 $w=2.1e-08 $l=7.5e-08 $layer=Gate_1 $thickness=5.6e-08
+ $X=0.513 $Y=0.2295 $X2=0.513 $Y2=0.1545
r28 20 21 24.8471 $w=2.08483e-08 $l=7.25e-08 $layer=Gate_1 $thickness=5.6e-08
+ $X=0.513 $Y=0.082 $X2=0.513 $Y2=0.1545
r29 19 20 6.81977 $w=2.04359e-08 $l=1.95e-08 $layer=Gate_1 $thickness=5.6e-08
+ $X=0.513 $Y=0.0625 $X2=0.513 $Y2=0.082
r30 18 19 7.48304 $w=2.1e-08 $l=2.2e-08 $layer=Gate_1 $thickness=5.6e-08
+ $X=0.513 $Y=0.0405 $X2=0.513 $Y2=0.0625
r31 18 9 5.44221 $w=2.1e-08 $l=1.6e-08 $layer=Gate_1 $thickness=5.6e-08
+ $X=0.513 $Y=0.0405 $X2=0.513 $Y2=0.0245
.ends

* End of included file DHLx1_ASAP7_75t_R.pex.sp.pex

*
.subckt DHLx1_ASAP7_75t_CUSTOM_4_25_0_7 VSS VDD CLK D Q
*
* VSS VSS
* VDD VDD
* CLK CLK
* D D
* Q Q
*
*

M0 VSS N_M0_g N_M0_s VSS nmos_rvt L=2e-08 W=5.4e-08 nfin=2 $X=0.071 $Y=0.027
M1 N_M1_d N_M1_g VSS VSS nmos_rvt L=2e-08 W=5.4e-08 nfin=2 $X=0.125 $Y=0.027
M2 N_M2_d N_M2_g VSS VSS nmos_rvt L=2e-08 W=8.1e-08 nfin=3 $X=0.287 $Y=0.027
M3 N_M3_d N_M3_g N_M3_s VSS nmos_rvt L=2e-08 W=8.1e-08 nfin=3 $X=0.395 $Y=0.027
M4 N_M4_d N_M4_g N_M4_s VSS nmos_rvt L=2e-08 W=2.7e-08 nfin=1 $X=0.449 $Y=0.027
M5 VSS N_M5_g N_M5_s VSS nmos_rvt L=2e-08 W=2.7e-08 nfin=1 $X=0.503 $Y=0.027
M6 N_M6_d N_M6_g VSS VSS nmos_rvt L=2e-08 W=2.7e-08 nfin=1 $X=0.557 $Y=0.027
M7 N_M7_d N_M7_g VSS VSS nmos_rvt L=2e-08 W=8.1e-08 nfin=3 $X=0.719 $Y=0.027
M8 VDD N_M8_g N_M8_s VDD pmos_rvt L=2e-08 W=5.4e-08 nfin=2 $X=0.071 $Y=0.189
M9 N_M9_d N_M9_g VDD VDD pmos_rvt L=2e-08 W=5.4e-08 nfin=2 $X=0.125 $Y=0.189
M10 N_M10_d N_M10_g VDD VDD pmos_rvt L=2e-08 W=8.1e-08 nfin=3 $X=0.287 $Y=0.162
M11 N_M11_d N_M11_g N_M11_s VDD pmos_rvt L=2e-08 W=8.1e-08 nfin=3 $X=0.341
+ $Y=0.162
M12 N_M12_d N_M12_g N_M12_s VDD pmos_rvt L=2e-08 W=2.7e-08 nfin=1 $X=0.395
+ $Y=0.216
M13 VDD N_M13_g N_M13_s VDD pmos_rvt L=2e-08 W=2.7e-08 nfin=1 $X=0.503 $Y=0.216
M14 N_M14_d N_M14_g VDD VDD pmos_rvt L=2e-08 W=2.7e-08 nfin=1 $X=0.557 $Y=0.216
M15 N_M15_d N_M15_g VDD VDD pmos_rvt L=2e-08 W=8.1e-08 nfin=3 $X=0.719 $Y=0.162

* .include "DHLx1_ASAP7_75t_R.pex.sp.pxi"

* Start of included file DHLx1_ASAP7_75t_R.pex.sp.pxi
x_PM_DHLx1_ASAP7_75t_R%12 vss N_M4_d N_M5_s N_12_1 PM_DHLx1_ASAP7_75t_R%12
cc_1 N_12_1 N_4_16 0.0075663f $X=0.486 $Y=0.0405
cc_2 N_12_1 N_7_9 0.00765946f $X=0.486 $Y=0.0405
x_PM_DHLx1_ASAP7_75t_R%D vss D N_M2_g N_M10_g N_D_5 N_D_1 N_D_3 N_D_4
+ PM_DHLx1_ASAP7_75t_R%D
cc_3 N_D_5 N_4_23 9.51963e-20 $X=0.297 $Y=0.0755
cc_4 N_D_5 N_4_30 9.57057e-20 $X=0.297 $Y=0.0755
cc_5 N_D_5 N_4_24 0.000606855f $X=0.297 $Y=0.0755
cc_6 N_D_5 N_4_2 0.000833146f $X=0.297 $Y=0.0755
cc_7 N_D_5 N_4_33 0.000866266f $X=0.297 $Y=0.0755
cc_8 N_D_1 N_4_2 0.00134709f $X=0.297 $Y=0.1345
cc_9 N_D_3 N_4_15 0.00494765f $X=0.297 $Y=0.0245
cc_10 N_D_5 N_4_31 0.00517105f $X=0.297 $Y=0.0755
x_PM_DHLx1_ASAP7_75t_R%13 vss N_M10_d N_M11_s N_13_1 PM_DHLx1_ASAP7_75t_R%13
cc_11 N_13_1 N_4_15 0.0169487f $X=0.324 $Y=0.2025
cc_12 N_13_1 N_D_3 0.0167267f $X=0.324 $Y=0.2025
x_PM_DHLx1_ASAP7_75t_R%4 vss N_M11_g N_M4_g N_M0_s N_M8_s N_M1_g N_M9_g N_4_20
+ N_4_22 N_4_7 N_4_6 N_4_23 N_4_18 N_4_17 N_4_30 N_4_1 N_4_28 N_4_25 N_4_29
+ N_4_33 N_4_27 N_4_14 N_4_24 N_4_2 N_4_15 N_4_31 N_4_3 N_4_16 N_4_8 N_4_32
+ PM_DHLx1_ASAP7_75t_R%4
cc_13 N_4_20 N_CLK_3 0.000194726f $X=0.0165 $Y=0.189
cc_14 N_4_22 N_CLK_3 0.000211358f $X=0.1505 $Y=0.189
cc_15 N_4_7 N_CLK_3 0.00102899f $X=0.054 $Y=0.216
cc_16 N_4_6 N_CLK_3 0.00107588f $X=0.054 $Y=0.054
cc_17 N_4_23 N_CLK_3 0.000282182f $X=0.189 $Y=0.135
cc_18 N_4_18 N_CLK_3 0.0111019f $X=0.056 $Y=0.216
cc_19 N_4_17 N_CLK_3 0.0110391f $X=0.056 $Y=0.054
cc_20 N_4_30 N_CLK_3 0.000364378f $X=0.189 $Y=0.1665
cc_21 N_4_1 N_CLK_3 0.000553865f $X=0.153 $Y=0.135
cc_22 N_4_28 N_CLK_3 0.000589585f $X=0.036 $Y=0.234
cc_23 N_4_1 N_CLK_1 0.00355233f $X=0.153 $Y=0.135
cc_24 N_4_25 N_CLK_6 0.0010989f $X=0.018 $Y=0.1665
cc_25 N_4_29 N_CLK_5 0.00116477f $X=0.1545 $Y=0.135
cc_26 N_4_29 N_CLK_4 0.00150678f $X=0.1545 $Y=0.135
cc_27 N_4_33 N_CLK_8 0.00162479f $X=0.2855 $Y=0.189
cc_28 N_4_22 N_CLK_8 0.00165017f $X=0.1505 $Y=0.189
cc_29 N_4_27 N_CLK_7 0.00185043f $X=0.036 $Y=0.036
cc_30 N_4_22 N_CLK_5 0.00216754f $X=0.1505 $Y=0.189
cc_31 N_4_20 N_CLK_5 0.00282939f $X=0.0165 $Y=0.189
cc_32 N_4_25 N_CLK_4 0.00291491f $X=0.018 $Y=0.1665
cc_33 N_4_14 N_CLK_3 0.0356374f $X=0.135 $Y=0.135
x_PM_DHLx1_ASAP7_75t_R%Q vss Q N_M7_d N_M15_d N_Q_7 N_Q_11 N_Q_8
+ PM_DHLx1_ASAP7_75t_R%Q
cc_34 N_Q_7 N_8_25 0.000811316f $X=0.7415 $Y=0.0675
cc_35 N_Q_7 N_8_2 0.00262432f $X=0.7415 $Y=0.0675
cc_36 N_Q_7 N_8_26 0.000906364f $X=0.7415 $Y=0.0675
cc_37 N_Q_11 N_8_25 0.00396243f $X=0.783 $Y=0.0627
cc_38 N_Q_8 N_8_12 0.0148831f $X=0.7415 $Y=0.2025
cc_39 N_Q_7 N_8_12 0.056463f $X=0.7415 $Y=0.0675
x_PM_DHLx1_ASAP7_75t_R%10 vss N_M2_d N_M3_s N_10_4 N_10_5 N_10_1
+ PM_DHLx1_ASAP7_75t_R%10
cc_40 N_10_4 N_4_2 0.00195011f $X=0.3095 $Y=0.0675
cc_41 N_10_4 N_4_31 0.000459313f $X=0.3095 $Y=0.0675
cc_42 N_10_4 N_4_15 0.0729479f $X=0.3095 $Y=0.0675
cc_43 N_10_4 N_D_3 0.0365022f $X=0.3095 $Y=0.0675
cc_44 N_10_5 N_6_1 0.000658041f $X=0.38 $Y=0.0675
cc_45 N_10_5 N_6_9 0.0346257f $X=0.38 $Y=0.0675
cc_46 N_10_1 N_8_14 0.000609124f $X=0.351 $Y=0.0675
cc_47 N_10_1 N_8_6 0.001071f $X=0.351 $Y=0.0675
cc_48 N_10_1 N_8_13 0.00267688f $X=0.351 $Y=0.0675
x_PM_DHLx1_ASAP7_75t_R%11 vss N_M12_d N_M13_s N_11_4 N_11_1 N_11_5
+ PM_DHLx1_ASAP7_75t_R%11
cc_49 N_11_4 N_4_32 0.000137245f $X=0.4175 $Y=0.2295
cc_50 N_11_1 N_4_3 0.00100704f $X=0.432 $Y=0.2295
cc_51 N_11_5 N_4_8 0.00107339f $X=0.488 $Y=0.2295
cc_52 N_11_1 N_4_16 0.0020497f $X=0.432 $Y=0.2295
cc_53 N_11_5 N_4_16 0.00694971f $X=0.488 $Y=0.2295
cc_54 N_11_4 N_4_16 0.024141f $X=0.4175 $Y=0.2295
cc_55 N_11_4 N_6_9 0.0149652f $X=0.4175 $Y=0.2295
cc_56 N_11_5 N_7_9 0.0144648f $X=0.488 $Y=0.2295
cc_57 N_11_1 N_8_16 0.00029572f $X=0.432 $Y=0.2295
cc_58 N_11_1 N_8_23 0.000399129f $X=0.432 $Y=0.2295
cc_59 N_11_1 N_8_20 0.000417743f $X=0.432 $Y=0.2295
cc_60 N_11_4 N_8_5 0.000524476f $X=0.4175 $Y=0.2295
cc_61 N_11_1 N_8_19 0.00209675f $X=0.432 $Y=0.2295
x_PM_DHLx1_ASAP7_75t_R%6 vss N_M3_g N_M12_g N_M1_d N_M9_d N_6_3 N_6_15 N_6_14
+ N_6_11 N_6_10 N_6_4 N_6_9 N_6_18 N_6_17 N_6_16 N_6_1 N_6_12
+ PM_DHLx1_ASAP7_75t_R%6
cc_62 N_6_3 N_CLK_7 0.000264236f $X=0.162 $Y=0.054
cc_63 N_6_15 N_CLK_7 0.00101638f $X=0.216 $Y=0.234
cc_64 N_6_14 N_CLK_7 0.00283836f $X=0.216 $Y=0.036
cc_65 N_6_11 N_4_7 5.51297e-20 $X=0.1475 $Y=0.216
cc_66 N_6_11 N_4_6 5.76364e-20 $X=0.1475 $Y=0.216
cc_67 N_6_11 N_4_25 0.000200344f $X=0.1475 $Y=0.216
cc_68 N_6_11 N_4_22 0.000254129f $X=0.1475 $Y=0.216
cc_69 N_6_15 N_4_22 0.00450665f $X=0.216 $Y=0.234
cc_70 N_6_10 N_4_14 0.011029f $X=0.1475 $Y=0.054
cc_71 N_6_4 N_4_22 0.000401379f $X=0.162 $Y=0.216
cc_72 N_6_3 N_4_1 0.000408307f $X=0.162 $Y=0.054
cc_73 N_6_9 N_4_3 0.000495195f $X=0.405 $Y=0.0245
cc_74 N_6_18 N_4_24 0.000511976f $X=0.2315 $Y=0.153
cc_75 N_6_17 N_4_24 0.000533852f $X=0.405 $Y=0.1155
cc_76 N_6_16 N_4_29 0.00053794f $X=0.243 $Y=0.135
cc_77 N_6_14 N_4_23 0.000608763f $X=0.216 $Y=0.036
cc_78 N_6_17 N_4_33 0.000696941f $X=0.405 $Y=0.1155
cc_79 N_6_16 N_4_33 0.000725925f $X=0.243 $Y=0.135
cc_80 N_6_3 N_4_14 0.000796617f $X=0.162 $Y=0.054
cc_81 N_6_1 N_4_2 0.00240527f $X=0.405 $Y=0.132
cc_82 N_6_16 N_4_30 0.000968826f $X=0.243 $Y=0.135
cc_83 N_6_10 N_4_1 0.00103453f $X=0.1475 $Y=0.054
cc_84 N_6_4 N_4_14 0.00121251f $X=0.162 $Y=0.216
cc_85 N_6_9 N_4_15 0.00163008f $X=0.405 $Y=0.0245
cc_86 N_6_16 N_4_23 0.00351432f $X=0.243 $Y=0.135
cc_87 N_6_17 N_4_31 0.00364925f $X=0.405 $Y=0.1155
cc_88 N_6_9 N_4_16 0.00857413f $X=0.405 $Y=0.0245
cc_89 N_6_18 N_4_33 0.0169539f $X=0.2315 $Y=0.153
cc_90 N_6_11 N_4_14 0.0390272f $X=0.1475 $Y=0.216
cc_91 N_6_18 N_D_5 0.00101784f $X=0.2315 $Y=0.153
cc_92 N_6_12 N_D_4 0.00125974f $X=0.243 $Y=0.036
cc_93 N_6_16 N_D_5 0.00829073f $X=0.243 $Y=0.135
x_PM_DHLx1_ASAP7_75t_R%8 vss N_M6_g N_M14_g N_M3_d N_M4_s N_M7_g N_M15_g
+ N_M11_d N_M12_s N_8_13 N_8_5 N_8_16 N_8_22 N_8_19 N_8_14 N_8_1 N_8_23 N_8_24
+ N_8_6 N_8_15 N_8_26 N_8_20 N_8_11 N_8_21 N_8_18 N_8_2 N_8_25 N_8_17 N_8_12
+ PM_DHLx1_ASAP7_75t_R%8
cc_94 N_8_13 N_4_32 0.000121492f $X=0.4175 $Y=0.0405
cc_95 N_8_13 N_4_24 0.000133481f $X=0.4175 $Y=0.0405
cc_96 N_8_13 N_4_15 0.000147816f $X=0.4175 $Y=0.0405
cc_97 N_8_5 N_4_2 0.000235203f $X=0.378 $Y=0.2295
cc_98 N_8_16 N_4_15 0.0244088f $X=0.3635 $Y=0.189
cc_99 N_8_22 N_4_32 0.000331649f $X=0.459 $Y=0.1135
cc_100 N_8_5 N_4_24 0.000423785f $X=0.378 $Y=0.2295
cc_101 N_8_19 N_4_32 0.000433496f $X=0.459 $Y=0.234
cc_102 N_8_14 N_4_16 0.0055869f $X=0.4175 $Y=0.081
cc_103 N_8_5 N_4_31 0.000505486f $X=0.378 $Y=0.2295
cc_104 N_8_1 N_4_8 0.00163f $X=0.567 $Y=0.124
cc_105 N_8_23 N_4_33 0.000602899f $X=0.459 $Y=0.1415
cc_106 N_8_24 N_4_8 0.00063682f $X=0.54 $Y=0.13
cc_107 N_8_6 N_4_16 0.000657216f $X=0.432 $Y=0.0405
cc_108 N_8_15 N_4_2 0.000707287f $X=0.3635 $Y=0.2295
cc_109 N_8_26 N_4_32 0.00091456f $X=0.459 $Y=0.153
cc_110 N_8_23 N_4_3 0.00103352f $X=0.459 $Y=0.1415
cc_111 N_8_24 N_4_32 0.00160663f $X=0.54 $Y=0.13
cc_112 N_8_5 N_4_15 0.00184122f $X=0.378 $Y=0.2295
cc_113 N_8_20 N_4_24 0.00357409f $X=0.432 $Y=0.234
cc_114 N_8_26 N_4_33 0.0041247f $X=0.459 $Y=0.153
cc_115 N_8_23 N_4_32 0.00467625f $X=0.459 $Y=0.1415
cc_116 N_8_20 N_4_33 0.00513331f $X=0.432 $Y=0.234
cc_117 N_8_11 N_4_8 0.0063119f $X=0.567 $Y=0.0245
cc_118 N_8_15 N_4_15 0.0099272f $X=0.3635 $Y=0.2295
cc_119 N_8_13 N_4_16 0.0318329f $X=0.4175 $Y=0.0405
cc_120 N_8_21 N_6_9 0.000273138f $X=0.432 $Y=0.036
cc_121 N_8_18 N_6_17 0.000423326f $X=0.459 $Y=0.13
cc_122 N_8_20 N_6_17 0.000428582f $X=0.432 $Y=0.234
cc_123 N_8_16 N_6_9 0.00556731f $X=0.3635 $Y=0.189
cc_124 N_8_26 N_6_18 0.000597652f $X=0.459 $Y=0.153
cc_125 N_8_22 N_6_17 0.000702295f $X=0.459 $Y=0.1135
cc_126 N_8_20 N_6_18 0.000750195f $X=0.432 $Y=0.234
cc_127 N_8_6 N_6_1 0.000810369f $X=0.432 $Y=0.0405
cc_128 N_8_23 N_6_17 0.00443348f $X=0.459 $Y=0.1415
cc_129 N_8_5 N_6_9 0.00100719f $X=0.378 $Y=0.2295
cc_130 N_8_6 N_6_9 0.00105088f $X=0.432 $Y=0.0405
cc_131 N_8_13 N_6_1 0.0016639f $X=0.4175 $Y=0.0405
cc_132 N_8_13 N_6_9 0.00963153f $X=0.4175 $Y=0.0405
cc_133 N_8_15 N_6_9 0.0108163f $X=0.3635 $Y=0.2295
cc_134 N_8_14 N_6_9 0.0457066f $X=0.4175 $Y=0.081
cc_135 N_8_2 N_7_9 0.000110904f $X=0.729 $Y=0.136
cc_136 N_8_24 N_7_9 0.000214226f $X=0.54 $Y=0.13
cc_137 N_8_25 N_7_9 0.000287673f $X=0.729 $Y=0.1245
cc_138 N_8_6 N_7_1 0.000388919f $X=0.432 $Y=0.0405
cc_139 N_8_11 N_7_3 0.000418972f $X=0.567 $Y=0.0245
cc_140 N_8_26 N_7_13 0.000494023f $X=0.459 $Y=0.153
cc_141 N_8_24 N_7_16 0.000617014f $X=0.54 $Y=0.13
cc_142 N_8_1 N_7_17 0.000812169f $X=0.567 $Y=0.124
cc_143 N_8_17 N_7_12 0.000859998f $X=0.459 $Y=0.036
cc_144 N_8_1 N_7_9 0.000943708f $X=0.567 $Y=0.124
cc_145 N_8_24 N_7_1 0.000984482f $X=0.54 $Y=0.13
cc_146 N_8_11 N_7_1 0.00106086f $X=0.567 $Y=0.0245
cc_147 N_8_11 N_7_11 0.0063348f $X=0.567 $Y=0.0245
cc_148 N_8_11 N_7_10 0.00655234f $X=0.567 $Y=0.0245
cc_149 N_8_26 N_7_17 0.00253173f $X=0.459 $Y=0.153
cc_150 N_8_24 N_7_15 0.00291861f $X=0.54 $Y=0.13
cc_151 N_8_22 N_7_15 0.00340463f $X=0.459 $Y=0.1135
cc_152 N_8_24 N_7_17 0.00378181f $X=0.54 $Y=0.13
cc_153 N_8_11 N_7_9 0.0307986f $X=0.567 $Y=0.0245
x_PM_DHLx1_ASAP7_75t_R%CLK vss CLK N_M0_g N_M8_g N_CLK_3 N_CLK_1 N_CLK_6
+ N_CLK_5 N_CLK_4 N_CLK_8 N_CLK_7 PM_DHLx1_ASAP7_75t_R%CLK
x_PM_DHLx1_ASAP7_75t_R%7 vss N_M5_g N_M13_g N_M6_d N_M14_d N_7_9 N_7_13 N_7_4
+ N_7_17 N_7_1 N_7_3 N_7_16 N_7_12 N_7_11 N_7_10 N_7_15 PM_DHLx1_ASAP7_75t_R%7
cc_154 N_7_9 N_4_3 0.000171771f $X=0.513 $Y=0.0245
cc_155 N_7_9 N_4_8 0.005455f $X=0.513 $Y=0.0245
cc_156 N_7_9 N_4_32 0.000335326f $X=0.513 $Y=0.0245
cc_157 N_7_13 N_4_8 0.000456746f $X=0.621 $Y=0.234
cc_158 N_7_4 N_4_8 0.000785152f $X=0.594 $Y=0.2295
cc_159 N_7_17 N_4_8 0.00132266f $X=0.621 $Y=0.0705
cc_160 N_7_9 N_4_16 0.014256f $X=0.513 $Y=0.0245

* End of included file DHLx1_ASAP7_75t_R.pex.sp.pxi
.ends

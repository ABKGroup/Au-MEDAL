.subckt PM_DFFHQx4_ASAP7_75t_R%CLK vss 17 9 15 3 1 7 8 4 5 6
c1 1 vss 0.00416754f $X=0.081 $Y=0.135
c2 3 vss 0.0697502f $X=0.081 $Y=0.0245
c3 4 vss 0.00264751f $X=0.081 $Y=0.088
c4 5 vss 0.00254485f $X=0.081 $Y=0.182
c5 6 vss 0.00129308f $X=0.081 $Y=0.1122
c6 7 vss 0.00421839f $X=0.108 $Y=0.0575
c7 8 vss 0.00408169f $X=0.108 $Y=0.2125
r1 8 25 3.22357 $w=2.26279e-08 $l=3.05e-08 $layer=M1 $thickness=3.6e-08
+ $X=0.108 $Y=0.2125 $X2=0.108 $Y2=0.182
r2 7 23 3.22357 $w=2.26279e-08 $l=3.05e-08 $layer=M1 $thickness=3.6e-08
+ $X=0.108 $Y=0.0575 $X2=0.108 $Y2=0.088
r3 24 25 0.502848 $w=3.43333e-08 $l=1.35e-08 $layer=M1 $thickness=3.6e-08
+ $X=0.0945 $Y=0.182 $X2=0.108 $Y2=0.182
r4 5 21 0.54189 $w=3.37e-08 $l=1.9e-08 $layer=M1 $thickness=3.6e-08 $X=0.081
+ $Y=0.182 $X2=0.081 $Y2=0.163
r5 5 24 0.502848 $w=3.43333e-08 $l=1.35e-08 $layer=M1 $thickness=3.6e-08
+ $X=0.081 $Y=0.182 $X2=0.0945 $Y2=0.182
r6 22 23 0.502848 $w=3.43333e-08 $l=1.35e-08 $layer=M1 $thickness=3.6e-08
+ $X=0.0945 $Y=0.088 $X2=0.108 $Y2=0.088
r7 4 6 1.76614 $w=2.65738e-08 $l=2.42e-08 $layer=M1 $thickness=3.6e-08 $X=0.081
+ $Y=0.088 $X2=0.081 $Y2=0.1122
r8 4 22 0.502848 $w=3.43333e-08 $l=1.35e-08 $layer=M1 $thickness=3.6e-08
+ $X=0.081 $Y=0.088 $X2=0.0945 $Y2=0.088
r9 20 21 2.3319 $w=1.3e-08 $l=1e-08 $layer=M1 $thickness=3.6e-08 $X=0.081
+ $Y=0.153 $X2=0.081 $Y2=0.163
r10 19 20 4.19742 $w=1.3e-08 $l=1.8e-08 $layer=M1 $thickness=3.6e-08 $X=0.081
+ $Y=0.135 $X2=0.081 $Y2=0.153
r11 18 19 2.85657 $w=1.3e-08 $l=1.23e-08 $layer=M1 $thickness=3.6e-08 $X=0.081
+ $Y=0.1227 $X2=0.081 $Y2=0.135
r12 17 18 0.874462 $w=1.3e-08 $l=3.7e-09 $layer=M1 $thickness=3.6e-08 $X=0.082
+ $Y=0.119 $X2=0.081 $Y2=0.1227
r13 17 6 1.57403 $w=1.3e-08 $l=6.8e-09 $layer=M1 $thickness=3.6e-08 $X=0.082
+ $Y=0.119 $X2=0.081 $Y2=0.1122
r14 1 12 10.4265 $w=1.765e-08 $layer=LIG $thickness=5.2e-08 $X=0.081 $Y=0.135
+ $X2=0.081 $Y2=0.135
r15 1 19 19.3796 $a=3.24e-16 $layer=V0LIG $X=0.081 $Y=0.135 $X2=0.081 $Y2=0.135
r16 15 14 14.6259 $w=2.1e-08 $l=4.3e-08 $layer=Gate_1 $thickness=5.6e-08
+ $X=0.081 $Y=0.216 $X2=0.081 $Y2=0.173
r17 13 14 7.31297 $w=2.1e-08 $l=2.15e-08 $layer=Gate_1 $thickness=5.6e-08
+ $X=0.081 $Y=0.1515 $X2=0.081 $Y2=0.173
r18 12 13 5.79936 $w=2.03333e-08 $l=1.65e-08 $layer=Gate_1 $thickness=5.6e-08
+ $X=0.081 $Y=0.135 $X2=0.081 $Y2=0.1515
r19 11 12 5.79936 $w=2.03333e-08 $l=1.65e-08 $layer=Gate_1 $thickness=5.6e-08
+ $X=0.081 $Y=0.1185 $X2=0.081 $Y2=0.135
r20 10 11 7.31297 $w=2.1e-08 $l=2.15e-08 $layer=Gate_1 $thickness=5.6e-08
+ $X=0.081 $Y=0.097 $X2=0.081 $Y2=0.1185
r21 9 10 14.6259 $w=2.1e-08 $l=4.3e-08 $layer=Gate_1 $thickness=5.6e-08
+ $X=0.081 $Y=0.054 $X2=0.081 $Y2=0.097
r22 9 3 10.0341 $w=2.1e-08 $l=2.95e-08 $layer=Gate_1 $thickness=5.6e-08
+ $X=0.081 $Y=0.054 $X2=0.081 $Y2=0.0245
.ends

.subckt PM_DFFHQx4_ASAP7_75t_R%15 vss 7 12 4 1 5
c1 1 vss 0.006321f $X=0.702 $Y=0.0405
c2 4 vss 0.00177422f $X=0.6875 $Y=0.0405
c3 5 vss 0.00217567f $X=0.758 $Y=0.0405
r1 12 11 0.0925926 $w=2.7e-08 $l=2.5e-09 $layer=N_src_drn $thickness=1e-09
+ $X=0.7733 $Y=0.0405 $X2=0.7705 $Y2=0.0405
r2 5 11 0.462963 $w=2.7e-08 $l=1.25e-08 $layer=N_src_drn $thickness=1e-09
+ $X=0.758 $Y=0.0405 $X2=0.7705 $Y2=0.0405
r3 9 5 8.23096 $w=2.32e-08 $l=1.75e-08 $layer=LISD $thickness=2.7e-08 $X=0.7385
+ $Y=0.0405 $X2=0.758 $Y2=0.0405
r4 8 9 7.05511 $w=2.32e-08 $l=1.5e-08 $layer=LISD $thickness=2.7e-08 $X=0.7235
+ $Y=0.0405 $X2=0.7385 $Y2=0.0405
r5 1 8 10.1123 $w=2.32e-08 $l=2.15e-08 $layer=LISD $thickness=2.7e-08 $X=0.702
+ $Y=0.0405 $X2=0.7235 $Y2=0.0405
r6 4 1 0.462963 $w=2.7e-08 $l=1.25e-08 $layer=N_src_drn $thickness=1e-09
+ $X=0.6875 $Y=0.0405 $X2=0.702 $Y2=0.0405
r7 7 4 0.0925926 $w=2.7e-08 $l=2.5e-09 $layer=N_src_drn $thickness=1e-09
+ $X=0.6846 $Y=0.0405 $X2=0.6875 $Y2=0.0405
.ends

.subckt PM_DFFHQx4_ASAP7_75t_R%16 vss 2 3 1
c1 1 vss 0.00056335f $X=0.486 $Y=0.0405
r1 2 1 0.62963 $w=2.7e-08 $l=1.7e-08 $layer=N_src_drn $thickness=1e-09
+ $X=0.4686 $Y=0.0405 $X2=0.486 $Y2=0.0405
r2 3 1 0.62963 $w=2.7e-08 $l=1.7e-08 $layer=N_src_drn $thickness=1e-09
+ $X=0.5033 $Y=0.0405 $X2=0.486 $Y2=0.0405
.ends

.subckt PM_DFFHQx4_ASAP7_75t_R%D vss 25 10 16 8 3 9 6 1 7 5
c1 1 vss 0.00941497f $X=0.2885 $Y=0.135
c2 3 vss 0.0907604f $X=0.297 $Y=0.0245
c3 4 vss 0.00669741f $X=0.243 $Y=0.036
c4 5 vss 0.000462204f $X=0.243 $Y=0.135
c5 6 vss 0.00645091f $X=0.243 $Y=0.234
c6 7 vss 0.00402766f $X=0.243 $Y=0.116
c7 8 vss 0.0029888f $X=0.243 $Y=0.1735
c8 9 vss 0.000929408f $X=0.2615 $Y=0.135
r1 6 27 3.48349 $w=1.525e-08 $l=2e-08 $layer=M1 $thickness=3.6e-08 $X=0.243
+ $Y=0.234 $X2=0.243 $Y2=0.214
r2 4 24 5.17411 $w=1.46514e-08 $l=2.72e-08 $layer=M1 $thickness=3.6e-08
+ $X=0.243 $Y=0.036 $X2=0.243 $Y2=0.0632
r3 8 27 9.44419 $w=1.3e-08 $l=4.05e-08 $layer=M1 $thickness=3.6e-08 $X=0.243
+ $Y=0.1735 $X2=0.243 $Y2=0.214
r4 25 26 2.85657 $w=1.3e-08 $l=1.22e-08 $layer=M1 $thickness=3.6e-08 $X=0.244
+ $Y=0.082 $X2=0.243 $Y2=0.0942
r5 25 24 4.37231 $w=1.3e-08 $l=1.88e-08 $layer=M1 $thickness=3.6e-08 $X=0.244
+ $Y=0.082 $X2=0.243 $Y2=0.0632
r6 7 26 5.07188 $w=1.3e-08 $l=2.18e-08 $layer=M1 $thickness=3.6e-08 $X=0.243
+ $Y=0.116 $X2=0.243 $Y2=0.0942
r7 5 9 3.1337 $w=1.54324e-08 $l=1.85e-08 $layer=M1 $thickness=3.6e-08 $X=0.243
+ $Y=0.135 $X2=0.2615 $Y2=0.135
r8 5 7 3.2503 $w=1.53684e-08 $l=1.9e-08 $layer=M1 $thickness=3.6e-08 $X=0.243
+ $Y=0.135 $X2=0.243 $Y2=0.116
r9 5 8 7.7975 $w=1.41688e-08 $l=3.85e-08 $layer=M1 $thickness=3.6e-08 $X=0.243
+ $Y=0.135 $X2=0.243 $Y2=0.1735
r10 22 23 2.2153 $w=1.3e-08 $l=9.5e-09 $layer=M1 $thickness=3.6e-08 $X=0.2715
+ $Y=0.135 $X2=0.281 $Y2=0.135
r11 9 22 2.3319 $w=1.3e-08 $l=1e-08 $layer=M1 $thickness=3.6e-08 $X=0.2615
+ $Y=0.135 $X2=0.2715 $Y2=0.135
r12 20 23 19.3796 $a=3.24e-16 $layer=V0LIG $X=0.2795 $Y=0.135 $X2=0.281
+ $Y2=0.135
r13 1 18 2.6116 $w=2.2e-08 $l=1e-08 $layer=LIG $thickness=4.8e-08 $X=0.2885
+ $Y=0.135 $X2=0.2985 $Y2=0.135
r14 1 20 4.82216 $w=1.64167e-08 $l=9e-09 $layer=LIG $thickness=4.8e-08
+ $X=0.2885 $Y=0.135 $X2=0.2795 $Y2=0.135
r15 16 15 14.6259 $w=2.1e-08 $l=4.3e-08 $layer=Gate_1 $thickness=5.6e-08
+ $X=0.297 $Y=0.2025 $X2=0.297 $Y2=0.1595
r16 14 15 2.7211 $w=2.1e-08 $l=8e-09 $layer=Gate_1 $thickness=5.6e-08 $X=0.297
+ $Y=0.1515 $X2=0.297 $Y2=0.1595
r17 13 14 5.79936 $w=2.03333e-08 $l=1.65e-08 $layer=Gate_1 $thickness=5.6e-08
+ $X=0.297 $Y=0.135 $X2=0.297 $Y2=0.1515
r18 13 18 6.14846 $w=2.08718e-08 $l=1.5e-09 $layer=Gate_1
+ $thickness=5.25128e-08 $X=0.297 $Y=0.135 $X2=0.2985 $Y2=0.135
r19 12 13 5.79936 $w=2.03333e-08 $l=1.65e-08 $layer=Gate_1 $thickness=5.6e-08
+ $X=0.297 $Y=0.1185 $X2=0.297 $Y2=0.135
r20 11 12 2.7211 $w=2.1e-08 $l=8e-09 $layer=Gate_1 $thickness=5.6e-08 $X=0.297
+ $Y=0.1105 $X2=0.297 $Y2=0.1185
r21 10 11 14.6259 $w=2.1e-08 $l=4.3e-08 $layer=Gate_1 $thickness=5.6e-08
+ $X=0.297 $Y=0.0675 $X2=0.297 $Y2=0.1105
r22 10 3 14.6259 $w=2.1e-08 $l=4.3e-08 $layer=Gate_1 $thickness=5.6e-08
+ $X=0.297 $Y=0.0675 $X2=0.297 $Y2=0.0245
.ends

.subckt PM_DFFHQx4_ASAP7_75t_R%17 vss 2 3 1
c1 1 vss 0.000755621f $X=0.324 $Y=0.2025
r1 2 1 0.209877 $w=8.1e-08 $l=1.7e-08 $layer=P_src_drn $thickness=1e-09
+ $X=0.3066 $Y=0.2025 $X2=0.324 $Y2=0.2025
r2 3 1 0.209877 $w=8.1e-08 $l=1.7e-08 $layer=P_src_drn $thickness=1e-09
+ $X=0.3413 $Y=0.2025 $X2=0.324 $Y2=0.2025
.ends

.subckt PM_DFFHQx4_ASAP7_75t_R%9 vss 19 23 35 45 9 18 3 4 1 17 12 15 16 11 10
c1 1 vss 0.0015388f $X=0.783 $Y=0.1055
c2 3 vss 0.00639271f $X=0.864 $Y=0.0405
c3 4 vss 0.00665759f $X=0.864 $Y=0.2295
c4 9 vss 0.0413703f $X=0.783 $Y=0.0245
c5 10 vss 0.0188548f $X=0.8495 $Y=0.0405
c6 11 vss 0.0187159f $X=0.8495 $Y=0.2295
c7 12 vss 0.00283168f $X=0.783 $Y=0.036
c8 13 vss 0.00369439f $X=0.945 $Y=0.036
c9 14 vss 0.00364617f $X=0.945 $Y=0.234
c10 15 vss 0.00218207f $X=0.783 $Y=0.0705
c11 16 vss 0.0138671f $X=0.81 $Y=0.036
c12 17 vss 0.0091401f $X=0.918 $Y=0.234
c13 18 vss 0.00879498f $X=0.945 $Y=0.081
r1 11 4 0.462963 $w=2.7e-08 $l=1.25e-08 $layer=P_src_drn $thickness=1e-09
+ $X=0.8495 $Y=0.2295 $X2=0.864 $Y2=0.2295
r2 45 11 0.0925926 $w=2.7e-08 $l=2.5e-09 $layer=P_src_drn $thickness=1e-09
+ $X=0.8466 $Y=0.2295 $X2=0.8495 $Y2=0.2295
r3 4 42 19.3796 $a=3.24e-16 $layer=V0LISD $X=0.864 $Y=0.2295 $X2=0.864 $Y2=0.234
r4 42 43 5.24677 $w=1.3e-08 $l=2.25e-08 $layer=M1 $thickness=3.6e-08 $X=0.864
+ $Y=0.234 $X2=0.8865 $Y2=0.234
r5 17 43 7.34548 $w=1.3e-08 $l=3.15e-08 $layer=M1 $thickness=3.6e-08 $X=0.918
+ $Y=0.234 $X2=0.8865 $Y2=0.234
r6 14 40 0.56619 $w=2.22842e-08 $l=9.5e-09 $layer=M1 $thickness=3.6e-08
+ $X=0.945 $Y=0.234 $X2=0.945 $Y2=0.2245
r7 14 17 4.64701 $w=1.46667e-08 $l=2.7e-08 $layer=M1 $thickness=3.6e-08
+ $X=0.945 $Y=0.234 $X2=0.918 $Y2=0.234
r8 39 40 6.29612 $w=1.3e-08 $l=2.7e-08 $layer=M1 $thickness=3.6e-08 $X=0.945
+ $Y=0.1975 $X2=0.945 $Y2=0.2245
r9 38 39 6.64591 $w=1.3e-08 $l=2.85e-08 $layer=M1 $thickness=3.6e-08 $X=0.945
+ $Y=0.169 $X2=0.945 $Y2=0.1975
r10 37 38 5.71315 $w=1.3e-08 $l=2.45e-08 $layer=M1 $thickness=3.6e-08 $X=0.945
+ $Y=0.1445 $X2=0.945 $Y2=0.169
r11 36 37 5.82974 $w=1.3e-08 $l=2.5e-08 $layer=M1 $thickness=3.6e-08 $X=0.945
+ $Y=0.1195 $X2=0.945 $Y2=0.1445
r12 18 36 8.97781 $w=1.3e-08 $l=3.85e-08 $layer=M1 $thickness=3.6e-08 $X=0.945
+ $Y=0.081 $X2=0.945 $Y2=0.1195
r13 10 3 0.462963 $w=2.7e-08 $l=1.25e-08 $layer=N_src_drn $thickness=1e-09
+ $X=0.8495 $Y=0.0405 $X2=0.864 $Y2=0.0405
r14 35 10 0.0925926 $w=2.7e-08 $l=2.5e-09 $layer=N_src_drn $thickness=1e-09
+ $X=0.8466 $Y=0.0405 $X2=0.8495 $Y2=0.0405
r15 13 33 4.64701 $w=1.46667e-08 $l=2.7e-08 $layer=M1 $thickness=3.6e-08
+ $X=0.945 $Y=0.036 $X2=0.918 $Y2=0.036
r16 13 18 8.84443 $w=1.496e-08 $l=4.5e-08 $layer=M1 $thickness=3.6e-08 $X=0.945
+ $Y=0.036 $X2=0.945 $Y2=0.081
r17 3 31 19.3796 $a=3.24e-16 $layer=V0LISD $X=0.864 $Y=0.0405 $X2=0.864
+ $Y2=0.036
r18 32 33 6.29612 $w=1.3e-08 $l=2.7e-08 $layer=M1 $thickness=3.6e-08 $X=0.891
+ $Y=0.036 $X2=0.918 $Y2=0.036
r19 31 32 6.29612 $w=1.3e-08 $l=2.7e-08 $layer=M1 $thickness=3.6e-08 $X=0.864
+ $Y=0.036 $X2=0.891 $Y2=0.036
r20 30 31 6.29612 $w=1.3e-08 $l=2.7e-08 $layer=M1 $thickness=3.6e-08 $X=0.837
+ $Y=0.036 $X2=0.864 $Y2=0.036
r21 16 30 6.29612 $w=1.3e-08 $l=2.7e-08 $layer=M1 $thickness=3.6e-08 $X=0.81
+ $Y=0.036 $X2=0.837 $Y2=0.036
r22 12 15 6.39593 $w=1.55565e-08 $l=3.45e-08 $layer=M1 $thickness=3.6e-08
+ $X=0.783 $Y=0.036 $X2=0.783 $Y2=0.0705
r23 12 16 4.64701 $w=1.46667e-08 $l=2.7e-08 $layer=M1 $thickness=3.6e-08
+ $X=0.783 $Y=0.036 $X2=0.81 $Y2=0.036
r24 15 27 8.04505 $w=1.3e-08 $l=3.45e-08 $layer=M1 $thickness=3.6e-08 $X=0.783
+ $Y=0.0705 $X2=0.783 $Y2=0.105
r25 1 21 6.4735 $w=2.13953e-08 $layer=Gate_1 $thickness=5.22791e-08 $X=0.783
+ $Y=0.1055 $X2=0.783 $Y2=0.1055
r26 1 27 19.3796 $a=3.24e-16 $layer=V0LIG $X=0.783 $Y=0.1055 $X2=0.783 $Y2=0.105
r27 23 22 21.4287 $w=2.1e-08 $l=6.3e-08 $layer=Gate_1 $thickness=5.6e-08
+ $X=0.783 $Y=0.2295 $X2=0.783 $Y2=0.1665
r28 21 22 20.944 $w=2.08115e-08 $l=6.1e-08 $layer=Gate_1 $thickness=5.6e-08
+ $X=0.783 $Y=0.1055 $X2=0.783 $Y2=0.1665
r29 20 21 10.9099 $w=2.06349e-08 $l=3.15e-08 $layer=Gate_1 $thickness=5.6e-08
+ $X=0.783 $Y=0.074 $X2=0.783 $Y2=0.1055
r30 19 20 11.3946 $w=2.1e-08 $l=3.35e-08 $layer=Gate_1 $thickness=5.6e-08
+ $X=0.783 $Y=0.0405 $X2=0.783 $Y2=0.074
r31 19 9 5.44221 $w=2.1e-08 $l=1.6e-08 $layer=Gate_1 $thickness=5.6e-08
+ $X=0.783 $Y=0.0405 $X2=0.783 $Y2=0.0245
.ends

.subckt PM_DFFHQx4_ASAP7_75t_R%18 vss 2 3 1
c1 1 vss 0.00058143f $X=0.756 $Y=0.2295
r1 2 1 0.62963 $w=2.7e-08 $l=1.7e-08 $layer=P_src_drn $thickness=1e-09
+ $X=0.7386 $Y=0.2295 $X2=0.756 $Y2=0.2295
r2 3 1 0.62963 $w=2.7e-08 $l=1.7e-08 $layer=P_src_drn $thickness=1e-09
+ $X=0.7733 $Y=0.2295 $X2=0.756 $Y2=0.2295
.ends

.subckt PM_DFFHQx4_ASAP7_75t_R%10 vss 32 38 77 78 81 85 88 91 95 96 5 24 6 15
+ 14 16 22 18 23 21 2 19 27 20 28 11 26 1 17 25 29 13 12
c1 1 vss 0.00172867f $X=0.837 $Y=0.135
c2 2 vss 0.00788792f $X=0.9895 $Y=0.136
c3 5 vss 0.00469853f $X=0.648 $Y=0.0405
c4 6 vss 0.00451629f $X=0.702 $Y=0.2295
c5 11 vss 0.0532786f $X=0.837 $Y=0.0245
c6 12 vss 0.0864512f $X=0.999 $Y=0.136
c7 13 vss 0.0812177f $X=1.053 $Y=0.136
c8 14 vss 0.00386726f $X=0.6335 $Y=0.0405
c9 15 vss 0.00398249f $X=0.6875 $Y=0.2295
c10 16 vss 0.00604599f $X=0.729 $Y=0.233
c11 17 vss 0.00264775f $X=0.729 $Y=0.036
c12 18 vss 0.000171213f $X=0.729 $Y=0.16
c13 19 vss 0.000302282f $X=0.837 $Y=0.162
c14 20 vss 0.00116163f $X=0.891 $Y=0.1575
c15 21 vss 0.00835784f $X=0.704 $Y=0.036
c16 22 vss 0.00175768f $X=0.729 $Y=0.136
c17 23 vss 0.00161077f $X=0.729 $Y=0.1975
c18 24 vss 0.00229901f $X=0.81 $Y=0.162
c19 25 vss 0.000771653f $X=0.837 $Y=0.118
c20 26 vss 0.000744185f $X=0.848 $Y=0.162
c21 27 vss 0.00113574f $X=0.891 $Y=0.1305
c22 28 vss 0.00211849f $X=0.999 $Y=0.1245
c23 29 vss 0.00811597f $X=0.8795 $Y=0.153
r1 96 94 0.0925926 $w=2.7e-08 $l=2.5e-09 $layer=N_src_drn $thickness=1e-09
+ $X=0.6653 $Y=0.0405 $X2=0.6625 $Y2=0.0405
r2 5 94 0.537037 $w=2.7e-08 $l=1.45e-08 $layer=N_src_drn $thickness=1e-09
+ $X=0.648 $Y=0.0405 $X2=0.6625 $Y2=0.0405
r3 14 5 0.537037 $w=2.7e-08 $l=1.45e-08 $layer=N_src_drn $thickness=1e-09
+ $X=0.6335 $Y=0.0405 $X2=0.648 $Y2=0.0405
r4 95 14 0.0925926 $w=2.7e-08 $l=2.5e-09 $layer=N_src_drn $thickness=1e-09
+ $X=0.6306 $Y=0.0405 $X2=0.6335 $Y2=0.0405
r5 91 90 16.3266 $w=2.1e-08 $l=4.8e-08 $layer=Gate_1 $thickness=5.6e-08
+ $X=1.053 $Y=0.2025 $X2=1.053 $Y2=0.1545
r6 88 89 16.6668 $w=2.1e-08 $l=4.9e-08 $layer=Gate_1 $thickness=5.6e-08
+ $X=1.053 $Y=0.0675 $X2=1.053 $Y2=0.1165
r7 13 71 6.54019 $w=2.09524e-08 $layer=Gate_1 $thickness=5.21905e-08 $X=1.053
+ $Y=0.136 $X2=1.053 $Y2=0.136
r8 13 89 6.81977 $w=2.04359e-08 $l=1.95e-08 $layer=Gate_1 $thickness=5.6e-08
+ $X=1.053 $Y=0.136 $X2=1.053 $Y2=0.1165
r9 13 90 6.47963 $w=2.04054e-08 $l=1.85e-08 $layer=Gate_1 $thickness=5.6e-08
+ $X=1.053 $Y=0.136 $X2=1.053 $Y2=0.1545
r10 85 84 14.6259 $w=2.1e-08 $l=4.3e-08 $layer=Gate_1 $thickness=5.6e-08
+ $X=0.999 $Y=0.2025 $X2=0.999 $Y2=0.1595
r11 83 84 2.55104 $w=2.1e-08 $l=7.5e-09 $layer=Gate_1 $thickness=5.6e-08
+ $X=0.999 $Y=0.152 $X2=0.999 $Y2=0.1595
r12 81 82 14.6259 $w=2.1e-08 $l=4.3e-08 $layer=Gate_1 $thickness=5.6e-08
+ $X=0.999 $Y=0.0675 $X2=0.999 $Y2=0.1105
r13 79 82 2.89117 $w=2.1e-08 $l=8.5e-09 $layer=Gate_1 $thickness=5.6e-08
+ $X=0.999 $Y=0.119 $X2=0.999 $Y2=0.1105
r14 12 67 6.27904 $w=2.09e-08 $layer=Gate_1 $thickness=5.24e-08 $X=0.999
+ $Y=0.136 $X2=0.999 $Y2=0.136
r15 12 79 5.96942 $w=2.03529e-08 $l=1.7e-08 $layer=Gate_1 $thickness=5.6e-08
+ $X=0.999 $Y=0.136 $X2=0.999 $Y2=0.119
r16 12 83 5.62929 $w=2.03125e-08 $l=1.6e-08 $layer=Gate_1 $thickness=5.6e-08
+ $X=0.999 $Y=0.136 $X2=0.999 $Y2=0.152
r17 78 76 0.0925926 $w=2.7e-08 $l=2.5e-09 $layer=P_src_drn $thickness=1e-09
+ $X=0.7193 $Y=0.2295 $X2=0.7165 $Y2=0.2295
r18 6 76 0.537037 $w=2.7e-08 $l=1.45e-08 $layer=P_src_drn $thickness=1e-09
+ $X=0.702 $Y=0.2295 $X2=0.7165 $Y2=0.2295
r19 15 6 0.537037 $w=2.7e-08 $l=1.45e-08 $layer=P_src_drn $thickness=1e-09
+ $X=0.6875 $Y=0.2295 $X2=0.702 $Y2=0.2295
r20 77 15 0.0925926 $w=2.7e-08 $l=2.5e-09 $layer=P_src_drn $thickness=1e-09
+ $X=0.6846 $Y=0.2295 $X2=0.6875 $Y2=0.2295
r21 5 65 19.3796 $a=3.24e-16 $layer=V0LISD $X=0.648 $Y=0.0405 $X2=0.648
+ $Y2=0.036
r22 70 71 12.6539 $w=1.77815e-08 $l=2.7e-08 $layer=LIG $thickness=4.8e-08
+ $X=1.026 $Y=0.136 $X2=1.053 $Y2=0.136
r23 68 70 10.1729 $w=1.54914e-08 $l=1.75e-08 $layer=LIG $thickness=4.8e-08
+ $X=1.0085 $Y=0.136 $X2=1.026 $Y2=0.136
r24 67 68 2.48102 $w=2.2e-08 $l=9.5e-09 $layer=LIG $thickness=4.8e-08 $X=0.999
+ $Y=0.136 $X2=1.0085 $Y2=0.136
r25 2 67 2.48102 $w=2.2e-08 $l=9.5e-09 $layer=LIG $thickness=4.8e-08 $X=0.9895
+ $Y=0.136 $X2=0.999 $Y2=0.136
r26 6 58 19.3796 $a=3.24e-16 $layer=V0LISD $X=0.702 $Y=0.2295 $X2=0.702
+ $Y2=0.233
r27 65 66 3.14806 $w=1.3e-08 $l=1.35e-08 $layer=M1 $thickness=3.6e-08 $X=0.648
+ $Y=0.036 $X2=0.6615 $Y2=0.036
r28 63 66 3.14806 $w=1.3e-08 $l=1.35e-08 $layer=M1 $thickness=3.6e-08 $X=0.675
+ $Y=0.036 $X2=0.6615 $Y2=0.036
r29 62 63 2.56509 $w=1.3e-08 $l=1.1e-08 $layer=M1 $thickness=3.6e-08 $X=0.686
+ $Y=0.036 $X2=0.675 $Y2=0.036
r30 21 62 4.19742 $w=1.3e-08 $l=1.8e-08 $layer=M1 $thickness=3.6e-08 $X=0.704
+ $Y=0.036 $X2=0.686 $Y2=0.036
r31 60 67 19.3796 $a=3.24e-16 $layer=V0LIG $X=0.999 $Y=0.1445 $X2=0.999
+ $Y2=0.136
r32 28 60 4.6638 $w=1.3e-08 $l=2e-08 $layer=M1 $thickness=3.6e-08 $X=0.999
+ $Y=0.1245 $X2=0.999 $Y2=0.1445
r33 58 59 3.14806 $w=1.3e-08 $l=1.35e-08 $layer=M1 $thickness=3.6e-08 $X=0.702
+ $Y=0.233 $X2=0.7155 $Y2=0.233
r34 16 23 7.09793 $w=1.42676e-08 $l=3.55e-08 $layer=M1 $thickness=3.6e-08
+ $X=0.729 $Y=0.233 $X2=0.729 $Y2=0.1975
r35 16 59 1.96775 $w=1.63333e-08 $l=1.35e-08 $layer=M1 $thickness=3.6e-08
+ $X=0.729 $Y=0.233 $X2=0.7155 $Y2=0.233
r36 17 51 4.64701 $w=1.62667e-08 $l=2.7e-08 $layer=M1 $thickness=3.6e-08
+ $X=0.729 $Y=0.036 $X2=0.729 $Y2=0.063
r37 17 21 4.18063 $w=1.48e-08 $l=2.5e-08 $layer=M1 $thickness=3.6e-08 $X=0.729
+ $Y=0.036 $X2=0.704 $Y2=0.036
r38 55 60 19.5347 $a=3.24e-16 $layer=V1 $X=0.999 $Y=0.153 $X2=0.999 $Y2=0.1445
r39 54 55 12.5922 $w=1.3e-08 $l=5.4e-08 $layer=M2 $thickness=3.6e-08 $X=0.945
+ $Y=0.153 $X2=0.999 $Y2=0.153
r40 53 54 12.5922 $w=1.3e-08 $l=5.4e-08 $layer=M2 $thickness=3.6e-08 $X=0.891
+ $Y=0.153 $X2=0.945 $Y2=0.153
r41 29 53 2.68168 $w=1.3e-08 $l=1.15e-08 $layer=M2 $thickness=3.6e-08 $X=0.8795
+ $Y=0.153 $X2=0.891 $Y2=0.153
r42 52 53 39.0693 $a=1.62e-16 $layer=V1 $X=0.891 $Y=0.1485 $X2=0.891 $Y2=0.153
r43 27 52 4.19742 $w=1.3e-08 $l=1.8e-08 $layer=M1 $thickness=3.6e-08 $X=0.891
+ $Y=0.1305 $X2=0.891 $Y2=0.1485
r44 23 46 6.38362 $w=1.33509e-08 $l=2.85e-08 $layer=M1 $thickness=3.6e-08
+ $X=0.729 $Y=0.1975 $X2=0.729 $Y2=0.169
r45 50 51 6.29612 $w=1.3e-08 $l=2.7e-08 $layer=M1 $thickness=3.6e-08 $X=0.729
+ $Y=0.09 $X2=0.729 $Y2=0.063
r46 49 50 2.3319 $w=1.3e-08 $l=1e-08 $layer=M1 $thickness=3.6e-08 $X=0.729
+ $Y=0.1 $X2=0.729 $Y2=0.09
r47 48 49 2.3319 $w=1.3e-08 $l=1e-08 $layer=M1 $thickness=3.6e-08 $X=0.729
+ $Y=0.11 $X2=0.729 $Y2=0.1
r48 22 48 6.06293 $w=1.3e-08 $l=2.6e-08 $layer=M1 $thickness=3.6e-08 $X=0.729
+ $Y=0.136 $X2=0.729 $Y2=0.11
r49 20 47 0.9184 $w=1.8e-08 $l=9e-09 $layer=M1 $thickness=3.6e-08 $X=0.891
+ $Y=0.1575 $X2=0.891 $Y2=0.1665
r50 20 52 1.50855 $w=1.55e-08 $l=9e-09 $layer=M1 $thickness=3.6e-08 $X=0.891
+ $Y=0.1575 $X2=0.891 $Y2=0.1485
r51 20 53 39.0693 $a=1.62e-16 $layer=V1 $X=0.891 $Y=0.1575 $X2=0.891 $Y2=0.153
r52 18 46 0.9184 $w=1.8e-08 $l=9e-09 $layer=M1 $thickness=3.6e-08 $X=0.729
+ $Y=0.16 $X2=0.729 $Y2=0.169
r53 18 22 4.67854 $w=1.44583e-08 $l=2.4e-08 $layer=M1 $thickness=3.6e-08
+ $X=0.729 $Y=0.16 $X2=0.729 $Y2=0.136
r54 45 47 4.19024 $w=1.156e-08 $l=2.54018e-08 $layer=M1 $thickness=3.6e-08
+ $X=0.866 $Y=0.162 $X2=0.891 $Y2=0.1665
r55 26 45 4.19742 $w=1.3e-08 $l=1.8e-08 $layer=M1 $thickness=3.6e-08 $X=0.848
+ $Y=0.162 $X2=0.866 $Y2=0.162
r56 44 46 4.4015 $w=1.35e-08 $l=2.78927e-08 $layer=M1 $thickness=3.6e-08
+ $X=0.756 $Y=0.162 $X2=0.729 $Y2=0.169
r57 43 44 6.29612 $w=1.3e-08 $l=2.7e-08 $layer=M1 $thickness=3.6e-08 $X=0.783
+ $Y=0.162 $X2=0.756 $Y2=0.162
r58 24 43 6.29612 $w=1.3e-08 $l=2.7e-08 $layer=M1 $thickness=3.6e-08 $X=0.81
+ $Y=0.162 $X2=0.783 $Y2=0.162
r59 19 42 4.88263 $w=1.47308e-08 $l=2.6e-08 $layer=M1 $thickness=3.6e-08
+ $X=0.837 $Y=0.162 $X2=0.837 $Y2=0.136
r60 19 24 5.11582 $w=1.46667e-08 $l=2.7e-08 $layer=M1 $thickness=3.6e-08
+ $X=0.837 $Y=0.162 $X2=0.81 $Y2=0.162
r61 19 26 1.38478 $w=1.70909e-08 $l=1.1e-08 $layer=M1 $thickness=3.6e-08
+ $X=0.837 $Y=0.162 $X2=0.848 $Y2=0.162
r62 25 42 4.19742 $w=1.3e-08 $l=1.8e-08 $layer=M1 $thickness=3.6e-08 $X=0.837
+ $Y=0.118 $X2=0.837 $Y2=0.136
r63 1 35 6.54019 $w=2.09524e-08 $layer=Gate_1 $thickness=5.21905e-08 $X=0.837
+ $Y=0.135 $X2=0.837 $Y2=0.135
r64 1 42 19.3796 $a=3.24e-16 $layer=V0LIG $X=0.837 $Y=0.135 $X2=0.837 $Y2=0.136
r65 38 37 14.6259 $w=2.1e-08 $l=4.3e-08 $layer=Gate_1 $thickness=5.6e-08
+ $X=0.837 $Y=0.2295 $X2=0.837 $Y2=0.1865
r66 36 37 11.9048 $w=2.1e-08 $l=3.5e-08 $layer=Gate_1 $thickness=5.6e-08
+ $X=0.837 $Y=0.1515 $X2=0.837 $Y2=0.1865
r67 35 36 5.79936 $w=2.03333e-08 $l=1.65e-08 $layer=Gate_1 $thickness=5.6e-08
+ $X=0.837 $Y=0.135 $X2=0.837 $Y2=0.1515
r68 34 35 5.79936 $w=2.03333e-08 $l=1.65e-08 $layer=Gate_1 $thickness=5.6e-08
+ $X=0.837 $Y=0.1185 $X2=0.837 $Y2=0.135
r69 33 34 11.9048 $w=2.1e-08 $l=3.5e-08 $layer=Gate_1 $thickness=5.6e-08
+ $X=0.837 $Y=0.0835 $X2=0.837 $Y2=0.1185
r70 32 33 14.6259 $w=2.1e-08 $l=4.3e-08 $layer=Gate_1 $thickness=5.6e-08
+ $X=0.837 $Y=0.0405 $X2=0.837 $Y2=0.0835
r71 32 11 5.44221 $w=2.1e-08 $l=1.6e-08 $layer=Gate_1 $thickness=5.6e-08
+ $X=0.837 $Y=0.0405 $X2=0.837 $Y2=0.0245
.ends

.subckt PM_DFFHQx4_ASAP7_75t_R%6 vss 32 79 81 83 87 92 7 6 23 21 20 18 3 4 22
+ 25 1 2 8 24 26 14 17 15 16 19
c1 1 vss 0.000919243f $X=0.351 $Y=0.135
c2 2 vss 7.66109e-20 $X=0.459 $Y=0.178
c3 3 vss 4.38504e-20 $X=0.621 $Y=0.178
c4 4 vss 0.00101913f $X=0.729 $Y=0.178
c5 6 vss 0.00761669f $X=0.162 $Y=0.054
c6 7 vss 0.00761566f $X=0.162 $Y=0.216
c7 8 vss 0.00485383f $X=0.501 $Y=0.178
c8 14 vss 0.00829969f $X=0.351 $Y=0.073
c9 15 vss 0.00695068f $X=0.459 $Y=0.178
c10 16 vss 0.00640251f $X=0.621 $Y=0.178
c11 17 vss 0.00784177f $X=0.729 $Y=0.178
c12 18 vss 0.0364084f $X=0.1475 $Y=0.054
c13 19 vss 0.0358989f $X=0.1475 $Y=0.216
c14 20 vss 0.00624556f $X=0.189 $Y=0.036
c15 21 vss 0.00599124f $X=0.189 $Y=0.234
c16 22 vss 0.00115425f $X=0.3375 $Y=0.135
c17 23 vss 0.00593367f $X=0.189 $Y=0.1735
c18 24 vss 0.00241839f $X=0.324 $Y=0.1555
c19 25 vss 0.00153076f $X=0.513 $Y=0.168
c20 26 vss 0.02789f $X=0.1775 $Y=0.189
r1 92 91 8.84359 $w=2.1e-08 $l=2.6e-08 $layer=Gate_1 $thickness=5.6e-08
+ $X=0.729 $Y=0.2295 $X2=0.729 $Y2=0.2035
r2 17 91 8.89461 $w=2.04902e-08 $l=2.55e-08 $layer=Gate_1 $thickness=5.6e-08
+ $X=0.729 $Y=0.178 $X2=0.729 $Y2=0.2035
r3 87 88 23.4695 $w=2.1e-08 $l=6.9e-08 $layer=Gate_1 $thickness=5.6e-08
+ $X=0.621 $Y=0.0405 $X2=0.621 $Y2=0.1095
r4 16 88 23.5205 $w=2.08102e-08 $l=6.85e-08 $layer=Gate_1 $thickness=5.6e-08
+ $X=0.621 $Y=0.178 $X2=0.621 $Y2=0.1095
r5 83 84 23.4695 $w=2.1e-08 $l=6.9e-08 $layer=Gate_1 $thickness=5.6e-08
+ $X=0.459 $Y=0.0405 $X2=0.459 $Y2=0.1095
r6 15 84 23.5205 $w=2.08102e-08 $l=6.85e-08 $layer=Gate_1 $thickness=5.6e-08
+ $X=0.459 $Y=0.178 $X2=0.459 $Y2=0.1095
r7 19 7 0.231482 $w=5.4e-08 $l=1.25e-08 $layer=P_src_drn $thickness=1e-09
+ $X=0.1475 $Y=0.216 $X2=0.162 $Y2=0.216
r8 81 19 0.0462963 $w=5.4e-08 $l=2.5e-09 $layer=P_src_drn $thickness=1e-09
+ $X=0.1446 $Y=0.216 $X2=0.1475 $Y2=0.216
r9 18 6 0.231482 $w=5.4e-08 $l=1.25e-08 $layer=N_src_drn $thickness=1e-09
+ $X=0.1475 $Y=0.054 $X2=0.162 $Y2=0.054
r10 79 18 0.0462963 $w=5.4e-08 $l=2.5e-09 $layer=N_src_drn $thickness=1e-09
+ $X=0.1446 $Y=0.054 $X2=0.1475 $Y2=0.054
r11 4 77 2.78395 $w=2.4e-08 $l=4e-09 $layer=LIG $thickness=4.8e-08 $X=0.729
+ $Y=0.178 $X2=0.725 $Y2=0.178
r12 4 17 7.42683 $w=2.2e-08 $layer=Gate_1 $thickness=5.2e-08 $X=0.729 $Y=0.178
+ $X2=0.729 $Y2=0.178
r13 3 72 10.3807 $w=2.30357e-08 $layer=LISD $thickness=3.675e-08 $X=0.621
+ $Y=0.178 $X2=0.621 $Y2=0.178
r14 3 16 7.42683 $w=2.2e-08 $layer=Gate_1 $thickness=5.2e-08 $X=0.621 $Y=0.178
+ $X2=0.621 $Y2=0.178
r15 2 68 2.78395 $w=2.4e-08 $l=5e-09 $layer=LIG $thickness=4.8e-08 $X=0.459
+ $Y=0.178 $X2=0.464 $Y2=0.178
r16 2 15 7.42683 $w=2.2e-08 $layer=Gate_1 $thickness=5.2e-08 $X=0.459 $Y=0.178
+ $X2=0.459 $Y2=0.178
r17 7 61 19.3796 $a=3.24e-16 $layer=V0LISD $X=0.162 $Y=0.216 $X2=0.1655
+ $Y2=0.234
r18 6 57 19.3796 $a=3.24e-16 $layer=V0LISD $X=0.162 $Y=0.054 $X2=0.1655
+ $Y2=0.036
r19 76 77 4.8113 $w=2.22e-08 $l=1.5e-09 $layer=LISD $thickness=2.7e-08
+ $X=0.7235 $Y=0.178 $X2=0.725 $Y2=0.178
r20 75 76 10.8887 $w=2.22e-08 $l=2.15e-08 $layer=LISD $thickness=2.7e-08
+ $X=0.702 $Y=0.178 $X2=0.7235 $Y2=0.178
r21 74 75 13.6742 $w=2.22e-08 $l=2.7e-08 $layer=LISD $thickness=2.7e-08
+ $X=0.675 $Y=0.178 $X2=0.702 $Y2=0.178
r22 73 74 13.6742 $w=2.22e-08 $l=2.7e-08 $layer=LISD $thickness=2.7e-08
+ $X=0.648 $Y=0.178 $X2=0.675 $Y2=0.178
r23 72 73 13.6742 $w=2.22e-08 $l=2.7e-08 $layer=LISD $thickness=2.7e-08
+ $X=0.621 $Y=0.178 $X2=0.648 $Y2=0.178
r24 71 72 13.6742 $w=2.22e-08 $l=2.7e-08 $layer=LISD $thickness=2.7e-08
+ $X=0.594 $Y=0.178 $X2=0.621 $Y2=0.178
r25 70 71 13.6742 $w=2.22e-08 $l=2.7e-08 $layer=LISD $thickness=2.7e-08
+ $X=0.567 $Y=0.178 $X2=0.594 $Y2=0.178
r26 69 70 13.6742 $w=2.22e-08 $l=2.7e-08 $layer=LISD $thickness=2.7e-08 $X=0.54
+ $Y=0.178 $X2=0.567 $Y2=0.178
r27 67 68 10.3823 $w=2.22e-08 $l=1.35e-08 $layer=LISD $thickness=2.7e-08
+ $X=0.4775 $Y=0.178 $X2=0.464 $Y2=0.178
r28 66 69 7.59679 $w=2.22e-08 $l=1.5e-08 $layer=LISD $thickness=2.7e-08
+ $X=0.525 $Y=0.178 $X2=0.54 $Y2=0.178
r29 65 66 6.07743 $w=2.22e-08 $l=1.2e-08 $layer=LISD $thickness=2.7e-08
+ $X=0.513 $Y=0.178 $X2=0.525 $Y2=0.178
r30 8 65 6.07743 $w=2.22e-08 $l=1.2e-08 $layer=LISD $thickness=2.7e-08 $X=0.501
+ $Y=0.178 $X2=0.513 $Y2=0.178
r31 8 67 11.9016 $w=2.22e-08 $l=2.35e-08 $layer=LISD $thickness=2.7e-08
+ $X=0.501 $Y=0.178 $X2=0.4775 $Y2=0.178
r32 61 62 2.3319 $w=1.3e-08 $l=1e-08 $layer=M1 $thickness=3.6e-08 $X=0.1655
+ $Y=0.234 $X2=0.1755 $Y2=0.234
r33 21 54 3.83327 $w=1.5093e-08 $l=2.15e-08 $layer=M1 $thickness=3.6e-08
+ $X=0.189 $Y=0.234 $X2=0.189 $Y2=0.2125
r34 21 62 1.96775 $w=1.63333e-08 $l=1.35e-08 $layer=M1 $thickness=3.6e-08
+ $X=0.189 $Y=0.234 $X2=0.1755 $Y2=0.234
r35 57 58 2.3319 $w=1.3e-08 $l=1e-08 $layer=M1 $thickness=3.6e-08 $X=0.1655
+ $Y=0.036 $X2=0.1755 $Y2=0.036
r36 20 53 3.83327 $w=1.5093e-08 $l=2.15e-08 $layer=M1 $thickness=3.6e-08
+ $X=0.189 $Y=0.036 $X2=0.189 $Y2=0.0575
r37 20 58 1.96775 $w=1.63333e-08 $l=1.35e-08 $layer=M1 $thickness=3.6e-08
+ $X=0.189 $Y=0.036 $X2=0.1755 $Y2=0.036
r38 55 65 19.3796 $a=3.24e-16 $layer=V0LISD $X=0.513 $Y=0.1845 $X2=0.513
+ $Y2=0.178
r39 25 55 3.84763 $w=1.3e-08 $l=1.65e-08 $layer=M1 $thickness=3.6e-08 $X=0.513
+ $Y=0.168 $X2=0.513 $Y2=0.1845
r40 52 53 7.11229 $w=1.3e-08 $l=3.05e-08 $layer=M1 $thickness=3.6e-08 $X=0.189
+ $Y=0.088 $X2=0.189 $Y2=0.0575
r41 51 52 11.3097 $w=1.3e-08 $l=4.85e-08 $layer=M1 $thickness=3.6e-08 $X=0.189
+ $Y=0.1365 $X2=0.189 $Y2=0.088
r42 50 54 3.14806 $w=1.3e-08 $l=1.35e-08 $layer=M1 $thickness=3.6e-08 $X=0.189
+ $Y=0.199 $X2=0.189 $Y2=0.2125
r43 49 50 2.3319 $w=1.3e-08 $l=1e-08 $layer=M1 $thickness=3.6e-08 $X=0.189
+ $Y=0.189 $X2=0.189 $Y2=0.199
r44 23 49 3.61444 $w=1.3e-08 $l=1.55e-08 $layer=M1 $thickness=3.6e-08 $X=0.189
+ $Y=0.1735 $X2=0.189 $Y2=0.189
r45 23 51 8.62802 $w=1.3e-08 $l=3.7e-08 $layer=M1 $thickness=3.6e-08 $X=0.189
+ $Y=0.1735 $X2=0.189 $Y2=0.1365
r46 47 55 19.5347 $a=3.24e-16 $layer=V1 $X=0.513 $Y=0.189 $X2=0.513 $Y2=0.1845
r47 46 47 22.0364 $w=1.3e-08 $l=9.45e-08 $layer=M2 $thickness=3.6e-08 $X=0.4185
+ $Y=0.189 $X2=0.513 $Y2=0.189
r48 45 46 22.0364 $w=1.3e-08 $l=9.45e-08 $layer=M2 $thickness=3.6e-08 $X=0.324
+ $Y=0.189 $X2=0.4185 $Y2=0.189
r49 44 45 15.7403 $w=1.3e-08 $l=6.75e-08 $layer=M2 $thickness=3.6e-08 $X=0.2565
+ $Y=0.189 $X2=0.324 $Y2=0.189
r50 43 44 15.7403 $w=1.3e-08 $l=6.75e-08 $layer=M2 $thickness=3.6e-08 $X=0.189
+ $Y=0.189 $X2=0.2565 $Y2=0.189
r51 43 49 19.5347 $a=3.24e-16 $layer=V1 $X=0.189 $Y=0.189 $X2=0.189 $Y2=0.189
r52 26 43 2.68168 $w=1.3e-08 $l=1.15e-08 $layer=M2 $thickness=3.6e-08 $X=0.1775
+ $Y=0.189 $X2=0.189 $Y2=0.189
r53 41 45 19.5347 $a=3.24e-16 $layer=V1 $X=0.324 $Y=0.189 $X2=0.324 $Y2=0.189
r54 40 41 3.61444 $w=1.3e-08 $l=1.55e-08 $layer=M1 $thickness=3.6e-08 $X=0.324
+ $Y=0.1735 $X2=0.324 $Y2=0.189
r55 24 38 3.60008 $w=1.51951e-08 $l=2.05e-08 $layer=M1 $thickness=3.6e-08
+ $X=0.324 $Y=0.1555 $X2=0.324 $Y2=0.135
r56 24 40 4.19742 $w=1.3e-08 $l=1.8e-08 $layer=M1 $thickness=3.6e-08 $X=0.324
+ $Y=0.1555 $X2=0.324 $Y2=0.1735
r57 22 36 3.14806 $w=1.3e-08 $l=1.35e-08 $layer=M1 $thickness=3.6e-08 $X=0.3375
+ $Y=0.135 $X2=0.351 $Y2=0.135
r58 22 38 1.96775 $w=1.63333e-08 $l=1.35e-08 $layer=M1 $thickness=3.6e-08
+ $X=0.3375 $Y=0.135 $X2=0.324 $Y2=0.135
r59 1 30 6.54019 $w=2.09524e-08 $layer=Gate_1 $thickness=5.21905e-08 $X=0.351
+ $Y=0.135 $X2=0.351 $Y2=0.135
r60 1 36 19.3796 $a=3.24e-16 $layer=V0LIG $X=0.351 $Y=0.135 $X2=0.351 $Y2=0.135
r61 32 31 16.4967 $w=2.1e-08 $l=4.85e-08 $layer=Gate_1 $thickness=5.6e-08
+ $X=0.351 $Y=0.2025 $X2=0.351 $Y2=0.154
r62 30 31 6.6497 $w=2.04211e-08 $l=1.9e-08 $layer=Gate_1 $thickness=5.6e-08
+ $X=0.351 $Y=0.135 $X2=0.351 $Y2=0.154
r63 14 30 21.2756 $w=2.08226e-08 $l=6.2e-08 $layer=Gate_1 $thickness=5.6e-08
+ $X=0.351 $Y=0.073 $X2=0.351 $Y2=0.135
.ends

.subckt PM_DFFHQx4_ASAP7_75t_R%7 vss 20 24 46 47 52 54 13 19 14 16 3 1 4 12 17
+ 11 10 18
c1 1 vss 0.00230382f $X=0.513 $Y=0.09
c2 3 vss 0.00487631f $X=0.594 $Y=0.0405
c3 4 vss 0.0084011f $X=0.594 $Y=0.2295
c4 10 vss 0.0524803f $X=0.513 $Y=0.0245
c5 11 vss 0.00402691f $X=0.5795 $Y=0.0405
c6 12 vss 0.00379547f $X=0.5795 $Y=0.2295
c7 13 vss 0.00342972f $X=0.65 $Y=0.2295
c8 14 vss 0.000541486f $X=0.594 $Y=0.09
c9 15 vss 0.00264667f $X=0.621 $Y=0.2335
c10 16 vss 0.00216433f $X=0.5 $Y=0.09
c11 17 vss 0.00402623f $X=0.5965 $Y=0.234
c12 18 vss 0.00195064f $X=0.594 $Y=0.054
c13 19 vss 0.00167076f $X=0.621 $Y=0.1
r1 54 53 0.0925926 $w=2.7e-08 $l=2.5e-09 $layer=P_src_drn $thickness=1e-09
+ $X=0.6653 $Y=0.2295 $X2=0.6625 $Y2=0.2295
r2 13 53 0.462963 $w=2.7e-08 $l=1.25e-08 $layer=P_src_drn $thickness=1e-09
+ $X=0.65 $Y=0.2295 $X2=0.6625 $Y2=0.2295
r3 12 4 0.462963 $w=2.7e-08 $l=1.25e-08 $layer=P_src_drn $thickness=1e-09
+ $X=0.5795 $Y=0.2295 $X2=0.594 $Y2=0.2295
r4 52 12 0.0925926 $w=2.7e-08 $l=2.5e-09 $layer=P_src_drn $thickness=1e-09
+ $X=0.5766 $Y=0.2295 $X2=0.5795 $Y2=0.2295
r5 49 13 12.6992 $w=2.32e-08 $l=2.7e-08 $layer=LISD $thickness=2.7e-08 $X=0.621
+ $Y=0.2295 $X2=0.65 $Y2=0.2295
r6 4 49 12.6992 $w=2.32e-08 $l=2.7e-08 $layer=LISD $thickness=2.7e-08 $X=0.594
+ $Y=0.2295 $X2=0.621 $Y2=0.2295
r7 4 17 19.3796 $a=3.24e-16 $layer=V0LISD $X=0.594 $Y=0.2295 $X2=0.5965
+ $Y2=0.234
r8 47 45 0.0925926 $w=2.7e-08 $l=2.5e-09 $layer=N_src_drn $thickness=1e-09
+ $X=0.6113 $Y=0.0405 $X2=0.6085 $Y2=0.0405
r9 3 45 0.537037 $w=2.7e-08 $l=1.45e-08 $layer=N_src_drn $thickness=1e-09
+ $X=0.594 $Y=0.0405 $X2=0.6085 $Y2=0.0405
r10 11 3 0.537037 $w=2.7e-08 $l=1.45e-08 $layer=N_src_drn $thickness=1e-09
+ $X=0.5795 $Y=0.0405 $X2=0.594 $Y2=0.0405
r11 46 11 0.0925926 $w=2.7e-08 $l=2.5e-09 $layer=N_src_drn $thickness=1e-09
+ $X=0.5766 $Y=0.0405 $X2=0.5795 $Y2=0.0405
r12 15 40 0.983973 $w=1.77222e-08 $l=9e-09 $layer=M1 $thickness=3.6e-08
+ $X=0.621 $Y=0.2335 $X2=0.621 $Y2=0.2245
r13 15 17 4.48182 $w=1.47708e-08 $l=2.45051e-08 $layer=M1 $thickness=3.6e-08
+ $X=0.621 $Y=0.2335 $X2=0.5965 $Y2=0.234
r14 3 18 19.3796 $a=3.24e-16 $layer=V0LISD $X=0.594 $Y=0.0405 $X2=0.594
+ $Y2=0.054
r15 39 40 2.56509 $w=1.3e-08 $l=1.1e-08 $layer=M1 $thickness=3.6e-08 $X=0.621
+ $Y=0.2135 $X2=0.621 $Y2=0.2245
r16 38 39 6.64591 $w=1.3e-08 $l=2.85e-08 $layer=M1 $thickness=3.6e-08 $X=0.621
+ $Y=0.185 $X2=0.621 $Y2=0.2135
r17 37 38 4.43061 $w=1.3e-08 $l=1.9e-08 $layer=M1 $thickness=3.6e-08 $X=0.621
+ $Y=0.166 $X2=0.621 $Y2=0.185
r18 36 37 3.14806 $w=1.3e-08 $l=1.35e-08 $layer=M1 $thickness=3.6e-08 $X=0.621
+ $Y=0.1525 $X2=0.621 $Y2=0.166
r19 35 36 5.01358 $w=1.3e-08 $l=2.15e-08 $layer=M1 $thickness=3.6e-08 $X=0.621
+ $Y=0.131 $X2=0.621 $Y2=0.1525
r20 34 35 4.5472 $w=1.3e-08 $l=1.95e-08 $layer=M1 $thickness=3.6e-08 $X=0.621
+ $Y=0.1115 $X2=0.621 $Y2=0.131
r21 19 32 1.15159 $w=1.75e-08 $l=1e-08 $layer=M1 $thickness=3.6e-08 $X=0.621
+ $Y=0.1 $X2=0.621 $Y2=0.09
r22 19 34 2.68168 $w=1.3e-08 $l=1.15e-08 $layer=M1 $thickness=3.6e-08 $X=0.621
+ $Y=0.1 $X2=0.621 $Y2=0.1115
r23 18 33 4.19742 $w=1.3e-08 $l=1.8e-08 $layer=M1 $thickness=3.6e-08 $X=0.594
+ $Y=0.054 $X2=0.594 $Y2=0.072
r24 31 32 1.96775 $w=1.63333e-08 $l=1.35e-08 $layer=M1 $thickness=3.6e-08
+ $X=0.6075 $Y=0.09 $X2=0.621 $Y2=0.09
r25 14 30 1.38478 $w=1.70909e-08 $l=1.1e-08 $layer=M1 $thickness=3.6e-08
+ $X=0.594 $Y=0.09 $X2=0.583 $Y2=0.09
r26 14 31 1.96775 $w=1.63333e-08 $l=1.35e-08 $layer=M1 $thickness=3.6e-08
+ $X=0.594 $Y=0.09 $X2=0.6075 $Y2=0.09
r27 14 33 3.01711 $w=1.55e-08 $l=1.8e-08 $layer=M1 $thickness=3.6e-08 $X=0.594
+ $Y=0.09 $X2=0.594 $Y2=0.072
r28 29 30 7.34548 $w=1.3e-08 $l=3.15e-08 $layer=M1 $thickness=3.6e-08 $X=0.5515
+ $Y=0.09 $X2=0.583 $Y2=0.09
r29 28 29 8.97781 $w=1.3e-08 $l=3.85e-08 $layer=M1 $thickness=3.6e-08 $X=0.513
+ $Y=0.09 $X2=0.5515 $Y2=0.09
r30 16 28 3.03147 $w=1.3e-08 $l=1.3e-08 $layer=M1 $thickness=3.6e-08 $X=0.5
+ $Y=0.09 $X2=0.513 $Y2=0.09
r31 1 22 6.54019 $w=2.09524e-08 $layer=Gate_1 $thickness=5.21905e-08 $X=0.513
+ $Y=0.09 $X2=0.513 $Y2=0.09
r32 1 28 19.3796 $a=3.24e-16 $layer=V0LIG $X=0.513 $Y=0.09 $X2=0.513 $Y2=0.09
r33 24 23 24.1498 $w=2.1e-08 $l=7.1e-08 $layer=Gate_1 $thickness=5.6e-08
+ $X=0.513 $Y=0.2295 $X2=0.513 $Y2=0.1585
r34 22 23 23.4865 $w=2.08394e-08 $l=6.85e-08 $layer=Gate_1 $thickness=5.6e-08
+ $X=0.513 $Y=0.09 $X2=0.513 $Y2=0.1585
r35 21 22 8.18032 $w=2.05319e-08 $l=2.35e-08 $layer=Gate_1 $thickness=5.6e-08
+ $X=0.513 $Y=0.0665 $X2=0.513 $Y2=0.09
r36 20 21 8.84359 $w=2.1e-08 $l=2.6e-08 $layer=Gate_1 $thickness=5.6e-08
+ $X=0.513 $Y=0.0405 $X2=0.513 $Y2=0.0665
r37 20 10 5.44221 $w=2.1e-08 $l=1.6e-08 $layer=Gate_1 $thickness=5.6e-08
+ $X=0.513 $Y=0.0405 $X2=0.513 $Y2=0.0245
.ends

.subckt PM_DFFHQx4_ASAP7_75t_R%8 vss 21 25 53 56 62 65 11 19 13 14 3 4 18 10 15
+ 20 12 16 1 17 9
c1 1 vss 0.000437323f $X=0.567 $Y=0.1305
c2 3 vss 0.00512496f $X=0.378 $Y=0.2295
c3 4 vss 0.00477933f $X=0.432 $Y=0.0405
c4 9 vss 0.0387023f $X=0.567 $Y=0.0245
c5 10 vss 0.00195549f $X=0.4175 $Y=0.0405
c6 11 vss 0.000321672f $X=0.4175 $Y=0.081
c7 12 vss 0.00223638f $X=0.3635 $Y=0.2295
c8 13 vss 0.000384616f $X=0.3635 $Y=0.189
c9 14 vss 0.00600037f $X=0.459 $Y=0.036
c10 15 vss 1.31668e-20 $X=0.459 $Y=0.131
c11 16 vss 0.00259937f $X=0.459 $Y=0.234
c12 17 vss 0.00706587f $X=0.434 $Y=0.234
c13 18 vss 0.00128246f $X=0.459 $Y=0.114
c14 19 vss 0.000587616f $X=0.459 $Y=0.1525
c15 20 vss 0.00083924f $X=0.54 $Y=0.131
r1 13 3 0.231482 $w=5.4e-08 $l=1.25e-08 $layer=P_src_drn $thickness=1e-09
+ $X=0.3635 $Y=0.189 $X2=0.378 $Y2=0.2295
r2 65 64 0.0925926 $w=2.7e-08 $l=2.5e-09 $layer=P_src_drn $thickness=1e-09
+ $X=0.3953 $Y=0.2295 $X2=0.3925 $Y2=0.2295
r3 63 64 0.166667 $w=2.7e-08 $l=4.5e-09 $layer=P_src_drn $thickness=1e-09
+ $X=0.388 $Y=0.2295 $X2=0.3925 $Y2=0.2295
r4 3 63 0.444445 $w=2.7e-08 $l=1.2e-08 $layer=P_src_drn $thickness=1e-09
+ $X=0.378 $Y=0.2295 $X2=0.388 $Y2=0.2295
r5 12 3 0.462963 $w=2.7e-08 $l=1.25e-08 $layer=P_src_drn $thickness=1e-09
+ $X=0.3635 $Y=0.2295 $X2=0.378 $Y2=0.2295
r6 62 12 0.0925926 $w=2.7e-08 $l=2.5e-09 $layer=P_src_drn $thickness=1e-09
+ $X=0.3606 $Y=0.2025 $X2=0.3635 $Y2=0.2295
r7 3 49 19.3796 $a=3.24e-16 $layer=V0LISD $X=0.378 $Y=0.2295 $X2=0.378 $Y2=0.234
r8 11 4 0.231482 $w=5.4e-08 $l=1.25e-08 $layer=N_src_drn $thickness=1e-09
+ $X=0.4175 $Y=0.081 $X2=0.432 $Y2=0.0405
r9 56 55 0.0925926 $w=2.7e-08 $l=2.5e-09 $layer=N_src_drn $thickness=1e-09
+ $X=0.4493 $Y=0.0405 $X2=0.4465 $Y2=0.0405
r10 54 55 0.166667 $w=2.7e-08 $l=4.5e-09 $layer=N_src_drn $thickness=1e-09
+ $X=0.442 $Y=0.0405 $X2=0.4465 $Y2=0.0405
r11 4 54 0.444445 $w=2.7e-08 $l=1.2e-08 $layer=N_src_drn $thickness=1e-09
+ $X=0.432 $Y=0.0405 $X2=0.442 $Y2=0.0405
r12 10 4 0.462963 $w=2.7e-08 $l=1.25e-08 $layer=N_src_drn $thickness=1e-09
+ $X=0.4175 $Y=0.0405 $X2=0.432 $Y2=0.0405
r13 53 10 0.0925926 $w=2.7e-08 $l=2.5e-09 $layer=N_src_drn $thickness=1e-09
+ $X=0.4146 $Y=0.0675 $X2=0.4175 $Y2=0.0405
r14 49 50 3.14806 $w=1.3e-08 $l=1.35e-08 $layer=M1 $thickness=3.6e-08 $X=0.378
+ $Y=0.234 $X2=0.3915 $Y2=0.234
r15 47 50 3.14806 $w=1.3e-08 $l=1.35e-08 $layer=M1 $thickness=3.6e-08 $X=0.405
+ $Y=0.234 $X2=0.3915 $Y2=0.234
r16 46 47 2.56509 $w=1.3e-08 $l=1.1e-08 $layer=M1 $thickness=3.6e-08 $X=0.416
+ $Y=0.234 $X2=0.405 $Y2=0.234
r17 17 46 4.19742 $w=1.3e-08 $l=1.8e-08 $layer=M1 $thickness=3.6e-08 $X=0.434
+ $Y=0.234 $X2=0.416 $Y2=0.234
r18 4 41 19.3796 $a=3.24e-16 $layer=V0LISD $X=0.432 $Y=0.0405 $X2=0.432
+ $Y2=0.036
r19 16 39 3.01468 $w=1.741e-08 $l=2e-08 $layer=M1 $thickness=3.6e-08 $X=0.459
+ $Y=0.234 $X2=0.459 $Y2=0.214
r20 16 17 4.18063 $w=1.48e-08 $l=2.5e-08 $layer=M1 $thickness=3.6e-08 $X=0.459
+ $Y=0.234 $X2=0.434 $Y2=0.234
r21 41 42 3.14806 $w=1.3e-08 $l=1.35e-08 $layer=M1 $thickness=3.6e-08 $X=0.432
+ $Y=0.036 $X2=0.4455 $Y2=0.036
r22 14 36 5.11582 $w=1.46667e-08 $l=2.7e-08 $layer=M1 $thickness=3.6e-08
+ $X=0.459 $Y=0.036 $X2=0.459 $Y2=0.063
r23 14 42 1.96775 $w=1.63333e-08 $l=1.35e-08 $layer=M1 $thickness=3.6e-08
+ $X=0.459 $Y=0.036 $X2=0.4455 $Y2=0.036
r24 38 39 6.7625 $w=1.3e-08 $l=2.9e-08 $layer=M1 $thickness=3.6e-08 $X=0.459
+ $Y=0.185 $X2=0.459 $Y2=0.214
r25 37 38 4.43061 $w=1.3e-08 $l=1.9e-08 $layer=M1 $thickness=3.6e-08 $X=0.459
+ $Y=0.166 $X2=0.459 $Y2=0.185
r26 19 37 3.14806 $w=1.3e-08 $l=1.35e-08 $layer=M1 $thickness=3.6e-08 $X=0.459
+ $Y=0.1525 $X2=0.459 $Y2=0.166
r27 35 36 6.29612 $w=1.3e-08 $l=2.7e-08 $layer=M1 $thickness=3.6e-08 $X=0.459
+ $Y=0.09 $X2=0.459 $Y2=0.063
r28 34 35 2.91487 $w=1.3e-08 $l=1.25e-08 $layer=M1 $thickness=3.6e-08 $X=0.459
+ $Y=0.1025 $X2=0.459 $Y2=0.09
r29 18 34 2.68168 $w=1.3e-08 $l=1.15e-08 $layer=M1 $thickness=3.6e-08 $X=0.459
+ $Y=0.114 $X2=0.459 $Y2=0.1025
r30 15 32 4.18306 $w=1.49565e-08 $l=2.3e-08 $layer=M1 $thickness=3.6e-08
+ $X=0.459 $Y=0.131 $X2=0.482 $Y2=0.131
r31 15 18 2.78392 $w=1.56471e-08 $l=1.7e-08 $layer=M1 $thickness=3.6e-08
+ $X=0.459 $Y=0.131 $X2=0.459 $Y2=0.114
r32 15 19 3.83327 $w=1.5093e-08 $l=2.15e-08 $layer=M1 $thickness=3.6e-08
+ $X=0.459 $Y=0.131 $X2=0.459 $Y2=0.1525
r33 31 32 4.19742 $w=1.3e-08 $l=1.8e-08 $layer=M1 $thickness=3.6e-08 $X=0.5
+ $Y=0.131 $X2=0.482 $Y2=0.131
r34 30 31 3.03147 $w=1.3e-08 $l=1.3e-08 $layer=M1 $thickness=3.6e-08 $X=0.513
+ $Y=0.131 $X2=0.5 $Y2=0.131
r35 20 29 6.29612 $w=1.3e-08 $l=2.7e-08 $layer=M1 $thickness=3.6e-08 $X=0.54
+ $Y=0.131 $X2=0.567 $Y2=0.131
r36 20 30 6.29612 $w=1.3e-08 $l=2.7e-08 $layer=M1 $thickness=3.6e-08 $X=0.54
+ $Y=0.131 $X2=0.513 $Y2=0.131
r37 1 23 6.4735 $w=2.13953e-08 $layer=Gate_1 $thickness=5.22791e-08 $X=0.567
+ $Y=0.1305 $X2=0.567 $Y2=0.1305
r38 1 29 19.3796 $a=3.24e-16 $layer=V0LIG $X=0.567 $Y=0.1305 $X2=0.567 $Y2=0.131
r39 25 24 17.177 $w=2.1e-08 $l=5.05e-08 $layer=Gate_1 $thickness=5.6e-08
+ $X=0.567 $Y=0.2295 $X2=0.567 $Y2=0.179
r40 23 24 16.6923 $w=2.07629e-08 $l=4.85e-08 $layer=Gate_1 $thickness=5.6e-08
+ $X=0.567 $Y=0.1305 $X2=0.567 $Y2=0.179
r41 22 23 15.1617 $w=2.07386e-08 $l=4.4e-08 $layer=Gate_1 $thickness=5.6e-08
+ $X=0.567 $Y=0.0865 $X2=0.567 $Y2=0.1305
r42 21 22 15.6464 $w=2.1e-08 $l=4.6e-08 $layer=Gate_1 $thickness=5.6e-08
+ $X=0.567 $Y=0.0405 $X2=0.567 $Y2=0.0865
r43 21 9 5.44221 $w=2.1e-08 $l=1.6e-08 $layer=Gate_1 $thickness=5.6e-08
+ $X=0.567 $Y=0.0405 $X2=0.567 $Y2=0.0245
.ends

.subckt PM_DFFHQx4_ASAP7_75t_R%14 vss 7 12 4 1 5
c1 1 vss 0.00589573f $X=0.432 $Y=0.2295
c2 4 vss 0.00164739f $X=0.4175 $Y=0.2295
c3 5 vss 0.00204382f $X=0.488 $Y=0.2295
r1 12 11 0.0925926 $w=2.7e-08 $l=2.5e-09 $layer=P_src_drn $thickness=1e-09
+ $X=0.5033 $Y=0.2295 $X2=0.5005 $Y2=0.2295
r2 5 11 0.462963 $w=2.7e-08 $l=1.25e-08 $layer=P_src_drn $thickness=1e-09
+ $X=0.488 $Y=0.2295 $X2=0.5005 $Y2=0.2295
r3 9 5 9.64198 $w=2.32e-08 $l=2.05e-08 $layer=LISD $thickness=2.7e-08 $X=0.4655
+ $Y=0.2295 $X2=0.488 $Y2=0.2295
r4 8 9 7.05511 $w=2.32e-08 $l=1.5e-08 $layer=LISD $thickness=2.7e-08 $X=0.4505
+ $Y=0.2295 $X2=0.4655 $Y2=0.2295
r5 1 8 8.7013 $w=2.32e-08 $l=1.85e-08 $layer=LISD $thickness=2.7e-08 $X=0.432
+ $Y=0.2295 $X2=0.4505 $Y2=0.2295
r6 4 1 0.462963 $w=2.7e-08 $l=1.25e-08 $layer=P_src_drn $thickness=1e-09
+ $X=0.4175 $Y=0.2295 $X2=0.432 $Y2=0.2295
r7 7 4 0.0925926 $w=2.7e-08 $l=2.5e-09 $layer=P_src_drn $thickness=1e-09
+ $X=0.4146 $Y=0.2295 $X2=0.4175 $Y2=0.2295
.ends

.subckt PM_DFFHQx4_ASAP7_75t_R%11 vss 23 27 40 43 50 53 57 61 73 74 77 78 14 18
+ 19 20 21 4 13 9 3 1 10 15 17 11 22 12
c1 1 vss 0.0174395f $X=1.107 $Y=0.136
c2 3 vss 0.00964545f $X=1.026 $Y=0.0675
c3 4 vss 0.0102658f $X=1.026 $Y=0.2025
c4 9 vss 0.0804332f $X=1.107 $Y=0.0245
c5 10 vss 0.0804618f $X=1.161 $Y=0.136
c6 11 vss 0.0807088f $X=1.215 $Y=0.136
c7 12 vss 0.0926135f $X=1.269 $Y=0.136
c8 13 vss 0.0119824f $X=1.0115 $Y=0.0675
c9 14 vss 0.011909f $X=1.0115 $Y=0.2025
c10 15 vss 0.00279097f $X=1.089 $Y=0.036
c11 16 vss 0.000240432f $X=1.089 $Y=0.136
c12 17 vss 0.0027907f $X=1.089 $Y=0.234
c13 18 vss 0.00900773f $X=1.0145 $Y=0.036
c14 19 vss 0.00889577f $X=1.0145 $Y=0.234
c15 20 vss 0.00489307f $X=1.089 $Y=0.1245
c16 21 vss 0.00425474f $X=1.089 $Y=0.156
c17 22 vss 0.00351852f $X=1.1475 $Y=0.136
r1 78 76 0.0308642 $w=8.1e-08 $l=2.5e-09 $layer=P_src_drn $thickness=1e-09
+ $X=1.0433 $Y=0.2025 $X2=1.0405 $Y2=0.2025
r2 4 76 0.179012 $w=8.1e-08 $l=1.45e-08 $layer=P_src_drn $thickness=1e-09
+ $X=1.026 $Y=0.2025 $X2=1.0405 $Y2=0.2025
r3 14 4 0.179012 $w=8.1e-08 $l=1.45e-08 $layer=P_src_drn $thickness=1e-09
+ $X=1.0115 $Y=0.2025 $X2=1.026 $Y2=0.2025
r4 77 14 0.0308642 $w=8.1e-08 $l=2.5e-09 $layer=P_src_drn $thickness=1e-09
+ $X=1.0086 $Y=0.2025 $X2=1.0115 $Y2=0.2025
r5 74 72 0.0308642 $w=8.1e-08 $l=2.5e-09 $layer=N_src_drn $thickness=1e-09
+ $X=1.0433 $Y=0.0675 $X2=1.0405 $Y2=0.0675
r6 3 72 0.179012 $w=8.1e-08 $l=1.45e-08 $layer=N_src_drn $thickness=1e-09
+ $X=1.026 $Y=0.0675 $X2=1.0405 $Y2=0.0675
r7 13 3 0.179012 $w=8.1e-08 $l=1.45e-08 $layer=N_src_drn $thickness=1e-09
+ $X=1.0115 $Y=0.0675 $X2=1.026 $Y2=0.0675
r8 73 13 0.0308642 $w=8.1e-08 $l=2.5e-09 $layer=N_src_drn $thickness=1e-09
+ $X=1.0086 $Y=0.0675 $X2=1.0115 $Y2=0.0675
r9 4 69 19.3796 $a=3.24e-16 $layer=V0LISD $X=1.026 $Y=0.2025 $X2=1.026 $Y2=0.234
r10 3 67 19.3796 $a=3.24e-16 $layer=V0LISD $X=1.026 $Y=0.0675 $X2=1.026
+ $Y2=0.036
r11 69 70 7.34548 $w=1.3e-08 $l=3.15e-08 $layer=M1 $thickness=3.6e-08 $X=1.026
+ $Y=0.234 $X2=1.0575 $Y2=0.234
r12 19 69 2.68168 $w=1.3e-08 $l=1.15e-08 $layer=M1 $thickness=3.6e-08 $X=1.0145
+ $Y=0.234 $X2=1.026 $Y2=0.234
r13 67 68 7.34548 $w=1.3e-08 $l=3.15e-08 $layer=M1 $thickness=3.6e-08 $X=1.026
+ $Y=0.036 $X2=1.0575 $Y2=0.036
r14 18 67 2.68168 $w=1.3e-08 $l=1.15e-08 $layer=M1 $thickness=3.6e-08 $X=1.0145
+ $Y=0.036 $X2=1.026 $Y2=0.036
r15 17 66 3.24787 $w=1.72e-08 $l=2.1e-08 $layer=M1 $thickness=3.6e-08 $X=1.089
+ $Y=0.234 $X2=1.089 $Y2=0.213
r16 17 70 5.69637 $w=1.44286e-08 $l=3.15e-08 $layer=M1 $thickness=3.6e-08
+ $X=1.089 $Y=0.234 $X2=1.0575 $Y2=0.234
r17 15 64 3.24787 $w=1.72e-08 $l=2.1e-08 $layer=M1 $thickness=3.6e-08 $X=1.089
+ $Y=0.036 $X2=1.089 $Y2=0.057
r18 15 68 5.69637 $w=1.44286e-08 $l=3.15e-08 $layer=M1 $thickness=3.6e-08
+ $X=1.089 $Y=0.036 $X2=1.0575 $Y2=0.036
r19 65 66 6.7625 $w=1.3e-08 $l=2.9e-08 $layer=M1 $thickness=3.6e-08 $X=1.089
+ $Y=0.184 $X2=1.089 $Y2=0.213
r20 21 65 6.52931 $w=1.3e-08 $l=2.8e-08 $layer=M1 $thickness=3.6e-08 $X=1.089
+ $Y=0.156 $X2=1.089 $Y2=0.184
r21 63 64 8.97781 $w=1.3e-08 $l=3.85e-08 $layer=M1 $thickness=3.6e-08 $X=1.089
+ $Y=0.0955 $X2=1.089 $Y2=0.057
r22 20 63 6.7625 $w=1.3e-08 $l=2.9e-08 $layer=M1 $thickness=3.6e-08 $X=1.089
+ $Y=0.1245 $X2=1.089 $Y2=0.0955
r23 16 48 4.06646 $w=1.5e-08 $l=2.25e-08 $layer=M1 $thickness=3.6e-08 $X=1.089
+ $Y=0.136 $X2=1.1115 $Y2=0.136
r24 16 20 1.50137 $w=1.6913e-08 $l=1.15e-08 $layer=M1 $thickness=3.6e-08
+ $X=1.089 $Y=0.136 $X2=1.089 $Y2=0.1245
r25 16 21 3.48349 $w=1.525e-08 $l=2e-08 $layer=M1 $thickness=3.6e-08 $X=1.089
+ $Y=0.136 $X2=1.089 $Y2=0.156
r26 61 60 14.6259 $w=2.1e-08 $l=4.3e-08 $layer=Gate_1 $thickness=5.6e-08
+ $X=1.269 $Y=0.2025 $X2=1.269 $Y2=0.1595
r27 59 60 2.55104 $w=2.1e-08 $l=7.5e-09 $layer=Gate_1 $thickness=5.6e-08
+ $X=1.269 $Y=0.152 $X2=1.269 $Y2=0.1595
r28 57 58 14.6259 $w=2.1e-08 $l=4.3e-08 $layer=Gate_1 $thickness=5.6e-08
+ $X=1.269 $Y=0.0675 $X2=1.269 $Y2=0.1105
r29 55 58 2.89117 $w=2.1e-08 $l=8.5e-09 $layer=Gate_1 $thickness=5.6e-08
+ $X=1.269 $Y=0.119 $X2=1.269 $Y2=0.1105
r30 12 37 6.54019 $w=2.09524e-08 $layer=Gate_1 $thickness=5.21905e-08 $X=1.269
+ $Y=0.136 $X2=1.269 $Y2=0.136
r31 12 55 5.96942 $w=2.03529e-08 $l=1.7e-08 $layer=Gate_1 $thickness=5.6e-08
+ $X=1.269 $Y=0.136 $X2=1.269 $Y2=0.119
r32 12 59 5.62929 $w=2.03125e-08 $l=1.6e-08 $layer=Gate_1 $thickness=5.6e-08
+ $X=1.269 $Y=0.136 $X2=1.269 $Y2=0.152
r33 53 52 16.3266 $w=2.1e-08 $l=4.8e-08 $layer=Gate_1 $thickness=5.6e-08
+ $X=1.215 $Y=0.2025 $X2=1.215 $Y2=0.1545
r34 50 51 16.6668 $w=2.1e-08 $l=4.9e-08 $layer=Gate_1 $thickness=5.6e-08
+ $X=1.215 $Y=0.0675 $X2=1.215 $Y2=0.1165
r35 11 35 6.54019 $w=2.09524e-08 $layer=Gate_1 $thickness=5.21905e-08 $X=1.215
+ $Y=0.136 $X2=1.215 $Y2=0.136
r36 11 51 6.81977 $w=2.04359e-08 $l=1.95e-08 $layer=Gate_1 $thickness=5.6e-08
+ $X=1.215 $Y=0.136 $X2=1.215 $Y2=0.1165
r37 11 52 6.47963 $w=2.04054e-08 $l=1.85e-08 $layer=Gate_1 $thickness=5.6e-08
+ $X=1.215 $Y=0.136 $X2=1.215 $Y2=0.1545
r38 47 48 5.24677 $w=1.3e-08 $l=2.25e-08 $layer=M1 $thickness=3.6e-08 $X=1.134
+ $Y=0.136 $X2=1.1115 $Y2=0.136
r39 22 45 3.14806 $w=1.3e-08 $l=1.35e-08 $layer=M1 $thickness=3.6e-08 $X=1.1475
+ $Y=0.136 $X2=1.161 $Y2=0.136
r40 22 47 3.14806 $w=1.3e-08 $l=1.35e-08 $layer=M1 $thickness=3.6e-08 $X=1.1475
+ $Y=0.136 $X2=1.134 $Y2=0.136
r41 43 42 16.3266 $w=2.1e-08 $l=4.8e-08 $layer=Gate_1 $thickness=5.6e-08
+ $X=1.161 $Y=0.2025 $X2=1.161 $Y2=0.1545
r42 40 41 16.6668 $w=2.1e-08 $l=4.9e-08 $layer=Gate_1 $thickness=5.6e-08
+ $X=1.161 $Y=0.0675 $X2=1.161 $Y2=0.1165
r43 10 32 6.27904 $w=2.09e-08 $layer=Gate_1 $thickness=5.24e-08 $X=1.161
+ $Y=0.136 $X2=1.161 $Y2=0.136
r44 10 41 6.81977 $w=2.04359e-08 $l=1.95e-08 $layer=Gate_1 $thickness=5.6e-08
+ $X=1.161 $Y=0.136 $X2=1.161 $Y2=0.1165
r45 10 42 6.47963 $w=2.04054e-08 $l=1.85e-08 $layer=Gate_1 $thickness=5.6e-08
+ $X=1.161 $Y=0.136 $X2=1.161 $Y2=0.1545
r46 36 37 12.6539 $w=1.77815e-08 $l=2.7e-08 $layer=LIG $thickness=4.8e-08
+ $X=1.242 $Y=0.136 $X2=1.269 $Y2=0.136
r47 35 36 12.6539 $w=1.77815e-08 $l=2.7e-08 $layer=LIG $thickness=4.8e-08
+ $X=1.215 $Y=0.136 $X2=1.242 $Y2=0.136
r48 34 35 12.6539 $w=1.77815e-08 $l=2.7e-08 $layer=LIG $thickness=4.8e-08
+ $X=1.188 $Y=0.136 $X2=1.215 $Y2=0.136
r49 33 34 10.1729 $w=1.54914e-08 $l=1.75e-08 $layer=LIG $thickness=4.8e-08
+ $X=1.1705 $Y=0.136 $X2=1.188 $Y2=0.136
r50 32 33 2.48102 $w=2.2e-08 $l=9.5e-09 $layer=LIG $thickness=4.8e-08 $X=1.161
+ $Y=0.136 $X2=1.1705 $Y2=0.136
r51 32 45 19.3796 $a=3.24e-16 $layer=V0LIG $X=1.161 $Y=0.136 $X2=1.161 $Y2=0.136
r52 31 32 2.48102 $w=2.2e-08 $l=9.5e-09 $layer=LIG $thickness=4.8e-08 $X=1.1515
+ $Y=0.136 $X2=1.161 $Y2=0.136
r53 30 31 10.1729 $w=1.54914e-08 $l=1.75e-08 $layer=LIG $thickness=4.8e-08
+ $X=1.134 $Y=0.136 $X2=1.1515 $Y2=0.136
r54 1 25 6.54019 $w=2.09524e-08 $layer=Gate_1 $thickness=5.21905e-08 $X=1.107
+ $Y=0.136 $X2=1.107 $Y2=0.136
r55 1 30 12.6539 $w=1.77815e-08 $l=2.7e-08 $layer=LIG $thickness=4.8e-08
+ $X=1.107 $Y=0.136 $X2=1.134 $Y2=0.136
r56 27 26 16.3266 $w=2.1e-08 $l=4.8e-08 $layer=Gate_1 $thickness=5.6e-08
+ $X=1.107 $Y=0.2025 $X2=1.107 $Y2=0.1545
r57 25 26 6.47963 $w=2.04054e-08 $l=1.85e-08 $layer=Gate_1 $thickness=5.6e-08
+ $X=1.107 $Y=0.136 $X2=1.107 $Y2=0.1545
r58 24 25 6.81977 $w=2.04359e-08 $l=1.95e-08 $layer=Gate_1 $thickness=5.6e-08
+ $X=1.107 $Y=0.1165 $X2=1.107 $Y2=0.136
r59 23 24 16.6668 $w=2.1e-08 $l=4.9e-08 $layer=Gate_1 $thickness=5.6e-08
+ $X=1.107 $Y=0.0675 $X2=1.107 $Y2=0.1165
r60 23 9 14.6259 $w=2.1e-08 $l=4.3e-08 $layer=Gate_1 $thickness=5.6e-08
+ $X=1.107 $Y=0.0675 $X2=1.107 $Y2=0.0245
.ends

.subckt PM_DFFHQx4_ASAP7_75t_R%Q vss 35 26 27 41 42 50 51 54 55 16 3 2 4 1 18
+ 17 14 13 15
c1 1 vss 0.00721848f $X=1.134 $Y=0.0675
c2 2 vss 0.00717555f $X=1.134 $Y=0.2025
c3 3 vss 0.00853352f $X=1.242 $Y=0.0675
c4 4 vss 0.0084909f $X=1.242 $Y=0.2025
c5 13 vss 0.00435816f $X=1.1195 $Y=0.0675
c6 14 vss 0.00443023f $X=1.2275 $Y=0.0675
c7 15 vss 0.00432066f $X=1.1195 $Y=0.2025
c8 16 vss 0.00442067f $X=1.2275 $Y=0.2025
c9 17 vss 0.00289023f $X=1.134 $Y=0.054
c10 18 vss 0.00315699f $X=1.134 $Y=0.234
c11 19 vss 0.00300626f $X=1.323 $Y=0.036
c12 20 vss 0.00300626f $X=1.323 $Y=0.234
c13 21 vss 0.0152963f $X=1.159 $Y=0.036
c14 22 vss 0.0151783f $X=1.204 $Y=0.234
c15 23 vss 0.00889637f $X=1.323 $Y=0.057
r1 55 53 0.0308642 $w=8.1e-08 $l=2.5e-09 $layer=P_src_drn $thickness=1e-09
+ $X=1.1513 $Y=0.2025 $X2=1.1485 $Y2=0.2025
r2 2 53 0.179012 $w=8.1e-08 $l=1.45e-08 $layer=P_src_drn $thickness=1e-09
+ $X=1.134 $Y=0.2025 $X2=1.1485 $Y2=0.2025
r3 15 2 0.179012 $w=8.1e-08 $l=1.45e-08 $layer=P_src_drn $thickness=1e-09
+ $X=1.1195 $Y=0.2025 $X2=1.134 $Y2=0.2025
r4 54 15 0.0308642 $w=8.1e-08 $l=2.5e-09 $layer=P_src_drn $thickness=1e-09
+ $X=1.1166 $Y=0.2025 $X2=1.1195 $Y2=0.2025
r5 2 47 19.3796 $a=3.24e-16 $layer=V0LISD $X=1.134 $Y=0.2025 $X2=1.134 $Y2=0.216
r6 51 49 0.0308642 $w=8.1e-08 $l=2.5e-09 $layer=P_src_drn $thickness=1e-09
+ $X=1.2593 $Y=0.2025 $X2=1.2565 $Y2=0.2025
r7 4 49 0.179012 $w=8.1e-08 $l=1.45e-08 $layer=P_src_drn $thickness=1e-09
+ $X=1.242 $Y=0.2025 $X2=1.2565 $Y2=0.2025
r8 16 4 0.179012 $w=8.1e-08 $l=1.45e-08 $layer=P_src_drn $thickness=1e-09
+ $X=1.2275 $Y=0.2025 $X2=1.242 $Y2=0.2025
r9 50 16 0.0308642 $w=8.1e-08 $l=2.5e-09 $layer=P_src_drn $thickness=1e-09
+ $X=1.2246 $Y=0.2025 $X2=1.2275 $Y2=0.2025
r10 18 45 4.64944 $w=1.48e-08 $l=2.5e-08 $layer=M1 $thickness=3.6e-08 $X=1.134
+ $Y=0.234 $X2=1.159 $Y2=0.234
r11 18 47 3.01711 $w=1.55e-08 $l=1.8e-08 $layer=M1 $thickness=3.6e-08 $X=1.134
+ $Y=0.234 $X2=1.134 $Y2=0.216
r12 4 43 19.3796 $a=3.24e-16 $layer=V0LISD $X=1.242 $Y=0.2025 $X2=1.242
+ $Y2=0.234
r13 43 44 9.32759 $w=1.3e-08 $l=4e-08 $layer=M1 $thickness=3.6e-08 $X=1.242
+ $Y=0.234 $X2=1.282 $Y2=0.234
r14 22 43 8.86121 $w=1.3e-08 $l=3.8e-08 $layer=M1 $thickness=3.6e-08 $X=1.204
+ $Y=0.234 $X2=1.242 $Y2=0.234
r15 22 45 10.4935 $w=1.3e-08 $l=4.5e-08 $layer=M1 $thickness=3.6e-08 $X=1.204
+ $Y=0.234 $X2=1.159 $Y2=0.234
r16 20 38 2.48126 $w=1.71429e-08 $l=2.1e-08 $layer=M1 $thickness=3.6e-08
+ $X=1.323 $Y=0.234 $X2=1.323 $Y2=0.213
r17 20 44 7.66726 $w=1.56829e-08 $l=4.1e-08 $layer=M1 $thickness=3.6e-08
+ $X=1.323 $Y=0.234 $X2=1.282 $Y2=0.234
r18 42 40 0.0308642 $w=8.1e-08 $l=2.5e-09 $layer=N_src_drn $thickness=1e-09
+ $X=1.2593 $Y=0.0675 $X2=1.2565 $Y2=0.0675
r19 3 40 0.179012 $w=8.1e-08 $l=1.45e-08 $layer=N_src_drn $thickness=1e-09
+ $X=1.242 $Y=0.0675 $X2=1.2565 $Y2=0.0675
r20 14 3 0.179012 $w=8.1e-08 $l=1.45e-08 $layer=N_src_drn $thickness=1e-09
+ $X=1.2275 $Y=0.0675 $X2=1.242 $Y2=0.0675
r21 41 14 0.0308642 $w=8.1e-08 $l=2.5e-09 $layer=N_src_drn $thickness=1e-09
+ $X=1.2246 $Y=0.0675 $X2=1.2275 $Y2=0.0675
r22 37 38 6.8096 $w=1.5e-08 $l=4e-08 $layer=M1 $thickness=3.6e-08 $X=1.323
+ $Y=0.173 $X2=1.323 $Y2=0.213
r23 36 37 5.66048 $w=1.5e-08 $l=3.33e-08 $layer=M1 $thickness=3.6e-08 $X=1.323
+ $Y=0.1397 $X2=1.323 $Y2=0.173
r24 35 36 0.97888 $w=1.5e-08 $l=5.7e-09 $layer=M1 $thickness=3.6e-08 $X=1.329
+ $Y=0.134 $X2=1.323 $Y2=0.1397
r25 35 34 0.6384 $w=1.5e-08 $l=3.8e-09 $layer=M1 $thickness=3.6e-08 $X=1.329
+ $Y=0.134 $X2=1.323 $Y2=0.1302
r26 33 34 5.49024 $w=1.5e-08 $l=3.22e-08 $layer=M1 $thickness=3.6e-08 $X=1.323
+ $Y=0.098 $X2=1.323 $Y2=0.1302
r27 23 33 6.97984 $w=1.5e-08 $l=4.1e-08 $layer=M1 $thickness=3.6e-08 $X=1.323
+ $Y=0.057 $X2=1.323 $Y2=0.098
r28 3 31 19.3796 $a=3.24e-16 $layer=V0LISD $X=1.242 $Y=0.0675 $X2=1.242
+ $Y2=0.036
r29 19 32 7.66726 $w=1.56829e-08 $l=4.1e-08 $layer=M1 $thickness=3.6e-08
+ $X=1.323 $Y=0.036 $X2=1.282 $Y2=0.036
r30 19 23 2.48126 $w=1.71429e-08 $l=2.1e-08 $layer=M1 $thickness=3.6e-08
+ $X=1.323 $Y=0.036 $X2=1.323 $Y2=0.057
r31 31 32 9.32759 $w=1.3e-08 $l=4e-08 $layer=M1 $thickness=3.6e-08 $X=1.242
+ $Y=0.036 $X2=1.282 $Y2=0.036
r32 30 31 8.86121 $w=1.3e-08 $l=3.8e-08 $layer=M1 $thickness=3.6e-08 $X=1.204
+ $Y=0.036 $X2=1.242 $Y2=0.036
r33 21 29 4.64944 $w=1.48e-08 $l=2.5e-08 $layer=M1 $thickness=3.6e-08 $X=1.159
+ $Y=0.036 $X2=1.134 $Y2=0.036
r34 21 30 10.4935 $w=1.3e-08 $l=4.5e-08 $layer=M1 $thickness=3.6e-08 $X=1.159
+ $Y=0.036 $X2=1.204 $Y2=0.036
r35 17 29 3.01711 $w=1.55e-08 $l=1.8e-08 $layer=M1 $thickness=3.6e-08 $X=1.134
+ $Y=0.054 $X2=1.134 $Y2=0.036
r36 1 17 19.3796 $a=3.24e-16 $layer=V0LISD $X=1.134 $Y=0.0675 $X2=1.134
+ $Y2=0.054
r37 27 25 0.0308642 $w=8.1e-08 $l=2.5e-09 $layer=N_src_drn $thickness=1e-09
+ $X=1.1513 $Y=0.0675 $X2=1.1485 $Y2=0.0675
r38 1 25 0.179012 $w=8.1e-08 $l=1.45e-08 $layer=N_src_drn $thickness=1e-09
+ $X=1.134 $Y=0.0675 $X2=1.1485 $Y2=0.0675
r39 13 1 0.179012 $w=8.1e-08 $l=1.45e-08 $layer=N_src_drn $thickness=1e-09
+ $X=1.1195 $Y=0.0675 $X2=1.134 $Y2=0.0675
r40 26 13 0.0308642 $w=8.1e-08 $l=2.5e-09 $layer=N_src_drn $thickness=1e-09
+ $X=1.1166 $Y=0.0675 $X2=1.1195 $Y2=0.0675
.ends

.subckt PM_DFFHQx4_ASAP7_75t_R%13 vss 7 9 5 4 1
c1 1 vss 0.00903554f $X=0.351 $Y=0.0675
c2 4 vss 0.00289665f $X=0.3095 $Y=0.0675
c3 5 vss 0.00175402f $X=0.38 $Y=0.0675
r1 9 8 0.0308642 $w=8.1e-08 $l=2.5e-09 $layer=N_src_drn $thickness=1e-09
+ $X=0.3953 $Y=0.0675 $X2=0.3925 $Y2=0.0675
r2 5 8 0.154321 $w=8.1e-08 $l=1.25e-08 $layer=N_src_drn $thickness=1e-09
+ $X=0.38 $Y=0.0675 $X2=0.3925 $Y2=0.0675
r3 4 1 0.154321 $w=8.1e-08 $l=1.25e-08 $layer=N_src_drn $thickness=1e-09
+ $X=0.3095 $Y=0.0675 $X2=0.351 $Y2=0.0675
r4 7 4 0.0308642 $w=8.1e-08 $l=2.5e-09 $layer=N_src_drn $thickness=1e-09
+ $X=0.3066 $Y=0.0675 $X2=0.3095 $Y2=0.0675
r5 1 5 1e-05 $l=2.9e-08 $X=0.351 $Y=0.0675 $X2=0.38 $Y2=0.0675
.ends

.subckt PM_DFFHQx4_ASAP7_75t_R%4 vss 33 39 75 78 81 84 93 95 8 7 25 19 17 16 1
+ 22 24 23 21 28 13 14 26 15 2 3 27
c1 1 vss 0.00338626f $X=0.1335 $Y=0.135
c2 2 vss 0.000175771f $X=0.405 $Y=0.135
c3 3 vss 0.000418989f $X=0.675 $Y=0.135
c4 7 vss 0.00795603f $X=0.054 $Y=0.054
c5 8 vss 0.0078987f $X=0.054 $Y=0.216
c6 13 vss 0.0686682f $X=0.135 $Y=0.0245
c7 14 vss 0.00715586f $X=0.405 $Y=0.135
c8 15 vss 0.00731842f $X=0.675 $Y=0.135
c9 16 vss 0.0311661f $X=0.056 $Y=0.054
c10 17 vss 0.0311482f $X=0.056 $Y=0.216
c11 18 vss 0.00368006f $X=0.018 $Y=0.036
c12 19 vss 0.00216555f $X=0.0165 $Y=0.153
c13 20 vss 0.00364831f $X=0.018 $Y=0.234
c14 21 vss 0.00659979f $X=0.018 $Y=0.125
c15 22 vss 0.00423254f $X=0.018 $Y=0.163
c16 23 vss 0.00447431f $X=0.036 $Y=0.036
c17 24 vss 0.00421578f $X=0.036 $Y=0.234
c18 25 vss 0.00104277f $X=0.151 $Y=0.116
c19 26 vss 0.00077457f $X=0.405 $Y=0.135
c20 27 vss 0.0015683f $X=0.675 $Y=0.1135
c21 28 vss 0.0270715f $X=0.0215 $Y=0.153
r1 95 94 0.0462963 $w=5.4e-08 $l=2.5e-09 $layer=P_src_drn $thickness=1e-09
+ $X=0.0713 $Y=0.216 $X2=0.0685 $Y2=0.216
r2 17 94 0.231482 $w=5.4e-08 $l=1.25e-08 $layer=P_src_drn $thickness=1e-09
+ $X=0.056 $Y=0.216 $X2=0.0685 $Y2=0.216
r3 93 92 0.0462963 $w=5.4e-08 $l=2.5e-09 $layer=N_src_drn $thickness=1e-09
+ $X=0.0713 $Y=0.054 $X2=0.0685 $Y2=0.054
r4 16 92 0.231482 $w=5.4e-08 $l=1.25e-08 $layer=N_src_drn $thickness=1e-09
+ $X=0.056 $Y=0.054 $X2=0.0685 $Y2=0.054
r5 8 90 19.3796 $a=3.24e-16 $layer=V0LISD $X=0.054 $Y=0.216 $X2=0.055 $Y2=0.234
r6 7 87 19.3796 $a=3.24e-16 $layer=V0LISD $X=0.054 $Y=0.054 $X2=0.055 $Y2=0.036
r7 89 90 2.09871 $w=1.3e-08 $l=9e-09 $layer=M1 $thickness=3.6e-08 $X=0.046
+ $Y=0.234 $X2=0.055 $Y2=0.234
r8 24 89 2.3319 $w=1.3e-08 $l=1e-08 $layer=M1 $thickness=3.6e-08 $X=0.036
+ $Y=0.234 $X2=0.046 $Y2=0.234
r9 86 87 2.09871 $w=1.3e-08 $l=9e-09 $layer=M1 $thickness=3.6e-08 $X=0.046
+ $Y=0.036 $X2=0.055 $Y2=0.036
r10 23 86 2.3319 $w=1.3e-08 $l=1e-08 $layer=M1 $thickness=3.6e-08 $X=0.036
+ $Y=0.036 $X2=0.046 $Y2=0.036
r11 84 83 16.4967 $w=2.1e-08 $l=4.85e-08 $layer=Gate_1 $thickness=5.6e-08
+ $X=0.675 $Y=0.2295 $X2=0.675 $Y2=0.181
r12 81 82 16.4967 $w=2.1e-08 $l=4.85e-08 $layer=Gate_1 $thickness=5.6e-08
+ $X=0.675 $Y=0.0405 $X2=0.675 $Y2=0.089
r13 15 82 15.8334 $w=2.07609e-08 $l=4.6e-08 $layer=Gate_1 $thickness=5.6e-08
+ $X=0.675 $Y=0.135 $X2=0.675 $Y2=0.089
r14 15 83 15.8334 $w=2.07609e-08 $l=4.6e-08 $layer=Gate_1 $thickness=5.6e-08
+ $X=0.675 $Y=0.135 $X2=0.675 $Y2=0.181
r15 78 77 16.4967 $w=2.1e-08 $l=4.85e-08 $layer=Gate_1 $thickness=5.6e-08
+ $X=0.405 $Y=0.2295 $X2=0.405 $Y2=0.181
r16 75 76 16.4967 $w=2.1e-08 $l=4.85e-08 $layer=Gate_1 $thickness=5.6e-08
+ $X=0.405 $Y=0.0675 $X2=0.405 $Y2=0.116
r17 14 76 6.6497 $w=2.04211e-08 $l=1.9e-08 $layer=Gate_1 $thickness=5.6e-08
+ $X=0.405 $Y=0.135 $X2=0.405 $Y2=0.116
r18 14 77 15.8334 $w=2.07609e-08 $l=4.6e-08 $layer=Gate_1 $thickness=5.6e-08
+ $X=0.405 $Y=0.135 $X2=0.405 $Y2=0.181
r19 20 69 3.36447 $w=1.71023e-08 $l=2.15e-08 $layer=M1 $thickness=3.6e-08
+ $X=0.018 $Y=0.234 $X2=0.018 $Y2=0.2125
r20 20 24 2.5483 $w=1.55e-08 $l=1.8e-08 $layer=M1 $thickness=3.6e-08 $X=0.018
+ $Y=0.234 $X2=0.036 $Y2=0.234
r21 18 67 3.36447 $w=1.71023e-08 $l=2.15e-08 $layer=M1 $thickness=3.6e-08
+ $X=0.018 $Y=0.036 $X2=0.018 $Y2=0.0575
r22 18 23 2.5483 $w=1.55e-08 $l=1.8e-08 $layer=M1 $thickness=3.6e-08 $X=0.018
+ $Y=0.036 $X2=0.036 $Y2=0.036
r23 3 64 19.3796 $a=3.24e-16 $layer=V0LIG $X=0.675 $Y=0.135 $X2=0.675 $Y2=0.144
r24 3 15 6.54019 $w=2.09524e-08 $layer=Gate_1 $thickness=5.21905e-08 $X=0.675
+ $Y=0.135 $X2=0.675 $Y2=0.135
r25 2 26 19.3796 $a=3.24e-16 $layer=V0LIG $X=0.405 $Y=0.135 $X2=0.405 $Y2=0.135
r26 2 14 6.54019 $w=2.09524e-08 $layer=Gate_1 $thickness=5.21905e-08 $X=0.405
+ $Y=0.135 $X2=0.405 $Y2=0.135
r27 68 69 7.11229 $w=1.3e-08 $l=3.05e-08 $layer=M1 $thickness=3.6e-08 $X=0.018
+ $Y=0.182 $X2=0.018 $Y2=0.2125
r28 22 68 4.43061 $w=1.3e-08 $l=1.9e-08 $layer=M1 $thickness=3.6e-08 $X=0.018
+ $Y=0.163 $X2=0.018 $Y2=0.182
r29 66 67 7.11229 $w=1.3e-08 $l=3.05e-08 $layer=M1 $thickness=3.6e-08 $X=0.018
+ $Y=0.088 $X2=0.018 $Y2=0.0575
r30 21 66 8.62802 $w=1.3e-08 $l=3.7e-08 $layer=M1 $thickness=3.6e-08 $X=0.018
+ $Y=0.125 $X2=0.018 $Y2=0.088
r31 27 64 7.11229 $w=1.3e-08 $l=3.05e-08 $layer=M1 $thickness=3.6e-08 $X=0.675
+ $Y=0.1135 $X2=0.675 $Y2=0.144
r32 26 62 4.19742 $w=1.3e-08 $l=1.8e-08 $layer=M1 $thickness=3.6e-08 $X=0.405
+ $Y=0.135 $X2=0.405 $Y2=0.153
r33 58 59 1.90199 $w=1.38333e-08 $l=9e-09 $layer=M1 $thickness=3.6e-08
+ $X=0.0255 $Y=0.153 $X2=0.0345 $Y2=0.153
r34 19 58 0.9184 $w=1.8e-08 $l=9e-09 $layer=M1 $thickness=3.6e-08 $X=0.0165
+ $Y=0.153 $X2=0.0255 $Y2=0.153
r35 19 21 5.19594 $w=1.44151e-08 $l=2.80401e-08 $layer=M1 $thickness=3.6e-08
+ $X=0.0165 $Y=0.153 $X2=0.018 $Y2=0.125
r36 19 22 0.998523 $w=1.74118e-08 $l=1.01119e-08 $layer=M1 $thickness=3.6e-08
+ $X=0.0165 $Y=0.153 $X2=0.018 $Y2=0.163
r37 56 64 19.5347 $a=3.24e-16 $layer=V1 $X=0.675 $Y=0.153 $X2=0.675 $Y2=0.144
r38 55 56 18.3054 $w=1.3e-08 $l=7.85e-08 $layer=M2 $thickness=3.6e-08 $X=0.5965
+ $Y=0.153 $X2=0.675 $Y2=0.153
r39 54 55 29.3819 $w=1.3e-08 $l=1.26e-07 $layer=M2 $thickness=3.6e-08 $X=0.4705
+ $Y=0.153 $X2=0.5965 $Y2=0.153
r40 53 54 15.2739 $w=1.3e-08 $l=6.55e-08 $layer=M2 $thickness=3.6e-08 $X=0.405
+ $Y=0.153 $X2=0.4705 $Y2=0.153
r41 53 62 19.5347 $a=3.24e-16 $layer=V1 $X=0.405 $Y=0.153 $X2=0.405 $Y2=0.153
r42 52 53 27.8662 $w=1.3e-08 $l=1.195e-07 $layer=M2 $thickness=3.6e-08
+ $X=0.2855 $Y=0.153 $X2=0.405 $Y2=0.153
r43 51 52 27.5164 $w=1.3e-08 $l=1.18e-07 $layer=M2 $thickness=3.6e-08 $X=0.1675
+ $Y=0.153 $X2=0.2855 $Y2=0.153
r44 50 51 3.84763 $w=1.3e-08 $l=1.65e-08 $layer=M2 $thickness=3.6e-08 $X=0.151
+ $Y=0.153 $X2=0.1675 $Y2=0.153
r45 49 50 13.7582 $w=1.3e-08 $l=5.9e-08 $layer=M2 $thickness=3.6e-08 $X=0.092
+ $Y=0.153 $X2=0.151 $Y2=0.153
r46 48 49 13.7582 $w=1.3e-08 $l=5.9e-08 $layer=M2 $thickness=3.6e-08 $X=0.033
+ $Y=0.153 $X2=0.092 $Y2=0.153
r47 48 59 19.5347 $a=3.24e-16 $layer=V1 $X=0.033 $Y=0.153 $X2=0.0345 $Y2=0.153
r48 28 48 2.68168 $w=1.3e-08 $l=1.15e-08 $layer=M2 $thickness=3.6e-08 $X=0.0215
+ $Y=0.153 $X2=0.033 $Y2=0.153
r49 45 50 19.5347 $a=3.24e-16 $layer=V1 $X=0.151 $Y=0.144 $X2=0.151 $Y2=0.153
r50 25 45 6.52931 $w=1.3e-08 $l=2.8e-08 $layer=M1 $thickness=3.6e-08 $X=0.151
+ $Y=0.116 $X2=0.151 $Y2=0.144
r51 43 45 19.3796 $a=3.24e-16 $layer=V0LIG $X=0.1525 $Y=0.135 $X2=0.151
+ $Y2=0.144
r52 41 43 4.82216 $w=1.64167e-08 $l=9e-09 $layer=LIG $thickness=4.8e-08
+ $X=0.1435 $Y=0.135 $X2=0.1525 $Y2=0.135
r53 1 41 2.6116 $w=2.2e-08 $l=1e-08 $layer=LIG $thickness=4.8e-08 $X=0.1335
+ $Y=0.135 $X2=0.1435 $Y2=0.135
r54 1 36 6.14846 $w=2.08718e-08 $l=1.5e-09 $layer=Gate_1 $thickness=5.25128e-08
+ $X=0.1335 $Y=0.135 $X2=0.135 $Y2=0.135
r55 39 38 14.6259 $w=2.1e-08 $l=4.3e-08 $layer=Gate_1 $thickness=5.6e-08
+ $X=0.135 $Y=0.216 $X2=0.135 $Y2=0.173
r56 37 38 7.31297 $w=2.1e-08 $l=2.15e-08 $layer=Gate_1 $thickness=5.6e-08
+ $X=0.135 $Y=0.1515 $X2=0.135 $Y2=0.173
r57 36 37 5.79936 $w=2.03333e-08 $l=1.65e-08 $layer=Gate_1 $thickness=5.6e-08
+ $X=0.135 $Y=0.135 $X2=0.135 $Y2=0.1515
r58 36 41 4.32033 $w=2.024e-08 $l=8.5e-09 $layer=Gate_1 $thickness=5.504e-08
+ $X=0.135 $Y=0.135 $X2=0.1435 $Y2=0.135
r59 35 36 5.79936 $w=2.03333e-08 $l=1.65e-08 $layer=Gate_1 $thickness=5.6e-08
+ $X=0.135 $Y=0.1185 $X2=0.135 $Y2=0.135
r60 34 35 7.31297 $w=2.1e-08 $l=2.15e-08 $layer=Gate_1 $thickness=5.6e-08
+ $X=0.135 $Y=0.097 $X2=0.135 $Y2=0.1185
r61 33 34 14.6259 $w=2.1e-08 $l=4.3e-08 $layer=Gate_1 $thickness=5.6e-08
+ $X=0.135 $Y=0.054 $X2=0.135 $Y2=0.097
r62 33 13 10.0341 $w=2.1e-08 $l=2.95e-08 $layer=Gate_1 $thickness=5.6e-08
+ $X=0.135 $Y=0.054 $X2=0.135 $Y2=0.0245
r63 8 17 1e-05 $l=2e-09 $X=0.054 $Y=0.216 $X2=0.056 $Y2=0.216
r64 7 16 1e-05 $l=2e-09 $X=0.054 $Y=0.054 $X2=0.056 $Y2=0.054
.ends

* End of included file DFFHQx4_ASAP7_75t_R.pex.sp.pex

*
.subckt DFFHQx4_ASAP7_75t_CUSTOM_4_25_0_7 VSS VDD CLK D Q
*
* VSS VSS
* VDD VDD
* CLK CLK
* D D
* Q Q
*
*

M0 VSS N_M0_g N_M0_s VSS nmos_rvt L=2e-08 W=5.4e-08 nfin=2 $X=0.071 $Y=0.027
M1 N_M1_d N_M1_g VSS VSS nmos_rvt L=2e-08 W=5.4e-08 nfin=2 $X=0.125 $Y=0.027
M2 N_M2_d N_M2_g VSS VSS nmos_rvt L=2e-08 W=8.1e-08 nfin=3 $X=0.287 $Y=0.027
M3 N_M3_d N_M3_g N_M3_s VSS nmos_rvt L=2e-08 W=8.1e-08 nfin=3 $X=0.395 $Y=0.027
M4 N_M4_d N_M4_g N_M4_s VSS nmos_rvt L=2e-08 W=2.7e-08 nfin=1 $X=0.449 $Y=0.027
M5 VSS N_M5_g N_M5_s VSS nmos_rvt L=2e-08 W=2.7e-08 nfin=1 $X=0.503 $Y=0.027
M6 N_M6_d N_M6_g VSS VSS nmos_rvt L=2e-08 W=2.7e-08 nfin=1 $X=0.557 $Y=0.027
M7 N_M7_d N_M7_g N_M7_s VSS nmos_rvt L=2e-08 W=2.7e-08 nfin=1 $X=0.611 $Y=0.027
M8 N_M8_d N_M8_g N_M8_s VSS nmos_rvt L=2e-08 W=2.7e-08 nfin=1 $X=0.665 $Y=0.027
M9 VSS N_M9_g N_M9_s VSS nmos_rvt L=2e-08 W=2.7e-08 nfin=1 $X=0.773 $Y=0.027
M10 N_M10_d N_M10_g VSS VSS nmos_rvt L=2e-08 W=2.7e-08 nfin=1 $X=0.827 $Y=0.027
M11 N_M11_d N_M11_g VSS VSS nmos_rvt L=2e-08 W=8.1e-08 nfin=3 $X=0.989 $Y=0.027
M12 N_M12_d N_M12_g VSS VSS nmos_rvt L=2e-08 W=8.1e-08 nfin=3 $X=1.043 $Y=0.027
M13 N_M13_d N_M13_g VSS VSS nmos_rvt L=2e-08 W=8.1e-08 nfin=3 $X=1.097 $Y=0.027
M14 N_M14_d N_M14_g VSS VSS nmos_rvt L=2e-08 W=8.1e-08 nfin=3 $X=1.151 $Y=0.027
M15 N_M15_d N_M15_g VSS VSS nmos_rvt L=2e-08 W=8.1e-08 nfin=3 $X=1.205 $Y=0.027
M16 N_M16_d N_M16_g VSS VSS nmos_rvt L=2e-08 W=8.1e-08 nfin=3 $X=1.259 $Y=0.027
M17 VDD N_M17_g N_M17_s VDD pmos_rvt L=2e-08 W=5.4e-08 nfin=2 $X=0.071 $Y=0.189
M18 N_M18_d N_M18_g VDD VDD pmos_rvt L=2e-08 W=5.4e-08 nfin=2 $X=0.125 $Y=0.189
M19 N_M19_d N_M19_g VDD VDD pmos_rvt L=2e-08 W=8.1e-08 nfin=3 $X=0.287 $Y=0.162
M20 N_M20_d N_M20_g N_M20_s VDD pmos_rvt L=2e-08 W=8.1e-08 nfin=3 $X=0.341
+ $Y=0.162
M21 N_M21_d N_M21_g N_M21_s VDD pmos_rvt L=2e-08 W=2.7e-08 nfin=1 $X=0.395
+ $Y=0.216
M22 VDD N_M22_g N_M22_s VDD pmos_rvt L=2e-08 W=2.7e-08 nfin=1 $X=0.503 $Y=0.216
M23 N_M23_d N_M23_g VDD VDD pmos_rvt L=2e-08 W=2.7e-08 nfin=1 $X=0.557 $Y=0.216
M24 N_M24_d N_M24_g N_M24_s VDD pmos_rvt L=2e-08 W=2.7e-08 nfin=1 $X=0.665
+ $Y=0.216
M25 N_M25_d N_M25_g N_M25_s VDD pmos_rvt L=2e-08 W=2.7e-08 nfin=1 $X=0.719
+ $Y=0.216
M26 VDD N_M26_g N_M26_s VDD pmos_rvt L=2e-08 W=2.7e-08 nfin=1 $X=0.773 $Y=0.216
M27 N_M27_d N_M27_g VDD VDD pmos_rvt L=2e-08 W=2.7e-08 nfin=1 $X=0.827 $Y=0.216
M28 N_M28_d N_M28_g VDD VDD pmos_rvt L=2e-08 W=8.1e-08 nfin=3 $X=0.989 $Y=0.162
M29 N_M29_d N_M29_g VDD VDD pmos_rvt L=2e-08 W=8.1e-08 nfin=3 $X=1.043 $Y=0.162
M30 N_M30_d N_M30_g VDD VDD pmos_rvt L=2e-08 W=8.1e-08 nfin=3 $X=1.097 $Y=0.162
M31 N_M31_d N_M31_g VDD VDD pmos_rvt L=2e-08 W=8.1e-08 nfin=3 $X=1.151 $Y=0.162
M32 N_M32_d N_M32_g VDD VDD pmos_rvt L=2e-08 W=8.1e-08 nfin=3 $X=1.205 $Y=0.162
M33 N_M33_d N_M33_g VDD VDD pmos_rvt L=2e-08 W=8.1e-08 nfin=3 $X=1.259 $Y=0.162

* .include "DFFHQx4_ASAP7_75t_R.pex.sp.pxi"

* Start of included file DFFHQx4_ASAP7_75t_R.pex.sp.pxi
x_PM_DFFHQx4_ASAP7_75t_R%CLK vss CLK N_M0_g N_M17_g N_CLK_3 N_CLK_1 N_CLK_7
+ N_CLK_8 N_CLK_4 N_CLK_5 N_CLK_6 PM_DFFHQx4_ASAP7_75t_R%CLK
x_PM_DFFHQx4_ASAP7_75t_R%15 vss N_M8_d N_M9_s N_15_4 N_15_1 N_15_5
+ PM_DFFHQx4_ASAP7_75t_R%15
cc_1 N_15_4 N_4_15 0.0148606f $X=0.6875 $Y=0.0405
cc_2 N_15_1 N_6_17 0.000699101f $X=0.702 $Y=0.0405
cc_3 N_15_5 N_6_17 0.0066678f $X=0.758 $Y=0.0405
cc_4 N_15_4 N_6_17 0.0257165f $X=0.6875 $Y=0.0405
cc_5 N_15_1 N_9_9 0.000886105f $X=0.702 $Y=0.0405
cc_6 N_15_5 N_9_9 0.0149704f $X=0.758 $Y=0.0405
cc_7 N_15_1 N_10_14 0.000318967f $X=0.702 $Y=0.0405
cc_8 N_15_1 N_10_21 0.000416628f $X=0.702 $Y=0.0405
cc_9 N_15_1 N_10_22 0.000547064f $X=0.702 $Y=0.0405
cc_10 N_15_4 N_10_5 0.000557904f $X=0.6875 $Y=0.0405
cc_11 N_15_1 N_10_17 0.00238799f $X=0.702 $Y=0.0405
x_PM_DFFHQx4_ASAP7_75t_R%16 vss N_M4_d N_M5_s N_16_1 PM_DFFHQx4_ASAP7_75t_R%16
cc_12 N_16_1 N_6_15 0.0075685f $X=0.486 $Y=0.0405
cc_13 N_16_1 N_7_10 0.00767702f $X=0.486 $Y=0.0405
x_PM_DFFHQx4_ASAP7_75t_R%D vss D N_M2_g N_M19_g N_D_8 N_D_3 N_D_9 N_D_6 N_D_1
+ N_D_7 N_D_5 PM_DFFHQx4_ASAP7_75t_R%D
cc_14 N_D_8 N_4_14 0.000100099f $X=0.243 $Y=0.1735
cc_15 N_D_8 N_4_1 0.000355176f $X=0.243 $Y=0.1735
cc_16 N_D_8 N_4_26 0.000158408f $X=0.243 $Y=0.1735
cc_17 N_D_8 N_4_28 0.00387338f $X=0.243 $Y=0.1735
x_PM_DFFHQx4_ASAP7_75t_R%17 vss N_M19_d N_M20_s N_17_1 PM_DFFHQx4_ASAP7_75t_R%17
cc_18 N_17_1 N_D_3 0.0167282f $X=0.324 $Y=0.2025
cc_19 N_17_1 N_6_14 0.016854f $X=0.324 $Y=0.2025
x_PM_DFFHQx4_ASAP7_75t_R%9 vss N_M9_g N_M26_g N_M10_d N_M27_d N_9_9 N_9_18
+ N_9_3 N_9_4 N_9_1 N_9_17 N_9_12 N_9_15 N_9_16 N_9_11 N_9_10
+ PM_DFFHQx4_ASAP7_75t_R%9
cc_20 N_9_9 N_6_8 0.000207124f $X=0.783 $Y=0.0245
cc_21 N_9_9 N_6_4 0.000410438f $X=0.783 $Y=0.0245
cc_22 N_9_9 N_6_17 0.0128883f $X=0.783 $Y=0.0245
x_PM_DFFHQx4_ASAP7_75t_R%18 vss N_M25_d N_M26_s N_18_1 PM_DFFHQx4_ASAP7_75t_R%18
cc_23 N_18_1 N_6_17 0.00758365f $X=0.756 $Y=0.2295
cc_24 N_18_1 N_9_9 0.00764492f $X=0.756 $Y=0.2295
x_PM_DFFHQx4_ASAP7_75t_R%10 vss N_M10_g N_M27_g N_M24_d N_M25_s N_M11_g N_M28_g
+ N_M12_g N_M29_g N_M7_d N_M8_s N_10_5 N_10_24 N_10_6 N_10_15 N_10_14 N_10_16
+ N_10_22 N_10_18 N_10_23 N_10_21 N_10_2 N_10_19 N_10_27 N_10_20 N_10_28
+ N_10_11 N_10_26 N_10_1 N_10_17 N_10_25 N_10_29 N_10_13 N_10_12
+ PM_DFFHQx4_ASAP7_75t_R%10
cc_25 N_10_5 N_4_28 0.000119931f $X=0.648 $Y=0.0405
cc_26 N_10_24 N_4_27 0.000128175f $X=0.81 $Y=0.162
cc_27 N_10_6 N_4_15 0.000137141f $X=0.702 $Y=0.2295
cc_28 N_10_15 N_4_15 0.00644125f $X=0.6875 $Y=0.2295
cc_29 N_10_14 N_4_15 0.00655253f $X=0.6335 $Y=0.0405
cc_30 N_10_16 N_4_27 0.000389659f $X=0.729 $Y=0.233
cc_31 N_10_22 N_4_27 0.00410403f $X=0.729 $Y=0.136
cc_32 N_10_18 N_4_27 0.000506285f $X=0.729 $Y=0.16
cc_33 N_10_5 N_4_3 0.000506878f $X=0.648 $Y=0.0405
cc_34 N_10_22 N_4_3 0.000528325f $X=0.729 $Y=0.136
cc_35 N_10_23 N_4_27 0.000533046f $X=0.729 $Y=0.1975
cc_36 N_10_21 N_4_27 0.000564954f $X=0.704 $Y=0.036
cc_37 N_10_21 N_4_28 0.000928459f $X=0.704 $Y=0.036
cc_38 N_10_5 N_4_15 0.01877f $X=0.648 $Y=0.0405
cc_39 N_10_18 N_6_8 0.000159554f $X=0.729 $Y=0.16
cc_40 N_10_16 N_6_8 0.00019558f $X=0.729 $Y=0.233
cc_41 N_10_6 N_6_8 0.000228243f $X=0.702 $Y=0.2295
cc_42 N_10_14 N_6_16 0.0065948f $X=0.6335 $Y=0.0405
cc_43 N_10_24 N_6_4 0.000357768f $X=0.81 $Y=0.162
cc_44 N_10_22 N_6_8 0.000478636f $X=0.729 $Y=0.136
cc_45 N_10_23 N_6_8 0.000561191f $X=0.729 $Y=0.1975
cc_46 N_10_6 N_6_17 0.000931626f $X=0.702 $Y=0.2295
cc_47 N_10_15 N_6_4 0.00131971f $X=0.6875 $Y=0.2295
cc_48 N_10_15 N_6_8 0.00219971f $X=0.6875 $Y=0.2295
cc_49 N_10_5 N_6_16 0.00947827f $X=0.648 $Y=0.0405
cc_50 N_10_15 N_6_17 0.0167411f $X=0.6875 $Y=0.2295
cc_51 N_10_16 N_7_3 0.000185371f $X=0.729 $Y=0.233
cc_52 N_10_15 N_7_3 0.000439713f $X=0.6875 $Y=0.2295
cc_53 N_10_14 N_7_11 0.000473064f $X=0.6335 $Y=0.0405
cc_54 N_10_16 N_7_4 0.000286835f $X=0.729 $Y=0.233
cc_55 N_10_6 N_7_4 0.000732266f $X=0.702 $Y=0.2295
cc_56 N_10_21 N_7_18 0.000479131f $X=0.704 $Y=0.036
cc_57 N_10_15 N_7_4 0.000567669f $X=0.6875 $Y=0.2295
cc_58 N_10_16 N_7_19 0.000573049f $X=0.729 $Y=0.233
cc_59 N_10_21 N_7_14 0.00147727f $X=0.704 $Y=0.036
cc_60 N_10_5 N_7_3 0.00343748f $X=0.648 $Y=0.0405
cc_61 N_10_2 N_9_9 0.000177797f $X=0.9895 $Y=0.136
cc_62 N_10_19 N_9_9 0.000212814f $X=0.837 $Y=0.162
cc_63 N_10_27 N_9_9 0.000229167f $X=0.891 $Y=0.1305
cc_64 N_10_20 N_9_9 0.000238481f $X=0.891 $Y=0.1575
cc_65 N_10_28 N_9_18 0.001346f $X=0.999 $Y=0.1245
cc_66 N_10_11 N_9_3 0.000359573f $X=0.837 $Y=0.0245
cc_67 N_10_2 N_9_18 0.000366746f $X=0.9895 $Y=0.136
cc_68 N_10_26 N_9_4 0.000373264f $X=0.848 $Y=0.162
cc_69 N_10_20 N_9_18 0.00128453f $X=0.891 $Y=0.1575
cc_70 N_10_11 N_9_4 0.000540779f $X=0.837 $Y=0.0245
cc_71 N_10_1 N_9_1 0.000606584f $X=0.837 $Y=0.135
cc_72 N_10_26 N_9_17 0.000685691f $X=0.848 $Y=0.162
cc_73 N_10_17 N_9_12 0.000791346f $X=0.729 $Y=0.036
cc_74 N_10_25 N_9_15 0.000831813f $X=0.837 $Y=0.118
cc_75 N_10_22 N_9_1 0.000980132f $X=0.729 $Y=0.136
cc_76 N_10_25 N_9_16 0.00112139f $X=0.837 $Y=0.118
cc_77 N_10_1 N_9_9 0.00116676f $X=0.837 $Y=0.135
cc_78 N_10_20 N_9_17 0.00120274f $X=0.891 $Y=0.1575
cc_79 N_10_11 N_9_1 0.00121785f $X=0.837 $Y=0.0245
cc_80 N_10_24 N_9_15 0.00140533f $X=0.81 $Y=0.162
cc_81 N_10_29 N_9_18 0.00177307f $X=0.8795 $Y=0.153
cc_82 N_10_11 N_9_11 0.00655451f $X=0.837 $Y=0.0245
cc_83 N_10_11 N_9_10 0.00653858f $X=0.837 $Y=0.0245
cc_84 N_10_22 N_9_15 0.00458304f $X=0.729 $Y=0.136
cc_85 N_10_27 N_9_18 0.00613799f $X=0.891 $Y=0.1305
cc_86 N_10_11 N_9_9 0.0307121f $X=0.837 $Y=0.0245
x_PM_DFFHQx4_ASAP7_75t_R%6 vss N_M20_g N_M1_d N_M18_d N_M4_g N_M7_g N_M25_g
+ N_6_7 N_6_6 N_6_23 N_6_21 N_6_20 N_6_18 N_6_3 N_6_4 N_6_22 N_6_25 N_6_1 N_6_2
+ N_6_8 N_6_24 N_6_26 N_6_14 N_6_17 N_6_15 N_6_16 N_6_19
+ PM_DFFHQx4_ASAP7_75t_R%6
cc_87 N_6_7 N_CLK_7 0.000348708f $X=0.162 $Y=0.216
cc_88 N_6_6 N_CLK_7 0.000349108f $X=0.162 $Y=0.054
cc_89 N_6_23 N_CLK_7 0.000661488f $X=0.189 $Y=0.1735
cc_90 N_6_21 N_CLK_7 0.00181406f $X=0.189 $Y=0.234
cc_91 N_6_20 N_CLK_7 0.0019534f $X=0.189 $Y=0.036
cc_92 N_6_18 N_4_13 0.0111085f $X=0.1475 $Y=0.054
cc_93 N_6_20 N_4_23 0.00010901f $X=0.189 $Y=0.036
cc_94 N_6_20 N_4_21 0.000117562f $X=0.189 $Y=0.036
cc_95 N_6_21 N_4_24 0.00012368f $X=0.189 $Y=0.234
cc_96 N_6_3 N_4_15 0.000190372f $X=0.621 $Y=0.178
cc_97 N_6_6 N_4_13 0.00094496f $X=0.162 $Y=0.054
cc_98 N_6_7 N_4_13 0.000945413f $X=0.162 $Y=0.216
cc_99 N_6_4 N_4_15 0.000244854f $X=0.729 $Y=0.178
cc_100 N_6_21 N_4_25 0.000318641f $X=0.189 $Y=0.234
cc_101 N_6_22 N_4_28 0.000327978f $X=0.3375 $Y=0.135
cc_102 N_6_25 N_4_28 0.000886896f $X=0.513 $Y=0.168
cc_103 N_6_1 N_4_2 0.00192127f $X=0.351 $Y=0.135
cc_104 N_6_20 N_4_25 0.000414057f $X=0.189 $Y=0.036
cc_105 N_6_22 N_4_2 0.000441763f $X=0.3375 $Y=0.135
cc_106 N_6_2 N_4_14 0.000469416f $X=0.459 $Y=0.178
cc_107 N_6_8 N_4_3 0.00244952f $X=0.501 $Y=0.178
cc_108 N_6_24 N_4_28 0.0011493f $X=0.324 $Y=0.1555
cc_109 N_6_8 N_4_27 0.000519748f $X=0.501 $Y=0.178
cc_110 N_6_23 N_4_25 0.00727017f $X=0.189 $Y=0.1735
cc_111 N_6_23 N_4_28 0.000580973f $X=0.189 $Y=0.1735
cc_112 N_6_26 N_4_26 0.000648149f $X=0.1775 $Y=0.189
cc_113 N_6_23 N_4_1 0.000678998f $X=0.189 $Y=0.1735
cc_114 N_6_18 N_4_1 0.000955825f $X=0.1475 $Y=0.054
cc_115 N_6_14 N_4_14 0.00159951f $X=0.351 $Y=0.073
cc_116 N_6_22 N_4_26 0.00258505f $X=0.3375 $Y=0.135
cc_117 N_6_8 N_4_15 0.00374548f $X=0.501 $Y=0.178
cc_118 N_6_17 N_4_15 0.00552826f $X=0.729 $Y=0.178
cc_119 N_6_15 N_4_14 0.0084847f $X=0.459 $Y=0.178
cc_120 N_6_16 N_4_15 0.0171829f $X=0.621 $Y=0.178
cc_121 N_6_26 N_4_28 0.0286514f $X=0.1775 $Y=0.189
cc_122 N_6_19 N_4_13 0.0388943f $X=0.1475 $Y=0.216
cc_123 N_6_7 N_D_3 0.000120905f $X=0.162 $Y=0.216
cc_124 N_6_24 N_D_3 0.000151526f $X=0.324 $Y=0.1555
cc_125 N_6_23 N_D_3 0.000177848f $X=0.189 $Y=0.1735
cc_126 N_6_1 N_D_3 0.000348427f $X=0.351 $Y=0.135
cc_127 N_6_22 N_D_3 0.00063335f $X=0.3375 $Y=0.135
cc_128 N_6_20 N_D_3 0.000865787f $X=0.189 $Y=0.036
cc_129 N_6_24 N_D_9 0.000997404f $X=0.324 $Y=0.1555
cc_130 N_6_26 N_D_9 0.001084f $X=0.1775 $Y=0.189
cc_131 N_6_21 N_D_6 0.00133275f $X=0.189 $Y=0.234
cc_132 N_6_1 N_D_1 0.00166992f $X=0.351 $Y=0.135
cc_133 N_6_23 N_D_7 0.00178174f $X=0.189 $Y=0.1735
cc_134 N_6_22 N_D_9 0.0018992f $X=0.3375 $Y=0.135
cc_135 N_6_23 N_D_8 0.00260302f $X=0.189 $Y=0.1735
cc_136 N_6_23 N_D_5 0.00362074f $X=0.189 $Y=0.1735
cc_137 N_6_14 N_D_3 0.00506373f $X=0.351 $Y=0.073
x_PM_DFFHQx4_ASAP7_75t_R%7 vss N_M5_g N_M22_g N_M6_d N_M7_s N_M23_d N_M24_s
+ N_7_13 N_7_19 N_7_14 N_7_16 N_7_3 N_7_1 N_7_4 N_7_12 N_7_17 N_7_11 N_7_10
+ N_7_18 PM_DFFHQx4_ASAP7_75t_R%7
cc_138 N_7_13 N_4_14 0.000115269f $X=0.65 $Y=0.2295
cc_139 N_7_13 N_4_27 0.000365537f $X=0.65 $Y=0.2295
cc_140 N_7_13 N_4_28 0.000213191f $X=0.65 $Y=0.2295
cc_141 N_7_19 N_4_3 0.000561187f $X=0.621 $Y=0.1
cc_142 N_7_19 N_4_27 0.00446471f $X=0.621 $Y=0.1
cc_143 N_7_14 N_4_27 0.000750899f $X=0.594 $Y=0.09
cc_144 N_7_16 N_4_28 0.00266539f $X=0.5 $Y=0.09
cc_145 N_7_13 N_4_15 0.0155425f $X=0.65 $Y=0.2295
cc_146 N_7_3 N_6_2 0.000104966f $X=0.594 $Y=0.0405
cc_147 N_7_3 N_6_25 0.000253868f $X=0.594 $Y=0.0405
cc_148 N_7_3 N_6_8 0.000337291f $X=0.594 $Y=0.0405
cc_149 N_7_1 N_6_15 0.000695945f $X=0.513 $Y=0.09
cc_150 N_7_4 N_6_8 0.00650721f $X=0.594 $Y=0.2295
cc_151 N_7_12 N_6_16 0.00763056f $X=0.5795 $Y=0.2295
cc_152 N_7_13 N_6_16 0.00766702f $X=0.65 $Y=0.2295
cc_153 N_7_17 N_6_25 0.000342067f $X=0.5965 $Y=0.234
cc_154 N_7_17 N_6_8 0.000479534f $X=0.5965 $Y=0.234
cc_155 N_7_4 N_6_3 0.000871237f $X=0.594 $Y=0.2295
cc_156 N_7_19 N_6_8 0.00164885f $X=0.621 $Y=0.1
cc_157 N_7_4 N_6_16 0.00229365f $X=0.594 $Y=0.2295
cc_158 N_7_11 N_6_16 0.0063312f $X=0.5795 $Y=0.0405
cc_159 N_7_10 N_6_15 0.0137077f $X=0.513 $Y=0.0245
cc_160 N_7_3 N_6_16 0.0290615f $X=0.594 $Y=0.0405
x_PM_DFFHQx4_ASAP7_75t_R%8 vss N_M6_g N_M23_g N_M3_d N_M4_s N_M20_d N_M21_s
+ N_8_11 N_8_19 N_8_13 N_8_14 N_8_3 N_8_4 N_8_18 N_8_10 N_8_15 N_8_20 N_8_12
+ N_8_16 N_8_1 N_8_17 N_8_9 PM_DFFHQx4_ASAP7_75t_R%8
cc_161 N_8_11 N_4_3 0.000149112f $X=0.4175 $Y=0.081
cc_162 N_8_11 N_4_26 0.000266334f $X=0.4175 $Y=0.081
cc_163 N_8_19 N_4_26 0.00161493f $X=0.459 $Y=0.1525
cc_164 N_8_13 N_4_14 0.00540893f $X=0.3635 $Y=0.189
cc_165 N_8_14 N_4_26 0.000465002f $X=0.459 $Y=0.036
cc_166 N_8_3 N_4_2 0.000859853f $X=0.378 $Y=0.2295
cc_167 N_8_4 N_4_14 0.00104386f $X=0.432 $Y=0.0405
cc_168 N_8_18 N_4_26 0.00105615f $X=0.459 $Y=0.114
cc_169 N_8_3 N_4_14 0.00105995f $X=0.378 $Y=0.2295
cc_170 N_8_10 N_4_2 0.00169477f $X=0.4175 $Y=0.0405
cc_171 N_8_15 N_4_26 0.0026732f $X=0.459 $Y=0.131
cc_172 N_8_20 N_4_28 0.00363516f $X=0.54 $Y=0.131
cc_173 N_8_10 N_4_14 0.00939855f $X=0.4175 $Y=0.0405
cc_174 N_8_12 N_4_14 0.0105036f $X=0.3635 $Y=0.2295
cc_175 N_8_11 N_4_14 0.0444342f $X=0.4175 $Y=0.081
cc_176 N_8_10 N_6_24 9.88791e-20 $X=0.4175 $Y=0.0405
cc_177 N_8_10 N_6_23 0.000102307f $X=0.4175 $Y=0.0405
cc_178 N_8_10 N_6_25 0.000356456f $X=0.4175 $Y=0.0405
cc_179 N_8_10 N_6_14 0.00013804f $X=0.4175 $Y=0.0405
cc_180 N_8_10 N_6_3 0.000168717f $X=0.4175 $Y=0.0405
cc_181 N_8_13 N_6_14 0.0238431f $X=0.3635 $Y=0.189
cc_182 N_8_3 N_6_24 0.00095488f $X=0.378 $Y=0.2295
cc_183 N_8_3 N_6_1 0.000326459f $X=0.378 $Y=0.2295
cc_184 N_8_3 N_6_22 0.000346862f $X=0.378 $Y=0.2295
cc_185 N_8_19 N_6_25 0.00272631f $X=0.459 $Y=0.1525
cc_186 N_8_16 N_6_25 0.000387897f $X=0.459 $Y=0.234
cc_187 N_8_11 N_6_15 0.00545082f $X=0.4175 $Y=0.081
cc_188 N_8_1 N_6_8 0.00209253f $X=0.567 $Y=0.1305
cc_189 N_8_20 N_6_8 0.000586572f $X=0.54 $Y=0.131
cc_190 N_8_4 N_6_15 0.000619763f $X=0.432 $Y=0.0405
cc_191 N_8_12 N_6_1 0.000765893f $X=0.3635 $Y=0.2295
cc_192 N_8_19 N_6_2 0.00100635f $X=0.459 $Y=0.1525
cc_193 N_8_3 N_6_14 0.00160569f $X=0.378 $Y=0.2295
cc_194 N_8_17 N_6_26 0.00289385f $X=0.434 $Y=0.234
cc_195 N_8_20 N_6_25 0.0031962f $X=0.54 $Y=0.131
cc_196 N_8_9 N_6_8 0.00421524f $X=0.567 $Y=0.0245
cc_197 N_8_12 N_6_14 0.00964052f $X=0.3635 $Y=0.2295
cc_198 N_8_9 N_6_16 0.0117129f $X=0.567 $Y=0.0245
cc_199 N_8_10 N_6_15 0.030941f $X=0.4175 $Y=0.0405
cc_200 N_8_9 N_7_11 0.00637894f $X=0.567 $Y=0.0245
cc_201 N_8_4 N_7_1 0.000329233f $X=0.432 $Y=0.0405
cc_202 N_8_20 N_7_14 0.00046802f $X=0.54 $Y=0.131
cc_203 N_8_20 N_7_1 0.000890107f $X=0.54 $Y=0.131
cc_204 N_8_1 N_7_16 0.000978525f $X=0.567 $Y=0.1305
cc_205 N_8_20 N_7_19 0.0010127f $X=0.54 $Y=0.131
cc_206 N_8_9 N_7_3 0.00103808f $X=0.567 $Y=0.0245
cc_207 N_8_1 N_7_10 0.00108658f $X=0.567 $Y=0.1305
cc_208 N_8_18 N_7_16 0.00110246f $X=0.459 $Y=0.114
cc_209 N_8_9 N_7_1 0.00116849f $X=0.567 $Y=0.0245
cc_210 N_8_9 N_7_12 0.006242f $X=0.567 $Y=0.0245
cc_211 N_8_20 N_7_16 0.00671983f $X=0.54 $Y=0.131
cc_212 N_8_9 N_7_10 0.0290667f $X=0.567 $Y=0.0245
x_PM_DFFHQx4_ASAP7_75t_R%14 vss N_M21_d N_M22_s N_14_4 N_14_1 N_14_5
+ PM_DFFHQx4_ASAP7_75t_R%14
cc_213 N_14_4 N_4_14 0.013984f $X=0.4175 $Y=0.2295
cc_214 N_14_1 N_6_2 0.000797301f $X=0.432 $Y=0.2295
cc_215 N_14_5 N_6_8 0.00101917f $X=0.488 $Y=0.2295
cc_216 N_14_1 N_6_15 0.00189544f $X=0.432 $Y=0.2295
cc_217 N_14_5 N_6_15 0.00652873f $X=0.488 $Y=0.2295
cc_218 N_14_4 N_6_15 0.0227417f $X=0.4175 $Y=0.2295
cc_219 N_14_5 N_7_10 0.0185694f $X=0.488 $Y=0.2295
cc_220 N_14_1 N_8_17 0.000404771f $X=0.432 $Y=0.2295
cc_221 N_14_4 N_8_3 0.000499064f $X=0.4175 $Y=0.2295
cc_222 N_14_1 N_8_16 0.00271568f $X=0.432 $Y=0.2295
x_PM_DFFHQx4_ASAP7_75t_R%11 vss N_M13_g N_M30_g N_M14_g N_M31_g N_M15_g N_M32_g
+ N_M16_g N_M33_g N_M11_d N_M12_d N_M28_d N_M29_d N_11_14 N_11_18 N_11_19
+ N_11_20 N_11_21 N_11_4 N_11_13 N_11_9 N_11_3 N_11_1 N_11_10 N_11_15 N_11_17
+ N_11_11 N_11_22 N_11_12 PM_DFFHQx4_ASAP7_75t_R%11
cc_223 N_11_14 N_10_13 0.0591183f $X=1.0115 $Y=0.2025
cc_224 N_11_14 N_10_2 0.00614197f $X=1.0115 $Y=0.2025
cc_225 N_11_14 N_10_28 0.000335062f $X=1.0115 $Y=0.2025
cc_226 N_11_18 N_10_28 0.000443201f $X=1.0145 $Y=0.036
cc_227 N_11_19 N_10_28 0.000475936f $X=1.0145 $Y=0.234
cc_228 N_11_20 N_10_2 0.000482764f $X=1.089 $Y=0.1245
cc_229 N_11_21 N_10_2 0.000588308f $X=1.089 $Y=0.156
cc_230 N_11_4 N_10_2 0.000629649f $X=1.026 $Y=0.2025
cc_231 N_11_19 N_10_29 0.000699657f $X=1.0145 $Y=0.234
cc_232 N_11_13 N_10_13 0.0114744f $X=1.0115 $Y=0.0675
cc_233 N_11_4 N_10_28 0.00115414f $X=1.026 $Y=0.2025
cc_234 N_11_9 N_10_13 0.00175093f $X=1.107 $Y=0.0245
cc_235 N_11_3 N_10_13 0.00175098f $X=1.026 $Y=0.0675
cc_236 N_11_4 N_10_13 0.00190878f $X=1.026 $Y=0.2025
cc_237 N_11_13 N_10_12 0.018837f $X=1.0115 $Y=0.0675
cc_238 N_11_14 N_10_12 0.0496111f $X=1.0115 $Y=0.2025
x_PM_DFFHQx4_ASAP7_75t_R%Q vss Q N_M13_d N_M14_d N_M15_d N_M16_d N_M32_d
+ N_M33_d N_M30_d N_M31_d N_Q_16 N_Q_3 N_Q_2 N_Q_4 N_Q_1 N_Q_18 N_Q_17 N_Q_14
+ N_Q_13 N_Q_15 PM_DFFHQx4_ASAP7_75t_R%Q
cc_239 N_Q_16 N_11_1 0.0107167f $X=1.2275 $Y=0.2025
cc_240 N_Q_16 N_11_21 0.000607748f $X=1.2275 $Y=0.2025
cc_241 N_Q_16 N_11_20 0.000608062f $X=1.2275 $Y=0.2025
cc_242 N_Q_16 N_11_10 0.0016379f $X=1.2275 $Y=0.2025
cc_243 N_Q_16 N_11_15 0.000981292f $X=1.2275 $Y=0.2025
cc_244 N_Q_16 N_11_17 0.000990233f $X=1.2275 $Y=0.2025
cc_245 N_Q_3 N_11_11 0.0015716f $X=1.242 $Y=0.0675
cc_246 N_Q_2 N_11_22 0.00161992f $X=1.134 $Y=0.2025
cc_247 N_Q_4 N_11_11 0.00166384f $X=1.242 $Y=0.2025
cc_248 N_Q_1 N_11_10 0.00200608f $X=1.134 $Y=0.0675
cc_249 N_Q_2 N_11_10 0.00207914f $X=1.134 $Y=0.2025
cc_250 N_Q_18 N_11_21 0.00229513f $X=1.134 $Y=0.234
cc_251 N_Q_17 N_11_20 0.00233414f $X=1.134 $Y=0.054
cc_252 N_Q_14 N_11_12 0.0102799f $X=1.2275 $Y=0.0675
cc_253 N_Q_13 N_11_10 0.0180597f $X=1.1195 $Y=0.0675
cc_254 N_Q_14 N_11_11 0.0542992f $X=1.2275 $Y=0.0675
cc_255 N_Q_16 N_11_11 0.0182403f $X=1.2275 $Y=0.2025
cc_256 N_Q_15 N_11_9 0.0182531f $X=1.1195 $Y=0.2025
cc_257 N_Q_13 N_11_9 0.0462247f $X=1.1195 $Y=0.0675
cc_258 N_Q_15 N_11_10 0.0463766f $X=1.1195 $Y=0.2025
cc_259 N_Q_16 N_11_12 0.0496881f $X=1.2275 $Y=0.2025
x_PM_DFFHQx4_ASAP7_75t_R%13 vss N_M2_d N_M3_s N_13_5 N_13_4 N_13_1
+ PM_DFFHQx4_ASAP7_75t_R%13
cc_260 N_13_5 N_4_26 0.000269192f $X=0.38 $Y=0.0675
cc_261 N_13_5 N_4_2 0.000662539f $X=0.38 $Y=0.0675
cc_262 N_13_5 N_4_14 0.0342058f $X=0.38 $Y=0.0675
cc_263 N_13_4 N_D_3 0.0344447f $X=0.3095 $Y=0.0675
cc_264 N_13_5 N_6_22 0.000354896f $X=0.38 $Y=0.0675
cc_265 N_13_5 N_6_1 0.00191255f $X=0.38 $Y=0.0675
cc_266 N_13_5 N_6_14 0.0725065f $X=0.38 $Y=0.0675
cc_267 N_13_1 N_8_11 0.000585407f $X=0.351 $Y=0.0675
cc_268 N_13_1 N_8_4 0.00106625f $X=0.351 $Y=0.0675
cc_269 N_13_1 N_8_10 0.00270005f $X=0.351 $Y=0.0675
x_PM_DFFHQx4_ASAP7_75t_R%4 vss N_M1_g N_M18_g N_M3_g N_M21_g N_M8_g N_M24_g
+ N_M0_s N_M17_s N_4_8 N_4_7 N_4_25 N_4_19 N_4_17 N_4_16 N_4_1 N_4_22 N_4_24
+ N_4_23 N_4_21 N_4_28 N_4_13 N_4_14 N_4_26 N_4_15 N_4_2 N_4_3 N_4_27
+ PM_DFFHQx4_ASAP7_75t_R%4
cc_270 N_4_8 N_CLK_3 0.00109242f $X=0.054 $Y=0.216
cc_271 N_4_7 N_CLK_3 0.00110989f $X=0.054 $Y=0.054
cc_272 N_4_25 N_CLK_3 0.000287412f $X=0.151 $Y=0.116
cc_273 N_4_19 N_CLK_3 0.00029017f $X=0.0165 $Y=0.153
cc_274 N_4_17 N_CLK_3 0.0110298f $X=0.056 $Y=0.216
cc_275 N_4_16 N_CLK_3 0.0110422f $X=0.056 $Y=0.054
cc_276 N_4_1 N_CLK_3 0.00037986f $X=0.1335 $Y=0.135
cc_277 N_4_22 N_CLK_3 0.000490939f $X=0.018 $Y=0.163
cc_278 N_4_24 N_CLK_3 0.000661403f $X=0.036 $Y=0.234
cc_279 N_4_19 N_CLK_1 0.000964146f $X=0.0165 $Y=0.153
cc_280 N_4_23 N_CLK_7 0.000981649f $X=0.036 $Y=0.036
cc_281 N_4_24 N_CLK_8 0.00104547f $X=0.036 $Y=0.234
cc_282 N_4_25 N_CLK_4 0.00107731f $X=0.151 $Y=0.116
cc_283 N_4_21 N_CLK_4 0.00110066f $X=0.018 $Y=0.125
cc_284 N_4_19 N_CLK_5 0.00162476f $X=0.0165 $Y=0.153
cc_285 N_4_28 N_CLK_5 0.00163091f $X=0.0215 $Y=0.153
cc_286 N_4_23 N_CLK_4 0.0026067f $X=0.036 $Y=0.036
cc_287 N_4_1 N_CLK_1 0.00274424f $X=0.1335 $Y=0.135
cc_288 N_4_19 N_CLK_6 0.00318651f $X=0.0165 $Y=0.153
cc_289 N_4_25 N_CLK_5 0.00325848f $X=0.151 $Y=0.116
cc_290 N_4_13 N_CLK_3 0.0354558f $X=0.135 $Y=0.0245

* End of included file DFFHQx4_ASAP7_75t_R.pex.sp.pxi
.ends

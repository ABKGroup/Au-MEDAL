* Design:	MAJx2_ASAP7_75t_R
* Created:	"Thu Nov14 2024"
* Vendor:	"Mentor Graphics Corporation"
* Program:	"Calibre xACT 3D"
* Version:	"v2023.3_29.15"
* Corner Name: typical_25
* Nominal Temperature: 25C
* Circuit Temperature: 25C
*
* Integrated TICER reduction is not enabled.
* SHORT DELAY THRESHOLD: 2e-14
* Fill Mode: GF
* PEX REDUCE CC ABSOLUTE : disabled
* PEX REDUCE CC RATIO : disabled
* Delta transform mode : 344834

.subckt PM_MAJX2_ASAP7_75T_R%VSS vss 18 20 14 15 16 22 59 73 5 1 7 6
c1 1 vss 0.0221716f $X=0.09751 $Y=0.0
c2 5 vss 0.000714919f $X=0.108 $Y=0.0085
c3 6 vss 0.000349991f $X=0.324 $Y=0.0
c4 7 vss 0.00376878f $X=0.432 $Y=0.0
c5 14 vss 0.00685634f $X=0.0906 $Y=0.06751
c6 15 vss 0.00686345f $X=0.3067 $Y=0.06751
c7 16 vss 0.0298654f $X=0.4147 $Y=0.06751
c8 20 vss 0.00480961f $X=0.2431 $Y=0.0
r1 1 28 4.91914 $l=1.05e-08 $layer=LIG $X=0.09751 $Y=0.0 $X2=0.108 $Y2=0.0
r2 5 23 5.54939 $l=9.5e-09 $layer=LISD $X=0.108 $Y=0.0085 $X2=0.108 $Y2=0.018
r3 5 25 3.80936 $l=8.5e-09 $layer=LISD $X=0.108 $Y=0.0085 $X2=0.108 $Y2=0.0
r4 6 35 3.51728 $l=0 $layer=LISD $X=0.324 $Y=0.0 $X2=0.324 $Y2=0.0
r5 6 46 19.38 $l=1.8e-08 $layer=V0LISD $X=0.324 $Y=0.0 $X2=0.324 $Y2=0.0
r6 6 51 3.80936 $l=8.5e-09 $layer=LISD $X=0.324 $Y=0.0 $X2=0.324 $Y2=0.0085
r7 7 40 3.51728 $l=0 $layer=LISD $X=0.432 $Y=0.0 $X2=0.432 $Y2=0.0
r8 7 48 19.38 $l=1.8e-08 $layer=V0LISD $X=0.432 $Y=0.0 $X2=0.432 $Y2=0.0
r9 7 55 3.80936 $l=8.5e-09 $layer=LISD $X=0.432 $Y=0.0 $X2=0.432 $Y2=0.0085
r10 14 21 0.209877 $l=1.7e-08 $layer=N_src_drn $X=0.0906 $Y=0.06751 $X2=0.108
+ $Y2=0.06751
r11 15 53 0.209877 $l=1.7e-08 $layer=N_src_drn $X=0.3067 $Y=0.06751 $X2=0.324
+ $Y2=0.06751
r12 16 57 0.154321 $l=1.25e-08 $layer=N_src_drn $X=0.4147 $Y=0.06751 $X2=0.432
+ $Y2=0.06751
r13 20 43 14.6322 $l=6.33e-08 $layer=M1 $X=0.2431 $Y=0.0 $X2=0.1797 $Y2=0.0
r14 20 45 8.38604 $l=3.62e-08 $layer=M1 $X=0.2431 $Y=0.0 $X2=0.2791 $Y2=0.0
r15 22 21 0.209877 $l=1.7e-08 $layer=N_src_drn $X=0.1255 $Y=0.06751 $X2=0.108
+ $Y2=0.06751
r16 23 21 28.9152 $l=4.95e-08 $layer=LISD $X=0.108 $Y=0.018 $X2=0.108
+ $Y2=0.06751
r17 25 26 3.51728 $l=0 $layer=LISD $X=0.108 $Y=0.0 $X2=0.108 $Y2=0.0
r18 25 42 19.38 $l=1.8e-08 $layer=V0LISD $X=0.108 $Y=0.0 $X2=0.108 $Y2=0.0
r19 26 29 0.702734 $l=1.05e-08 $layer=LIG $X=0.108 $Y=0.0 $X2=0.1185 $Y2=0.0
r20 26 28 4.21641 $l=0 $layer=LIG $X=0.108 $Y=0.0 $X2=0.108 $Y2=0.0
r21 28 29 4.91914 $l=1.05e-08 $layer=LIG $X=0.108 $Y=0.0 $X2=0.1185 $Y2=0.0
r22 28 42 28.9688 $l=1.6e-08 $layer=V0LIG $X=0.108 $Y=0.0 $X2=0.108 $Y2=0.0
r23 29 31 222.489 $l=9.75e-08 $layer=LIG $X=0.1185 $Y=0.0 $X2=0.216 $Y2=0.0
r24 31 32 222.489 $l=9.75e-08 $layer=LIG $X=0.216 $Y=0.0 $X2=0.3134 $Y2=0.0
r25 32 33 4.91914 $l=1.05e-08 $layer=LIG $X=0.3134 $Y=0.0 $X2=0.324 $Y2=0.0
r26 33 34 4.91914 $l=1.05e-08 $layer=LIG $X=0.324 $Y=0.0 $X2=0.3345 $Y2=0.0
r27 33 35 4.21641 $l=0 $layer=LIG $X=0.324 $Y=0.0 $X2=0.324 $Y2=0.0
r28 33 46 28.9688 $l=1.6e-08 $layer=V0LIG $X=0.324 $Y=0.0 $X2=0.324 $Y2=0.0
r29 34 36 97.7343 $l=4.35e-08 $layer=LIG $X=0.3345 $Y=0.0 $X2=0.378 $Y2=0.0
r30 36 37 97.7343 $l=4.35e-08 $layer=LIG $X=0.378 $Y=0.0 $X2=0.4214 $Y2=0.0
r31 37 38 4.91914 $l=1.05e-08 $layer=LIG $X=0.4214 $Y=0.0 $X2=0.432 $Y2=0.0
r32 38 40 4.21641 $l=0 $layer=LIG $X=0.432 $Y=0.0 $X2=0.432 $Y2=0.0
r33 38 48 28.9688 $l=1.6e-08 $layer=V0LIG $X=0.432 $Y=0.0 $X2=0.432 $Y2=0.0
r34 42 43 16.5986 $l=7.17e-08 $layer=M1 $X=0.108 $Y=0.0 $X2=0.1797 $Y2=0.0
r35 45 46 10.3524 $l=4.48e-08 $layer=M1 $X=0.2791 $Y=0.0 $X2=0.324 $Y2=0.0
r36 46 47 12.4923 $l=5.4e-08 $layer=M1 $X=0.324 $Y=0.0 $X2=0.378 $Y2=0.0
r37 47 48 12.4923 $l=5.4e-08 $layer=M1 $X=0.378 $Y=0.0 $X2=0.432 $Y2=0.0
r38 51 52 5.54939 $l=9.5e-09 $layer=LISD $X=0.324 $Y=0.0085 $X2=0.324 $Y2=0.018
r39 52 53 28.9152 $l=4.95e-08 $layer=LISD $X=0.324 $Y=0.018 $X2=0.324
+ $Y2=0.06751
r40 55 56 5.54939 $l=9.5e-09 $layer=LISD $X=0.432 $Y=0.0085 $X2=0.432 $Y2=0.018
r41 56 57 28.9152 $l=4.95e-08 $layer=LISD $X=0.432 $Y=0.018 $X2=0.432
+ $Y2=0.06751
r42 59 53 0.209877 $l=1.7e-08 $layer=N_src_drn $X=0.3415 $Y=0.06751 $X2=0.324
+ $Y2=0.06751
.ends

.subckt PM_MAJX2_ASAP7_75T_R%C vss 5 3 4 11 24 1
c1 1 vss 0.0016729f $X=0.081 $Y=0.1351
c2 4 vss 0.00823554f $X=0.1351 $Y=0.06751
c3 5 vss 0.000280657f $X=0.108 $Y=0.1149
r1 1 9 4.6849 $l=0 $layer=LIG $X=0.081 $Y=0.1351 $X2=0.081 $Y2=0.1351
r2 1 14 43.9596 $l=2.7e-08 $layer=LIG $X=0.081 $Y=0.1351 $X2=0.108 $Y2=0.1351
r3 3 7 10.1531 $l=2.98e-08 $layer=Gate_1 $X=0.081 $Y=0.06751 $X2=0.081
+ $Y2=0.09729
r4 4 22 10.1531 $l=2.98e-08 $layer=Gate_1 $X=0.1351 $Y=0.06751 $X2=0.1351
+ $Y2=0.09729
r5 5 18 5.72564 $l=2.47e-08 $layer=M1 $X=0.108 $Y=0.1149 $X2=0.108 $Y2=0.1396
r6 7 8 12.9422 $l=3.77e-08 $layer=Gate_1 $X=0.081 $Y=0.09729 $X2=0.081
+ $Y2=0.1351
r7 8 9 2.85714 $l=0 $layer=Gate_1 $X=0.081 $Y=0.1351 $X2=0.081 $Y2=0.1351
r8 8 10 12.9422 $l=3.76e-08 $layer=Gate_1 $X=0.081 $Y=0.1351 $X2=0.081
+ $Y2=0.1725
r9 11 10 10.1531 $l=2.99e-08 $layer=Gate_1 $X=0.081 $Y=0.2025 $X2=0.081
+ $Y2=0.1725
r10 14 15 43.9596 $l=2.7e-08 $layer=LIG $X=0.108 $Y=0.1351 $X2=0.1351 $Y2=0.1351
r11 14 18 28.9688 $l=1.6e-08 $layer=V0LIG $X=0.108 $Y=0.1351 $X2=0.108
+ $Y2=0.1396
r12 15 21 4.6849 $l=0 $layer=LIG $X=0.1351 $Y=0.1351 $X2=0.1351 $Y2=0.1351
r13 19 21 2.85714 $l=0 $layer=Gate_1 $X=0.1351 $Y=0.1351 $X2=0.1351 $Y2=0.1351
r14 19 22 12.9422 $l=3.77e-08 $layer=Gate_1 $X=0.1351 $Y=0.1351 $X2=0.1351
+ $Y2=0.09729
r15 19 23 12.9422 $l=3.76e-08 $layer=Gate_1 $X=0.1351 $Y=0.1351 $X2=0.1351
+ $Y2=0.1725
r16 24 23 10.1531 $l=2.99e-08 $layer=Gate_1 $X=0.1351 $Y=0.2025 $X2=0.1351
+ $Y2=0.1725
.ends

.subckt PM_MAJX2_ASAP7_75T_R%VDD vss 17 18 14 15 16 20 57 65 7 6 5 1
c1 1 vss 0.0223141f $X=0.3134 $Y=0.27
c2 5 vss 0.000721624f $X=0.108 $Y=0.27
c3 6 vss 0.000352614f $X=0.324 $Y=0.2025
c4 7 vss 0.00377875f $X=0.432 $Y=0.27
c5 14 vss 0.00690752f $X=0.0906 $Y=0.2025
c6 15 vss 0.00691525f $X=0.3067 $Y=0.2025
c7 16 vss 0.0298992f $X=0.4147 $Y=0.2025
c8 18 vss 0.00484391f $X=0.2431 $Y=0.27
r1 1 26 4.91914 $l=1.05e-08 $layer=LIG $X=0.3134 $Y=0.27 $X2=0.324 $Y2=0.27
r2 1 28 222.489 $l=9.75e-08 $layer=LIG $X=0.3134 $Y=0.27 $X2=0.216 $Y2=0.27
r3 5 32 3.51728 $l=0 $layer=LISD $X=0.108 $Y=0.27 $X2=0.108 $Y2=0.27
r4 5 40 19.38 $l=1.8e-08 $layer=V0LISD $X=0.108 $Y=0.27 $X2=0.108 $Y2=0.27
r5 5 50 3.80936 $l=8.5e-09 $layer=LISD $X=0.108 $Y=0.27 $X2=0.108 $Y2=0.2616
r6 6 21 28.9152 $l=4.95e-08 $layer=LISD $X=0.324 $Y=0.2025 $X2=0.324 $Y2=0.252
r7 7 38 3.51728 $l=0 $layer=LISD $X=0.432 $Y=0.27 $X2=0.432 $Y2=0.27
r8 7 46 19.38 $l=1.8e-08 $layer=V0LISD $X=0.432 $Y=0.27 $X2=0.432 $Y2=0.27
r9 7 54 3.80936 $l=8.5e-09 $layer=LISD $X=0.432 $Y=0.27 $X2=0.432 $Y2=0.2616
r10 14 48 0.209877 $l=1.7e-08 $layer=P_src_drn $X=0.0906 $Y=0.2025 $X2=0.108
+ $Y2=0.2025
r11 15 6 0.209877 $l=1.7e-08 $layer=P_src_drn $X=0.3067 $Y=0.2025 $X2=0.324
+ $Y2=0.2025
r12 16 52 0.154321 $l=1.25e-08 $layer=P_src_drn $X=0.4147 $Y=0.2025 $X2=0.432
+ $Y2=0.2025
r13 18 41 14.6322 $l=6.33e-08 $layer=M1 $X=0.2431 $Y=0.27 $X2=0.1797 $Y2=0.27
r14 18 43 8.38604 $l=3.62e-08 $layer=M1 $X=0.2431 $Y=0.27 $X2=0.2791 $Y2=0.27
r15 20 6 0.209877 $l=1.7e-08 $layer=P_src_drn $X=0.3415 $Y=0.2025 $X2=0.324
+ $Y2=0.2025
r16 21 22 5.54939 $l=9.5e-09 $layer=LISD $X=0.324 $Y=0.252 $X2=0.324 $Y2=0.2616
r17 22 23 3.80936 $l=8.5e-09 $layer=LISD $X=0.324 $Y=0.2616 $X2=0.324 $Y2=0.27
r18 23 24 3.51728 $l=0 $layer=LISD $X=0.324 $Y=0.27 $X2=0.324 $Y2=0.27
r19 23 44 19.38 $l=1.8e-08 $layer=V0LISD $X=0.324 $Y=0.27 $X2=0.324 $Y2=0.27
r20 24 27 0.702734 $l=1.05e-08 $layer=LIG $X=0.324 $Y=0.27 $X2=0.3345 $Y2=0.27
r21 24 26 4.21641 $l=0 $layer=LIG $X=0.324 $Y=0.27 $X2=0.324 $Y2=0.27
r22 26 27 4.91914 $l=1.05e-08 $layer=LIG $X=0.324 $Y=0.27 $X2=0.3345 $Y2=0.27
r23 26 44 28.9688 $l=1.6e-08 $layer=V0LIG $X=0.324 $Y=0.27 $X2=0.324 $Y2=0.27
r24 27 34 97.7343 $l=4.35e-08 $layer=LIG $X=0.3345 $Y=0.27 $X2=0.378 $Y2=0.27
r25 28 31 222.489 $l=9.75e-08 $layer=LIG $X=0.216 $Y=0.27 $X2=0.1185 $Y2=0.27
r26 30 31 4.91914 $l=1.05e-08 $layer=LIG $X=0.108 $Y=0.27 $X2=0.1185 $Y2=0.27
r27 30 32 4.21641 $l=0 $layer=LIG $X=0.108 $Y=0.27 $X2=0.108 $Y2=0.27
r28 30 40 28.9688 $l=1.6e-08 $layer=V0LIG $X=0.108 $Y=0.27 $X2=0.108 $Y2=0.27
r29 34 35 97.7343 $l=4.35e-08 $layer=LIG $X=0.378 $Y=0.27 $X2=0.4214 $Y2=0.27
r30 35 36 4.91914 $l=1.05e-08 $layer=LIG $X=0.4214 $Y=0.27 $X2=0.432 $Y2=0.27
r31 36 38 4.21641 $l=0 $layer=LIG $X=0.432 $Y=0.27 $X2=0.432 $Y2=0.27
r32 36 46 28.9688 $l=1.6e-08 $layer=V0LIG $X=0.432 $Y=0.27 $X2=0.432 $Y2=0.27
r33 40 41 16.5986 $l=7.17e-08 $layer=M1 $X=0.108 $Y=0.27 $X2=0.1797 $Y2=0.27
r34 43 44 10.3524 $l=4.48e-08 $layer=M1 $X=0.2791 $Y=0.27 $X2=0.324 $Y2=0.27
r35 44 45 12.4923 $l=5.4e-08 $layer=M1 $X=0.324 $Y=0.27 $X2=0.378 $Y2=0.27
r36 45 46 12.4923 $l=5.4e-08 $layer=M1 $X=0.378 $Y=0.27 $X2=0.432 $Y2=0.27
r37 48 49 28.9152 $l=4.95e-08 $layer=LISD $X=0.108 $Y=0.2025 $X2=0.108 $Y2=0.252
r38 49 50 5.54939 $l=9.5e-09 $layer=LISD $X=0.108 $Y=0.252 $X2=0.108 $Y2=0.2616
r39 52 53 28.9152 $l=4.95e-08 $layer=LISD $X=0.432 $Y=0.2025 $X2=0.432 $Y2=0.252
r40 53 54 5.54939 $l=9.5e-09 $layer=LISD $X=0.432 $Y=0.252 $X2=0.432 $Y2=0.2616
r41 57 48 0.209877 $l=1.7e-08 $layer=P_src_drn $X=0.1255 $Y=0.2025 $X2=0.108
+ $Y2=0.2025
.ends

.subckt PM_MAJX2_ASAP7_75T_R%B vss 7 5 6 17 36 1 2 8 9
c1 1 vss 0.00111071f $X=0.1891 $Y=0.1351
c2 2 vss 0.0025525f $X=0.2971 $Y=0.1351
c3 6 vss 0.000448134f $X=0.2971 $Y=0.06751
c4 7 vss 0.000541769f $X=0.1891 $Y=0.1149
c5 8 vss 0.000647237f $X=0.2971 $Y=0.1279
c6 9 vss 0.00428371f $X=0.1776 $Y=0.1351
r1 1 33 4.6849 $l=0 $layer=LIG $X=0.1891 $Y=0.1351 $X2=0.1891 $Y2=0.1351
r2 1 28 28.9688 $l=1.6e-08 $layer=V0LIG $X=0.1891 $Y=0.1351 $X2=0.1891
+ $Y2=0.1396
r3 2 15 4.6849 $l=0 $layer=LIG $X=0.2971 $Y=0.1351 $X2=0.2971 $Y2=0.1351
r4 2 21 28.9688 $l=1.6e-08 $layer=V0LIG $X=0.2971 $Y=0.1351 $X2=0.2971
+ $Y2=0.1351
r5 5 34 10.1531 $l=2.98e-08 $layer=Gate_1 $X=0.1891 $Y=0.06751 $X2=0.1891
+ $Y2=0.09729
r6 6 13 10.1531 $l=2.98e-08 $layer=Gate_1 $X=0.2971 $Y=0.06751 $X2=0.2971
+ $Y2=0.09729
r7 7 28 5.72564 $l=2.47e-08 $layer=M1 $X=0.1891 $Y=0.1149 $X2=0.1891 $Y2=0.1396
r8 8 21 1.64251 $l=7.1e-09 $layer=M1 $X=0.2971 $Y=0.1279 $X2=0.2971 $Y2=0.1351
r9 9 23 2.6604 $l=1.15e-08 $layer=M2 $X=0.1776 $Y=0.1351 $X2=0.1891 $Y2=0.1351
r10 13 14 12.9422 $l=3.77e-08 $layer=Gate_1 $X=0.2971 $Y=0.09729 $X2=0.2971
+ $Y2=0.1351
r11 14 15 2.85714 $l=0 $layer=Gate_1 $X=0.2971 $Y=0.1351 $X2=0.2971 $Y2=0.1351
r12 14 16 12.9422 $l=3.76e-08 $layer=Gate_1 $X=0.2971 $Y=0.1351 $X2=0.2971
+ $Y2=0.1725
r13 17 16 10.1531 $l=2.99e-08 $layer=Gate_1 $X=0.2971 $Y=0.2025 $X2=0.2971
+ $Y2=0.1725
r14 21 25 19.38 $l=1.8e-08 $layer=V1 $X=0.2971 $Y=0.1351 $X2=0.2971 $Y2=0.1351
r15 23 24 12.4923 $l=5.4e-08 $layer=M2 $X=0.1891 $Y=0.1351 $X2=0.2431 $Y2=0.1351
r16 23 28 19.38 $l=1.8e-08 $layer=V1 $X=0.1891 $Y=0.1351 $X2=0.1891 $Y2=0.1396
r17 24 25 12.4923 $l=5.4e-08 $layer=M2 $X=0.2431 $Y=0.1351 $X2=0.2971 $Y2=0.1351
r18 31 33 2.85714 $l=0 $layer=Gate_1 $X=0.1891 $Y=0.1351 $X2=0.1891 $Y2=0.1351
r19 31 34 12.9422 $l=3.77e-08 $layer=Gate_1 $X=0.1891 $Y=0.1351 $X2=0.1891
+ $Y2=0.09729
r20 31 35 12.9422 $l=3.76e-08 $layer=Gate_1 $X=0.1891 $Y=0.1351 $X2=0.1891
+ $Y2=0.1725
r21 36 35 10.1531 $l=2.99e-08 $layer=Gate_1 $X=0.1891 $Y=0.2025 $X2=0.1891
+ $Y2=0.1725
.ends

.subckt PM_MAJX2_ASAP7_75T_R%A vss 4 3 10 1
c1 1 vss 0.00263787f $X=0.2431 $Y=0.1351
c2 4 vss 0.000513075f $X=0.2431 $Y=0.1149
r1 1 8 4.6849 $l=0 $layer=LIG $X=0.2431 $Y=0.1351 $X2=0.2431 $Y2=0.1351
r2 1 15 28.9688 $l=1.6e-08 $layer=V0LIG $X=0.2431 $Y=0.1351 $X2=0.2431
+ $Y2=0.1396
r3 3 6 10.1531 $l=2.98e-08 $layer=Gate_1 $X=0.2431 $Y=0.06751 $X2=0.2431
+ $Y2=0.09729
r4 4 15 5.72564 $l=2.47e-08 $layer=M1 $X=0.2431 $Y=0.1149 $X2=0.2431 $Y2=0.1396
r5 6 7 12.9422 $l=3.77e-08 $layer=Gate_1 $X=0.2431 $Y=0.09729 $X2=0.2431
+ $Y2=0.1351
r6 7 8 2.85714 $l=0 $layer=Gate_1 $X=0.2431 $Y=0.1351 $X2=0.2431 $Y2=0.1351
r7 7 9 12.9422 $l=3.76e-08 $layer=Gate_1 $X=0.2431 $Y=0.1351 $X2=0.2431
+ $Y2=0.1725
r8 10 9 10.1531 $l=2.99e-08 $layer=Gate_1 $X=0.2431 $Y=0.2025 $X2=0.2431
+ $Y2=0.1725
.ends

.subckt PM_MAJX2_ASAP7_75T_R%MAJI vss 9 10 11 12 27 40 57 59 3 13 1 14 21 17 19
+ 4 16 15 18 20
c1 1 vss 0.000995917f $X=0.3415 $Y=0.1351
c2 3 vss 0.000681345f $X=0.216 $Y=0.0299
c3 4 vss 0.00043269f $X=0.216 $Y=0.1821
c4 10 vss 0.00466344f $X=0.4051 $Y=0.06751
c5 11 vss 0.00403743f $X=0.1987 $Y=0.06751
c6 12 vss 0.00189822f $X=0.1987 $Y=0.2025
c7 13 vss 0.000141061f $X=0.324 $Y=0.036
c8 14 vss 0.000219234f $X=0.3511 $Y=0.072
c9 15 vss 0.000222888f $X=0.3511 $Y=0.198
c10 16 vss 0.000141622f $X=0.324 $Y=0.234
c11 19 vss 0.000100819f $X=0.324 $Y=0.054
c12 20 vss 0.000100798f $X=0.324 $Y=0.216
c13 21 vss 3.35801e-20 $X=0.3511 $Y=0.1351
r1 1 29 4.45065 $l=9.5e-09 $layer=LIG $X=0.3415 $Y=0.1351 $X2=0.3511 $Y2=0.1351
r2 3 48 3.56329 $l=6.1e-09 $layer=LISD $X=0.216 $Y=0.0299 $X2=0.216 $Y2=0.036
r3 4 52 11.8874 $l=2.04e-08 $layer=LISD $X=0.216 $Y=0.1821 $X2=0.216 $Y2=0.2025
r4 9 23 10.1531 $l=2.98e-08 $layer=Gate_1 $X=0.3511 $Y=0.06751 $X2=0.3511
+ $Y2=0.09729
r5 10 38 10.1531 $l=2.98e-08 $layer=Gate_1 $X=0.4051 $Y=0.06751 $X2=0.4051
+ $Y2=0.09729
r6 11 50 0.209877 $l=1.7e-08 $layer=N_src_drn $X=0.1987 $Y=0.06751 $X2=0.216
+ $Y2=0.06751
r7 12 52 0.209877 $l=1.7e-08 $layer=P_src_drn $X=0.1987 $Y=0.2025 $X2=0.216
+ $Y2=0.2025
r8 13 19 2.52808 $l=1.8e-08 $layer=M1 $X=0.324 $Y=0.036 $X2=0.324 $Y2=0.054
r9 13 46 10.8563 $l=5.4e-08 $layer=M1 $X=0.324 $Y=0.036 $X2=0.27 $Y2=0.036
r10 14 21 13.4034 $l=6.3e-08 $layer=M1 $X=0.3511 $Y=0.072 $X2=0.3511 $Y2=0.1351
r11 14 42 1.95214 $l=1.35e-08 $layer=M1 $X=0.3511 $Y=0.072 $X2=0.3374 $Y2=0.072
r12 15 21 13.4034 $l=6.3e-08 $layer=M1 $X=0.3511 $Y=0.198 $X2=0.3511 $Y2=0.1351
r13 15 44 1.95214 $l=1.35e-08 $layer=M1 $X=0.3511 $Y=0.198 $X2=0.3374 $Y2=0.198
r14 16 20 2.52808 $l=1.8e-08 $layer=M1 $X=0.324 $Y=0.234 $X2=0.324 $Y2=0.216
r15 16 47 10.8563 $l=5.4e-08 $layer=M1 $X=0.324 $Y=0.234 $X2=0.27 $Y2=0.234
r16 17 46 12.4923 $l=5.4e-08 $layer=M1 $X=0.216 $Y=0.036 $X2=0.27 $Y2=0.036
r17 17 48 19.38 $l=1.8e-08 $layer=V0LISD $X=0.216 $Y=0.036 $X2=0.216 $Y2=0.036
r18 18 47 12.4923 $l=5.4e-08 $layer=M1 $X=0.216 $Y=0.234 $X2=0.27 $Y2=0.234
r19 18 54 19.38 $l=1.8e-08 $layer=V0LISD $X=0.216 $Y=0.234 $X2=0.216 $Y2=0.234
r20 19 43 2.99316 $l=1.8e-08 $layer=M1 $X=0.324 $Y=0.054 $X2=0.324 $Y2=0.072
r21 20 45 2.99316 $l=1.8e-08 $layer=M1 $X=0.324 $Y=0.216 $X2=0.324 $Y2=0.198
r22 21 29 28.9688 $l=1.6e-08 $layer=V0LIG $X=0.3511 $Y=0.1351 $X2=0.3511
+ $Y2=0.1351
r23 23 24 12.9422 $l=3.77e-08 $layer=Gate_1 $X=0.3511 $Y=0.09729 $X2=0.3511
+ $Y2=0.1351
r24 24 25 2.85714 $l=0 $layer=Gate_1 $X=0.3511 $Y=0.1351 $X2=0.3511 $Y2=0.1351
r25 24 26 12.9422 $l=3.76e-08 $layer=Gate_1 $X=0.3511 $Y=0.1351 $X2=0.3511
+ $Y2=0.1725
r26 25 30 0.234245 $l=9.5e-09 $layer=LIG $X=0.3511 $Y=0.1351 $X2=0.3604
+ $Y2=0.1351
r27 25 29 4.21641 $l=0 $layer=LIG $X=0.3511 $Y=0.1351 $X2=0.3511 $Y2=0.1351
r28 27 26 10.1531 $l=2.99e-08 $layer=Gate_1 $X=0.3511 $Y=0.2025 $X2=0.3511
+ $Y2=0.1725
r29 29 30 4.45065 $l=9.5e-09 $layer=LIG $X=0.3511 $Y=0.1351 $X2=0.3604
+ $Y2=0.1351
r30 30 32 39.5089 $l=1.75e-08 $layer=LIG $X=0.3604 $Y=0.1351 $X2=0.378
+ $Y2=0.1351
r31 32 33 43.9596 $l=2.7e-08 $layer=LIG $X=0.378 $Y=0.1351 $X2=0.4051 $Y2=0.1351
r32 33 37 4.6849 $l=0 $layer=LIG $X=0.4051 $Y=0.1351 $X2=0.4051 $Y2=0.1351
r33 35 37 2.85714 $l=0 $layer=Gate_1 $X=0.4051 $Y=0.1351 $X2=0.4051 $Y2=0.1351
r34 35 38 12.9422 $l=3.77e-08 $layer=Gate_1 $X=0.4051 $Y=0.1351 $X2=0.4051
+ $Y2=0.09729
r35 35 39 12.9422 $l=3.76e-08 $layer=Gate_1 $X=0.4051 $Y=0.1351 $X2=0.4051
+ $Y2=0.1725
r36 40 39 10.1531 $l=2.99e-08 $layer=Gate_1 $X=0.4051 $Y=0.2025 $X2=0.4051
+ $Y2=0.1725
r37 42 43 1.95214 $l=1.35e-08 $layer=M1 $X=0.3374 $Y=0.072 $X2=0.324 $Y2=0.072
r38 44 45 1.95214 $l=1.35e-08 $layer=M1 $X=0.3374 $Y=0.198 $X2=0.324 $Y2=0.198
r39 48 49 9.2003 $l=1.57e-08 $layer=LISD $X=0.216 $Y=0.036 $X2=0.216 $Y2=0.05169
r40 49 50 9.2003 $l=1.58e-08 $layer=LISD $X=0.216 $Y=0.05169 $X2=0.216
+ $Y2=0.06751
r41 52 53 9.2003 $l=1.57e-08 $layer=LISD $X=0.216 $Y=0.2025 $X2=0.216 $Y2=0.2181
r42 53 54 9.2003 $l=1.58e-08 $layer=LISD $X=0.216 $Y=0.2181 $X2=0.216 $Y2=0.234
r43 57 50 0.209877 $l=1.7e-08 $layer=N_src_drn $X=0.2335 $Y=0.06751 $X2=0.216
+ $Y2=0.06751
r44 59 52 0.209877 $l=1.7e-08 $layer=P_src_drn $X=0.2335 $Y=0.2025 $X2=0.216
+ $Y2=0.2025
.ends

.subckt PM_MAJX2_ASAP7_75T_R%NET1 vss 7 8 22 1 2 9
c1 1 vss 0.00256902f $X=0.054 $Y=0.04711
c2 2 vss 0.000390062f $X=0.27 $Y=0.04711
c3 7 vss 0.028024f $X=0.0714 $Y=0.06751
c4 8 vss 0.00369034f $X=0.2527 $Y=0.06751
c5 9 vss 0.00134712f $X=0.054 $Y=0.072
r1 1 10 11.8874 $l=2.04e-08 $layer=LISD $X=0.054 $Y=0.04711 $X2=0.05851
+ $Y2=0.06751
r2 2 17 11.8874 $l=2.04e-08 $layer=LISD $X=0.27 $Y=0.04711 $X2=0.27 $Y2=0.06751
r3 7 10 0.154321 $l=1.25e-08 $layer=N_src_drn $X=0.0714 $Y=0.06751 $X2=0.05851
+ $Y2=0.06751
r4 8 17 0.209877 $l=1.7e-08 $layer=N_src_drn $X=0.2527 $Y=0.06751 $X2=0.27
+ $Y2=0.06751
r5 9 15 24.9846 $l=1.08e-07 $layer=M1 $X=0.054 $Y=0.072 $X2=0.162 $Y2=0.072
r6 9 13 19.38 $l=1.8e-08 $layer=V0LISD $X=0.054 $Y=0.072 $X2=0.054 $Y2=0.072
r7 10 12 1.31433 $l=2.2e-09 $layer=LISD $X=0.05851 $Y=0.06751 $X2=0.054
+ $Y2=0.06969
r8 12 13 1.31433 $l=2.3e-09 $layer=LISD $X=0.054 $Y=0.06969 $X2=0.054 $Y2=0.072
r9 15 16 24.9846 $l=1.08e-07 $layer=M1 $X=0.162 $Y=0.072 $X2=0.27 $Y2=0.072
r10 16 19 19.38 $l=1.8e-08 $layer=V0LISD $X=0.27 $Y=0.072 $X2=0.27 $Y2=0.072
r11 17 18 1.31433 $l=2.2e-09 $layer=LISD $X=0.27 $Y=0.06751 $X2=0.27 $Y2=0.06969
r12 18 19 1.31433 $l=2.3e-09 $layer=LISD $X=0.27 $Y=0.06969 $X2=0.27 $Y2=0.072
r13 22 17 0.209877 $l=1.7e-08 $layer=N_src_drn $X=0.2875 $Y=0.06751 $X2=0.27
+ $Y2=0.06751
.ends

.subckt PM_MAJX2_ASAP7_75T_R%NET3 vss 7 8 11 1 9 2
c1 1 vss 0.00249891f $X=0.054 $Y=0.18
c2 2 vss 0.000342599f $X=0.27 $Y=0.18
c3 7 vss 0.0276593f $X=0.0714 $Y=0.2025
c4 8 vss 0.00322913f $X=0.2527 $Y=0.2025
c5 9 vss 0.00117759f $X=0.054 $Y=0.198
r1 1 18 10.573 $l=1.81e-08 $layer=LISD $X=0.054 $Y=0.18 $X2=0.054 $Y2=0.198
r2 2 12 10.573 $l=1.81e-08 $layer=LISD $X=0.27 $Y=0.18 $X2=0.27 $Y2=0.198
r3 7 20 0.154321 $l=1.25e-08 $layer=P_src_drn $X=0.0714 $Y=0.2025 $X2=0.054
+ $Y2=0.2025
r4 8 10 0.209877 $l=1.7e-08 $layer=P_src_drn $X=0.2527 $Y=0.2025 $X2=0.27
+ $Y2=0.2025
r5 9 16 24.9846 $l=1.08e-07 $layer=M1 $X=0.054 $Y=0.198 $X2=0.162 $Y2=0.198
r6 9 18 19.38 $l=1.8e-08 $layer=V0LISD $X=0.054 $Y=0.198 $X2=0.054 $Y2=0.198
r7 11 10 0.209877 $l=1.7e-08 $layer=P_src_drn $X=0.2875 $Y=0.2025 $X2=0.27
+ $Y2=0.2025
r8 12 13 1.31433 $l=2.2e-09 $layer=LISD $X=0.27 $Y=0.198 $X2=0.27 $Y2=0.2001
r9 12 17 19.38 $l=1.8e-08 $layer=V0LISD $X=0.27 $Y=0.198 $X2=0.27 $Y2=0.198
r10 13 10 1.31433 $l=2.3e-09 $layer=LISD $X=0.27 $Y=0.2001 $X2=0.27 $Y2=0.2025
r11 16 17 24.9846 $l=1.08e-07 $layer=M1 $X=0.162 $Y=0.198 $X2=0.27 $Y2=0.198
r12 18 19 1.31433 $l=2.2e-09 $layer=LISD $X=0.054 $Y=0.198 $X2=0.054 $Y2=0.2001
r13 19 20 1.31433 $l=2.3e-09 $layer=LISD $X=0.054 $Y=0.2001 $X2=0.054 $Y2=0.2025
.ends

.subckt PM_MAJX2_ASAP7_75T_R%Y vss 11 7 8 13 29 1 9 10 2
c1 1 vss 0.00025157f $X=0.378 $Y=0.0299
c2 2 vss 0.000189689f $X=0.378 $Y=0.1821
c3 7 vss 0.00305228f $X=0.3607 $Y=0.06751
c4 8 vss 0.00132974f $X=0.3607 $Y=0.2025
c5 11 vss 0.000971571f $X=0.4051 $Y=0.1149
r1 1 14 3.56329 $l=6.1e-09 $layer=LISD $X=0.378 $Y=0.0299 $X2=0.378 $Y2=0.036
r2 2 24 11.8874 $l=2.04e-08 $layer=LISD $X=0.378 $Y=0.1821 $X2=0.378 $Y2=0.2025
r3 7 12 0.209877 $l=1.7e-08 $layer=N_src_drn $X=0.3607 $Y=0.06751 $X2=0.378
+ $Y2=0.06751
r4 8 24 0.209877 $l=1.7e-08 $layer=P_src_drn $X=0.3607 $Y=0.2025 $X2=0.378
+ $Y2=0.2025
r5 9 18 3.12308 $l=1.35e-08 $layer=M1 $X=0.378 $Y=0.036 $X2=0.3914 $Y2=0.036
r6 9 14 19.38 $l=1.8e-08 $layer=V0LISD $X=0.378 $Y=0.036 $X2=0.378 $Y2=0.036
r7 10 21 13.1118 $l=6.38e-08 $layer=M1 $X=0.4051 $Y=0.234 $X2=0.4051 $Y2=0.1701
r8 10 23 1.48705 $l=1.35e-08 $layer=M1 $X=0.4051 $Y=0.234 $X2=0.3914 $Y2=0.234
r9 11 20 8.1547 $l=3.53e-08 $layer=M1 $X=0.4051 $Y=0.1149 $X2=0.4051 $Y2=0.0797
r10 11 21 12.7815 $l=5.52e-08 $layer=M1 $X=0.4051 $Y=0.1149 $X2=0.4051
+ $Y2=0.1701
r11 13 12 0.209877 $l=1.7e-08 $layer=N_src_drn $X=0.3955 $Y=0.06751 $X2=0.378
+ $Y2=0.06751
r12 14 15 9.2003 $l=1.57e-08 $layer=LISD $X=0.378 $Y=0.036 $X2=0.378 $Y2=0.05169
r13 15 12 9.2003 $l=1.58e-08 $layer=LISD $X=0.378 $Y=0.05169 $X2=0.378
+ $Y2=0.06751
r14 18 19 1.48705 $l=1.35e-08 $layer=M1 $X=0.3914 $Y=0.036 $X2=0.4051 $Y2=0.036
r15 19 20 8.48506 $l=4.37e-08 $layer=M1 $X=0.4051 $Y=0.036 $X2=0.4051 $Y2=0.0797
r16 22 23 3.12308 $l=1.35e-08 $layer=M1 $X=0.378 $Y=0.234 $X2=0.3914 $Y2=0.234
r17 22 26 19.38 $l=1.8e-08 $layer=V0LISD $X=0.378 $Y=0.234 $X2=0.378 $Y2=0.234
r18 24 25 9.2003 $l=1.57e-08 $layer=LISD $X=0.378 $Y=0.2025 $X2=0.378 $Y2=0.2181
r19 25 26 9.2003 $l=1.58e-08 $layer=LISD $X=0.378 $Y=0.2181 $X2=0.378 $Y2=0.234
r20 29 24 0.209877 $l=1.7e-08 $layer=P_src_drn $X=0.3955 $Y=0.2025 $X2=0.378
+ $Y2=0.2025
.ends

.subckt PM_MAJX2_ASAP7_75T_R%NET17 vss 1 3
c1 1 vss 0.00230115f $X=0.1447 $Y=0.06751
r1 1 2 0.209877 $l=1.7e-08 $layer=N_src_drn $X=0.1447 $Y=0.06751 $X2=0.162
+ $Y2=0.06751
r2 3 2 0.209877 $l=1.7e-08 $layer=N_src_drn $X=0.1795 $Y=0.06751 $X2=0.162
+ $Y2=0.06751
.ends

.subckt PM_MAJX2_ASAP7_75T_R%NET16 vss 1 3
c1 1 vss 0.00230132f $X=0.1447 $Y=0.2025
r1 1 2 0.209877 $l=1.7e-08 $layer=P_src_drn $X=0.1447 $Y=0.2025 $X2=0.162
+ $Y2=0.2025
r2 3 2 0.209877 $l=1.7e-08 $layer=P_src_drn $X=0.1795 $Y=0.2025 $X2=0.162
+ $Y2=0.2025
.ends

*
.SUBCKT MAJx2_ASAP7_75t_R VSS C VDD B A Y
*
* VSS VSS
* C C
* VDD VDD
* B B
* A A
* Y Y
*
*

MM2 N_MM2_d N_MM2_g N_MM2_s N_MM10@2_b nmos_rvt L=2e-08 W=8.1e-08 nfin=3
MM4 N_MM4_d N_MM4_g N_MM4_s N_MM10@2_b nmos_rvt L=2e-08 W=8.1e-08 nfin=3
MM3 N_MM3_d N_MM3_g N_MM3_s N_MM10@2_b nmos_rvt L=2e-08 W=8.1e-08 nfin=3
MM0 N_MM0_d N_MM0_g N_MM0_s N_MM10@2_b nmos_rvt L=2e-08 W=8.1e-08 nfin=3
MM1 N_MM1_d N_MM1_g N_MM1_s N_MM10@2_b nmos_rvt L=2e-08 W=8.1e-08 nfin=3
MM10 N_MM10_d N_MM10_g N_MM10_s N_MM10@2_b nmos_rvt L=2e-08 W=8.1e-08 nfin=3
MM10@2 N_MM10@2_d N_MM10@2_g N_MM10@2_s N_MM10@2_b nmos_rvt L=2e-08 W=8.1e-08
+ nfin=3
MM7 N_MM7_d N_MM7_g N_MM7_s N_MM5_b pmos_rvt L=2e-08 W=8.1e-08 nfin=3
MM9 N_MM9_d N_MM9_g N_MM9_s N_MM5_b pmos_rvt L=2e-08 W=8.1e-08 nfin=3
MM8 N_MM8_d N_MM8_g N_MM8_s N_MM5_b pmos_rvt L=2e-08 W=8.1e-08 nfin=3
MM5 N_MM5_d N_MM5_g N_MM5_s N_MM5_b pmos_rvt L=2e-08 W=8.1e-08 nfin=3
MM6 N_MM6_d N_MM6_g N_MM6_s N_MM5_b pmos_rvt L=2e-08 W=8.1e-08 nfin=3
MM11 N_MM11_d N_MM11_g N_MM11_s N_MM5_b pmos_rvt L=2e-08 W=8.1e-08 nfin=3
MM11@2 N_MM11@2_d N_MM11@2_g N_MM11@2_s N_MM5_b pmos_rvt L=2e-08 W=8.1e-08
+ nfin=3

x_PM_MAJX2_ASAP7_75T_R%VSS vss VSS VSS N_MM2_s N_MM1_s N_MM10@2_s N_MM4_s
+ N_MM10_s N_MM10@2_b N_VSS_5 N_VSS_1 N_VSS_7 N_VSS_6 PM_MAJX2_ASAP7_75T_R%VSS
x_PM_MAJX2_ASAP7_75T_R%C vss C N_MM2_g N_MM4_g N_MM7_g N_MM9_g N_C_1
+ PM_MAJX2_ASAP7_75T_R%C
cc_1 N_MM4_G N_VSS_1 0.00257232f $X=0.1351 $Y=0.06751
cc_2 N_MM2_G N_VSS_1 8.74416e-21 $X=0.081 $Y=0.06751
cc_3 N_C_1 N_VSS_5 0.000263859f $X=0.081 $Y=0.1351
cc_4 N_MM2_G N_VSS_5 0.00219601f $X=0.081 $Y=0.06751
cc_5 C N_VSS_5 0.000352293f $X=0.108 $Y=0.1149
cc_6 N_C_1 N_MM2_S 0.00191997f $X=0.081 $Y=0.1351
cc_7 N_MM2_G N_MM2_S 0.0569821f $X=0.081 $Y=0.06751
cc_8 N_MM4_G N_MM2_S 0.0205983f $X=0.1351 $Y=0.06751
x_PM_MAJX2_ASAP7_75T_R%VDD vss VDD VDD N_MM7_s N_MM6_s N_MM11@2_s N_MM11_s
+ N_MM9_s N_MM5_b N_VDD_7 N_VDD_6 N_VDD_5 N_VDD_1 PM_MAJX2_ASAP7_75T_R%VDD
cc_9 VDD N_VSS_6 0.000343296f $X=0.2431 $Y=0.27
cc_10 N_MM11@2_S N_VSS_7 0.000258335f $X=0.4147 $Y=0.2025
cc_11 N_VDD_7 N_MM10@2_S 0.000258335f $X=0.432 $Y=0.27
cc_12 N_VDD_6 VSS 0.00034309f $X=0.324 $Y=0.2025
cc_13 N_MM7_S N_C_1 0.00191999f $X=0.0906 $Y=0.2025
cc_14 N_VDD_5 N_C_1 0.000263938f $X=0.108 $Y=0.27
cc_15 N_VDD_1 N_MM2_G 8.74416e-21 $X=0.3134 $Y=0.27
cc_16 N_VDD_5 N_MM2_G 0.00219601f $X=0.108 $Y=0.27
cc_17 N_MM7_S N_MM2_G 0.0549741f $X=0.0906 $Y=0.2025
cc_18 N_VDD_1 N_MM4_G 0.00254893f $X=0.3134 $Y=0.27
cc_19 N_MM7_S N_MM4_G 0.0226114f $X=0.0906 $Y=0.2025
cc_20 N_VDD_5 C 0.00035223f $X=0.108 $Y=0.27
x_PM_MAJX2_ASAP7_75T_R%B vss B N_MM3_g N_MM1_g N_MM6_g N_MM8_g N_B_1 N_B_2
+ N_B_8 N_B_9 PM_MAJX2_ASAP7_75T_R%B
cc_21 N_MM3_G N_VSS_1 0.00259373f $X=0.1891 $Y=0.06751
cc_22 N_B_1 N_VSS_5 3.59155e-20 $X=0.1891 $Y=0.1351
cc_23 N_MM3_G N_VSS_5 9.28393e-20 $X=0.1891 $Y=0.06751
cc_24 B N_VSS_5 0.000128995f $X=0.1891 $Y=0.1149
cc_25 N_B_2 N_VSS_6 0.000201711f $X=0.2971 $Y=0.1351
cc_26 N_MM1_G N_VSS_6 0.000816619f $X=0.2971 $Y=0.06751
cc_27 N_B_8 N_VSS_6 9.42697e-20 $X=0.2971 $Y=0.1279
cc_28 N_B_1 N_MM2_S 9.14784e-20 $X=0.1891 $Y=0.1351
cc_29 N_MM3_G N_MM2_S 0.00158918f $X=0.1891 $Y=0.06751
cc_30 N_B_2 N_MM1_S 0.000596238f $X=0.2971 $Y=0.1351
cc_31 N_MM1_G N_MM1_S 0.0383332f $X=0.2971 $Y=0.06751
cc_32 N_MM3_G VSS 0.000702741f $X=0.1891 $Y=0.06751
cc_33 N_B_9 VSS 0.000598266f $X=0.1776 $Y=0.1351
cc_34 N_B_1 N_C_1 0.00170863f $X=0.1891 $Y=0.1351
cc_35 B N_C_1 0.000369728f $X=0.1891 $Y=0.1149
cc_36 N_MM3_G N_MM4_G 0.00627036f $X=0.1891 $Y=0.06751
cc_37 B C 0.000699757f $X=0.1891 $Y=0.1149
cc_38 N_B_9 C 0.00020767f $X=0.1776 $Y=0.1351
cc_39 N_MM1_G N_VDD_1 0.00267188f $X=0.2971 $Y=0.06751
cc_40 N_B_1 N_VDD_5 3.59192e-20 $X=0.1891 $Y=0.1351
cc_41 N_MM3_G N_VDD_5 9.10415e-20 $X=0.1891 $Y=0.06751
cc_42 B N_VDD_5 0.000127163f $X=0.1891 $Y=0.1149
cc_43 N_B_2 N_VDD_6 0.000183734f $X=0.2971 $Y=0.1351
cc_44 N_MM1_G N_VDD_6 0.000867716f $X=0.2971 $Y=0.06751
cc_45 N_B_8 N_VDD_6 0.000187006f $X=0.2971 $Y=0.1279
cc_46 N_B_1 N_MM7_S 9.14128e-20 $X=0.1891 $Y=0.1351
cc_47 N_MM3_G N_MM7_S 0.00158778f $X=0.1891 $Y=0.06751
cc_48 N_B_2 N_MM6_S 0.000595323f $X=0.2971 $Y=0.1351
cc_49 N_MM1_G N_MM6_S 0.0383185f $X=0.2971 $Y=0.06751
cc_50 N_MM3_G VDD 0.000713964f $X=0.1891 $Y=0.06751
cc_51 N_B_9 VDD 0.000597073f $X=0.1776 $Y=0.1351
x_PM_MAJX2_ASAP7_75T_R%A vss A N_MM0_g N_MM5_g N_A_1 PM_MAJX2_ASAP7_75T_R%A
cc_52 N_MM0_G N_VSS_1 0.0011456f $X=0.2431 $Y=0.06751
cc_53 N_MM0_G N_VSS_6 6.12803e-20 $X=0.2431 $Y=0.06751
cc_54 N_MM0_G N_MM1_S 0.00103916f $X=0.2431 $Y=0.06751
cc_55 N_MM0_G N_VDD_1 0.00116277f $X=0.2431 $Y=0.06751
cc_56 N_MM0_G N_MM6_S 0.00103926f $X=0.2431 $Y=0.06751
cc_57 N_A_1 N_B_1 0.00231126f $X=0.2431 $Y=0.1351
cc_58 N_A_1 N_B_2 0.001248f $X=0.2431 $Y=0.1351
cc_59 N_MM0_G N_MM3_G 0.00483351f $X=0.2431 $Y=0.06751
cc_60 N_MM0_G N_MM1_G 0.00160242f $X=0.2431 $Y=0.06751
cc_61 A B 0.00356862f $X=0.2431 $Y=0.1149
cc_62 A N_B_8 0.000783373f $X=0.2431 $Y=0.1149
cc_63 A N_B_9 0.000732696f $X=0.2431 $Y=0.1149
x_PM_MAJX2_ASAP7_75T_R%MAJI vss N_MM10_g N_MM10@2_g N_MM3_d N_MM8_d N_MM11_g
+ N_MM11@2_g N_MM0_d N_MM5_d N_MAJI_3 N_MAJI_13 N_MAJI_1 N_MAJI_14 N_MAJI_21
+ N_MAJI_17 N_MAJI_19 N_MAJI_4 N_MAJI_16 N_MAJI_15 N_MAJI_18 N_MAJI_20
+ PM_MAJX2_ASAP7_75T_R%MAJI
cc_64 N_MAJI_3 N_VSS_1 0.00158937f $X=0.216 $Y=0.0299
cc_65 N_MM3_D N_VSS_1 0.00637369f $X=0.1987 $Y=0.06751
cc_66 N_MAJI_13 N_VSS_1 0.000294804f $X=0.324 $Y=0.036
cc_67 N_MM10@2_G N_VSS_1 1.22991e-20 $X=0.4051 $Y=0.06751
cc_68 N_MM3_D N_VSS_5 0.000429089f $X=0.1987 $Y=0.06751
cc_69 N_MAJI_1 N_VSS_6 0.000193965f $X=0.3415 $Y=0.1351
cc_70 N_MM10_G N_VSS_6 0.0020838f $X=0.3511 $Y=0.06751
cc_71 N_MAJI_14 N_VSS_6 0.000774361f $X=0.3511 $Y=0.072
cc_72 N_MAJI_21 N_VSS_6 0.000419782f $X=0.3511 $Y=0.1351
cc_73 N_MM10@2_G N_VSS_7 0.000779357f $X=0.4051 $Y=0.06751
cc_74 N_MAJI_3 N_VSS_5 1.85918e-20 $X=0.216 $Y=0.0299
cc_75 N_MAJI_13 N_VSS_6 0.000390526f $X=0.324 $Y=0.036
cc_76 N_MAJI_1 N_MM1_S 0.00140986f $X=0.3415 $Y=0.1351
cc_77 N_MM10_G N_MM1_S 0.0384141f $X=0.3511 $Y=0.06751
cc_78 N_MM10@2_G N_MM10@2_S 0.0387057f $X=0.4051 $Y=0.06751
cc_79 N_MAJI_3 VSS 0.00105414f $X=0.216 $Y=0.0299
cc_80 N_MAJI_13 VSS 0.00141567f $X=0.324 $Y=0.036
cc_81 N_MAJI_17 VSS 0.0100901f $X=0.216 $Y=0.036
cc_82 N_MAJI_19 VSS 0.000303857f $X=0.324 $Y=0.054
cc_83 N_MM8_D N_C_1 0.000333236f $X=0.1987 $Y=0.2025
cc_84 N_MAJI_4 N_C_1 3.57664e-20 $X=0.216 $Y=0.1821
cc_85 N_MAJI_3 N_MM4_G 0.000116474f $X=0.216 $Y=0.0299
cc_86 N_MAJI_4 N_MM4_G 0.000116474f $X=0.216 $Y=0.1821
cc_87 N_MAJI_4 C 7.66997e-20 $X=0.216 $Y=0.1821
cc_88 N_MAJI_4 N_VDD_1 0.00158937f $X=0.216 $Y=0.1821
cc_89 N_MM8_D N_VDD_1 0.00615713f $X=0.1987 $Y=0.2025
cc_90 N_MAJI_16 N_VDD_1 0.000294804f $X=0.324 $Y=0.234
cc_91 N_MM10@2_G N_VDD_1 1.22991e-20 $X=0.4051 $Y=0.06751
cc_92 N_MM8_D N_VDD_5 0.000429089f $X=0.1987 $Y=0.2025
cc_93 N_MAJI_1 N_VDD_6 0.000192463f $X=0.3415 $Y=0.1351
cc_94 N_MM10_G N_VDD_6 0.00206489f $X=0.3511 $Y=0.06751
cc_95 N_MAJI_15 N_VDD_6 0.000726426f $X=0.3511 $Y=0.198
cc_96 N_MAJI_21 N_VDD_6 0.000374512f $X=0.3511 $Y=0.1351
cc_97 N_MM10@2_G N_VDD_7 0.000779357f $X=0.4051 $Y=0.06751
cc_98 N_MAJI_4 N_VDD_5 1.85918e-20 $X=0.216 $Y=0.1821
cc_99 N_MAJI_16 N_VDD_6 0.000390526f $X=0.324 $Y=0.234
cc_100 N_MAJI_1 N_MM6_S 0.00140919f $X=0.3415 $Y=0.1351
cc_101 N_MM10_G N_MM6_S 0.0383772f $X=0.3511 $Y=0.06751
cc_102 N_MM10@2_G N_MM11@2_S 0.0387165f $X=0.4051 $Y=0.06751
cc_103 N_MAJI_4 VDD 0.00105414f $X=0.216 $Y=0.1821
cc_104 N_MAJI_16 VDD 0.00141559f $X=0.324 $Y=0.234
cc_105 N_MAJI_18 VDD 0.0100837f $X=0.216 $Y=0.234
cc_106 N_MAJI_20 VDD 0.000303797f $X=0.324 $Y=0.216
cc_107 N_MM8_D N_B_1 0.00129815f $X=0.1987 $Y=0.2025
cc_108 N_MAJI_1 N_B_2 0.00110344f $X=0.3415 $Y=0.1351
cc_109 N_MAJI_4 N_B_1 0.000468433f $X=0.216 $Y=0.1821
cc_110 N_MAJI_3 N_MM3_G 0.00114979f $X=0.216 $Y=0.0299
cc_111 N_MAJI_4 N_MM3_G 0.00114979f $X=0.216 $Y=0.1821
cc_112 N_MM3_D N_MM3_G 0.0186185f $X=0.1987 $Y=0.06751
cc_113 N_MM8_D N_MM3_G 0.057683f $X=0.1987 $Y=0.2025
cc_114 N_MM10_G N_MM1_G 0.00325345f $X=0.3511 $Y=0.06751
cc_115 N_MAJI_4 B 0.000387872f $X=0.216 $Y=0.1821
cc_116 N_MAJI_13 N_B_8 0.000102785f $X=0.324 $Y=0.036
cc_117 N_MAJI_14 N_B_8 0.000541624f $X=0.3511 $Y=0.072
cc_118 N_MAJI_15 N_B_8 0.000750547f $X=0.3511 $Y=0.198
cc_119 N_MAJI_16 N_B_8 0.000103429f $X=0.324 $Y=0.234
cc_120 N_MAJI_17 N_B_8 0.000308413f $X=0.216 $Y=0.036
cc_121 N_MAJI_18 N_B_8 0.000340114f $X=0.216 $Y=0.234
cc_122 N_MAJI_19 N_B_8 0.000144805f $X=0.324 $Y=0.054
cc_123 N_MAJI_20 N_B_8 0.000144795f $X=0.324 $Y=0.216
cc_124 N_MAJI_21 N_B_8 0.00333863f $X=0.3511 $Y=0.1351
cc_125 N_MAJI_18 N_B_9 0.000897794f $X=0.216 $Y=0.234
cc_126 N_MAJI_18 B 3.51698e-20 $X=0.216 $Y=0.234
cc_127 N_MM8_D N_A_1 0.0011479f $X=0.1987 $Y=0.2025
cc_128 N_MAJI_1 N_A_1 3.52092e-20 $X=0.3415 $Y=0.1351
cc_129 N_MAJI_4 N_A_1 0.000580687f $X=0.216 $Y=0.1821
cc_130 N_MAJI_3 N_MM0_G 0.000802745f $X=0.216 $Y=0.0299
cc_131 N_MAJI_4 N_MM0_G 0.000802745f $X=0.216 $Y=0.1821
cc_132 N_MM3_D N_MM0_G 0.0184109f $X=0.1987 $Y=0.06751
cc_133 N_MM8_D N_MM0_G 0.0564281f $X=0.1987 $Y=0.2025
cc_134 N_MAJI_4 A 0.000608362f $X=0.216 $Y=0.1821
cc_135 N_MAJI_14 A 5.01541e-20 $X=0.3511 $Y=0.072
cc_136 N_MAJI_15 A 4.95086e-20 $X=0.3511 $Y=0.198
x_PM_MAJX2_ASAP7_75T_R%NET1 vss N_MM2_d N_MM0_s N_MM1_d N_NET1_1 N_NET1_2
+ N_NET1_9 PM_MAJX2_ASAP7_75T_R%NET1
cc_137 N_MM0_S N_VSS_1 0.00473885f $X=0.2527 $Y=0.06751
cc_138 N_NET1_1 N_VSS_1 0.000163909f $X=0.054 $Y=0.04711
cc_139 N_NET1_2 N_VSS_1 2.50254e-20 $X=0.27 $Y=0.04711
cc_140 N_NET1_1 N_VSS_5 0.00622916f $X=0.054 $Y=0.04711
cc_141 N_NET1_2 N_VSS_6 0.0039071f $X=0.27 $Y=0.04711
cc_142 N_MM2_D N_MM2_S 0.00220615f $X=0.0714 $Y=0.06751
cc_143 N_MM0_S N_MM1_S 0.00197919f $X=0.2527 $Y=0.06751
cc_144 N_NET1_2 VSS 0.00284902f $X=0.27 $Y=0.04711
cc_145 N_NET1_9 VSS 0.0038258f $X=0.054 $Y=0.072
cc_146 N_MM2_D N_C_1 0.0010154f $X=0.0714 $Y=0.06751
cc_147 N_NET1_1 N_C_1 0.000277809f $X=0.054 $Y=0.04711
cc_148 N_NET1_1 N_MM2_G 0.000820654f $X=0.054 $Y=0.04711
cc_149 N_MM2_D N_MM2_G 0.0377341f $X=0.0714 $Y=0.06751
cc_150 N_NET1_1 C 0.000134243f $X=0.054 $Y=0.04711
cc_151 N_NET1_9 C 0.00318429f $X=0.054 $Y=0.072
cc_152 N_NET1_1 N_VDD_5 2.40263e-20 $X=0.054 $Y=0.04711
cc_153 N_NET1_9 N_VDD_5 0.000340107f $X=0.054 $Y=0.072
cc_154 N_NET1_1 N_MM7_S 0.00017362f $X=0.054 $Y=0.04711
cc_155 N_MM0_S N_B_1 7.95946e-20 $X=0.2527 $Y=0.06751
cc_156 N_NET1_9 N_B_1 0.000167345f $X=0.054 $Y=0.072
cc_157 N_NET1_2 N_B_2 0.000325765f $X=0.27 $Y=0.04711
cc_158 N_NET1_1 N_MM3_G 1.25396e-20 $X=0.054 $Y=0.04711
cc_159 N_NET1_2 N_MM1_G 0.000767601f $X=0.27 $Y=0.04711
cc_160 N_MM0_S N_MM1_G 0.0375011f $X=0.2527 $Y=0.06751
cc_161 N_NET1_9 B 0.00378383f $X=0.054 $Y=0.072
cc_162 N_NET1_2 N_B_8 0.000367205f $X=0.27 $Y=0.04711
cc_163 N_NET1_9 N_B_8 0.000366056f $X=0.054 $Y=0.072
cc_164 N_NET1_9 N_B_9 0.000642314f $X=0.054 $Y=0.072
cc_165 N_MM0_S N_A_1 0.000596238f $X=0.2527 $Y=0.06751
cc_166 N_NET1_2 N_A_1 0.000323144f $X=0.27 $Y=0.04711
cc_167 N_NET1_2 N_MM0_G 0.00077317f $X=0.27 $Y=0.04711
cc_168 N_MM0_S N_MM0_G 0.0374916f $X=0.2527 $Y=0.06751
cc_169 N_NET1_2 A 0.000257272f $X=0.27 $Y=0.04711
cc_170 N_NET1_9 A 0.00208417f $X=0.054 $Y=0.072
cc_171 N_NET1_2 N_MAJI_1 1.9609e-20 $X=0.27 $Y=0.04711
cc_172 N_NET1_2 N_MAJI_3 0.00369252f $X=0.27 $Y=0.04711
cc_173 N_NET1_9 N_MAJI_3 0.000724661f $X=0.054 $Y=0.072
cc_174 N_MM0_S N_MM3_D 0.00125846f $X=0.2527 $Y=0.06751
cc_175 N_NET1_9 N_MAJI_13 6.05915e-20 $X=0.054 $Y=0.072
cc_176 N_NET1_9 N_MAJI_14 0.000397936f $X=0.054 $Y=0.072
cc_177 N_NET1_2 N_MAJI_17 0.000791737f $X=0.27 $Y=0.04711
cc_178 N_NET1_9 N_MAJI_17 0.00786249f $X=0.054 $Y=0.072
cc_179 N_NET1_9 N_MAJI_19 0.000151962f $X=0.054 $Y=0.072
cc_180 N_NET1_9 N_MAJI_21 0.000150339f $X=0.054 $Y=0.072
x_PM_MAJX2_ASAP7_75T_R%NET3 vss N_MM7_d N_MM5_s N_MM6_d N_NET3_1 N_NET3_9
+ N_NET3_2 PM_MAJX2_ASAP7_75T_R%NET3
cc_181 N_NET3_1 N_VSS_5 2.40263e-20 $X=0.054 $Y=0.18
cc_182 N_NET3_9 N_VSS_5 0.000339566f $X=0.054 $Y=0.198
cc_183 N_NET3_1 N_MM2_S 0.00017362f $X=0.054 $Y=0.18
cc_184 N_MM7_D N_C_1 0.00101535f $X=0.0714 $Y=0.2025
cc_185 N_NET3_1 N_C_1 0.000277793f $X=0.054 $Y=0.18
cc_186 N_NET3_1 N_MM2_G 0.000820654f $X=0.054 $Y=0.18
cc_187 N_MM7_D N_MM2_G 0.0377559f $X=0.0714 $Y=0.2025
cc_188 N_NET3_1 C 0.000134243f $X=0.054 $Y=0.18
cc_189 N_NET3_9 C 0.00318078f $X=0.054 $Y=0.198
cc_190 N_MM5_S N_VDD_1 0.00471682f $X=0.2527 $Y=0.2025
cc_191 N_NET3_1 N_VDD_1 0.000163909f $X=0.054 $Y=0.18
cc_192 N_NET3_2 N_VDD_1 2.50254e-20 $X=0.27 $Y=0.18
cc_193 N_NET3_1 N_VDD_5 0.00622916f $X=0.054 $Y=0.18
cc_194 N_NET3_2 N_VDD_6 0.00386744f $X=0.27 $Y=0.18
cc_195 N_MM7_D N_MM7_S 0.00223498f $X=0.0714 $Y=0.2025
cc_196 N_MM5_S N_MM6_S 0.00198794f $X=0.2527 $Y=0.2025
cc_197 N_NET3_2 VDD 0.00284729f $X=0.27 $Y=0.18
cc_198 N_NET3_9 VDD 0.00382924f $X=0.054 $Y=0.198
cc_199 N_MM5_S N_B_1 7.96046e-20 $X=0.2527 $Y=0.2025
cc_200 N_MM5_S N_B_2 0.0011479f $X=0.2527 $Y=0.2025
cc_201 N_NET3_9 N_B_1 0.000167036f $X=0.054 $Y=0.198
cc_202 N_NET3_2 N_B_2 0.00026035f $X=0.27 $Y=0.18
cc_203 N_NET3_1 N_MM3_G 1.25396e-20 $X=0.054 $Y=0.18
cc_204 N_NET3_2 N_MM1_G 0.000815522f $X=0.27 $Y=0.18
cc_205 N_MM5_S N_MM1_G 0.0374719f $X=0.2527 $Y=0.2025
cc_206 N_NET3_9 B 0.00387679f $X=0.054 $Y=0.198
cc_207 N_NET3_2 N_B_8 0.000342449f $X=0.27 $Y=0.18
cc_208 N_NET3_9 N_B_8 0.000535467f $X=0.054 $Y=0.198
cc_209 N_NET3_9 N_B_9 0.000629023f $X=0.054 $Y=0.198
cc_210 N_MM5_S N_A_1 0.000593957f $X=0.2527 $Y=0.2025
cc_211 N_NET3_2 N_A_1 0.000319836f $X=0.27 $Y=0.18
cc_212 N_NET3_2 N_MM0_G 0.000766579f $X=0.27 $Y=0.18
cc_213 N_MM5_S N_MM0_G 0.0374467f $X=0.2527 $Y=0.2025
cc_214 N_NET3_2 A 0.000265577f $X=0.27 $Y=0.18
cc_215 N_NET3_9 A 0.0020549f $X=0.054 $Y=0.198
cc_216 N_NET3_2 N_MAJI_1 1.6387e-20 $X=0.27 $Y=0.18
cc_217 N_NET3_2 N_MAJI_4 0.00367366f $X=0.27 $Y=0.18
cc_218 N_NET3_9 N_MAJI_4 0.000724661f $X=0.054 $Y=0.198
cc_219 N_MM5_S N_MM8_D 0.00126997f $X=0.2527 $Y=0.2025
cc_220 N_NET3_9 N_MAJI_15 0.00033362f $X=0.054 $Y=0.198
cc_221 N_NET3_9 N_MAJI_16 6.03086e-20 $X=0.054 $Y=0.198
cc_222 N_NET3_2 N_MAJI_18 0.000804226f $X=0.27 $Y=0.18
cc_223 N_NET3_9 N_MAJI_18 0.0078295f $X=0.054 $Y=0.198
cc_224 N_NET3_9 N_MAJI_20 0.00015195f $X=0.054 $Y=0.198
cc_225 N_NET3_9 N_MAJI_21 0.000113124f $X=0.054 $Y=0.198
cc_226 N_NET3_1 N_NET1_1 0.000266678f $X=0.054 $Y=0.18
cc_227 N_MM7_D N_NET1_1 0.000182853f $X=0.0714 $Y=0.2025
cc_228 N_NET3_1 N_MM2_D 0.000182853f $X=0.054 $Y=0.18
cc_229 N_NET3_9 N_NET1_9 0.0004254f $X=0.054 $Y=0.198
x_PM_MAJX2_ASAP7_75T_R%Y vss Y N_MM10_d N_MM11_d N_MM10@2_d N_MM11@2_d N_Y_1
+ N_Y_9 N_Y_10 N_Y_2 PM_MAJX2_ASAP7_75T_R%Y
cc_230 N_MM10_D N_VSS_1 0.00265907f $X=0.3607 $Y=0.06751
cc_231 N_Y_1 N_VSS_1 6.75675e-20 $X=0.378 $Y=0.0299
cc_232 N_Y_9 N_VSS_1 0.000194713f $X=0.378 $Y=0.036
cc_233 N_Y_1 N_VSS_6 0.0049042f $X=0.378 $Y=0.0299
cc_234 N_Y_1 N_VSS_7 0.00251659f $X=0.378 $Y=0.0299
cc_235 N_Y_10 N_VSS_7 2.5307e-20 $X=0.4051 $Y=0.234
cc_236 Y N_VSS_7 0.00180336f $X=0.4051 $Y=0.1149
cc_237 N_Y_9 N_VSS_7 0.000265251f $X=0.378 $Y=0.036
cc_238 N_MM10_D N_MM1_S 0.00248109f $X=0.3607 $Y=0.06751
cc_239 N_MM10_D N_MM10@2_S 0.000622233f $X=0.3607 $Y=0.06751
cc_240 N_Y_1 VSS 0.00124574f $X=0.378 $Y=0.0299
cc_241 N_Y_9 VSS 0.00569768f $X=0.378 $Y=0.036
cc_242 N_MM11_D N_VDD_1 0.0025521f $X=0.3607 $Y=0.2025
cc_243 N_Y_2 N_VDD_1 6.75675e-20 $X=0.378 $Y=0.1821
cc_244 N_Y_10 N_VDD_1 0.000194713f $X=0.4051 $Y=0.234
cc_245 N_Y_2 N_VDD_6 0.00490389f $X=0.378 $Y=0.1821
cc_246 N_Y_2 N_VDD_7 0.00251659f $X=0.378 $Y=0.1821
cc_247 N_Y_9 N_VDD_7 2.5307e-20 $X=0.378 $Y=0.036
cc_248 Y N_VDD_7 0.001808f $X=0.4051 $Y=0.1149
cc_249 N_Y_10 N_VDD_7 0.000265251f $X=0.4051 $Y=0.234
cc_250 N_MM11_D N_MM6_S 0.00244482f $X=0.3607 $Y=0.2025
cc_251 N_MM11_D N_MM11@2_S 0.000623494f $X=0.3607 $Y=0.2025
cc_252 N_Y_2 VDD 0.00124574f $X=0.378 $Y=0.1821
cc_253 N_Y_10 VDD 0.00569785f $X=0.4051 $Y=0.234
cc_254 N_Y_2 N_B_2 4.56495e-20 $X=0.378 $Y=0.1821
cc_255 N_Y_2 N_B_8 0.000128228f $X=0.378 $Y=0.1821
cc_256 N_Y_9 N_B_8 8.43636e-20 $X=0.378 $Y=0.036
cc_257 N_Y_10 N_B_8 8.28578e-20 $X=0.4051 $Y=0.234
cc_258 Y N_B_8 0.000370236f $X=0.4051 $Y=0.1149
cc_259 Y N_B_9 0.000275986f $X=0.4051 $Y=0.1149
cc_260 N_MM11_D N_MAJI_1 0.00424216f $X=0.3607 $Y=0.2025
cc_261 N_Y_2 N_MAJI_1 0.000589793f $X=0.378 $Y=0.1821
cc_262 N_Y_1 N_MM10_G 0.00196081f $X=0.378 $Y=0.0299
cc_263 N_Y_2 N_MM10_G 0.00196081f $X=0.378 $Y=0.1821
cc_264 N_MM10_D N_MM10_G 0.0350332f $X=0.3607 $Y=0.06751
cc_265 N_MM11_D N_MM10_G 0.0749064f $X=0.3607 $Y=0.2025
cc_266 N_MM11_D N_MM10@2_G 0.0377933f $X=0.3607 $Y=0.2025
cc_267 N_MM10_D N_MM10@2_G 0.00206055f $X=0.3607 $Y=0.06751
cc_268 N_Y_9 N_MAJI_13 0.000307723f $X=0.378 $Y=0.036
cc_269 N_Y_1 N_MAJI_14 0.000425417f $X=0.378 $Y=0.0299
cc_270 N_Y_9 N_MAJI_14 0.00198962f $X=0.378 $Y=0.036
cc_271 N_Y_2 N_MAJI_15 0.000425417f $X=0.378 $Y=0.1821
cc_272 N_Y_10 N_MAJI_15 0.00190612f $X=0.4051 $Y=0.234
cc_273 N_Y_10 N_MAJI_16 0.000312527f $X=0.4051 $Y=0.234
cc_274 N_Y_9 N_MAJI_19 0.000249252f $X=0.378 $Y=0.036
cc_275 N_Y_10 N_MAJI_20 0.000249177f $X=0.4051 $Y=0.234
cc_276 Y N_MAJI_21 0.00582918f $X=0.4051 $Y=0.1149
cc_277 N_Y_1 N_NET1_2 4.78445e-20 $X=0.378 $Y=0.0299
cc_278 N_Y_2 N_NET3_2 4.80243e-20 $X=0.378 $Y=0.1821
cc_279 N_MM11_D N_NET3_2 6.02373e-20 $X=0.3607 $Y=0.2025
x_PM_MAJX2_ASAP7_75T_R%NET17 vss N_MM4_d N_MM3_s PM_MAJX2_ASAP7_75T_R%NET17
cc_280 N_MM4_D N_MM2_S 0.000257257f $X=0.1447 $Y=0.06751
cc_281 N_MM4_D N_MM4_G 0.0187142f $X=0.1447 $Y=0.06751
cc_282 N_MM4_D N_B_1 1.73199e-20 $X=0.1447 $Y=0.06751
cc_283 N_MM4_D N_MM3_G 0.0187346f $X=0.1447 $Y=0.06751
x_PM_MAJX2_ASAP7_75T_R%NET16 vss N_MM9_d N_MM8_s PM_MAJX2_ASAP7_75T_R%NET16
cc_284 N_MM9_D N_MM4_G 0.0187139f $X=0.1447 $Y=0.2025
cc_285 N_MM9_D N_MM7_S 0.000257331f $X=0.1447 $Y=0.2025
cc_286 N_MM9_D N_B_1 1.73284e-20 $X=0.1447 $Y=0.2025
cc_287 N_MM9_D N_MM3_G 0.0187347f $X=0.1447 $Y=0.2025

.ENDS
*

.subckt PM_SDFHx2_ASAP7_75t_R%CLK vss 20 7 13 3 1 4 5 6
c1 1 vss 0.00427454f $X=0.081 $Y=0.135
c2 3 vss 0.0695976f $X=0.081 $Y=0.0245
c3 4 vss 0.00217636f $X=0.081 $Y=0.09
c4 5 vss 0.0029444f $X=0.081 $Y=0.1235
c5 6 vss 0.00484719f $X=0.108 $Y=0.063
r1 6 23 5.11582 $w=1.46667e-08 $l=2.7e-08 $layer=M1 $thickness=3.6e-08 $X=0.108
+ $Y=0.063 $X2=0.108 $Y2=0.09
r2 22 23 1.96775 $w=1.63333e-08 $l=1.35e-08 $layer=M1 $thickness=3.6e-08
+ $X=0.0945 $Y=0.09 $X2=0.108 $Y2=0.09
r3 4 16 3.48349 $w=1.525e-08 $l=2e-08 $layer=M1 $thickness=3.6e-08 $X=0.081
+ $Y=0.09 $X2=0.081 $Y2=0.11
r4 4 22 1.96775 $w=1.63333e-08 $l=1.35e-08 $layer=M1 $thickness=3.6e-08
+ $X=0.081 $Y=0.09 $X2=0.0945 $Y2=0.09
r5 20 19 2.73998 $w=1.3e-08 $l=1.18e-08 $layer=M1 $thickness=3.6e-08 $X=0.078
+ $Y=0.19 $X2=0.081 $Y2=0.1782
r6 18 19 3.20636 $w=1.3e-08 $l=1.37e-08 $layer=M1 $thickness=3.6e-08 $X=0.081
+ $Y=0.1645 $X2=0.081 $Y2=0.1782
r7 17 18 2.68168 $w=1.3e-08 $l=1.15e-08 $layer=M1 $thickness=3.6e-08 $X=0.081
+ $Y=0.153 $X2=0.081 $Y2=0.1645
r8 15 17 4.19742 $w=1.3e-08 $l=1.8e-08 $layer=M1 $thickness=3.6e-08 $X=0.081
+ $Y=0.135 $X2=0.081 $Y2=0.153
r9 5 15 2.68168 $w=1.3e-08 $l=1.15e-08 $layer=M1 $thickness=3.6e-08 $X=0.081
+ $Y=0.1235 $X2=0.081 $Y2=0.135
r10 5 16 3.14806 $w=1.3e-08 $l=1.35e-08 $layer=M1 $thickness=3.6e-08 $X=0.081
+ $Y=0.1235 $X2=0.081 $Y2=0.11
r11 1 10 10.4265 $w=1.765e-08 $layer=LIG $thickness=5.2e-08 $X=0.081 $Y=0.135
+ $X2=0.081 $Y2=0.135
r12 1 15 19.3796 $a=3.24e-16 $layer=V0LIG $X=0.081 $Y=0.135 $X2=0.081 $Y2=0.135
r13 13 12 14.6259 $w=2.1e-08 $l=4.3e-08 $layer=Gate_1 $thickness=5.6e-08
+ $X=0.081 $Y=0.216 $X2=0.081 $Y2=0.173
r14 11 12 7.31297 $w=2.1e-08 $l=2.15e-08 $layer=Gate_1 $thickness=5.6e-08
+ $X=0.081 $Y=0.1515 $X2=0.081 $Y2=0.173
r15 10 11 5.79936 $w=2.03333e-08 $l=1.65e-08 $layer=Gate_1 $thickness=5.6e-08
+ $X=0.081 $Y=0.135 $X2=0.081 $Y2=0.1515
r16 9 10 5.79936 $w=2.03333e-08 $l=1.65e-08 $layer=Gate_1 $thickness=5.6e-08
+ $X=0.081 $Y=0.1185 $X2=0.081 $Y2=0.135
r17 8 9 7.31297 $w=2.1e-08 $l=2.15e-08 $layer=Gate_1 $thickness=5.6e-08
+ $X=0.081 $Y=0.097 $X2=0.081 $Y2=0.1185
r18 7 8 14.6259 $w=2.1e-08 $l=4.3e-08 $layer=Gate_1 $thickness=5.6e-08 $X=0.081
+ $Y=0.054 $X2=0.081 $Y2=0.097
r19 7 3 10.0341 $w=2.1e-08 $l=2.95e-08 $layer=Gate_1 $thickness=5.6e-08
+ $X=0.081 $Y=0.054 $X2=0.081 $Y2=0.0245
.ends

.subckt PM_SDFHx2_ASAP7_75t_R%16 vss 12 13 27 28 7 1 9 2 8
c1 1 vss 0.00451219f $X=0.324 $Y=0.2025
c2 2 vss 0.00450694f $X=0.432 $Y=0.2025
c3 7 vss 0.00310042f $X=0.3095 $Y=0.2025
c4 8 vss 0.00310021f $X=0.4175 $Y=0.2025
c5 9 vss 0.00343914f $X=0.31 $Y=0.198
r1 28 26 0.0308642 $w=8.1e-08 $l=2.5e-09 $layer=P_src_drn $thickness=1e-09
+ $X=0.4493 $Y=0.2025 $X2=0.4465 $Y2=0.2025
r2 2 26 0.179012 $w=8.1e-08 $l=1.45e-08 $layer=P_src_drn $thickness=1e-09
+ $X=0.432 $Y=0.2025 $X2=0.4465 $Y2=0.2025
r3 8 2 0.179012 $w=8.1e-08 $l=1.45e-08 $layer=P_src_drn $thickness=1e-09
+ $X=0.4175 $Y=0.2025 $X2=0.432 $Y2=0.2025
r4 27 8 0.0308642 $w=8.1e-08 $l=2.5e-09 $layer=P_src_drn $thickness=1e-09
+ $X=0.4146 $Y=0.2025 $X2=0.4175 $Y2=0.2025
r5 2 22 19.3796 $a=3.24e-16 $layer=V0LISD $X=0.432 $Y=0.2025 $X2=0.428 $Y2=0.198
r6 21 22 2.2153 $w=1.3e-08 $l=9.5e-09 $layer=M1 $thickness=3.6e-08 $X=0.4185
+ $Y=0.198 $X2=0.428 $Y2=0.198
r7 20 21 3.14806 $w=1.3e-08 $l=1.35e-08 $layer=M1 $thickness=3.6e-08 $X=0.405
+ $Y=0.198 $X2=0.4185 $Y2=0.198
r8 19 20 4.08082 $w=1.3e-08 $l=1.75e-08 $layer=M1 $thickness=3.6e-08 $X=0.3875
+ $Y=0.198 $X2=0.405 $Y2=0.198
r9 18 19 4.19742 $w=1.3e-08 $l=1.8e-08 $layer=M1 $thickness=3.6e-08 $X=0.3695
+ $Y=0.198 $X2=0.3875 $Y2=0.198
r10 17 18 4.31401 $w=1.3e-08 $l=1.85e-08 $layer=M1 $thickness=3.6e-08 $X=0.351
+ $Y=0.198 $X2=0.3695 $Y2=0.198
r11 16 17 3.14806 $w=1.3e-08 $l=1.35e-08 $layer=M1 $thickness=3.6e-08 $X=0.3375
+ $Y=0.198 $X2=0.351 $Y2=0.198
r12 15 16 3.14806 $w=1.3e-08 $l=1.35e-08 $layer=M1 $thickness=3.6e-08 $X=0.324
+ $Y=0.198 $X2=0.3375 $Y2=0.198
r13 14 15 2.56509 $w=1.3e-08 $l=1.1e-08 $layer=M1 $thickness=3.6e-08 $X=0.313
+ $Y=0.198 $X2=0.324 $Y2=0.198
r14 9 14 0.699569 $w=1.3e-08 $l=3e-09 $layer=M1 $thickness=3.6e-08 $X=0.31
+ $Y=0.198 $X2=0.313 $Y2=0.198
r15 1 15 19.3796 $a=3.24e-16 $layer=V0LISD $X=0.324 $Y=0.2025 $X2=0.324
+ $Y2=0.198
r16 13 11 0.0308642 $w=8.1e-08 $l=2.5e-09 $layer=P_src_drn $thickness=1e-09
+ $X=0.3413 $Y=0.2025 $X2=0.3385 $Y2=0.2025
r17 1 11 0.179012 $w=8.1e-08 $l=1.45e-08 $layer=P_src_drn $thickness=1e-09
+ $X=0.324 $Y=0.2025 $X2=0.3385 $Y2=0.2025
r18 7 1 0.179012 $w=8.1e-08 $l=1.45e-08 $layer=P_src_drn $thickness=1e-09
+ $X=0.3095 $Y=0.2025 $X2=0.324 $Y2=0.2025
r19 12 7 0.0308642 $w=8.1e-08 $l=2.5e-09 $layer=P_src_drn $thickness=1e-09
+ $X=0.3066 $Y=0.2025 $X2=0.3095 $Y2=0.2025
.ends

.subckt PM_SDFHx2_ASAP7_75t_R%14 vss 13 24 26 8 1 9 11 2 10
c1 1 vss 0.00620035f $X=0.27 $Y=0.1755
c2 2 vss 0.0102065f $X=0.513 $Y=0.2025
c3 8 vss 0.0365574f $X=0.272 $Y=0.2025
c4 9 vss 0.0358277f $X=0.4715 $Y=0.2025
c5 10 vss 0.035736f $X=0.542 $Y=0.2025
c6 11 vss 0.0204139f $X=0.258 $Y=0.234
r1 26 25 0.0308642 $w=8.1e-08 $l=2.5e-09 $layer=P_src_drn $thickness=1e-09
+ $X=0.5573 $Y=0.2025 $X2=0.5545 $Y2=0.2025
r2 10 25 0.154321 $w=8.1e-08 $l=1.25e-08 $layer=P_src_drn $thickness=1e-09
+ $X=0.542 $Y=0.2025 $X2=0.5545 $Y2=0.2025
r3 9 2 0.154321 $w=8.1e-08 $l=1.25e-08 $layer=P_src_drn $thickness=1e-09
+ $X=0.4715 $Y=0.2025 $X2=0.513 $Y2=0.2025
r4 24 9 0.0308642 $w=8.1e-08 $l=2.5e-09 $layer=P_src_drn $thickness=1e-09
+ $X=0.4686 $Y=0.2025 $X2=0.4715 $Y2=0.2025
r5 2 21 19.3796 $a=3.24e-16 $layer=V0LISD $X=0.513 $Y=0.2025 $X2=0.49 $Y2=0.234
r6 20 21 2.09871 $w=1.3e-08 $l=9e-09 $layer=M1 $thickness=3.6e-08 $X=0.481
+ $Y=0.234 $X2=0.49 $Y2=0.234
r7 19 20 2.79828 $w=1.3e-08 $l=1.2e-08 $layer=M1 $thickness=3.6e-08 $X=0.469
+ $Y=0.234 $X2=0.481 $Y2=0.234
r8 18 19 3.49785 $w=1.3e-08 $l=1.5e-08 $layer=M1 $thickness=3.6e-08 $X=0.454
+ $Y=0.234 $X2=0.469 $Y2=0.234
r9 17 18 17.7224 $w=1.3e-08 $l=7.6e-08 $layer=M1 $thickness=3.6e-08 $X=0.378
+ $Y=0.234 $X2=0.454 $Y2=0.234
r10 16 17 19.5879 $w=1.3e-08 $l=8.4e-08 $layer=M1 $thickness=3.6e-08 $X=0.294
+ $Y=0.234 $X2=0.378 $Y2=0.234
r11 15 16 5.59655 $w=1.3e-08 $l=2.4e-08 $layer=M1 $thickness=3.6e-08 $X=0.27
+ $Y=0.234 $X2=0.294 $Y2=0.234
r12 11 15 2.79828 $w=1.3e-08 $l=1.2e-08 $layer=M1 $thickness=3.6e-08 $X=0.258
+ $Y=0.234 $X2=0.27 $Y2=0.234
r13 8 15 19.3796 $a=3.24e-16 $layer=V0LISD $X=0.272 $Y=0.2025 $X2=0.27 $Y2=0.234
r14 1 8 23.8708 $w=2.02e-08 $l=4.05e-08 $layer=LISD $thickness=2.7e-08 $X=0.27
+ $Y=0.1755 $X2=0.272 $Y2=0.2025
r15 13 12 0.0308642 $w=8.1e-08 $l=2.5e-09 $layer=P_src_drn $thickness=1e-09
+ $X=0.2873 $Y=0.2025 $X2=0.2845 $Y2=0.2025
r16 8 12 0.154321 $w=8.1e-08 $l=1.25e-08 $layer=P_src_drn $thickness=1e-09
+ $X=0.272 $Y=0.2025 $X2=0.2845 $Y2=0.2025
r17 2 10 1e-05 $l=2.9e-08 $X=0.513 $Y=0.2025 $X2=0.542 $Y2=0.2025
.ends

.subckt PM_SDFHx2_ASAP7_75t_R%11 vss 22 26 59 62 65 68 11 3 13 15 17 19 4 21 20
+ 10 12 16 1 9 14
c1 1 vss 0.00029174f $X=0.783 $Y=0.131
c2 3 vss 0.00419826f $X=0.594 $Y=0.2295
c3 4 vss 0.0077563f $X=0.648 $Y=0.0405
c4 9 vss 0.0385182f $X=0.783 $Y=0.0245
c5 10 vss 0.00311824f $X=0.6335 $Y=0.0405
c6 11 vss 0.000350497f $X=0.6335 $Y=0.081
c7 12 vss 0.00175367f $X=0.5795 $Y=0.2295
c8 13 vss 0.000287221f $X=0.5795 $Y=0.189
c9 14 vss 0.0029595f $X=0.693 $Y=0.036
c10 15 vss 9.74077e-20 $X=0.693 $Y=0.131
c11 16 vss 0.0026422f $X=0.693 $Y=0.234
c12 17 vss 0.00820275f $X=0.6665 $Y=0.234
c13 18 vss 0.00802112f $X=0.653 $Y=0.036
c14 19 vss 0.00167372f $X=0.693 $Y=0.114
c15 20 vss 0.000494645f $X=0.693 $Y=0.1465
c16 21 vss 0.000757398f $X=0.756 $Y=0.131
r1 13 3 0.231482 $w=5.4e-08 $l=1.25e-08 $layer=P_src_drn $thickness=1e-09
+ $X=0.5795 $Y=0.189 $X2=0.594 $Y2=0.2295
r2 68 67 0.0925926 $w=2.7e-08 $l=2.5e-09 $layer=P_src_drn $thickness=1e-09
+ $X=0.6113 $Y=0.2295 $X2=0.6085 $Y2=0.2295
r3 66 67 0.166667 $w=2.7e-08 $l=4.5e-09 $layer=P_src_drn $thickness=1e-09
+ $X=0.604 $Y=0.2295 $X2=0.6085 $Y2=0.2295
r4 3 66 0.444445 $w=2.7e-08 $l=1.2e-08 $layer=P_src_drn $thickness=1e-09
+ $X=0.594 $Y=0.2295 $X2=0.604 $Y2=0.2295
r5 12 3 0.462963 $w=2.7e-08 $l=1.25e-08 $layer=P_src_drn $thickness=1e-09
+ $X=0.5795 $Y=0.2295 $X2=0.594 $Y2=0.2295
r6 65 12 0.0925926 $w=2.7e-08 $l=2.5e-09 $layer=P_src_drn $thickness=1e-09
+ $X=0.5766 $Y=0.2025 $X2=0.5795 $Y2=0.2295
r7 11 52 0.231482 $w=5.4e-08 $l=1.25e-08 $layer=N_src_drn $thickness=1e-09
+ $X=0.6335 $Y=0.081 $X2=0.648 $Y2=0.0685
r8 62 61 0.0925926 $w=2.7e-08 $l=2.5e-09 $layer=N_src_drn $thickness=1e-09
+ $X=0.6653 $Y=0.0405 $X2=0.6625 $Y2=0.0405
r9 60 61 0.166667 $w=2.7e-08 $l=4.5e-09 $layer=N_src_drn $thickness=1e-09
+ $X=0.658 $Y=0.0405 $X2=0.6625 $Y2=0.0405
r10 52 60 0.444445 $w=2.7e-08 $l=1.2e-08 $layer=N_src_drn $thickness=1e-09
+ $X=0.648 $Y=0.0685 $X2=0.658 $Y2=0.0405
r11 10 52 0.462963 $w=2.7e-08 $l=1.25e-08 $layer=N_src_drn $thickness=1e-09
+ $X=0.6335 $Y=0.0405 $X2=0.648 $Y2=0.0685
r12 59 10 0.0925926 $w=2.7e-08 $l=2.5e-09 $layer=N_src_drn $thickness=1e-09
+ $X=0.6306 $Y=0.0675 $X2=0.6335 $Y2=0.0405
r13 3 51 19.3796 $a=3.24e-16 $layer=V0LISD $X=0.594 $Y=0.2295 $X2=0.59 $Y2=0.234
r14 4 45 19.3796 $a=3.24e-16 $layer=V0LISD $X=0.648 $Y=0.0405 $X2=0.644
+ $Y2=0.036
r15 4 52 16.5033 $w=2.02e-08 $l=2.8e-08 $layer=LISD $thickness=2.7e-08 $X=0.648
+ $Y=0.0405 $X2=0.648 $Y2=0.0685
r16 48 49 1.63233 $w=1.3e-08 $l=7e-09 $layer=M1 $thickness=3.6e-08 $X=0.599
+ $Y=0.234 $X2=0.606 $Y2=0.234
r17 48 51 2.09871 $w=1.3e-08 $l=9e-09 $layer=M1 $thickness=3.6e-08 $X=0.599
+ $Y=0.234 $X2=0.59 $Y2=0.234
r18 47 49 1.04935 $w=1.3e-08 $l=4.5e-09 $layer=M1 $thickness=3.6e-08 $X=0.6105
+ $Y=0.234 $X2=0.606 $Y2=0.234
r19 46 47 4.6638 $w=1.3e-08 $l=2e-08 $layer=M1 $thickness=3.6e-08 $X=0.6305
+ $Y=0.234 $X2=0.6105 $Y2=0.234
r20 17 46 8.39483 $w=1.3e-08 $l=3.6e-08 $layer=M1 $thickness=3.6e-08 $X=0.6665
+ $Y=0.234 $X2=0.6305 $Y2=0.234
r21 18 43 4.08082 $w=1.3e-08 $l=1.75e-08 $layer=M1 $thickness=3.6e-08 $X=0.653
+ $Y=0.036 $X2=0.6705 $Y2=0.036
r22 18 45 2.09871 $w=1.3e-08 $l=9e-09 $layer=M1 $thickness=3.6e-08 $X=0.653
+ $Y=0.036 $X2=0.644 $Y2=0.036
r23 16 42 2.5483 $w=1.79e-08 $l=1.8e-08 $layer=M1 $thickness=3.6e-08 $X=0.693
+ $Y=0.234 $X2=0.693 $Y2=0.216
r24 16 17 4.53042 $w=1.46981e-08 $l=2.65e-08 $layer=M1 $thickness=3.6e-08
+ $X=0.693 $Y=0.234 $X2=0.6665 $Y2=0.234
r25 14 37 2.43171 $w=1.804e-08 $l=1.75e-08 $layer=M1 $thickness=3.6e-08
+ $X=0.693 $Y=0.036 $X2=0.693 $Y2=0.0535
r26 14 43 3.59766 $w=1.5e-08 $l=2.25e-08 $layer=M1 $thickness=3.6e-08 $X=0.693
+ $Y=0.036 $X2=0.6705 $Y2=0.036
r27 41 42 4.19742 $w=1.3e-08 $l=1.8e-08 $layer=M1 $thickness=3.6e-08 $X=0.693
+ $Y=0.198 $X2=0.693 $Y2=0.216
r28 40 41 4.19742 $w=1.3e-08 $l=1.8e-08 $layer=M1 $thickness=3.6e-08 $X=0.693
+ $Y=0.18 $X2=0.693 $Y2=0.198
r29 39 40 2.79828 $w=1.3e-08 $l=1.2e-08 $layer=M1 $thickness=3.6e-08 $X=0.693
+ $Y=0.168 $X2=0.693 $Y2=0.18
r30 38 39 2.09871 $w=1.3e-08 $l=9e-09 $layer=M1 $thickness=3.6e-08 $X=0.693
+ $Y=0.159 $X2=0.693 $Y2=0.168
r31 20 38 2.91487 $w=1.3e-08 $l=1.25e-08 $layer=M1 $thickness=3.6e-08 $X=0.693
+ $Y=0.1465 $X2=0.693 $Y2=0.159
r32 36 37 2.09871 $w=1.3e-08 $l=9e-09 $layer=M1 $thickness=3.6e-08 $X=0.693
+ $Y=0.0625 $X2=0.693 $Y2=0.0535
r33 35 36 2.2153 $w=1.3e-08 $l=9.5e-09 $layer=M1 $thickness=3.6e-08 $X=0.693
+ $Y=0.072 $X2=0.693 $Y2=0.0625
r34 34 35 4.19742 $w=1.3e-08 $l=1.8e-08 $layer=M1 $thickness=3.6e-08 $X=0.693
+ $Y=0.09 $X2=0.693 $Y2=0.072
r35 33 34 2.91487 $w=1.3e-08 $l=1.25e-08 $layer=M1 $thickness=3.6e-08 $X=0.693
+ $Y=0.1025 $X2=0.693 $Y2=0.09
r36 19 33 2.68168 $w=1.3e-08 $l=1.15e-08 $layer=M1 $thickness=3.6e-08 $X=0.693
+ $Y=0.114 $X2=0.693 $Y2=0.1025
r37 15 32 3.01711 $w=1.55e-08 $l=1.8e-08 $layer=M1 $thickness=3.6e-08 $X=0.693
+ $Y=0.131 $X2=0.711 $Y2=0.131
r38 15 19 2.78392 $w=1.56471e-08 $l=1.7e-08 $layer=M1 $thickness=3.6e-08
+ $X=0.693 $Y=0.131 $X2=0.693 $Y2=0.114
r39 15 20 2.43413 $w=1.59032e-08 $l=1.55e-08 $layer=M1 $thickness=3.6e-08
+ $X=0.693 $Y=0.131 $X2=0.693 $Y2=0.1465
r40 31 32 4.19742 $w=1.3e-08 $l=1.8e-08 $layer=M1 $thickness=3.6e-08 $X=0.729
+ $Y=0.131 $X2=0.711 $Y2=0.131
r41 21 30 6.29612 $w=1.3e-08 $l=2.7e-08 $layer=M1 $thickness=3.6e-08 $X=0.756
+ $Y=0.131 $X2=0.783 $Y2=0.131
r42 21 31 6.29612 $w=1.3e-08 $l=2.7e-08 $layer=M1 $thickness=3.6e-08 $X=0.756
+ $Y=0.131 $X2=0.729 $Y2=0.131
r43 1 24 6.54019 $w=2.09524e-08 $layer=Gate_1 $thickness=5.21905e-08 $X=0.783
+ $Y=0.131 $X2=0.783 $Y2=0.131
r44 1 30 19.3796 $a=3.24e-16 $layer=V0LIG $X=0.783 $Y=0.131 $X2=0.783 $Y2=0.131
r45 26 25 17.177 $w=2.1e-08 $l=5.05e-08 $layer=Gate_1 $thickness=5.6e-08
+ $X=0.783 $Y=0.2295 $X2=0.783 $Y2=0.179
r46 24 25 16.5137 $w=2.07708e-08 $l=4.8e-08 $layer=Gate_1 $thickness=5.6e-08
+ $X=0.783 $Y=0.131 $X2=0.783 $Y2=0.179
r47 23 24 15.1532 $w=2.075e-08 $l=4.4e-08 $layer=Gate_1 $thickness=5.6e-08
+ $X=0.783 $Y=0.087 $X2=0.783 $Y2=0.131
r48 22 23 15.8164 $w=2.1e-08 $l=4.65e-08 $layer=Gate_1 $thickness=5.6e-08
+ $X=0.783 $Y=0.0405 $X2=0.783 $Y2=0.087
r49 22 9 5.44221 $w=2.1e-08 $l=1.6e-08 $layer=Gate_1 $thickness=5.6e-08
+ $X=0.783 $Y=0.0405 $X2=0.783 $Y2=0.0245
.ends

.subckt PM_SDFHx2_ASAP7_75t_R%19 vss 7 12 4 5 1
c1 1 vss 0.0059359f $X=0.648 $Y=0.2295
c2 4 vss 0.00167554f $X=0.6335 $Y=0.2295
c3 5 vss 0.0020574f $X=0.704 $Y=0.2295
r1 12 11 0.0925926 $w=2.7e-08 $l=2.5e-09 $layer=P_src_drn $thickness=1e-09
+ $X=0.7193 $Y=0.2295 $X2=0.7165 $Y2=0.2295
r2 5 11 0.462963 $w=2.7e-08 $l=1.25e-08 $layer=P_src_drn $thickness=1e-09
+ $X=0.704 $Y=0.2295 $X2=0.7165 $Y2=0.2295
r3 9 5 11.9937 $w=2.32e-08 $l=2.55e-08 $layer=LISD $thickness=2.7e-08 $X=0.6765
+ $Y=0.2295 $X2=0.704 $Y2=0.2295
r4 8 9 7.05511 $w=2.32e-08 $l=1.5e-08 $layer=LISD $thickness=2.7e-08 $X=0.6615
+ $Y=0.2295 $X2=0.6765 $Y2=0.2295
r5 1 8 6.3496 $w=2.32e-08 $l=1.35e-08 $layer=LISD $thickness=2.7e-08 $X=0.648
+ $Y=0.2295 $X2=0.6615 $Y2=0.2295
r6 4 1 0.462963 $w=2.7e-08 $l=1.25e-08 $layer=P_src_drn $thickness=1e-09
+ $X=0.6335 $Y=0.2295 $X2=0.648 $Y2=0.2295
r7 7 4 0.0925926 $w=2.7e-08 $l=2.5e-09 $layer=P_src_drn $thickness=1e-09
+ $X=0.6306 $Y=0.2295 $X2=0.6335 $Y2=0.2295
.ends

.subckt PM_SDFHx2_ASAP7_75t_R%22 vss 2 3 1
c1 1 vss 0.000541444f $X=0.702 $Y=0.0405
r1 2 1 0.62963 $w=2.7e-08 $l=1.7e-08 $layer=N_src_drn $thickness=1e-09
+ $X=0.6846 $Y=0.0405 $X2=0.702 $Y2=0.0405
r2 3 1 0.62963 $w=2.7e-08 $l=1.7e-08 $layer=N_src_drn $thickness=1e-09
+ $X=0.7193 $Y=0.0405 $X2=0.702 $Y2=0.0405
.ends

.subckt PM_SDFHx2_ASAP7_75t_R%23 vss 2 3 1
c1 1 vss 0.000577083f $X=0.972 $Y=0.2295
r1 2 1 0.62963 $w=2.7e-08 $l=1.7e-08 $layer=P_src_drn $thickness=1e-09
+ $X=0.9546 $Y=0.2295 $X2=0.972 $Y2=0.2295
r2 3 1 0.62963 $w=2.7e-08 $l=1.7e-08 $layer=P_src_drn $thickness=1e-09
+ $X=0.9893 $Y=0.2295 $X2=0.972 $Y2=0.2295
.ends

.subckt PM_SDFHx2_ASAP7_75t_R%4 vss 34 38 69 72 76 80 89 91 8 26 7 19 16 17 25
+ 23 1 22 24 29 13 28 27 15 3 21 14 2
c1 1 vss 0.00224425f $X=0.135 $Y=0.135
c2 2 vss 0.00235791f $X=0.621 $Y=0.135
c3 3 vss 0.000376589f $X=0.891 $Y=0.135
c4 7 vss 0.00789569f $X=0.054 $Y=0.054
c5 8 vss 0.00791452f $X=0.054 $Y=0.216
c6 13 vss 0.06994f $X=0.135 $Y=0.135
c7 14 vss 0.0461703f $X=0.621 $Y=0.135
c8 15 vss 0.00703915f $X=0.891 $Y=0.0245
c9 16 vss 0.0306452f $X=0.056 $Y=0.054
c10 17 vss 0.0306702f $X=0.056 $Y=0.216
c11 18 vss 0.00350473f $X=0.018 $Y=0.036
c12 19 vss 0.0019441f $X=0.0165 $Y=0.153
c13 20 vss 0.00343821f $X=0.018 $Y=0.234
c14 21 vss 0.000412327f $X=0.621 $Y=0.162
c15 22 vss 0.00576064f $X=0.018 $Y=0.1215
c16 23 vss 0.00394802f $X=0.018 $Y=0.181
c17 24 vss 0.00447052f $X=0.036 $Y=0.036
c18 25 vss 0.00458786f $X=0.036 $Y=0.234
c19 26 vss 0.000735022f $X=0.135 $Y=0.1235
c20 27 vss 0.00149469f $X=0.621 $Y=0.116
c21 28 vss 0.000765243f $X=0.891 $Y=0.1135
c22 29 vss 0.0248433f $X=0.8125 $Y=0.153
r1 91 90 0.0462963 $w=5.4e-08 $l=2.5e-09 $layer=P_src_drn $thickness=1e-09
+ $X=0.0713 $Y=0.216 $X2=0.0685 $Y2=0.216
r2 17 90 0.231482 $w=5.4e-08 $l=1.25e-08 $layer=P_src_drn $thickness=1e-09
+ $X=0.056 $Y=0.216 $X2=0.0685 $Y2=0.216
r3 89 88 0.0462963 $w=5.4e-08 $l=2.5e-09 $layer=N_src_drn $thickness=1e-09
+ $X=0.0713 $Y=0.054 $X2=0.0685 $Y2=0.054
r4 16 88 0.231482 $w=5.4e-08 $l=1.25e-08 $layer=N_src_drn $thickness=1e-09
+ $X=0.056 $Y=0.054 $X2=0.0685 $Y2=0.054
r5 8 86 19.3796 $a=3.24e-16 $layer=V0LISD $X=0.054 $Y=0.216 $X2=0.055 $Y2=0.234
r6 7 83 19.3796 $a=3.24e-16 $layer=V0LISD $X=0.054 $Y=0.054 $X2=0.055 $Y2=0.036
r7 85 86 2.09871 $w=1.3e-08 $l=9e-09 $layer=M1 $thickness=3.6e-08 $X=0.046
+ $Y=0.234 $X2=0.055 $Y2=0.234
r8 25 85 2.3319 $w=1.3e-08 $l=1e-08 $layer=M1 $thickness=3.6e-08 $X=0.036
+ $Y=0.234 $X2=0.046 $Y2=0.234
r9 82 83 2.09871 $w=1.3e-08 $l=9e-09 $layer=M1 $thickness=3.6e-08 $X=0.046
+ $Y=0.036 $X2=0.055 $Y2=0.036
r10 24 82 2.3319 $w=1.3e-08 $l=1e-08 $layer=M1 $thickness=3.6e-08 $X=0.036
+ $Y=0.036 $X2=0.046 $Y2=0.036
r11 80 79 14.6259 $w=2.1e-08 $l=4.3e-08 $layer=Gate_1 $thickness=5.6e-08
+ $X=0.135 $Y=0.216 $X2=0.135 $Y2=0.173
r12 78 79 7.31297 $w=2.1e-08 $l=2.15e-08 $layer=Gate_1 $thickness=5.6e-08
+ $X=0.135 $Y=0.1515 $X2=0.135 $Y2=0.173
r13 76 77 14.6259 $w=2.1e-08 $l=4.3e-08 $layer=Gate_1 $thickness=5.6e-08
+ $X=0.135 $Y=0.054 $X2=0.135 $Y2=0.097
r14 74 77 7.31297 $w=2.1e-08 $l=2.15e-08 $layer=Gate_1 $thickness=5.6e-08
+ $X=0.135 $Y=0.1185 $X2=0.135 $Y2=0.097
r15 13 74 5.79936 $w=2.03333e-08 $l=1.65e-08 $layer=Gate_1 $thickness=5.6e-08
+ $X=0.135 $Y=0.135 $X2=0.135 $Y2=0.1185
r16 13 78 5.79936 $w=2.03333e-08 $l=1.65e-08 $layer=Gate_1 $thickness=5.6e-08
+ $X=0.135 $Y=0.135 $X2=0.135 $Y2=0.1515
r17 20 67 3.36447 $w=1.71023e-08 $l=2.15e-08 $layer=M1 $thickness=3.6e-08
+ $X=0.018 $Y=0.234 $X2=0.018 $Y2=0.2125
r18 20 25 2.5483 $w=1.55e-08 $l=1.8e-08 $layer=M1 $thickness=3.6e-08 $X=0.018
+ $Y=0.234 $X2=0.036 $Y2=0.234
r19 18 66 4.64701 $w=1.62667e-08 $l=2.7e-08 $layer=M1 $thickness=3.6e-08
+ $X=0.018 $Y=0.036 $X2=0.018 $Y2=0.063
r20 18 24 2.5483 $w=1.55e-08 $l=1.8e-08 $layer=M1 $thickness=3.6e-08 $X=0.018
+ $Y=0.036 $X2=0.036 $Y2=0.036
r21 72 71 16.4967 $w=2.1e-08 $l=4.85e-08 $layer=Gate_1 $thickness=5.6e-08
+ $X=0.621 $Y=0.2295 $X2=0.621 $Y2=0.181
r22 69 70 16.4967 $w=2.1e-08 $l=4.85e-08 $layer=Gate_1 $thickness=5.6e-08
+ $X=0.621 $Y=0.0675 $X2=0.621 $Y2=0.116
r23 14 70 6.6497 $w=2.04211e-08 $l=1.9e-08 $layer=Gate_1 $thickness=5.6e-08
+ $X=0.621 $Y=0.135 $X2=0.621 $Y2=0.116
r24 14 71 15.8334 $w=2.07609e-08 $l=4.6e-08 $layer=Gate_1 $thickness=5.6e-08
+ $X=0.621 $Y=0.135 $X2=0.621 $Y2=0.181
r25 1 61 19.3796 $a=3.24e-16 $layer=V0LIG $X=0.135 $Y=0.135 $X2=0.135 $Y2=0.144
r26 1 13 10.4265 $w=1.765e-08 $layer=LIG $thickness=5.2e-08 $X=0.135 $Y=0.135
+ $X2=0.135 $Y2=0.135
r27 23 67 7.34548 $w=1.3e-08 $l=3.15e-08 $layer=M1 $thickness=3.6e-08 $X=0.018
+ $Y=0.181 $X2=0.018 $Y2=0.2125
r28 65 66 6.29612 $w=1.3e-08 $l=2.7e-08 $layer=M1 $thickness=3.6e-08 $X=0.018
+ $Y=0.09 $X2=0.018 $Y2=0.063
r29 22 65 7.34548 $w=1.3e-08 $l=3.15e-08 $layer=M1 $thickness=3.6e-08 $X=0.018
+ $Y=0.1215 $X2=0.018 $Y2=0.09
r30 2 57 19.3796 $a=3.24e-16 $layer=V0LIG $X=0.621 $Y=0.135 $X2=0.621 $Y2=0.1395
r31 2 14 6.54019 $w=2.09524e-08 $layer=Gate_1 $thickness=5.21905e-08 $X=0.621
+ $Y=0.135 $X2=0.621 $Y2=0.135
r32 26 61 4.78039 $w=1.3e-08 $l=2.05e-08 $layer=M1 $thickness=3.6e-08 $X=0.135
+ $Y=0.1235 $X2=0.135 $Y2=0.144
r33 58 59 1.90199 $w=1.38333e-08 $l=9e-09 $layer=M1 $thickness=3.6e-08
+ $X=0.0255 $Y=0.153 $X2=0.0345 $Y2=0.153
r34 19 58 0.9184 $w=1.8e-08 $l=9e-09 $layer=M1 $thickness=3.6e-08 $X=0.0165
+ $Y=0.153 $X2=0.0255 $Y2=0.153
r35 19 22 6.0121 $w=1.425e-08 $l=3.15357e-08 $layer=M1 $thickness=3.6e-08
+ $X=0.0165 $Y=0.153 $X2=0.018 $Y2=0.1215
r36 19 23 5.19594 $w=1.44151e-08 $l=2.80401e-08 $layer=M1 $thickness=3.6e-08
+ $X=0.0165 $Y=0.153 $X2=0.018 $Y2=0.181
r37 27 57 5.47996 $w=1.3e-08 $l=2.35e-08 $layer=M1 $thickness=3.6e-08 $X=0.621
+ $Y=0.116 $X2=0.621 $Y2=0.1395
r38 21 46 39.0693 $a=1.62e-16 $layer=V1 $X=0.621 $Y=0.162 $X2=0.621 $Y2=0.153
r39 21 57 4.06646 $w=1.5e-08 $l=2.25e-08 $layer=M1 $thickness=3.6e-08 $X=0.621
+ $Y=0.162 $X2=0.621 $Y2=0.1395
r40 53 54 5.71315 $w=1.3e-08 $l=2.45e-08 $layer=M2 $thickness=3.6e-08 $X=0.135
+ $Y=0.153 $X2=0.1595 $Y2=0.153
r41 53 61 19.5347 $a=3.24e-16 $layer=V1 $X=0.135 $Y=0.153 $X2=0.135 $Y2=0.144
r42 52 53 11.8927 $w=1.3e-08 $l=5.1e-08 $layer=M2 $thickness=3.6e-08 $X=0.084
+ $Y=0.153 $X2=0.135 $Y2=0.153
r43 51 52 11.8927 $w=1.3e-08 $l=5.1e-08 $layer=M2 $thickness=3.6e-08 $X=0.033
+ $Y=0.153 $X2=0.084 $Y2=0.153
r44 51 59 19.5347 $a=3.24e-16 $layer=V1 $X=0.033 $Y=0.153 $X2=0.0345 $Y2=0.153
r45 49 54 7.81186 $w=1.3e-08 $l=3.35e-08 $layer=M2 $thickness=3.6e-08 $X=0.193
+ $Y=0.153 $X2=0.1595 $Y2=0.153
r46 48 49 18.8884 $w=1.3e-08 $l=8.1e-08 $layer=M2 $thickness=3.6e-08 $X=0.274
+ $Y=0.153 $X2=0.193 $Y2=0.153
r47 46 47 15.2739 $w=1.3e-08 $l=6.55e-08 $layer=M2 $thickness=3.6e-08 $X=0.621
+ $Y=0.153 $X2=0.6865 $Y2=0.153
r48 46 57 39.0693 $a=1.62e-16 $layer=V1 $X=0.621 $Y=0.153 $X2=0.621 $Y2=0.1395
r49 45 46 34.1623 $w=1.3e-08 $l=1.465e-07 $layer=M2 $thickness=3.6e-08
+ $X=0.4745 $Y=0.153 $X2=0.621 $Y2=0.153
r50 45 48 46.7545 $w=1.3e-08 $l=2.005e-07 $layer=M2 $thickness=3.6e-08
+ $X=0.4745 $Y=0.153 $X2=0.274 $Y2=0.153
r51 29 44 18.3054 $w=1.3e-08 $l=7.85e-08 $layer=M2 $thickness=3.6e-08 $X=0.8125
+ $Y=0.153 $X2=0.891 $Y2=0.153
r52 29 47 29.3819 $w=1.3e-08 $l=1.26e-07 $layer=M2 $thickness=3.6e-08 $X=0.8125
+ $Y=0.153 $X2=0.6865 $Y2=0.153
r53 42 44 19.5347 $a=3.24e-16 $layer=V1 $X=0.891 $Y=0.144 $X2=0.891 $Y2=0.153
r54 28 42 7.11229 $w=1.3e-08 $l=3.05e-08 $layer=M1 $thickness=3.6e-08 $X=0.891
+ $Y=0.1135 $X2=0.891 $Y2=0.144
r55 3 36 6.54019 $w=2.09524e-08 $layer=Gate_1 $thickness=5.21905e-08 $X=0.891
+ $Y=0.135 $X2=0.891 $Y2=0.135
r56 3 42 19.3796 $a=3.24e-16 $layer=V0LIG $X=0.891 $Y=0.135 $X2=0.891 $Y2=0.144
r57 38 37 16.4967 $w=2.1e-08 $l=4.85e-08 $layer=Gate_1 $thickness=5.6e-08
+ $X=0.891 $Y=0.2295 $X2=0.891 $Y2=0.181
r58 36 37 15.8334 $w=2.07609e-08 $l=4.6e-08 $layer=Gate_1 $thickness=5.6e-08
+ $X=0.891 $Y=0.135 $X2=0.891 $Y2=0.181
r59 35 36 15.8334 $w=2.07609e-08 $l=4.6e-08 $layer=Gate_1 $thickness=5.6e-08
+ $X=0.891 $Y=0.089 $X2=0.891 $Y2=0.135
r60 34 35 16.4967 $w=2.1e-08 $l=4.85e-08 $layer=Gate_1 $thickness=5.6e-08
+ $X=0.891 $Y=0.0405 $X2=0.891 $Y2=0.089
r61 34 15 5.44221 $w=2.1e-08 $l=1.6e-08 $layer=Gate_1 $thickness=5.6e-08
+ $X=0.891 $Y=0.0405 $X2=0.891 $Y2=0.0245
r62 8 17 1e-05 $l=2e-09 $X=0.054 $Y=0.216 $X2=0.056 $Y2=0.216
r63 7 16 1e-05 $l=2e-09 $X=0.054 $Y=0.054 $X2=0.056 $Y2=0.054
.ends

.subckt PM_SDFHx2_ASAP7_75t_R%SE vss 41 16 22 51 55 11 7 8 10 13 6 9 12 1 2 5
c1 1 vss 0.004865f $X=0.297 $Y=0.135
c2 2 vss 0.00488987f $X=1.215 $Y=0.136
c3 5 vss 0.0856046f $X=0.297 $Y=0.135
c4 6 vss 0.098145f $X=1.215 $Y=0.0245
c5 7 vss 0.00777162f $X=0.225 $Y=0.036
c6 8 vss 0.000475324f $X=0.225 $Y=0.1297
c7 9 vss 0.00651501f $X=1.215 $Y=0.036
c8 10 vss 0.00423053f $X=0.225 $Y=0.0495
c9 11 vss 0.00355766f $X=0.2445 $Y=0.135
c10 12 vss 0.0038988f $X=1.215 $Y=0.0495
c11 13 vss 0.0535919f $X=1.1905 $Y=0.045
r1 55 54 14.6259 $w=2.1e-08 $l=4.3e-08 $layer=Gate_1 $thickness=5.6e-08
+ $X=0.297 $Y=0.2025 $X2=0.297 $Y2=0.1595
r2 53 54 2.7211 $w=2.1e-08 $l=8e-09 $layer=Gate_1 $thickness=5.6e-08 $X=0.297
+ $Y=0.1515 $X2=0.297 $Y2=0.1595
r3 51 52 14.6259 $w=2.1e-08 $l=4.3e-08 $layer=Gate_1 $thickness=5.6e-08
+ $X=0.297 $Y=0.0675 $X2=0.297 $Y2=0.1105
r4 49 52 2.7211 $w=2.1e-08 $l=8e-09 $layer=Gate_1 $thickness=5.6e-08 $X=0.297
+ $Y=0.1185 $X2=0.297 $Y2=0.1105
r5 5 49 5.79936 $w=2.03333e-08 $l=1.65e-08 $layer=Gate_1 $thickness=5.6e-08
+ $X=0.297 $Y=0.135 $X2=0.297 $Y2=0.1185
r6 5 53 5.79936 $w=2.03333e-08 $l=1.65e-08 $layer=Gate_1 $thickness=5.6e-08
+ $X=0.297 $Y=0.135 $X2=0.297 $Y2=0.1515
r7 1 46 19.3796 $a=3.24e-16 $layer=V0LIG $X=0.297 $Y=0.135 $X2=0.297 $Y2=0.135
r8 1 5 10.4265 $w=1.765e-08 $layer=LIG $thickness=5.2e-08 $X=0.297 $Y=0.135
+ $X2=0.297 $Y2=0.135
r9 45 46 5.24677 $w=1.3e-08 $l=2.25e-08 $layer=M1 $thickness=3.6e-08 $X=0.2745
+ $Y=0.135 $X2=0.297 $Y2=0.135
r10 44 45 3.49785 $w=1.3e-08 $l=1.5e-08 $layer=M1 $thickness=3.6e-08 $X=0.2595
+ $Y=0.135 $X2=0.2745 $Y2=0.135
r11 43 44 0.699569 $w=1.3e-08 $l=3e-09 $layer=M1 $thickness=3.6e-08 $X=0.2565
+ $Y=0.135 $X2=0.2595 $Y2=0.135
r12 41 11 2.49951 $w=7.46154e-09 $l=1.95256e-08 $layer=M1 $thickness=3.6e-08
+ $X=0.227 $Y=0.134 $X2=0.2445 $Y2=0.135
r13 11 43 2.79828 $w=1.3e-08 $l=1.2e-08 $layer=M1 $thickness=3.6e-08 $X=0.2445
+ $Y=0.135 $X2=0.2565 $Y2=0.135
r14 41 8 0.433689 $w=1.8e-08 $l=4.3e-09 $layer=M1 $thickness=3.6e-08 $X=0.227
+ $Y=0.134 $X2=0.225 $Y2=0.1297
r15 8 40 3.53073 $w=1.4087e-08 $l=1.72e-08 $layer=M1 $thickness=3.6e-08
+ $X=0.225 $Y=0.1297 $X2=0.225 $Y2=0.1125
r16 39 40 5.24677 $w=1.3e-08 $l=2.25e-08 $layer=M1 $thickness=3.6e-08 $X=0.225
+ $Y=0.09 $X2=0.225 $Y2=0.1125
r17 38 39 5.24677 $w=1.3e-08 $l=2.25e-08 $layer=M1 $thickness=3.6e-08 $X=0.225
+ $Y=0.0675 $X2=0.225 $Y2=0.09
r18 10 38 4.19742 $w=1.3e-08 $l=1.8e-08 $layer=M1 $thickness=3.6e-08 $X=0.225
+ $Y=0.0495 $X2=0.225 $Y2=0.0675
r19 10 35 39.0693 $a=1.62e-16 $layer=V1 $X=0.225 $Y=0.0495 $X2=0.225 $Y2=0.045
r20 7 35 39.0693 $a=1.62e-16 $layer=V1 $X=0.225 $Y=0.036 $X2=0.225 $Y2=0.045
r21 7 10 1.96775 $w=1.63333e-08 $l=1.35e-08 $layer=M1 $thickness=3.6e-08
+ $X=0.225 $Y=0.036 $X2=0.225 $Y2=0.0495
r22 35 36 14.108 $w=1.3e-08 $l=6.05e-08 $layer=M2 $thickness=3.6e-08 $X=0.225
+ $Y=0.045 $X2=0.2855 $Y2=0.045
r23 33 36 109.716 $w=1.3e-08 $l=4.705e-07 $layer=M2 $thickness=3.6e-08 $X=0.756
+ $Y=0.045 $X2=0.2855 $Y2=0.045
r24 13 31 5.71315 $w=1.3e-08 $l=2.45e-08 $layer=M2 $thickness=3.6e-08 $X=1.1905
+ $Y=0.045 $X2=1.215 $Y2=0.045
r25 13 33 101.321 $w=1.3e-08 $l=4.345e-07 $layer=M2 $thickness=3.6e-08
+ $X=1.1905 $Y=0.045 $X2=0.756 $Y2=0.045
r26 9 12 1.96775 $w=1.63333e-08 $l=1.35e-08 $layer=M1 $thickness=3.6e-08
+ $X=1.215 $Y=0.036 $X2=1.215 $Y2=0.0495
r27 9 31 39.0693 $a=1.62e-16 $layer=V1 $X=1.215 $Y=0.036 $X2=1.215 $Y2=0.045
r28 27 28 6.41272 $w=1.3e-08 $l=2.75e-08 $layer=M1 $thickness=3.6e-08 $X=1.215
+ $Y=0.1085 $X2=1.215 $Y2=0.136
r29 26 27 8.51143 $w=1.3e-08 $l=3.65e-08 $layer=M1 $thickness=3.6e-08 $X=1.215
+ $Y=0.072 $X2=1.215 $Y2=0.1085
r30 12 26 5.24677 $w=1.3e-08 $l=2.25e-08 $layer=M1 $thickness=3.6e-08 $X=1.215
+ $Y=0.0495 $X2=1.215 $Y2=0.072
r31 12 31 39.0693 $a=1.62e-16 $layer=V1 $X=1.215 $Y=0.0495 $X2=1.215 $Y2=0.045
r32 2 19 6.54019 $w=2.09524e-08 $layer=Gate_1 $thickness=5.21905e-08 $X=1.215
+ $Y=0.136 $X2=1.215 $Y2=0.136
r33 2 28 19.3796 $a=3.24e-16 $layer=V0LIG $X=1.215 $Y=0.136 $X2=1.215 $Y2=0.136
r34 22 21 14.6259 $w=2.1e-08 $l=4.3e-08 $layer=Gate_1 $thickness=5.6e-08
+ $X=1.215 $Y=0.2295 $X2=1.215 $Y2=0.1865
r35 20 21 11.7348 $w=2.1e-08 $l=3.45e-08 $layer=Gate_1 $thickness=5.6e-08
+ $X=1.215 $Y=0.152 $X2=1.215 $Y2=0.1865
r36 19 20 5.62929 $w=2.03125e-08 $l=1.6e-08 $layer=Gate_1 $thickness=5.6e-08
+ $X=1.215 $Y=0.136 $X2=1.215 $Y2=0.152
r37 18 19 5.96942 $w=2.03529e-08 $l=1.7e-08 $layer=Gate_1 $thickness=5.6e-08
+ $X=1.215 $Y=0.119 $X2=1.215 $Y2=0.136
r38 17 18 12.0749 $w=2.1e-08 $l=3.55e-08 $layer=Gate_1 $thickness=5.6e-08
+ $X=1.215 $Y=0.0835 $X2=1.215 $Y2=0.119
r39 16 17 14.6259 $w=2.1e-08 $l=4.3e-08 $layer=Gate_1 $thickness=5.6e-08
+ $X=1.215 $Y=0.0405 $X2=1.215 $Y2=0.0835
r40 16 6 5.44221 $w=2.1e-08 $l=1.6e-08 $layer=Gate_1 $thickness=5.6e-08
+ $X=1.215 $Y=0.0405 $X2=1.215 $Y2=0.0245
.ends

.subckt PM_SDFHx2_ASAP7_75t_R%6 vss 19 23 50 52 16 14 10 15 4 3 1 13 12 9 11
c1 1 vss 0.00454098f $X=0.351 $Y=0.135
c2 3 vss 0.0113831f $X=1.1485 $Y=0.0455
c3 4 vss 0.0065735f $X=1.188 $Y=0.2295
c4 9 vss 0.102112f $X=0.351 $Y=0.0245
c5 10 vss 0.0184124f $X=1.19 $Y=0.0405
c6 11 vss 0.0193219f $X=1.19 $Y=0.2295
c7 12 vss 0.00719241f $X=0.351 $Y=0.072
c8 13 vss 0.0063339f $X=1.161 $Y=0.234
c9 14 vss 0.00321779f $X=0.351 $Y=0.135
c10 15 vss 0.00508954f $X=1.161 $Y=0.037
c11 16 vss 0.0197655f $X=0.3395 $Y=0.081
r1 52 51 0.0925926 $w=2.7e-08 $l=2.5e-09 $layer=P_src_drn $thickness=1e-09
+ $X=1.2053 $Y=0.2295 $X2=1.2025 $Y2=0.2295
r2 11 51 0.462963 $w=2.7e-08 $l=1.25e-08 $layer=P_src_drn $thickness=1e-09
+ $X=1.19 $Y=0.2295 $X2=1.2025 $Y2=0.2295
r3 4 47 19.3796 $a=3.24e-16 $layer=V0LISD $X=1.188 $Y=0.2295 $X2=1.188 $Y2=0.234
r4 50 49 0.0925926 $w=2.7e-08 $l=2.5e-09 $layer=N_src_drn $thickness=1e-09
+ $X=1.2053 $Y=0.0405 $X2=1.2025 $Y2=0.0405
r5 10 49 0.462963 $w=2.7e-08 $l=1.25e-08 $layer=N_src_drn $thickness=1e-09
+ $X=1.19 $Y=0.0405 $X2=1.2025 $Y2=0.0405
r6 46 47 3.14806 $w=1.3e-08 $l=1.35e-08 $layer=M1 $thickness=3.6e-08 $X=1.1745
+ $Y=0.234 $X2=1.188 $Y2=0.234
r7 13 42 3.83327 $w=1.5093e-08 $l=2.15e-08 $layer=M1 $thickness=3.6e-08
+ $X=1.161 $Y=0.234 $X2=1.161 $Y2=0.2125
r8 13 46 1.96775 $w=1.63333e-08 $l=1.35e-08 $layer=M1 $thickness=3.6e-08
+ $X=1.161 $Y=0.234 $X2=1.1745 $Y2=0.234
r9 44 10 3.98201 $w=3.32e-08 $l=1.5e-08 $layer=LISD $thickness=2.7e-08 $X=1.173
+ $Y=0.0455 $X2=1.19 $Y2=0.0405
r10 43 44 3.18561 $w=3.32e-08 $l=1.2e-08 $layer=LISD $thickness=2.7e-08
+ $X=1.161 $Y=0.0455 $X2=1.173 $Y2=0.0455
r11 3 43 3.31834 $w=3.32e-08 $l=1.25e-08 $layer=LISD $thickness=2.7e-08
+ $X=1.1485 $Y=0.0455 $X2=1.161 $Y2=0.0455
r12 41 42 15.7403 $w=1.3e-08 $l=6.75e-08 $layer=M1 $thickness=3.6e-08 $X=1.161
+ $Y=0.145 $X2=1.161 $Y2=0.2125
r13 40 41 14.9241 $w=1.3e-08 $l=6.4e-08 $layer=M1 $thickness=3.6e-08 $X=1.161
+ $Y=0.081 $X2=1.161 $Y2=0.145
r14 39 40 3.73104 $w=1.3e-08 $l=1.6e-08 $layer=M1 $thickness=3.6e-08 $X=1.161
+ $Y=0.065 $X2=1.161 $Y2=0.081
r15 38 39 3.14806 $w=1.3e-08 $l=1.35e-08 $layer=M1 $thickness=3.6e-08 $X=1.161
+ $Y=0.0515 $X2=1.161 $Y2=0.065
r16 38 43 19.3796 $a=3.24e-16 $layer=V0LISD $X=1.161 $Y=0.0515 $X2=1.161
+ $Y2=0.0455
r17 37 38 2.09871 $w=1.3e-08 $l=9e-09 $layer=M1 $thickness=3.6e-08 $X=1.161
+ $Y=0.0425 $X2=1.161 $Y2=0.0515
r18 15 37 1.28254 $w=1.3e-08 $l=5.5e-09 $layer=M1 $thickness=3.6e-08 $X=1.161
+ $Y=0.037 $X2=1.161 $Y2=0.0425
r19 35 40 19.5347 $a=3.24e-16 $layer=V1 $X=1.161 $Y=0.081 $X2=1.161 $Y2=0.081
r20 34 35 27.2832 $w=1.3e-08 $l=1.17e-07 $layer=M2 $thickness=3.6e-08 $X=1.044
+ $Y=0.081 $X2=1.161 $Y2=0.081
r21 33 34 29.3819 $w=1.3e-08 $l=1.26e-07 $layer=M2 $thickness=3.6e-08 $X=0.918
+ $Y=0.081 $X2=1.044 $Y2=0.081
r22 32 33 67.1587 $w=1.3e-08 $l=2.88e-07 $layer=M2 $thickness=3.6e-08 $X=0.63
+ $Y=0.081 $X2=0.918 $Y2=0.081
r23 31 32 65.0599 $w=1.3e-08 $l=2.79e-07 $layer=M2 $thickness=3.6e-08 $X=0.351
+ $Y=0.081 $X2=0.63 $Y2=0.081
r24 16 31 2.68168 $w=1.3e-08 $l=1.15e-08 $layer=M2 $thickness=3.6e-08 $X=0.3395
+ $Y=0.081 $X2=0.351 $Y2=0.081
r25 12 27 1.96775 $w=1.63333e-08 $l=1.35e-08 $layer=M1 $thickness=3.6e-08
+ $X=0.351 $Y=0.072 $X2=0.351 $Y2=0.0855
r26 12 31 39.0693 $a=1.62e-16 $layer=V1 $X=0.351 $Y=0.072 $X2=0.351 $Y2=0.081
r27 27 28 2.09871 $w=1.3e-08 $l=9e-09 $layer=M1 $thickness=3.6e-08 $X=0.351
+ $Y=0.0855 $X2=0.351 $Y2=0.0945
r28 27 31 39.0693 $a=1.62e-16 $layer=V1 $X=0.351 $Y=0.0855 $X2=0.351 $Y2=0.081
r29 26 28 3.14806 $w=1.3e-08 $l=1.35e-08 $layer=M1 $thickness=3.6e-08 $X=0.351
+ $Y=0.108 $X2=0.351 $Y2=0.0945
r30 25 26 3.14806 $w=1.3e-08 $l=1.35e-08 $layer=M1 $thickness=3.6e-08 $X=0.351
+ $Y=0.1215 $X2=0.351 $Y2=0.108
r31 14 25 3.14806 $w=1.3e-08 $l=1.35e-08 $layer=M1 $thickness=3.6e-08 $X=0.351
+ $Y=0.135 $X2=0.351 $Y2=0.1215
r32 1 21 10.4265 $w=1.765e-08 $layer=LIG $thickness=5.2e-08 $X=0.351 $Y=0.135
+ $X2=0.351 $Y2=0.135
r33 1 14 19.3796 $a=3.24e-16 $layer=V0LIG $X=0.351 $Y=0.135 $X2=0.351 $Y2=0.135
r34 23 22 16.4967 $w=2.1e-08 $l=4.85e-08 $layer=Gate_1 $thickness=5.6e-08
+ $X=0.351 $Y=0.2025 $X2=0.351 $Y2=0.154
r35 21 22 6.6497 $w=2.04211e-08 $l=1.9e-08 $layer=Gate_1 $thickness=5.6e-08
+ $X=0.351 $Y=0.135 $X2=0.351 $Y2=0.154
r36 20 21 6.6497 $w=2.04211e-08 $l=1.9e-08 $layer=Gate_1 $thickness=5.6e-08
+ $X=0.351 $Y=0.116 $X2=0.351 $Y2=0.135
r37 19 20 16.4967 $w=2.1e-08 $l=4.85e-08 $layer=Gate_1 $thickness=5.6e-08
+ $X=0.351 $Y=0.0675 $X2=0.351 $Y2=0.116
r38 19 9 14.6259 $w=2.1e-08 $l=4.3e-08 $layer=Gate_1 $thickness=5.6e-08
+ $X=0.351 $Y=0.0675 $X2=0.351 $Y2=0.0245
r39 4 11 1e-05 $l=2e-09 $X=1.188 $Y=0.2295 $X2=1.19 $Y2=0.2295
.ends

.subckt PM_SDFHx2_ASAP7_75t_R%9 vss 30 56 61 91 94 96 7 21 6 23 20 18 19 3 4 25
+ 8 22 26 2 1 24 15 16 14 17
c1 1 vss 0.00357136f $X=0.567 $Y=0.1355
c2 2 vss 8.68537e-20 $X=0.675 $Y=0.178
c3 3 vss 4.42191e-20 $X=0.837 $Y=0.178
c4 4 vss 0.000803689f $X=0.945 $Y=0.178
c5 6 vss 0.00774229f $X=0.162 $Y=0.054
c6 7 vss 0.00761664f $X=0.162 $Y=0.216
c7 8 vss 0.00561129f $X=0.837 $Y=0.178
c8 14 vss 0.0597017f $X=0.567 $Y=0.1355
c9 15 vss 0.00669183f $X=0.675 $Y=0.178
c10 16 vss 0.00621553f $X=0.837 $Y=0.0245
c11 17 vss 0.00749284f $X=0.945 $Y=0.178
c12 18 vss 0.0349174f $X=0.1475 $Y=0.054
c13 19 vss 0.0346278f $X=0.1475 $Y=0.216
c14 20 vss 0.00562973f $X=0.189 $Y=0.036
c15 21 vss 0.00615899f $X=0.189 $Y=0.234
c16 22 vss 0.00125339f $X=0.567 $Y=0.198
c17 23 vss 0.00511316f $X=0.189 $Y=0.1735
c18 24 vss 0.00440311f $X=0.567 $Y=0.1755
c19 25 vss 0.00142838f $X=0.729 $Y=0.168
c20 26 vss 0.0333011f $X=0.1775 $Y=0.189
r1 19 7 0.231482 $w=5.4e-08 $l=1.25e-08 $layer=P_src_drn $thickness=1e-09
+ $X=0.1475 $Y=0.216 $X2=0.162 $Y2=0.216
r2 96 19 0.0462963 $w=5.4e-08 $l=2.5e-09 $layer=P_src_drn $thickness=1e-09
+ $X=0.1446 $Y=0.216 $X2=0.1475 $Y2=0.216
r3 18 6 0.231482 $w=5.4e-08 $l=1.25e-08 $layer=N_src_drn $thickness=1e-09
+ $X=0.1475 $Y=0.054 $X2=0.162 $Y2=0.054
r4 94 18 0.0462963 $w=5.4e-08 $l=2.5e-09 $layer=N_src_drn $thickness=1e-09
+ $X=0.1446 $Y=0.054 $X2=0.1475 $Y2=0.054
r5 91 90 16.4967 $w=2.1e-08 $l=4.85e-08 $layer=Gate_1 $thickness=5.6e-08
+ $X=0.567 $Y=0.2025 $X2=0.567 $Y2=0.154
r6 14 90 6.47113 $w=2.04324e-08 $l=1.85e-08 $layer=Gate_1 $thickness=5.6e-08
+ $X=0.567 $Y=0.1355 $X2=0.567 $Y2=0.154
r7 7 85 19.3796 $a=3.24e-16 $layer=V0LISD $X=0.162 $Y=0.216 $X2=0.162 $Y2=0.234
r8 6 82 19.3796 $a=3.24e-16 $layer=V0LISD $X=0.162 $Y=0.054 $X2=0.162 $Y2=0.036
r9 1 79 19.3796 $a=3.24e-16 $layer=V0LIG $X=0.567 $Y=0.1355 $X2=0.567 $Y2=0.135
r10 1 14 6.63025 $w=2.04878e-08 $layer=Gate_1 $thickness=5.20976e-08 $X=0.567
+ $Y=0.1355 $X2=0.567 $Y2=0.1355
r11 85 86 3.14806 $w=1.3e-08 $l=1.35e-08 $layer=M1 $thickness=3.6e-08 $X=0.162
+ $Y=0.234 $X2=0.1755 $Y2=0.234
r12 21 73 3.01711 $w=1.55e-08 $l=1.8e-08 $layer=M1 $thickness=3.6e-08 $X=0.189
+ $Y=0.234 $X2=0.189 $Y2=0.216
r13 21 86 1.96775 $w=1.63333e-08 $l=1.35e-08 $layer=M1 $thickness=3.6e-08
+ $X=0.189 $Y=0.234 $X2=0.1755 $Y2=0.234
r14 82 83 3.14806 $w=1.3e-08 $l=1.35e-08 $layer=M1 $thickness=3.6e-08 $X=0.162
+ $Y=0.036 $X2=0.1755 $Y2=0.036
r15 20 69 5.11582 $w=1.46667e-08 $l=2.7e-08 $layer=M1 $thickness=3.6e-08
+ $X=0.189 $Y=0.036 $X2=0.189 $Y2=0.063
r16 20 83 1.96775 $w=1.63333e-08 $l=1.35e-08 $layer=M1 $thickness=3.6e-08
+ $X=0.189 $Y=0.036 $X2=0.1755 $Y2=0.036
r17 79 80 3.14806 $w=1.3e-08 $l=1.35e-08 $layer=M1 $thickness=3.6e-08 $X=0.567
+ $Y=0.135 $X2=0.567 $Y2=0.1485
r18 77 80 3.14806 $w=1.3e-08 $l=1.35e-08 $layer=M1 $thickness=3.6e-08 $X=0.567
+ $Y=0.162 $X2=0.567 $Y2=0.1485
r19 24 76 2.09871 $w=1.3e-08 $l=9e-09 $layer=M1 $thickness=3.6e-08 $X=0.567
+ $Y=0.1755 $X2=0.567 $Y2=0.1845
r20 24 77 3.14806 $w=1.3e-08 $l=1.35e-08 $layer=M1 $thickness=3.6e-08 $X=0.567
+ $Y=0.1755 $X2=0.567 $Y2=0.162
r21 22 51 39.0693 $a=1.62e-16 $layer=V1 $X=0.567 $Y=0.198 $X2=0.567 $Y2=0.189
r22 22 76 1.96775 $w=1.63333e-08 $l=1.35e-08 $layer=M1 $thickness=3.6e-08
+ $X=0.567 $Y=0.198 $X2=0.567 $Y2=0.1845
r23 72 73 2.91487 $w=1.3e-08 $l=1.25e-08 $layer=M1 $thickness=3.6e-08 $X=0.189
+ $Y=0.2035 $X2=0.189 $Y2=0.216
r24 71 72 1.04935 $w=1.3e-08 $l=4.5e-09 $layer=M1 $thickness=3.6e-08 $X=0.189
+ $Y=0.199 $X2=0.189 $Y2=0.2035
r25 70 71 1.28254 $w=1.3e-08 $l=5.5e-09 $layer=M1 $thickness=3.6e-08 $X=0.189
+ $Y=0.1935 $X2=0.189 $Y2=0.199
r26 68 69 6.29612 $w=1.3e-08 $l=2.7e-08 $layer=M1 $thickness=3.6e-08 $X=0.189
+ $Y=0.09 $X2=0.189 $Y2=0.063
r27 67 68 4.6638 $w=1.3e-08 $l=2e-08 $layer=M1 $thickness=3.6e-08 $X=0.189
+ $Y=0.11 $X2=0.189 $Y2=0.09
r28 66 67 5.24677 $w=1.3e-08 $l=2.25e-08 $layer=M1 $thickness=3.6e-08 $X=0.189
+ $Y=0.1325 $X2=0.189 $Y2=0.11
r29 65 66 5.01358 $w=1.3e-08 $l=2.15e-08 $layer=M1 $thickness=3.6e-08 $X=0.189
+ $Y=0.154 $X2=0.189 $Y2=0.1325
r30 64 65 2.68168 $w=1.3e-08 $l=1.15e-08 $layer=M1 $thickness=3.6e-08 $X=0.189
+ $Y=0.1655 $X2=0.189 $Y2=0.154
r31 63 70 2.09871 $w=1.3e-08 $l=9e-09 $layer=M1 $thickness=3.6e-08 $X=0.189
+ $Y=0.1845 $X2=0.189 $Y2=0.1935
r32 23 63 2.56509 $w=1.3e-08 $l=1.1e-08 $layer=M1 $thickness=3.6e-08 $X=0.189
+ $Y=0.1735 $X2=0.189 $Y2=0.1845
r33 23 64 1.86552 $w=1.3e-08 $l=8e-09 $layer=M1 $thickness=3.6e-08 $X=0.189
+ $Y=0.1735 $X2=0.189 $Y2=0.1655
r34 61 60 8.84359 $w=2.1e-08 $l=2.6e-08 $layer=Gate_1 $thickness=5.6e-08
+ $X=0.945 $Y=0.2295 $X2=0.945 $Y2=0.2035
r35 17 60 8.89461 $w=2.04902e-08 $l=2.55e-08 $layer=Gate_1 $thickness=5.6e-08
+ $X=0.945 $Y=0.178 $X2=0.945 $Y2=0.2035
r36 56 57 23.4695 $w=2.1e-08 $l=6.9e-08 $layer=Gate_1 $thickness=5.6e-08
+ $X=0.675 $Y=0.0405 $X2=0.675 $Y2=0.1095
r37 15 57 23.5205 $w=2.08102e-08 $l=6.85e-08 $layer=Gate_1 $thickness=5.6e-08
+ $X=0.675 $Y=0.178 $X2=0.675 $Y2=0.1095
r38 52 53 18.8884 $w=1.3e-08 $l=8.1e-08 $layer=M2 $thickness=3.6e-08 $X=0.648
+ $Y=0.189 $X2=0.729 $Y2=0.189
r39 51 52 18.8884 $w=1.3e-08 $l=8.1e-08 $layer=M2 $thickness=3.6e-08 $X=0.567
+ $Y=0.189 $X2=0.648 $Y2=0.189
r40 51 76 39.0693 $a=1.62e-16 $layer=V1 $X=0.567 $Y=0.189 $X2=0.567 $Y2=0.1845
r41 50 51 44.0729 $w=1.3e-08 $l=1.89e-07 $layer=M2 $thickness=3.6e-08 $X=0.378
+ $Y=0.189 $X2=0.567 $Y2=0.189
r42 49 50 44.0729 $w=1.3e-08 $l=1.89e-07 $layer=M2 $thickness=3.6e-08 $X=0.189
+ $Y=0.189 $X2=0.378 $Y2=0.189
r43 49 63 19.5347 $a=3.24e-16 $layer=V1 $X=0.189 $Y=0.189 $X2=0.189 $Y2=0.1845
r44 26 49 2.68168 $w=1.3e-08 $l=1.15e-08 $layer=M2 $thickness=3.6e-08 $X=0.1775
+ $Y=0.189 $X2=0.189 $Y2=0.189
r45 4 46 2.78395 $w=2.4e-08 $layer=LIG $thickness=4.8e-08 $X=0.945 $Y=0.178
+ $X2=0.945 $Y2=0.178
r46 4 17 7.42683 $w=2.2e-08 $layer=Gate_1 $thickness=5.2e-08 $X=0.945 $Y=0.178
+ $X2=0.945 $Y2=0.178
r47 2 41 2.78395 $w=2.4e-08 $layer=LIG $thickness=4.8e-08 $X=0.675 $Y=0.178
+ $X2=0.675 $Y2=0.178
r48 2 15 7.42683 $w=2.2e-08 $layer=Gate_1 $thickness=5.2e-08 $X=0.675 $Y=0.178
+ $X2=0.675 $Y2=0.178
r49 47 53 19.5347 $a=3.24e-16 $layer=V1 $X=0.729 $Y=0.1845 $X2=0.729 $Y2=0.189
r50 25 47 3.84763 $w=1.3e-08 $l=1.65e-08 $layer=M1 $thickness=3.6e-08 $X=0.729
+ $Y=0.168 $X2=0.729 $Y2=0.1845
r51 45 46 6.83711 $w=2.22e-08 $l=1.5e-09 $layer=LISD $thickness=2.7e-08
+ $X=0.9435 $Y=0.178 $X2=0.945 $Y2=0.178
r52 44 45 12.9145 $w=2.22e-08 $l=2.55e-08 $layer=LISD $thickness=2.7e-08
+ $X=0.918 $Y=0.178 $X2=0.9435 $Y2=0.178
r53 43 44 13.6742 $w=2.22e-08 $l=2.7e-08 $layer=LISD $thickness=2.7e-08
+ $X=0.891 $Y=0.178 $X2=0.918 $Y2=0.178
r54 42 43 13.6742 $w=2.22e-08 $l=2.7e-08 $layer=LISD $thickness=2.7e-08
+ $X=0.864 $Y=0.178 $X2=0.891 $Y2=0.178
r55 40 41 12.9145 $w=2.22e-08 $l=1.35e-08 $layer=LISD $thickness=2.7e-08
+ $X=0.6885 $Y=0.178 $X2=0.675 $Y2=0.178
r56 38 39 6.07743 $w=2.22e-08 $l=1.2e-08 $layer=LISD $thickness=2.7e-08
+ $X=0.729 $Y=0.178 $X2=0.741 $Y2=0.178
r57 38 47 19.3796 $a=3.24e-16 $layer=V0LISD $X=0.729 $Y=0.178 $X2=0.729
+ $Y2=0.1845
r58 37 38 6.07743 $w=2.22e-08 $l=1.2e-08 $layer=LISD $thickness=2.7e-08
+ $X=0.717 $Y=0.178 $X2=0.729 $Y2=0.178
r59 37 40 14.4339 $w=2.22e-08 $l=2.85e-08 $layer=LISD $thickness=2.7e-08
+ $X=0.717 $Y=0.178 $X2=0.6885 $Y2=0.178
r60 36 39 7.59679 $w=2.22e-08 $l=1.5e-08 $layer=LISD $thickness=2.7e-08
+ $X=0.756 $Y=0.178 $X2=0.741 $Y2=0.178
r61 35 36 13.6742 $w=2.22e-08 $l=2.7e-08 $layer=LISD $thickness=2.7e-08
+ $X=0.783 $Y=0.178 $X2=0.756 $Y2=0.178
r62 34 35 13.6742 $w=2.22e-08 $l=2.7e-08 $layer=LISD $thickness=2.7e-08 $X=0.81
+ $Y=0.178 $X2=0.783 $Y2=0.178
r63 8 34 13.6742 $w=2.22e-08 $l=2.7e-08 $layer=LISD $thickness=2.7e-08 $X=0.837
+ $Y=0.178 $X2=0.81 $Y2=0.178
r64 8 42 13.6742 $w=2.22e-08 $l=2.7e-08 $layer=LISD $thickness=2.7e-08 $X=0.837
+ $Y=0.178 $X2=0.864 $Y2=0.178
r65 3 32 7.42683 $w=2.2e-08 $layer=Gate_1 $thickness=5.2e-08 $X=0.837 $Y=0.178
+ $X2=0.837 $Y2=0.178
r66 3 8 10.3807 $w=2.30357e-08 $layer=LISD $thickness=3.675e-08 $X=0.837
+ $Y=0.178 $X2=0.837 $Y2=0.178
r67 31 32 23.5205 $w=2.08102e-08 $l=6.85e-08 $layer=Gate_1 $thickness=5.6e-08
+ $X=0.837 $Y=0.1095 $X2=0.837 $Y2=0.178
r68 30 31 23.4695 $w=2.1e-08 $l=6.9e-08 $layer=Gate_1 $thickness=5.6e-08
+ $X=0.837 $Y=0.0405 $X2=0.837 $Y2=0.1095
r69 30 16 5.44221 $w=2.1e-08 $l=1.6e-08 $layer=Gate_1 $thickness=5.6e-08
+ $X=0.837 $Y=0.0405 $X2=0.837 $Y2=0.0245
.ends

.subckt PM_SDFHx2_ASAP7_75t_R%10 vss 21 25 47 48 52 54 13 18 20 15 14 17 3 4 11
+ 12 1 10 19
c1 1 vss 0.00323265f $X=0.7285 $Y=0.09
c2 3 vss 0.00518758f $X=0.81 $Y=0.0405
c3 4 vss 0.00826655f $X=0.81 $Y=0.2295
c4 10 vss 0.0489659f $X=0.729 $Y=0.0245
c5 11 vss 0.00376089f $X=0.7955 $Y=0.0405
c6 12 vss 0.00358684f $X=0.7955 $Y=0.2295
c7 13 vss 0.00314749f $X=0.866 $Y=0.2295
c8 14 vss 0.00131691f $X=0.729 $Y=0.09
c9 15 vss 0.00123359f $X=0.81 $Y=0.09
c10 16 vss 0.00262761f $X=0.837 $Y=0.234
c11 17 vss 0.00104305f $X=0.747 $Y=0.09
c12 18 vss 0.00366209f $X=0.81 $Y=0.234
c13 19 vss 0.00182539f $X=0.81 $Y=0.0625
c14 20 vss 0.00139394f $X=0.837 $Y=0.1
r1 54 53 0.0925926 $w=2.7e-08 $l=2.5e-09 $layer=P_src_drn $thickness=1e-09
+ $X=0.8813 $Y=0.2295 $X2=0.8785 $Y2=0.2295
r2 13 53 0.462963 $w=2.7e-08 $l=1.25e-08 $layer=P_src_drn $thickness=1e-09
+ $X=0.866 $Y=0.2295 $X2=0.8785 $Y2=0.2295
r3 12 4 0.462963 $w=2.7e-08 $l=1.25e-08 $layer=P_src_drn $thickness=1e-09
+ $X=0.7955 $Y=0.2295 $X2=0.81 $Y2=0.2295
r4 52 12 0.0925926 $w=2.7e-08 $l=2.5e-09 $layer=P_src_drn $thickness=1e-09
+ $X=0.7926 $Y=0.2295 $X2=0.7955 $Y2=0.2295
r5 49 13 12.6992 $w=2.32e-08 $l=2.7e-08 $layer=LISD $thickness=2.7e-08 $X=0.837
+ $Y=0.2295 $X2=0.866 $Y2=0.2295
r6 4 49 12.6992 $w=2.32e-08 $l=2.7e-08 $layer=LISD $thickness=2.7e-08 $X=0.81
+ $Y=0.2295 $X2=0.837 $Y2=0.2295
r7 4 18 19.3796 $a=3.24e-16 $layer=V0LISD $X=0.81 $Y=0.2295 $X2=0.81 $Y2=0.234
r8 47 46 0.0925926 $w=2.7e-08 $l=2.5e-09 $layer=N_src_drn $thickness=1e-09
+ $X=0.8273 $Y=0.0405 $X2=0.8245 $Y2=0.0405
r9 3 46 0.537037 $w=2.7e-08 $l=1.45e-08 $layer=N_src_drn $thickness=1e-09
+ $X=0.81 $Y=0.0405 $X2=0.8245 $Y2=0.0405
r10 11 3 0.537037 $w=2.7e-08 $l=1.45e-08 $layer=N_src_drn $thickness=1e-09
+ $X=0.7955 $Y=0.0405 $X2=0.81 $Y2=0.0405
r11 48 11 0.0925926 $w=2.7e-08 $l=2.5e-09 $layer=N_src_drn $thickness=1e-09
+ $X=0.7926 $Y=0.0405 $X2=0.7955 $Y2=0.0405
r12 16 42 2.5483 $w=1.79e-08 $l=1.8e-08 $layer=M1 $thickness=3.6e-08 $X=0.837
+ $Y=0.234 $X2=0.837 $Y2=0.216
r13 16 18 4.64701 $w=1.46667e-08 $l=2.7e-08 $layer=M1 $thickness=3.6e-08
+ $X=0.837 $Y=0.234 $X2=0.81 $Y2=0.234
r14 3 36 19.3796 $a=3.24e-16 $layer=V0LISD $X=0.81 $Y=0.0405 $X2=0.81 $Y2=0.0535
r15 41 42 6.7625 $w=1.3e-08 $l=2.9e-08 $layer=M1 $thickness=3.6e-08 $X=0.837
+ $Y=0.187 $X2=0.837 $Y2=0.216
r16 40 41 4.89699 $w=1.3e-08 $l=2.1e-08 $layer=M1 $thickness=3.6e-08 $X=0.837
+ $Y=0.166 $X2=0.837 $Y2=0.187
r17 39 40 3.14806 $w=1.3e-08 $l=1.35e-08 $layer=M1 $thickness=3.6e-08 $X=0.837
+ $Y=0.1525 $X2=0.837 $Y2=0.166
r18 38 39 5.01358 $w=1.3e-08 $l=2.15e-08 $layer=M1 $thickness=3.6e-08 $X=0.837
+ $Y=0.131 $X2=0.837 $Y2=0.1525
r19 37 38 4.5472 $w=1.3e-08 $l=1.95e-08 $layer=M1 $thickness=3.6e-08 $X=0.837
+ $Y=0.1115 $X2=0.837 $Y2=0.131
r20 20 34 1.15159 $w=1.75e-08 $l=1e-08 $layer=M1 $thickness=3.6e-08 $X=0.837
+ $Y=0.1 $X2=0.837 $Y2=0.09
r21 20 37 2.68168 $w=1.3e-08 $l=1.15e-08 $layer=M1 $thickness=3.6e-08 $X=0.837
+ $Y=0.1 $X2=0.837 $Y2=0.1115
r22 19 35 2.2153 $w=1.3e-08 $l=9.5e-09 $layer=M1 $thickness=3.6e-08 $X=0.81
+ $Y=0.0625 $X2=0.81 $Y2=0.072
r23 19 36 2.09871 $w=1.3e-08 $l=9e-09 $layer=M1 $thickness=3.6e-08 $X=0.81
+ $Y=0.0625 $X2=0.81 $Y2=0.0535
r24 33 34 1.96775 $w=1.63333e-08 $l=1.35e-08 $layer=M1 $thickness=3.6e-08
+ $X=0.8235 $Y=0.09 $X2=0.837 $Y2=0.09
r25 15 31 1.96775 $w=1.63333e-08 $l=1.35e-08 $layer=M1 $thickness=3.6e-08
+ $X=0.81 $Y=0.09 $X2=0.7965 $Y2=0.09
r26 15 33 1.96775 $w=1.63333e-08 $l=1.35e-08 $layer=M1 $thickness=3.6e-08
+ $X=0.81 $Y=0.09 $X2=0.8235 $Y2=0.09
r27 15 35 3.01711 $w=1.55e-08 $l=1.8e-08 $layer=M1 $thickness=3.6e-08 $X=0.81
+ $Y=0.09 $X2=0.81 $Y2=0.072
r28 14 17 3.01711 $w=1.55e-08 $l=1.8e-08 $layer=M1 $thickness=3.6e-08 $X=0.729
+ $Y=0.09 $X2=0.747 $Y2=0.09
r29 30 31 5.24677 $w=1.3e-08 $l=2.25e-08 $layer=M1 $thickness=3.6e-08 $X=0.774
+ $Y=0.09 $X2=0.7965 $Y2=0.09
r30 17 30 6.29612 $w=1.3e-08 $l=2.7e-08 $layer=M1 $thickness=3.6e-08 $X=0.747
+ $Y=0.09 $X2=0.774 $Y2=0.09
r31 17 29 19.3796 $a=3.24e-16 $layer=V0LIG $X=0.747 $Y=0.09 $X2=0.7475 $Y2=0.09
r32 27 29 5.15173 $w=1.56722e-08 $l=9e-09 $layer=LIG $thickness=4.8e-08
+ $X=0.7385 $Y=0.09 $X2=0.7475 $Y2=0.09
r33 1 27 2.6116 $w=2.2e-08 $l=1e-08 $layer=LIG $thickness=4.8e-08 $X=0.7285
+ $Y=0.09 $X2=0.7385 $Y2=0.09
r34 1 23 6.40962 $w=2.09268e-08 $l=5e-10 $layer=Gate_1 $thickness=5.22927e-08
+ $X=0.7285 $Y=0.09 $X2=0.729 $Y2=0.09
r35 25 24 24.1498 $w=2.1e-08 $l=7.1e-08 $layer=Gate_1 $thickness=5.6e-08
+ $X=0.729 $Y=0.2295 $X2=0.729 $Y2=0.1585
r36 23 24 23.4865 $w=2.08394e-08 $l=6.85e-08 $layer=Gate_1 $thickness=5.6e-08
+ $X=0.729 $Y=0.09 $X2=0.729 $Y2=0.1585
r37 23 27 4.05918 $w=2.0087e-08 $l=9.5e-09 $layer=Gate_1 $thickness=5.56522e-08
+ $X=0.729 $Y=0.09 $X2=0.7385 $Y2=0.09
r38 22 23 8.18032 $w=2.05319e-08 $l=2.35e-08 $layer=Gate_1 $thickness=5.6e-08
+ $X=0.729 $Y=0.0665 $X2=0.729 $Y2=0.09
r39 21 22 8.84359 $w=2.1e-08 $l=2.6e-08 $layer=Gate_1 $thickness=5.6e-08
+ $X=0.729 $Y=0.0405 $X2=0.729 $Y2=0.0665
r40 21 10 5.44221 $w=2.1e-08 $l=1.6e-08 $layer=Gate_1 $thickness=5.6e-08
+ $X=0.729 $Y=0.0405 $X2=0.729 $Y2=0.0245
.ends

.subckt PM_SDFHx2_ASAP7_75t_R%12 vss 18 22 38 43 16 15 17 14 13 9 1 3 4 12 11 10
c1 1 vss 0.00188569f $X=0.999 $Y=0.1055
c2 3 vss 0.00589814f $X=1.08 $Y=0.0405
c3 4 vss 0.00635893f $X=1.08 $Y=0.2295
c4 9 vss 0.0412297f $X=0.999 $Y=0.0245
c5 10 vss 0.0186313f $X=1.0655 $Y=0.0405
c6 11 vss 0.0186608f $X=1.0655 $Y=0.2295
c7 12 vss 0.00254466f $X=0.999 $Y=0.036
c8 13 vss 0.0060413f $X=1.107 $Y=0.234
c9 14 vss 0.00251496f $X=1.107 $Y=0.0305
c10 15 vss 0.00100638f $X=0.999 $Y=0.0705
c11 16 vss 0.00726213f $X=1.026 $Y=0.036
c12 17 vss 0.00377633f $X=1.107 $Y=0.081
r1 11 4 0.462963 $w=2.7e-08 $l=1.25e-08 $layer=P_src_drn $thickness=1e-09
+ $X=1.0655 $Y=0.2295 $X2=1.08 $Y2=0.2295
r2 43 11 0.0925926 $w=2.7e-08 $l=2.5e-09 $layer=P_src_drn $thickness=1e-09
+ $X=1.0626 $Y=0.2295 $X2=1.0655 $Y2=0.2295
r3 4 40 19.3796 $a=3.24e-16 $layer=V0LISD $X=1.08 $Y=0.2295 $X2=1.08 $Y2=0.234
r4 40 41 3.14806 $w=1.3e-08 $l=1.35e-08 $layer=M1 $thickness=3.6e-08 $X=1.08
+ $Y=0.234 $X2=1.0935 $Y2=0.234
r5 13 36 7.21452 $w=1.425e-08 $l=3.6e-08 $layer=M1 $thickness=3.6e-08 $X=1.107
+ $Y=0.234 $X2=1.107 $Y2=0.198
r6 13 41 1.96775 $w=1.63333e-08 $l=1.35e-08 $layer=M1 $thickness=3.6e-08
+ $X=1.107 $Y=0.234 $X2=1.0935 $Y2=0.234
r7 10 3 0.462963 $w=2.7e-08 $l=1.25e-08 $layer=N_src_drn $thickness=1e-09
+ $X=1.0655 $Y=0.0405 $X2=1.08 $Y2=0.0405
r8 38 10 0.0925926 $w=2.7e-08 $l=2.5e-09 $layer=N_src_drn $thickness=1e-09
+ $X=1.0626 $Y=0.0405 $X2=1.0655 $Y2=0.0405
r9 35 36 12.5922 $w=1.3e-08 $l=5.4e-08 $layer=M1 $thickness=3.6e-08 $X=1.107
+ $Y=0.144 $X2=1.107 $Y2=0.198
r10 17 34 8.95608 $w=1.36627e-08 $l=4.15e-08 $layer=M1 $thickness=3.6e-08
+ $X=1.107 $Y=0.081 $X2=1.107 $Y2=0.0395
r11 17 35 14.691 $w=1.3e-08 $l=6.3e-08 $layer=M1 $thickness=3.6e-08 $X=1.107
+ $Y=0.081 $X2=1.107 $Y2=0.144
r12 3 32 19.3796 $a=3.24e-16 $layer=V0LISD $X=1.08 $Y=0.0405 $X2=1.08 $Y2=0.036
r13 14 33 1.40651 $w=1.51875e-08 $l=1.45774e-08 $layer=M1 $thickness=3.6e-08
+ $X=1.107 $Y=0.0305 $X2=1.0935 $Y2=0.036
r14 14 34 0.9184 $w=1.8e-08 $l=9e-09 $layer=M1 $thickness=3.6e-08 $X=1.107
+ $Y=0.0305 $X2=1.107 $Y2=0.0395
r15 32 33 3.14806 $w=1.3e-08 $l=1.35e-08 $layer=M1 $thickness=3.6e-08 $X=1.08
+ $Y=0.036 $X2=1.0935 $Y2=0.036
r16 31 32 2.68168 $w=1.3e-08 $l=1.15e-08 $layer=M1 $thickness=3.6e-08 $X=1.0685
+ $Y=0.036 $X2=1.08 $Y2=0.036
r17 30 31 1.04935 $w=1.3e-08 $l=4.5e-09 $layer=M1 $thickness=3.6e-08 $X=1.064
+ $Y=0.036 $X2=1.0685 $Y2=0.036
r18 29 30 2.56509 $w=1.3e-08 $l=1.1e-08 $layer=M1 $thickness=3.6e-08 $X=1.053
+ $Y=0.036 $X2=1.064 $Y2=0.036
r19 16 29 6.29612 $w=1.3e-08 $l=2.7e-08 $layer=M1 $thickness=3.6e-08 $X=1.026
+ $Y=0.036 $X2=1.053 $Y2=0.036
r20 12 15 6.39593 $w=1.55565e-08 $l=3.45e-08 $layer=M1 $thickness=3.6e-08
+ $X=0.999 $Y=0.036 $X2=0.999 $Y2=0.0705
r21 12 16 4.64701 $w=1.46667e-08 $l=2.7e-08 $layer=M1 $thickness=3.6e-08
+ $X=0.999 $Y=0.036 $X2=1.026 $Y2=0.036
r22 15 26 8.04505 $w=1.3e-08 $l=3.45e-08 $layer=M1 $thickness=3.6e-08 $X=0.999
+ $Y=0.0705 $X2=0.999 $Y2=0.105
r23 1 20 6.4735 $w=2.13953e-08 $layer=Gate_1 $thickness=5.22791e-08 $X=0.999
+ $Y=0.1055 $X2=0.999 $Y2=0.1055
r24 1 26 19.3796 $a=3.24e-16 $layer=V0LIG $X=0.999 $Y=0.1055 $X2=0.999 $Y2=0.105
r25 22 21 21.4287 $w=2.1e-08 $l=6.3e-08 $layer=Gate_1 $thickness=5.6e-08
+ $X=0.999 $Y=0.2295 $X2=0.999 $Y2=0.1665
r26 20 21 20.944 $w=2.08115e-08 $l=6.1e-08 $layer=Gate_1 $thickness=5.6e-08
+ $X=0.999 $Y=0.1055 $X2=0.999 $Y2=0.1665
r27 19 20 10.9099 $w=2.06349e-08 $l=3.15e-08 $layer=Gate_1 $thickness=5.6e-08
+ $X=0.999 $Y=0.074 $X2=0.999 $Y2=0.1055
r28 18 19 11.3946 $w=2.1e-08 $l=3.35e-08 $layer=Gate_1 $thickness=5.6e-08
+ $X=0.999 $Y=0.0405 $X2=0.999 $Y2=0.074
r29 18 9 5.44221 $w=2.1e-08 $l=1.6e-08 $layer=Gate_1 $thickness=5.6e-08
+ $X=0.999 $Y=0.0405 $X2=0.999 $Y2=0.0245
.ends

.subckt PM_SDFHx2_ASAP7_75t_R%QN vss 22 16 17 28 29 11 7 13 1 2 8
c1 1 vss 0.00917804f $X=1.296 $Y=0.0675
c2 2 vss 0.00925427f $X=1.296 $Y=0.2025
c3 7 vss 0.00555105f $X=1.2815 $Y=0.0675
c4 8 vss 0.00554104f $X=1.2815 $Y=0.2025
c5 9 vss 0.00319834f $X=1.377 $Y=0.036
c6 10 vss 0.00321735f $X=1.377 $Y=0.234
c7 11 vss 0.00868081f $X=1.2845 $Y=0.036
c8 12 vss 0.00918363f $X=1.2845 $Y=0.234
c9 13 vss 0.0108266f $X=1.377 $Y=0.0675
r1 29 27 0.0308642 $w=8.1e-08 $l=2.5e-09 $layer=P_src_drn $thickness=1e-09
+ $X=1.3133 $Y=0.2025 $X2=1.3105 $Y2=0.2025
r2 2 27 0.179012 $w=8.1e-08 $l=1.45e-08 $layer=P_src_drn $thickness=1e-09
+ $X=1.296 $Y=0.2025 $X2=1.3105 $Y2=0.2025
r3 8 2 0.179012 $w=8.1e-08 $l=1.45e-08 $layer=P_src_drn $thickness=1e-09
+ $X=1.2815 $Y=0.2025 $X2=1.296 $Y2=0.2025
r4 28 8 0.0308642 $w=8.1e-08 $l=2.5e-09 $layer=P_src_drn $thickness=1e-09
+ $X=1.2786 $Y=0.2025 $X2=1.2815 $Y2=0.2025
r5 2 24 19.3796 $a=3.24e-16 $layer=V0LISD $X=1.296 $Y=0.2025 $X2=1.296 $Y2=0.234
r6 24 25 9.44419 $w=1.3e-08 $l=4.05e-08 $layer=M1 $thickness=3.6e-08 $X=1.296
+ $Y=0.234 $X2=1.3365 $Y2=0.234
r7 12 24 2.68168 $w=1.3e-08 $l=1.15e-08 $layer=M1 $thickness=3.6e-08 $X=1.2845
+ $Y=0.234 $X2=1.296 $Y2=0.234
r8 10 23 0.624487 $w=2.20462e-08 $l=9.8e-09 $layer=M1 $thickness=3.6e-08
+ $X=1.377 $Y=0.234 $X2=1.377 $Y2=0.2242
r9 10 25 7.79507 $w=1.41111e-08 $l=4.05e-08 $layer=M1 $thickness=3.6e-08
+ $X=1.377 $Y=0.234 $X2=1.3365 $Y2=0.234
r10 22 23 0.291487 $w=1.3e-08 $l=1.2e-09 $layer=M1 $thickness=3.6e-08 $X=1.379
+ $Y=0.223 $X2=1.377 $Y2=0.2242
r11 22 21 2.73998 $w=1.3e-08 $l=1.18e-08 $layer=M1 $thickness=3.6e-08 $X=1.379
+ $Y=0.223 $X2=1.377 $Y2=0.2112
r12 20 21 15.4488 $w=1.3e-08 $l=6.62e-08 $layer=M1 $thickness=3.6e-08 $X=1.377
+ $Y=0.145 $X2=1.377 $Y2=0.2112
r13 13 20 18.0722 $w=1.3e-08 $l=7.75e-08 $layer=M1 $thickness=3.6e-08 $X=1.377
+ $Y=0.0675 $X2=1.377 $Y2=0.145
r14 9 19 7.79507 $w=1.41111e-08 $l=4.05e-08 $layer=M1 $thickness=3.6e-08
+ $X=1.377 $Y=0.036 $X2=1.3365 $Y2=0.036
r15 9 13 5.69636 $w=1.58e-08 $l=3.15e-08 $layer=M1 $thickness=3.6e-08 $X=1.377
+ $Y=0.036 $X2=1.377 $Y2=0.0675
r16 18 19 9.44419 $w=1.3e-08 $l=4.05e-08 $layer=M1 $thickness=3.6e-08 $X=1.296
+ $Y=0.036 $X2=1.3365 $Y2=0.036
r17 11 18 2.68168 $w=1.3e-08 $l=1.15e-08 $layer=M1 $thickness=3.6e-08 $X=1.2845
+ $Y=0.036 $X2=1.296 $Y2=0.036
r18 1 18 19.3796 $a=3.24e-16 $layer=V0LISD $X=1.296 $Y=0.0675 $X2=1.296
+ $Y2=0.036
r19 17 15 0.0308642 $w=8.1e-08 $l=2.5e-09 $layer=N_src_drn $thickness=1e-09
+ $X=1.3133 $Y=0.0675 $X2=1.3105 $Y2=0.0675
r20 1 15 0.179012 $w=8.1e-08 $l=1.45e-08 $layer=N_src_drn $thickness=1e-09
+ $X=1.296 $Y=0.0675 $X2=1.3105 $Y2=0.0675
r21 7 1 0.179012 $w=8.1e-08 $l=1.45e-08 $layer=N_src_drn $thickness=1e-09
+ $X=1.2815 $Y=0.0675 $X2=1.296 $Y2=0.0675
r22 16 7 0.0308642 $w=8.1e-08 $l=2.5e-09 $layer=N_src_drn $thickness=1e-09
+ $X=1.2786 $Y=0.0675 $X2=1.2815 $Y2=0.0675
.ends

.subckt PM_SDFHx2_ASAP7_75t_R%20 vss 7 12 4 1 5
c1 1 vss 0.00627677f $X=0.918 $Y=0.0405
c2 4 vss 0.00176377f $X=0.9035 $Y=0.0405
c3 5 vss 0.00217885f $X=0.974 $Y=0.0405
r1 12 11 0.0925926 $w=2.7e-08 $l=2.5e-09 $layer=N_src_drn $thickness=1e-09
+ $X=0.9893 $Y=0.0405 $X2=0.9865 $Y2=0.0405
r2 5 11 0.462963 $w=2.7e-08 $l=1.25e-08 $layer=N_src_drn $thickness=1e-09
+ $X=0.974 $Y=0.0405 $X2=0.9865 $Y2=0.0405
r3 9 5 6.3496 $w=2.32e-08 $l=1.35e-08 $layer=LISD $thickness=2.7e-08 $X=0.9585
+ $Y=0.0405 $X2=0.974 $Y2=0.0405
r4 8 9 7.05511 $w=2.32e-08 $l=1.5e-08 $layer=LISD $thickness=2.7e-08 $X=0.9435
+ $Y=0.0405 $X2=0.9585 $Y2=0.0405
r5 1 8 11.9937 $w=2.32e-08 $l=2.55e-08 $layer=LISD $thickness=2.7e-08 $X=0.918
+ $Y=0.0405 $X2=0.9435 $Y2=0.0405
r6 4 1 0.462963 $w=2.7e-08 $l=1.25e-08 $layer=N_src_drn $thickness=1e-09
+ $X=0.9035 $Y=0.0405 $X2=0.918 $Y2=0.0405
r7 7 4 0.0925926 $w=2.7e-08 $l=2.5e-09 $layer=N_src_drn $thickness=1e-09
+ $X=0.9006 $Y=0.0405 $X2=0.9035 $Y2=0.0405
.ends

.subckt PM_SDFHx2_ASAP7_75t_R%13 vss 29 35 76 79 83 87 91 92 95 96 23 14 15 16
+ 18 20 22 5 21 26 25 2 17 12 19 1 24 6 11 13
c1 1 vss 0.0016763f $X=1.053 $Y=0.14
c2 2 vss 0.00728068f $X=1.2595 $Y=0.136
c3 5 vss 0.00471752f $X=0.864 $Y=0.0405
c4 6 vss 0.0045483f $X=0.918 $Y=0.2295
c5 11 vss 0.053181f $X=1.053 $Y=0.0245
c6 12 vss 0.0856679f $X=1.269 $Y=0.136
c7 13 vss 0.0837586f $X=1.323 $Y=0.136
c8 14 vss 0.002967f $X=0.8495 $Y=0.0405
c9 15 vss 0.00319214f $X=0.9035 $Y=0.2295
c10 16 vss 0.00601752f $X=0.945 $Y=0.234
c11 17 vss 0.00231772f $X=0.945 $Y=0.036
c12 18 vss 0.000195056f $X=0.945 $Y=0.1575
c13 19 vss 0.00035966f $X=1.053 $Y=0.162
c14 20 vss 0.00696348f $X=0.92 $Y=0.036
c15 21 vss 0.00055519f $X=0.945 $Y=0.1315
c16 22 vss 0.00123841f $X=0.945 $Y=0.198
c17 23 vss 0.00134115f $X=1.026 $Y=0.162
c18 24 vss 0.000249475f $X=1.053 $Y=0.125
c19 25 vss 0.00355235f $X=1.269 $Y=0.1085
c20 26 vss 0.00850838f $X=0.945 $Y=0.153
r1 96 94 0.0925926 $w=2.7e-08 $l=2.5e-09 $layer=N_src_drn $thickness=1e-09
+ $X=0.8813 $Y=0.0405 $X2=0.8785 $Y2=0.0405
r2 5 94 0.537037 $w=2.7e-08 $l=1.45e-08 $layer=N_src_drn $thickness=1e-09
+ $X=0.864 $Y=0.0405 $X2=0.8785 $Y2=0.0405
r3 14 5 0.537037 $w=2.7e-08 $l=1.45e-08 $layer=N_src_drn $thickness=1e-09
+ $X=0.8495 $Y=0.0405 $X2=0.864 $Y2=0.0405
r4 95 14 0.0925926 $w=2.7e-08 $l=2.5e-09 $layer=N_src_drn $thickness=1e-09
+ $X=0.8466 $Y=0.0405 $X2=0.8495 $Y2=0.0405
r5 92 90 0.0925926 $w=2.7e-08 $l=2.5e-09 $layer=P_src_drn $thickness=1e-09
+ $X=0.9353 $Y=0.2295 $X2=0.9325 $Y2=0.2295
r6 6 90 0.537037 $w=2.7e-08 $l=1.45e-08 $layer=P_src_drn $thickness=1e-09
+ $X=0.918 $Y=0.2295 $X2=0.9325 $Y2=0.2295
r7 15 6 0.537037 $w=2.7e-08 $l=1.45e-08 $layer=P_src_drn $thickness=1e-09
+ $X=0.9035 $Y=0.2295 $X2=0.918 $Y2=0.2295
r8 91 15 0.0925926 $w=2.7e-08 $l=2.5e-09 $layer=P_src_drn $thickness=1e-09
+ $X=0.9006 $Y=0.2295 $X2=0.9035 $Y2=0.2295
r9 87 86 14.6259 $w=2.1e-08 $l=4.3e-08 $layer=Gate_1 $thickness=5.6e-08
+ $X=1.323 $Y=0.2025 $X2=1.323 $Y2=0.1595
r10 85 86 2.55104 $w=2.1e-08 $l=7.5e-09 $layer=Gate_1 $thickness=5.6e-08
+ $X=1.323 $Y=0.152 $X2=1.323 $Y2=0.1595
r11 83 84 14.6259 $w=2.1e-08 $l=4.3e-08 $layer=Gate_1 $thickness=5.6e-08
+ $X=1.323 $Y=0.0675 $X2=1.323 $Y2=0.1105
r12 81 84 2.89117 $w=2.1e-08 $l=8.5e-09 $layer=Gate_1 $thickness=5.6e-08
+ $X=1.323 $Y=0.119 $X2=1.323 $Y2=0.1105
r13 13 70 6.54019 $w=2.09524e-08 $layer=Gate_1 $thickness=5.21905e-08 $X=1.323
+ $Y=0.136 $X2=1.323 $Y2=0.136
r14 13 81 5.96942 $w=2.03529e-08 $l=1.7e-08 $layer=Gate_1 $thickness=5.6e-08
+ $X=1.323 $Y=0.136 $X2=1.323 $Y2=0.119
r15 13 85 5.62929 $w=2.03125e-08 $l=1.6e-08 $layer=Gate_1 $thickness=5.6e-08
+ $X=1.323 $Y=0.136 $X2=1.323 $Y2=0.152
r16 79 78 16.3266 $w=2.1e-08 $l=4.8e-08 $layer=Gate_1 $thickness=5.6e-08
+ $X=1.269 $Y=0.2025 $X2=1.269 $Y2=0.1545
r17 76 77 16.6668 $w=2.1e-08 $l=4.9e-08 $layer=Gate_1 $thickness=5.6e-08
+ $X=1.269 $Y=0.0675 $X2=1.269 $Y2=0.1165
r18 12 66 6.27904 $w=2.09e-08 $layer=Gate_1 $thickness=5.24e-08 $X=1.269
+ $Y=0.136 $X2=1.269 $Y2=0.136
r19 12 77 6.81977 $w=2.04359e-08 $l=1.95e-08 $layer=Gate_1 $thickness=5.6e-08
+ $X=1.269 $Y=0.136 $X2=1.269 $Y2=0.1165
r20 12 78 6.47963 $w=2.04054e-08 $l=1.85e-08 $layer=Gate_1 $thickness=5.6e-08
+ $X=1.269 $Y=0.136 $X2=1.269 $Y2=0.1545
r21 5 64 19.3796 $a=3.24e-16 $layer=V0LISD $X=0.864 $Y=0.0405 $X2=0.864
+ $Y2=0.036
r22 6 59 19.3796 $a=3.24e-16 $layer=V0LISD $X=0.918 $Y=0.2295 $X2=0.918
+ $Y2=0.234
r23 69 70 12.6539 $w=1.77815e-08 $l=2.7e-08 $layer=LIG $thickness=4.8e-08
+ $X=1.296 $Y=0.136 $X2=1.323 $Y2=0.136
r24 67 69 10.1729 $w=1.54914e-08 $l=1.75e-08 $layer=LIG $thickness=4.8e-08
+ $X=1.2785 $Y=0.136 $X2=1.296 $Y2=0.136
r25 66 67 2.48102 $w=2.2e-08 $l=9.5e-09 $layer=LIG $thickness=4.8e-08 $X=1.269
+ $Y=0.136 $X2=1.2785 $Y2=0.136
r26 2 66 2.48102 $w=2.2e-08 $l=9.5e-09 $layer=LIG $thickness=4.8e-08 $X=1.2595
+ $Y=0.136 $X2=1.269 $Y2=0.136
r27 64 65 3.14806 $w=1.3e-08 $l=1.35e-08 $layer=M1 $thickness=3.6e-08 $X=0.864
+ $Y=0.036 $X2=0.8775 $Y2=0.036
r28 62 65 3.14806 $w=1.3e-08 $l=1.35e-08 $layer=M1 $thickness=3.6e-08 $X=0.891
+ $Y=0.036 $X2=0.8775 $Y2=0.036
r29 61 62 2.56509 $w=1.3e-08 $l=1.1e-08 $layer=M1 $thickness=3.6e-08 $X=0.902
+ $Y=0.036 $X2=0.891 $Y2=0.036
r30 20 61 4.19742 $w=1.3e-08 $l=1.8e-08 $layer=M1 $thickness=3.6e-08 $X=0.92
+ $Y=0.036 $X2=0.902 $Y2=0.036
r31 59 60 3.14806 $w=1.3e-08 $l=1.35e-08 $layer=M1 $thickness=3.6e-08 $X=0.918
+ $Y=0.234 $X2=0.9315 $Y2=0.234
r32 16 22 7.21452 $w=1.425e-08 $l=3.6e-08 $layer=M1 $thickness=3.6e-08 $X=0.945
+ $Y=0.234 $X2=0.945 $Y2=0.198
r33 16 60 1.96775 $w=1.63333e-08 $l=1.35e-08 $layer=M1 $thickness=3.6e-08
+ $X=0.945 $Y=0.234 $X2=0.9315 $Y2=0.234
r34 56 66 19.3796 $a=3.24e-16 $layer=V0LIG $X=1.269 $Y=0.1445 $X2=1.269
+ $Y2=0.136
r35 25 56 8.39483 $w=1.3e-08 $l=3.6e-08 $layer=M1 $thickness=3.6e-08 $X=1.269
+ $Y=0.1085 $X2=1.269 $Y2=0.1445
r36 17 50 4.64701 $w=1.62667e-08 $l=2.7e-08 $layer=M1 $thickness=3.6e-08
+ $X=0.945 $Y=0.036 $X2=0.945 $Y2=0.063
r37 17 20 4.18063 $w=1.48e-08 $l=2.5e-08 $layer=M1 $thickness=3.6e-08 $X=0.945
+ $Y=0.036 $X2=0.92 $Y2=0.036
r38 22 45 6.50021 $w=1.33448e-08 $l=2.9e-08 $layer=M1 $thickness=3.6e-08
+ $X=0.945 $Y=0.198 $X2=0.945 $Y2=0.169
r39 54 56 19.5347 $a=3.24e-16 $layer=V1 $X=1.269 $Y=0.153 $X2=1.269 $Y2=0.1445
r40 53 54 5.71315 $w=1.3e-08 $l=2.45e-08 $layer=M2 $thickness=3.6e-08 $X=1.2445
+ $Y=0.153 $X2=1.269 $Y2=0.153
r41 52 53 9.91056 $w=1.3e-08 $l=4.25e-08 $layer=M2 $thickness=3.6e-08 $X=1.202
+ $Y=0.153 $X2=1.2445 $Y2=0.153
r42 51 52 32.0636 $w=1.3e-08 $l=1.375e-07 $layer=M2 $thickness=3.6e-08
+ $X=1.0645 $Y=0.153 $X2=1.202 $Y2=0.153
r43 26 51 27.8662 $w=1.3e-08 $l=1.195e-07 $layer=M2 $thickness=3.6e-08 $X=0.945
+ $Y=0.153 $X2=1.0645 $Y2=0.153
r44 26 46 39.0693 $a=1.62e-16 $layer=V1 $X=0.945 $Y=0.153 $X2=0.945 $Y2=0.1485
r45 49 50 6.29612 $w=1.3e-08 $l=2.7e-08 $layer=M1 $thickness=3.6e-08 $X=0.945
+ $Y=0.09 $X2=0.945 $Y2=0.063
r46 48 49 2.3319 $w=1.3e-08 $l=1e-08 $layer=M1 $thickness=3.6e-08 $X=0.945
+ $Y=0.1 $X2=0.945 $Y2=0.09
r47 47 48 2.3319 $w=1.3e-08 $l=1e-08 $layer=M1 $thickness=3.6e-08 $X=0.945
+ $Y=0.11 $X2=0.945 $Y2=0.1
r48 21 46 3.96423 $w=1.3e-08 $l=1.7e-08 $layer=M1 $thickness=3.6e-08 $X=0.945
+ $Y=0.1315 $X2=0.945 $Y2=0.1485
r49 21 47 5.01358 $w=1.3e-08 $l=2.15e-08 $layer=M1 $thickness=3.6e-08 $X=0.945
+ $Y=0.1315 $X2=0.945 $Y2=0.11
r50 44 45 0.4592 $w=1.8e-08 $l=4.5e-09 $layer=M1 $thickness=3.6e-08 $X=0.945
+ $Y=0.1645 $X2=0.945 $Y2=0.169
r51 18 44 0.714311 $w=1.8e-08 $l=7e-09 $layer=M1 $thickness=3.6e-08 $X=0.945
+ $Y=0.1575 $X2=0.945 $Y2=0.1645
r52 18 46 1.50855 $w=1.55e-08 $l=9e-09 $layer=M1 $thickness=3.6e-08 $X=0.945
+ $Y=0.1575 $X2=0.945 $Y2=0.1485
r53 18 26 39.0693 $a=1.62e-16 $layer=V1 $X=0.945 $Y=0.1575 $X2=0.945 $Y2=0.153
r54 43 45 4.4015 $w=1.35e-08 $l=2.78927e-08 $layer=M1 $thickness=3.6e-08
+ $X=0.972 $Y=0.162 $X2=0.945 $Y2=0.169
r55 42 43 6.29612 $w=1.3e-08 $l=2.7e-08 $layer=M1 $thickness=3.6e-08 $X=0.999
+ $Y=0.162 $X2=0.972 $Y2=0.162
r56 23 42 6.29612 $w=1.3e-08 $l=2.7e-08 $layer=M1 $thickness=3.6e-08 $X=1.026
+ $Y=0.162 $X2=0.999 $Y2=0.162
r57 19 40 0.915974 $w=2.10182e-08 $l=1.1e-08 $layer=M1 $thickness=3.6e-08
+ $X=1.053 $Y=0.162 $X2=1.053 $Y2=0.151
r58 19 23 4.64701 $w=1.46667e-08 $l=2.7e-08 $layer=M1 $thickness=3.6e-08
+ $X=1.053 $Y=0.162 $X2=1.026 $Y2=0.162
r59 39 40 2.56509 $w=1.3e-08 $l=1.1e-08 $layer=M1 $thickness=3.6e-08 $X=1.053
+ $Y=0.14 $X2=1.053 $Y2=0.151
r60 24 39 3.49785 $w=1.3e-08 $l=1.5e-08 $layer=M1 $thickness=3.6e-08 $X=1.053
+ $Y=0.125 $X2=1.053 $Y2=0.14
r61 1 32 6.54019 $w=2.09524e-08 $layer=Gate_1 $thickness=5.21905e-08 $X=1.053
+ $Y=0.14 $X2=1.053 $Y2=0.14
r62 1 39 19.3796 $a=3.24e-16 $layer=V0LIG $X=1.053 $Y=0.14 $X2=1.053 $Y2=0.14
r63 35 34 14.6259 $w=2.1e-08 $l=4.3e-08 $layer=Gate_1 $thickness=5.6e-08
+ $X=1.053 $Y=0.2295 $X2=1.053 $Y2=0.1865
r64 33 34 11.0545 $w=2.1e-08 $l=3.25e-08 $layer=Gate_1 $thickness=5.6e-08
+ $X=1.053 $Y=0.154 $X2=1.053 $Y2=0.1865
r65 32 33 4.94901 $w=2.02143e-08 $l=1.4e-08 $layer=Gate_1 $thickness=5.6e-08
+ $X=1.053 $Y=0.14 $X2=1.053 $Y2=0.154
r66 31 32 6.6497 $w=2.04211e-08 $l=1.9e-08 $layer=Gate_1 $thickness=5.6e-08
+ $X=1.053 $Y=0.121 $X2=1.053 $Y2=0.14
r67 30 31 12.7552 $w=2.1e-08 $l=3.75e-08 $layer=Gate_1 $thickness=5.6e-08
+ $X=1.053 $Y=0.0835 $X2=1.053 $Y2=0.121
r68 29 30 14.6259 $w=2.1e-08 $l=4.3e-08 $layer=Gate_1 $thickness=5.6e-08
+ $X=1.053 $Y=0.0405 $X2=1.053 $Y2=0.0835
r69 29 11 5.44221 $w=2.1e-08 $l=1.6e-08 $layer=Gate_1 $thickness=5.6e-08
+ $X=1.053 $Y=0.0405 $X2=1.053 $Y2=0.0245
.ends

.subckt PM_SDFHx2_ASAP7_75t_R%D vss 5 6 10 3 4 1
c1 1 vss 0.00715467f $X=0.405 $Y=0.135
c2 3 vss 0.10263f $X=0.405 $Y=0.0245
c3 4 vss 0.00570686f $X=0.405 $Y=0.108
c4 5 vss 0.0035686f $X=0.405 $Y=0.134
r1 4 12 1.96775 $w=1.63333e-08 $l=1.35e-08 $layer=M1 $thickness=3.6e-08
+ $X=0.405 $Y=0.108 $X2=0.405 $Y2=0.1215
r2 5 12 3.14806 $w=1.3e-08 $l=1.35e-08 $layer=M1 $thickness=3.6e-08 $X=0.405
+ $Y=0.134 $X2=0.405 $Y2=0.1215
r3 1 8 10.4265 $w=1.765e-08 $layer=LIG $thickness=5.2e-08 $X=0.405 $Y=0.135
+ $X2=0.405 $Y2=0.135
r4 5 1 19.3796 $a=3.24e-16 $layer=V0LIG $X=0.405 $Y=0.134 $X2=0.405 $Y2=0.135
r5 10 9 16.4967 $w=2.1e-08 $l=4.85e-08 $layer=Gate_1 $thickness=5.6e-08
+ $X=0.405 $Y=0.2025 $X2=0.405 $Y2=0.154
r6 8 9 6.6497 $w=2.04211e-08 $l=1.9e-08 $layer=Gate_1 $thickness=5.6e-08
+ $X=0.405 $Y=0.135 $X2=0.405 $Y2=0.154
r7 7 8 6.6497 $w=2.04211e-08 $l=1.9e-08 $layer=Gate_1 $thickness=5.6e-08
+ $X=0.405 $Y=0.116 $X2=0.405 $Y2=0.135
r8 6 7 16.4967 $w=2.1e-08 $l=4.85e-08 $layer=Gate_1 $thickness=5.6e-08 $X=0.405
+ $Y=0.0675 $X2=0.405 $Y2=0.116
r9 6 3 14.6259 $w=2.1e-08 $l=4.3e-08 $layer=Gate_1 $thickness=5.6e-08 $X=0.405
+ $Y=0.0675 $X2=0.405 $Y2=0.0245
.ends

.subckt PM_SDFHx2_ASAP7_75t_R%SI vss 18 8 12 7 6 1 3 4
c1 1 vss 0.0100908f $X=0.4575 $Y=0.135
c2 3 vss 0.0847207f $X=0.459 $Y=0.0245
c3 4 vss 0.00252462f $X=0.513 $Y=0.198
c4 5 vss 0.00504041f $X=0.513 $Y=0.135
c5 6 vss 0.0027979f $X=0.4635 $Y=0.135
c6 7 vss 0.0021773f $X=0.513 $Y=0.154
r1 4 23 3.83327 $w=1.5093e-08 $l=2.15e-08 $layer=M1 $thickness=3.6e-08 $X=0.513
+ $Y=0.198 $X2=0.513 $Y2=0.1765
r2 7 23 5.24677 $w=1.3e-08 $l=2.25e-08 $layer=M1 $thickness=3.6e-08 $X=0.513
+ $Y=0.154 $X2=0.513 $Y2=0.1765
r3 5 20 3.1337 $w=1.54324e-08 $l=1.85e-08 $layer=M1 $thickness=3.6e-08 $X=0.513
+ $Y=0.135 $X2=0.4945 $Y2=0.135
r4 5 7 3.2503 $w=1.53684e-08 $l=1.9e-08 $layer=M1 $thickness=3.6e-08 $X=0.513
+ $Y=0.135 $X2=0.513 $Y2=0.154
r5 19 20 2.3319 $w=1.3e-08 $l=1e-08 $layer=M1 $thickness=3.6e-08 $X=0.4845
+ $Y=0.135 $X2=0.4945 $Y2=0.135
r6 18 19 2.2153 $w=1.3e-08 $l=9.5e-09 $layer=M1 $thickness=3.6e-08 $X=0.473
+ $Y=0.135 $X2=0.4845 $Y2=0.135
r7 18 6 2.68168 $w=1.3e-08 $l=1.15e-08 $layer=M1 $thickness=3.6e-08 $X=0.473
+ $Y=0.135 $X2=0.4635 $Y2=0.135
r8 18 16 19.3796 $a=3.24e-16 $layer=V0LIG $X=0.473 $Y=0.135 $X2=0.4765 $Y2=0.135
r9 14 16 4.82216 $w=1.64167e-08 $l=9e-09 $layer=LIG $thickness=4.8e-08
+ $X=0.4675 $Y=0.135 $X2=0.4765 $Y2=0.135
r10 1 14 2.6116 $w=2.2e-08 $l=1e-08 $layer=LIG $thickness=4.8e-08 $X=0.4575
+ $Y=0.135 $X2=0.4675 $Y2=0.135
r11 1 10 6.14846 $w=2.08718e-08 $l=1.5e-09 $layer=Gate_1 $thickness=5.25128e-08
+ $X=0.4575 $Y=0.135 $X2=0.459 $Y2=0.135
r12 12 11 16.4967 $w=2.1e-08 $l=4.85e-08 $layer=Gate_1 $thickness=5.6e-08
+ $X=0.459 $Y=0.2025 $X2=0.459 $Y2=0.154
r13 10 11 6.6497 $w=2.04211e-08 $l=1.9e-08 $layer=Gate_1 $thickness=5.6e-08
+ $X=0.459 $Y=0.135 $X2=0.459 $Y2=0.154
r14 10 14 4.32033 $w=2.024e-08 $l=8.5e-09 $layer=Gate_1 $thickness=5.504e-08
+ $X=0.459 $Y=0.135 $X2=0.4675 $Y2=0.135
r15 9 10 6.6497 $w=2.04211e-08 $l=1.9e-08 $layer=Gate_1 $thickness=5.6e-08
+ $X=0.459 $Y=0.116 $X2=0.459 $Y2=0.135
r16 8 9 16.4967 $w=2.1e-08 $l=4.85e-08 $layer=Gate_1 $thickness=5.6e-08
+ $X=0.459 $Y=0.0675 $X2=0.459 $Y2=0.116
r17 8 3 14.6259 $w=2.1e-08 $l=4.3e-08 $layer=Gate_1 $thickness=5.6e-08 $X=0.459
+ $Y=0.0675 $X2=0.459 $Y2=0.0245
.ends

* End of included file SDFHx2_ASAP7_75t_R.pex.sp.pex

*
.subckt SDFHx2_ASAP7_75t_CUSTOM_4_25_0_7 VSS VDD CLK SE D SI QN
*
* VSS VSS
* VDD VDD
* CLK CLK
* SE SE
* D D
* SI SI
* QN QN
*
*

M0 VSS N_M0_g N_M0_s VSS nmos_rvt L=2e-08 W=5.4e-08 nfin=2 $X=0.071 $Y=0.027
M1 N_M1_d N_M1_g VSS VSS nmos_rvt L=2e-08 W=5.4e-08 nfin=2 $X=0.125 $Y=0.027
M2 VSS N_M2_g noxref_15 VSS nmos_rvt L=2e-08 W=8.1e-08 nfin=3 $X=0.287 $Y=0.027
M3 noxref_21 N_M3_g VSS VSS nmos_rvt L=2e-08 W=8.1e-08 nfin=3 $X=0.341 $Y=0.027
M4 noxref_17 N_M4_g noxref_21 VSS nmos_rvt L=2e-08 W=8.1e-08 nfin=3 $X=0.395
+ $Y=0.027
M5 noxref_15 N_M5_g noxref_17 VSS nmos_rvt L=2e-08 W=8.1e-08 nfin=3 $X=0.449
+ $Y=0.027
M6 N_M6_d N_M6_g noxref_17 VSS nmos_rvt L=2e-08 W=8.1e-08 nfin=3 $X=0.611
+ $Y=0.027
M7 N_M7_d N_M7_g N_M7_s VSS nmos_rvt L=2e-08 W=2.7e-08 nfin=1 $X=0.665 $Y=0.027
M8 VSS N_M8_g N_M8_s VSS nmos_rvt L=2e-08 W=2.7e-08 nfin=1 $X=0.719 $Y=0.027
M9 N_M9_d N_M9_g VSS VSS nmos_rvt L=2e-08 W=2.7e-08 nfin=1 $X=0.773 $Y=0.027
M10 N_M10_d N_M10_g N_M10_s VSS nmos_rvt L=2e-08 W=2.7e-08 nfin=1 $X=0.827
+ $Y=0.027
M11 N_M11_d N_M11_g N_M11_s VSS nmos_rvt L=2e-08 W=2.7e-08 nfin=1 $X=0.881
+ $Y=0.027
M12 VSS N_M12_g N_M12_s VSS nmos_rvt L=2e-08 W=2.7e-08 nfin=1 $X=0.989 $Y=0.027
M13 N_M13_d N_M13_g VSS VSS nmos_rvt L=2e-08 W=2.7e-08 nfin=1 $X=1.043 $Y=0.027
M14 VSS N_M14_g N_M14_s VSS nmos_rvt L=2e-08 W=2.7e-08 nfin=1 $X=1.205 $Y=0.027
M15 N_M15_d N_M15_g VSS VSS nmos_rvt L=2e-08 W=8.1e-08 nfin=3 $X=1.259 $Y=0.027
M16 N_M16_d N_M16_g VSS VSS nmos_rvt L=2e-08 W=8.1e-08 nfin=3 $X=1.313 $Y=0.027
M17 VDD N_M17_g N_M17_s VDD pmos_rvt L=2e-08 W=5.4e-08 nfin=2 $X=0.071 $Y=0.189
M18 N_M18_d N_M18_g VDD VDD pmos_rvt L=2e-08 W=5.4e-08 nfin=2 $X=0.125 $Y=0.189
M19 N_M19_d N_M19_g N_M19_s VDD pmos_rvt L=2e-08 W=8.1e-08 nfin=3 $X=0.287
+ $Y=0.162
M20 VDD N_M20_g N_M20_s VDD pmos_rvt L=2e-08 W=8.1e-08 nfin=3 $X=0.341 $Y=0.162
M21 N_M21_d N_M21_g VDD VDD pmos_rvt L=2e-08 W=8.1e-08 nfin=3 $X=0.395 $Y=0.162
M22 N_M22_d N_M22_g N_M22_s VDD pmos_rvt L=2e-08 W=8.1e-08 nfin=3 $X=0.449
+ $Y=0.162
M23 N_M23_d N_M23_g N_M23_s VDD pmos_rvt L=2e-08 W=8.1e-08 nfin=3 $X=0.557
+ $Y=0.162
M24 N_M24_d N_M24_g N_M24_s VDD pmos_rvt L=2e-08 W=2.7e-08 nfin=1 $X=0.611
+ $Y=0.216
M25 VDD N_M25_g N_M25_s VDD pmos_rvt L=2e-08 W=2.7e-08 nfin=1 $X=0.719 $Y=0.216
M26 N_M26_d N_M26_g VDD VDD pmos_rvt L=2e-08 W=2.7e-08 nfin=1 $X=0.773 $Y=0.216
M27 N_M27_d N_M27_g N_M27_s VDD pmos_rvt L=2e-08 W=2.7e-08 nfin=1 $X=0.881
+ $Y=0.216
M28 N_M28_d N_M28_g N_M28_s VDD pmos_rvt L=2e-08 W=2.7e-08 nfin=1 $X=0.935
+ $Y=0.216
M29 VDD N_M29_g N_M29_s VDD pmos_rvt L=2e-08 W=2.7e-08 nfin=1 $X=0.989 $Y=0.216
M30 N_M30_d N_M30_g VDD VDD pmos_rvt L=2e-08 W=2.7e-08 nfin=1 $X=1.043 $Y=0.216
M31 VDD N_M31_g N_M31_s VDD pmos_rvt L=2e-08 W=2.7e-08 nfin=1 $X=1.205 $Y=0.216
M32 N_M32_d N_M32_g VDD VDD pmos_rvt L=2e-08 W=8.1e-08 nfin=3 $X=1.259 $Y=0.162
M33 N_M33_d N_M33_g VDD VDD pmos_rvt L=2e-08 W=8.1e-08 nfin=3 $X=1.313 $Y=0.162

* .include "SDFHx2_ASAP7_75t_R.pex.sp.pxi"

* Start of included file SDFHx2_ASAP7_75t_R.pex.sp.pxi
x_PM_SDFHx2_ASAP7_75t_R%CLK vss CLK N_M0_g N_M17_g N_CLK_3 N_CLK_1 N_CLK_4
+ N_CLK_5 N_CLK_6 PM_SDFHx2_ASAP7_75t_R%CLK
x_PM_SDFHx2_ASAP7_75t_R%16 vss N_M19_d N_M20_s N_M21_d N_M22_s N_16_7 N_16_1
+ N_16_9 N_16_2 N_16_8 PM_SDFHx2_ASAP7_75t_R%16
cc_1 N_16_7 N_SE_1 0.000960382f $X=0.3095 $Y=0.2025
cc_2 N_16_1 N_SE_5 0.000744903f $X=0.324 $Y=0.2025
cc_3 N_16_9 N_SE_11 0.000766669f $X=0.31 $Y=0.198
cc_4 N_16_7 N_SE_5 0.0324717f $X=0.3095 $Y=0.2025
cc_5 N_16_7 N_6_1 0.001021f $X=0.3095 $Y=0.2025
cc_6 N_16_1 N_6_9 0.000795639f $X=0.324 $Y=0.2025
cc_7 N_16_9 N_6_14 0.00194796f $X=0.31 $Y=0.198
cc_8 N_16_7 N_6_9 0.0325586f $X=0.3095 $Y=0.2025
cc_9 N_16_2 N_D_3 0.000822797f $X=0.432 $Y=0.2025
cc_10 N_16_9 D 0.00201223f $X=0.31 $Y=0.198
cc_11 N_16_8 N_D_3 0.0337133f $X=0.4175 $Y=0.2025
cc_12 N_16_8 N_SI_1 0.00072658f $X=0.4175 $Y=0.2025
cc_13 N_16_9 N_SI_6 0.000742768f $X=0.31 $Y=0.198
cc_14 N_16_2 N_SI_3 0.000785577f $X=0.432 $Y=0.2025
cc_15 N_16_8 N_SI_3 0.0330831f $X=0.4175 $Y=0.2025
cc_16 N_16_9 N_9_26 0.0029382f $X=0.31 $Y=0.198
cc_17 N_16_7 N_14_11 0.00114175f $X=0.3095 $Y=0.2025
cc_18 N_16_8 N_14_11 0.000591185f $X=0.4175 $Y=0.2025
cc_19 N_16_2 N_14_11 0.000641991f $X=0.432 $Y=0.2025
cc_20 N_16_1 N_14_11 0.000661521f $X=0.324 $Y=0.2025
cc_21 N_16_8 N_14_2 0.00105359f $X=0.4175 $Y=0.2025
cc_22 N_16_2 N_14_2 0.00154263f $X=0.432 $Y=0.2025
cc_23 N_16_1 N_14_1 0.00277102f $X=0.324 $Y=0.2025
cc_24 N_16_9 N_14_11 0.0113418f $X=0.31 $Y=0.198
x_PM_SDFHx2_ASAP7_75t_R%14 vss N_M19_s N_M22_d N_M23_s N_14_8 N_14_1 N_14_9
+ N_14_11 N_14_2 N_14_10 PM_SDFHx2_ASAP7_75t_R%14
cc_25 N_14_8 N_SE_1 0.00105321f $X=0.272 $Y=0.2025
cc_26 N_14_8 N_SE_11 0.000884545f $X=0.272 $Y=0.2025
cc_27 N_14_1 N_SE_5 0.0012547f $X=0.27 $Y=0.1755
cc_28 N_14_8 N_SE_5 0.034291f $X=0.272 $Y=0.2025
cc_29 N_14_9 N_SI_7 0.000637451f $X=0.4715 $Y=0.2025
cc_30 N_14_9 N_SI_1 0.00163644f $X=0.4715 $Y=0.2025
cc_31 N_14_11 N_SI_4 0.00286788f $X=0.258 $Y=0.234
cc_32 N_14_2 N_SI_4 0.00317161f $X=0.513 $Y=0.2025
cc_33 N_14_9 N_SI_3 0.0350781f $X=0.4715 $Y=0.2025
cc_34 N_14_10 N_9_7 0.00021788f $X=0.542 $Y=0.2025
cc_35 N_14_10 N_9_21 0.00041479f $X=0.542 $Y=0.2025
cc_36 N_14_10 N_9_1 0.00100009f $X=0.542 $Y=0.2025
cc_37 N_14_10 N_9_24 0.000306329f $X=0.542 $Y=0.2025
cc_38 N_14_10 N_9_22 0.000345873f $X=0.542 $Y=0.2025
cc_39 N_14_1 N_9_23 0.000898444f $X=0.27 $Y=0.1755
cc_40 N_14_2 N_9_14 0.00162838f $X=0.513 $Y=0.2025
cc_41 N_14_11 N_9_26 0.00378336f $X=0.258 $Y=0.234
cc_42 N_14_10 N_9_14 0.0343494f $X=0.542 $Y=0.2025
cc_43 N_14_2 N_11_13 0.000572553f $X=0.513 $Y=0.2025
cc_44 N_14_2 N_11_3 0.00104101f $X=0.513 $Y=0.2025
cc_45 N_14_2 N_11_12 0.00219655f $X=0.513 $Y=0.2025
x_PM_SDFHx2_ASAP7_75t_R%11 vss N_M9_g N_M26_g N_M6_d N_M7_s N_M23_d N_M24_s
+ N_11_11 N_11_3 N_11_13 N_11_15 N_11_17 N_11_19 N_11_4 N_11_21 N_11_20 N_11_10
+ N_11_12 N_11_16 N_11_1 N_11_9 N_11_14 PM_SDFHx2_ASAP7_75t_R%11
cc_46 N_11_11 N_4_27 0.000104299f $X=0.6335 $Y=0.081
cc_47 N_11_11 N_4_3 0.000104555f $X=0.6335 $Y=0.081
cc_48 N_11_11 N_4_21 0.000195464f $X=0.6335 $Y=0.081
cc_49 N_11_3 N_4_21 0.000388523f $X=0.594 $Y=0.2295
cc_50 N_11_13 N_4_14 0.0054022f $X=0.5795 $Y=0.189
cc_51 N_11_15 N_4_21 0.000438126f $X=0.693 $Y=0.131
cc_52 N_11_17 N_4_21 0.000448545f $X=0.6665 $Y=0.234
cc_53 N_11_19 N_4_27 0.000574505f $X=0.693 $Y=0.114
cc_54 N_11_3 N_4_2 0.000754092f $X=0.594 $Y=0.2295
cc_55 N_11_4 N_4_27 0.000890669f $X=0.648 $Y=0.0405
cc_56 N_11_21 N_4_29 0.000894327f $X=0.756 $Y=0.131
cc_57 N_11_4 N_4_14 0.000998888f $X=0.648 $Y=0.0405
cc_58 N_11_3 N_4_14 0.00117915f $X=0.594 $Y=0.2295
cc_59 N_11_20 N_4_29 0.00160792f $X=0.693 $Y=0.1465
cc_60 N_11_10 N_4_2 0.00162116f $X=0.6335 $Y=0.0405
cc_61 N_11_20 N_4_21 0.0020697f $X=0.693 $Y=0.1465
cc_62 N_11_10 N_4_14 0.00938745f $X=0.6335 $Y=0.0405
cc_63 N_11_12 N_4_14 0.010478f $X=0.5795 $Y=0.2295
cc_64 N_11_11 N_4_14 0.0442799f $X=0.6335 $Y=0.081
cc_65 N_11_10 N_9_14 0.000137506f $X=0.6335 $Y=0.0405
cc_66 N_11_10 N_9_25 0.000315342f $X=0.6335 $Y=0.0405
cc_67 N_11_10 N_9_3 0.000168003f $X=0.6335 $Y=0.0405
cc_68 N_11_10 N_9_1 0.000185687f $X=0.6335 $Y=0.0405
cc_69 N_11_13 N_9_14 0.0233918f $X=0.5795 $Y=0.189
cc_70 N_11_3 N_9_24 0.00035585f $X=0.594 $Y=0.2295
cc_71 N_11_3 N_9_22 0.000369659f $X=0.594 $Y=0.2295
cc_72 N_11_11 N_9_15 0.00541867f $X=0.6335 $Y=0.081
cc_73 N_11_16 N_9_25 0.000440134f $X=0.693 $Y=0.234
cc_74 N_11_20 N_9_25 0.00609709f $X=0.693 $Y=0.1465
cc_75 N_11_1 N_9_8 0.00206096f $X=0.783 $Y=0.131
cc_76 N_11_20 N_9_2 0.000629462f $X=0.693 $Y=0.1465
cc_77 N_11_4 N_9_15 0.000645269f $X=0.648 $Y=0.0405
cc_78 N_11_12 N_9_1 0.000651053f $X=0.5795 $Y=0.2295
cc_79 N_11_20 N_9_8 0.000760187f $X=0.693 $Y=0.1465
cc_80 N_11_21 N_9_25 0.00129188f $X=0.756 $Y=0.131
cc_81 N_11_17 N_9_26 0.00135124f $X=0.6665 $Y=0.234
cc_82 N_11_3 N_9_14 0.00156983f $X=0.594 $Y=0.2295
cc_83 N_11_17 N_9_22 0.003606f $X=0.6665 $Y=0.234
cc_84 N_11_9 N_9_8 0.00497133f $X=0.783 $Y=0.0245
cc_85 N_11_12 N_9_14 0.00937924f $X=0.5795 $Y=0.2295
cc_86 N_11_9 N_9_16 0.0117578f $X=0.783 $Y=0.0245
cc_87 N_11_10 N_9_15 0.0308817f $X=0.6335 $Y=0.0405
cc_88 N_11_9 N_10_12 0.0064752f $X=0.783 $Y=0.0245
cc_89 N_11_21 N_10_18 0.000237333f $X=0.756 $Y=0.131
cc_90 N_11_14 N_10_14 0.000285051f $X=0.693 $Y=0.036
cc_91 N_11_4 N_10_1 0.000321694f $X=0.648 $Y=0.0405
cc_92 N_11_21 N_10_15 0.000395922f $X=0.756 $Y=0.131
cc_93 N_11_20 N_10_14 0.000396565f $X=0.693 $Y=0.1465
cc_94 N_11_21 N_10_1 0.000616865f $X=0.756 $Y=0.131
cc_95 N_11_21 N_10_20 0.000868211f $X=0.756 $Y=0.131
cc_96 N_11_9 N_10_3 0.000988316f $X=0.783 $Y=0.0245
cc_97 N_11_1 N_10_17 0.00110496f $X=0.783 $Y=0.131
cc_98 N_11_1 N_10_1 0.00121869f $X=0.783 $Y=0.131
cc_99 N_11_9 N_10_1 0.00208896f $X=0.783 $Y=0.0245
cc_100 N_11_9 N_10_11 0.00616087f $X=0.783 $Y=0.0245
cc_101 N_11_19 N_10_14 0.00441106f $X=0.693 $Y=0.114
cc_102 N_11_21 N_10_17 0.0045427f $X=0.756 $Y=0.131
cc_103 N_11_9 N_10_10 0.0288445f $X=0.783 $Y=0.0245
x_PM_SDFHx2_ASAP7_75t_R%19 vss N_M24_d N_M25_s N_19_4 N_19_5 N_19_1
+ PM_SDFHx2_ASAP7_75t_R%19
cc_104 N_19_4 N_4_14 0.0141832f $X=0.6335 $Y=0.2295
cc_105 N_19_5 N_9_8 0.00152125f $X=0.704 $Y=0.2295
cc_106 N_19_1 N_9_2 0.000733218f $X=0.648 $Y=0.2295
cc_107 N_19_1 N_9_15 0.00177016f $X=0.648 $Y=0.2295
cc_108 N_19_4 N_9_15 0.00648872f $X=0.6335 $Y=0.2295
cc_109 N_19_5 N_9_15 0.0230893f $X=0.704 $Y=0.2295
cc_110 N_19_5 N_10_10 0.0175878f $X=0.704 $Y=0.2295
cc_111 N_19_4 N_11_3 0.000498166f $X=0.6335 $Y=0.2295
cc_112 N_19_1 N_11_17 0.0036028f $X=0.648 $Y=0.2295
x_PM_SDFHx2_ASAP7_75t_R%22 vss N_M7_d N_M8_s N_22_1 PM_SDFHx2_ASAP7_75t_R%22
cc_113 N_22_1 N_9_15 0.00753042f $X=0.702 $Y=0.0405
cc_114 N_22_1 N_10_10 0.00760973f $X=0.702 $Y=0.0405
x_PM_SDFHx2_ASAP7_75t_R%23 vss N_M28_d N_M29_s N_23_1 PM_SDFHx2_ASAP7_75t_R%23
cc_115 N_23_1 N_9_17 0.00757584f $X=0.972 $Y=0.2295
cc_116 N_23_1 N_12_9 0.0076342f $X=0.972 $Y=0.2295
x_PM_SDFHx2_ASAP7_75t_R%4 vss N_M11_g N_M27_g N_M6_g N_M24_g N_M1_g N_M18_g
+ N_M0_s N_M17_s N_4_8 N_4_26 N_4_7 N_4_19 N_4_16 N_4_17 N_4_25 N_4_23 N_4_1
+ N_4_22 N_4_24 N_4_29 N_4_13 N_4_28 N_4_27 N_4_15 N_4_3 N_4_21 N_4_14 N_4_2
+ PM_SDFHx2_ASAP7_75t_R%4
cc_117 N_4_8 N_CLK_3 0.000899386f $X=0.054 $Y=0.216
cc_118 N_4_26 N_CLK_3 0.000252818f $X=0.135 $Y=0.1235
cc_119 N_4_7 N_CLK_3 0.00105746f $X=0.054 $Y=0.054
cc_120 N_4_19 N_CLK_3 0.000288587f $X=0.0165 $Y=0.153
cc_121 N_4_16 N_CLK_3 0.0110328f $X=0.056 $Y=0.054
cc_122 N_4_17 N_CLK_3 0.0110251f $X=0.056 $Y=0.216
cc_123 N_4_25 N_CLK_3 0.000466629f $X=0.036 $Y=0.234
cc_124 N_4_23 N_CLK_3 0.000478268f $X=0.018 $Y=0.181
cc_125 N_4_1 N_CLK_3 0.000596267f $X=0.135 $Y=0.135
cc_126 N_4_19 N_CLK_1 0.000947665f $X=0.0165 $Y=0.153
cc_127 N_4_22 N_CLK_4 0.00100739f $X=0.018 $Y=0.1215
cc_128 N_4_24 N_CLK_4 0.00102439f $X=0.036 $Y=0.036
cc_129 N_4_26 N_CLK_4 0.00106837f $X=0.135 $Y=0.1235
cc_130 N_4_29 N_CLK_4 0.00129589f $X=0.8125 $Y=0.153
cc_131 N_4_26 N_CLK_5 0.00130327f $X=0.135 $Y=0.1235
cc_132 N_4_24 N_CLK_6 0.00171969f $X=0.036 $Y=0.036
cc_133 N_4_1 N_CLK_1 0.00328833f $X=0.135 $Y=0.135
cc_134 N_4_19 N_CLK_5 0.00602383f $X=0.0165 $Y=0.153
cc_135 N_4_13 N_CLK_3 0.0354266f $X=0.135 $Y=0.135
x_PM_SDFHx2_ASAP7_75t_R%SE vss SE N_M14_g N_M31_g N_M2_g N_M19_g N_SE_11 N_SE_7
+ N_SE_8 N_SE_10 N_SE_13 N_SE_6 N_SE_9 N_SE_12 N_SE_1 N_SE_2 N_SE_5
+ PM_SDFHx2_ASAP7_75t_R%SE
cc_136 N_SE_11 N_4_24 0.000103174f $X=0.2445 $Y=0.135
cc_137 N_SE_7 N_4_29 0.00010693f $X=0.225 $Y=0.036
cc_138 N_SE_8 N_4_26 0.000108225f $X=0.225 $Y=0.1297
cc_139 N_SE_7 N_4_22 0.000149165f $X=0.225 $Y=0.036
cc_140 N_SE_8 N_4_29 0.000401027f $X=0.225 $Y=0.1297
cc_141 N_SE_10 N_4_29 0.000410824f $X=0.225 $Y=0.0495
cc_142 N_SE_13 N_4_28 0.000529995f $X=1.1905 $Y=0.045
cc_143 N_SE_13 N_4_29 0.0024447f $X=1.1905 $Y=0.045
cc_144 N_SE_11 N_4_29 0.00359352f $X=0.2445 $Y=0.135
x_PM_SDFHx2_ASAP7_75t_R%6 vss N_M3_g N_M20_g N_M14_s N_M31_s N_6_16 N_6_14
+ N_6_10 N_6_15 N_6_4 N_6_3 N_6_1 N_6_13 N_6_12 N_6_9 N_6_11
+ PM_SDFHx2_ASAP7_75t_R%6
cc_145 N_6_16 N_4_28 0.00282923f $X=0.3395 $Y=0.081
cc_146 N_6_16 N_4_27 0.000314641f $X=0.3395 $Y=0.081
cc_147 N_6_14 N_4_29 0.00298976f $X=0.351 $Y=0.135
cc_148 N_6_16 N_4_29 0.0107202f $X=0.3395 $Y=0.081
cc_149 N_6_16 N_SE_6 0.000220076f $X=0.3395 $Y=0.081
cc_150 N_6_10 N_SE_6 0.00663715f $X=1.19 $Y=0.0405
cc_151 N_6_15 N_SE_9 0.000594732f $X=1.161 $Y=0.037
cc_152 N_6_4 N_SE_12 0.000237698f $X=1.188 $Y=0.2295
cc_153 N_6_3 N_SE_12 0.000260677f $X=1.1485 $Y=0.0455
cc_154 N_6_1 N_SE_11 0.00030133f $X=0.351 $Y=0.135
cc_155 N_6_1 N_SE_1 0.00128679f $X=0.351 $Y=0.135
cc_156 N_6_4 N_SE_6 0.000390022f $X=1.188 $Y=0.2295
cc_157 N_6_3 N_SE_2 0.000453208f $X=1.1485 $Y=0.0455
cc_158 N_6_15 N_SE_2 0.000490655f $X=1.161 $Y=0.037
cc_159 N_6_13 N_SE_12 0.000493504f $X=1.161 $Y=0.234
cc_160 N_6_12 N_SE_13 0.000505653f $X=0.351 $Y=0.072
cc_161 N_6_15 N_SE_13 0.000641588f $X=1.161 $Y=0.037
cc_162 N_6_3 N_SE_6 0.00108736f $X=1.1485 $Y=0.0455
cc_163 N_6_14 N_SE_11 0.00154663f $X=0.351 $Y=0.135
cc_164 N_6_9 N_SE_5 0.00323521f $X=0.351 $Y=0.0245
cc_165 N_6_11 N_SE_6 0.0236932f $X=1.19 $Y=0.2295
cc_166 N_6_15 N_SE_12 0.00714093f $X=1.161 $Y=0.037
cc_167 N_6_16 N_SE_13 0.0577366f $X=0.3395 $Y=0.081
x_PM_SDFHx2_ASAP7_75t_R%9 vss N_M10_g N_M7_g N_M28_g N_M23_g N_M1_d N_M18_d
+ N_9_7 N_9_21 N_9_6 N_9_23 N_9_20 N_9_18 N_9_19 N_9_3 N_9_4 N_9_25 N_9_8
+ N_9_22 N_9_26 N_9_2 N_9_1 N_9_24 N_9_15 N_9_16 N_9_14 N_9_17
+ PM_SDFHx2_ASAP7_75t_R%9
cc_168 N_9_7 N_CLK_6 0.000534333f $X=0.162 $Y=0.216
cc_169 N_9_21 N_CLK_6 0.000143658f $X=0.189 $Y=0.234
cc_170 N_9_6 N_CLK_6 0.00039049f $X=0.162 $Y=0.054
cc_171 N_9_23 N_CLK_6 0.00033069f $X=0.189 $Y=0.1735
cc_172 N_9_20 N_CLK_6 0.00197319f $X=0.189 $Y=0.036
cc_173 N_9_21 N_4_29 4.68809e-20 $X=0.189 $Y=0.234
cc_174 N_9_18 N_4_29 5.58704e-20 $X=0.1475 $Y=0.054
cc_175 N_9_20 N_4_22 6.71541e-20 $X=0.189 $Y=0.036
cc_176 N_9_20 N_4_24 6.7242e-20 $X=0.189 $Y=0.036
cc_177 N_9_18 N_4_1 7.4123e-20 $X=0.1475 $Y=0.054
cc_178 N_9_6 N_4_13 0.000642283f $X=0.162 $Y=0.054
cc_179 N_9_21 N_4_8 7.83038e-20 $X=0.189 $Y=0.234
cc_180 N_9_19 N_4_8 9.03343e-20 $X=0.1475 $Y=0.216
cc_181 N_9_21 N_4_25 0.000148464f $X=0.189 $Y=0.234
cc_182 N_9_7 N_4_13 0.000841307f $X=0.162 $Y=0.216
cc_183 N_9_3 N_4_15 0.000190356f $X=0.837 $Y=0.178
cc_184 N_9_4 N_4_15 0.000216944f $X=0.945 $Y=0.178
cc_185 N_9_20 N_4_26 0.000291753f $X=0.189 $Y=0.036
cc_186 N_9_25 N_4_29 0.000839697f $X=0.729 $Y=0.168
cc_187 N_9_19 N_4_13 0.0110839f $X=0.1475 $Y=0.216
cc_188 N_9_18 N_4_13 0.0389733f $X=0.1475 $Y=0.054
cc_189 N_9_21 N_4_26 0.000386916f $X=0.189 $Y=0.234
cc_190 N_9_23 N_4_26 0.00469363f $X=0.189 $Y=0.1735
cc_191 N_9_8 N_4_28 0.000442756f $X=0.837 $Y=0.178
cc_192 N_9_8 N_4_3 0.00241447f $X=0.837 $Y=0.178
cc_193 N_9_22 N_4_29 0.000469897f $X=0.567 $Y=0.198
cc_194 N_9_26 N_4_21 0.000562674f $X=0.1775 $Y=0.189
cc_195 N_9_23 N_4_29 0.000612896f $X=0.189 $Y=0.1735
cc_196 N_9_2 N_4_14 0.000640102f $X=0.675 $Y=0.178
cc_197 N_9_23 N_4_1 0.000672475f $X=0.189 $Y=0.1735
cc_198 N_9_1 N_4_2 0.0023819f $X=0.567 $Y=0.1355
cc_199 N_9_22 N_4_21 0.00175603f $X=0.567 $Y=0.198
cc_200 N_9_24 N_4_27 0.00250282f $X=0.567 $Y=0.1755
cc_201 N_9_15 N_4_14 0.00334544f $X=0.675 $Y=0.178
cc_202 N_9_8 N_4_15 0.00476967f $X=0.837 $Y=0.178
cc_203 N_9_16 N_4_15 0.00545622f $X=0.837 $Y=0.0245
cc_204 N_9_14 N_4_14 0.00676249f $X=0.567 $Y=0.1355
cc_205 N_9_17 N_4_15 0.0172121f $X=0.945 $Y=0.178
cc_206 N_9_26 N_4_29 0.0426288f $X=0.1775 $Y=0.189
cc_207 N_9_6 N_SE_10 0.000214818f $X=0.162 $Y=0.054
cc_208 N_9_26 N_SE_13 0.000245112f $X=0.1775 $Y=0.189
cc_209 N_9_23 N_SE_7 0.000332344f $X=0.189 $Y=0.1735
cc_210 N_9_24 N_SE_13 0.000802461f $X=0.567 $Y=0.1755
cc_211 N_9_26 N_SE_11 0.00115817f $X=0.1775 $Y=0.189
cc_212 N_9_20 N_SE_7 0.00163909f $X=0.189 $Y=0.036
cc_213 N_9_23 N_SE_10 0.00262915f $X=0.189 $Y=0.1735
cc_214 N_9_23 N_SE_8 0.00549943f $X=0.189 $Y=0.1735
cc_215 N_9_22 N_SI_7 0.000139244f $X=0.567 $Y=0.198
cc_216 N_9_1 N_SI_7 0.000439125f $X=0.567 $Y=0.1355
cc_217 N_9_26 N_SI_7 0.00015975f $X=0.1775 $Y=0.189
cc_218 N_9_26 N_SI_4 0.00109262f $X=0.1775 $Y=0.189
cc_219 N_9_22 N_SI_4 0.00110423f $X=0.567 $Y=0.198
cc_220 N_9_24 N_SI_7 0.00376522f $X=0.567 $Y=0.1755
x_PM_SDFHx2_ASAP7_75t_R%10 vss N_M8_g N_M25_g N_M10_s N_M9_d N_M26_d N_M27_s
+ N_10_13 N_10_18 N_10_20 N_10_15 N_10_14 N_10_17 N_10_3 N_10_4 N_10_11 N_10_12
+ N_10_1 N_10_10 N_10_19 PM_SDFHx2_ASAP7_75t_R%10
cc_221 N_10_13 N_4_14 0.000108761f $X=0.866 $Y=0.2295
cc_222 N_10_13 N_4_28 0.000144296f $X=0.866 $Y=0.2295
cc_223 N_10_13 N_4_3 0.000194575f $X=0.866 $Y=0.2295
cc_224 N_10_13 N_4_29 0.000204301f $X=0.866 $Y=0.2295
cc_225 N_10_18 N_4_29 0.000252733f $X=0.81 $Y=0.234
cc_226 N_10_20 N_4_28 0.00417326f $X=0.837 $Y=0.1
cc_227 N_10_20 N_4_3 0.000353515f $X=0.837 $Y=0.1
cc_228 N_10_15 N_4_28 0.00053752f $X=0.81 $Y=0.09
cc_229 N_10_14 N_4_29 0.00162457f $X=0.729 $Y=0.09
cc_230 N_10_13 N_4_15 0.0153887f $X=0.866 $Y=0.2295
cc_231 N_10_17 N_6_16 0.000574038f $X=0.747 $Y=0.09
cc_232 N_10_14 N_6_16 0.000855937f $X=0.729 $Y=0.09
cc_233 N_10_15 N_6_16 0.00240292f $X=0.81 $Y=0.09
cc_234 N_10_3 N_9_8 0.000588455f $X=0.81 $Y=0.0405
cc_235 N_10_3 N_9_2 0.000104684f $X=0.81 $Y=0.0405
cc_236 N_10_3 N_9_25 0.000114255f $X=0.81 $Y=0.0405
cc_237 N_10_4 N_9_8 0.0065628f $X=0.81 $Y=0.2295
cc_238 N_10_11 N_9_16 0.00654964f $X=0.7955 $Y=0.0405
cc_239 N_10_18 N_9_8 0.000284855f $X=0.81 $Y=0.234
cc_240 N_10_12 N_9_16 0.00763476f $X=0.7955 $Y=0.2295
cc_241 N_10_13 N_9_16 0.00766863f $X=0.866 $Y=0.2295
cc_242 N_10_18 N_9_25 0.000362962f $X=0.81 $Y=0.234
cc_243 N_10_1 N_9_15 0.000640958f $X=0.7285 $Y=0.09
cc_244 N_10_4 N_9_3 0.000871193f $X=0.81 $Y=0.2295
cc_245 N_10_20 N_9_8 0.00165025f $X=0.837 $Y=0.1
cc_246 N_10_4 N_9_16 0.00227824f $X=0.81 $Y=0.2295
cc_247 N_10_10 N_9_15 0.0136694f $X=0.729 $Y=0.0245
cc_248 N_10_3 N_9_16 0.0288369f $X=0.81 $Y=0.0405
x_PM_SDFHx2_ASAP7_75t_R%12 vss N_M12_g N_M29_g N_M13_d N_M30_d N_12_16 N_12_15
+ N_12_17 N_12_14 N_12_13 N_12_9 N_12_1 N_12_3 N_12_4 N_12_12 N_12_11 N_12_10
+ PM_SDFHx2_ASAP7_75t_R%12
cc_249 N_12_16 N_SE_13 0.000897973f $X=1.026 $Y=0.036
cc_250 N_12_15 N_SE_13 0.00341956f $X=0.999 $Y=0.0705
cc_251 N_12_17 N_6_13 0.000131983f $X=1.107 $Y=0.081
cc_252 N_12_17 N_6_3 0.00118405f $X=1.107 $Y=0.081
cc_253 N_12_16 N_6_16 0.000337041f $X=1.026 $Y=0.036
cc_254 N_12_14 N_6_15 0.000399389f $X=1.107 $Y=0.0305
cc_255 N_12_13 N_6_13 0.00073346f $X=1.107 $Y=0.234
cc_256 N_12_15 N_6_16 0.00256552f $X=0.999 $Y=0.0705
cc_257 N_12_17 N_6_15 0.00804336f $X=1.107 $Y=0.081
cc_258 N_12_9 N_9_8 0.000579802f $X=0.999 $Y=0.0245
cc_259 N_12_9 N_9_4 0.000352076f $X=0.999 $Y=0.0245
cc_260 N_12_1 N_9_17 0.000500085f $X=0.999 $Y=0.1055
cc_261 N_12_9 N_9_17 0.0122616f $X=0.999 $Y=0.0245
x_PM_SDFHx2_ASAP7_75t_R%QN vss QN N_M15_d N_M16_d N_M32_d N_M33_d N_QN_11
+ N_QN_7 N_QN_13 N_QN_1 N_QN_2 N_QN_8 PM_SDFHx2_ASAP7_75t_R%QN
cc_262 N_QN_11 N_SE_12 0.000549993f $X=1.2845 $Y=0.036
cc_263 N_QN_11 N_SE_9 0.00163106f $X=1.2845 $Y=0.036
cc_264 N_QN_7 N_13_25 0.00219048f $X=1.2815 $Y=0.0675
cc_265 N_QN_7 N_13_2 0.00047108f $X=1.2815 $Y=0.0675
cc_266 N_QN_7 N_13_26 0.000607026f $X=1.2815 $Y=0.0675
cc_267 N_QN_7 N_13_12 0.0460679f $X=1.2815 $Y=0.0675
cc_268 N_QN_13 N_13_2 0.000972862f $X=1.377 $Y=0.0675
cc_269 N_QN_1 N_13_13 0.00187654f $X=1.296 $Y=0.0675
cc_270 N_QN_2 N_13_13 0.0021347f $X=1.296 $Y=0.2025
cc_271 N_QN_2 N_13_25 0.00245446f $X=1.296 $Y=0.2025
cc_272 N_QN_8 N_13_2 0.00503275f $X=1.2815 $Y=0.2025
cc_273 N_QN_8 N_13_12 0.0297107f $X=1.2815 $Y=0.2025
cc_274 N_QN_7 N_13_13 0.0496342f $X=1.2815 $Y=0.0675
x_PM_SDFHx2_ASAP7_75t_R%20 vss N_M11_d N_M12_s N_20_4 N_20_1 N_20_5
+ PM_SDFHx2_ASAP7_75t_R%20
cc_275 N_20_4 N_4_3 0.00023862f $X=0.9035 $Y=0.0405
cc_276 N_20_4 N_4_15 0.0147476f $X=0.9035 $Y=0.0405
cc_277 N_20_1 N_9_17 0.000690949f $X=0.918 $Y=0.0405
cc_278 N_20_5 N_9_17 0.00667207f $X=0.974 $Y=0.0405
cc_279 N_20_4 N_9_17 0.025764f $X=0.9035 $Y=0.0405
cc_280 N_20_1 N_12_9 0.00085105f $X=0.918 $Y=0.0405
cc_281 N_20_5 N_12_9 0.0149602f $X=0.974 $Y=0.0405
cc_282 N_20_1 N_13_14 0.000510378f $X=0.918 $Y=0.0405
cc_283 N_20_1 N_13_20 0.000406652f $X=0.918 $Y=0.0405
cc_284 N_20_1 N_13_21 0.000465753f $X=0.918 $Y=0.0405
cc_285 N_20_4 N_13_5 0.000557417f $X=0.9035 $Y=0.0405
cc_286 N_20_1 N_13_17 0.00213066f $X=0.918 $Y=0.0405
x_PM_SDFHx2_ASAP7_75t_R%13 vss N_M13_g N_M30_g N_M15_g N_M32_g N_M16_g N_M33_g
+ N_M27_d N_M28_s N_M10_d N_M11_s N_13_23 N_13_14 N_13_15 N_13_16 N_13_18
+ N_13_20 N_13_22 N_13_5 N_13_21 N_13_26 N_13_25 N_13_2 N_13_17 N_13_12 N_13_19
+ N_13_1 N_13_24 N_13_6 N_13_11 N_13_13 PM_SDFHx2_ASAP7_75t_R%13
cc_287 N_13_23 N_4_28 0.000163867f $X=1.026 $Y=0.162
cc_288 N_13_14 N_4_15 0.00653501f $X=0.8495 $Y=0.0405
cc_289 N_13_15 N_4_15 0.0065085f $X=0.9035 $Y=0.2295
cc_290 N_13_16 N_4_28 0.000317452f $X=0.945 $Y=0.234
cc_291 N_13_18 N_4_28 0.00138724f $X=0.945 $Y=0.1575
cc_292 N_13_20 N_4_28 0.000412848f $X=0.92 $Y=0.036
cc_293 N_13_22 N_4_28 0.00042549f $X=0.945 $Y=0.198
cc_294 N_13_5 N_4_3 0.0005001f $X=0.864 $Y=0.0405
cc_295 N_13_21 N_4_3 0.000513079f $X=0.945 $Y=0.1315
cc_296 N_13_26 N_4_29 0.00075103f $X=0.945 $Y=0.153
cc_297 N_13_20 N_4_29 0.000963044f $X=0.92 $Y=0.036
cc_298 N_13_21 N_4_28 0.0044001f $X=0.945 $Y=0.1315
cc_299 N_13_5 N_4_15 0.0187415f $X=0.864 $Y=0.0405
cc_300 N_13_21 N_SE_13 0.000330659f $X=0.945 $Y=0.1315
cc_301 N_13_25 N_SE_9 0.000375684f $X=1.269 $Y=0.1085
cc_302 N_13_2 N_SE_2 0.00211781f $X=1.2595 $Y=0.136
cc_303 N_13_20 N_SE_13 0.000975098f $X=0.92 $Y=0.036
cc_304 N_13_26 N_SE_13 0.00195044f $X=0.945 $Y=0.153
cc_305 N_13_17 N_SE_13 0.00281266f $X=0.945 $Y=0.036
cc_306 N_13_12 N_SE_6 0.00342543f $X=1.269 $Y=0.136
cc_307 N_13_25 N_SE_12 0.00582464f $X=1.269 $Y=0.1085
cc_308 N_13_19 N_6_16 0.000105306f $X=1.053 $Y=0.162
cc_309 N_13_26 N_6_16 0.00464757f $X=0.945 $Y=0.153
cc_310 N_13_18 N_6_16 0.000160704f $X=0.945 $Y=0.1575
cc_311 N_13_12 N_6_3 0.000162734f $X=1.269 $Y=0.136
cc_312 N_13_25 N_6_15 0.000192144f $X=1.269 $Y=0.1085
cc_313 N_13_26 N_6_15 0.00174206f $X=0.945 $Y=0.153
cc_314 N_13_1 N_6_15 0.000215713f $X=1.053 $Y=0.14
cc_315 N_13_23 N_6_16 0.000219276f $X=1.026 $Y=0.162
cc_316 N_13_20 N_6_16 0.000293579f $X=0.92 $Y=0.036
cc_317 N_13_25 N_6_13 0.000313276f $X=1.269 $Y=0.1085
cc_318 N_13_24 N_6_16 0.000376706f $X=1.053 $Y=0.125
cc_319 N_13_21 N_6_16 0.00578396f $X=0.945 $Y=0.1315
cc_320 N_13_16 N_9_8 0.000166367f $X=0.945 $Y=0.234
cc_321 N_13_18 N_9_8 0.000191687f $X=0.945 $Y=0.1575
cc_322 N_13_6 N_9_8 0.000219339f $X=0.918 $Y=0.2295
cc_323 N_13_14 N_9_16 0.00656824f $X=0.8495 $Y=0.0405
cc_324 N_13_23 N_9_8 0.000356948f $X=1.026 $Y=0.162
cc_325 N_13_21 N_9_8 0.000518101f $X=0.945 $Y=0.1315
cc_326 N_13_22 N_9_8 0.000569524f $X=0.945 $Y=0.198
cc_327 N_13_6 N_9_17 0.000928804f $X=0.918 $Y=0.2295
cc_328 N_13_15 N_9_4 0.00117066f $X=0.9035 $Y=0.2295
cc_329 N_13_5 N_9_8 0.00278448f $X=0.864 $Y=0.0405
cc_330 N_13_5 N_9_16 0.00946323f $X=0.864 $Y=0.0405
cc_331 N_13_15 N_9_17 0.0167433f $X=0.9035 $Y=0.2295
cc_332 N_13_15 N_10_3 0.000439214f $X=0.9035 $Y=0.2295
cc_333 N_13_16 N_10_3 0.000236821f $X=0.945 $Y=0.234
cc_334 N_13_14 N_10_11 0.000478204f $X=0.8495 $Y=0.0405
cc_335 N_13_16 N_10_4 0.000280175f $X=0.945 $Y=0.234
cc_336 N_13_6 N_10_4 0.000720692f $X=0.918 $Y=0.2295
cc_337 N_13_20 N_10_19 0.000391418f $X=0.92 $Y=0.036
cc_338 N_13_16 N_10_20 0.000543969f $X=0.945 $Y=0.234
cc_339 N_13_15 N_10_4 0.000581349f $X=0.9035 $Y=0.2295
cc_340 N_13_20 N_10_15 0.00134244f $X=0.92 $Y=0.036
cc_341 N_13_5 N_10_3 0.00340653f $X=0.864 $Y=0.0405
cc_342 N_13_22 N_12_9 0.000211093f $X=0.945 $Y=0.198
cc_343 N_13_24 N_12_16 0.00033165f $X=1.053 $Y=0.125
cc_344 N_13_11 N_12_3 0.000350043f $X=1.053 $Y=0.0245
cc_345 N_13_11 N_12_4 0.000484593f $X=1.053 $Y=0.0245
cc_346 N_13_19 N_12_13 0.000738398f $X=1.053 $Y=0.162
cc_347 N_13_19 N_12_17 0.000772014f $X=1.053 $Y=0.162
cc_348 N_13_17 N_12_12 0.000860689f $X=0.945 $Y=0.036
cc_349 N_13_1 N_12_17 0.000873129f $X=1.053 $Y=0.14
cc_350 N_13_21 N_12_1 0.000937725f $X=0.945 $Y=0.1315
cc_351 N_13_11 N_12_1 0.0010674f $X=1.053 $Y=0.0245
cc_352 N_13_1 N_12_9 0.00117175f $X=1.053 $Y=0.14
cc_353 N_13_23 N_12_15 0.00148777f $X=1.026 $Y=0.162
cc_354 N_13_26 N_12_17 0.00162311f $X=0.945 $Y=0.153
cc_355 N_13_11 N_12_11 0.00648716f $X=1.053 $Y=0.0245
cc_356 N_13_11 N_12_10 0.00645581f $X=1.053 $Y=0.0245
cc_357 N_13_21 N_12_15 0.00398801f $X=0.945 $Y=0.1315
cc_358 N_13_24 N_12_17 0.00484453f $X=1.053 $Y=0.125
cc_359 N_13_11 N_12_9 0.0307878f $X=1.053 $Y=0.0245
x_PM_SDFHx2_ASAP7_75t_R%D vss D N_M4_g N_M21_g N_D_3 N_D_4 N_D_1
+ PM_SDFHx2_ASAP7_75t_R%D
cc_360 N_D_3 N_6_16 0.000473832f $X=0.405 $Y=0.0245
cc_361 N_D_3 N_6_1 0.00197926f $X=0.405 $Y=0.0245
cc_362 N_D_4 N_6_12 0.001308f $X=0.405 $Y=0.108
cc_363 D N_6_14 0.00248349f $X=0.405 $Y=0.134
cc_364 N_D_3 N_6_9 0.0050922f $X=0.405 $Y=0.0245
x_PM_SDFHx2_ASAP7_75t_R%SI vss SI N_M5_g N_M22_g N_SI_7 N_SI_6 N_SI_1 N_SI_3
+ N_SI_4 PM_SDFHx2_ASAP7_75t_R%SI
cc_365 N_SI_7 N_4_29 0.00236341f $X=0.513 $Y=0.154
cc_366 N_SI_6 N_D_3 0.00106583f $X=0.4635 $Y=0.135
cc_367 N_SI_1 N_D_1 0.00115009f $X=0.4575 $Y=0.135
cc_368 N_SI_3 N_D_3 0.00467408f $X=0.459 $Y=0.0245

* End of included file SDFHx2_ASAP7_75t_R.pex.sp.pxi
.ends

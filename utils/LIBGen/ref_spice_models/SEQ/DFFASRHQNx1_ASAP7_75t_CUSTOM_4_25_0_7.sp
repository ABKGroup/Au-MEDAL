.subckt PM_DFFASRHQNx1_ASAP7_75t_R%CLK vss 16 7 11 3 6 1 5 4
c1 1 vss 0.00453237f $X=0.081 $Y=0.135
c2 3 vss 0.0701278f $X=0.081 $Y=0.0245
c3 4 vss 0.00224983f $X=0.081 $Y=0.191
c4 5 vss 0.00278803f $X=0.081 $Y=0.117
c5 6 vss 0.00434661f $X=0.108 $Y=0.2125
r1 6 20 3.83327 $w=1.5093e-08 $l=2.15e-08 $layer=M1 $thickness=3.6e-08 $X=0.108
+ $Y=0.2125 $X2=0.108 $Y2=0.191
r2 19 20 1.96775 $w=1.63333e-08 $l=1.35e-08 $layer=M1 $thickness=3.6e-08
+ $X=0.0945 $Y=0.191 $X2=0.108 $Y2=0.191
r3 4 18 3.01711 $w=1.55e-08 $l=1.8e-08 $layer=M1 $thickness=3.6e-08 $X=0.081
+ $Y=0.191 $X2=0.081 $Y2=0.173
r4 4 19 1.96775 $w=1.63333e-08 $l=1.35e-08 $layer=M1 $thickness=3.6e-08
+ $X=0.081 $Y=0.191 $X2=0.0945 $Y2=0.191
r5 17 18 3.55614 $w=1.3e-08 $l=1.53e-08 $layer=M1 $thickness=3.6e-08 $X=0.081
+ $Y=0.1577 $X2=0.081 $Y2=0.173
r6 16 17 1.57403 $w=1.3e-08 $l=6.7e-09 $layer=M1 $thickness=3.6e-08 $X=0.082
+ $Y=0.151 $X2=0.081 $Y2=0.1577
r7 16 15 0.874462 $w=1.3e-08 $l=3.8e-09 $layer=M1 $thickness=3.6e-08 $X=0.082
+ $Y=0.151 $X2=0.081 $Y2=0.1472
r8 14 15 2.85657 $w=1.3e-08 $l=1.22e-08 $layer=M1 $thickness=3.6e-08 $X=0.081
+ $Y=0.135 $X2=0.081 $Y2=0.1472
r9 5 14 4.19742 $w=1.3e-08 $l=1.8e-08 $layer=M1 $thickness=3.6e-08 $X=0.081
+ $Y=0.117 $X2=0.081 $Y2=0.135
r10 1 9 10.4265 $w=1.765e-08 $layer=LIG $thickness=5.2e-08 $X=0.081 $Y=0.135
+ $X2=0.081 $Y2=0.135
r11 1 14 19.3796 $a=3.24e-16 $layer=V0LIG $X=0.081 $Y=0.135 $X2=0.081 $Y2=0.135
r12 11 10 16.4967 $w=2.1e-08 $l=4.85e-08 $layer=Gate_1 $thickness=5.6e-08
+ $X=0.081 $Y=0.216 $X2=0.081 $Y2=0.1675
r13 9 10 11.2416 $w=2.06615e-08 $l=3.25e-08 $layer=Gate_1 $thickness=5.6e-08
+ $X=0.081 $Y=0.135 $X2=0.081 $Y2=0.1675
r14 8 9 11.2416 $w=2.06615e-08 $l=3.25e-08 $layer=Gate_1 $thickness=5.6e-08
+ $X=0.081 $Y=0.1025 $X2=0.081 $Y2=0.135
r15 7 8 16.4967 $w=2.1e-08 $l=4.85e-08 $layer=Gate_1 $thickness=5.6e-08
+ $X=0.081 $Y=0.054 $X2=0.081 $Y2=0.1025
r16 7 3 10.0341 $w=2.1e-08 $l=2.95e-08 $layer=Gate_1 $thickness=5.6e-08
+ $X=0.081 $Y=0.054 $X2=0.081 $Y2=0.0245
.ends

.subckt PM_DFFASRHQNx1_ASAP7_75t_R%19 vss 2 3 1
c1 1 vss 0.000640911f $X=0.702 $Y=0.054
r1 2 1 0.314815 $w=5.4e-08 $l=1.7e-08 $layer=N_src_drn $thickness=1e-09
+ $X=0.6846 $Y=0.054 $X2=0.702 $Y2=0.054
r2 3 1 0.314815 $w=5.4e-08 $l=1.7e-08 $layer=N_src_drn $thickness=1e-09
+ $X=0.7193 $Y=0.054 $X2=0.702 $Y2=0.054
.ends

.subckt PM_DFFASRHQNx1_ASAP7_75t_R%16 vss 7 9 5 4 1
c1 1 vss 0.00874579f $X=0.351 $Y=0.0675
c2 4 vss 0.00296206f $X=0.3095 $Y=0.0675
c3 5 vss 0.00174972f $X=0.38 $Y=0.0675
r1 9 8 0.0308642 $w=8.1e-08 $l=2.5e-09 $layer=N_src_drn $thickness=1e-09
+ $X=0.3953 $Y=0.0675 $X2=0.3925 $Y2=0.0675
r2 5 8 0.154321 $w=8.1e-08 $l=1.25e-08 $layer=N_src_drn $thickness=1e-09
+ $X=0.38 $Y=0.0675 $X2=0.3925 $Y2=0.0675
r3 4 1 0.154321 $w=8.1e-08 $l=1.25e-08 $layer=N_src_drn $thickness=1e-09
+ $X=0.3095 $Y=0.0675 $X2=0.351 $Y2=0.0675
r4 7 4 0.0308642 $w=8.1e-08 $l=2.5e-09 $layer=N_src_drn $thickness=1e-09
+ $X=0.3066 $Y=0.0675 $X2=0.3095 $Y2=0.0675
r5 1 5 1e-05 $l=2.9e-08 $X=0.351 $Y=0.0675 $X2=0.38 $Y2=0.0675
.ends

.subckt PM_DFFASRHQNx1_ASAP7_75t_R%17 vss 7 11 4 5 1
c1 1 vss 0.00797716f $X=0.486 $Y=0.0405
c2 4 vss 0.0166676f $X=0.4715 $Y=0.0405
c3 5 vss 0.0168554f $X=0.542 $Y=0.0405
r1 11 10 0.0925926 $w=2.7e-08 $l=2.5e-09 $layer=N_src_drn $thickness=1e-09
+ $X=0.5573 $Y=0.0405 $X2=0.5545 $Y2=0.0405
r2 5 10 0.462963 $w=2.7e-08 $l=1.25e-08 $layer=N_src_drn $thickness=1e-09
+ $X=0.542 $Y=0.0405 $X2=0.5545 $Y2=0.0405
r3 8 5 12.6992 $w=2.32e-08 $l=2.7e-08 $layer=LISD $thickness=2.7e-08 $X=0.513
+ $Y=0.0405 $X2=0.542 $Y2=0.0405
r4 1 8 12.6992 $w=2.32e-08 $l=2.7e-08 $layer=LISD $thickness=2.7e-08 $X=0.486
+ $Y=0.0405 $X2=0.513 $Y2=0.0405
r5 4 1 0.462963 $w=2.7e-08 $l=1.25e-08 $layer=N_src_drn $thickness=1e-09
+ $X=0.4715 $Y=0.0405 $X2=0.486 $Y2=0.0405
r6 7 4 0.0925926 $w=2.7e-08 $l=2.5e-09 $layer=N_src_drn $thickness=1e-09
+ $X=0.4686 $Y=0.0405 $X2=0.4715 $Y2=0.0405
.ends

.subckt PM_DFFASRHQNx1_ASAP7_75t_R%9 vss 26 30 54 57 77 80 11 14 15 18 13 4 3
+ 17 21 10 19 22 12 20 16 1 9
c1 1 vss 0.00324275f $X=0.724 $Y=0.16
c2 3 vss 0.00411759f $X=0.378 $Y=0.174
c3 4 vss 0.00428082f $X=0.432 $Y=0.0405
c4 9 vss 0.0406443f $X=0.729 $Y=0.0245
c5 10 vss 0.00176899f $X=0.4175 $Y=0.0405
c6 11 vss 0.000316574f $X=0.4175 $Y=0.081
c7 12 vss 0.00212434f $X=0.3635 $Y=0.1975
c8 13 vss 3.13438e-20 $X=0.3635 $Y=0.1755
c9 14 vss 0.000338788f $X=0.3635 $Y=0.2245
c10 15 vss 0.00252625f $X=0.495 $Y=0.0405
c11 16 vss 0.00048558f $X=0.495 $Y=0.189
c12 17 vss 0.00258601f $X=0.378 $Y=0.1725
c13 18 vss 0.00558783f $X=0.477 $Y=0.036
c14 19 vss 0.00167392f $X=0.495 $Y=0.1745
c15 20 vss 0.00150013f $X=0.508 $Y=0.189
c16 21 vss 0.00156513f $X=0.738 $Y=0.144
c17 22 vss 0.00542814f $X=0.6805 $Y=0.189
r1 11 4 0.231482 $w=5.4e-08 $l=1.25e-08 $layer=N_src_drn $thickness=1e-09
+ $X=0.4175 $Y=0.081 $X2=0.432 $Y2=0.0405
r2 80 79 0.0925926 $w=2.7e-08 $l=2.5e-09 $layer=N_src_drn $thickness=1e-09
+ $X=0.4493 $Y=0.0405 $X2=0.4465 $Y2=0.0405
r3 78 79 0.166667 $w=2.7e-08 $l=4.5e-09 $layer=N_src_drn $thickness=1e-09
+ $X=0.442 $Y=0.0405 $X2=0.4465 $Y2=0.0405
r4 4 78 0.444445 $w=2.7e-08 $l=1.2e-08 $layer=N_src_drn $thickness=1e-09
+ $X=0.432 $Y=0.0405 $X2=0.442 $Y2=0.0405
r5 10 4 0.462963 $w=2.7e-08 $l=1.25e-08 $layer=N_src_drn $thickness=1e-09
+ $X=0.4175 $Y=0.0405 $X2=0.432 $Y2=0.0405
r6 77 10 0.0925926 $w=2.7e-08 $l=2.5e-09 $layer=N_src_drn $thickness=1e-09
+ $X=0.4146 $Y=0.0675 $X2=0.4175 $Y2=0.0405
r7 4 71 19.3796 $a=3.24e-16 $layer=V0LISD $X=0.432 $Y=0.0405 $X2=0.432 $Y2=0.036
r8 71 72 3.14806 $w=1.3e-08 $l=1.35e-08 $layer=M1 $thickness=3.6e-08 $X=0.432
+ $Y=0.036 $X2=0.4455 $Y2=0.036
r9 69 72 3.14806 $w=1.3e-08 $l=1.35e-08 $layer=M1 $thickness=3.6e-08 $X=0.459
+ $Y=0.036 $X2=0.4455 $Y2=0.036
r10 18 69 4.19742 $w=1.3e-08 $l=1.8e-08 $layer=M1 $thickness=3.6e-08 $X=0.477
+ $Y=0.036 $X2=0.459 $Y2=0.036
r11 15 67 3.02429 $w=1.44516e-08 $l=1.55e-08 $layer=M1 $thickness=3.6e-08
+ $X=0.495 $Y=0.0405 $X2=0.495 $Y2=0.056
r12 15 18 2.55791 $w=1.46667e-08 $l=1.8554e-08 $layer=M1 $thickness=3.6e-08
+ $X=0.495 $Y=0.0405 $X2=0.477 $Y2=0.036
r13 66 67 6.7625 $w=1.3e-08 $l=2.9e-08 $layer=M1 $thickness=3.6e-08 $X=0.495
+ $Y=0.085 $X2=0.495 $Y2=0.056
r14 65 66 4.5472 $w=1.3e-08 $l=1.95e-08 $layer=M1 $thickness=3.6e-08 $X=0.495
+ $Y=0.1045 $X2=0.495 $Y2=0.085
r15 64 65 4.78039 $w=1.3e-08 $l=2.05e-08 $layer=M1 $thickness=3.6e-08 $X=0.495
+ $Y=0.125 $X2=0.495 $Y2=0.1045
r16 63 64 5.24677 $w=1.3e-08 $l=2.25e-08 $layer=M1 $thickness=3.6e-08 $X=0.495
+ $Y=0.1475 $X2=0.495 $Y2=0.125
r17 62 63 2.09871 $w=1.3e-08 $l=9e-09 $layer=M1 $thickness=3.6e-08 $X=0.495
+ $Y=0.1565 $X2=0.495 $Y2=0.1475
r18 61 62 2.09871 $w=1.3e-08 $l=9e-09 $layer=M1 $thickness=3.6e-08 $X=0.495
+ $Y=0.1655 $X2=0.495 $Y2=0.1565
r19 19 61 2.09871 $w=1.3e-08 $l=9e-09 $layer=M1 $thickness=3.6e-08 $X=0.495
+ $Y=0.1745 $X2=0.495 $Y2=0.1655
r20 14 52 0.391892 $w=3.7e-08 $l=1.45e-08 $layer=P_src_drn $thickness=1e-09
+ $X=0.3635 $Y=0.2245 $X2=0.378 $Y2=0.216
r21 13 52 0.462963 $w=2.7e-08 $l=1.25e-08 $layer=P_src_drn $thickness=1e-09
+ $X=0.3635 $Y=0.1755 $X2=0.378 $Y2=0.216
r22 57 56 0.147059 $w=1.7e-08 $l=2.5e-09 $layer=P_src_drn $thickness=1e-09
+ $X=0.3953 $Y=0.216 $X2=0.3925 $Y2=0.1975
r23 55 56 0.264706 $w=1.7e-08 $l=4.5e-09 $layer=P_src_drn $thickness=1e-09
+ $X=0.388 $Y=0.1975 $X2=0.3925 $Y2=0.1975
r24 52 55 0.705882 $w=1.7e-08 $l=1.2e-08 $layer=P_src_drn $thickness=1e-09
+ $X=0.378 $Y=0.216 $X2=0.388 $Y2=0.1975
r25 12 52 0.735294 $w=1.7e-08 $l=1.25e-08 $layer=P_src_drn $thickness=1e-09
+ $X=0.3635 $Y=0.1975 $X2=0.378 $Y2=0.216
r26 54 12 0.147059 $w=1.7e-08 $l=2.5e-09 $layer=P_src_drn $thickness=1e-09
+ $X=0.3606 $Y=0.2025 $X2=0.3635 $Y2=0.1975
r27 16 20 1.38235 $w=1.64615e-08 $l=1.3e-08 $layer=M1 $thickness=3.6e-08
+ $X=0.495 $Y=0.189 $X2=0.508 $Y2=0.189
r28 16 19 1.73214 $w=1.90828e-08 $l=1.45e-08 $layer=M1 $thickness=3.6e-08
+ $X=0.495 $Y=0.189 $X2=0.495 $Y2=0.1745
r29 51 52 16.798 $w=2.02e-08 $l=2.85e-08 $layer=LISD $thickness=2.7e-08
+ $X=0.378 $Y=0.1875 $X2=0.378 $Y2=0.216
r30 3 47 19.3796 $a=3.24e-16 $layer=V0LISD $X=0.378 $Y=0.174 $X2=0.378 $Y2=0.187
r31 3 51 7.95695 $w=2.02e-08 $l=1.35e-08 $layer=LISD $thickness=2.7e-08
+ $X=0.378 $Y=0.174 $X2=0.378 $Y2=0.1875
r32 20 49 3.03147 $w=1.3e-08 $l=1.3e-08 $layer=M1 $thickness=3.6e-08 $X=0.508
+ $Y=0.189 $X2=0.521 $Y2=0.189
r33 17 47 3.38125 $w=1.3e-08 $l=1.45e-08 $layer=M1 $thickness=3.6e-08 $X=0.378
+ $Y=0.1725 $X2=0.378 $Y2=0.187
r34 45 46 13.9914 $w=1.3e-08 $l=6e-08 $layer=M2 $thickness=3.6e-08 $X=0.521
+ $Y=0.189 $X2=0.581 $Y2=0.189
r35 45 49 19.5347 $a=3.24e-16 $layer=V1 $X=0.521 $Y=0.189 $X2=0.521 $Y2=0.189
r36 44 45 16.6731 $w=1.3e-08 $l=7.15e-08 $layer=M2 $thickness=3.6e-08 $X=0.4495
+ $Y=0.189 $X2=0.521 $Y2=0.189
r37 43 44 16.6731 $w=1.3e-08 $l=7.15e-08 $layer=M2 $thickness=3.6e-08 $X=0.378
+ $Y=0.189 $X2=0.4495 $Y2=0.189
r38 43 47 19.5347 $a=3.24e-16 $layer=V1 $X=0.378 $Y=0.189 $X2=0.378 $Y2=0.187
r39 22 40 13.4084 $w=1.3e-08 $l=5.75e-08 $layer=M2 $thickness=3.6e-08 $X=0.6805
+ $Y=0.189 $X2=0.738 $Y2=0.189
r40 22 46 23.2024 $w=1.3e-08 $l=9.95e-08 $layer=M2 $thickness=3.6e-08 $X=0.6805
+ $Y=0.189 $X2=0.581 $Y2=0.189
r41 38 40 19.5347 $a=3.24e-16 $layer=V1 $X=0.738 $Y=0.189 $X2=0.738 $Y2=0.189
r42 37 38 3.38125 $w=1.3e-08 $l=1.45e-08 $layer=M1 $thickness=3.6e-08 $X=0.738
+ $Y=0.1745 $X2=0.738 $Y2=0.189
r43 36 37 3.38125 $w=1.3e-08 $l=1.45e-08 $layer=M1 $thickness=3.6e-08 $X=0.738
+ $Y=0.16 $X2=0.738 $Y2=0.1745
r44 21 36 3.73104 $w=1.3e-08 $l=1.6e-08 $layer=M1 $thickness=3.6e-08 $X=0.738
+ $Y=0.144 $X2=0.738 $Y2=0.16
r45 32 36 19.3796 $a=3.24e-16 $layer=V0LIG $X=0.734 $Y=0.16 $X2=0.738 $Y2=0.16
r46 1 32 2.1415 $w=2.4e-08 $l=1e-08 $layer=LIG $thickness=4.8e-08 $X=0.724
+ $Y=0.16 $X2=0.734 $Y2=0.16
r47 30 29 12.0749 $w=2.1e-08 $l=3.55e-08 $layer=Gate_1 $thickness=5.6e-08
+ $X=0.729 $Y=0.2295 $X2=0.729 $Y2=0.194
r48 28 29 11.7688 $w=2.06471e-08 $l=3.4e-08 $layer=Gate_1 $thickness=5.6e-08
+ $X=0.729 $Y=0.16 $X2=0.729 $Y2=0.194
r49 28 32 5.35649 $w=2.11765e-08 $l=5e-09 $layer=Gate_1 $thickness=5.36471e-08
+ $X=0.729 $Y=0.16 $X2=0.734 $Y2=0.16
r50 27 28 15.6804 $w=2.07363e-08 $l=4.55e-08 $layer=Gate_1 $thickness=5.6e-08
+ $X=0.729 $Y=0.1145 $X2=0.729 $Y2=0.16
r51 26 27 20.5784 $w=2.1e-08 $l=6.05e-08 $layer=Gate_1 $thickness=5.6e-08
+ $X=0.729 $Y=0.054 $X2=0.729 $Y2=0.1145
r52 26 9 10.0341 $w=2.1e-08 $l=2.95e-08 $layer=Gate_1 $thickness=5.6e-08
+ $X=0.729 $Y=0.054 $X2=0.729 $Y2=0.0245
.ends

.subckt PM_DFFASRHQNx1_ASAP7_75t_R%QN vss 19 13 27 7 8 11
c1 1 vss 0.00901748f $X=1.35 $Y=0.0675
c2 2 vss 0.00900085f $X=1.35 $Y=0.2025
c3 7 vss 0.0392635f $X=1.3355 $Y=0.0675
c4 8 vss 0.0389701f $X=1.3355 $Y=0.2025
c5 9 vss 0.00629163f $X=1.3385 $Y=0.036
c6 10 vss 0.0063282f $X=1.377 $Y=0.234
c7 11 vss 0.00553688f $X=1.377 $Y=0.0735
r1 8 2 0.154321 $w=8.1e-08 $l=1.25e-08 $layer=P_src_drn $thickness=1e-09
+ $X=1.3355 $Y=0.2025 $X2=1.35 $Y2=0.2025
r2 27 8 0.0308642 $w=8.1e-08 $l=2.5e-09 $layer=P_src_drn $thickness=1e-09
+ $X=1.3326 $Y=0.2025 $X2=1.3355 $Y2=0.2025
r3 2 24 19.3796 $a=3.24e-16 $layer=V0LISD $X=1.35 $Y=0.2025 $X2=1.35 $Y2=0.234
r4 24 25 3.14806 $w=1.3e-08 $l=1.35e-08 $layer=M1 $thickness=3.6e-08 $X=1.35
+ $Y=0.234 $X2=1.3635 $Y2=0.234
r5 10 22 1.96775 $w=1.63333e-08 $l=1.35e-08 $layer=M1 $thickness=3.6e-08
+ $X=1.377 $Y=0.234 $X2=1.377 $Y2=0.2205
r6 10 25 1.96775 $w=1.63333e-08 $l=1.35e-08 $layer=M1 $thickness=3.6e-08
+ $X=1.377 $Y=0.234 $X2=1.3635 $Y2=0.234
r7 21 22 5.24677 $w=1.3e-08 $l=2.25e-08 $layer=M1 $thickness=3.6e-08 $X=1.377
+ $Y=0.198 $X2=1.377 $Y2=0.2205
r8 20 21 11.1348 $w=1.3e-08 $l=4.78e-08 $layer=M1 $thickness=3.6e-08 $X=1.377
+ $Y=0.1502 $X2=1.377 $Y2=0.198
r9 19 20 7.05399 $w=1.3e-08 $l=3.02e-08 $layer=M1 $thickness=3.6e-08 $X=1.377
+ $Y=0.12 $X2=1.377 $Y2=0.1502
r10 19 18 2.04041 $w=1.3e-08 $l=8.8e-09 $layer=M1 $thickness=3.6e-08 $X=1.377
+ $Y=0.12 $X2=1.377 $Y2=0.1112
r11 17 18 2.04041 $w=1.3e-08 $l=8.7e-09 $layer=M1 $thickness=3.6e-08 $X=1.377
+ $Y=0.1025 $X2=1.377 $Y2=0.1112
r12 11 16 7.56431 $w=1.42e-08 $l=3.75e-08 $layer=M1 $thickness=3.6e-08 $X=1.377
+ $Y=0.0735 $X2=1.377 $Y2=0.036
r13 11 17 6.7625 $w=1.3e-08 $l=2.9e-08 $layer=M1 $thickness=3.6e-08 $X=1.377
+ $Y=0.0735 $X2=1.377 $Y2=0.1025
r14 15 16 1.96775 $w=1.63333e-08 $l=1.35e-08 $layer=M1 $thickness=3.6e-08
+ $X=1.3635 $Y=0.036 $X2=1.377 $Y2=0.036
r15 14 15 3.14806 $w=1.3e-08 $l=1.35e-08 $layer=M1 $thickness=3.6e-08 $X=1.35
+ $Y=0.036 $X2=1.3635 $Y2=0.036
r16 9 14 2.68168 $w=1.3e-08 $l=1.15e-08 $layer=M1 $thickness=3.6e-08 $X=1.3385
+ $Y=0.036 $X2=1.35 $Y2=0.036
r17 1 14 19.3796 $a=3.24e-16 $layer=V0LISD $X=1.35 $Y=0.0675 $X2=1.35 $Y2=0.036
r18 7 1 0.154321 $w=8.1e-08 $l=1.25e-08 $layer=N_src_drn $thickness=1e-09
+ $X=1.3355 $Y=0.0675 $X2=1.35 $Y2=0.0675
r19 13 7 0.0308642 $w=8.1e-08 $l=2.5e-09 $layer=N_src_drn $thickness=1e-09
+ $X=1.3326 $Y=0.0675 $X2=1.3355 $Y2=0.0675
.ends

.subckt PM_DFFASRHQNx1_ASAP7_75t_R%14 vss 16 17 28 7 1 11 9 10 8 2
c1 1 vss 0.00527495f $X=0.81 $Y=0.216
c2 2 vss 0.00664453f $X=1.188 $Y=0.2295
c3 7 vss 0.00315051f $X=0.7955 $Y=0.216
c4 8 vss 0.0179914f $X=1.1735 $Y=0.2295
c5 9 vss 0.00394127f $X=0.783 $Y=0.225
c6 10 vss 0.00506599f $X=1.1725 $Y=0.225
c7 11 vss 0.011776f $X=0.7855 $Y=0.225
r1 8 2 0.462963 $w=2.7e-08 $l=1.25e-08 $layer=P_src_drn $thickness=1e-09
+ $X=1.1735 $Y=0.2295 $X2=1.188 $Y2=0.2295
r2 28 8 0.0925926 $w=2.7e-08 $l=2.5e-09 $layer=P_src_drn $thickness=1e-09
+ $X=1.1706 $Y=0.2295 $X2=1.1735 $Y2=0.2295
r3 2 25 19.3796 $a=3.24e-16 $layer=V0LISD $X=1.188 $Y=0.2295 $X2=1.186 $Y2=0.225
r4 10 25 3.14806 $w=1.3e-08 $l=1.35e-08 $layer=M1 $thickness=3.6e-08 $X=1.1725
+ $Y=0.225 $X2=1.186 $Y2=0.225
r5 23 25 19.5347 $a=3.24e-16 $layer=V1 $X=1.184 $Y=0.225 $X2=1.186 $Y2=0.225
r6 22 23 14.691 $w=1.3e-08 $l=6.3e-08 $layer=M2 $thickness=3.6e-08 $X=1.121
+ $Y=0.225 $X2=1.184 $Y2=0.225
r7 21 22 43.0235 $w=1.3e-08 $l=1.845e-07 $layer=M2 $thickness=3.6e-08 $X=0.9365
+ $Y=0.225 $X2=1.121 $Y2=0.225
r8 20 21 32.53 $w=1.3e-08 $l=1.395e-07 $layer=M2 $thickness=3.6e-08 $X=0.797
+ $Y=0.225 $X2=0.9365 $Y2=0.225
r9 11 20 2.68168 $w=1.3e-08 $l=1.15e-08 $layer=M2 $thickness=3.6e-08 $X=0.7855
+ $Y=0.225 $X2=0.797 $Y2=0.225
r10 18 20 19.5347 $a=3.24e-16 $layer=V1 $X=0.7995 $Y=0.225 $X2=0.797 $Y2=0.225
r11 9 18 3.84763 $w=1.3e-08 $l=1.65e-08 $layer=M1 $thickness=3.6e-08 $X=0.783
+ $Y=0.225 $X2=0.7995 $Y2=0.225
r12 1 18 19.3796 $a=3.24e-16 $layer=V0LISD $X=0.81 $Y=0.216 $X2=0.7995 $Y2=0.225
r13 17 15 0.0462963 $w=5.4e-08 $l=2.5e-09 $layer=P_src_drn $thickness=1e-09
+ $X=0.8273 $Y=0.216 $X2=0.8245 $Y2=0.216
r14 1 15 0.268519 $w=5.4e-08 $l=1.45e-08 $layer=P_src_drn $thickness=1e-09
+ $X=0.81 $Y=0.216 $X2=0.8245 $Y2=0.216
r15 7 1 0.268519 $w=5.4e-08 $l=1.45e-08 $layer=P_src_drn $thickness=1e-09
+ $X=0.7955 $Y=0.216 $X2=0.81 $Y2=0.216
r16 16 7 0.0462963 $w=5.4e-08 $l=2.5e-09 $layer=P_src_drn $thickness=1e-09
+ $X=0.7926 $Y=0.216 $X2=0.7955 $Y2=0.216
.ends

.subckt PM_DFFASRHQNx1_ASAP7_75t_R%7 vss 31 35 73 74 76 78 89 91 18 4 5 20 26
+ 28 23 27 24 25 1 16 14 3 22 17 15 19
c1 1 vss 0.00195309f $X=0.567 $Y=0.089
c2 3 vss 0.00695486f $X=0.702 $Y=0.198
c3 4 vss 0.00770278f $X=0.756 $Y=0.054
c4 5 vss 0.00802681f $X=0.947 $Y=0.2295
c5 14 vss 0.0428785f $X=0.567 $Y=0.0245
c6 15 vss 0.00217285f $X=0.7415 $Y=0.054
c7 16 vss 0.00190922f $X=0.812 $Y=0.0405
c8 17 vss 0.00296705f $X=0.6875 $Y=0.2295
c9 18 vss 0.00190689f $X=0.9035 $Y=0.2295
c10 19 vss 0.00234902f $X=0.974 $Y=0.2295
c11 20 vss 0.00195324f $X=0.567 $Y=0.0495
c12 21 vss 0.0015224f $X=0.702 $Y=0.045
c13 22 vss 0.00565333f $X=0.972 $Y=0.045
c14 23 vss 0.000802534f $X=0.567 $Y=0.0765
c15 24 vss 0.00798519f $X=0.592 $Y=0.045
c16 25 vss 0.00230629f $X=0.702 $Y=0.0605
c17 26 vss 0.00413497f $X=0.72 $Y=0.045
c18 27 vss 0.00323985f $X=0.972 $Y=0.078
c19 28 vss 0.0077278f $X=0.7435 $Y=0.045
r1 18 86 0.462963 $w=2.7e-08 $l=1.25e-08 $layer=P_src_drn $thickness=1e-09
+ $X=0.9035 $Y=0.2295 $X2=0.918 $Y2=0.2295
r2 91 18 0.0925926 $w=2.7e-08 $l=2.5e-09 $layer=P_src_drn $thickness=1e-09
+ $X=0.9006 $Y=0.2295 $X2=0.9035 $Y2=0.2295
r3 89 88 0.0925926 $w=2.7e-08 $l=2.5e-09 $layer=P_src_drn $thickness=1e-09
+ $X=0.9893 $Y=0.2295 $X2=0.9865 $Y2=0.2295
r4 19 88 0.462963 $w=2.7e-08 $l=1.25e-08 $layer=P_src_drn $thickness=1e-09
+ $X=0.974 $Y=0.2295 $X2=0.9865 $Y2=0.2295
r5 86 87 6.58477 $w=2.32e-08 $l=1.4e-08 $layer=LISD $thickness=2.7e-08 $X=0.918
+ $Y=0.2295 $X2=0.932 $Y2=0.2295
r6 5 19 11.7585 $w=2.32e-08 $l=2.5e-08 $layer=LISD $thickness=2.7e-08 $X=0.947
+ $Y=0.2295 $X2=0.974 $Y2=0.2295
r7 5 87 7.05511 $w=2.32e-08 $l=1.5e-08 $layer=LISD $thickness=2.7e-08 $X=0.947
+ $Y=0.2295 $X2=0.932 $Y2=0.2295
r8 84 19 19.3796 $a=3.24e-16 $layer=V0LISD $X=0.972 $Y=0.225 $X2=0.974
+ $Y2=0.2295
r9 83 84 7.81186 $w=1.3e-08 $l=3.35e-08 $layer=M1 $thickness=3.6e-08 $X=0.972
+ $Y=0.1915 $X2=0.972 $Y2=0.225
r10 82 83 13.2918 $w=1.3e-08 $l=5.7e-08 $layer=M1 $thickness=3.6e-08 $X=0.972
+ $Y=0.1345 $X2=0.972 $Y2=0.1915
r11 27 82 13.1752 $w=1.3e-08 $l=5.65e-08 $layer=M1 $thickness=3.6e-08 $X=0.972
+ $Y=0.078 $X2=0.972 $Y2=0.1345
r12 79 80 2.56509 $w=1.3e-08 $l=1.1e-08 $layer=M1 $thickness=3.6e-08 $X=0.983
+ $Y=0.045 $X2=0.994 $Y2=0.045
r13 22 79 1.38478 $w=1.70909e-08 $l=1.1e-08 $layer=M1 $thickness=3.6e-08
+ $X=0.972 $Y=0.045 $X2=0.983 $Y2=0.045
r14 22 27 6.51495 $w=1.43636e-08 $l=3.3e-08 $layer=M1 $thickness=3.6e-08
+ $X=0.972 $Y=0.045 $X2=0.972 $Y2=0.078
r15 78 77 0.0925926 $w=2.7e-08 $l=2.5e-09 $layer=N_src_drn $thickness=1e-09
+ $X=0.8273 $Y=0.0405 $X2=0.8245 $Y2=0.0405
r16 16 77 0.462963 $w=2.7e-08 $l=1.25e-08 $layer=N_src_drn $thickness=1e-09
+ $X=0.812 $Y=0.0405 $X2=0.8245 $Y2=0.0405
r17 15 4 0.231482 $w=5.4e-08 $l=1.25e-08 $layer=N_src_drn $thickness=1e-09
+ $X=0.7415 $Y=0.054 $X2=0.756 $Y2=0.054
r18 76 15 0.0462963 $w=5.4e-08 $l=2.5e-09 $layer=N_src_drn $thickness=1e-09
+ $X=0.7386 $Y=0.054 $X2=0.7415 $Y2=0.054
r19 74 72 0.0925926 $w=2.7e-08 $l=2.5e-09 $layer=P_src_drn $thickness=1e-09
+ $X=0.7193 $Y=0.2295 $X2=0.7165 $Y2=0.2295
r20 63 72 0.537037 $w=2.7e-08 $l=1.45e-08 $layer=P_src_drn $thickness=1e-09
+ $X=0.702 $Y=0.2295 $X2=0.7165 $Y2=0.2295
r21 17 63 0.537037 $w=2.7e-08 $l=1.45e-08 $layer=P_src_drn $thickness=1e-09
+ $X=0.6875 $Y=0.2295 $X2=0.702 $Y2=0.2295
r22 73 17 0.0925926 $w=2.7e-08 $l=2.5e-09 $layer=P_src_drn $thickness=1e-09
+ $X=0.6846 $Y=0.2295 $X2=0.6875 $Y2=0.2295
r23 69 80 19.5347 $a=3.24e-16 $layer=V1 $X=0.994 $Y=0.045 $X2=0.994 $Y2=0.045
r24 68 69 8.97781 $w=1.3e-08 $l=3.85e-08 $layer=M2 $thickness=3.6e-08 $X=0.9555
+ $Y=0.045 $X2=0.994 $Y2=0.045
r25 67 68 25.7675 $w=1.3e-08 $l=1.105e-07 $layer=M2 $thickness=3.6e-08 $X=0.845
+ $Y=0.045 $X2=0.9555 $Y2=0.045
r26 66 67 20.9871 $w=1.3e-08 $l=9e-08 $layer=M2 $thickness=3.6e-08 $X=0.755
+ $Y=0.045 $X2=0.845 $Y2=0.045
r27 28 66 2.68168 $w=1.3e-08 $l=1.15e-08 $layer=M2 $thickness=3.6e-08 $X=0.7435
+ $Y=0.045 $X2=0.755 $Y2=0.045
r28 64 16 4.04632 $w=5.02e-08 $l=2.7e-08 $layer=LISD $thickness=2.7e-08
+ $X=0.783 $Y=0.054 $X2=0.812 $Y2=0.0405
r29 4 64 4.04632 $w=5.02e-08 $l=2.7e-08 $layer=LISD $thickness=2.7e-08 $X=0.756
+ $Y=0.054 $X2=0.783 $Y2=0.054
r30 4 60 19.3796 $a=3.24e-16 $layer=V0LISD $X=0.756 $Y=0.054 $X2=0.756 $Y2=0.045
r31 62 63 10.6093 $w=2.02e-08 $l=1.8e-08 $layer=LISD $thickness=2.7e-08
+ $X=0.702 $Y=0.2115 $X2=0.702 $Y2=0.2295
r32 3 62 7.95695 $w=2.02e-08 $l=1.35e-08 $layer=LISD $thickness=2.7e-08
+ $X=0.702 $Y=0.198 $X2=0.702 $Y2=0.2115
r33 3 54 19.3796 $a=3.24e-16 $layer=V0LISD $X=0.702 $Y=0.198 $X2=0.702
+ $Y2=0.1935
r34 60 66 19.5347 $a=3.24e-16 $layer=V1 $X=0.756 $Y=0.045 $X2=0.755 $Y2=0.045
r35 59 60 2.2153 $w=1.3e-08 $l=9.5e-09 $layer=M1 $thickness=3.6e-08 $X=0.7465
+ $Y=0.045 $X2=0.756 $Y2=0.045
r36 58 59 2.09871 $w=1.3e-08 $l=9e-09 $layer=M1 $thickness=3.6e-08 $X=0.7375
+ $Y=0.045 $X2=0.7465 $Y2=0.045
r37 26 58 4.08082 $w=1.3e-08 $l=1.75e-08 $layer=M1 $thickness=3.6e-08 $X=0.72
+ $Y=0.045 $X2=0.7375 $Y2=0.045
r38 53 54 2.09871 $w=1.3e-08 $l=9e-09 $layer=M1 $thickness=3.6e-08 $X=0.702
+ $Y=0.1845 $X2=0.702 $Y2=0.1935
r39 52 53 3.14806 $w=1.3e-08 $l=1.35e-08 $layer=M1 $thickness=3.6e-08 $X=0.702
+ $Y=0.171 $X2=0.702 $Y2=0.1845
r40 51 52 4.19742 $w=1.3e-08 $l=1.8e-08 $layer=M1 $thickness=3.6e-08 $X=0.702
+ $Y=0.153 $X2=0.702 $Y2=0.171
r41 50 51 2.91487 $w=1.3e-08 $l=1.25e-08 $layer=M1 $thickness=3.6e-08 $X=0.702
+ $Y=0.1405 $X2=0.702 $Y2=0.153
r42 49 50 5.47996 $w=1.3e-08 $l=2.35e-08 $layer=M1 $thickness=3.6e-08 $X=0.702
+ $Y=0.117 $X2=0.702 $Y2=0.1405
r43 48 49 5.47996 $w=1.3e-08 $l=2.35e-08 $layer=M1 $thickness=3.6e-08 $X=0.702
+ $Y=0.0935 $X2=0.702 $Y2=0.117
r44 47 48 2.91487 $w=1.3e-08 $l=1.25e-08 $layer=M1 $thickness=3.6e-08 $X=0.702
+ $Y=0.081 $X2=0.702 $Y2=0.0935
r45 46 47 2.68168 $w=1.3e-08 $l=1.15e-08 $layer=M1 $thickness=3.6e-08 $X=0.702
+ $Y=0.0695 $X2=0.702 $Y2=0.081
r46 25 46 2.09871 $w=1.3e-08 $l=9e-09 $layer=M1 $thickness=3.6e-08 $X=0.702
+ $Y=0.0605 $X2=0.702 $Y2=0.0695
r47 21 45 3.83327 $w=1.5093e-08 $l=2.15e-08 $layer=M1 $thickness=3.6e-08
+ $X=0.702 $Y=0.045 $X2=0.6805 $Y2=0.045
r48 21 25 2.43413 $w=1.59032e-08 $l=1.55e-08 $layer=M1 $thickness=3.6e-08
+ $X=0.702 $Y=0.045 $X2=0.702 $Y2=0.0605
r49 21 26 3.01711 $w=1.55e-08 $l=1.8e-08 $layer=M1 $thickness=3.6e-08 $X=0.702
+ $Y=0.045 $X2=0.72 $Y2=0.045
r50 44 45 9.44419 $w=1.3e-08 $l=4.05e-08 $layer=M1 $thickness=3.6e-08 $X=0.64
+ $Y=0.045 $X2=0.6805 $Y2=0.045
r51 43 44 6.99569 $w=1.3e-08 $l=3e-08 $layer=M1 $thickness=3.6e-08 $X=0.61
+ $Y=0.045 $X2=0.64 $Y2=0.045
r52 24 43 4.19742 $w=1.3e-08 $l=1.8e-08 $layer=M1 $thickness=3.6e-08 $X=0.592
+ $Y=0.045 $X2=0.61 $Y2=0.045
r53 20 41 2.55791 $w=1.46667e-08 $l=1.35e-08 $layer=M1 $thickness=3.6e-08
+ $X=0.567 $Y=0.0495 $X2=0.567 $Y2=0.063
r54 20 24 4.19024 $w=1.40976e-08 $l=2.54018e-08 $layer=M1 $thickness=3.6e-08
+ $X=0.567 $Y=0.0495 $X2=0.592 $Y2=0.045
r55 23 39 3.14806 $w=1.3e-08 $l=1.35e-08 $layer=M1 $thickness=3.6e-08 $X=0.567
+ $Y=0.0765 $X2=0.567 $Y2=0.09
r56 23 41 3.14806 $w=1.3e-08 $l=1.35e-08 $layer=M1 $thickness=3.6e-08 $X=0.567
+ $Y=0.0765 $X2=0.567 $Y2=0.063
r57 37 38 0.590723 $w=1.53e-08 $l=1e-09 $layer=LIG $thickness=4.8e-08 $X=0.567
+ $Y=0.0995 $X2=0.567 $Y2=0.1005
r58 1 37 6.20259 $w=1.53e-08 $l=1.05e-08 $layer=LIG $thickness=4.8e-08 $X=0.567
+ $Y=0.089 $X2=0.567 $Y2=0.0995
r59 1 39 19.3796 $a=3.24e-16 $layer=V0LIG $X=0.567 $Y=0.089 $X2=0.567 $Y2=0.09
r60 35 34 24.1498 $w=2.1e-08 $l=7.1e-08 $layer=Gate_1 $thickness=5.6e-08
+ $X=0.567 $Y=0.216 $X2=0.567 $Y2=0.145
r61 33 34 18.8947 $w=2.08e-08 $l=5.5e-08 $layer=Gate_1 $thickness=5.6e-08
+ $X=0.567 $Y=0.09 $X2=0.567 $Y2=0.145
r62 33 37 4.22396 $w=1.97957e-08 $l=9.5e-09 $layer=Gate_1
+ $thickness=5.56522e-08 $X=0.567 $Y=0.09 $X2=0.567 $Y2=0.0995
r63 33 38 4.22396 $w=1.97957e-08 $l=1.05e-08 $layer=Gate_1
+ $thickness=5.56522e-08 $X=0.567 $Y=0.09 $X2=0.567 $Y2=0.1005
r64 32 33 8.18032 $w=2.05319e-08 $l=2.35e-08 $layer=Gate_1 $thickness=5.6e-08
+ $X=0.567 $Y=0.0665 $X2=0.567 $Y2=0.09
r65 31 32 8.84359 $w=2.1e-08 $l=2.6e-08 $layer=Gate_1 $thickness=5.6e-08
+ $X=0.567 $Y=0.0405 $X2=0.567 $Y2=0.0665
r66 31 14 5.44221 $w=2.1e-08 $l=1.6e-08 $layer=Gate_1 $thickness=5.6e-08
+ $X=0.567 $Y=0.0405 $X2=0.567 $Y2=0.0245
.ends

.subckt PM_DFFASRHQNx1_ASAP7_75t_R%20 vss 2 3 1
c1 1 vss 0.000493671f $X=0.918 $Y=0.054
r1 2 1 0.314815 $w=5.4e-08 $l=1.7e-08 $layer=N_src_drn $thickness=1e-09
+ $X=0.9006 $Y=0.054 $X2=0.918 $Y2=0.054
r2 3 1 0.314815 $w=5.4e-08 $l=1.7e-08 $layer=N_src_drn $thickness=1e-09
+ $X=0.9353 $Y=0.054 $X2=0.918 $Y2=0.054
.ends

.subckt PM_DFFASRHQNx1_ASAP7_75t_R%D vss 27 10 14 7 3 4 6 1 8 9 5
c1 1 vss 0.00952516f $X=0.2885 $Y=0.135
c2 3 vss 0.0907011f $X=0.297 $Y=0.0245
c3 4 vss 0.00644407f $X=0.243 $Y=0.036
c4 5 vss 0.000499575f $X=0.243 $Y=0.135
c5 6 vss 0.00707626f $X=0.243 $Y=0.234
c6 7 vss 0.00326067f $X=0.243 $Y=0.1145
c7 8 vss 0.00563021f $X=0.243 $Y=0.147
c8 9 vss 0.00104735f $X=0.2615 $Y=0.135
r1 6 29 1.96775 $w=1.63333e-08 $l=1.35e-08 $layer=M1 $thickness=3.6e-08
+ $X=0.243 $Y=0.234 $X2=0.243 $Y2=0.2205
r2 4 23 3.48349 $w=1.525e-08 $l=2e-08 $layer=M1 $thickness=3.6e-08 $X=0.243
+ $Y=0.036 $X2=0.243 $Y2=0.056
r3 28 29 4.25571 $w=1.3e-08 $l=1.83e-08 $layer=M1 $thickness=3.6e-08 $X=0.243
+ $Y=0.2022 $X2=0.243 $Y2=0.2205
r4 27 28 3.32295 $w=1.3e-08 $l=1.42e-08 $layer=M1 $thickness=3.6e-08 $X=0.244
+ $Y=0.188 $X2=0.243 $Y2=0.2022
r5 27 26 2.2736 $w=1.3e-08 $l=9.8e-09 $layer=M1 $thickness=3.6e-08 $X=0.244
+ $Y=0.188 $X2=0.243 $Y2=0.1782
r6 25 26 4.25571 $w=1.3e-08 $l=1.82e-08 $layer=M1 $thickness=3.6e-08 $X=0.243
+ $Y=0.16 $X2=0.243 $Y2=0.1782
r7 24 25 2.2153 $w=1.3e-08 $l=9.5e-09 $layer=M1 $thickness=3.6e-08 $X=0.243
+ $Y=0.1505 $X2=0.243 $Y2=0.16
r8 8 24 0.816164 $w=1.3e-08 $l=3.5e-09 $layer=M1 $thickness=3.6e-08 $X=0.243
+ $Y=0.147 $X2=0.243 $Y2=0.1505
r9 22 23 6.7625 $w=1.3e-08 $l=2.9e-08 $layer=M1 $thickness=3.6e-08 $X=0.243
+ $Y=0.085 $X2=0.243 $Y2=0.056
r10 7 22 6.8791 $w=1.3e-08 $l=2.95e-08 $layer=M1 $thickness=3.6e-08 $X=0.243
+ $Y=0.1145 $X2=0.243 $Y2=0.085
r11 5 9 3.1337 $w=1.54324e-08 $l=1.85e-08 $layer=M1 $thickness=3.6e-08 $X=0.243
+ $Y=0.135 $X2=0.2615 $Y2=0.135
r12 5 7 3.60008 $w=1.51951e-08 $l=2.05e-08 $layer=M1 $thickness=3.6e-08
+ $X=0.243 $Y=0.135 $X2=0.243 $Y2=0.1145
r13 5 8 1.61797 $w=1.675e-08 $l=1.2e-08 $layer=M1 $thickness=3.6e-08 $X=0.243
+ $Y=0.135 $X2=0.243 $Y2=0.147
r14 20 21 2.2153 $w=1.3e-08 $l=9.5e-09 $layer=M1 $thickness=3.6e-08 $X=0.2715
+ $Y=0.135 $X2=0.281 $Y2=0.135
r15 9 20 2.3319 $w=1.3e-08 $l=1e-08 $layer=M1 $thickness=3.6e-08 $X=0.2615
+ $Y=0.135 $X2=0.2715 $Y2=0.135
r16 18 21 19.3796 $a=3.24e-16 $layer=V0LIG $X=0.2795 $Y=0.135 $X2=0.281
+ $Y2=0.135
r17 1 16 2.6116 $w=2.2e-08 $l=1e-08 $layer=LIG $thickness=4.8e-08 $X=0.2885
+ $Y=0.135 $X2=0.2985 $Y2=0.135
r18 1 18 4.82216 $w=1.64167e-08 $l=9e-09 $layer=LIG $thickness=4.8e-08
+ $X=0.2885 $Y=0.135 $X2=0.2795 $Y2=0.135
r19 14 13 16.4967 $w=2.1e-08 $l=4.85e-08 $layer=Gate_1 $thickness=5.6e-08
+ $X=0.297 $Y=0.2025 $X2=0.297 $Y2=0.154
r20 12 13 6.6497 $w=2.04211e-08 $l=1.9e-08 $layer=Gate_1 $thickness=5.6e-08
+ $X=0.297 $Y=0.135 $X2=0.297 $Y2=0.154
r21 12 16 6.14846 $w=2.08718e-08 $l=1.5e-09 $layer=Gate_1
+ $thickness=5.25128e-08 $X=0.297 $Y=0.135 $X2=0.2985 $Y2=0.135
r22 11 12 6.6497 $w=2.04211e-08 $l=1.9e-08 $layer=Gate_1 $thickness=5.6e-08
+ $X=0.297 $Y=0.116 $X2=0.297 $Y2=0.135
r23 10 11 16.4967 $w=2.1e-08 $l=4.85e-08 $layer=Gate_1 $thickness=5.6e-08
+ $X=0.297 $Y=0.0675 $X2=0.297 $Y2=0.116
r24 10 3 14.6259 $w=2.1e-08 $l=4.3e-08 $layer=Gate_1 $thickness=5.6e-08
+ $X=0.297 $Y=0.0675 $X2=0.297 $Y2=0.0245
.ends

.subckt PM_DFFASRHQNx1_ASAP7_75t_R%23 vss 2 3 1
c1 1 vss 0.000920975f $X=0.324 $Y=0.2025
r1 2 1 0.209877 $w=8.1e-08 $l=1.7e-08 $layer=P_src_drn $thickness=1e-09
+ $X=0.3066 $Y=0.2025 $X2=0.324 $Y2=0.2025
r2 3 1 0.209877 $w=8.1e-08 $l=1.7e-08 $layer=P_src_drn $thickness=1e-09
+ $X=0.3413 $Y=0.2025 $X2=0.324 $Y2=0.2025
.ends

.subckt PM_DFFASRHQNx1_ASAP7_75t_R%4 vss 31 35 81 84 89 92 95 101 21 7 8 1 17
+ 16 18 23 20 19 26 22 13 14 25 2 24 3 15
c1 1 vss 0.00393889f $X=0.1335 $Y=0.135
c2 2 vss 0.000352397f $X=0.405 $Y=0.135
c3 3 vss 0.000467733f $X=0.891 $Y=0.159
c4 7 vss 0.00804929f $X=0.054 $Y=0.054
c5 8 vss 0.00805943f $X=0.054 $Y=0.216
c6 13 vss 0.0692332f $X=0.135 $Y=0.135
c7 14 vss 0.00792202f $X=0.405 $Y=0.135
c8 15 vss 0.00740666f $X=0.891 $Y=0.0245
c9 16 vss 0.0320953f $X=0.056 $Y=0.054
c10 17 vss 0.0320479f $X=0.056 $Y=0.216
c11 18 vss 0.00687985f $X=0.027 $Y=0.036
c12 19 vss 0.00135094f $X=0.0325 $Y=0.117
c13 20 vss 0.00732836f $X=0.027 $Y=0.234
c14 21 vss 0.00575803f $X=0.027 $Y=0.0575
c15 22 vss 0.00760846f $X=0.027 $Y=0.154
c16 23 vss 0.00203218f $X=0.151 $Y=0.071
c17 24 vss 0.00164094f $X=0.405 $Y=0.0695
c18 25 vss 0.00212304f $X=0.891 $Y=0.1265
c19 26 vss 0.0388636f $X=0.867 $Y=0.081
r1 101 100 0.0462963 $w=5.4e-08 $l=2.5e-09 $layer=P_src_drn $thickness=1e-09
+ $X=0.0713 $Y=0.216 $X2=0.0685 $Y2=0.216
r2 17 100 0.231482 $w=5.4e-08 $l=1.25e-08 $layer=P_src_drn $thickness=1e-09
+ $X=0.056 $Y=0.216 $X2=0.0685 $Y2=0.216
r3 8 98 19.3796 $a=3.24e-16 $layer=V0LISD $X=0.054 $Y=0.216 $X2=0.055 $Y2=0.234
r4 97 98 2.09871 $w=1.3e-08 $l=9e-09 $layer=M1 $thickness=3.6e-08 $X=0.046
+ $Y=0.234 $X2=0.055 $Y2=0.234
r5 96 97 1.28254 $w=1.3e-08 $l=5.5e-09 $layer=M1 $thickness=3.6e-08 $X=0.0405
+ $Y=0.234 $X2=0.046 $Y2=0.234
r6 20 87 3.83327 $w=1.5093e-08 $l=2.15e-08 $layer=M1 $thickness=3.6e-08
+ $X=0.027 $Y=0.234 $X2=0.027 $Y2=0.2125
r7 20 96 1.96775 $w=1.63333e-08 $l=1.35e-08 $layer=M1 $thickness=3.6e-08
+ $X=0.027 $Y=0.234 $X2=0.0405 $Y2=0.234
r8 95 94 0.0462963 $w=5.4e-08 $l=2.5e-09 $layer=N_src_drn $thickness=1e-09
+ $X=0.0713 $Y=0.054 $X2=0.0685 $Y2=0.054
r9 16 94 0.231482 $w=5.4e-08 $l=1.25e-08 $layer=N_src_drn $thickness=1e-09
+ $X=0.056 $Y=0.054 $X2=0.0685 $Y2=0.054
r10 92 91 16.4967 $w=2.1e-08 $l=4.85e-08 $layer=Gate_1 $thickness=5.6e-08
+ $X=0.135 $Y=0.216 $X2=0.135 $Y2=0.1675
r11 89 90 16.4967 $w=2.1e-08 $l=4.85e-08 $layer=Gate_1 $thickness=5.6e-08
+ $X=0.135 $Y=0.054 $X2=0.135 $Y2=0.1025
r12 13 76 3.9286 $w=2e-08 $layer=Gate_1 $thickness=5.6e-08 $X=0.135 $Y=0.135
+ $X2=0.135 $Y2=0.135
r13 13 90 11.2416 $w=2.06615e-08 $l=3.25e-08 $layer=Gate_1 $thickness=5.6e-08
+ $X=0.135 $Y=0.135 $X2=0.135 $Y2=0.1025
r14 13 91 11.2416 $w=2.06615e-08 $l=3.25e-08 $layer=Gate_1 $thickness=5.6e-08
+ $X=0.135 $Y=0.135 $X2=0.135 $Y2=0.1675
r15 86 87 5.01358 $w=1.3e-08 $l=2.15e-08 $layer=M1 $thickness=3.6e-08 $X=0.027
+ $Y=0.191 $X2=0.027 $Y2=0.2125
r16 22 86 8.62802 $w=1.3e-08 $l=3.7e-08 $layer=M1 $thickness=3.6e-08 $X=0.027
+ $Y=0.154 $X2=0.027 $Y2=0.191
r17 7 73 19.3796 $a=3.24e-16 $layer=V0LISD $X=0.054 $Y=0.054 $X2=0.055 $Y2=0.036
r18 84 83 16.4967 $w=2.1e-08 $l=4.85e-08 $layer=Gate_1 $thickness=5.6e-08
+ $X=0.405 $Y=0.216 $X2=0.405 $Y2=0.1675
r19 81 82 16.4967 $w=2.1e-08 $l=4.85e-08 $layer=Gate_1 $thickness=5.6e-08
+ $X=0.405 $Y=0.0675 $X2=0.405 $Y2=0.116
r20 14 82 6.6497 $w=2.04211e-08 $l=1.9e-08 $layer=Gate_1 $thickness=5.6e-08
+ $X=0.405 $Y=0.135 $X2=0.405 $Y2=0.116
r21 14 83 11.2416 $w=2.06615e-08 $l=3.25e-08 $layer=Gate_1 $thickness=5.6e-08
+ $X=0.405 $Y=0.135 $X2=0.405 $Y2=0.1675
r22 75 78 4.82216 $w=1.64167e-08 $l=9e-09 $layer=LIG $thickness=4.8e-08
+ $X=0.1435 $Y=0.135 $X2=0.1525 $Y2=0.135
r23 1 75 2.6116 $w=2.2e-08 $l=1e-08 $layer=LIG $thickness=4.8e-08 $X=0.1335
+ $Y=0.135 $X2=0.1435 $Y2=0.135
r24 1 76 2.21986 $w=2.2e-08 $l=1.5e-09 $layer=LIG $thickness=4.8e-08 $X=0.1335
+ $Y=0.135 $X2=0.135 $Y2=0.135
r25 19 64 2.68321 $w=1.85e-08 $l=1.88215e-08 $layer=M1 $thickness=3.6e-08
+ $X=0.0325 $Y=0.117 $X2=0.027 $Y2=0.099
r26 19 22 7.11381 $w=1.56757e-08 $l=3.74065e-08 $layer=M1 $thickness=3.6e-08
+ $X=0.0325 $Y=0.117 $X2=0.027 $Y2=0.154
r27 72 73 2.09871 $w=1.3e-08 $l=9e-09 $layer=M1 $thickness=3.6e-08 $X=0.046
+ $Y=0.036 $X2=0.055 $Y2=0.036
r28 71 72 1.28254 $w=1.3e-08 $l=5.5e-09 $layer=M1 $thickness=3.6e-08 $X=0.0405
+ $Y=0.036 $X2=0.046 $Y2=0.036
r29 18 21 3.83327 $w=1.5093e-08 $l=2.15e-08 $layer=M1 $thickness=3.6e-08
+ $X=0.027 $Y=0.036 $X2=0.027 $Y2=0.0575
r30 18 71 1.96775 $w=1.63333e-08 $l=1.35e-08 $layer=M1 $thickness=3.6e-08
+ $X=0.027 $Y=0.036 $X2=0.0405 $Y2=0.036
r31 2 60 19.3796 $a=3.24e-16 $layer=V0LIG $X=0.405 $Y=0.135 $X2=0.405 $Y2=0.135
r32 2 14 6.54019 $w=2.09524e-08 $layer=Gate_1 $thickness=5.21905e-08 $X=0.405
+ $Y=0.135 $X2=0.405 $Y2=0.135
r33 67 78 19.3796 $a=3.24e-16 $layer=V0LIG $X=0.151 $Y=0.135 $X2=0.1525
+ $Y2=0.135
r34 66 67 6.29612 $w=1.3e-08 $l=2.7e-08 $layer=M1 $thickness=3.6e-08 $X=0.151
+ $Y=0.108 $X2=0.151 $Y2=0.135
r35 65 66 6.29612 $w=1.3e-08 $l=2.7e-08 $layer=M1 $thickness=3.6e-08 $X=0.151
+ $Y=0.081 $X2=0.151 $Y2=0.108
r36 23 65 2.3319 $w=1.3e-08 $l=1e-08 $layer=M1 $thickness=3.6e-08 $X=0.151
+ $Y=0.071 $X2=0.151 $Y2=0.081
r37 63 64 4.19742 $w=1.3e-08 $l=1.8e-08 $layer=M1 $thickness=3.6e-08 $X=0.027
+ $Y=0.081 $X2=0.027 $Y2=0.099
r38 62 63 2.3319 $w=1.3e-08 $l=1e-08 $layer=M1 $thickness=3.6e-08 $X=0.027
+ $Y=0.071 $X2=0.027 $Y2=0.081
r39 21 62 3.14806 $w=1.3e-08 $l=1.35e-08 $layer=M1 $thickness=3.6e-08 $X=0.027
+ $Y=0.0575 $X2=0.027 $Y2=0.071
r40 59 60 4.78039 $w=1.3e-08 $l=2.05e-08 $layer=M1 $thickness=3.6e-08 $X=0.405
+ $Y=0.1145 $X2=0.405 $Y2=0.135
r41 58 59 4.19742 $w=1.3e-08 $l=1.8e-08 $layer=M1 $thickness=3.6e-08 $X=0.405
+ $Y=0.0965 $X2=0.405 $Y2=0.1145
r42 57 58 3.61444 $w=1.3e-08 $l=1.55e-08 $layer=M1 $thickness=3.6e-08 $X=0.405
+ $Y=0.081 $X2=0.405 $Y2=0.0965
r43 24 57 2.68168 $w=1.3e-08 $l=1.15e-08 $layer=M1 $thickness=3.6e-08 $X=0.405
+ $Y=0.0695 $X2=0.405 $Y2=0.081
r44 54 55 3.84763 $w=1.3e-08 $l=1.65e-08 $layer=M2 $thickness=3.6e-08 $X=0.151
+ $Y=0.081 $X2=0.1675 $Y2=0.081
r45 54 65 19.5347 $a=3.24e-16 $layer=V1 $X=0.151 $Y=0.081 $X2=0.151 $Y2=0.081
r46 53 54 14.4578 $w=1.3e-08 $l=6.2e-08 $layer=M2 $thickness=3.6e-08 $X=0.089
+ $Y=0.081 $X2=0.151 $Y2=0.081
r47 52 53 14.4578 $w=1.3e-08 $l=6.2e-08 $layer=M2 $thickness=3.6e-08 $X=0.027
+ $Y=0.081 $X2=0.089 $Y2=0.081
r48 52 63 19.5347 $a=3.24e-16 $layer=V1 $X=0.027 $Y=0.081 $X2=0.027 $Y2=0.081
r49 50 51 40.2252 $w=1.3e-08 $l=1.725e-07 $layer=M2 $thickness=3.6e-08 $X=0.405
+ $Y=0.081 $X2=0.5775 $Y2=0.081
r50 50 57 19.5347 $a=3.24e-16 $layer=V1 $X=0.405 $Y=0.081 $X2=0.405 $Y2=0.081
r51 49 50 27.8662 $w=1.3e-08 $l=1.195e-07 $layer=M2 $thickness=3.6e-08
+ $X=0.2855 $Y=0.081 $X2=0.405 $Y2=0.081
r52 49 55 27.5164 $w=1.3e-08 $l=1.18e-07 $layer=M2 $thickness=3.6e-08 $X=0.2855
+ $Y=0.081 $X2=0.1675 $Y2=0.081
r53 48 51 51.0686 $w=1.3e-08 $l=2.19e-07 $layer=M2 $thickness=3.6e-08 $X=0.7965
+ $Y=0.081 $X2=0.5775 $Y2=0.081
r54 26 46 5.59655 $w=1.3e-08 $l=2.4e-08 $layer=M2 $thickness=3.6e-08 $X=0.867
+ $Y=0.081 $X2=0.891 $Y2=0.081
r55 26 48 16.4399 $w=1.3e-08 $l=7.05e-08 $layer=M2 $thickness=3.6e-08 $X=0.867
+ $Y=0.081 $X2=0.7965 $Y2=0.081
r56 43 44 2.91487 $w=1.3e-08 $l=1.25e-08 $layer=M1 $thickness=3.6e-08 $X=0.891
+ $Y=0.081 $X2=0.891 $Y2=0.0935
r57 43 46 19.5347 $a=3.24e-16 $layer=V1 $X=0.891 $Y=0.081 $X2=0.891 $Y2=0.081
r58 41 44 1.51573 $w=1.3e-08 $l=6.5e-09 $layer=M1 $thickness=3.6e-08 $X=0.891
+ $Y=0.1 $X2=0.891 $Y2=0.0935
r59 25 39 7.57867 $w=1.3e-08 $l=3.25e-08 $layer=M1 $thickness=3.6e-08 $X=0.891
+ $Y=0.1265 $X2=0.891 $Y2=0.159
r60 25 41 6.17953 $w=1.3e-08 $l=2.65e-08 $layer=M1 $thickness=3.6e-08 $X=0.891
+ $Y=0.1265 $X2=0.891 $Y2=0.1
r61 3 33 6.54019 $w=2.09524e-08 $layer=Gate_1 $thickness=5.21905e-08 $X=0.891
+ $Y=0.159 $X2=0.891 $Y2=0.159
r62 3 39 19.3796 $a=3.24e-16 $layer=V0LIG $X=0.891 $Y=0.159 $X2=0.891 $Y2=0.159
r63 35 34 12.415 $w=2.1e-08 $l=3.65e-08 $layer=Gate_1 $thickness=5.6e-08
+ $X=0.891 $Y=0.2295 $X2=0.891 $Y2=0.193
r64 33 34 11.7518 $w=2.06765e-08 $l=3.4e-08 $layer=Gate_1 $thickness=5.6e-08
+ $X=0.891 $Y=0.159 $X2=0.891 $Y2=0.193
r65 32 33 15.3232 $w=2.07528e-08 $l=4.45e-08 $layer=Gate_1 $thickness=5.6e-08
+ $X=0.891 $Y=0.1145 $X2=0.891 $Y2=0.159
r66 31 32 20.5784 $w=2.1e-08 $l=6.05e-08 $layer=Gate_1 $thickness=5.6e-08
+ $X=0.891 $Y=0.054 $X2=0.891 $Y2=0.1145
r67 31 15 10.0341 $w=2.1e-08 $l=2.95e-08 $layer=Gate_1 $thickness=5.6e-08
+ $X=0.891 $Y=0.054 $X2=0.891 $Y2=0.0245
r68 8 17 1e-05 $l=2e-09 $X=0.054 $Y=0.216 $X2=0.056 $Y2=0.216
r69 7 16 1e-05 $l=2e-09 $X=0.054 $Y=0.054 $X2=0.056 $Y2=0.054
.ends

.subckt PM_DFFASRHQNx1_ASAP7_75t_R%SETN vss 58 14 18 44 51 54 5 12 11 8 2 10 7
+ 9 3 1
c1 1 vss 0.0035904f $X=0.6755 $Y=0.111
c2 2 vss 0.00460135f $X=0.783 $Y=0.111
c3 3 vss 0.00358893f $X=0.999 $Y=0.111
c4 5 vss 0.00824727f $X=0.9735 $Y=0.111
c5 7 vss 0.0650676f $X=0.675 $Y=0.111
c6 8 vss 0.0355988f $X=0.783 $Y=0.111
c7 9 vss 0.0611949f $X=0.999 $Y=0.0245
c8 10 vss 0.00500769f $X=0.776 $Y=0.189
c9 11 vss 0.00285644f $X=0.783 $Y=0.0995
c10 12 vss 0.00365685f $X=0.7855 $Y=0.189
r1 58 57 4.37231 $w=1.3e-08 $l=1.88e-08 $layer=M2 $thickness=3.6e-08 $X=0.843
+ $Y=0.189 $X2=0.8242 $Y2=0.189
r2 56 57 6.35442 $w=1.3e-08 $l=2.72e-08 $layer=M2 $thickness=3.6e-08 $X=0.797
+ $Y=0.189 $X2=0.8242 $Y2=0.189
r3 12 56 2.68168 $w=1.3e-08 $l=1.15e-08 $layer=M2 $thickness=3.6e-08 $X=0.7855
+ $Y=0.189 $X2=0.797 $Y2=0.189
r4 54 53 20.4083 $w=2.1e-08 $l=6e-08 $layer=Gate_1 $thickness=5.6e-08 $X=0.675
+ $Y=0.2295 $X2=0.675 $Y2=0.1695
r5 51 52 12.245 $w=2.1e-08 $l=3.6e-08 $layer=Gate_1 $thickness=5.6e-08 $X=0.675
+ $Y=0.054 $X2=0.675 $Y2=0.09
r6 7 52 7.34698 $w=2.04286e-08 $l=2.1e-08 $layer=Gate_1 $thickness=5.6e-08
+ $X=0.675 $Y=0.111 $X2=0.675 $Y2=0.09
r7 7 53 20.1022 $w=2.07949e-08 $l=5.85e-08 $layer=Gate_1 $thickness=5.6e-08
+ $X=0.675 $Y=0.111 $X2=0.675 $Y2=0.1695
r8 48 56 19.5347 $a=3.24e-16 $layer=V1 $X=0.799 $Y=0.189 $X2=0.797 $Y2=0.189
r9 47 48 1.83642 $w=1.41111e-08 $l=9e-09 $layer=M1 $thickness=3.6e-08 $X=0.79
+ $Y=0.189 $X2=0.799 $Y2=0.189
r10 46 47 0.714311 $w=1.8e-08 $l=7e-09 $layer=M1 $thickness=3.6e-08 $X=0.783
+ $Y=0.189 $X2=0.79 $Y2=0.189
r11 10 39 1.02025 $w=1.48182e-08 $l=1.43265e-08 $layer=M1 $thickness=3.6e-08
+ $X=0.776 $Y=0.189 $X2=0.783 $Y2=0.1765
r12 10 46 0.714311 $w=1.8e-08 $l=7e-09 $layer=M1 $thickness=3.6e-08 $X=0.776
+ $Y=0.189 $X2=0.783 $Y2=0.189
r13 44 43 20.4083 $w=2.1e-08 $l=6e-08 $layer=Gate_1 $thickness=5.6e-08 $X=0.783
+ $Y=0.216 $X2=0.783 $Y2=0.156
r14 8 43 15.5103 $w=2.07333e-08 $l=4.5e-08 $layer=Gate_1 $thickness=5.6e-08
+ $X=0.783 $Y=0.111 $X2=0.783 $Y2=0.156
r15 1 33 2.60296 $w=2.3e-08 $layer=LIG $thickness=4.8e-08 $X=0.6755 $Y=0.111
+ $X2=0.6755 $Y2=0.111
r16 1 7 6.8887 $w=2.14348e-08 $l=5e-10 $layer=Gate_1 $thickness=5.21739e-08
+ $X=0.6755 $Y=0.111 $X2=0.675 $Y2=0.111
r17 38 39 1.04935 $w=1.3e-08 $l=4.5e-09 $layer=M1 $thickness=3.6e-08 $X=0.783
+ $Y=0.172 $X2=0.783 $Y2=0.1765
r18 37 38 4.19742 $w=1.3e-08 $l=1.8e-08 $layer=M1 $thickness=3.6e-08 $X=0.783
+ $Y=0.154 $X2=0.783 $Y2=0.172
r19 36 37 5.94634 $w=1.3e-08 $l=2.55e-08 $layer=M1 $thickness=3.6e-08 $X=0.783
+ $Y=0.1285 $X2=0.783 $Y2=0.154
r20 35 36 3.96423 $w=1.3e-08 $l=1.7e-08 $layer=M1 $thickness=3.6e-08 $X=0.783
+ $Y=0.1115 $X2=0.783 $Y2=0.1285
r21 34 35 2.09871 $w=1.3e-08 $l=9e-09 $layer=M1 $thickness=3.6e-08 $X=0.783
+ $Y=0.1025 $X2=0.783 $Y2=0.1115
r22 11 34 0.699569 $w=1.3e-08 $l=3e-09 $layer=M1 $thickness=3.6e-08 $X=0.783
+ $Y=0.0995 $X2=0.783 $Y2=0.1025
r23 2 27 8.43855 $w=2.12286e-08 $layer=LISD $thickness=3.9e-08 $X=0.783
+ $Y=0.111 $X2=0.783 $Y2=0.111
r24 2 35 19.3796 $a=3.24e-16 $layer=V0LIG $X=0.783 $Y=0.111 $X2=0.783 $Y2=0.1115
r25 2 8 7.41966 $w=2.1e-08 $layer=Gate_1 $thickness=5.2e-08 $X=0.783 $Y=0.111
+ $X2=0.783 $Y2=0.111
r26 32 33 7.66224 $w=2.02e-08 $l=1.5e-09 $layer=LISD $thickness=2.7e-08
+ $X=0.677 $Y=0.111 $X2=0.6755 $Y2=0.111
r27 31 32 14.7351 $w=2.02e-08 $l=2.5e-08 $layer=LISD $thickness=2.7e-08
+ $X=0.702 $Y=0.111 $X2=0.677 $Y2=0.111
r28 30 31 15.9139 $w=2.02e-08 $l=2.7e-08 $layer=LISD $thickness=2.7e-08
+ $X=0.729 $Y=0.111 $X2=0.702 $Y2=0.111
r29 29 30 15.9139 $w=2.02e-08 $l=2.7e-08 $layer=LISD $thickness=2.7e-08
+ $X=0.756 $Y=0.111 $X2=0.729 $Y2=0.111
r30 27 28 7.07284 $w=2.02e-08 $l=1.2e-08 $layer=LISD $thickness=2.7e-08
+ $X=0.783 $Y=0.111 $X2=0.795 $Y2=0.111
r31 27 35 19.3796 $a=3.24e-16 $layer=V0LISD $X=0.783 $Y=0.111 $X2=0.783
+ $Y2=0.1115
r32 26 27 7.07284 $w=2.02e-08 $l=1.2e-08 $layer=LISD $thickness=2.7e-08
+ $X=0.771 $Y=0.111 $X2=0.783 $Y2=0.111
r33 26 29 8.84105 $w=2.02e-08 $l=1.5e-08 $layer=LISD $thickness=2.7e-08
+ $X=0.771 $Y=0.111 $X2=0.756 $Y2=0.111
r34 25 28 8.84105 $w=2.02e-08 $l=1.5e-08 $layer=LISD $thickness=2.7e-08 $X=0.81
+ $Y=0.111 $X2=0.795 $Y2=0.111
r35 24 25 15.9139 $w=2.02e-08 $l=2.7e-08 $layer=LISD $thickness=2.7e-08
+ $X=0.837 $Y=0.111 $X2=0.81 $Y2=0.111
r36 23 24 15.9139 $w=2.02e-08 $l=2.7e-08 $layer=LISD $thickness=2.7e-08
+ $X=0.864 $Y=0.111 $X2=0.837 $Y2=0.111
r37 22 23 15.9139 $w=2.02e-08 $l=2.7e-08 $layer=LISD $thickness=2.7e-08
+ $X=0.891 $Y=0.111 $X2=0.864 $Y2=0.111
r38 21 22 17.0927 $w=2.02e-08 $l=2.9e-08 $layer=LISD $thickness=2.7e-08 $X=0.92
+ $Y=0.111 $X2=0.891 $Y2=0.111
r39 20 21 9.13575 $w=2.02e-08 $l=1.55e-08 $layer=LISD $thickness=2.7e-08
+ $X=0.9355 $Y=0.111 $X2=0.92 $Y2=0.111
r40 5 20 22.3973 $w=2.02e-08 $l=3.8e-08 $layer=LISD $thickness=2.7e-08
+ $X=0.9735 $Y=0.111 $X2=0.9355 $Y2=0.111
r41 3 16 7.41966 $w=2.1e-08 $layer=Gate_1 $thickness=5.2e-08 $X=0.999 $Y=0.111
+ $X2=0.999 $Y2=0.111
r42 3 5 24.6471 $w=2.06454e-08 $l=2.55e-08 $layer=LISD $thickness=3.21959e-08
+ $X=0.999 $Y=0.111 $X2=0.9735 $Y2=0.111
r43 18 17 20.4083 $w=2.1e-08 $l=6e-08 $layer=Gate_1 $thickness=5.6e-08 $X=0.999
+ $Y=0.2295 $X2=0.999 $Y2=0.1695
r44 16 17 20.1022 $w=2.07949e-08 $l=5.85e-08 $layer=Gate_1 $thickness=5.6e-08
+ $X=0.999 $Y=0.111 $X2=0.999 $Y2=0.1695
r45 15 16 7.34698 $w=2.04286e-08 $l=2.1e-08 $layer=Gate_1 $thickness=5.6e-08
+ $X=0.999 $Y=0.09 $X2=0.999 $Y2=0.111
r46 14 15 12.245 $w=2.1e-08 $l=3.6e-08 $layer=Gate_1 $thickness=5.6e-08
+ $X=0.999 $Y=0.054 $X2=0.999 $Y2=0.09
r47 14 9 10.0341 $w=2.1e-08 $l=2.95e-08 $layer=Gate_1 $thickness=5.6e-08
+ $X=0.999 $Y=0.054 $X2=0.999 $Y2=0.0245
.ends

.subckt PM_DFFASRHQNx1_ASAP7_75t_R%21 vss 2 3 1
c1 1 vss 0.000657582f $X=0.972 $Y=0.054
r1 2 1 0.314815 $w=5.4e-08 $l=1.7e-08 $layer=N_src_drn $thickness=1e-09
+ $X=0.9546 $Y=0.054 $X2=0.972 $Y2=0.054
r2 3 1 0.314815 $w=5.4e-08 $l=1.7e-08 $layer=N_src_drn $thickness=1e-09
+ $X=0.9893 $Y=0.054 $X2=0.972 $Y2=0.054
.ends

.subckt PM_DFFASRHQNx1_ASAP7_75t_R%12 vss 17 32 33 40 44 1 7 13 9 8 3 16 15 6
+ 10 4 14
c1 1 vss 6.06102e-20 $X=0.9455 $Y=0.171
c2 2 vss 0.000950067f $X=1.1605 $Y=0.07
c3 3 vss 0.000183762f $X=1.08 $Y=0.174
c4 4 vss 0.00425572f $X=1.134 $Y=0.069
c5 5 vss 0.00170529f $X=1.159 $Y=0.069
c6 6 vss 0.00148697f $X=1.159 $Y=0.174
c7 7 vss 0.00263266f $X=0.959 $Y=0.174
c8 8 vss 0.00516608f $X=1.08 $Y=0.1875
c9 9 vss 0.00136582f $X=1.107 $Y=0.174
c10 10 vss 0.00303233f $X=1.159 $Y=0.1425
c11 13 vss 0.00654475f $X=0.945 $Y=0.0245
c12 14 vss 0.0362395f $X=1.161 $Y=0.07
c13 15 vss 0.00291805f $X=1.1195 $Y=0.054
c14 16 vss 0.00315643f $X=1.0655 $Y=0.2295
r1 15 42 0.231482 $w=5.4e-08 $l=1.25e-08 $layer=N_src_drn $thickness=1e-09
+ $X=1.1195 $Y=0.054 $X2=1.134 $Y2=0.042
r2 44 15 0.0462963 $w=5.4e-08 $l=2.5e-09 $layer=N_src_drn $thickness=1e-09
+ $X=1.1166 $Y=0.054 $X2=1.1195 $Y2=0.054
r3 4 5 10.7315 $w=2.5e-08 $l=2.5e-08 $layer=LISD $thickness=2.7e-08 $X=1.134
+ $Y=0.069 $X2=1.159 $Y2=0.069
r4 4 42 14.1645 $w=2.18889e-08 $l=2.7e-08 $layer=LISD $thickness=2.7e-08
+ $X=1.134 $Y=0.069 $X2=1.134 $Y2=0.042
r5 40 39 27.5512 $w=2.1e-08 $l=8.1e-08 $layer=Gate_1 $thickness=5.6e-08
+ $X=1.161 $Y=0.2295 $X2=1.161 $Y2=0.1485
r6 14 39 26.8879 $w=2.08599e-08 $l=7.85e-08 $layer=Gate_1 $thickness=5.6e-08
+ $X=1.161 $Y=0.07 $X2=1.161 $Y2=0.1485
r7 5 36 9.16613 $w=2.44455e-08 $l=2.1e-08 $layer=LISD $thickness=2.7e-08
+ $X=1.159 $Y=0.069 $X2=1.159 $Y2=0.09
r8 2 37 2.60296 $w=2.3e-08 $l=1.1e-08 $layer=LIG $thickness=4.8e-08 $X=1.1605
+ $Y=0.07 $X2=1.1605 $Y2=0.081
r9 2 5 8.01102 $w=2.45652e-08 $l=1.80278e-09 $layer=LISD $thickness=3.70435e-08
+ $X=1.1605 $Y=0.07 $X2=1.159 $Y2=0.069
r10 2 14 6.53156 $w=2.15e-08 $l=5e-10 $layer=Gate_1 $thickness=5.2e-08
+ $X=1.1605 $Y=0.07 $X2=1.161 $Y2=0.07
r11 36 37 4.55807 $w=2.22e-08 $l=9.12414e-09 $layer=LISD $thickness=2.7e-08
+ $X=1.159 $Y=0.09 $X2=1.1605 $Y2=0.081
r12 35 36 6.83711 $w=2.22e-08 $l=1.35e-08 $layer=LISD $thickness=2.7e-08
+ $X=1.159 $Y=0.1035 $X2=1.159 $Y2=0.09
r13 34 35 6.07743 $w=2.22e-08 $l=1.2e-08 $layer=LISD $thickness=2.7e-08
+ $X=1.159 $Y=0.1155 $X2=1.159 $Y2=0.1035
r14 10 34 13.6742 $w=2.22e-08 $l=2.7e-08 $layer=LISD $thickness=2.7e-08
+ $X=1.159 $Y=0.1425 $X2=1.159 $Y2=0.1155
r15 6 29 9.60184 $w=2.6128e-08 $l=2.5e-08 $layer=LISD $thickness=2.7e-08
+ $X=1.159 $Y=0.174 $X2=1.134 $Y2=0.174
r16 6 10 12.4048 $w=2.36476e-08 $l=3.15e-08 $layer=LISD $thickness=2.7e-08
+ $X=1.159 $Y=0.174 $X2=1.159 $Y2=0.1425
r17 33 31 0.0925926 $w=2.7e-08 $l=2.5e-09 $layer=P_src_drn $thickness=1e-09
+ $X=1.0973 $Y=0.2295 $X2=1.0945 $Y2=0.2295
r18 28 31 0.537037 $w=2.7e-08 $l=1.45e-08 $layer=P_src_drn $thickness=1e-09
+ $X=1.08 $Y=0.2295 $X2=1.0945 $Y2=0.2295
r19 16 28 0.537037 $w=2.7e-08 $l=1.45e-08 $layer=P_src_drn $thickness=1e-09
+ $X=1.0655 $Y=0.2295 $X2=1.08 $Y2=0.2295
r20 32 16 0.0925926 $w=2.7e-08 $l=2.5e-09 $layer=P_src_drn $thickness=1e-09
+ $X=1.0626 $Y=0.2295 $X2=1.0655 $Y2=0.2295
r21 9 29 15.9139 $w=2.02e-08 $l=2.7e-08 $layer=LISD $thickness=2.7e-08 $X=1.107
+ $Y=0.174 $X2=1.134 $Y2=0.174
r22 27 28 15.9139 $w=2.02e-08 $l=2.7e-08 $layer=LISD $thickness=2.7e-08 $X=1.08
+ $Y=0.2025 $X2=1.08 $Y2=0.2295
r23 8 27 8.84105 $w=2.02e-08 $l=1.5e-08 $layer=LISD $thickness=2.7e-08 $X=1.08
+ $Y=0.1875 $X2=1.08 $Y2=0.2025
r24 3 26 14.1645 $w=2.18889e-08 $l=2.7e-08 $layer=LISD $thickness=2.7e-08
+ $X=1.08 $Y=0.174 $X2=1.053 $Y2=0.174
r25 3 8 6.20751 $w=2.35778e-08 $l=1.35e-08 $layer=LISD $thickness=2.7e-08
+ $X=1.08 $Y=0.174 $X2=1.08 $Y2=0.1875
r26 3 9 14.1645 $w=2.18889e-08 $l=2.7e-08 $layer=LISD $thickness=2.7e-08
+ $X=1.08 $Y=0.174 $X2=1.107 $Y2=0.174
r27 25 26 15.9139 $w=2.02e-08 $l=2.7e-08 $layer=LISD $thickness=2.7e-08
+ $X=1.026 $Y=0.174 $X2=1.053 $Y2=0.174
r28 24 25 8.25165 $w=2.02e-08 $l=1.4e-08 $layer=LISD $thickness=2.7e-08
+ $X=1.012 $Y=0.174 $X2=1.026 $Y2=0.174
r29 23 24 8.84105 $w=2.02e-08 $l=1.5e-08 $layer=LISD $thickness=2.7e-08
+ $X=0.997 $Y=0.174 $X2=1.012 $Y2=0.174
r30 7 23 22.3973 $w=2.02e-08 $l=3.8e-08 $layer=LISD $thickness=2.7e-08 $X=0.959
+ $Y=0.174 $X2=0.997 $Y2=0.174
r31 1 19 4.52237 $w=2.02308e-08 $l=3.04138e-09 $layer=Gate_1
+ $thickness=5.53846e-08 $X=0.9455 $Y=0.171 $X2=0.945 $Y2=0.174
r32 1 21 1.18316 $w=2.3e-08 $l=5e-09 $layer=LIG $thickness=4.8e-08 $X=0.9455
+ $Y=0.171 $X2=0.9455 $Y2=0.166
r33 1 22 1.89306 $w=2.3e-08 $l=8e-09 $layer=LIG $thickness=4.8e-08 $X=0.9455
+ $Y=0.171 $X2=0.9455 $Y2=0.179
r34 1 7 14.9717 $w=2.03077e-08 $l=1.38293e-08 $layer=LISD
+ $thickness=2.78077e-08 $X=0.9455 $Y=0.171 $X2=0.959 $Y2=0.174
r35 19 21 5.23227 $w=2.075e-08 $l=8.01561e-09 $layer=Gate_1 $thickness=5.4e-08
+ $X=0.945 $Y=0.174 $X2=0.9455 $Y2=0.166
r36 19 22 5.94217 $w=2.11053e-08 $l=5.02494e-09 $layer=Gate_1
+ $thickness=5.30526e-08 $X=0.945 $Y=0.174 $X2=0.9455 $Y2=0.179
r37 18 19 18.0613 $w=2.07714e-08 $l=5.25e-08 $layer=Gate_1 $thickness=5.6e-08
+ $X=0.945 $Y=0.1215 $X2=0.945 $Y2=0.174
r38 17 18 22.9593 $w=2.1e-08 $l=6.75e-08 $layer=Gate_1 $thickness=5.6e-08
+ $X=0.945 $Y=0.054 $X2=0.945 $Y2=0.1215
r39 17 13 10.0341 $w=2.1e-08 $l=2.95e-08 $layer=Gate_1 $thickness=5.6e-08
+ $X=0.945 $Y=0.054 $X2=0.945 $Y2=0.0245
.ends

.subckt PM_DFFASRHQNx1_ASAP7_75t_R%6 vss 32 74 78 81 84 86 7 20 8 21 18 25 19 1
+ 16 17 23 22 24 3 2 14 13 15
c1 1 vss 0.000879242f $X=0.351 $Y=0.135
c2 2 vss 0.0015011f $X=0.459 $Y=0.135
c3 3 vss 0.000812693f $X=0.837 $Y=0.159
c4 7 vss 0.00738977f $X=0.162 $Y=0.054
c5 8 vss 0.00748852f $X=0.162 $Y=0.216
c6 13 vss 0.00756315f $X=0.351 $Y=0.073
c7 14 vss 0.0243768f $X=0.459 $Y=0.135
c8 15 vss 0.00906127f $X=0.837 $Y=0.159
c9 16 vss 0.0356823f $X=0.1475 $Y=0.054
c10 17 vss 0.0358178f $X=0.1475 $Y=0.216
c11 18 vss 0.0061594f $X=0.189 $Y=0.234
c12 19 vss 0.0028589f $X=0.189 $Y=0.036
c13 20 vss 0.00395226f $X=0.1655 $Y=0.036
c14 21 vss 0.00498705f $X=0.189 $Y=0.089
c15 22 vss 0.00107858f $X=0.351 $Y=0.135
c16 23 vss 0.00103676f $X=0.459 $Y=0.1055
c17 24 vss 0.000875256f $X=0.838 $Y=0.1055
c18 25 vss 0.0307163f $X=0.1775 $Y=0.117
r1 16 7 0.231482 $w=5.4e-08 $l=1.25e-08 $layer=N_src_drn $thickness=1e-09
+ $X=0.1475 $Y=0.054 $X2=0.162 $Y2=0.054
r2 86 16 0.0462963 $w=5.4e-08 $l=2.5e-09 $layer=N_src_drn $thickness=1e-09
+ $X=0.1446 $Y=0.054 $X2=0.1475 $Y2=0.054
r3 17 8 0.231482 $w=5.4e-08 $l=1.25e-08 $layer=P_src_drn $thickness=1e-09
+ $X=0.1475 $Y=0.216 $X2=0.162 $Y2=0.216
r4 84 17 0.0462963 $w=5.4e-08 $l=2.5e-09 $layer=P_src_drn $thickness=1e-09
+ $X=0.1446 $Y=0.216 $X2=0.1475 $Y2=0.216
r5 7 20 19.3796 $a=3.24e-16 $layer=V0LISD $X=0.162 $Y=0.054 $X2=0.1655 $Y2=0.036
r6 81 80 12.415 $w=2.1e-08 $l=3.65e-08 $layer=Gate_1 $thickness=5.6e-08
+ $X=0.837 $Y=0.216 $X2=0.837 $Y2=0.1795
r7 78 79 20.5784 $w=2.1e-08 $l=6.05e-08 $layer=Gate_1 $thickness=5.6e-08
+ $X=0.837 $Y=0.0405 $X2=0.837 $Y2=0.101
r8 15 79 19.9151 $w=2.08103e-08 $l=5.8e-08 $layer=Gate_1 $thickness=5.6e-08
+ $X=0.837 $Y=0.159 $X2=0.837 $Y2=0.101
r9 15 80 7.15991 $w=2.04634e-08 $l=2.05e-08 $layer=Gate_1 $thickness=5.6e-08
+ $X=0.837 $Y=0.159 $X2=0.837 $Y2=0.1795
r10 74 75 16.4967 $w=2.1e-08 $l=4.85e-08 $layer=Gate_1 $thickness=5.6e-08
+ $X=0.459 $Y=0.0405 $X2=0.459 $Y2=0.089
r11 14 75 15.8334 $w=2.07609e-08 $l=4.6e-08 $layer=Gate_1 $thickness=5.6e-08
+ $X=0.459 $Y=0.135 $X2=0.459 $Y2=0.089
r12 8 62 19.3796 $a=3.24e-16 $layer=V0LISD $X=0.162 $Y=0.216 $X2=0.1655
+ $Y2=0.234
r13 20 70 2.3319 $w=1.3e-08 $l=1e-08 $layer=M1 $thickness=3.6e-08 $X=0.1655
+ $Y=0.036 $X2=0.1755 $Y2=0.036
r14 3 60 19.3796 $a=3.24e-16 $layer=V0LIG $X=0.837 $Y=0.159 $X2=0.838 $Y2=0.157
r15 3 15 6.54019 $w=2.09524e-08 $layer=Gate_1 $thickness=5.21905e-08 $X=0.837
+ $Y=0.159 $X2=0.837 $Y2=0.159
r16 2 55 19.3796 $a=3.24e-16 $layer=V0LIG $X=0.459 $Y=0.135 $X2=0.459 $Y2=0.126
r17 2 14 6.54019 $w=2.09524e-08 $layer=Gate_1 $thickness=5.21905e-08 $X=0.459
+ $Y=0.135 $X2=0.459 $Y2=0.135
r18 62 63 2.3319 $w=1.3e-08 $l=1e-08 $layer=M1 $thickness=3.6e-08 $X=0.1655
+ $Y=0.234 $X2=0.1755 $Y2=0.234
r19 18 54 3.83327 $w=1.5093e-08 $l=2.15e-08 $layer=M1 $thickness=3.6e-08
+ $X=0.189 $Y=0.234 $X2=0.189 $Y2=0.2125
r20 18 63 1.96775 $w=1.63333e-08 $l=1.35e-08 $layer=M1 $thickness=3.6e-08
+ $X=0.189 $Y=0.234 $X2=0.1755 $Y2=0.234
r21 19 51 3.36447 $w=1.71023e-08 $l=2.15e-08 $layer=M1 $thickness=3.6e-08
+ $X=0.189 $Y=0.036 $X2=0.189 $Y2=0.0575
r22 19 70 1.49895 $w=1.63333e-08 $l=1.35e-08 $layer=M1 $thickness=3.6e-08
+ $X=0.189 $Y=0.036 $X2=0.1755 $Y2=0.036
r23 59 60 4.6638 $w=1.3e-08 $l=2e-08 $layer=M1 $thickness=3.6e-08 $X=0.838
+ $Y=0.137 $X2=0.838 $Y2=0.157
r24 58 59 4.6638 $w=1.3e-08 $l=2e-08 $layer=M1 $thickness=3.6e-08 $X=0.838
+ $Y=0.117 $X2=0.838 $Y2=0.137
r25 24 58 2.68168 $w=1.3e-08 $l=1.15e-08 $layer=M1 $thickness=3.6e-08 $X=0.838
+ $Y=0.1055 $X2=0.838 $Y2=0.117
r26 23 55 4.78039 $w=1.3e-08 $l=2.05e-08 $layer=M1 $thickness=3.6e-08 $X=0.459
+ $Y=0.1055 $X2=0.459 $Y2=0.126
r27 53 54 5.01358 $w=1.3e-08 $l=2.15e-08 $layer=M1 $thickness=3.6e-08 $X=0.189
+ $Y=0.191 $X2=0.189 $Y2=0.2125
r28 52 53 4.19742 $w=1.3e-08 $l=1.8e-08 $layer=M1 $thickness=3.6e-08 $X=0.189
+ $Y=0.173 $X2=0.189 $Y2=0.191
r29 50 52 6.52931 $w=1.3e-08 $l=2.8e-08 $layer=M1 $thickness=3.6e-08 $X=0.189
+ $Y=0.145 $X2=0.189 $Y2=0.173
r30 49 50 6.52931 $w=1.3e-08 $l=2.8e-08 $layer=M1 $thickness=3.6e-08 $X=0.189
+ $Y=0.117 $X2=0.189 $Y2=0.145
r31 21 49 6.52931 $w=1.3e-08 $l=2.8e-08 $layer=M1 $thickness=3.6e-08 $X=0.189
+ $Y=0.089 $X2=0.189 $Y2=0.117
r32 21 51 7.34548 $w=1.3e-08 $l=3.15e-08 $layer=M1 $thickness=3.6e-08 $X=0.189
+ $Y=0.089 $X2=0.189 $Y2=0.0575
r33 47 58 19.5347 $a=3.24e-16 $layer=V1 $X=0.838 $Y=0.117 $X2=0.838 $Y2=0.117
r34 46 47 25.0679 $w=1.3e-08 $l=1.075e-07 $layer=M2 $thickness=3.6e-08
+ $X=0.7305 $Y=0.117 $X2=0.838 $Y2=0.117
r35 45 46 42.0908 $w=1.3e-08 $l=1.805e-07 $layer=M2 $thickness=3.6e-08 $X=0.55
+ $Y=0.117 $X2=0.7305 $Y2=0.117
r36 44 45 21.2203 $w=1.3e-08 $l=9.1e-08 $layer=M2 $thickness=3.6e-08 $X=0.459
+ $Y=0.117 $X2=0.55 $Y2=0.117
r37 44 55 19.5347 $a=3.24e-16 $layer=V1 $X=0.459 $Y=0.117 $X2=0.459 $Y2=0.126
r38 43 44 12.1259 $w=1.3e-08 $l=5.2e-08 $layer=M2 $thickness=3.6e-08 $X=0.407
+ $Y=0.117 $X2=0.459 $Y2=0.117
r39 42 43 10.4935 $w=1.3e-08 $l=4.5e-08 $layer=M2 $thickness=3.6e-08 $X=0.362
+ $Y=0.117 $X2=0.407 $Y2=0.117
r40 41 42 2.56509 $w=1.3e-08 $l=1.1e-08 $layer=M2 $thickness=3.6e-08 $X=0.351
+ $Y=0.117 $X2=0.362 $Y2=0.117
r41 40 41 18.8884 $w=1.3e-08 $l=8.1e-08 $layer=M2 $thickness=3.6e-08 $X=0.27
+ $Y=0.117 $X2=0.351 $Y2=0.117
r42 39 40 18.8884 $w=1.3e-08 $l=8.1e-08 $layer=M2 $thickness=3.6e-08 $X=0.189
+ $Y=0.117 $X2=0.27 $Y2=0.117
r43 39 49 19.5347 $a=3.24e-16 $layer=V1 $X=0.189 $Y=0.117 $X2=0.189 $Y2=0.117
r44 25 39 2.68168 $w=1.3e-08 $l=1.15e-08 $layer=M2 $thickness=3.6e-08 $X=0.1775
+ $Y=0.117 $X2=0.189 $Y2=0.117
r45 37 41 19.5347 $a=3.24e-16 $layer=V1 $X=0.351 $Y=0.117 $X2=0.351 $Y2=0.117
r46 22 37 4.19742 $w=1.3e-08 $l=1.8e-08 $layer=M1 $thickness=3.6e-08 $X=0.351
+ $Y=0.135 $X2=0.351 $Y2=0.117
r47 1 30 6.54019 $w=2.09524e-08 $layer=Gate_1 $thickness=5.21905e-08 $X=0.351
+ $Y=0.135 $X2=0.351 $Y2=0.135
r48 1 22 19.3796 $a=3.24e-16 $layer=V0LIG $X=0.351 $Y=0.135 $X2=0.351 $Y2=0.135
r49 32 31 16.4967 $w=2.1e-08 $l=4.85e-08 $layer=Gate_1 $thickness=5.6e-08
+ $X=0.351 $Y=0.2025 $X2=0.351 $Y2=0.154
r50 30 31 6.6497 $w=2.04211e-08 $l=1.9e-08 $layer=Gate_1 $thickness=5.6e-08
+ $X=0.351 $Y=0.135 $X2=0.351 $Y2=0.154
r51 13 30 21.2756 $w=2.08226e-08 $l=6.2e-08 $layer=Gate_1 $thickness=5.6e-08
+ $X=0.351 $Y=0.073 $X2=0.351 $Y2=0.135
.ends

.subckt PM_DFFASRHQNx1_ASAP7_75t_R%RESETN vss 29 15 19 44 47 10 9 7 12 8 5 2 11
+ 1 6
c1 1 vss 0.00303915f $X=0.621 $Y=0.111
c2 2 vss 0.00128683f $X=1.053 $Y=0.135
c3 5 vss 0.0674633f $X=0.621 $Y=0.111
c4 6 vss 0.0604182f $X=1.053 $Y=0.0245
c5 7 vss 0.000623443f $X=0.621 $Y=0.081
c6 8 vss 0.00150885f $X=0.6335 $Y=0.153
c7 9 vss 0.000440851f $X=0.621 $Y=0.113
c8 10 vss 0.00105216f $X=0.646 $Y=0.081
c9 11 vss 0.00136258f $X=1.053 $Y=0.114
c10 12 vss 0.00899531f $X=0.9785 $Y=0.153
r1 47 46 20.5784 $w=2.1e-08 $l=6.05e-08 $layer=Gate_1 $thickness=5.6e-08
+ $X=0.621 $Y=0.216 $X2=0.621 $Y2=0.1555
r2 44 45 12.415 $w=2.1e-08 $l=3.65e-08 $layer=Gate_1 $thickness=5.6e-08
+ $X=0.621 $Y=0.0405 $X2=0.621 $Y2=0.077
r3 5 45 11.7518 $w=2.06765e-08 $l=3.4e-08 $layer=Gate_1 $thickness=5.6e-08
+ $X=0.621 $Y=0.111 $X2=0.621 $Y2=0.077
r4 5 46 15.3232 $w=2.07528e-08 $l=4.45e-08 $layer=Gate_1 $thickness=5.6e-08
+ $X=0.621 $Y=0.111 $X2=0.621 $Y2=0.1555
r5 7 39 1.84873 $w=1.888e-08 $l=1.5e-08 $layer=M1 $thickness=3.6e-08 $X=0.621
+ $Y=0.081 $X2=0.621 $Y2=0.096
r6 7 10 4.18063 $w=1.48e-08 $l=2.5e-08 $layer=M1 $thickness=3.6e-08 $X=0.621
+ $Y=0.081 $X2=0.646 $Y2=0.081
r7 1 9 19.3796 $a=3.24e-16 $layer=V0LIG $X=0.621 $Y=0.111 $X2=0.621 $Y2=0.113
r8 1 5 6.54019 $w=2.09524e-08 $layer=Gate_1 $thickness=5.21905e-08 $X=0.621
+ $Y=0.111 $X2=0.621 $Y2=0.111
r9 39 40 1.86552 $w=1.3e-08 $l=8e-09 $layer=M1 $thickness=3.6e-08 $X=0.621
+ $Y=0.096 $X2=0.621 $Y2=0.104
r10 9 38 4.43061 $w=1.3e-08 $l=1.9e-08 $layer=M1 $thickness=3.6e-08 $X=0.621
+ $Y=0.113 $X2=0.621 $Y2=0.132
r11 9 40 2.09871 $w=1.3e-08 $l=9e-09 $layer=M1 $thickness=3.6e-08 $X=0.621
+ $Y=0.113 $X2=0.621 $Y2=0.104
r12 37 38 3.71668 $w=1.51429e-08 $l=2.1e-08 $layer=M1 $thickness=3.6e-08
+ $X=0.621 $Y=0.153 $X2=0.621 $Y2=0.132
r13 8 35 2.91487 $w=1.3e-08 $l=1.25e-08 $layer=M1 $thickness=3.6e-08 $X=0.6335
+ $Y=0.153 $X2=0.646 $Y2=0.153
r14 8 37 1.73456 $w=1.66e-08 $l=1.25e-08 $layer=M1 $thickness=3.6e-08 $X=0.6335
+ $Y=0.153 $X2=0.621 $Y2=0.153
r15 33 34 13.4084 $w=1.3e-08 $l=5.75e-08 $layer=M2 $thickness=3.6e-08 $X=0.646
+ $Y=0.153 $X2=0.7035 $Y2=0.153
r16 33 35 19.5347 $a=3.24e-16 $layer=V1 $X=0.646 $Y=0.153 $X2=0.646 $Y2=0.153
r17 31 34 14.9241 $w=1.3e-08 $l=6.4e-08 $layer=M2 $thickness=3.6e-08 $X=0.7675
+ $Y=0.153 $X2=0.7035 $Y2=0.153
r18 29 30 2.85657 $w=1.3e-08 $l=1.22e-08 $layer=M2 $thickness=3.6e-08 $X=0.828
+ $Y=0.154 $X2=0.8402 $Y2=0.153
r19 29 28 5.30507 $w=1.3e-08 $l=2.28e-08 $layer=M2 $thickness=3.6e-08 $X=0.828
+ $Y=0.154 $X2=0.8052 $Y2=0.153
r20 28 31 8.80291 $w=1.3e-08 $l=3.77e-08 $layer=M2 $thickness=3.6e-08 $X=0.8052
+ $Y=0.153 $X2=0.7675 $Y2=0.153
r21 27 30 9.85227 $w=1.3e-08 $l=4.23e-08 $layer=M2 $thickness=3.6e-08 $X=0.8825
+ $Y=0.153 $X2=0.8402 $Y2=0.153
r22 12 25 17.3726 $w=1.3e-08 $l=7.45e-08 $layer=M2 $thickness=3.6e-08 $X=0.9785
+ $Y=0.153 $X2=1.053 $Y2=0.153
r23 12 27 22.3862 $w=1.3e-08 $l=9.6e-08 $layer=M2 $thickness=3.6e-08 $X=0.9785
+ $Y=0.153 $X2=0.8825 $Y2=0.153
r24 23 25 19.5347 $a=3.24e-16 $layer=V1 $X=1.053 $Y=0.144 $X2=1.053 $Y2=0.153
r25 11 23 6.99569 $w=1.3e-08 $l=3e-08 $layer=M1 $thickness=3.6e-08 $X=1.053
+ $Y=0.114 $X2=1.053 $Y2=0.144
r26 2 17 6.54019 $w=2.09524e-08 $layer=Gate_1 $thickness=5.21905e-08 $X=1.053
+ $Y=0.135 $X2=1.053 $Y2=0.135
r27 2 23 19.3796 $a=3.24e-16 $layer=V0LIG $X=1.053 $Y=0.135 $X2=1.053 $Y2=0.144
r28 19 18 16.4967 $w=2.1e-08 $l=4.85e-08 $layer=Gate_1 $thickness=5.6e-08
+ $X=1.053 $Y=0.2295 $X2=1.053 $Y2=0.181
r29 17 18 15.8334 $w=2.07609e-08 $l=4.6e-08 $layer=Gate_1 $thickness=5.6e-08
+ $X=1.053 $Y=0.135 $X2=1.053 $Y2=0.181
r30 16 17 11.2416 $w=2.06615e-08 $l=3.25e-08 $layer=Gate_1 $thickness=5.6e-08
+ $X=1.053 $Y=0.1025 $X2=1.053 $Y2=0.135
r31 15 16 16.4967 $w=2.1e-08 $l=4.85e-08 $layer=Gate_1 $thickness=5.6e-08
+ $X=1.053 $Y=0.054 $X2=1.053 $Y2=0.1025
r32 15 6 10.0341 $w=2.1e-08 $l=2.95e-08 $layer=Gate_1 $thickness=5.6e-08
+ $X=1.053 $Y=0.054 $X2=1.053 $Y2=0.0245
.ends

.subckt PM_DFFASRHQNx1_ASAP7_75t_R%22 vss 2 3 1
c1 1 vss 0.000655177f $X=1.08 $Y=0.054
r1 2 1 0.314815 $w=5.4e-08 $l=1.7e-08 $layer=N_src_drn $thickness=1e-09
+ $X=1.0626 $Y=0.054 $X2=1.08 $Y2=0.054
r2 3 1 0.314815 $w=5.4e-08 $l=1.7e-08 $layer=N_src_drn $thickness=1e-09
+ $X=1.0973 $Y=0.054 $X2=1.08 $Y2=0.054
.ends

.subckt PM_DFFASRHQNx1_ASAP7_75t_R%11 vss 27 31 73 76 79 82 86 89 16 17 20 7 5
+ 19 6 23 14 15 18 1 21 12 22 2 13
c1 1 vss 0.000668809f $X=1.107 $Y=0.135
c2 2 vss 0.00515518f $X=1.323 $Y=0.135
c3 5 vss 0.00341765f $X=0.864 $Y=0.069
c4 6 vss 0.00404254f $X=0.864 $Y=0.2295
c5 7 vss 0.00244091f $X=0.897 $Y=0.069
c6 12 vss 0.0322487f $X=1.107 $Y=0.0245
c7 13 vss 0.0868331f $X=1.323 $Y=0.135
c8 14 vss 0.0023015f $X=0.8495 $Y=0.0405
c9 15 vss 0.000884233f $X=0.866 $Y=0.0675
c10 16 vss 0.00229052f $X=0.8495 $Y=0.2295
c11 17 vss 0.000897975f $X=0.8495 $Y=0.2025
c12 18 vss 0.00216955f $X=0.927 $Y=0.228
c13 19 vss 0.00453867f $X=0.909 $Y=0.231
c14 20 vss 0.00146382f $X=0.927 $Y=0.057
c15 21 vss 0.00145597f $X=1.107 $Y=0.1055
c16 22 vss 0.00402724f $X=1.323 $Y=0.1055
c17 23 vss 0.0107425f $X=1.0375 $Y=0.117
r1 17 84 0.462963 $w=2.7e-08 $l=1.25e-08 $layer=P_src_drn $thickness=1e-09
+ $X=0.8495 $Y=0.2025 $X2=0.864 $Y2=0.2025
r2 89 88 0.0925926 $w=2.7e-08 $l=2.5e-09 $layer=P_src_drn $thickness=1e-09
+ $X=0.8813 $Y=0.2295 $X2=0.8785 $Y2=0.2295
r3 87 88 0.166667 $w=2.7e-08 $l=4.5e-09 $layer=P_src_drn $thickness=1e-09
+ $X=0.874 $Y=0.2295 $X2=0.8785 $Y2=0.2295
r4 84 87 0.444445 $w=2.7e-08 $l=1.2e-08 $layer=P_src_drn $thickness=1e-09
+ $X=0.864 $Y=0.2025 $X2=0.874 $Y2=0.2295
r5 16 84 0.462963 $w=2.7e-08 $l=1.25e-08 $layer=P_src_drn $thickness=1e-09
+ $X=0.8495 $Y=0.2295 $X2=0.864 $Y2=0.2025
r6 86 16 0.0925926 $w=2.7e-08 $l=2.5e-09 $layer=P_src_drn $thickness=1e-09
+ $X=0.8466 $Y=0.216 $X2=0.8495 $Y2=0.2295
r7 6 70 19.3796 $a=3.24e-16 $layer=V0LISD $X=0.864 $Y=0.2295 $X2=0.864 $Y2=0.231
r8 6 84 15.9139 $w=2.02e-08 $l=2.7e-08 $layer=LISD $thickness=2.7e-08 $X=0.864
+ $Y=0.2295 $X2=0.864 $Y2=0.2025
r9 82 81 0.0925926 $w=2.7e-08 $l=2.5e-09 $layer=N_src_drn $thickness=1e-09
+ $X=0.8813 $Y=0.054 $X2=0.8785 $Y2=0.0405
r10 15 81 0.462963 $w=2.7e-08 $l=1.25e-08 $layer=N_src_drn $thickness=1e-09
+ $X=0.866 $Y=0.0675 $X2=0.8785 $Y2=0.0405
r11 78 15 0.444445 $w=2.7e-08 $l=1.2e-08 $layer=N_src_drn $thickness=1e-09
+ $X=0.854 $Y=0.0405 $X2=0.866 $Y2=0.0675
r12 14 78 0.166667 $w=2.7e-08 $l=4.5e-09 $layer=N_src_drn $thickness=1e-09
+ $X=0.8495 $Y=0.0405 $X2=0.854 $Y2=0.0405
r13 79 14 0.0925926 $w=2.7e-08 $l=2.5e-09 $layer=N_src_drn $thickness=1e-09
+ $X=0.8466 $Y=0.0405 $X2=0.8495 $Y2=0.0405
r14 76 75 16.4967 $w=2.1e-08 $l=4.85e-08 $layer=Gate_1 $thickness=5.6e-08
+ $X=1.323 $Y=0.2025 $X2=1.323 $Y2=0.154
r15 73 74 16.4967 $w=2.1e-08 $l=4.85e-08 $layer=Gate_1 $thickness=5.6e-08
+ $X=1.323 $Y=0.0675 $X2=1.323 $Y2=0.116
r16 13 74 6.6497 $w=2.04211e-08 $l=1.9e-08 $layer=Gate_1 $thickness=5.6e-08
+ $X=1.323 $Y=0.135 $X2=1.323 $Y2=0.116
r17 13 75 6.6497 $w=2.04211e-08 $l=1.9e-08 $layer=Gate_1 $thickness=5.6e-08
+ $X=1.323 $Y=0.135 $X2=1.323 $Y2=0.154
r18 70 71 3.14806 $w=1.3e-08 $l=1.35e-08 $layer=M1 $thickness=3.6e-08 $X=0.864
+ $Y=0.231 $X2=0.8775 $Y2=0.231
r19 69 71 3.14806 $w=1.3e-08 $l=1.35e-08 $layer=M1 $thickness=3.6e-08 $X=0.891
+ $Y=0.231 $X2=0.8775 $Y2=0.231
r20 19 69 4.19742 $w=1.3e-08 $l=1.8e-08 $layer=M1 $thickness=3.6e-08 $X=0.909
+ $Y=0.231 $X2=0.891 $Y2=0.231
r21 5 7 17.7009 $w=2.15818e-08 $l=3.3e-08 $layer=LISD $thickness=2.7e-08
+ $X=0.864 $Y=0.069 $X2=0.897 $Y2=0.069
r22 5 15 14.1645 $w=2.18889e-08 $l=2.7e-08 $layer=LISD $thickness=2.7e-08
+ $X=0.864 $Y=0.069 $X2=0.866 $Y2=0.0675
r23 2 60 19.3796 $a=3.24e-16 $layer=V0LIG $X=1.323 $Y=0.135 $X2=1.323 $Y2=0.126
r24 2 13 6.54019 $w=2.09524e-08 $layer=Gate_1 $thickness=5.21905e-08 $X=1.323
+ $Y=0.135 $X2=1.323 $Y2=0.135
r25 18 59 1.31184 $w=1.63333e-08 $l=9e-09 $layer=M1 $thickness=3.6e-08 $X=0.927
+ $Y=0.228 $X2=0.927 $Y2=0.219
r26 18 19 2.71097 $w=1.5e-08 $l=1.82483e-08 $layer=M1 $thickness=3.6e-08
+ $X=0.927 $Y=0.228 $X2=0.909 $Y2=0.231
r27 7 63 17.6821 $w=2.02e-08 $l=3e-08 $layer=LISD $thickness=2.7e-08 $X=0.897
+ $Y=0.069 $X2=0.927 $Y2=0.069
r28 22 60 4.78039 $w=1.3e-08 $l=2.05e-08 $layer=M1 $thickness=3.6e-08 $X=1.323
+ $Y=0.1055 $X2=1.323 $Y2=0.126
r29 58 59 1.16595 $w=1.3e-08 $l=5e-09 $layer=M1 $thickness=3.6e-08 $X=0.927
+ $Y=0.214 $X2=0.927 $Y2=0.219
r30 57 58 1.51573 $w=1.3e-08 $l=6.5e-09 $layer=M1 $thickness=3.6e-08 $X=0.927
+ $Y=0.2075 $X2=0.927 $Y2=0.214
r31 56 57 1.63233 $w=1.3e-08 $l=7e-09 $layer=M1 $thickness=3.6e-08 $X=0.927
+ $Y=0.2005 $X2=0.927 $Y2=0.2075
r32 55 56 2.68168 $w=1.3e-08 $l=1.15e-08 $layer=M1 $thickness=3.6e-08 $X=0.927
+ $Y=0.189 $X2=0.927 $Y2=0.2005
r33 54 55 2.91487 $w=1.3e-08 $l=1.25e-08 $layer=M1 $thickness=3.6e-08 $X=0.927
+ $Y=0.1765 $X2=0.927 $Y2=0.189
r34 53 54 6.29612 $w=1.3e-08 $l=2.7e-08 $layer=M1 $thickness=3.6e-08 $X=0.927
+ $Y=0.1495 $X2=0.927 $Y2=0.1765
r35 52 53 7.57867 $w=1.3e-08 $l=3.25e-08 $layer=M1 $thickness=3.6e-08 $X=0.927
+ $Y=0.117 $X2=0.927 $Y2=0.1495
r36 51 52 5.59655 $w=1.3e-08 $l=2.4e-08 $layer=M1 $thickness=3.6e-08 $X=0.927
+ $Y=0.093 $X2=0.927 $Y2=0.117
r37 50 51 4.78039 $w=1.3e-08 $l=2.05e-08 $layer=M1 $thickness=3.6e-08 $X=0.927
+ $Y=0.0725 $X2=0.927 $Y2=0.093
r38 50 63 19.3796 $a=3.24e-16 $layer=V0LISD $X=0.927 $Y=0.0725 $X2=0.927
+ $Y2=0.069
r39 48 50 2.09871 $w=1.3e-08 $l=9e-09 $layer=M1 $thickness=3.6e-08 $X=0.927
+ $Y=0.0635 $X2=0.927 $Y2=0.0725
r40 20 48 1.51573 $w=1.3e-08 $l=6.5e-09 $layer=M1 $thickness=3.6e-08 $X=0.927
+ $Y=0.057 $X2=0.927 $Y2=0.0635
r41 46 60 19.5347 $a=3.24e-16 $layer=V1 $X=1.323 $Y=0.117 $X2=1.323 $Y2=0.126
r42 45 46 15.6237 $w=1.3e-08 $l=6.7e-08 $layer=M2 $thickness=3.6e-08 $X=1.256
+ $Y=0.117 $X2=1.323 $Y2=0.117
r43 44 45 23.0858 $w=1.3e-08 $l=9.9e-08 $layer=M2 $thickness=3.6e-08 $X=1.157
+ $Y=0.117 $X2=1.256 $Y2=0.117
r44 43 44 11.6595 $w=1.3e-08 $l=5e-08 $layer=M2 $thickness=3.6e-08 $X=1.107
+ $Y=0.117 $X2=1.157 $Y2=0.117
r45 42 43 5.71315 $w=1.3e-08 $l=2.45e-08 $layer=M2 $thickness=3.6e-08 $X=1.0825
+ $Y=0.117 $X2=1.107 $Y2=0.117
r46 38 39 9.56078 $w=1.3e-08 $l=4.1e-08 $layer=M2 $thickness=3.6e-08 $X=0.931
+ $Y=0.117 $X2=0.972 $Y2=0.117
r47 38 52 19.5347 $a=3.24e-16 $layer=V1 $X=0.931 $Y=0.117 $X2=0.927 $Y2=0.117
r48 23 39 15.2739 $w=1.3e-08 $l=6.55e-08 $layer=M2 $thickness=3.6e-08 $X=1.0375
+ $Y=0.117 $X2=0.972 $Y2=0.117
r49 23 42 10.4935 $w=1.3e-08 $l=4.5e-08 $layer=M2 $thickness=3.6e-08 $X=1.0375
+ $Y=0.117 $X2=1.0825 $Y2=0.117
r50 35 43 19.5347 $a=3.24e-16 $layer=V1 $X=1.107 $Y=0.126 $X2=1.107 $Y2=0.117
r51 21 35 4.78039 $w=1.3e-08 $l=2.05e-08 $layer=M1 $thickness=3.6e-08 $X=1.107
+ $Y=0.1055 $X2=1.107 $Y2=0.126
r52 1 29 6.54019 $w=2.09524e-08 $layer=Gate_1 $thickness=5.21905e-08 $X=1.107
+ $Y=0.135 $X2=1.107 $Y2=0.135
r53 1 35 19.3796 $a=3.24e-16 $layer=V0LIG $X=1.107 $Y=0.135 $X2=1.107 $Y2=0.126
r54 31 30 16.4967 $w=2.1e-08 $l=4.85e-08 $layer=Gate_1 $thickness=5.6e-08
+ $X=1.107 $Y=0.2295 $X2=1.107 $Y2=0.181
r55 29 30 15.8334 $w=2.07609e-08 $l=4.6e-08 $layer=Gate_1 $thickness=5.6e-08
+ $X=1.107 $Y=0.135 $X2=1.107 $Y2=0.181
r56 28 29 11.2416 $w=2.06615e-08 $l=3.25e-08 $layer=Gate_1 $thickness=5.6e-08
+ $X=1.107 $Y=0.1025 $X2=1.107 $Y2=0.135
r57 27 28 16.4967 $w=2.1e-08 $l=4.85e-08 $layer=Gate_1 $thickness=5.6e-08
+ $X=1.107 $Y=0.054 $X2=1.107 $Y2=0.1025
r58 27 12 10.0341 $w=2.1e-08 $l=2.95e-08 $layer=Gate_1 $thickness=5.6e-08
+ $X=1.107 $Y=0.054 $X2=1.107 $Y2=0.0245
.ends

.subckt PM_DFFASRHQNx1_ASAP7_75t_R%18 vss 2 3 1
c1 1 vss 0.00059033f $X=0.594 $Y=0.0405
r1 2 1 0.62963 $w=2.7e-08 $l=1.7e-08 $layer=N_src_drn $thickness=1e-09
+ $X=0.5766 $Y=0.0405 $X2=0.594 $Y2=0.0405
r2 3 1 0.62963 $w=2.7e-08 $l=1.7e-08 $layer=N_src_drn $thickness=1e-09
+ $X=0.6113 $Y=0.0405 $X2=0.594 $Y2=0.0405
.ends

.subckt PM_DFFASRHQNx1_ASAP7_75t_R%13 vss 11 25 26 7 1 8 2 9
c1 1 vss 0.00472045f $X=0.432 $Y=0.216
c2 2 vss 0.0075959f $X=0.594 $Y=0.216
c3 7 vss 0.00207537f $X=0.4175 $Y=0.216
c4 8 vss 0.00355417f $X=0.5795 $Y=0.216
c5 9 vss 0.0167279f $X=0.4165 $Y=0.234
r1 26 24 0.0462963 $w=5.4e-08 $l=2.5e-09 $layer=P_src_drn $thickness=1e-09
+ $X=0.6113 $Y=0.216 $X2=0.6085 $Y2=0.216
r2 2 24 0.268519 $w=5.4e-08 $l=1.45e-08 $layer=P_src_drn $thickness=1e-09
+ $X=0.594 $Y=0.216 $X2=0.6085 $Y2=0.216
r3 8 2 0.268519 $w=5.4e-08 $l=1.45e-08 $layer=P_src_drn $thickness=1e-09
+ $X=0.5795 $Y=0.216 $X2=0.594 $Y2=0.216
r4 25 8 0.0462963 $w=5.4e-08 $l=2.5e-09 $layer=P_src_drn $thickness=1e-09
+ $X=0.5766 $Y=0.216 $X2=0.5795 $Y2=0.216
r5 2 21 19.3796 $a=3.24e-16 $layer=V0LISD $X=0.594 $Y=0.216 $X2=0.594 $Y2=0.234
r6 20 21 3.14806 $w=1.3e-08 $l=1.35e-08 $layer=M1 $thickness=3.6e-08 $X=0.5805
+ $Y=0.234 $X2=0.594 $Y2=0.234
r7 19 20 3.14806 $w=1.3e-08 $l=1.35e-08 $layer=M1 $thickness=3.6e-08 $X=0.567
+ $Y=0.234 $X2=0.5805 $Y2=0.234
r8 18 19 3.38125 $w=1.3e-08 $l=1.45e-08 $layer=M1 $thickness=3.6e-08 $X=0.5525
+ $Y=0.234 $X2=0.567 $Y2=0.234
r9 17 18 8.39483 $w=1.3e-08 $l=3.6e-08 $layer=M1 $thickness=3.6e-08 $X=0.5165
+ $Y=0.234 $X2=0.5525 $Y2=0.234
r10 16 17 9.211 $w=1.3e-08 $l=3.95e-08 $layer=M1 $thickness=3.6e-08 $X=0.477
+ $Y=0.234 $X2=0.5165 $Y2=0.234
r11 15 16 4.19742 $w=1.3e-08 $l=1.8e-08 $layer=M1 $thickness=3.6e-08 $X=0.459
+ $Y=0.234 $X2=0.477 $Y2=0.234
r12 14 15 3.14806 $w=1.3e-08 $l=1.35e-08 $layer=M1 $thickness=3.6e-08 $X=0.4455
+ $Y=0.234 $X2=0.459 $Y2=0.234
r13 13 14 3.14806 $w=1.3e-08 $l=1.35e-08 $layer=M1 $thickness=3.6e-08 $X=0.432
+ $Y=0.234 $X2=0.4455 $Y2=0.234
r14 12 13 2.68168 $w=1.3e-08 $l=1.15e-08 $layer=M1 $thickness=3.6e-08 $X=0.4205
+ $Y=0.234 $X2=0.432 $Y2=0.234
r15 9 12 0.932759 $w=1.3e-08 $l=4e-09 $layer=M1 $thickness=3.6e-08 $X=0.4165
+ $Y=0.234 $X2=0.4205 $Y2=0.234
r16 1 13 19.3796 $a=3.24e-16 $layer=V0LISD $X=0.432 $Y=0.216 $X2=0.432 $Y2=0.234
r17 7 1 0.231482 $w=5.4e-08 $l=1.25e-08 $layer=P_src_drn $thickness=1e-09
+ $X=0.4175 $Y=0.216 $X2=0.432 $Y2=0.216
r18 11 7 0.0462963 $w=5.4e-08 $l=2.5e-09 $layer=P_src_drn $thickness=1e-09
+ $X=0.4146 $Y=0.216 $X2=0.4175 $Y2=0.216
.ends

* End of included file DFFASRHQNx1_ASAP7_75t_R.pex.sp.pex

*
.subckt DFFASRHQNx1_ASAP7_75t_CUSTOM_4_25_0_7 VSS VDD CLK D RESETN SETN QN
*
* VSS VSS
* VDD VDD
* CLK CLK
* D D
* RESETN RESETN
* SETN SETN
* QN QN
*
*

M0 VSS N_M0_g N_M0_s VSS nmos_rvt L=2e-08 W=5.4e-08 nfin=2 $X=0.071 $Y=0.027
M1 N_M1_d N_M1_g VSS VSS nmos_rvt L=2e-08 W=5.4e-08 nfin=2 $X=0.125 $Y=0.027
M2 N_M2_d N_M2_g VSS VSS nmos_rvt L=2e-08 W=8.1e-08 nfin=3 $X=0.287 $Y=0.027
M3 N_M3_d N_M3_g N_M3_s VSS nmos_rvt L=2e-08 W=8.1e-08 nfin=3 $X=0.395 $Y=0.027
M4 N_M4_d N_M4_g N_M4_s VSS nmos_rvt L=2e-08 W=2.7e-08 nfin=1 $X=0.449 $Y=0.027
M5 N_M5_d N_M5_g N_M5_s VSS nmos_rvt L=2e-08 W=2.7e-08 nfin=1 $X=0.557 $Y=0.027
M6 VSS N_M6_g N_M6_s VSS nmos_rvt L=2e-08 W=2.7e-08 nfin=1 $X=0.611 $Y=0.027
M7 N_M7_d N_M7_g VSS VSS nmos_rvt L=2e-08 W=5.4e-08 nfin=2 $X=0.665 $Y=0.027
M8 N_M8_d N_M8_g N_M8_s VSS nmos_rvt L=2e-08 W=5.4e-08 nfin=2 $X=0.719 $Y=0.027
M9 N_M9_d N_M9_g N_M9_s VSS nmos_rvt L=2e-08 W=2.7e-08 nfin=1 $X=0.827 $Y=0.027
M10 N_M10_d N_M10_g N_M10_s VSS nmos_rvt L=2e-08 W=5.4e-08 nfin=2 $X=0.881
+ $Y=0.027
M11 N_M11_d N_M11_g N_M11_s VSS nmos_rvt L=2e-08 W=5.4e-08 nfin=2 $X=0.935
+ $Y=0.027
M12 VSS N_M12_g N_M12_s VSS nmos_rvt L=2e-08 W=5.4e-08 nfin=2 $X=0.989 $Y=0.027
M13 N_M13_d N_M13_g VSS VSS nmos_rvt L=2e-08 W=5.4e-08 nfin=2 $X=1.043 $Y=0.027
M14 N_M14_d N_M14_g N_M14_s VSS nmos_rvt L=2e-08 W=5.4e-08 nfin=2 $X=1.097
+ $Y=0.027
M15 N_M15_d N_M15_g VSS VSS nmos_rvt L=2e-08 W=8.1e-08 nfin=3 $X=1.313 $Y=0.027
M16 VDD N_M16_g N_M16_s VDD pmos_rvt L=2e-08 W=5.4e-08 nfin=2 $X=0.071 $Y=0.189
M17 N_M17_d N_M17_g VDD VDD pmos_rvt L=2e-08 W=5.4e-08 nfin=2 $X=0.125 $Y=0.189
M18 N_M18_d N_M18_g VDD VDD pmos_rvt L=2e-08 W=8.1e-08 nfin=3 $X=0.287 $Y=0.162
M19 N_M19_d N_M19_g N_M19_s VDD pmos_rvt L=2e-08 W=8.1e-08 nfin=3 $X=0.341
+ $Y=0.162
M20 N_M20_d N_M20_g N_M20_s VDD pmos_rvt L=2e-08 W=5.4e-08 nfin=2 $X=0.395
+ $Y=0.189
M21 N_M21_d N_M21_g VDD VDD pmos_rvt L=2e-08 W=5.4e-08 nfin=2 $X=0.557 $Y=0.189
M22 VDD N_M22_g N_M22_s VDD pmos_rvt L=2e-08 W=5.4e-08 nfin=2 $X=0.611 $Y=0.189
M23 N_M23_d N_M23_g VDD VDD pmos_rvt L=2e-08 W=2.7e-08 nfin=1 $X=0.665 $Y=0.216
M24 VDD N_M24_g N_M24_s VDD pmos_rvt L=2e-08 W=2.7e-08 nfin=1 $X=0.719 $Y=0.216
M25 N_M25_d N_M25_g VDD VDD pmos_rvt L=2e-08 W=5.4e-08 nfin=2 $X=0.773 $Y=0.189
M26 N_M26_d N_M26_g N_M26_s VDD pmos_rvt L=2e-08 W=5.4e-08 nfin=2 $X=0.827
+ $Y=0.189
M27 N_M27_d N_M27_g N_M27_s VDD pmos_rvt L=2e-08 W=2.7e-08 nfin=1 $X=0.881
+ $Y=0.216
M28 N_M28_d N_M28_g VDD VDD pmos_rvt L=2e-08 W=2.7e-08 nfin=1 $X=0.989 $Y=0.216
M29 N_M29_d N_M29_g VDD VDD pmos_rvt L=2e-08 W=2.7e-08 nfin=1 $X=1.043 $Y=0.216
M30 VDD N_M30_g N_M30_s VDD pmos_rvt L=2e-08 W=2.7e-08 nfin=1 $X=1.097 $Y=0.216
M31 N_M31_d N_M31_g VDD VDD pmos_rvt L=2e-08 W=2.7e-08 nfin=1 $X=1.151 $Y=0.216
M32 N_M32_d N_M32_g VDD VDD pmos_rvt L=2e-08 W=8.1e-08 nfin=3 $X=1.313 $Y=0.162

* .include "DFFASRHQNx1_ASAP7_75t_R.pex.sp.pxi"

* Start of included file DFFASRHQNx1_ASAP7_75t_R.pex.sp.pxi
x_PM_DFFASRHQNx1_ASAP7_75t_R%CLK vss CLK N_M0_g N_M16_g N_CLK_3 N_CLK_6 N_CLK_1
+ N_CLK_5 N_CLK_4 PM_DFFASRHQNx1_ASAP7_75t_R%CLK
x_PM_DFFASRHQNx1_ASAP7_75t_R%19 vss N_M7_d N_M8_s N_19_1
+ PM_DFFASRHQNx1_ASAP7_75t_R%19
cc_1 N_19_1 N_9_9 0.0121432f $X=0.702 $Y=0.054
cc_2 N_19_1 N_SETN_7 0.0121872f $X=0.702 $Y=0.054
x_PM_DFFASRHQNx1_ASAP7_75t_R%16 vss N_M2_d N_M3_s N_16_5 N_16_4 N_16_1
+ PM_DFFASRHQNx1_ASAP7_75t_R%16
cc_3 N_16_5 N_4_24 0.000491285f $X=0.38 $Y=0.0675
cc_4 N_16_5 N_4_2 0.000628956f $X=0.38 $Y=0.0675
cc_5 N_16_5 N_4_14 0.0347805f $X=0.38 $Y=0.0675
cc_6 N_16_4 N_D_3 0.0346521f $X=0.3095 $Y=0.0675
cc_7 N_16_4 N_6_1 0.00191069f $X=0.3095 $Y=0.0675
cc_8 N_16_4 N_6_22 0.000506835f $X=0.3095 $Y=0.0675
cc_9 N_16_4 N_6_13 0.0727829f $X=0.3095 $Y=0.0675
cc_10 N_16_1 N_9_4 0.00121303f $X=0.351 $Y=0.0675
cc_11 N_16_1 N_9_11 0.000574646f $X=0.351 $Y=0.0675
cc_12 N_16_1 N_9_10 0.0021876f $X=0.351 $Y=0.0675
x_PM_DFFASRHQNx1_ASAP7_75t_R%17 vss N_M4_d N_M5_s N_17_4 N_17_5 N_17_1
+ PM_DFFASRHQNx1_ASAP7_75t_R%17
cc_13 N_17_4 N_6_14 0.015485f $X=0.4715 $Y=0.0405
cc_14 N_17_5 N_7_1 0.000741001f $X=0.542 $Y=0.0405
cc_15 N_17_5 N_7_20 0.000174435f $X=0.542 $Y=0.0405
cc_16 N_17_1 N_7_14 0.00117419f $X=0.486 $Y=0.0405
cc_17 N_17_5 N_7_14 0.0154043f $X=0.542 $Y=0.0405
cc_18 N_17_1 N_9_10 0.000315898f $X=0.486 $Y=0.0405
cc_19 N_17_1 N_9_11 0.000346506f $X=0.486 $Y=0.0405
cc_20 N_17_1 N_9_19 0.000477867f $X=0.486 $Y=0.0405
cc_21 N_17_4 N_9_4 0.000556321f $X=0.4715 $Y=0.0405
cc_22 N_17_1 N_9_15 0.00215207f $X=0.486 $Y=0.0405
x_PM_DFFASRHQNx1_ASAP7_75t_R%9 vss N_M8_g N_M24_g N_M19_d N_M20_s N_M3_d N_M4_s
+ N_9_11 N_9_14 N_9_15 N_9_18 N_9_13 N_9_4 N_9_3 N_9_17 N_9_21 N_9_10 N_9_19
+ N_9_22 N_9_12 N_9_20 N_9_16 N_9_1 N_9_9 PM_DFFASRHQNx1_ASAP7_75t_R%9
cc_23 N_9_11 N_4_24 0.000105503f $X=0.4175 $Y=0.081
cc_24 N_9_14 N_4_14 0.00509669f $X=0.3635 $Y=0.2245
cc_25 N_9_15 N_4_26 0.000211972f $X=0.495 $Y=0.0405
cc_26 N_9_18 N_4_24 0.00130611f $X=0.477 $Y=0.036
cc_27 N_9_13 N_4_14 0.000218693f $X=0.3635 $Y=0.1755
cc_28 N_9_4 N_4_24 0.00223353f $X=0.432 $Y=0.0405
cc_29 N_9_3 N_4_24 0.000275058f $X=0.378 $Y=0.174
cc_30 N_9_17 N_4_24 0.000575525f $X=0.378 $Y=0.1725
cc_31 N_9_4 N_4_2 0.00067539f $X=0.432 $Y=0.0405
cc_32 N_9_3 N_4_14 0.000754125f $X=0.378 $Y=0.174
cc_33 N_9_21 N_4_26 0.00118811f $X=0.738 $Y=0.144
cc_34 N_9_4 N_4_14 0.00120448f $X=0.432 $Y=0.0405
cc_35 N_9_10 N_4_2 0.00148708f $X=0.4175 $Y=0.0405
cc_36 N_9_19 N_4_26 0.00150409f $X=0.495 $Y=0.1745
cc_37 N_9_22 N_4_26 0.00168776f $X=0.6805 $Y=0.189
cc_38 N_9_10 N_4_14 0.00932921f $X=0.4175 $Y=0.0405
cc_39 N_9_12 N_4_14 0.00983792f $X=0.3635 $Y=0.1975
cc_40 N_9_11 N_4_14 0.0488213f $X=0.4175 $Y=0.081
cc_41 N_9_14 N_6_25 6.89749e-20 $X=0.3635 $Y=0.2245
cc_42 N_9_14 N_6_14 8.4001e-20 $X=0.3635 $Y=0.2245
cc_43 N_9_13 N_6_13 0.000143229f $X=0.3635 $Y=0.1755
cc_44 N_9_20 N_6_25 0.000148121f $X=0.508 $Y=0.189
cc_45 N_9_10 N_6_14 0.0298843f $X=0.4175 $Y=0.0405
cc_46 N_9_21 N_6_25 0.000164341f $X=0.738 $Y=0.144
cc_47 N_9_17 N_6_22 0.0022093f $X=0.378 $Y=0.1725
cc_48 N_9_20 N_6_23 0.000196232f $X=0.508 $Y=0.189
cc_49 N_9_16 N_6_23 0.000273865f $X=0.495 $Y=0.189
cc_50 N_9_3 N_6_22 0.000363535f $X=0.378 $Y=0.174
cc_51 N_9_11 N_6_14 0.00540888f $X=0.4175 $Y=0.081
cc_52 N_9_3 N_6_1 0.000464285f $X=0.378 $Y=0.174
cc_53 N_9_18 N_6_23 0.000515444f $X=0.477 $Y=0.036
cc_54 N_9_1 N_6_3 0.000517421f $X=0.724 $Y=0.16
cc_55 N_9_19 N_6_23 0.00670119f $X=0.495 $Y=0.1745
cc_56 N_9_12 N_6_1 0.00081618f $X=0.3635 $Y=0.1975
cc_57 N_9_19 N_6_2 0.000911624f $X=0.495 $Y=0.1745
cc_58 N_9_4 N_6_14 0.000979231f $X=0.432 $Y=0.0405
cc_59 N_9_3 N_6_13 0.00106957f $X=0.378 $Y=0.174
cc_60 N_9_10 N_6_2 0.00108995f $X=0.4175 $Y=0.0405
cc_61 N_9_22 N_6_25 0.00854736f $X=0.6805 $Y=0.189
cc_62 N_9_12 N_6_13 0.00954173f $X=0.3635 $Y=0.1975
cc_63 N_9_14 N_6_13 0.0304181f $X=0.3635 $Y=0.2245
cc_64 N_9_20 N_7_23 0.000191996f $X=0.508 $Y=0.189
cc_65 N_9_19 N_7_1 0.000469144f $X=0.495 $Y=0.1745
cc_66 N_9_9 N_7_17 0.00632853f $X=0.729 $Y=0.0245
cc_67 N_9_21 N_7_25 0.00604766f $X=0.738 $Y=0.144
cc_68 N_9_9 N_7_4 0.000293023f $X=0.729 $Y=0.0245
cc_69 N_9_15 N_7_20 0.000374288f $X=0.495 $Y=0.0405
cc_70 N_9_21 N_7_3 0.000581377f $X=0.738 $Y=0.144
cc_71 N_9_1 N_7_25 0.000653416f $X=0.724 $Y=0.16
cc_72 N_9_22 N_7_23 0.000821076f $X=0.6805 $Y=0.189
cc_73 N_9_1 N_7_3 0.00108344f $X=0.724 $Y=0.16
cc_74 N_9_9 N_7_3 0.00115727f $X=0.729 $Y=0.0245
cc_75 N_9_19 N_7_23 0.0019307f $X=0.495 $Y=0.1745
cc_76 N_9_9 N_7_15 0.034059f $X=0.729 $Y=0.0245
cc_77 N_9_22 N_RESETN_9 0.000201952f $X=0.6805 $Y=0.189
cc_78 N_9_20 N_RESETN_8 0.000242779f $X=0.508 $Y=0.189
cc_79 N_9_21 N_RESETN_12 0.000795962f $X=0.738 $Y=0.144
cc_80 N_9_22 N_RESETN_8 0.00123363f $X=0.6805 $Y=0.189
cc_81 N_9_22 N_RESETN_12 0.0102531f $X=0.6805 $Y=0.189
x_PM_DFFASRHQNx1_ASAP7_75t_R%QN vss QN N_M15_d N_M32_d N_QN_7 N_QN_8 N_QN_11
+ PM_DFFASRHQNx1_ASAP7_75t_R%QN
cc_82 N_QN_7 N_11_22 0.00117959f $X=1.3355 $Y=0.0675
cc_83 N_QN_7 N_11_2 0.00246824f $X=1.3355 $Y=0.0675
cc_84 N_QN_7 N_11_23 0.000893239f $X=1.3355 $Y=0.0675
cc_85 N_QN_8 N_11_13 0.0147798f $X=1.3355 $Y=0.2025
cc_86 N_QN_11 N_11_22 0.00536278f $X=1.377 $Y=0.0735
cc_87 N_QN_7 N_11_13 0.0562935f $X=1.3355 $Y=0.0675
x_PM_DFFASRHQNx1_ASAP7_75t_R%14 vss N_M25_d N_M26_s N_M31_d N_14_7 N_14_1
+ N_14_11 N_14_9 N_14_10 N_14_8 N_14_2 PM_DFFASRHQNx1_ASAP7_75t_R%14
cc_88 N_14_7 N_6_24 0.000431707f $X=0.7955 $Y=0.216
cc_89 N_14_7 N_6_3 0.000964443f $X=0.7955 $Y=0.216
cc_90 N_14_1 N_6_15 0.000703559f $X=0.81 $Y=0.216
cc_91 N_14_7 N_6_15 0.0249451f $X=0.7955 $Y=0.216
cc_92 N_14_11 N_7_27 0.00175259f $X=0.7855 $Y=0.225
cc_93 N_14_11 N_RESETN_12 0.00217531f $X=0.7855 $Y=0.225
cc_94 N_14_11 N_9_21 0.000658456f $X=0.7855 $Y=0.225
cc_95 N_14_11 N_9_22 0.00134853f $X=0.7855 $Y=0.225
cc_96 N_14_11 N_SETN_8 0.000320283f $X=0.7855 $Y=0.225
cc_97 N_14_11 N_SETN_10 0.000342089f $X=0.7855 $Y=0.225
cc_98 N_14_1 N_SETN_8 0.000620285f $X=0.81 $Y=0.216
cc_99 N_14_9 N_SETN_10 0.00437676f $X=0.783 $Y=0.225
cc_100 N_14_7 N_SETN_8 0.0243213f $X=0.7955 $Y=0.216
cc_101 N_14_11 N_SETN_12 0.019824f $X=0.7855 $Y=0.225
cc_102 N_14_11 N_11_1 9.74562e-20 $X=0.7855 $Y=0.225
cc_103 N_14_11 N_11_22 0.000142977f $X=0.7855 $Y=0.225
cc_104 N_14_11 N_11_12 0.000166793f $X=0.7855 $Y=0.225
cc_105 N_14_11 N_11_21 0.000729373f $X=0.7855 $Y=0.225
cc_106 N_14_11 N_11_20 0.000262965f $X=0.7855 $Y=0.225
cc_107 N_14_10 N_11_21 0.0003774f $X=1.1725 $Y=0.225
cc_108 N_14_7 N_11_17 0.000409398f $X=0.7955 $Y=0.216
cc_109 N_14_7 N_11_16 0.00041059f $X=0.7955 $Y=0.216
cc_110 N_14_9 N_11_19 0.000414731f $X=0.783 $Y=0.225
cc_111 N_14_1 N_11_6 0.0023336f $X=0.81 $Y=0.216
cc_112 N_14_11 N_11_19 0.00116657f $X=0.7855 $Y=0.225
cc_113 N_14_11 N_11_23 0.00153209f $X=0.7855 $Y=0.225
cc_114 N_14_11 N_11_18 0.00332008f $X=0.7855 $Y=0.225
cc_115 N_14_8 N_12_6 0.000871526f $X=1.1735 $Y=0.2295
cc_116 N_14_8 N_12_10 0.000274726f $X=1.1735 $Y=0.2295
cc_117 N_14_8 N_12_9 0.000297943f $X=1.1735 $Y=0.2295
cc_118 N_14_2 N_12_6 0.000329313f $X=1.188 $Y=0.2295
cc_119 N_14_2 N_12_14 0.000480799f $X=1.188 $Y=0.2295
cc_120 N_14_8 N_12_14 0.0155012f $X=1.1735 $Y=0.2295
x_PM_DFFASRHQNx1_ASAP7_75t_R%7 vss N_M5_g N_M21_g N_M23_d N_M24_s N_M8_d N_M9_s
+ N_M28_d N_M27_d N_7_18 N_7_4 N_7_5 N_7_20 N_7_26 N_7_28 N_7_23 N_7_27 N_7_24
+ N_7_25 N_7_1 N_7_16 N_7_14 N_7_3 N_7_22 N_7_17 N_7_15 N_7_19
+ PM_DFFASRHQNx1_ASAP7_75t_R%7
cc_121 N_7_18 N_4_3 0.000159828f $X=0.9035 $Y=0.2295
cc_122 N_7_4 N_4_15 0.000165073f $X=0.756 $Y=0.054
cc_123 N_7_5 N_4_3 0.000195092f $X=0.947 $Y=0.2295
cc_124 N_7_5 N_4_15 0.000226525f $X=0.947 $Y=0.2295
cc_125 N_7_20 N_4_26 0.000236847f $X=0.567 $Y=0.0495
cc_126 N_7_26 N_4_26 0.000834897f $X=0.72 $Y=0.045
cc_127 N_7_28 N_4_25 0.000450973f $X=0.7435 $Y=0.045
cc_128 N_7_23 N_4_26 0.000630862f $X=0.567 $Y=0.0765
cc_129 N_7_27 N_4_25 0.00076914f $X=0.972 $Y=0.078
cc_130 N_7_24 N_4_26 0.000829224f $X=0.592 $Y=0.045
cc_131 N_7_28 N_4_26 0.00709065f $X=0.7435 $Y=0.045
cc_132 N_7_25 N_4_26 0.00994315f $X=0.702 $Y=0.0605
cc_133 N_7_18 N_4_15 0.0150105f $X=0.9035 $Y=0.2295
cc_134 N_7_4 N_6_25 0.000123503f $X=0.756 $Y=0.054
cc_135 N_7_4 N_6_23 8.41951e-20 $X=0.756 $Y=0.054
cc_136 N_7_28 N_6_24 9.26006e-20 $X=0.7435 $Y=0.045
cc_137 N_7_1 N_6_14 0.000106209f $X=0.567 $Y=0.089
cc_138 N_7_16 N_6_15 0.0064505f $X=0.812 $Y=0.0405
cc_139 N_7_14 N_6_2 0.000227725f $X=0.567 $Y=0.0245
cc_140 N_7_4 N_6_24 0.000260576f $X=0.756 $Y=0.054
cc_141 N_7_28 N_6_25 0.000413273f $X=0.7435 $Y=0.045
cc_142 N_7_23 N_6_25 0.000457251f $X=0.567 $Y=0.0765
cc_143 N_7_25 N_6_25 0.00214353f $X=0.702 $Y=0.0605
cc_144 N_7_4 N_6_15 0.00933404f $X=0.756 $Y=0.054
x_PM_DFFASRHQNx1_ASAP7_75t_R%20 vss N_M10_d N_M11_s N_20_1
+ PM_DFFASRHQNx1_ASAP7_75t_R%20
cc_145 N_20_1 N_4_15 0.0121666f $X=0.918 $Y=0.054
cc_146 N_20_1 N_11_14 0.000275542f $X=0.918 $Y=0.054
cc_147 N_20_1 N_12_13 0.0120924f $X=0.918 $Y=0.054
x_PM_DFFASRHQNx1_ASAP7_75t_R%D vss D N_M2_g N_M18_g N_D_7 N_D_3 N_D_4 N_D_6
+ N_D_1 N_D_8 N_D_9 N_D_5 PM_DFFASRHQNx1_ASAP7_75t_R%D
cc_148 N_D_7 N_4_23 0.000293258f $X=0.243 $Y=0.1145
cc_149 N_D_7 N_4_1 0.000308114f $X=0.243 $Y=0.1145
cc_150 N_D_7 N_4_14 0.000389011f $X=0.243 $Y=0.1145
cc_151 N_D_7 N_4_26 0.0030978f $X=0.243 $Y=0.1145
x_PM_DFFASRHQNx1_ASAP7_75t_R%23 vss N_M18_d N_M19_s N_23_1
+ PM_DFFASRHQNx1_ASAP7_75t_R%23
cc_152 N_23_1 N_D_3 0.0166812f $X=0.324 $Y=0.2025
cc_153 N_23_1 N_6_13 0.0167896f $X=0.324 $Y=0.2025
x_PM_DFFASRHQNx1_ASAP7_75t_R%4 vss N_M10_g N_M27_g N_M3_g N_M20_g N_M1_g
+ N_M17_g N_M0_s N_M16_s N_4_21 N_4_7 N_4_8 N_4_1 N_4_17 N_4_16 N_4_18 N_4_23
+ N_4_20 N_4_19 N_4_26 N_4_22 N_4_13 N_4_14 N_4_25 N_4_2 N_4_24 N_4_3 N_4_15
+ PM_DFFASRHQNx1_ASAP7_75t_R%4
cc_154 N_4_21 N_CLK_3 0.000818206f $X=0.027 $Y=0.0575
cc_155 N_4_7 N_CLK_3 0.000976364f $X=0.054 $Y=0.054
cc_156 N_4_8 N_CLK_3 0.00107382f $X=0.054 $Y=0.216
cc_157 N_4_1 N_CLK_3 0.000301523f $X=0.1335 $Y=0.135
cc_158 N_4_17 N_CLK_3 0.011135f $X=0.056 $Y=0.216
cc_159 N_4_16 N_CLK_3 0.0111248f $X=0.056 $Y=0.054
cc_160 N_4_18 N_CLK_3 0.000445295f $X=0.027 $Y=0.036
cc_161 N_4_23 N_CLK_3 0.000626061f $X=0.151 $Y=0.071
cc_162 N_4_20 N_CLK_6 0.000889701f $X=0.027 $Y=0.234
cc_163 N_4_19 N_CLK_1 0.000923865f $X=0.0325 $Y=0.117
cc_164 N_4_26 N_CLK_5 0.0010752f $X=0.867 $Y=0.081
cc_165 N_4_23 N_CLK_5 0.00133225f $X=0.151 $Y=0.071
cc_166 N_4_22 N_CLK_5 0.00153077f $X=0.027 $Y=0.154
cc_167 N_4_20 N_CLK_4 0.00211756f $X=0.027 $Y=0.234
cc_168 N_4_1 N_CLK_1 0.0025291f $X=0.1335 $Y=0.135
cc_169 N_4_19 N_CLK_5 0.00629428f $X=0.0325 $Y=0.117
cc_170 N_4_13 N_CLK_3 0.0350667f $X=0.135 $Y=0.135
x_PM_DFFASRHQNx1_ASAP7_75t_R%SETN vss SETN N_M12_g N_M28_g N_M25_g N_M7_g
+ N_M23_g N_SETN_5 N_SETN_12 N_SETN_11 N_SETN_8 N_SETN_2 N_SETN_10 N_SETN_7
+ N_SETN_9 N_SETN_3 N_SETN_1 PM_DFFASRHQNx1_ASAP7_75t_R%SETN
cc_171 N_SETN_5 N_4_3 0.00135976f $X=0.9735 $Y=0.111
cc_172 N_SETN_12 N_4_25 0.000345658f $X=0.7855 $Y=0.189
cc_173 N_SETN_11 N_4_26 0.000910834f $X=0.783 $Y=0.0995
cc_174 N_SETN_5 N_4_25 0.000972625f $X=0.9735 $Y=0.111
cc_175 N_SETN_5 N_4_15 0.00542662f $X=0.9735 $Y=0.111
cc_176 N_SETN_8 N_6_24 0.000206745f $X=0.783 $Y=0.111
cc_177 N_SETN_11 N_6_24 0.00412961f $X=0.783 $Y=0.0995
cc_178 N_SETN_2 N_6_24 0.000318582f $X=0.783 $Y=0.111
cc_179 N_SETN_5 N_6_24 0.000376148f $X=0.9735 $Y=0.111
cc_180 N_SETN_12 N_6_24 0.000431233f $X=0.7855 $Y=0.189
cc_181 N_SETN_10 N_6_24 0.000616273f $X=0.776 $Y=0.189
cc_182 N_SETN_11 N_6_25 0.000682804f $X=0.783 $Y=0.0995
cc_183 N_SETN_5 N_6_3 0.00197534f $X=0.9735 $Y=0.111
cc_184 N_SETN_5 N_6_15 0.00375524f $X=0.9735 $Y=0.111
cc_185 N_SETN_8 N_6_15 0.0106666f $X=0.783 $Y=0.111
cc_186 N_SETN_5 N_7_24 0.000117982f $X=0.9735 $Y=0.111
cc_187 N_SETN_5 N_7_22 0.000141641f $X=0.9735 $Y=0.111
cc_188 N_SETN_7 N_7_3 0.0101607f $X=0.675 $Y=0.111
cc_189 N_SETN_9 N_7_5 0.000183071f $X=0.999 $Y=0.0245
cc_190 N_SETN_9 N_7_19 0.0190348f $X=0.999 $Y=0.0245
cc_191 N_SETN_7 N_7_17 0.00637761f $X=0.675 $Y=0.111
cc_192 N_SETN_5 N_7_4 0.00649148f $X=0.9735 $Y=0.111
cc_193 N_SETN_8 N_7_16 0.00713103f $X=0.783 $Y=0.111
cc_194 N_SETN_3 N_7_27 0.000335368f $X=0.999 $Y=0.111
cc_195 N_SETN_2 N_7_4 0.00117806f $X=0.783 $Y=0.111
cc_196 N_SETN_1 N_7_25 0.00042758f $X=0.6755 $Y=0.111
cc_197 N_SETN_11 N_7_26 0.000542753f $X=0.783 $Y=0.0995
cc_198 N_SETN_11 N_7_25 0.000749416f $X=0.783 $Y=0.0995
cc_199 N_SETN_12 N_7_27 0.000753542f $X=0.7855 $Y=0.189
cc_200 N_SETN_5 N_7_27 0.00168414f $X=0.9735 $Y=0.111
cc_201 N_SETN_5 N_7_25 0.00197679f $X=0.9735 $Y=0.111
cc_202 N_SETN_8 N_7_4 0.00425701f $X=0.783 $Y=0.111
cc_203 N_SETN_8 N_7_15 0.0352589f $X=0.783 $Y=0.111
cc_204 N_SETN_5 N_RESETN_2 0.000661793f $X=0.9735 $Y=0.111
cc_205 N_SETN_5 N_RESETN_8 0.000210415f $X=0.9735 $Y=0.111
cc_206 N_SETN_5 N_RESETN_10 0.000214078f $X=0.9735 $Y=0.111
cc_207 N_SETN_12 N_RESETN_11 0.000305331f $X=0.7855 $Y=0.189
cc_208 N_SETN_10 N_RESETN_12 0.000347087f $X=0.776 $Y=0.189
cc_209 N_SETN_5 N_RESETN_11 0.000375841f $X=0.9735 $Y=0.111
cc_210 N_SETN_11 N_RESETN_12 0.000481283f $X=0.783 $Y=0.0995
cc_211 N_SETN_5 N_RESETN_1 0.000584766f $X=0.9735 $Y=0.111
cc_212 N_SETN_3 N_RESETN_2 0.000595629f $X=0.999 $Y=0.111
cc_213 N_SETN_1 N_RESETN_1 0.00090241f $X=0.6755 $Y=0.111
cc_214 N_SETN_5 N_RESETN_12 0.00165006f $X=0.9735 $Y=0.111
cc_215 N_SETN_7 N_RESETN_5 0.0073818f $X=0.675 $Y=0.111
cc_216 N_SETN_9 N_RESETN_6 0.00877218f $X=0.999 $Y=0.0245
cc_217 N_SETN_12 N_RESETN_12 0.0194473f $X=0.7855 $Y=0.189
cc_218 N_SETN_2 N_9_9 0.000143757f $X=0.783 $Y=0.111
cc_219 N_SETN_5 N_9_21 0.000176017f $X=0.9735 $Y=0.111
cc_220 N_SETN_1 N_9_9 0.000188897f $X=0.6755 $Y=0.111
cc_221 N_SETN_10 N_9_21 0.000864062f $X=0.776 $Y=0.189
cc_222 N_SETN_12 N_9_22 0.000435311f $X=0.7855 $Y=0.189
cc_223 N_SETN_5 N_9_22 0.000511985f $X=0.9735 $Y=0.111
cc_224 N_SETN_11 N_9_1 0.00065499f $X=0.783 $Y=0.0995
cc_225 N_SETN_11 N_9_21 0.00305899f $X=0.783 $Y=0.0995
cc_226 N_SETN_8 N_9_9 0.00377853f $X=0.783 $Y=0.111
cc_227 N_SETN_5 N_9_1 0.00599884f $X=0.9735 $Y=0.111
cc_228 N_SETN_7 N_9_9 0.0146418f $X=0.675 $Y=0.111
x_PM_DFFASRHQNx1_ASAP7_75t_R%21 vss N_M11_d N_M12_s N_21_1
+ PM_DFFASRHQNx1_ASAP7_75t_R%21
cc_229 N_21_1 N_SETN_9 0.0121585f $X=0.972 $Y=0.054
cc_230 N_21_1 N_12_13 0.0121551f $X=0.972 $Y=0.054
x_PM_DFFASRHQNx1_ASAP7_75t_R%12 vss N_M11_g N_M29_d N_M30_s N_M31_g N_M14_d
+ N_12_1 N_12_7 N_12_13 N_12_9 N_12_8 N_12_3 N_12_16 N_12_15 N_12_6 N_12_10
+ N_12_4 N_12_14 PM_DFFASRHQNx1_ASAP7_75t_R%12
cc_231 N_12_1 N_4_3 0.000579697f $X=0.9455 $Y=0.171
cc_232 N_12_7 N_4_3 0.00114794f $X=0.959 $Y=0.174
cc_233 N_12_13 N_4_15 0.00984501f $X=0.945 $Y=0.0245
cc_234 N_12_13 N_7_19 0.00741556f $X=0.945 $Y=0.0245
cc_235 N_12_7 N_7_5 0.000316688f $X=0.959 $Y=0.174
cc_236 N_12_1 N_7_5 0.000804053f $X=0.9455 $Y=0.171
cc_237 N_12_7 N_7_27 0.00106191f $X=0.959 $Y=0.174
cc_238 N_12_13 N_7_5 0.00136226f $X=0.945 $Y=0.0245
cc_239 N_12_7 N_7_19 0.00269061f $X=0.959 $Y=0.174
cc_240 N_12_13 N_7_18 0.0249755f $X=0.945 $Y=0.0245
cc_241 N_12_9 N_RESETN_2 0.000261058f $X=1.107 $Y=0.174
cc_242 N_12_8 N_RESETN_6 0.000449363f $X=1.08 $Y=0.1875
cc_243 N_12_7 N_RESETN_2 0.00222479f $X=0.959 $Y=0.174
cc_244 N_12_7 N_RESETN_11 0.000656045f $X=0.959 $Y=0.174
cc_245 N_12_3 N_RESETN_2 0.000875862f $X=1.08 $Y=0.174
cc_246 N_12_16 N_RESETN_6 0.00628587f $X=1.0655 $Y=0.2295
cc_247 N_12_7 N_RESETN_6 0.017634f $X=0.959 $Y=0.174
cc_248 N_12_1 N_SETN_9 0.000427205f $X=0.9455 $Y=0.171
cc_249 N_12_13 N_SETN_3 0.000490864f $X=0.945 $Y=0.0245
cc_250 N_12_7 N_SETN_9 0.00293886f $X=0.959 $Y=0.174
cc_251 N_12_13 N_SETN_5 0.00316357f $X=0.945 $Y=0.0245
cc_252 N_12_13 N_SETN_9 0.0135651f $X=0.945 $Y=0.0245
cc_253 N_12_16 N_11_12 0.00649827f $X=1.0655 $Y=0.2295
cc_254 N_12_15 N_11_12 0.0111183f $X=1.1195 $Y=0.054
cc_255 N_12_1 N_11_20 0.000425044f $X=0.9455 $Y=0.171
cc_256 N_12_6 N_11_1 0.000448354f $X=1.159 $Y=0.174
cc_257 N_12_10 N_11_23 0.000474501f $X=1.159 $Y=0.1425
cc_258 N_12_8 N_11_12 0.000521268f $X=1.08 $Y=0.1875
cc_259 N_12_9 N_11_1 0.00576984f $X=1.107 $Y=0.174
cc_260 N_12_3 N_11_1 0.000850423f $X=1.08 $Y=0.174
cc_261 N_12_4 N_11_12 0.000995617f $X=1.134 $Y=0.069
cc_262 N_12_9 N_11_21 0.00117584f $X=1.107 $Y=0.174
cc_263 N_12_7 N_11_20 0.00132878f $X=0.959 $Y=0.174
cc_264 N_12_10 N_11_1 0.00159034f $X=1.159 $Y=0.1425
cc_265 N_12_13 N_11_7 0.00209676f $X=0.945 $Y=0.0245
cc_266 N_12_14 N_11_12 0.0365409f $X=1.161 $Y=0.07
x_PM_DFFASRHQNx1_ASAP7_75t_R%6 vss N_M19_g N_M4_g N_M9_g N_M26_g N_M17_d N_M1_d
+ N_6_7 N_6_20 N_6_8 N_6_21 N_6_18 N_6_25 N_6_19 N_6_1 N_6_16 N_6_17 N_6_23
+ N_6_22 N_6_24 N_6_3 N_6_2 N_6_14 N_6_13 N_6_15 PM_DFFASRHQNx1_ASAP7_75t_R%6
cc_267 N_6_7 N_CLK_6 0.000363528f $X=0.162 $Y=0.054
cc_268 N_6_20 N_CLK_6 7.8715e-20 $X=0.1655 $Y=0.036
cc_269 N_6_8 N_CLK_6 0.000341471f $X=0.162 $Y=0.216
cc_270 N_6_21 N_CLK_6 0.000523244f $X=0.189 $Y=0.089
cc_271 N_6_18 N_CLK_6 0.0020584f $X=0.189 $Y=0.234
cc_272 N_6_20 N_4_18 5.78575e-20 $X=0.1655 $Y=0.036
cc_273 N_6_18 N_4_20 7.52634e-20 $X=0.189 $Y=0.234
cc_274 N_6_20 N_4_7 8.36897e-20 $X=0.1655 $Y=0.036
cc_275 N_6_25 N_4_25 0.000158447f $X=0.1775 $Y=0.117
cc_276 N_6_8 N_4_13 0.00094239f $X=0.162 $Y=0.216
cc_277 N_6_18 N_4_22 0.000198096f $X=0.189 $Y=0.234
cc_278 N_6_19 N_4_23 0.000236105f $X=0.189 $Y=0.036
cc_279 N_6_7 N_4_23 0.000253099f $X=0.162 $Y=0.054
cc_280 N_6_18 N_4_23 0.000287686f $X=0.189 $Y=0.234
cc_281 N_6_1 N_4_2 0.000896126f $X=0.351 $Y=0.135
cc_282 N_6_16 N_4_13 0.0110927f $X=0.1475 $Y=0.054
cc_283 N_6_17 N_4_13 0.0386494f $X=0.1475 $Y=0.216
cc_284 N_6_23 N_4_26 0.00053898f $X=0.459 $Y=0.1055
cc_285 N_6_25 N_4_24 0.000559044f $X=0.1775 $Y=0.117
cc_286 N_6_21 N_4_23 0.00947649f $X=0.189 $Y=0.089
cc_287 N_6_22 N_4_26 0.000605303f $X=0.351 $Y=0.135
cc_288 N_6_24 N_4_26 0.000619294f $X=0.838 $Y=0.1055
cc_289 N_6_21 N_4_1 0.000694495f $X=0.189 $Y=0.089
cc_290 N_6_3 N_4_3 0.00197448f $X=0.837 $Y=0.159
cc_291 N_6_21 N_4_26 0.000805827f $X=0.189 $Y=0.089
cc_292 N_6_23 N_4_24 0.000861073f $X=0.459 $Y=0.1055
cc_293 N_6_7 N_4_13 0.000956264f $X=0.162 $Y=0.054
cc_294 N_6_2 N_4_2 0.0028377f $X=0.459 $Y=0.135
cc_295 N_6_20 N_4_23 0.00112469f $X=0.1655 $Y=0.036
cc_296 N_6_17 N_4_1 0.00122624f $X=0.1475 $Y=0.216
cc_297 N_6_14 N_4_14 0.00237988f $X=0.459 $Y=0.135
cc_298 N_6_24 N_4_25 0.00280479f $X=0.838 $Y=0.1055
cc_299 N_6_22 N_4_24 0.00414248f $X=0.351 $Y=0.135
cc_300 N_6_13 N_4_14 0.00563167f $X=0.351 $Y=0.073
cc_301 N_6_15 N_4_15 0.00670241f $X=0.837 $Y=0.159
cc_302 N_6_25 N_4_26 0.0488155f $X=0.1775 $Y=0.117
cc_303 N_6_8 N_D_3 0.000120245f $X=0.162 $Y=0.216
cc_304 N_6_21 N_D_3 0.000179438f $X=0.189 $Y=0.089
cc_305 N_6_22 N_D_3 0.000747457f $X=0.351 $Y=0.135
cc_306 N_6_1 N_D_3 0.00075322f $X=0.351 $Y=0.135
cc_307 N_6_19 N_D_4 0.00077458f $X=0.189 $Y=0.036
cc_308 N_6_18 N_D_6 0.00117522f $X=0.189 $Y=0.234
cc_309 N_6_1 N_D_1 0.00157262f $X=0.351 $Y=0.135
cc_310 N_6_21 N_D_7 0.00209403f $X=0.189 $Y=0.089
cc_311 N_6_21 N_D_8 0.00214698f $X=0.189 $Y=0.089
cc_312 N_6_25 N_D_9 0.00256879f $X=0.1775 $Y=0.117
cc_313 N_6_21 N_D_5 0.00389001f $X=0.189 $Y=0.089
cc_314 N_6_13 N_D_3 0.00515841f $X=0.351 $Y=0.073
x_PM_DFFASRHQNx1_ASAP7_75t_R%RESETN vss RESETN N_M13_g N_M29_g N_M6_g N_M22_g
+ N_RESETN_10 N_RESETN_9 N_RESETN_7 N_RESETN_12 N_RESETN_8 N_RESETN_5
+ N_RESETN_2 N_RESETN_11 N_RESETN_1 N_RESETN_6 PM_DFFASRHQNx1_ASAP7_75t_R%RESETN
cc_315 N_RESETN_10 N_4_25 0.000151903f $X=0.646 $Y=0.081
cc_316 N_RESETN_9 N_4_26 0.000215865f $X=0.621 $Y=0.113
cc_317 N_RESETN_7 N_4_26 0.000264644f $X=0.621 $Y=0.081
cc_318 N_RESETN_12 N_4_25 0.0018632f $X=0.9785 $Y=0.153
cc_319 N_RESETN_10 N_4_26 0.00207572f $X=0.646 $Y=0.081
cc_320 N_RESETN_8 N_6_25 0.000380107f $X=0.6335 $Y=0.153
cc_321 N_RESETN_12 N_6_24 0.000819862f $X=0.9785 $Y=0.153
cc_322 N_RESETN_9 N_6_25 0.000520398f $X=0.621 $Y=0.113
cc_323 N_RESETN_12 N_6_25 0.0170184f $X=0.9785 $Y=0.153
cc_324 N_RESETN_5 N_7_3 0.00011043f $X=0.621 $Y=0.111
cc_325 N_RESETN_2 N_7_27 0.000288268f $X=1.053 $Y=0.135
cc_326 N_RESETN_11 N_7_27 0.000928368f $X=1.053 $Y=0.114
cc_327 N_RESETN_8 N_7_25 0.00346904f $X=0.6335 $Y=0.153
cc_328 N_RESETN_11 N_7_22 0.000237114f $X=1.053 $Y=0.114
cc_329 N_RESETN_8 N_7_23 0.000256354f $X=0.6335 $Y=0.153
cc_330 N_RESETN_7 N_7_23 0.000680635f $X=0.621 $Y=0.081
cc_331 N_RESETN_9 N_7_23 0.000775558f $X=0.621 $Y=0.113
cc_332 N_RESETN_1 N_7_1 0.00258232f $X=0.621 $Y=0.111
cc_333 N_RESETN_7 N_7_24 0.00136628f $X=0.621 $Y=0.081
cc_334 N_RESETN_12 N_7_27 0.00171769f $X=0.9785 $Y=0.153
cc_335 N_RESETN_12 N_7_28 0.00173565f $X=0.9785 $Y=0.153
cc_336 N_RESETN_10 N_7_24 0.00471086f $X=0.646 $Y=0.081
cc_337 N_RESETN_5 N_7_14 0.0104901f $X=0.621 $Y=0.111
x_PM_DFFASRHQNx1_ASAP7_75t_R%22 vss N_M13_d N_M14_s N_22_1
+ PM_DFFASRHQNx1_ASAP7_75t_R%22
cc_338 N_22_1 N_RESETN_6 0.0121787f $X=1.08 $Y=0.054
cc_339 N_22_1 N_11_12 0.012188f $X=1.08 $Y=0.054
x_PM_DFFASRHQNx1_ASAP7_75t_R%11 vss N_M14_g N_M30_g N_M15_g N_M32_g N_M9_d
+ N_M10_s N_M26_d N_M27_s N_11_16 N_11_17 N_11_20 N_11_7 N_11_5 N_11_19 N_11_6
+ N_11_23 N_11_14 N_11_15 N_11_18 N_11_1 N_11_21 N_11_12 N_11_22 N_11_2 N_11_13
+ PM_DFFASRHQNx1_ASAP7_75t_R%11
cc_340 N_11_16 N_4_15 0.00756654f $X=0.8495 $Y=0.2295
cc_341 N_11_17 N_4_15 0.0039926f $X=0.8495 $Y=0.2025
cc_342 N_11_20 N_4_25 0.00949485f $X=0.927 $Y=0.057
cc_343 N_11_7 N_4_25 0.000357914f $X=0.897 $Y=0.069
cc_344 N_11_5 N_4_15 0.000367726f $X=0.864 $Y=0.069
cc_345 N_11_19 N_4_25 0.000371683f $X=0.909 $Y=0.231
cc_346 N_11_6 N_4_15 0.000751784f $X=0.864 $Y=0.2295
cc_347 N_11_20 N_4_3 0.000751985f $X=0.927 $Y=0.057
cc_348 N_11_16 N_4_3 0.000853144f $X=0.8495 $Y=0.2295
cc_349 N_11_23 N_4_26 0.00132584f $X=1.0375 $Y=0.117
cc_350 N_11_7 N_4_15 0.00140498f $X=0.897 $Y=0.069
cc_351 N_11_5 N_4_26 0.00156082f $X=0.864 $Y=0.069
cc_352 N_11_14 N_4_15 0.00663027f $X=0.8495 $Y=0.0405
cc_353 N_11_15 N_4_15 0.0330197f $X=0.866 $Y=0.0675
cc_354 N_11_20 N_6_25 0.00014705f $X=0.927 $Y=0.057
cc_355 N_11_14 N_6_15 0.00736745f $X=0.8495 $Y=0.0405
cc_356 N_11_19 N_6_24 0.000222258f $X=0.909 $Y=0.231
cc_357 N_11_15 N_6_15 0.00384839f $X=0.866 $Y=0.0675
cc_358 N_11_20 N_6_24 0.000335431f $X=0.927 $Y=0.057
cc_359 N_11_6 N_6_3 0.000354472f $X=0.864 $Y=0.2295
cc_360 N_11_5 N_6_15 0.000361005f $X=0.864 $Y=0.069
cc_361 N_11_6 N_6_24 0.000455655f $X=0.864 $Y=0.2295
cc_362 N_11_16 N_6_3 0.000624632f $X=0.8495 $Y=0.2295
cc_363 N_11_6 N_6_15 0.000703252f $X=0.864 $Y=0.2295
cc_364 N_11_16 N_6_15 0.00687084f $X=0.8495 $Y=0.2295
cc_365 N_11_17 N_6_15 0.0406356f $X=0.8495 $Y=0.2025
cc_366 N_11_6 N_7_5 0.000674861f $X=0.864 $Y=0.2295
cc_367 N_11_15 N_7_16 0.000225181f $X=0.866 $Y=0.0675
cc_368 N_11_7 N_7_27 0.000648829f $X=0.897 $Y=0.069
cc_369 N_11_19 N_7_5 0.000264872f $X=0.909 $Y=0.231
cc_370 N_11_20 N_7_22 0.000826681f $X=0.927 $Y=0.057
cc_371 N_11_16 N_7_18 0.000277117f $X=0.8495 $Y=0.2295
cc_372 N_11_18 N_7_5 0.00166759f $X=0.927 $Y=0.228
cc_373 N_11_17 N_7_18 0.000309527f $X=0.8495 $Y=0.2025
cc_374 N_11_14 N_7_16 0.000335847f $X=0.8495 $Y=0.0405
cc_375 N_11_18 N_7_27 0.000633242f $X=0.927 $Y=0.228
cc_376 N_11_14 N_7_4 0.000800732f $X=0.8495 $Y=0.0405
cc_377 N_11_5 N_7_4 0.00084386f $X=0.864 $Y=0.069
cc_378 N_11_20 N_7_28 0.00158596f $X=0.927 $Y=0.057
cc_379 N_11_23 N_7_28 0.00220106f $X=1.0375 $Y=0.117
cc_380 N_11_20 N_7_27 0.00916904f $X=0.927 $Y=0.057
cc_381 N_11_20 N_RESETN_12 0.000850405f $X=0.927 $Y=0.057
cc_382 N_11_23 N_RESETN_11 0.00060549f $X=1.0375 $Y=0.117
cc_383 N_11_1 N_RESETN_2 0.00207981f $X=1.107 $Y=0.135
cc_384 N_11_21 N_RESETN_11 0.00311934f $X=1.107 $Y=0.1055
cc_385 N_11_12 N_RESETN_6 0.00996859f $X=1.107 $Y=0.0245
cc_386 N_11_23 N_RESETN_12 0.0130308f $X=1.0375 $Y=0.117
cc_387 N_11_21 N_SETN_12 0.000100129f $X=1.107 $Y=0.1055
cc_388 N_11_7 N_SETN_3 0.00010448f $X=0.897 $Y=0.069
cc_389 N_11_19 N_SETN_10 0.000143523f $X=0.909 $Y=0.231
cc_390 N_11_19 N_SETN_12 0.0002666f $X=0.909 $Y=0.231
cc_391 N_11_7 N_SETN_5 0.00251283f $X=0.897 $Y=0.069
cc_392 N_11_23 N_SETN_12 0.000484178f $X=1.0375 $Y=0.117
cc_393 N_11_5 N_SETN_5 0.000917129f $X=0.864 $Y=0.069
cc_394 N_11_20 N_SETN_5 0.00121139f $X=0.927 $Y=0.057
cc_395 N_11_20 N_SETN_12 0.00131688f $X=0.927 $Y=0.057
cc_396 N_11_14 N_SETN_5 0.00526783f $X=0.8495 $Y=0.0405
x_PM_DFFASRHQNx1_ASAP7_75t_R%18 vss N_M5_d N_M6_s N_18_1
+ PM_DFFASRHQNx1_ASAP7_75t_R%18
cc_397 N_18_1 N_7_14 0.00756267f $X=0.594 $Y=0.0405
cc_398 N_18_1 N_RESETN_5 0.00752801f $X=0.594 $Y=0.0405
x_PM_DFFASRHQNx1_ASAP7_75t_R%13 vss N_M20_d N_M21_d N_M22_s N_13_7 N_13_1
+ N_13_8 N_13_2 N_13_9 PM_DFFASRHQNx1_ASAP7_75t_R%13
cc_399 N_13_7 N_4_2 0.000165533f $X=0.4175 $Y=0.216
cc_400 N_13_7 N_4_24 0.000191179f $X=0.4175 $Y=0.216
cc_401 N_13_7 N_4_14 0.0244265f $X=0.4175 $Y=0.216
cc_402 N_13_7 N_6_23 0.000494878f $X=0.4175 $Y=0.216
cc_403 N_13_7 N_6_2 0.000599822f $X=0.4175 $Y=0.216
cc_404 N_13_1 N_6_14 0.000605821f $X=0.432 $Y=0.216
cc_405 N_13_7 N_6_14 0.0271064f $X=0.4175 $Y=0.216
cc_406 N_13_8 N_7_3 0.000114398f $X=0.5795 $Y=0.216
cc_407 N_13_8 N_7_14 0.0247957f $X=0.5795 $Y=0.216
cc_408 N_13_8 N_RESETN_8 0.000353842f $X=0.5795 $Y=0.216
cc_409 N_13_2 N_RESETN_8 0.00038145f $X=0.594 $Y=0.216
cc_410 N_13_2 N_RESETN_5 0.000495692f $X=0.594 $Y=0.216
cc_411 N_13_8 N_RESETN_5 0.0243024f $X=0.5795 $Y=0.216
cc_412 N_13_9 N_9_3 0.0002282f $X=0.4165 $Y=0.234
cc_413 N_13_9 N_9_19 0.000317033f $X=0.4165 $Y=0.234
cc_414 N_13_1 N_9_3 0.00266899f $X=0.432 $Y=0.216
cc_415 N_13_7 N_9_12 0.000436019f $X=0.4175 $Y=0.216
cc_416 N_13_7 N_9_14 0.00054081f $X=0.4175 $Y=0.216
cc_417 N_13_9 N_9_17 0.000554719f $X=0.4165 $Y=0.234
cc_418 N_13_9 N_9_16 0.000795339f $X=0.4165 $Y=0.234
cc_419 N_13_9 N_9_22 0.00148527f $X=0.4165 $Y=0.234
cc_420 N_13_9 N_9_20 0.00625266f $X=0.4165 $Y=0.234

* End of included file DFFASRHQNx1_ASAP7_75t_R.pex.sp.pxi
.ends

.subckt PM_DFFLQNx3_ASAP7_75t_R%CLK vss 18 9 15 3 4 7 1 8 5 6
c1 1 vss 0.00386849f $X=0.081 $Y=0.135
c2 3 vss 0.0688318f $X=0.081 $Y=0.0245
c3 4 vss 0.0025192f $X=0.081 $Y=0.088
c4 5 vss 0.00221098f $X=0.081 $Y=0.182
c5 6 vss 0.00127523f $X=0.081 $Y=0.135
c6 7 vss 0.00415905f $X=0.108 $Y=0.0575
c7 8 vss 0.00395363f $X=0.108 $Y=0.2125
r1 8 24 3.22357 $w=2.26279e-08 $l=3.05e-08 $layer=M1 $thickness=3.6e-08
+ $X=0.108 $Y=0.2125 $X2=0.108 $Y2=0.182
r2 7 22 3.22357 $w=2.26279e-08 $l=3.05e-08 $layer=M1 $thickness=3.6e-08
+ $X=0.108 $Y=0.0575 $X2=0.108 $Y2=0.088
r3 23 24 0.502848 $w=3.43333e-08 $l=1.35e-08 $layer=M1 $thickness=3.6e-08
+ $X=0.0945 $Y=0.182 $X2=0.108 $Y2=0.182
r4 5 20 2.6406 $w=2.38947e-08 $l=2.8e-08 $layer=M1 $thickness=3.6e-08 $X=0.081
+ $Y=0.182 $X2=0.081 $Y2=0.154
r5 5 23 0.502848 $w=3.43333e-08 $l=1.35e-08 $layer=M1 $thickness=3.6e-08
+ $X=0.081 $Y=0.182 $X2=0.0945 $Y2=0.182
r6 21 22 0.502848 $w=3.43333e-08 $l=1.35e-08 $layer=M1 $thickness=3.6e-08
+ $X=0.0945 $Y=0.088 $X2=0.108 $Y2=0.088
r7 4 17 1.76614 $w=2.65738e-08 $l=2.42e-08 $layer=M1 $thickness=3.6e-08
+ $X=0.081 $Y=0.088 $X2=0.081 $Y2=0.1122
r8 4 21 0.502848 $w=3.43333e-08 $l=1.35e-08 $layer=M1 $thickness=3.6e-08
+ $X=0.081 $Y=0.088 $X2=0.0945 $Y2=0.088
r9 18 19 0.874462 $w=1.3e-08 $l=3.7e-09 $layer=M1 $thickness=3.6e-08 $X=0.082
+ $Y=0.119 $X2=0.081 $Y2=0.1227
r10 18 17 1.57403 $w=1.3e-08 $l=6.8e-09 $layer=M1 $thickness=3.6e-08 $X=0.082
+ $Y=0.119 $X2=0.081 $Y2=0.1122
r11 6 19 2.85657 $w=1.3e-08 $l=1.23e-08 $layer=M1 $thickness=3.6e-08 $X=0.081
+ $Y=0.135 $X2=0.081 $Y2=0.1227
r12 6 20 4.43061 $w=1.3e-08 $l=1.9e-08 $layer=M1 $thickness=3.6e-08 $X=0.081
+ $Y=0.135 $X2=0.081 $Y2=0.154
r13 1 12 10.4265 $w=1.765e-08 $layer=LIG $thickness=5.2e-08 $X=0.081 $Y=0.135
+ $X2=0.081 $Y2=0.135
r14 1 6 19.3796 $a=3.24e-16 $layer=V0LIG $X=0.081 $Y=0.135 $X2=0.081 $Y2=0.135
r15 15 14 14.6259 $w=2.1e-08 $l=4.3e-08 $layer=Gate_1 $thickness=5.6e-08
+ $X=0.081 $Y=0.216 $X2=0.081 $Y2=0.173
r16 13 14 7.31297 $w=2.1e-08 $l=2.15e-08 $layer=Gate_1 $thickness=5.6e-08
+ $X=0.081 $Y=0.1515 $X2=0.081 $Y2=0.173
r17 12 13 5.79936 $w=2.03333e-08 $l=1.65e-08 $layer=Gate_1 $thickness=5.6e-08
+ $X=0.081 $Y=0.135 $X2=0.081 $Y2=0.1515
r18 11 12 5.79936 $w=2.03333e-08 $l=1.65e-08 $layer=Gate_1 $thickness=5.6e-08
+ $X=0.081 $Y=0.1185 $X2=0.081 $Y2=0.135
r19 10 11 7.31297 $w=2.1e-08 $l=2.15e-08 $layer=Gate_1 $thickness=5.6e-08
+ $X=0.081 $Y=0.097 $X2=0.081 $Y2=0.1185
r20 9 10 14.6259 $w=2.1e-08 $l=4.3e-08 $layer=Gate_1 $thickness=5.6e-08
+ $X=0.081 $Y=0.054 $X2=0.081 $Y2=0.097
r21 9 3 10.0341 $w=2.1e-08 $l=2.95e-08 $layer=Gate_1 $thickness=5.6e-08
+ $X=0.081 $Y=0.054 $X2=0.081 $Y2=0.0245
.ends

.subckt PM_DFFLQNx3_ASAP7_75t_R%13 vss 7 12 5 1 4
c1 1 vss 0.00591087f $X=0.432 $Y=0.2295
c2 4 vss 0.00165211f $X=0.4175 $Y=0.2295
c3 5 vss 0.00204255f $X=0.488 $Y=0.2295
r1 12 11 0.0925926 $w=2.7e-08 $l=2.5e-09 $layer=P_src_drn $thickness=1e-09
+ $X=0.5033 $Y=0.2295 $X2=0.5005 $Y2=0.2295
r2 5 11 0.462963 $w=2.7e-08 $l=1.25e-08 $layer=P_src_drn $thickness=1e-09
+ $X=0.488 $Y=0.2295 $X2=0.5005 $Y2=0.2295
r3 9 5 9.64198 $w=2.32e-08 $l=2.05e-08 $layer=LISD $thickness=2.7e-08 $X=0.4655
+ $Y=0.2295 $X2=0.488 $Y2=0.2295
r4 8 9 7.05511 $w=2.32e-08 $l=1.5e-08 $layer=LISD $thickness=2.7e-08 $X=0.4505
+ $Y=0.2295 $X2=0.4655 $Y2=0.2295
r5 1 8 8.7013 $w=2.32e-08 $l=1.85e-08 $layer=LISD $thickness=2.7e-08 $X=0.432
+ $Y=0.2295 $X2=0.4505 $Y2=0.2295
r6 4 1 0.462963 $w=2.7e-08 $l=1.25e-08 $layer=P_src_drn $thickness=1e-09
+ $X=0.4175 $Y=0.2295 $X2=0.432 $Y2=0.2295
r7 7 4 0.0925926 $w=2.7e-08 $l=2.5e-09 $layer=P_src_drn $thickness=1e-09
+ $X=0.4146 $Y=0.2295 $X2=0.4175 $Y2=0.2295
.ends

.subckt PM_DFFLQNx3_ASAP7_75t_R%15 vss 2 3 1
c1 1 vss 0.000540393f $X=0.486 $Y=0.0405
r1 2 1 0.62963 $w=2.7e-08 $l=1.7e-08 $layer=N_src_drn $thickness=1e-09
+ $X=0.4686 $Y=0.0405 $X2=0.486 $Y2=0.0405
r2 3 1 0.62963 $w=2.7e-08 $l=1.7e-08 $layer=N_src_drn $thickness=1e-09
+ $X=0.5033 $Y=0.0405 $X2=0.486 $Y2=0.0405
.ends

.subckt PM_DFFLQNx3_ASAP7_75t_R%8 vss 21 25 51 54 60 63 10 18 13 3 19 16 11 1
+ 20 4 12 17 9 14 15
c1 1 vss 0.00024064f $X=0.567 $Y=0.1215
c2 3 vss 0.00466184f $X=0.378 $Y=0.2295
c3 4 vss 0.00473675f $X=0.432 $Y=0.0405
c4 9 vss 0.0386584f $X=0.567 $Y=0.0245
c5 10 vss 0.00195067f $X=0.4175 $Y=0.0405
c6 11 vss 0.000316075f $X=0.4175 $Y=0.081
c7 12 vss 0.00203013f $X=0.3635 $Y=0.2295
c8 13 vss 0.000384339f $X=0.3635 $Y=0.189
c9 14 vss 0.00594515f $X=0.459 $Y=0.036
c10 15 vss 1.30826e-20 $X=0.459 $Y=0.131
c11 16 vss 0.0025979f $X=0.459 $Y=0.234
c12 17 vss 0.00691044f $X=0.434 $Y=0.234
c13 18 vss 0.00124844f $X=0.459 $Y=0.114
c14 19 vss 0.000656627f $X=0.459 $Y=0.1525
c15 20 vss 0.000780726f $X=0.54 $Y=0.131
r1 13 3 0.231482 $w=5.4e-08 $l=1.25e-08 $layer=P_src_drn $thickness=1e-09
+ $X=0.3635 $Y=0.189 $X2=0.378 $Y2=0.2295
r2 63 62 0.0925926 $w=2.7e-08 $l=2.5e-09 $layer=P_src_drn $thickness=1e-09
+ $X=0.3953 $Y=0.2295 $X2=0.3925 $Y2=0.2295
r3 61 62 0.166667 $w=2.7e-08 $l=4.5e-09 $layer=P_src_drn $thickness=1e-09
+ $X=0.388 $Y=0.2295 $X2=0.3925 $Y2=0.2295
r4 3 61 0.444445 $w=2.7e-08 $l=1.2e-08 $layer=P_src_drn $thickness=1e-09
+ $X=0.378 $Y=0.2295 $X2=0.388 $Y2=0.2295
r5 12 3 0.462963 $w=2.7e-08 $l=1.25e-08 $layer=P_src_drn $thickness=1e-09
+ $X=0.3635 $Y=0.2295 $X2=0.378 $Y2=0.2295
r6 60 12 0.0925926 $w=2.7e-08 $l=2.5e-09 $layer=P_src_drn $thickness=1e-09
+ $X=0.3606 $Y=0.2025 $X2=0.3635 $Y2=0.2295
r7 3 48 19.3796 $a=3.24e-16 $layer=V0LISD $X=0.378 $Y=0.2295 $X2=0.378 $Y2=0.234
r8 11 42 0.231482 $w=5.4e-08 $l=1.25e-08 $layer=N_src_drn $thickness=1e-09
+ $X=0.4175 $Y=0.081 $X2=0.432 $Y2=0.0685
r9 54 53 0.0925926 $w=2.7e-08 $l=2.5e-09 $layer=N_src_drn $thickness=1e-09
+ $X=0.4493 $Y=0.0405 $X2=0.4465 $Y2=0.0405
r10 52 53 0.166667 $w=2.7e-08 $l=4.5e-09 $layer=N_src_drn $thickness=1e-09
+ $X=0.442 $Y=0.0405 $X2=0.4465 $Y2=0.0405
r11 42 52 0.444445 $w=2.7e-08 $l=1.2e-08 $layer=N_src_drn $thickness=1e-09
+ $X=0.432 $Y=0.0685 $X2=0.442 $Y2=0.0405
r12 10 42 0.462963 $w=2.7e-08 $l=1.25e-08 $layer=N_src_drn $thickness=1e-09
+ $X=0.4175 $Y=0.0405 $X2=0.432 $Y2=0.0685
r13 51 10 0.0925926 $w=2.7e-08 $l=2.5e-09 $layer=N_src_drn $thickness=1e-09
+ $X=0.4146 $Y=0.0675 $X2=0.4175 $Y2=0.0405
r14 48 49 3.14806 $w=1.3e-08 $l=1.35e-08 $layer=M1 $thickness=3.6e-08 $X=0.378
+ $Y=0.234 $X2=0.3915 $Y2=0.234
r15 46 49 3.14806 $w=1.3e-08 $l=1.35e-08 $layer=M1 $thickness=3.6e-08 $X=0.405
+ $Y=0.234 $X2=0.3915 $Y2=0.234
r16 45 46 2.56509 $w=1.3e-08 $l=1.1e-08 $layer=M1 $thickness=3.6e-08 $X=0.416
+ $Y=0.234 $X2=0.405 $Y2=0.234
r17 17 45 4.19742 $w=1.3e-08 $l=1.8e-08 $layer=M1 $thickness=3.6e-08 $X=0.434
+ $Y=0.234 $X2=0.416 $Y2=0.234
r18 4 40 19.3796 $a=3.24e-16 $layer=V0LISD $X=0.432 $Y=0.0405 $X2=0.432
+ $Y2=0.036
r19 4 42 16.5033 $w=2.02e-08 $l=2.8e-08 $layer=LISD $thickness=2.7e-08 $X=0.432
+ $Y=0.0405 $X2=0.432 $Y2=0.0685
r20 16 38 3.01468 $w=1.741e-08 $l=2e-08 $layer=M1 $thickness=3.6e-08 $X=0.459
+ $Y=0.234 $X2=0.459 $Y2=0.214
r21 16 17 4.18063 $w=1.48e-08 $l=2.5e-08 $layer=M1 $thickness=3.6e-08 $X=0.459
+ $Y=0.234 $X2=0.434 $Y2=0.234
r22 40 41 3.14806 $w=1.3e-08 $l=1.35e-08 $layer=M1 $thickness=3.6e-08 $X=0.432
+ $Y=0.036 $X2=0.4455 $Y2=0.036
r23 14 35 5.11582 $w=1.46667e-08 $l=2.7e-08 $layer=M1 $thickness=3.6e-08
+ $X=0.459 $Y=0.036 $X2=0.459 $Y2=0.063
r24 14 41 1.96775 $w=1.63333e-08 $l=1.35e-08 $layer=M1 $thickness=3.6e-08
+ $X=0.459 $Y=0.036 $X2=0.4455 $Y2=0.036
r25 37 38 6.7625 $w=1.3e-08 $l=2.9e-08 $layer=M1 $thickness=3.6e-08 $X=0.459
+ $Y=0.185 $X2=0.459 $Y2=0.214
r26 36 37 4.43061 $w=1.3e-08 $l=1.9e-08 $layer=M1 $thickness=3.6e-08 $X=0.459
+ $Y=0.166 $X2=0.459 $Y2=0.185
r27 19 36 3.14806 $w=1.3e-08 $l=1.35e-08 $layer=M1 $thickness=3.6e-08 $X=0.459
+ $Y=0.1525 $X2=0.459 $Y2=0.166
r28 34 35 6.29612 $w=1.3e-08 $l=2.7e-08 $layer=M1 $thickness=3.6e-08 $X=0.459
+ $Y=0.09 $X2=0.459 $Y2=0.063
r29 33 34 2.91487 $w=1.3e-08 $l=1.25e-08 $layer=M1 $thickness=3.6e-08 $X=0.459
+ $Y=0.1025 $X2=0.459 $Y2=0.09
r30 18 33 2.68168 $w=1.3e-08 $l=1.15e-08 $layer=M1 $thickness=3.6e-08 $X=0.459
+ $Y=0.114 $X2=0.459 $Y2=0.1025
r31 15 31 4.18306 $w=1.49565e-08 $l=2.3e-08 $layer=M1 $thickness=3.6e-08
+ $X=0.459 $Y=0.131 $X2=0.482 $Y2=0.131
r32 15 18 2.78392 $w=1.56471e-08 $l=1.7e-08 $layer=M1 $thickness=3.6e-08
+ $X=0.459 $Y=0.131 $X2=0.459 $Y2=0.114
r33 15 19 3.83327 $w=1.5093e-08 $l=2.15e-08 $layer=M1 $thickness=3.6e-08
+ $X=0.459 $Y=0.131 $X2=0.459 $Y2=0.1525
r34 30 31 4.19742 $w=1.3e-08 $l=1.8e-08 $layer=M1 $thickness=3.6e-08 $X=0.5
+ $Y=0.131 $X2=0.482 $Y2=0.131
r35 29 30 3.03147 $w=1.3e-08 $l=1.3e-08 $layer=M1 $thickness=3.6e-08 $X=0.513
+ $Y=0.131 $X2=0.5 $Y2=0.131
r36 20 28 6.29612 $w=1.3e-08 $l=2.7e-08 $layer=M1 $thickness=3.6e-08 $X=0.54
+ $Y=0.131 $X2=0.567 $Y2=0.131
r37 20 29 6.29612 $w=1.3e-08 $l=2.7e-08 $layer=M1 $thickness=3.6e-08 $X=0.54
+ $Y=0.131 $X2=0.513 $Y2=0.131
r38 27 28 19.3796 $a=3.24e-16 $layer=V0LIG $X=0.567 $Y=0.133 $X2=0.567 $Y2=0.131
r39 1 23 5.58398 $w=1.91607e-08 $l=9e-09 $layer=Gate_1 $thickness=5.45714e-08
+ $X=0.567 $Y=0.1215 $X2=0.567 $Y2=0.1305
r40 1 27 6.79332 $w=1.53e-08 $l=1.15e-08 $layer=LIG $thickness=4.8e-08 $X=0.567
+ $Y=0.1215 $X2=0.567 $Y2=0.133
r41 25 24 17.177 $w=2.1e-08 $l=5.05e-08 $layer=Gate_1 $thickness=5.6e-08
+ $X=0.567 $Y=0.2295 $X2=0.567 $Y2=0.179
r42 23 24 16.6923 $w=2.07629e-08 $l=4.85e-08 $layer=Gate_1 $thickness=5.6e-08
+ $X=0.567 $Y=0.1305 $X2=0.567 $Y2=0.179
r43 22 23 15.1617 $w=2.07386e-08 $l=4.4e-08 $layer=Gate_1 $thickness=5.6e-08
+ $X=0.567 $Y=0.0865 $X2=0.567 $Y2=0.1305
r44 21 22 15.6464 $w=2.1e-08 $l=4.6e-08 $layer=Gate_1 $thickness=5.6e-08
+ $X=0.567 $Y=0.0405 $X2=0.567 $Y2=0.0865
r45 21 9 5.44221 $w=2.1e-08 $l=1.6e-08 $layer=Gate_1 $thickness=5.6e-08
+ $X=0.567 $Y=0.0405 $X2=0.567 $Y2=0.0245
.ends

.subckt PM_DFFLQNx3_ASAP7_75t_R%17 vss 2 3 1
c1 1 vss 0.000558281f $X=0.756 $Y=0.2295
r1 2 1 0.62963 $w=2.7e-08 $l=1.7e-08 $layer=P_src_drn $thickness=1e-09
+ $X=0.7386 $Y=0.2295 $X2=0.756 $Y2=0.2295
r2 3 1 0.62963 $w=2.7e-08 $l=1.7e-08 $layer=P_src_drn $thickness=1e-09
+ $X=0.7733 $Y=0.2295 $X2=0.756 $Y2=0.2295
.ends

.subckt PM_DFFLQNx3_ASAP7_75t_R%D vss 16 7 13 3 1 6 5 4
c1 1 vss 0.00504577f $X=0.297 $Y=0.135
c2 3 vss 0.091856f $X=0.297 $Y=0.0245
c3 4 vss 0.00537223f $X=0.297 $Y=0.036
c4 5 vss 0.0051273f $X=0.297 $Y=0.234
c5 6 vss 0.00582225f $X=0.297 $Y=0.116
r1 5 20 3.48349 $w=1.525e-08 $l=2e-08 $layer=M1 $thickness=3.6e-08 $X=0.297
+ $Y=0.234 $X2=0.297 $Y2=0.214
r2 4 15 5.17411 $w=1.46514e-08 $l=2.72e-08 $layer=M1 $thickness=3.6e-08
+ $X=0.297 $Y=0.036 $X2=0.297 $Y2=0.0632
r3 19 20 9.44419 $w=1.3e-08 $l=4.05e-08 $layer=M1 $thickness=3.6e-08 $X=0.297
+ $Y=0.1735 $X2=0.297 $Y2=0.214
r4 18 19 8.97781 $w=1.3e-08 $l=3.85e-08 $layer=M1 $thickness=3.6e-08 $X=0.297
+ $Y=0.135 $X2=0.297 $Y2=0.1735
r5 16 17 2.85657 $w=1.3e-08 $l=1.22e-08 $layer=M1 $thickness=3.6e-08 $X=0.298
+ $Y=0.082 $X2=0.297 $Y2=0.0942
r6 16 15 4.37231 $w=1.3e-08 $l=1.88e-08 $layer=M1 $thickness=3.6e-08 $X=0.298
+ $Y=0.082 $X2=0.297 $Y2=0.0632
r7 6 17 5.07188 $w=1.3e-08 $l=2.18e-08 $layer=M1 $thickness=3.6e-08 $X=0.297
+ $Y=0.116 $X2=0.297 $Y2=0.0942
r8 6 18 4.43061 $w=1.3e-08 $l=1.9e-08 $layer=M1 $thickness=3.6e-08 $X=0.297
+ $Y=0.116 $X2=0.297 $Y2=0.135
r9 1 10 10.4265 $w=1.765e-08 $layer=LIG $thickness=5.2e-08 $X=0.297 $Y=0.135
+ $X2=0.297 $Y2=0.135
r10 1 18 19.3796 $a=3.24e-16 $layer=V0LIG $X=0.297 $Y=0.135 $X2=0.297 $Y2=0.135
r11 13 12 14.6259 $w=2.1e-08 $l=4.3e-08 $layer=Gate_1 $thickness=5.6e-08
+ $X=0.297 $Y=0.2025 $X2=0.297 $Y2=0.1595
r12 11 12 2.7211 $w=2.1e-08 $l=8e-09 $layer=Gate_1 $thickness=5.6e-08 $X=0.297
+ $Y=0.1515 $X2=0.297 $Y2=0.1595
r13 10 11 5.79936 $w=2.03333e-08 $l=1.65e-08 $layer=Gate_1 $thickness=5.6e-08
+ $X=0.297 $Y=0.135 $X2=0.297 $Y2=0.1515
r14 9 10 5.79936 $w=2.03333e-08 $l=1.65e-08 $layer=Gate_1 $thickness=5.6e-08
+ $X=0.297 $Y=0.1185 $X2=0.297 $Y2=0.135
r15 8 9 2.7211 $w=2.1e-08 $l=8e-09 $layer=Gate_1 $thickness=5.6e-08 $X=0.297
+ $Y=0.1105 $X2=0.297 $Y2=0.1185
r16 7 8 14.6259 $w=2.1e-08 $l=4.3e-08 $layer=Gate_1 $thickness=5.6e-08 $X=0.297
+ $Y=0.0675 $X2=0.297 $Y2=0.1105
r17 7 3 14.6259 $w=2.1e-08 $l=4.3e-08 $layer=Gate_1 $thickness=5.6e-08 $X=0.297
+ $Y=0.0675 $X2=0.297 $Y2=0.0245
.ends

.subckt PM_DFFLQNx3_ASAP7_75t_R%4 vss 41 47 95 104 108 113 116 118 23 24 26 27
+ 9 8 33 21 22 32 31 1 30 36 28 16 34 2 17 4 5 35 10 3 19 18 20
c1 1 vss 0.00239126f $X=0.135 $Y=0.135
c2 2 vss 0.000504636f $X=0.351 $Y=0.135
c3 3 vss 7.75268e-20 $X=0.459 $Y=0.178
c4 4 vss 4.351e-20 $X=0.621 $Y=0.178
c5 5 vss 0.000885621f $X=0.729 $Y=0.178
c6 8 vss 0.00829902f $X=0.054 $Y=0.054
c7 9 vss 0.00821965f $X=0.054 $Y=0.216
c8 10 vss 0.00457629f $X=0.501 $Y=0.178
c9 16 vss 0.0708123f $X=0.135 $Y=0.0245
c10 17 vss 0.00802354f $X=0.351 $Y=0.135
c11 18 vss 0.00668103f $X=0.459 $Y=0.178
c12 19 vss 0.00615408f $X=0.621 $Y=0.178
c13 20 vss 0.007367f $X=0.729 $Y=0.178
c14 21 vss 0.0329822f $X=0.056 $Y=0.054
c15 22 vss 0.0329213f $X=0.056 $Y=0.216
c16 23 vss 0.00427803f $X=0.018 $Y=0.036
c17 24 vss 0.00330979f $X=0.0165 $Y=0.189
c18 25 vss 0.00410123f $X=0.018 $Y=0.234
c19 26 vss 0.00146419f $X=0.189 $Y=0.189
c20 27 vss 0.000716288f $X=0.189 $Y=0.135
c21 28 vss 0.0122129f $X=0.018 $Y=0.172
c22 29 vss 0.00257295f $X=0.018 $Y=0.199
c23 30 vss 0.0050005f $X=0.036 $Y=0.036
c24 31 vss 0.00396049f $X=0.036 $Y=0.234
c25 32 vss 0.00135772f $X=0.1235 $Y=0.135
c26 33 vss 0.000508221f $X=0.189 $Y=0.154
c27 34 vss 0.00133469f $X=0.351 $Y=0.1735
c28 35 vss 0.0014894f $X=0.513 $Y=0.168
c29 36 vss 0.0327388f $X=0.0215 $Y=0.189
r1 118 117 0.0462963 $w=5.4e-08 $l=2.5e-09 $layer=P_src_drn $thickness=1e-09
+ $X=0.0713 $Y=0.216 $X2=0.0685 $Y2=0.216
r2 22 117 0.231482 $w=5.4e-08 $l=1.25e-08 $layer=P_src_drn $thickness=1e-09
+ $X=0.056 $Y=0.216 $X2=0.0685 $Y2=0.216
r3 116 115 0.0462963 $w=5.4e-08 $l=2.5e-09 $layer=N_src_drn $thickness=1e-09
+ $X=0.0713 $Y=0.054 $X2=0.0685 $Y2=0.054
r4 21 115 0.231482 $w=5.4e-08 $l=1.25e-08 $layer=N_src_drn $thickness=1e-09
+ $X=0.056 $Y=0.054 $X2=0.0685 $Y2=0.054
r5 9 101 19.3796 $a=3.24e-16 $layer=V0LISD $X=0.054 $Y=0.216 $X2=0.055 $Y2=0.234
r6 8 98 19.3796 $a=3.24e-16 $layer=V0LISD $X=0.054 $Y=0.054 $X2=0.055 $Y2=0.036
r7 113 112 8.84359 $w=2.1e-08 $l=2.6e-08 $layer=Gate_1 $thickness=5.6e-08
+ $X=0.729 $Y=0.2295 $X2=0.729 $Y2=0.2035
r8 20 112 8.89461 $w=2.04902e-08 $l=2.55e-08 $layer=Gate_1 $thickness=5.6e-08
+ $X=0.729 $Y=0.178 $X2=0.729 $Y2=0.2035
r9 108 109 23.4695 $w=2.1e-08 $l=6.9e-08 $layer=Gate_1 $thickness=5.6e-08
+ $X=0.621 $Y=0.0405 $X2=0.621 $Y2=0.1095
r10 19 109 23.5205 $w=2.08102e-08 $l=6.85e-08 $layer=Gate_1 $thickness=5.6e-08
+ $X=0.621 $Y=0.178 $X2=0.621 $Y2=0.1095
r11 104 105 23.4695 $w=2.1e-08 $l=6.9e-08 $layer=Gate_1 $thickness=5.6e-08
+ $X=0.459 $Y=0.0405 $X2=0.459 $Y2=0.1095
r12 18 105 23.5205 $w=2.08102e-08 $l=6.85e-08 $layer=Gate_1 $thickness=5.6e-08
+ $X=0.459 $Y=0.178 $X2=0.459 $Y2=0.1095
r13 100 101 2.09871 $w=1.3e-08 $l=9e-09 $layer=M1 $thickness=3.6e-08 $X=0.046
+ $Y=0.234 $X2=0.055 $Y2=0.234
r14 31 100 2.3319 $w=1.3e-08 $l=1e-08 $layer=M1 $thickness=3.6e-08 $X=0.036
+ $Y=0.234 $X2=0.046 $Y2=0.234
r15 97 98 2.09871 $w=1.3e-08 $l=9e-09 $layer=M1 $thickness=3.6e-08 $X=0.046
+ $Y=0.036 $X2=0.055 $Y2=0.036
r16 30 97 2.3319 $w=1.3e-08 $l=1e-08 $layer=M1 $thickness=3.6e-08 $X=0.036
+ $Y=0.036 $X2=0.046 $Y2=0.036
r17 5 92 2.78395 $w=2.4e-08 $l=4e-09 $layer=LIG $thickness=4.8e-08 $X=0.729
+ $Y=0.178 $X2=0.725 $Y2=0.178
r18 5 20 7.42683 $w=2.2e-08 $layer=Gate_1 $thickness=5.2e-08 $X=0.729 $Y=0.178
+ $X2=0.729 $Y2=0.178
r19 4 87 10.3807 $w=2.30357e-08 $layer=LISD $thickness=3.675e-08 $X=0.621
+ $Y=0.178 $X2=0.621 $Y2=0.178
r20 4 19 7.42683 $w=2.2e-08 $layer=Gate_1 $thickness=5.2e-08 $X=0.621 $Y=0.178
+ $X2=0.621 $Y2=0.178
r21 3 83 2.78395 $w=2.4e-08 $l=5e-09 $layer=LIG $thickness=4.8e-08 $X=0.459
+ $Y=0.178 $X2=0.464 $Y2=0.178
r22 3 18 7.42683 $w=2.2e-08 $layer=Gate_1 $thickness=5.2e-08 $X=0.459 $Y=0.178
+ $X2=0.459 $Y2=0.178
r23 95 94 16.4967 $w=2.1e-08 $l=4.85e-08 $layer=Gate_1 $thickness=5.6e-08
+ $X=0.351 $Y=0.2025 $X2=0.351 $Y2=0.154
r24 17 94 6.6497 $w=2.04211e-08 $l=1.9e-08 $layer=Gate_1 $thickness=5.6e-08
+ $X=0.351 $Y=0.135 $X2=0.351 $Y2=0.154
r25 25 79 3.36447 $w=1.71023e-08 $l=2.15e-08 $layer=M1 $thickness=3.6e-08
+ $X=0.018 $Y=0.234 $X2=0.018 $Y2=0.2125
r26 25 31 2.5483 $w=1.55e-08 $l=1.8e-08 $layer=M1 $thickness=3.6e-08 $X=0.018
+ $Y=0.234 $X2=0.036 $Y2=0.234
r27 23 78 3.36447 $w=1.71023e-08 $l=2.15e-08 $layer=M1 $thickness=3.6e-08
+ $X=0.018 $Y=0.036 $X2=0.018 $Y2=0.0575
r28 23 30 2.5483 $w=1.55e-08 $l=1.8e-08 $layer=M1 $thickness=3.6e-08 $X=0.018
+ $Y=0.036 $X2=0.036 $Y2=0.036
r29 91 92 4.8113 $w=2.22e-08 $l=1.5e-09 $layer=LISD $thickness=2.7e-08
+ $X=0.7235 $Y=0.178 $X2=0.725 $Y2=0.178
r30 90 91 10.8887 $w=2.22e-08 $l=2.15e-08 $layer=LISD $thickness=2.7e-08
+ $X=0.702 $Y=0.178 $X2=0.7235 $Y2=0.178
r31 89 90 13.6742 $w=2.22e-08 $l=2.7e-08 $layer=LISD $thickness=2.7e-08
+ $X=0.675 $Y=0.178 $X2=0.702 $Y2=0.178
r32 88 89 13.6742 $w=2.22e-08 $l=2.7e-08 $layer=LISD $thickness=2.7e-08
+ $X=0.648 $Y=0.178 $X2=0.675 $Y2=0.178
r33 87 88 13.6742 $w=2.22e-08 $l=2.7e-08 $layer=LISD $thickness=2.7e-08
+ $X=0.621 $Y=0.178 $X2=0.648 $Y2=0.178
r34 86 87 13.6742 $w=2.22e-08 $l=2.7e-08 $layer=LISD $thickness=2.7e-08
+ $X=0.594 $Y=0.178 $X2=0.621 $Y2=0.178
r35 85 86 13.6742 $w=2.22e-08 $l=2.7e-08 $layer=LISD $thickness=2.7e-08
+ $X=0.567 $Y=0.178 $X2=0.594 $Y2=0.178
r36 84 85 13.6742 $w=2.22e-08 $l=2.7e-08 $layer=LISD $thickness=2.7e-08 $X=0.54
+ $Y=0.178 $X2=0.567 $Y2=0.178
r37 82 83 10.3823 $w=2.22e-08 $l=1.35e-08 $layer=LISD $thickness=2.7e-08
+ $X=0.4775 $Y=0.178 $X2=0.464 $Y2=0.178
r38 81 84 7.59679 $w=2.22e-08 $l=1.5e-08 $layer=LISD $thickness=2.7e-08
+ $X=0.525 $Y=0.178 $X2=0.54 $Y2=0.178
r39 80 81 6.07743 $w=2.22e-08 $l=1.2e-08 $layer=LISD $thickness=2.7e-08
+ $X=0.513 $Y=0.178 $X2=0.525 $Y2=0.178
r40 10 80 6.07743 $w=2.22e-08 $l=1.2e-08 $layer=LISD $thickness=2.7e-08
+ $X=0.501 $Y=0.178 $X2=0.513 $Y2=0.178
r41 10 82 11.9016 $w=2.22e-08 $l=2.35e-08 $layer=LISD $thickness=2.7e-08
+ $X=0.501 $Y=0.178 $X2=0.4775 $Y2=0.178
r42 2 72 19.3796 $a=3.24e-16 $layer=V0LIG $X=0.351 $Y=0.135 $X2=0.351 $Y2=0.135
r43 2 17 10.4265 $w=1.765e-08 $layer=LIG $thickness=5.2e-08 $X=0.351 $Y=0.135
+ $X2=0.351 $Y2=0.135
r44 29 79 3.14806 $w=1.3e-08 $l=1.35e-08 $layer=M1 $thickness=3.6e-08 $X=0.018
+ $Y=0.199 $X2=0.018 $Y2=0.2125
r45 77 78 7.11229 $w=1.3e-08 $l=3.05e-08 $layer=M1 $thickness=3.6e-08 $X=0.018
+ $Y=0.088 $X2=0.018 $Y2=0.0575
r46 76 77 10.9599 $w=1.3e-08 $l=4.7e-08 $layer=M1 $thickness=3.6e-08 $X=0.018
+ $Y=0.135 $X2=0.018 $Y2=0.088
r47 28 76 8.62802 $w=1.3e-08 $l=3.7e-08 $layer=M1 $thickness=3.6e-08 $X=0.018
+ $Y=0.172 $X2=0.018 $Y2=0.135
r48 74 80 19.3796 $a=3.24e-16 $layer=V0LISD $X=0.513 $Y=0.1845 $X2=0.513
+ $Y2=0.178
r49 35 74 3.84763 $w=1.3e-08 $l=1.65e-08 $layer=M1 $thickness=3.6e-08 $X=0.513
+ $Y=0.168 $X2=0.513 $Y2=0.1845
r50 72 73 4.78039 $w=1.3e-08 $l=2.05e-08 $layer=M1 $thickness=3.6e-08 $X=0.351
+ $Y=0.135 $X2=0.351 $Y2=0.1555
r51 34 70 3.61444 $w=1.3e-08 $l=1.55e-08 $layer=M1 $thickness=3.6e-08 $X=0.351
+ $Y=0.1735 $X2=0.351 $Y2=0.189
r52 34 73 4.19742 $w=1.3e-08 $l=1.8e-08 $layer=M1 $thickness=3.6e-08 $X=0.351
+ $Y=0.1735 $X2=0.351 $Y2=0.1555
r53 67 68 1.90199 $w=1.38333e-08 $l=9e-09 $layer=M1 $thickness=3.6e-08
+ $X=0.0255 $Y=0.189 $X2=0.0345 $Y2=0.189
r54 24 67 0.9184 $w=1.8e-08 $l=9e-09 $layer=M1 $thickness=3.6e-08 $X=0.0165
+ $Y=0.189 $X2=0.0255 $Y2=0.189
r55 24 28 2.63085 $w=1.54194e-08 $l=1.7066e-08 $layer=M1 $thickness=3.6e-08
+ $X=0.0165 $Y=0.189 $X2=0.018 $Y2=0.172
r56 24 29 0.998523 $w=1.74118e-08 $l=1.01119e-08 $layer=M1 $thickness=3.6e-08
+ $X=0.0165 $Y=0.189 $X2=0.018 $Y2=0.199
r57 65 74 19.5347 $a=3.24e-16 $layer=V1 $X=0.513 $Y=0.189 $X2=0.513 $Y2=0.1845
r58 64 65 18.8884 $w=1.3e-08 $l=8.1e-08 $layer=M2 $thickness=3.6e-08 $X=0.432
+ $Y=0.189 $X2=0.513 $Y2=0.189
r59 63 64 18.8884 $w=1.3e-08 $l=8.1e-08 $layer=M2 $thickness=3.6e-08 $X=0.351
+ $Y=0.189 $X2=0.432 $Y2=0.189
r60 63 70 19.5347 $a=3.24e-16 $layer=V1 $X=0.351 $Y=0.189 $X2=0.351 $Y2=0.189
r61 62 63 15.2739 $w=1.3e-08 $l=6.55e-08 $layer=M2 $thickness=3.6e-08 $X=0.2855
+ $Y=0.189 $X2=0.351 $Y2=0.189
r62 61 62 20.2875 $w=1.3e-08 $l=8.7e-08 $layer=M2 $thickness=3.6e-08 $X=0.1985
+ $Y=0.189 $X2=0.2855 $Y2=0.189
r63 60 61 9.211 $w=1.3e-08 $l=3.95e-08 $layer=M2 $thickness=3.6e-08 $X=0.159
+ $Y=0.189 $X2=0.1985 $Y2=0.189
r64 59 60 14.691 $w=1.3e-08 $l=6.3e-08 $layer=M2 $thickness=3.6e-08 $X=0.096
+ $Y=0.189 $X2=0.159 $Y2=0.189
r65 58 59 14.691 $w=1.3e-08 $l=6.3e-08 $layer=M2 $thickness=3.6e-08 $X=0.033
+ $Y=0.189 $X2=0.096 $Y2=0.189
r66 58 68 19.5347 $a=3.24e-16 $layer=V1 $X=0.033 $Y=0.189 $X2=0.0345 $Y2=0.189
r67 36 58 2.68168 $w=1.3e-08 $l=1.15e-08 $layer=M2 $thickness=3.6e-08 $X=0.0215
+ $Y=0.189 $X2=0.033 $Y2=0.189
r68 55 56 3.49785 $w=1.3e-08 $l=1.5e-08 $layer=M1 $thickness=3.6e-08 $X=0.159
+ $Y=0.189 $X2=0.174 $Y2=0.189
r69 55 60 19.5347 $a=3.24e-16 $layer=V1 $X=0.159 $Y=0.189 $X2=0.159 $Y2=0.189
r70 26 53 2.78392 $w=1.56471e-08 $l=1.7e-08 $layer=M1 $thickness=3.6e-08
+ $X=0.189 $Y=0.189 $X2=0.189 $Y2=0.172
r71 26 56 2.31754 $w=1.6e-08 $l=1.5e-08 $layer=M1 $thickness=3.6e-08 $X=0.189
+ $Y=0.189 $X2=0.174 $Y2=0.189
r72 33 53 4.19742 $w=1.3e-08 $l=1.8e-08 $layer=M1 $thickness=3.6e-08 $X=0.189
+ $Y=0.154 $X2=0.189 $Y2=0.172
r73 27 52 4.18063 $w=1.48e-08 $l=2.5e-08 $layer=M1 $thickness=3.6e-08 $X=0.189
+ $Y=0.135 $X2=0.164 $Y2=0.135
r74 27 33 2.78149 $w=1.76421e-08 $l=1.9e-08 $layer=M1 $thickness=3.6e-08
+ $X=0.189 $Y=0.135 $X2=0.189 $Y2=0.154
r75 51 52 4.08082 $w=1.3e-08 $l=1.75e-08 $layer=M1 $thickness=3.6e-08 $X=0.1465
+ $Y=0.135 $X2=0.164 $Y2=0.135
r76 50 51 0.46638 $w=1.3e-08 $l=2e-09 $layer=M1 $thickness=3.6e-08 $X=0.1445
+ $Y=0.135 $X2=0.1465 $Y2=0.135
r77 49 50 2.2153 $w=1.3e-08 $l=9.5e-09 $layer=M1 $thickness=3.6e-08 $X=0.135
+ $Y=0.135 $X2=0.1445 $Y2=0.135
r78 32 49 2.68168 $w=1.3e-08 $l=1.15e-08 $layer=M1 $thickness=3.6e-08 $X=0.1235
+ $Y=0.135 $X2=0.135 $Y2=0.135
r79 1 44 10.4265 $w=1.765e-08 $layer=LIG $thickness=5.2e-08 $X=0.135 $Y=0.135
+ $X2=0.135 $Y2=0.135
r80 1 49 19.3796 $a=3.24e-16 $layer=V0LIG $X=0.135 $Y=0.135 $X2=0.135 $Y2=0.135
r81 47 46 14.6259 $w=2.1e-08 $l=4.3e-08 $layer=Gate_1 $thickness=5.6e-08
+ $X=0.135 $Y=0.216 $X2=0.135 $Y2=0.173
r82 45 46 7.31297 $w=2.1e-08 $l=2.15e-08 $layer=Gate_1 $thickness=5.6e-08
+ $X=0.135 $Y=0.1515 $X2=0.135 $Y2=0.173
r83 44 45 5.79936 $w=2.03333e-08 $l=1.65e-08 $layer=Gate_1 $thickness=5.6e-08
+ $X=0.135 $Y=0.135 $X2=0.135 $Y2=0.1515
r84 43 44 5.79936 $w=2.03333e-08 $l=1.65e-08 $layer=Gate_1 $thickness=5.6e-08
+ $X=0.135 $Y=0.1185 $X2=0.135 $Y2=0.135
r85 42 43 7.31297 $w=2.1e-08 $l=2.15e-08 $layer=Gate_1 $thickness=5.6e-08
+ $X=0.135 $Y=0.097 $X2=0.135 $Y2=0.1185
r86 41 42 14.6259 $w=2.1e-08 $l=4.3e-08 $layer=Gate_1 $thickness=5.6e-08
+ $X=0.135 $Y=0.054 $X2=0.135 $Y2=0.097
r87 41 16 10.0341 $w=2.1e-08 $l=2.95e-08 $layer=Gate_1 $thickness=5.6e-08
+ $X=0.135 $Y=0.054 $X2=0.135 $Y2=0.0245
r88 9 22 1e-05 $l=2e-09 $X=0.054 $Y=0.216 $X2=0.056 $Y2=0.216
r89 8 21 1e-05 $l=2e-09 $X=0.054 $Y=0.054 $X2=0.056 $Y2=0.054
.ends

.subckt PM_DFFLQNx3_ASAP7_75t_R%6 vss 26 30 61 64 67 69 5 6 18 17 13 12 16 14
+ 22 2 11 21 20 19 1 15
c1 1 vss 0.000295401f $X=0.405 $Y=0.133
c2 2 vss 0.00051423f $X=0.675 $Y=0.135
c3 5 vss 0.00775268f $X=0.162 $Y=0.054
c4 6 vss 0.00754244f $X=0.162 $Y=0.216
c5 11 vss 0.00745112f $X=0.405 $Y=0.0245
c6 12 vss 0.0076724f $X=0.675 $Y=0.135
c7 13 vss 0.0324712f $X=0.1475 $Y=0.054
c8 14 vss 0.0323368f $X=0.1475 $Y=0.216
c9 15 vss 0.00308428f $X=0.243 $Y=0.036
c10 16 vss 0.00281313f $X=0.243 $Y=0.234
c11 17 vss 0.00923871f $X=0.216 $Y=0.036
c12 18 vss 0.00833342f $X=0.216 $Y=0.234
c13 19 vss 0.00722916f $X=0.243 $Y=0.135
c14 20 vss 0.000982291f $X=0.405 $Y=0.116
c15 21 vss 0.00195015f $X=0.675 $Y=0.1125
c16 22 vss 0.0189619f $X=0.2315 $Y=0.153
r1 14 6 0.231482 $w=5.4e-08 $l=1.25e-08 $layer=P_src_drn $thickness=1e-09
+ $X=0.1475 $Y=0.216 $X2=0.162 $Y2=0.216
r2 69 14 0.0462963 $w=5.4e-08 $l=2.5e-09 $layer=P_src_drn $thickness=1e-09
+ $X=0.1446 $Y=0.216 $X2=0.1475 $Y2=0.216
r3 13 5 0.231482 $w=5.4e-08 $l=1.25e-08 $layer=N_src_drn $thickness=1e-09
+ $X=0.1475 $Y=0.054 $X2=0.162 $Y2=0.054
r4 67 13 0.0462963 $w=5.4e-08 $l=2.5e-09 $layer=N_src_drn $thickness=1e-09
+ $X=0.1446 $Y=0.054 $X2=0.1475 $Y2=0.054
r5 6 58 19.3796 $a=3.24e-16 $layer=V0LISD $X=0.162 $Y=0.216 $X2=0.162 $Y2=0.234
r6 5 55 19.3796 $a=3.24e-16 $layer=V0LISD $X=0.162 $Y=0.054 $X2=0.162 $Y2=0.036
r7 64 63 16.4967 $w=2.1e-08 $l=4.85e-08 $layer=Gate_1 $thickness=5.6e-08
+ $X=0.675 $Y=0.2295 $X2=0.675 $Y2=0.181
r8 61 62 16.4967 $w=2.1e-08 $l=4.85e-08 $layer=Gate_1 $thickness=5.6e-08
+ $X=0.675 $Y=0.0405 $X2=0.675 $Y2=0.089
r9 12 62 15.8334 $w=2.07609e-08 $l=4.6e-08 $layer=Gate_1 $thickness=5.6e-08
+ $X=0.675 $Y=0.135 $X2=0.675 $Y2=0.089
r10 12 63 15.8334 $w=2.07609e-08 $l=4.6e-08 $layer=Gate_1 $thickness=5.6e-08
+ $X=0.675 $Y=0.135 $X2=0.675 $Y2=0.181
r11 58 59 5.24677 $w=1.3e-08 $l=2.25e-08 $layer=M1 $thickness=3.6e-08 $X=0.162
+ $Y=0.234 $X2=0.1845 $Y2=0.234
r12 18 59 7.34548 $w=1.3e-08 $l=3.15e-08 $layer=M1 $thickness=3.6e-08 $X=0.216
+ $Y=0.234 $X2=0.1845 $Y2=0.234
r13 55 56 5.24677 $w=1.3e-08 $l=2.25e-08 $layer=M1 $thickness=3.6e-08 $X=0.162
+ $Y=0.036 $X2=0.1845 $Y2=0.036
r14 17 56 7.34548 $w=1.3e-08 $l=3.15e-08 $layer=M1 $thickness=3.6e-08 $X=0.216
+ $Y=0.036 $X2=0.1845 $Y2=0.036
r15 2 50 19.3796 $a=3.24e-16 $layer=V0LIG $X=0.675 $Y=0.135 $X2=0.675 $Y2=0.144
r16 2 12 6.54019 $w=2.09524e-08 $layer=Gate_1 $thickness=5.21905e-08 $X=0.675
+ $Y=0.135 $X2=0.675 $Y2=0.135
r17 16 49 3.36447 $w=1.71023e-08 $l=2.15e-08 $layer=M1 $thickness=3.6e-08
+ $X=0.243 $Y=0.234 $X2=0.243 $Y2=0.2125
r18 16 18 4.64701 $w=1.46667e-08 $l=2.7e-08 $layer=M1 $thickness=3.6e-08
+ $X=0.243 $Y=0.234 $X2=0.216 $Y2=0.234
r19 15 46 3.36447 $w=1.71023e-08 $l=2.15e-08 $layer=M1 $thickness=3.6e-08
+ $X=0.243 $Y=0.036 $X2=0.243 $Y2=0.0575
r20 15 17 4.64701 $w=1.46667e-08 $l=2.7e-08 $layer=M1 $thickness=3.6e-08
+ $X=0.243 $Y=0.036 $X2=0.216 $Y2=0.036
r21 21 50 7.34548 $w=1.3e-08 $l=3.15e-08 $layer=M1 $thickness=3.6e-08 $X=0.675
+ $Y=0.1125 $X2=0.675 $Y2=0.144
r22 48 49 3.14806 $w=1.3e-08 $l=1.35e-08 $layer=M1 $thickness=3.6e-08 $X=0.243
+ $Y=0.199 $X2=0.243 $Y2=0.2125
r23 47 48 2.3319 $w=1.3e-08 $l=1e-08 $layer=M1 $thickness=3.6e-08 $X=0.243
+ $Y=0.189 $X2=0.243 $Y2=0.199
r24 45 46 7.11229 $w=1.3e-08 $l=3.05e-08 $layer=M1 $thickness=3.6e-08 $X=0.243
+ $Y=0.088 $X2=0.243 $Y2=0.0575
r25 44 45 6.52931 $w=1.3e-08 $l=2.8e-08 $layer=M1 $thickness=3.6e-08 $X=0.243
+ $Y=0.116 $X2=0.243 $Y2=0.088
r26 43 47 4.19742 $w=1.3e-08 $l=1.8e-08 $layer=M1 $thickness=3.6e-08 $X=0.243
+ $Y=0.171 $X2=0.243 $Y2=0.189
r27 42 43 4.19742 $w=1.3e-08 $l=1.8e-08 $layer=M1 $thickness=3.6e-08 $X=0.243
+ $Y=0.153 $X2=0.243 $Y2=0.171
r28 19 42 4.19742 $w=1.3e-08 $l=1.8e-08 $layer=M1 $thickness=3.6e-08 $X=0.243
+ $Y=0.135 $X2=0.243 $Y2=0.153
r29 19 44 4.43061 $w=1.3e-08 $l=1.9e-08 $layer=M1 $thickness=3.6e-08 $X=0.243
+ $Y=0.135 $X2=0.243 $Y2=0.116
r30 40 50 19.5347 $a=3.24e-16 $layer=V1 $X=0.675 $Y=0.153 $X2=0.675 $Y2=0.144
r31 39 40 18.3054 $w=1.3e-08 $l=7.85e-08 $layer=M2 $thickness=3.6e-08 $X=0.5965
+ $Y=0.153 $X2=0.675 $Y2=0.153
r32 38 39 29.3819 $w=1.3e-08 $l=1.26e-07 $layer=M2 $thickness=3.6e-08 $X=0.4705
+ $Y=0.153 $X2=0.5965 $Y2=0.153
r33 37 38 15.2739 $w=1.3e-08 $l=6.55e-08 $layer=M2 $thickness=3.6e-08 $X=0.405
+ $Y=0.153 $X2=0.4705 $Y2=0.153
r34 36 37 18.8884 $w=1.3e-08 $l=8.1e-08 $layer=M2 $thickness=3.6e-08 $X=0.324
+ $Y=0.153 $X2=0.405 $Y2=0.153
r35 35 36 18.8884 $w=1.3e-08 $l=8.1e-08 $layer=M2 $thickness=3.6e-08 $X=0.243
+ $Y=0.153 $X2=0.324 $Y2=0.153
r36 35 42 19.5347 $a=3.24e-16 $layer=V1 $X=0.243 $Y=0.153 $X2=0.243 $Y2=0.153
r37 22 35 2.68168 $w=1.3e-08 $l=1.15e-08 $layer=M2 $thickness=3.6e-08 $X=0.2315
+ $Y=0.153 $X2=0.243 $Y2=0.153
r38 33 37 19.5347 $a=3.24e-16 $layer=V1 $X=0.405 $Y=0.144 $X2=0.405 $Y2=0.153
r39 20 33 6.52931 $w=1.3e-08 $l=2.8e-08 $layer=M1 $thickness=3.6e-08 $X=0.405
+ $Y=0.116 $X2=0.405 $Y2=0.144
r40 1 28 9.2451 $w=1.7885e-08 $l=2e-09 $layer=LIG $thickness=5.24e-08 $X=0.405
+ $Y=0.133 $X2=0.405 $Y2=0.135
r41 1 33 19.3796 $a=3.24e-16 $layer=V0LIG $X=0.405 $Y=0.133 $X2=0.405 $Y2=0.144
r42 30 29 16.4967 $w=2.1e-08 $l=4.85e-08 $layer=Gate_1 $thickness=5.6e-08
+ $X=0.405 $Y=0.2295 $X2=0.405 $Y2=0.181
r43 28 29 15.8334 $w=2.07609e-08 $l=4.6e-08 $layer=Gate_1 $thickness=5.6e-08
+ $X=0.405 $Y=0.135 $X2=0.405 $Y2=0.181
r44 27 28 6.6497 $w=2.04211e-08 $l=1.9e-08 $layer=Gate_1 $thickness=5.6e-08
+ $X=0.405 $Y=0.116 $X2=0.405 $Y2=0.135
r45 26 27 16.4967 $w=2.1e-08 $l=4.85e-08 $layer=Gate_1 $thickness=5.6e-08
+ $X=0.405 $Y=0.0675 $X2=0.405 $Y2=0.116
r46 26 11 14.6259 $w=2.1e-08 $l=4.3e-08 $layer=Gate_1 $thickness=5.6e-08
+ $X=0.405 $Y=0.0675 $X2=0.405 $Y2=0.0245
.ends

.subckt PM_DFFLQNx3_ASAP7_75t_R%7 vss 20 24 44 45 50 52 3 1 4 12 13 17 19 11 10
+ 18 14 16
c1 1 vss 0.00215866f $X=0.513 $Y=0.09
c2 3 vss 0.00459824f $X=0.594 $Y=0.0405
c3 4 vss 0.00838772f $X=0.594 $Y=0.2295
c4 10 vss 0.052381f $X=0.513 $Y=0.0245
c5 11 vss 0.00396671f $X=0.5795 $Y=0.0405
c6 12 vss 0.00376503f $X=0.5795 $Y=0.2295
c7 13 vss 0.00338868f $X=0.65 $Y=0.2295
c8 14 vss 0.000537399f $X=0.594 $Y=0.09
c9 15 vss 0.00263781f $X=0.621 $Y=0.234
c10 16 vss 0.00223819f $X=0.5 $Y=0.09
c11 17 vss 0.00401697f $X=0.5965 $Y=0.234
c12 18 vss 0.00321152f $X=0.594 $Y=0.054
c13 19 vss 0.00165538f $X=0.621 $Y=0.1105
r1 52 51 0.0925926 $w=2.7e-08 $l=2.5e-09 $layer=P_src_drn $thickness=1e-09
+ $X=0.6653 $Y=0.2295 $X2=0.6625 $Y2=0.2295
r2 13 51 0.462963 $w=2.7e-08 $l=1.25e-08 $layer=P_src_drn $thickness=1e-09
+ $X=0.65 $Y=0.2295 $X2=0.6625 $Y2=0.2295
r3 12 4 0.462963 $w=2.7e-08 $l=1.25e-08 $layer=P_src_drn $thickness=1e-09
+ $X=0.5795 $Y=0.2295 $X2=0.594 $Y2=0.2295
r4 50 12 0.0925926 $w=2.7e-08 $l=2.5e-09 $layer=P_src_drn $thickness=1e-09
+ $X=0.5766 $Y=0.2295 $X2=0.5795 $Y2=0.2295
r5 47 13 12.6992 $w=2.32e-08 $l=2.7e-08 $layer=LISD $thickness=2.7e-08 $X=0.621
+ $Y=0.2295 $X2=0.65 $Y2=0.2295
r6 4 47 12.6992 $w=2.32e-08 $l=2.7e-08 $layer=LISD $thickness=2.7e-08 $X=0.594
+ $Y=0.2295 $X2=0.621 $Y2=0.2295
r7 4 17 19.3796 $a=3.24e-16 $layer=V0LISD $X=0.594 $Y=0.2295 $X2=0.5965
+ $Y2=0.234
r8 45 43 0.0925926 $w=2.7e-08 $l=2.5e-09 $layer=N_src_drn $thickness=1e-09
+ $X=0.6113 $Y=0.0405 $X2=0.6085 $Y2=0.0405
r9 3 43 0.537037 $w=2.7e-08 $l=1.45e-08 $layer=N_src_drn $thickness=1e-09
+ $X=0.594 $Y=0.0405 $X2=0.6085 $Y2=0.0405
r10 11 3 0.537037 $w=2.7e-08 $l=1.45e-08 $layer=N_src_drn $thickness=1e-09
+ $X=0.5795 $Y=0.0405 $X2=0.594 $Y2=0.0405
r11 44 11 0.0925926 $w=2.7e-08 $l=2.5e-09 $layer=N_src_drn $thickness=1e-09
+ $X=0.5766 $Y=0.0405 $X2=0.5795 $Y2=0.0405
r12 15 39 3.01468 $w=1.741e-08 $l=2e-08 $layer=M1 $thickness=3.6e-08 $X=0.621
+ $Y=0.234 $X2=0.621 $Y2=0.214
r13 15 17 4.06404 $w=1.48367e-08 $l=2.45e-08 $layer=M1 $thickness=3.6e-08
+ $X=0.621 $Y=0.234 $X2=0.5965 $Y2=0.234
r14 3 18 19.3796 $a=3.24e-16 $layer=V0LISD $X=0.594 $Y=0.0405 $X2=0.594
+ $Y2=0.054
r15 38 39 6.7625 $w=1.3e-08 $l=2.9e-08 $layer=M1 $thickness=3.6e-08 $X=0.621
+ $Y=0.185 $X2=0.621 $Y2=0.214
r16 37 38 4.43061 $w=1.3e-08 $l=1.9e-08 $layer=M1 $thickness=3.6e-08 $X=0.621
+ $Y=0.166 $X2=0.621 $Y2=0.185
r17 36 37 3.14806 $w=1.3e-08 $l=1.35e-08 $layer=M1 $thickness=3.6e-08 $X=0.621
+ $Y=0.1525 $X2=0.621 $Y2=0.166
r18 35 36 5.01358 $w=1.3e-08 $l=2.15e-08 $layer=M1 $thickness=3.6e-08 $X=0.621
+ $Y=0.131 $X2=0.621 $Y2=0.1525
r19 19 32 3.60008 $w=1.51951e-08 $l=2.05e-08 $layer=M1 $thickness=3.6e-08
+ $X=0.621 $Y=0.1105 $X2=0.621 $Y2=0.09
r20 19 35 4.78039 $w=1.3e-08 $l=2.05e-08 $layer=M1 $thickness=3.6e-08 $X=0.621
+ $Y=0.1105 $X2=0.621 $Y2=0.131
r21 18 33 4.19742 $w=1.3e-08 $l=1.8e-08 $layer=M1 $thickness=3.6e-08 $X=0.594
+ $Y=0.054 $X2=0.594 $Y2=0.072
r22 31 32 1.96775 $w=1.63333e-08 $l=1.35e-08 $layer=M1 $thickness=3.6e-08
+ $X=0.6075 $Y=0.09 $X2=0.621 $Y2=0.09
r23 14 30 1.38478 $w=1.70909e-08 $l=1.1e-08 $layer=M1 $thickness=3.6e-08
+ $X=0.594 $Y=0.09 $X2=0.583 $Y2=0.09
r24 14 31 1.96775 $w=1.63333e-08 $l=1.35e-08 $layer=M1 $thickness=3.6e-08
+ $X=0.594 $Y=0.09 $X2=0.6075 $Y2=0.09
r25 14 33 3.01711 $w=1.55e-08 $l=1.8e-08 $layer=M1 $thickness=3.6e-08 $X=0.594
+ $Y=0.09 $X2=0.594 $Y2=0.072
r26 29 30 7.34548 $w=1.3e-08 $l=3.15e-08 $layer=M1 $thickness=3.6e-08 $X=0.5515
+ $Y=0.09 $X2=0.583 $Y2=0.09
r27 28 29 8.97781 $w=1.3e-08 $l=3.85e-08 $layer=M1 $thickness=3.6e-08 $X=0.513
+ $Y=0.09 $X2=0.5515 $Y2=0.09
r28 16 28 3.03147 $w=1.3e-08 $l=1.3e-08 $layer=M1 $thickness=3.6e-08 $X=0.5
+ $Y=0.09 $X2=0.513 $Y2=0.09
r29 1 22 6.54019 $w=2.09524e-08 $layer=Gate_1 $thickness=5.21905e-08 $X=0.513
+ $Y=0.09 $X2=0.513 $Y2=0.09
r30 1 28 19.3796 $a=3.24e-16 $layer=V0LIG $X=0.513 $Y=0.09 $X2=0.513 $Y2=0.09
r31 24 23 24.1498 $w=2.1e-08 $l=7.1e-08 $layer=Gate_1 $thickness=5.6e-08
+ $X=0.513 $Y=0.2295 $X2=0.513 $Y2=0.1585
r32 22 23 23.4865 $w=2.08394e-08 $l=6.85e-08 $layer=Gate_1 $thickness=5.6e-08
+ $X=0.513 $Y=0.09 $X2=0.513 $Y2=0.1585
r33 21 22 8.18032 $w=2.05319e-08 $l=2.35e-08 $layer=Gate_1 $thickness=5.6e-08
+ $X=0.513 $Y=0.0665 $X2=0.513 $Y2=0.09
r34 20 21 8.84359 $w=2.1e-08 $l=2.6e-08 $layer=Gate_1 $thickness=5.6e-08
+ $X=0.513 $Y=0.0405 $X2=0.513 $Y2=0.0665
r35 20 10 5.44221 $w=2.1e-08 $l=1.6e-08 $layer=Gate_1 $thickness=5.6e-08
+ $X=0.513 $Y=0.0405 $X2=0.513 $Y2=0.0245
.ends

.subckt PM_DFFLQNx3_ASAP7_75t_R%9 vss 19 23 35 44 9 14 18 4 3 1 17 12 15 16 10
+ 11
c1 1 vss 0.00162592f $X=0.783 $Y=0.1055
c2 3 vss 0.00643281f $X=0.864 $Y=0.0405
c3 4 vss 0.00666201f $X=0.864 $Y=0.2295
c4 9 vss 0.04137f $X=0.783 $Y=0.0245
c5 10 vss 0.0188031f $X=0.8495 $Y=0.0405
c6 11 vss 0.0188109f $X=0.8495 $Y=0.2295
c7 12 vss 0.00283207f $X=0.783 $Y=0.036
c8 13 vss 0.00378933f $X=0.945 $Y=0.036
c9 14 vss 0.00365777f $X=0.945 $Y=0.234
c10 15 vss 0.00214817f $X=0.783 $Y=0.0705
c11 16 vss 0.0137593f $X=0.81 $Y=0.036
c12 17 vss 0.00912965f $X=0.918 $Y=0.234
c13 18 vss 0.00828832f $X=0.945 $Y=0.0675
r1 11 4 0.462963 $w=2.7e-08 $l=1.25e-08 $layer=P_src_drn $thickness=1e-09
+ $X=0.8495 $Y=0.2295 $X2=0.864 $Y2=0.2295
r2 44 11 0.0925926 $w=2.7e-08 $l=2.5e-09 $layer=P_src_drn $thickness=1e-09
+ $X=0.8466 $Y=0.2295 $X2=0.8495 $Y2=0.2295
r3 4 41 19.3796 $a=3.24e-16 $layer=V0LISD $X=0.864 $Y=0.2295 $X2=0.864 $Y2=0.234
r4 41 42 5.24677 $w=1.3e-08 $l=2.25e-08 $layer=M1 $thickness=3.6e-08 $X=0.864
+ $Y=0.234 $X2=0.8865 $Y2=0.234
r5 17 42 7.34548 $w=1.3e-08 $l=3.15e-08 $layer=M1 $thickness=3.6e-08 $X=0.918
+ $Y=0.234 $X2=0.8865 $Y2=0.234
r6 14 39 6.74572 $w=1.545e-08 $l=3.6e-08 $layer=M1 $thickness=3.6e-08 $X=0.945
+ $Y=0.234 $X2=0.945 $Y2=0.198
r7 14 17 4.64701 $w=1.46667e-08 $l=2.7e-08 $layer=M1 $thickness=3.6e-08
+ $X=0.945 $Y=0.234 $X2=0.918 $Y2=0.234
r8 38 39 6.7625 $w=1.3e-08 $l=2.9e-08 $layer=M1 $thickness=3.6e-08 $X=0.945
+ $Y=0.169 $X2=0.945 $Y2=0.198
r9 37 38 6.29612 $w=1.3e-08 $l=2.7e-08 $layer=M1 $thickness=3.6e-08 $X=0.945
+ $Y=0.142 $X2=0.945 $Y2=0.169
r10 36 37 8.97781 $w=1.3e-08 $l=3.85e-08 $layer=M1 $thickness=3.6e-08 $X=0.945
+ $Y=0.1035 $X2=0.945 $Y2=0.142
r11 18 36 8.39483 $w=1.3e-08 $l=3.6e-08 $layer=M1 $thickness=3.6e-08 $X=0.945
+ $Y=0.0675 $X2=0.945 $Y2=0.1035
r12 10 3 0.462963 $w=2.7e-08 $l=1.25e-08 $layer=N_src_drn $thickness=1e-09
+ $X=0.8495 $Y=0.0405 $X2=0.864 $Y2=0.0405
r13 35 10 0.0925926 $w=2.7e-08 $l=2.5e-09 $layer=N_src_drn $thickness=1e-09
+ $X=0.8466 $Y=0.0405 $X2=0.8495 $Y2=0.0405
r14 13 33 4.64701 $w=1.46667e-08 $l=2.7e-08 $layer=M1 $thickness=3.6e-08
+ $X=0.945 $Y=0.036 $X2=0.918 $Y2=0.036
r15 13 18 5.69636 $w=1.58e-08 $l=3.15e-08 $layer=M1 $thickness=3.6e-08 $X=0.945
+ $Y=0.036 $X2=0.945 $Y2=0.0675
r16 3 31 19.3796 $a=3.24e-16 $layer=V0LISD $X=0.864 $Y=0.0405 $X2=0.864
+ $Y2=0.036
r17 32 33 6.29612 $w=1.3e-08 $l=2.7e-08 $layer=M1 $thickness=3.6e-08 $X=0.891
+ $Y=0.036 $X2=0.918 $Y2=0.036
r18 31 32 6.29612 $w=1.3e-08 $l=2.7e-08 $layer=M1 $thickness=3.6e-08 $X=0.864
+ $Y=0.036 $X2=0.891 $Y2=0.036
r19 30 31 6.29612 $w=1.3e-08 $l=2.7e-08 $layer=M1 $thickness=3.6e-08 $X=0.837
+ $Y=0.036 $X2=0.864 $Y2=0.036
r20 16 30 6.29612 $w=1.3e-08 $l=2.7e-08 $layer=M1 $thickness=3.6e-08 $X=0.81
+ $Y=0.036 $X2=0.837 $Y2=0.036
r21 12 15 6.39593 $w=1.55565e-08 $l=3.45e-08 $layer=M1 $thickness=3.6e-08
+ $X=0.783 $Y=0.036 $X2=0.783 $Y2=0.0705
r22 12 16 4.64701 $w=1.46667e-08 $l=2.7e-08 $layer=M1 $thickness=3.6e-08
+ $X=0.783 $Y=0.036 $X2=0.81 $Y2=0.036
r23 15 27 8.04505 $w=1.3e-08 $l=3.45e-08 $layer=M1 $thickness=3.6e-08 $X=0.783
+ $Y=0.0705 $X2=0.783 $Y2=0.105
r24 1 21 6.4735 $w=2.13953e-08 $layer=Gate_1 $thickness=5.22791e-08 $X=0.783
+ $Y=0.1055 $X2=0.783 $Y2=0.1055
r25 1 27 19.3796 $a=3.24e-16 $layer=V0LIG $X=0.783 $Y=0.1055 $X2=0.783 $Y2=0.105
r26 23 22 21.4287 $w=2.1e-08 $l=6.3e-08 $layer=Gate_1 $thickness=5.6e-08
+ $X=0.783 $Y=0.2295 $X2=0.783 $Y2=0.1665
r27 21 22 20.944 $w=2.08115e-08 $l=6.1e-08 $layer=Gate_1 $thickness=5.6e-08
+ $X=0.783 $Y=0.1055 $X2=0.783 $Y2=0.1665
r28 20 21 10.9099 $w=2.06349e-08 $l=3.15e-08 $layer=Gate_1 $thickness=5.6e-08
+ $X=0.783 $Y=0.074 $X2=0.783 $Y2=0.1055
r29 19 20 11.3946 $w=2.1e-08 $l=3.35e-08 $layer=Gate_1 $thickness=5.6e-08
+ $X=0.783 $Y=0.0405 $X2=0.783 $Y2=0.074
r30 19 9 5.44221 $w=2.1e-08 $l=1.6e-08 $layer=Gate_1 $thickness=5.6e-08
+ $X=0.783 $Y=0.0405 $X2=0.783 $Y2=0.0245
.ends

.subckt PM_DFFLQNx3_ASAP7_75t_R%QN vss 32 24 25 36 43 44 46 15 1 2 14 16 13
c1 1 vss 0.00917f $X=1.026 $Y=0.0675
c2 2 vss 0.00990468f $X=1.026 $Y=0.2025
c3 3 vss 0.00819065f $X=1.134 $Y=0.0675
c4 4 vss 0.00818317f $X=1.134 $Y=0.2025
c5 13 vss 0.0045426f $X=1.0115 $Y=0.0675
c6 14 vss 0.0371311f $X=1.1195 $Y=0.0675
c7 15 vss 0.00452157f $X=1.0115 $Y=0.2025
c8 16 vss 0.0371184f $X=1.1195 $Y=0.2025
c9 17 vss 0.00265788f $X=1.162 $Y=0.036
c10 18 vss 0.00265788f $X=1.162 $Y=0.234
c11 19 vss 0.0133719f $X=1.0115 $Y=0.036
c12 20 vss 0.0135436f $X=1.0145 $Y=0.234
c13 21 vss 0.0047806f $X=1.162 $Y=0.0675
r1 16 4 0.154321 $w=8.1e-08 $l=1.25e-08 $layer=P_src_drn $thickness=1e-09
+ $X=1.1195 $Y=0.2025 $X2=1.134 $Y2=0.2025
r2 46 16 0.0308642 $w=8.1e-08 $l=2.5e-09 $layer=P_src_drn $thickness=1e-09
+ $X=1.1166 $Y=0.2025 $X2=1.1195 $Y2=0.2025
r3 44 42 0.0308642 $w=8.1e-08 $l=2.5e-09 $layer=P_src_drn $thickness=1e-09
+ $X=1.0433 $Y=0.2025 $X2=1.0405 $Y2=0.2025
r4 2 42 0.179012 $w=8.1e-08 $l=1.45e-08 $layer=P_src_drn $thickness=1e-09
+ $X=1.026 $Y=0.2025 $X2=1.0405 $Y2=0.2025
r5 15 2 0.179012 $w=8.1e-08 $l=1.45e-08 $layer=P_src_drn $thickness=1e-09
+ $X=1.0115 $Y=0.2025 $X2=1.026 $Y2=0.2025
r6 43 15 0.0308642 $w=8.1e-08 $l=2.5e-09 $layer=P_src_drn $thickness=1e-09
+ $X=1.0086 $Y=0.2025 $X2=1.0115 $Y2=0.2025
r7 4 39 19.3796 $a=3.24e-16 $layer=V0LISD $X=1.134 $Y=0.2025 $X2=1.134 $Y2=0.234
r8 2 37 19.3796 $a=3.24e-16 $layer=V0LISD $X=1.026 $Y=0.2025 $X2=1.026 $Y2=0.234
r9 39 40 3.26466 $w=1.3e-08 $l=1.4e-08 $layer=M1 $thickness=3.6e-08 $X=1.134
+ $Y=0.234 $X2=1.148 $Y2=0.234
r10 38 39 12.5922 $w=1.3e-08 $l=5.4e-08 $layer=M1 $thickness=3.6e-08 $X=1.08
+ $Y=0.234 $X2=1.134 $Y2=0.234
r11 37 38 12.5922 $w=1.3e-08 $l=5.4e-08 $layer=M1 $thickness=3.6e-08 $X=1.026
+ $Y=0.234 $X2=1.08 $Y2=0.234
r12 20 37 2.68168 $w=1.3e-08 $l=1.15e-08 $layer=M1 $thickness=3.6e-08 $X=1.0145
+ $Y=0.234 $X2=1.026 $Y2=0.234
r13 18 34 7.2121 $w=1.53211e-08 $l=3.8e-08 $layer=M1 $thickness=3.6e-08
+ $X=1.162 $Y=0.234 $X2=1.162 $Y2=0.196
r14 18 40 1.61554 $w=1.62143e-08 $l=1.4e-08 $layer=M1 $thickness=3.6e-08
+ $X=1.162 $Y=0.234 $X2=1.148 $Y2=0.234
r15 14 3 0.154321 $w=8.1e-08 $l=1.25e-08 $layer=N_src_drn $thickness=1e-09
+ $X=1.1195 $Y=0.0675 $X2=1.134 $Y2=0.0675
r16 36 14 0.0308642 $w=8.1e-08 $l=2.5e-09 $layer=N_src_drn $thickness=1e-09
+ $X=1.1166 $Y=0.0675 $X2=1.1195 $Y2=0.0675
r17 33 34 11.1348 $w=1.3e-08 $l=4.78e-08 $layer=M1 $thickness=3.6e-08 $X=1.162
+ $Y=0.1482 $X2=1.162 $Y2=0.196
r18 32 33 4.4889 $w=1.3e-08 $l=1.92e-08 $layer=M1 $thickness=3.6e-08 $X=1.161
+ $Y=0.129 $X2=1.162 $Y2=0.1482
r19 32 31 4.6055 $w=1.3e-08 $l=1.98e-08 $layer=M1 $thickness=3.6e-08 $X=1.161
+ $Y=0.129 $X2=1.162 $Y2=0.1092
r20 21 31 9.73567 $w=1.3e-08 $l=4.17e-08 $layer=M1 $thickness=3.6e-08 $X=1.162
+ $Y=0.0675 $X2=1.162 $Y2=0.1092
r21 3 29 19.3796 $a=3.24e-16 $layer=V0LISD $X=1.134 $Y=0.0675 $X2=1.134
+ $Y2=0.036
r22 17 30 1.61554 $w=1.62143e-08 $l=1.4e-08 $layer=M1 $thickness=3.6e-08
+ $X=1.162 $Y=0.036 $X2=1.148 $Y2=0.036
r23 17 21 5.69636 $w=1.58e-08 $l=3.15e-08 $layer=M1 $thickness=3.6e-08 $X=1.162
+ $Y=0.036 $X2=1.162 $Y2=0.0675
r24 29 30 3.26466 $w=1.3e-08 $l=1.4e-08 $layer=M1 $thickness=3.6e-08 $X=1.134
+ $Y=0.036 $X2=1.148 $Y2=0.036
r25 28 29 12.5922 $w=1.3e-08 $l=5.4e-08 $layer=M1 $thickness=3.6e-08 $X=1.08
+ $Y=0.036 $X2=1.134 $Y2=0.036
r26 27 28 12.5922 $w=1.3e-08 $l=5.4e-08 $layer=M1 $thickness=3.6e-08 $X=1.026
+ $Y=0.036 $X2=1.08 $Y2=0.036
r27 26 27 2.68168 $w=1.3e-08 $l=1.15e-08 $layer=M1 $thickness=3.6e-08 $X=1.0145
+ $Y=0.036 $X2=1.026 $Y2=0.036
r28 19 26 0.699569 $w=1.3e-08 $l=3e-09 $layer=M1 $thickness=3.6e-08 $X=1.0115
+ $Y=0.036 $X2=1.0145 $Y2=0.036
r29 1 27 19.3796 $a=3.24e-16 $layer=V0LISD $X=1.026 $Y=0.0675 $X2=1.026
+ $Y2=0.036
r30 25 23 0.0308642 $w=8.1e-08 $l=2.5e-09 $layer=N_src_drn $thickness=1e-09
+ $X=1.0433 $Y=0.0675 $X2=1.0405 $Y2=0.0675
r31 1 23 0.179012 $w=8.1e-08 $l=1.45e-08 $layer=N_src_drn $thickness=1e-09
+ $X=1.026 $Y=0.0675 $X2=1.0405 $Y2=0.0675
r32 13 1 0.179012 $w=8.1e-08 $l=1.45e-08 $layer=N_src_drn $thickness=1e-09
+ $X=1.0115 $Y=0.0675 $X2=1.026 $Y2=0.0675
r33 24 13 0.0308642 $w=8.1e-08 $l=2.5e-09 $layer=N_src_drn $thickness=1e-09
+ $X=1.0086 $Y=0.0675 $X2=1.0115 $Y2=0.0675
.ends

.subckt PM_DFFLQNx3_ASAP7_75t_R%14 vss 7 12 1 5 4
c1 1 vss 0.00632288f $X=0.702 $Y=0.0405
c2 4 vss 0.00174985f $X=0.6875 $Y=0.0405
c3 5 vss 0.0021751f $X=0.758 $Y=0.0405
r1 12 11 0.0925926 $w=2.7e-08 $l=2.5e-09 $layer=N_src_drn $thickness=1e-09
+ $X=0.7733 $Y=0.0405 $X2=0.7705 $Y2=0.0405
r2 5 11 0.462963 $w=2.7e-08 $l=1.25e-08 $layer=N_src_drn $thickness=1e-09
+ $X=0.758 $Y=0.0405 $X2=0.7705 $Y2=0.0405
r3 9 5 8.23096 $w=2.32e-08 $l=1.75e-08 $layer=LISD $thickness=2.7e-08 $X=0.7385
+ $Y=0.0405 $X2=0.758 $Y2=0.0405
r4 8 9 7.05511 $w=2.32e-08 $l=1.5e-08 $layer=LISD $thickness=2.7e-08 $X=0.7235
+ $Y=0.0405 $X2=0.7385 $Y2=0.0405
r5 1 8 10.1123 $w=2.32e-08 $l=2.15e-08 $layer=LISD $thickness=2.7e-08 $X=0.702
+ $Y=0.0405 $X2=0.7235 $Y2=0.0405
r6 4 1 0.462963 $w=2.7e-08 $l=1.25e-08 $layer=N_src_drn $thickness=1e-09
+ $X=0.6875 $Y=0.0405 $X2=0.702 $Y2=0.0405
r7 7 4 0.0925926 $w=2.7e-08 $l=2.5e-09 $layer=N_src_drn $thickness=1e-09
+ $X=0.6846 $Y=0.0405 $X2=0.6875 $Y2=0.0405
.ends

.subckt PM_DFFLQNx3_ASAP7_75t_R%10 vss 33 39 78 79 82 86 89 92 96 100 104 105
+ 16 19 17 6 15 25 23 24 5 30 22 2 20 29 21 27 11 1 18 26 28 14 13 12
c1 1 vss 0.00179751f $X=0.837 $Y=0.1245
c2 2 vss 0.0153776f $X=0.9895 $Y=0.136
c3 5 vss 0.00465567f $X=0.648 $Y=0.0405
c4 6 vss 0.00464982f $X=0.702 $Y=0.2295
c5 11 vss 0.0538508f $X=0.837 $Y=0.0245
c6 12 vss 0.0881591f $X=0.999 $Y=0.136
c7 13 vss 0.0806397f $X=1.053 $Y=0.136
c8 14 vss 0.0864931f $X=1.107 $Y=0.136
c9 15 vss 0.00439989f $X=0.6335 $Y=0.0405
c10 16 vss 0.00449822f $X=0.6875 $Y=0.2295
c11 17 vss 0.00636259f $X=0.729 $Y=0.234
c12 18 vss 0.00266636f $X=0.729 $Y=0.036
c13 19 vss 0.000165725f $X=0.729 $Y=0.16
c14 20 vss 0.000316447f $X=0.837 $Y=0.162
c15 21 vss 0.00129462f $X=0.891 $Y=0.1575
c16 22 vss 0.00864455f $X=0.704 $Y=0.036
c17 23 vss 0.00200086f $X=0.729 $Y=0.136
c18 24 vss 0.00196496f $X=0.729 $Y=0.198
c19 25 vss 0.00273062f $X=0.81 $Y=0.162
c20 26 vss 0.000874899f $X=0.837 $Y=0.118
c21 27 vss 0.000782208f $X=0.848 $Y=0.162
c22 28 vss 0.00120995f $X=0.891 $Y=0.1305
c23 29 vss 0.00408591f $X=0.999 $Y=0.1085
c24 30 vss 0.0100184f $X=0.8795 $Y=0.153
r1 105 103 0.0925926 $w=2.7e-08 $l=2.5e-09 $layer=N_src_drn $thickness=1e-09
+ $X=0.6653 $Y=0.0405 $X2=0.6625 $Y2=0.0405
r2 5 103 0.537037 $w=2.7e-08 $l=1.45e-08 $layer=N_src_drn $thickness=1e-09
+ $X=0.648 $Y=0.0405 $X2=0.6625 $Y2=0.0405
r3 15 5 0.537037 $w=2.7e-08 $l=1.45e-08 $layer=N_src_drn $thickness=1e-09
+ $X=0.6335 $Y=0.0405 $X2=0.648 $Y2=0.0405
r4 104 15 0.0925926 $w=2.7e-08 $l=2.5e-09 $layer=N_src_drn $thickness=1e-09
+ $X=0.6306 $Y=0.0405 $X2=0.6335 $Y2=0.0405
r5 100 99 14.6259 $w=2.1e-08 $l=4.3e-08 $layer=Gate_1 $thickness=5.6e-08
+ $X=1.107 $Y=0.2025 $X2=1.107 $Y2=0.1595
r6 98 99 2.55104 $w=2.1e-08 $l=7.5e-09 $layer=Gate_1 $thickness=5.6e-08
+ $X=1.107 $Y=0.152 $X2=1.107 $Y2=0.1595
r7 96 97 14.6259 $w=2.1e-08 $l=4.3e-08 $layer=Gate_1 $thickness=5.6e-08
+ $X=1.107 $Y=0.0675 $X2=1.107 $Y2=0.1105
r8 94 97 2.89117 $w=2.1e-08 $l=8.5e-09 $layer=Gate_1 $thickness=5.6e-08
+ $X=1.107 $Y=0.119 $X2=1.107 $Y2=0.1105
r9 14 72 6.54019 $w=2.09524e-08 $layer=Gate_1 $thickness=5.21905e-08 $X=1.107
+ $Y=0.136 $X2=1.107 $Y2=0.136
r10 14 94 5.96942 $w=2.03529e-08 $l=1.7e-08 $layer=Gate_1 $thickness=5.6e-08
+ $X=1.107 $Y=0.136 $X2=1.107 $Y2=0.119
r11 14 98 5.62929 $w=2.03125e-08 $l=1.6e-08 $layer=Gate_1 $thickness=5.6e-08
+ $X=1.107 $Y=0.136 $X2=1.107 $Y2=0.152
r12 92 91 16.3266 $w=2.1e-08 $l=4.8e-08 $layer=Gate_1 $thickness=5.6e-08
+ $X=1.053 $Y=0.2025 $X2=1.053 $Y2=0.1545
r13 89 90 16.6668 $w=2.1e-08 $l=4.9e-08 $layer=Gate_1 $thickness=5.6e-08
+ $X=1.053 $Y=0.0675 $X2=1.053 $Y2=0.1165
r14 13 70 6.54019 $w=2.09524e-08 $layer=Gate_1 $thickness=5.21905e-08 $X=1.053
+ $Y=0.136 $X2=1.053 $Y2=0.136
r15 13 90 6.81977 $w=2.04359e-08 $l=1.95e-08 $layer=Gate_1 $thickness=5.6e-08
+ $X=1.053 $Y=0.136 $X2=1.053 $Y2=0.1165
r16 13 91 6.47963 $w=2.04054e-08 $l=1.85e-08 $layer=Gate_1 $thickness=5.6e-08
+ $X=1.053 $Y=0.136 $X2=1.053 $Y2=0.1545
r17 86 85 14.6259 $w=2.1e-08 $l=4.3e-08 $layer=Gate_1 $thickness=5.6e-08
+ $X=0.999 $Y=0.2025 $X2=0.999 $Y2=0.1595
r18 84 85 2.55104 $w=2.1e-08 $l=7.5e-09 $layer=Gate_1 $thickness=5.6e-08
+ $X=0.999 $Y=0.152 $X2=0.999 $Y2=0.1595
r19 82 83 14.6259 $w=2.1e-08 $l=4.3e-08 $layer=Gate_1 $thickness=5.6e-08
+ $X=0.999 $Y=0.0675 $X2=0.999 $Y2=0.1105
r20 80 83 2.89117 $w=2.1e-08 $l=8.5e-09 $layer=Gate_1 $thickness=5.6e-08
+ $X=0.999 $Y=0.119 $X2=0.999 $Y2=0.1105
r21 12 66 6.27904 $w=2.09e-08 $layer=Gate_1 $thickness=5.24e-08 $X=0.999
+ $Y=0.136 $X2=0.999 $Y2=0.136
r22 12 80 5.96942 $w=2.03529e-08 $l=1.7e-08 $layer=Gate_1 $thickness=5.6e-08
+ $X=0.999 $Y=0.136 $X2=0.999 $Y2=0.119
r23 12 84 5.62929 $w=2.03125e-08 $l=1.6e-08 $layer=Gate_1 $thickness=5.6e-08
+ $X=0.999 $Y=0.136 $X2=0.999 $Y2=0.152
r24 79 77 0.0925926 $w=2.7e-08 $l=2.5e-09 $layer=P_src_drn $thickness=1e-09
+ $X=0.7193 $Y=0.2295 $X2=0.7165 $Y2=0.2295
r25 6 77 0.537037 $w=2.7e-08 $l=1.45e-08 $layer=P_src_drn $thickness=1e-09
+ $X=0.702 $Y=0.2295 $X2=0.7165 $Y2=0.2295
r26 16 6 0.537037 $w=2.7e-08 $l=1.45e-08 $layer=P_src_drn $thickness=1e-09
+ $X=0.6875 $Y=0.2295 $X2=0.702 $Y2=0.2295
r27 78 16 0.0925926 $w=2.7e-08 $l=2.5e-09 $layer=P_src_drn $thickness=1e-09
+ $X=0.6846 $Y=0.2295 $X2=0.6875 $Y2=0.2295
r28 5 64 19.3796 $a=3.24e-16 $layer=V0LISD $X=0.648 $Y=0.0405 $X2=0.648
+ $Y2=0.036
r29 71 72 12.6539 $w=1.77815e-08 $l=2.7e-08 $layer=LIG $thickness=4.8e-08
+ $X=1.08 $Y=0.136 $X2=1.107 $Y2=0.136
r30 70 71 12.6539 $w=1.77815e-08 $l=2.7e-08 $layer=LIG $thickness=4.8e-08
+ $X=1.053 $Y=0.136 $X2=1.08 $Y2=0.136
r31 69 70 12.6539 $w=1.77815e-08 $l=2.7e-08 $layer=LIG $thickness=4.8e-08
+ $X=1.026 $Y=0.136 $X2=1.053 $Y2=0.136
r32 67 69 10.1729 $w=1.54914e-08 $l=1.75e-08 $layer=LIG $thickness=4.8e-08
+ $X=1.0085 $Y=0.136 $X2=1.026 $Y2=0.136
r33 66 67 2.48102 $w=2.2e-08 $l=9.5e-09 $layer=LIG $thickness=4.8e-08 $X=0.999
+ $Y=0.136 $X2=1.0085 $Y2=0.136
r34 2 66 2.48102 $w=2.2e-08 $l=9.5e-09 $layer=LIG $thickness=4.8e-08 $X=0.9895
+ $Y=0.136 $X2=0.999 $Y2=0.136
r35 6 57 19.3796 $a=3.24e-16 $layer=V0LISD $X=0.702 $Y=0.2295 $X2=0.702
+ $Y2=0.234
r36 64 65 3.14806 $w=1.3e-08 $l=1.35e-08 $layer=M1 $thickness=3.6e-08 $X=0.648
+ $Y=0.036 $X2=0.6615 $Y2=0.036
r37 62 65 3.14806 $w=1.3e-08 $l=1.35e-08 $layer=M1 $thickness=3.6e-08 $X=0.675
+ $Y=0.036 $X2=0.6615 $Y2=0.036
r38 61 62 2.56509 $w=1.3e-08 $l=1.1e-08 $layer=M1 $thickness=3.6e-08 $X=0.686
+ $Y=0.036 $X2=0.675 $Y2=0.036
r39 22 61 4.19742 $w=1.3e-08 $l=1.8e-08 $layer=M1 $thickness=3.6e-08 $X=0.704
+ $Y=0.036 $X2=0.686 $Y2=0.036
r40 59 66 19.3796 $a=3.24e-16 $layer=V0LIG $X=0.999 $Y=0.1445 $X2=0.999
+ $Y2=0.136
r41 29 59 8.39483 $w=1.3e-08 $l=3.6e-08 $layer=M1 $thickness=3.6e-08 $X=0.999
+ $Y=0.1085 $X2=0.999 $Y2=0.1445
r42 57 58 3.14806 $w=1.3e-08 $l=1.35e-08 $layer=M1 $thickness=3.6e-08 $X=0.702
+ $Y=0.234 $X2=0.7155 $Y2=0.234
r43 17 24 7.21452 $w=1.425e-08 $l=3.6e-08 $layer=M1 $thickness=3.6e-08 $X=0.729
+ $Y=0.234 $X2=0.729 $Y2=0.198
r44 17 58 1.96775 $w=1.63333e-08 $l=1.35e-08 $layer=M1 $thickness=3.6e-08
+ $X=0.729 $Y=0.234 $X2=0.7155 $Y2=0.234
r45 18 50 4.64701 $w=1.62667e-08 $l=2.7e-08 $layer=M1 $thickness=3.6e-08
+ $X=0.729 $Y=0.036 $X2=0.729 $Y2=0.063
r46 18 22 4.18063 $w=1.48e-08 $l=2.5e-08 $layer=M1 $thickness=3.6e-08 $X=0.729
+ $Y=0.036 $X2=0.704 $Y2=0.036
r47 54 59 19.5347 $a=3.24e-16 $layer=V1 $X=0.999 $Y=0.153 $X2=0.999 $Y2=0.1445
r48 53 54 12.5922 $w=1.3e-08 $l=5.4e-08 $layer=M2 $thickness=3.6e-08 $X=0.945
+ $Y=0.153 $X2=0.999 $Y2=0.153
r49 52 53 12.5922 $w=1.3e-08 $l=5.4e-08 $layer=M2 $thickness=3.6e-08 $X=0.891
+ $Y=0.153 $X2=0.945 $Y2=0.153
r50 30 52 2.68168 $w=1.3e-08 $l=1.15e-08 $layer=M2 $thickness=3.6e-08 $X=0.8795
+ $Y=0.153 $X2=0.891 $Y2=0.153
r51 51 52 39.0693 $a=1.62e-16 $layer=V1 $X=0.891 $Y=0.1485 $X2=0.891 $Y2=0.153
r52 28 51 4.19742 $w=1.3e-08 $l=1.8e-08 $layer=M1 $thickness=3.6e-08 $X=0.891
+ $Y=0.1305 $X2=0.891 $Y2=0.1485
r53 24 46 6.50021 $w=1.33448e-08 $l=2.9e-08 $layer=M1 $thickness=3.6e-08
+ $X=0.729 $Y=0.198 $X2=0.729 $Y2=0.169
r54 49 50 6.29612 $w=1.3e-08 $l=2.7e-08 $layer=M1 $thickness=3.6e-08 $X=0.729
+ $Y=0.09 $X2=0.729 $Y2=0.063
r55 48 49 4.43061 $w=1.3e-08 $l=1.9e-08 $layer=M1 $thickness=3.6e-08 $X=0.729
+ $Y=0.109 $X2=0.729 $Y2=0.09
r56 23 48 6.29612 $w=1.3e-08 $l=2.7e-08 $layer=M1 $thickness=3.6e-08 $X=0.729
+ $Y=0.136 $X2=0.729 $Y2=0.109
r57 21 47 0.9184 $w=1.8e-08 $l=9e-09 $layer=M1 $thickness=3.6e-08 $X=0.891
+ $Y=0.1575 $X2=0.891 $Y2=0.1665
r58 21 51 1.50855 $w=1.55e-08 $l=9e-09 $layer=M1 $thickness=3.6e-08 $X=0.891
+ $Y=0.1575 $X2=0.891 $Y2=0.1485
r59 21 52 39.0693 $a=1.62e-16 $layer=V1 $X=0.891 $Y=0.1575 $X2=0.891 $Y2=0.153
r60 19 46 0.9184 $w=1.8e-08 $l=9e-09 $layer=M1 $thickness=3.6e-08 $X=0.729
+ $Y=0.16 $X2=0.729 $Y2=0.169
r61 19 23 4.67854 $w=1.44583e-08 $l=2.4e-08 $layer=M1 $thickness=3.6e-08
+ $X=0.729 $Y=0.16 $X2=0.729 $Y2=0.136
r62 45 47 4.19024 $w=1.156e-08 $l=2.54018e-08 $layer=M1 $thickness=3.6e-08
+ $X=0.866 $Y=0.162 $X2=0.891 $Y2=0.1665
r63 27 45 4.19742 $w=1.3e-08 $l=1.8e-08 $layer=M1 $thickness=3.6e-08 $X=0.848
+ $Y=0.162 $X2=0.866 $Y2=0.162
r64 44 46 4.4015 $w=1.35e-08 $l=2.78927e-08 $layer=M1 $thickness=3.6e-08
+ $X=0.756 $Y=0.162 $X2=0.729 $Y2=0.169
r65 43 44 6.29612 $w=1.3e-08 $l=2.7e-08 $layer=M1 $thickness=3.6e-08 $X=0.783
+ $Y=0.162 $X2=0.756 $Y2=0.162
r66 25 43 6.29612 $w=1.3e-08 $l=2.7e-08 $layer=M1 $thickness=3.6e-08 $X=0.81
+ $Y=0.162 $X2=0.783 $Y2=0.162
r67 20 42 4.88263 $w=1.47308e-08 $l=2.6e-08 $layer=M1 $thickness=3.6e-08
+ $X=0.837 $Y=0.162 $X2=0.837 $Y2=0.136
r68 20 25 5.11582 $w=1.46667e-08 $l=2.7e-08 $layer=M1 $thickness=3.6e-08
+ $X=0.837 $Y=0.162 $X2=0.81 $Y2=0.162
r69 20 27 1.38478 $w=1.70909e-08 $l=1.1e-08 $layer=M1 $thickness=3.6e-08
+ $X=0.837 $Y=0.162 $X2=0.848 $Y2=0.162
r70 26 42 4.19742 $w=1.3e-08 $l=1.8e-08 $layer=M1 $thickness=3.6e-08 $X=0.837
+ $Y=0.118 $X2=0.837 $Y2=0.136
r71 41 42 19.3796 $a=3.24e-16 $layer=V0LIG $X=0.837 $Y=0.1355 $X2=0.837
+ $Y2=0.136
r72 1 36 4.22396 $w=1.97957e-08 $l=1.05e-08 $layer=Gate_1
+ $thickness=5.56522e-08 $X=0.837 $Y=0.1245 $X2=0.837 $Y2=0.135
r73 1 41 6.49795 $w=1.53e-08 $l=1.1e-08 $layer=LIG $thickness=4.8e-08 $X=0.837
+ $Y=0.1245 $X2=0.837 $Y2=0.1355
r74 39 38 14.6259 $w=2.1e-08 $l=4.3e-08 $layer=Gate_1 $thickness=5.6e-08
+ $X=0.837 $Y=0.2295 $X2=0.837 $Y2=0.1865
r75 37 38 11.9048 $w=2.1e-08 $l=3.5e-08 $layer=Gate_1 $thickness=5.6e-08
+ $X=0.837 $Y=0.1515 $X2=0.837 $Y2=0.1865
r76 36 37 5.79936 $w=2.03333e-08 $l=1.65e-08 $layer=Gate_1 $thickness=5.6e-08
+ $X=0.837 $Y=0.135 $X2=0.837 $Y2=0.1515
r77 35 36 5.79936 $w=2.03333e-08 $l=1.65e-08 $layer=Gate_1 $thickness=5.6e-08
+ $X=0.837 $Y=0.1185 $X2=0.837 $Y2=0.135
r78 34 35 11.9048 $w=2.1e-08 $l=3.5e-08 $layer=Gate_1 $thickness=5.6e-08
+ $X=0.837 $Y=0.0835 $X2=0.837 $Y2=0.1185
r79 33 34 14.6259 $w=2.1e-08 $l=4.3e-08 $layer=Gate_1 $thickness=5.6e-08
+ $X=0.837 $Y=0.0405 $X2=0.837 $Y2=0.0835
r80 33 11 5.44221 $w=2.1e-08 $l=1.6e-08 $layer=Gate_1 $thickness=5.6e-08
+ $X=0.837 $Y=0.0405 $X2=0.837 $Y2=0.0245
.ends

.subckt PM_DFFLQNx3_ASAP7_75t_R%12 vss 7 9 5 4 1
c1 1 vss 0.00828922f $X=0.351 $Y=0.0675
c2 4 vss 0.0028572f $X=0.3095 $Y=0.0675
c3 5 vss 0.00175602f $X=0.38 $Y=0.0675
r1 9 8 0.0308642 $w=8.1e-08 $l=2.5e-09 $layer=N_src_drn $thickness=1e-09
+ $X=0.3953 $Y=0.0675 $X2=0.3925 $Y2=0.0675
r2 5 8 0.154321 $w=8.1e-08 $l=1.25e-08 $layer=N_src_drn $thickness=1e-09
+ $X=0.38 $Y=0.0675 $X2=0.3925 $Y2=0.0675
r3 4 1 0.154321 $w=8.1e-08 $l=1.25e-08 $layer=N_src_drn $thickness=1e-09
+ $X=0.3095 $Y=0.0675 $X2=0.351 $Y2=0.0675
r4 7 4 0.0308642 $w=8.1e-08 $l=2.5e-09 $layer=N_src_drn $thickness=1e-09
+ $X=0.3066 $Y=0.0675 $X2=0.3095 $Y2=0.0675
r5 1 5 1e-05 $l=2.9e-08 $X=0.351 $Y=0.0675 $X2=0.38 $Y2=0.0675
.ends

.subckt PM_DFFLQNx3_ASAP7_75t_R%16 vss 2 3 1
c1 1 vss 0.00075171f $X=0.324 $Y=0.2025
r1 2 1 0.209877 $w=8.1e-08 $l=1.7e-08 $layer=P_src_drn $thickness=1e-09
+ $X=0.3066 $Y=0.2025 $X2=0.324 $Y2=0.2025
r2 3 1 0.209877 $w=8.1e-08 $l=1.7e-08 $layer=P_src_drn $thickness=1e-09
+ $X=0.3413 $Y=0.2025 $X2=0.324 $Y2=0.2025
.ends

* End of included file DFFLQNx3_ASAP7_75t_R.pex.sp.pex

*
.subckt DFFLQNx3_ASAP7_75t_CUSTOM_4_25_0_7 VSS VDD CLK D QN
*
* VSS VSS
* VDD VDD
* CLK CLK
* D D
* QN QN
*
*

M0 VSS N_M0_g N_M0_s VSS nmos_rvt L=2e-08 W=5.4e-08 nfin=2 $X=0.071 $Y=0.027
M1 N_M1_d N_M1_g VSS VSS nmos_rvt L=2e-08 W=5.4e-08 nfin=2 $X=0.125 $Y=0.027
M2 N_M2_d N_M2_g VSS VSS nmos_rvt L=2e-08 W=8.1e-08 nfin=3 $X=0.287 $Y=0.027
M3 N_M3_d N_M3_g N_M3_s VSS nmos_rvt L=2e-08 W=8.1e-08 nfin=3 $X=0.395 $Y=0.027
M4 N_M4_d N_M4_g N_M4_s VSS nmos_rvt L=2e-08 W=2.7e-08 nfin=1 $X=0.449 $Y=0.027
M5 VSS N_M5_g N_M5_s VSS nmos_rvt L=2e-08 W=2.7e-08 nfin=1 $X=0.503 $Y=0.027
M6 N_M6_d N_M6_g VSS VSS nmos_rvt L=2e-08 W=2.7e-08 nfin=1 $X=0.557 $Y=0.027
M7 N_M7_d N_M7_g N_M7_s VSS nmos_rvt L=2e-08 W=2.7e-08 nfin=1 $X=0.611 $Y=0.027
M8 N_M8_d N_M8_g N_M8_s VSS nmos_rvt L=2e-08 W=2.7e-08 nfin=1 $X=0.665 $Y=0.027
M9 VSS N_M9_g N_M9_s VSS nmos_rvt L=2e-08 W=2.7e-08 nfin=1 $X=0.773 $Y=0.027
M10 N_M10_d N_M10_g VSS VSS nmos_rvt L=2e-08 W=2.7e-08 nfin=1 $X=0.827 $Y=0.027
M11 N_M11_d N_M11_g VSS VSS nmos_rvt L=2e-08 W=8.1e-08 nfin=3 $X=0.989 $Y=0.027
M12 N_M12_d N_M12_g VSS VSS nmos_rvt L=2e-08 W=8.1e-08 nfin=3 $X=1.043 $Y=0.027
M13 N_M13_d N_M13_g VSS VSS nmos_rvt L=2e-08 W=8.1e-08 nfin=3 $X=1.097 $Y=0.027
M14 VDD N_M14_g N_M14_s VDD pmos_rvt L=2e-08 W=5.4e-08 nfin=2 $X=0.071 $Y=0.189
M15 N_M15_d N_M15_g VDD VDD pmos_rvt L=2e-08 W=5.4e-08 nfin=2 $X=0.125 $Y=0.189
M16 N_M16_d N_M16_g VDD VDD pmos_rvt L=2e-08 W=8.1e-08 nfin=3 $X=0.287 $Y=0.162
M17 N_M17_d N_M17_g N_M17_s VDD pmos_rvt L=2e-08 W=8.1e-08 nfin=3 $X=0.341
+ $Y=0.162
M18 N_M18_d N_M18_g N_M18_s VDD pmos_rvt L=2e-08 W=2.7e-08 nfin=1 $X=0.395
+ $Y=0.216
M19 VDD N_M19_g N_M19_s VDD pmos_rvt L=2e-08 W=2.7e-08 nfin=1 $X=0.503 $Y=0.216
M20 N_M20_d N_M20_g VDD VDD pmos_rvt L=2e-08 W=2.7e-08 nfin=1 $X=0.557 $Y=0.216
M21 N_M21_d N_M21_g N_M21_s VDD pmos_rvt L=2e-08 W=2.7e-08 nfin=1 $X=0.665
+ $Y=0.216
M22 N_M22_d N_M22_g N_M22_s VDD pmos_rvt L=2e-08 W=2.7e-08 nfin=1 $X=0.719
+ $Y=0.216
M23 VDD N_M23_g N_M23_s VDD pmos_rvt L=2e-08 W=2.7e-08 nfin=1 $X=0.773 $Y=0.216
M24 N_M24_d N_M24_g VDD VDD pmos_rvt L=2e-08 W=2.7e-08 nfin=1 $X=0.827 $Y=0.216
M25 N_M25_d N_M25_g VDD VDD pmos_rvt L=2e-08 W=8.1e-08 nfin=3 $X=0.989 $Y=0.162
M26 N_M26_d N_M26_g VDD VDD pmos_rvt L=2e-08 W=8.1e-08 nfin=3 $X=1.043 $Y=0.162
M27 N_M27_d N_M27_g VDD VDD pmos_rvt L=2e-08 W=8.1e-08 nfin=3 $X=1.097 $Y=0.162

* .include "DFFLQNx3_ASAP7_75t_R.pex.sp.pxi"

* Start of included file DFFLQNx3_ASAP7_75t_R.pex.sp.pxi
x_PM_DFFLQNx3_ASAP7_75t_R%CLK vss CLK N_M0_g N_M14_g N_CLK_3 N_CLK_4 N_CLK_7
+ N_CLK_1 N_CLK_8 N_CLK_5 N_CLK_6 PM_DFFLQNx3_ASAP7_75t_R%CLK
x_PM_DFFLQNx3_ASAP7_75t_R%13 vss N_M18_d N_M19_s N_13_5 N_13_1 N_13_4
+ PM_DFFLQNx3_ASAP7_75t_R%13
cc_1 N_13_5 N_4_10 0.00112978f $X=0.488 $Y=0.2295
cc_2 N_13_1 N_4_3 0.000800649f $X=0.432 $Y=0.2295
cc_3 N_13_1 N_4_18 0.00190594f $X=0.432 $Y=0.2295
cc_4 N_13_4 N_4_18 0.00639314f $X=0.4175 $Y=0.2295
cc_5 N_13_5 N_4_18 0.0229087f $X=0.488 $Y=0.2295
cc_6 N_13_4 N_6_11 0.0139073f $X=0.4175 $Y=0.2295
cc_7 N_13_5 N_7_10 0.0185426f $X=0.488 $Y=0.2295
cc_8 N_13_1 N_8_19 0.000397558f $X=0.432 $Y=0.2295
cc_9 N_13_1 N_8_17 0.000404479f $X=0.432 $Y=0.2295
cc_10 N_13_4 N_8_3 0.000508722f $X=0.4175 $Y=0.2295
cc_11 N_13_1 N_8_16 0.00260156f $X=0.432 $Y=0.2295
x_PM_DFFLQNx3_ASAP7_75t_R%15 vss N_M4_d N_M5_s N_15_1 PM_DFFLQNx3_ASAP7_75t_R%15
cc_12 N_15_1 N_4_18 0.00756209f $X=0.486 $Y=0.0405
cc_13 N_15_1 N_7_10 0.00766123f $X=0.486 $Y=0.0405
x_PM_DFFLQNx3_ASAP7_75t_R%8 vss N_M6_g N_M20_g N_M3_d N_M4_s N_M17_d N_M18_s
+ N_8_10 N_8_18 N_8_13 N_8_3 N_8_19 N_8_16 N_8_11 N_8_1 N_8_20 N_8_4 N_8_12
+ N_8_17 N_8_9 N_8_14 N_8_15 PM_DFFLQNx3_ASAP7_75t_R%8
cc_14 N_8_10 N_4_35 0.000133684f $X=0.4175 $Y=0.0405
cc_15 N_8_10 N_4_17 0.000137875f $X=0.4175 $Y=0.0405
cc_16 N_8_10 N_4_4 0.000168616f $X=0.4175 $Y=0.0405
cc_17 N_8_10 N_4_34 0.000184013f $X=0.4175 $Y=0.0405
cc_18 N_8_18 N_4_35 0.000222222f $X=0.459 $Y=0.114
cc_19 N_8_13 N_4_17 0.0237531f $X=0.3635 $Y=0.189
cc_20 N_8_3 N_4_34 0.00154363f $X=0.378 $Y=0.2295
cc_21 N_8_3 N_4_2 0.000303864f $X=0.378 $Y=0.2295
cc_22 N_8_19 N_4_35 0.00272235f $X=0.459 $Y=0.1525
cc_23 N_8_16 N_4_35 0.000417227f $X=0.459 $Y=0.234
cc_24 N_8_11 N_4_18 0.00542654f $X=0.4175 $Y=0.081
cc_25 N_8_1 N_4_10 0.00202419f $X=0.567 $Y=0.1215
cc_26 N_8_20 N_4_10 0.000585913f $X=0.54 $Y=0.131
cc_27 N_8_4 N_4_18 0.000614077f $X=0.432 $Y=0.0405
cc_28 N_8_12 N_4_2 0.000736734f $X=0.3635 $Y=0.2295
cc_29 N_8_19 N_4_3 0.00100585f $X=0.459 $Y=0.1525
cc_30 N_8_17 N_4_34 0.00140458f $X=0.434 $Y=0.234
cc_31 N_8_17 N_4_36 0.00150246f $X=0.434 $Y=0.234
cc_32 N_8_3 N_4_17 0.001687f $X=0.378 $Y=0.2295
cc_33 N_8_20 N_4_35 0.00313748f $X=0.54 $Y=0.131
cc_34 N_8_9 N_4_10 0.0042132f $X=0.567 $Y=0.0245
cc_35 N_8_12 N_4_17 0.00960547f $X=0.3635 $Y=0.2295
cc_36 N_8_9 N_4_19 0.0117759f $X=0.567 $Y=0.0245
cc_37 N_8_10 N_4_18 0.0308756f $X=0.4175 $Y=0.0405
cc_38 N_8_3 N_D_5 0.000402224f $X=0.378 $Y=0.2295
cc_39 N_8_17 N_D_5 0.00159241f $X=0.434 $Y=0.234
cc_40 N_8_17 N_6_20 0.000275875f $X=0.434 $Y=0.234
cc_41 N_8_19 N_6_20 0.00200114f $X=0.459 $Y=0.1525
cc_42 N_8_13 N_6_11 0.0054064f $X=0.3635 $Y=0.189
cc_43 N_8_14 N_6_20 0.000431069f $X=0.459 $Y=0.036
cc_44 N_8_4 N_6_1 0.000799703f $X=0.432 $Y=0.0405
cc_45 N_8_4 N_6_11 0.00100891f $X=0.432 $Y=0.0405
cc_46 N_8_3 N_6_11 0.00103465f $X=0.378 $Y=0.2295
cc_47 N_8_18 N_6_20 0.00104749f $X=0.459 $Y=0.114
cc_48 N_8_20 N_6_22 0.00139343f $X=0.54 $Y=0.131
cc_49 N_8_10 N_6_1 0.00160756f $X=0.4175 $Y=0.0405
cc_50 N_8_19 N_6_22 0.00219106f $X=0.459 $Y=0.1525
cc_51 N_8_15 N_6_20 0.00257764f $X=0.459 $Y=0.131
cc_52 N_8_10 N_6_11 0.00933912f $X=0.4175 $Y=0.0405
cc_53 N_8_12 N_6_11 0.0104882f $X=0.3635 $Y=0.2295
cc_54 N_8_11 N_6_11 0.0443676f $X=0.4175 $Y=0.081
cc_55 N_8_4 N_7_1 0.000329111f $X=0.432 $Y=0.0405
cc_56 N_8_20 N_7_14 0.000463542f $X=0.54 $Y=0.131
cc_57 N_8_20 N_7_1 0.000884663f $X=0.54 $Y=0.131
cc_58 N_8_1 N_7_16 0.000978511f $X=0.567 $Y=0.1215
cc_59 N_8_20 N_7_19 0.00100284f $X=0.54 $Y=0.131
cc_60 N_8_18 N_7_16 0.00108419f $X=0.459 $Y=0.114
cc_61 N_8_1 N_7_10 0.00111842f $X=0.567 $Y=0.1215
cc_62 N_8_9 N_7_3 0.00113418f $X=0.567 $Y=0.0245
cc_63 N_8_9 N_7_1 0.00114639f $X=0.567 $Y=0.0245
cc_64 N_8_9 N_7_11 0.00615793f $X=0.567 $Y=0.0245
cc_65 N_8_9 N_7_12 0.00625919f $X=0.567 $Y=0.0245
cc_66 N_8_20 N_7_16 0.00671089f $X=0.54 $Y=0.131
cc_67 N_8_9 N_7_10 0.0292166f $X=0.567 $Y=0.0245
x_PM_DFFLQNx3_ASAP7_75t_R%17 vss N_M22_d N_M23_s N_17_1
+ PM_DFFLQNx3_ASAP7_75t_R%17
cc_68 N_17_1 N_4_20 0.00757779f $X=0.756 $Y=0.2295
cc_69 N_17_1 N_9_9 0.00762858f $X=0.756 $Y=0.2295
x_PM_DFFLQNx3_ASAP7_75t_R%D vss D N_M2_g N_M16_g N_D_3 N_D_1 N_D_6 N_D_5 N_D_4
+ PM_DFFLQNx3_ASAP7_75t_R%D
cc_70 N_D_3 N_4_27 9.64591e-20 $X=0.297 $Y=0.0245
cc_71 N_D_3 N_4_33 9.84682e-20 $X=0.297 $Y=0.0245
cc_72 N_D_3 N_4_34 0.000904816f $X=0.297 $Y=0.0245
cc_73 N_D_1 N_4_2 0.00225005f $X=0.297 $Y=0.135
cc_74 N_D_6 N_4_36 0.000984252f $X=0.297 $Y=0.116
cc_75 N_D_6 N_4_34 0.00427945f $X=0.297 $Y=0.116
cc_76 N_D_3 N_4_17 0.00508196f $X=0.297 $Y=0.0245
x_PM_DFFLQNx3_ASAP7_75t_R%4 vss N_M1_g N_M15_g N_M17_g N_M4_g N_M7_g N_M22_g
+ N_M0_s N_M14_s N_4_23 N_4_24 N_4_26 N_4_27 N_4_9 N_4_8 N_4_33 N_4_21 N_4_22
+ N_4_32 N_4_31 N_4_1 N_4_30 N_4_36 N_4_28 N_4_16 N_4_34 N_4_2 N_4_17 N_4_4
+ N_4_5 N_4_35 N_4_10 N_4_3 N_4_19 N_4_18 N_4_20 PM_DFFLQNx3_ASAP7_75t_R%4
cc_77 N_4_23 N_CLK_3 8.06591e-20 $X=0.018 $Y=0.036
cc_78 N_4_24 N_CLK_3 0.000220998f $X=0.0165 $Y=0.189
cc_79 N_4_26 N_CLK_3 0.000224667f $X=0.189 $Y=0.189
cc_80 N_4_27 N_CLK_3 0.000240317f $X=0.189 $Y=0.135
cc_81 N_4_9 N_CLK_3 0.0010554f $X=0.054 $Y=0.216
cc_82 N_4_8 N_CLK_3 0.00112698f $X=0.054 $Y=0.054
cc_83 N_4_33 N_CLK_3 0.000293521f $X=0.189 $Y=0.154
cc_84 N_4_21 N_CLK_3 0.011101f $X=0.056 $Y=0.054
cc_85 N_4_22 N_CLK_3 0.011035f $X=0.056 $Y=0.216
cc_86 N_4_32 N_CLK_3 0.000603132f $X=0.1235 $Y=0.135
cc_87 N_4_31 N_CLK_3 0.000684074f $X=0.036 $Y=0.234
cc_88 N_4_1 N_CLK_4 0.000785371f $X=0.135 $Y=0.135
cc_89 N_4_30 N_CLK_7 0.000863422f $X=0.036 $Y=0.036
cc_90 N_4_32 N_CLK_1 0.000881094f $X=0.1235 $Y=0.135
cc_91 N_4_31 N_CLK_8 0.00134292f $X=0.036 $Y=0.234
cc_92 N_4_36 N_CLK_5 0.00156429f $X=0.0215 $Y=0.189
cc_93 N_4_28 N_CLK_6 0.00183049f $X=0.018 $Y=0.172
cc_94 N_4_32 N_CLK_6 0.00201601f $X=0.1235 $Y=0.135
cc_95 N_4_30 N_CLK_4 0.00213612f $X=0.036 $Y=0.036
cc_96 N_4_1 N_CLK_1 0.00241733f $X=0.135 $Y=0.135
cc_97 N_4_26 N_CLK_5 0.00245515f $X=0.189 $Y=0.189
cc_98 N_4_24 N_CLK_5 0.00250889f $X=0.0165 $Y=0.189
cc_99 N_4_32 N_CLK_4 0.00319048f $X=0.1235 $Y=0.135
cc_100 N_4_16 N_CLK_3 0.0355899f $X=0.135 $Y=0.0245
x_PM_DFFLQNx3_ASAP7_75t_R%6 vss N_M3_g N_M18_g N_M8_g N_M21_g N_M1_d N_M15_d
+ N_6_5 N_6_6 N_6_18 N_6_17 N_6_13 N_6_12 N_6_16 N_6_14 N_6_22 N_6_2 N_6_11
+ N_6_21 N_6_20 N_6_19 N_6_1 N_6_15 PM_DFFLQNx3_ASAP7_75t_R%6
cc_101 N_6_5 N_CLK_7 0.000466939f $X=0.162 $Y=0.054
cc_102 N_6_6 N_CLK_7 0.000194572f $X=0.162 $Y=0.216
cc_103 N_6_18 N_CLK_7 0.00117913f $X=0.216 $Y=0.234
cc_104 N_6_17 N_CLK_7 0.0023162f $X=0.216 $Y=0.036
cc_105 N_6_13 N_4_8 9.35035e-20 $X=0.1475 $Y=0.054
cc_106 N_6_13 N_4_31 5.19961e-20 $X=0.1475 $Y=0.054
cc_107 N_6_13 N_4_9 5.45547e-20 $X=0.1475 $Y=0.054
cc_108 N_6_13 N_4_24 5.82638e-20 $X=0.1475 $Y=0.054
cc_109 N_6_5 N_4_28 7.47517e-20 $X=0.162 $Y=0.054
cc_110 N_6_5 N_4_16 0.000765064f $X=0.162 $Y=0.054
cc_111 N_6_17 N_4_30 0.000148594f $X=0.216 $Y=0.036
cc_112 N_6_12 N_4_4 0.000190373f $X=0.675 $Y=0.135
cc_113 N_6_16 N_4_26 0.000229396f $X=0.243 $Y=0.234
cc_114 N_6_12 N_4_5 0.000244847f $X=0.675 $Y=0.135
cc_115 N_6_18 N_4_26 0.00461554f $X=0.216 $Y=0.234
cc_116 N_6_14 N_4_16 0.0110692f $X=0.1475 $Y=0.216
cc_117 N_6_22 N_4_35 0.000900134f $X=0.2315 $Y=0.153
cc_118 N_6_6 N_4_1 0.000398564f $X=0.162 $Y=0.216
cc_119 N_6_6 N_4_26 0.000427882f $X=0.162 $Y=0.216
cc_120 N_6_2 N_4_10 0.0024285f $X=0.675 $Y=0.135
cc_121 N_6_11 N_4_3 0.000469478f $X=0.405 $Y=0.0245
cc_122 N_6_22 N_4_34 0.000514389f $X=0.2315 $Y=0.153
cc_123 N_6_21 N_4_10 0.000535573f $X=0.675 $Y=0.1125
cc_124 N_6_20 N_4_36 0.000561037f $X=0.405 $Y=0.116
cc_125 N_6_17 N_4_27 0.000561974f $X=0.216 $Y=0.036
cc_126 N_6_13 N_4_1 0.000672326f $X=0.1475 $Y=0.054
cc_127 N_6_19 N_4_36 0.000693028f $X=0.243 $Y=0.135
cc_128 N_6_5 N_4_32 0.000856626f $X=0.162 $Y=0.054
cc_129 N_6_1 N_4_2 0.00243806f $X=0.405 $Y=0.133
cc_130 N_6_19 N_4_33 0.000975523f $X=0.243 $Y=0.135
cc_131 N_6_6 N_4_16 0.00111469f $X=0.162 $Y=0.216
cc_132 N_6_11 N_4_17 0.00164501f $X=0.405 $Y=0.0245
cc_133 N_6_20 N_4_34 0.00306294f $X=0.405 $Y=0.116
cc_134 N_6_19 N_4_27 0.00342787f $X=0.243 $Y=0.135
cc_135 N_6_12 N_4_10 0.00375601f $X=0.675 $Y=0.135
cc_136 N_6_12 N_4_19 0.00549905f $X=0.675 $Y=0.135
cc_137 N_6_11 N_4_18 0.00850299f $X=0.405 $Y=0.0245
cc_138 N_6_12 N_4_20 0.0172213f $X=0.675 $Y=0.135
cc_139 N_6_22 N_4_36 0.0253088f $X=0.2315 $Y=0.153
cc_140 N_6_13 N_4_16 0.0390953f $X=0.1475 $Y=0.054
cc_141 N_6_16 N_D_5 0.0010218f $X=0.243 $Y=0.234
cc_142 N_6_22 N_D_6 0.00112115f $X=0.2315 $Y=0.153
cc_143 N_6_15 N_D_4 0.0012609f $X=0.243 $Y=0.036
cc_144 N_6_19 N_D_6 0.00813795f $X=0.243 $Y=0.135
x_PM_DFFLQNx3_ASAP7_75t_R%7 vss N_M5_g N_M19_g N_M6_d N_M7_s N_M20_d N_M21_s
+ N_7_3 N_7_1 N_7_4 N_7_12 N_7_13 N_7_17 N_7_19 N_7_11 N_7_10 N_7_18 N_7_14
+ N_7_16 PM_DFFLQNx3_ASAP7_75t_R%7
cc_145 N_7_3 N_4_35 0.000230387f $X=0.594 $Y=0.0405
cc_146 N_7_3 N_4_3 0.00010497f $X=0.594 $Y=0.0405
cc_147 N_7_3 N_4_10 0.000337309f $X=0.594 $Y=0.0405
cc_148 N_7_1 N_4_18 0.00069346f $X=0.513 $Y=0.09
cc_149 N_7_4 N_4_10 0.00652078f $X=0.594 $Y=0.2295
cc_150 N_7_12 N_4_19 0.00762788f $X=0.5795 $Y=0.2295
cc_151 N_7_13 N_4_19 0.00767505f $X=0.65 $Y=0.2295
cc_152 N_7_17 N_4_35 0.000342061f $X=0.5965 $Y=0.234
cc_153 N_7_17 N_4_10 0.000479617f $X=0.5965 $Y=0.234
cc_154 N_7_4 N_4_4 0.000871281f $X=0.594 $Y=0.2295
cc_155 N_7_19 N_4_10 0.00164006f $X=0.621 $Y=0.1105
cc_156 N_7_4 N_4_19 0.00228889f $X=0.594 $Y=0.2295
cc_157 N_7_11 N_4_19 0.00632598f $X=0.5795 $Y=0.0405
cc_158 N_7_10 N_4_18 0.0136873f $X=0.513 $Y=0.0245
cc_159 N_7_3 N_4_19 0.029123f $X=0.594 $Y=0.0405
cc_160 N_7_13 N_6_21 0.00015435f $X=0.65 $Y=0.2295
cc_161 N_7_13 N_6_22 0.000213276f $X=0.65 $Y=0.2295
cc_162 N_7_13 N_6_2 0.000222687f $X=0.65 $Y=0.2295
cc_163 N_7_18 N_6_21 0.000255635f $X=0.594 $Y=0.054
cc_164 N_7_19 N_6_21 0.00455877f $X=0.621 $Y=0.1105
cc_165 N_7_19 N_6_2 0.000355934f $X=0.621 $Y=0.1105
cc_166 N_7_14 N_6_21 0.000751356f $X=0.594 $Y=0.09
cc_167 N_7_16 N_6_22 0.00268544f $X=0.5 $Y=0.09
cc_168 N_7_13 N_6_12 0.0156515f $X=0.65 $Y=0.2295
x_PM_DFFLQNx3_ASAP7_75t_R%9 vss N_M9_g N_M23_g N_M10_d N_M24_d N_9_9 N_9_14
+ N_9_18 N_9_4 N_9_3 N_9_1 N_9_17 N_9_12 N_9_15 N_9_16 N_9_10 N_9_11
+ PM_DFFLQNx3_ASAP7_75t_R%9
cc_169 N_9_9 N_4_10 0.000207779f $X=0.783 $Y=0.0245
cc_170 N_9_9 N_4_5 0.000410434f $X=0.783 $Y=0.0245
cc_171 N_9_9 N_4_20 0.0128627f $X=0.783 $Y=0.0245
x_PM_DFFLQNx3_ASAP7_75t_R%QN vss QN N_M11_d N_M12_d N_M13_d N_M25_d N_M26_d
+ N_M27_d N_QN_15 N_QN_1 N_QN_2 N_QN_14 N_QN_16 N_QN_13
+ PM_DFFLQNx3_ASAP7_75t_R%QN
cc_172 N_QN_15 N_10_29 0.00286946f $X=1.0115 $Y=0.2025
cc_173 N_QN_15 N_10_2 0.00790411f $X=1.0115 $Y=0.2025
cc_174 N_QN_15 N_10_14 0.00322969f $X=1.0115 $Y=0.2025
cc_175 N_QN_15 N_10_30 0.00064916f $X=1.0115 $Y=0.2025
cc_176 N_QN_15 N_10_13 0.0574353f $X=1.0115 $Y=0.2025
cc_177 N_QN_1 N_10_13 0.00191352f $X=1.026 $Y=0.0675
cc_178 N_QN_2 N_10_13 0.00194576f $X=1.026 $Y=0.2025
cc_179 N_QN_14 N_10_14 0.014562f $X=1.1195 $Y=0.0675
cc_180 N_QN_16 N_10_14 0.0520758f $X=1.1195 $Y=0.2025
cc_181 N_QN_13 N_10_13 0.0103962f $X=1.0115 $Y=0.0675
cc_182 N_QN_13 N_10_12 0.0184767f $X=1.0115 $Y=0.0675
cc_183 N_QN_15 N_10_12 0.0476507f $X=1.0115 $Y=0.2025
x_PM_DFFLQNx3_ASAP7_75t_R%14 vss N_M8_d N_M9_s N_14_1 N_14_5 N_14_4
+ PM_DFFLQNx3_ASAP7_75t_R%14
cc_184 N_14_1 N_4_20 0.000699307f $X=0.702 $Y=0.0405
cc_185 N_14_5 N_4_20 0.00666805f $X=0.758 $Y=0.0405
cc_186 N_14_4 N_4_20 0.025755f $X=0.6875 $Y=0.0405
cc_187 N_14_4 N_6_12 0.0147721f $X=0.6875 $Y=0.0405
cc_188 N_14_1 N_9_9 0.000885209f $X=0.702 $Y=0.0405
cc_189 N_14_5 N_9_9 0.014978f $X=0.758 $Y=0.0405
cc_190 N_14_1 N_10_15 0.000289721f $X=0.702 $Y=0.0405
cc_191 N_14_1 N_10_22 0.000417428f $X=0.702 $Y=0.0405
cc_192 N_14_1 N_10_23 0.000529888f $X=0.702 $Y=0.0405
cc_193 N_14_4 N_10_5 0.000557108f $X=0.6875 $Y=0.0405
cc_194 N_14_1 N_10_18 0.00238611f $X=0.702 $Y=0.0405
x_PM_DFFLQNx3_ASAP7_75t_R%10 vss N_M10_g N_M24_g N_M21_d N_M22_s N_M11_g
+ N_M25_g N_M12_g N_M26_g N_M13_g N_M27_g N_M7_d N_M8_s N_10_16 N_10_19 N_10_17
+ N_10_6 N_10_15 N_10_25 N_10_23 N_10_24 N_10_5 N_10_30 N_10_22 N_10_2 N_10_20
+ N_10_29 N_10_21 N_10_27 N_10_11 N_10_1 N_10_18 N_10_26 N_10_28 N_10_14
+ N_10_13 N_10_12 PM_DFFLQNx3_ASAP7_75t_R%10
cc_195 N_10_16 N_4_4 4.32634e-20 $X=0.6875 $Y=0.2295
cc_196 N_10_19 N_4_10 0.000161924f $X=0.729 $Y=0.16
cc_197 N_10_17 N_4_10 0.000205557f $X=0.729 $Y=0.234
cc_198 N_10_6 N_4_10 0.000209185f $X=0.702 $Y=0.2295
cc_199 N_10_15 N_4_19 0.00656552f $X=0.6335 $Y=0.0405
cc_200 N_10_25 N_4_5 0.000391283f $X=0.81 $Y=0.162
cc_201 N_10_23 N_4_10 0.000483068f $X=0.729 $Y=0.136
cc_202 N_10_24 N_4_10 0.000560028f $X=0.729 $Y=0.198
cc_203 N_10_6 N_4_20 0.000927852f $X=0.702 $Y=0.2295
cc_204 N_10_16 N_4_5 0.0013197f $X=0.6875 $Y=0.2295
cc_205 N_10_16 N_4_10 0.00211595f $X=0.6875 $Y=0.2295
cc_206 N_10_5 N_4_19 0.00946003f $X=0.648 $Y=0.0405
cc_207 N_10_16 N_4_20 0.0166856f $X=0.6875 $Y=0.2295
cc_208 N_10_30 N_6_22 0.000116828f $X=0.8795 $Y=0.153
cc_209 N_10_6 N_6_12 0.000132205f $X=0.702 $Y=0.2295
cc_210 N_10_16 N_6_12 0.00643982f $X=0.6875 $Y=0.2295
cc_211 N_10_25 N_6_21 0.00014867f $X=0.81 $Y=0.162
cc_212 N_10_15 N_6_12 0.0065504f $X=0.6335 $Y=0.0405
cc_213 N_10_17 N_6_21 0.000372554f $X=0.729 $Y=0.234
cc_214 N_10_19 N_6_21 0.000947594f $X=0.729 $Y=0.16
cc_215 N_10_24 N_6_21 0.000503598f $X=0.729 $Y=0.198
cc_216 N_10_23 N_6_2 0.000505057f $X=0.729 $Y=0.136
cc_217 N_10_5 N_6_2 0.000506675f $X=0.648 $Y=0.0405
cc_218 N_10_22 N_6_21 0.000595848f $X=0.704 $Y=0.036
cc_219 N_10_22 N_6_22 0.00102053f $X=0.704 $Y=0.036
cc_220 N_10_23 N_6_21 0.00376506f $X=0.729 $Y=0.136
cc_221 N_10_5 N_6_12 0.0187755f $X=0.648 $Y=0.0405
cc_222 N_10_22 N_7_3 0.000105767f $X=0.704 $Y=0.036
cc_223 N_10_17 N_7_3 0.00018693f $X=0.729 $Y=0.234
cc_224 N_10_16 N_7_3 0.000433971f $X=0.6875 $Y=0.2295
cc_225 N_10_15 N_7_11 0.000459362f $X=0.6335 $Y=0.0405
cc_226 N_10_17 N_7_4 0.000264411f $X=0.729 $Y=0.234
cc_227 N_10_6 N_7_4 0.000727389f $X=0.702 $Y=0.2295
cc_228 N_10_17 N_7_19 0.000565632f $X=0.729 $Y=0.234
cc_229 N_10_16 N_7_4 0.000574655f $X=0.6875 $Y=0.2295
cc_230 N_10_22 N_7_18 0.000596031f $X=0.704 $Y=0.036
cc_231 N_10_22 N_7_14 0.00152335f $X=0.704 $Y=0.036
cc_232 N_10_5 N_7_3 0.00346745f $X=0.648 $Y=0.0405
cc_233 N_10_24 N_9_9 0.000135974f $X=0.729 $Y=0.198
cc_234 N_10_2 N_9_9 0.000148113f $X=0.9895 $Y=0.136
cc_235 N_10_20 N_9_9 0.000212908f $X=0.837 $Y=0.162
cc_236 N_10_29 N_9_9 0.000237002f $X=0.999 $Y=0.1085
cc_237 N_10_21 N_9_14 0.000238549f $X=0.891 $Y=0.1575
cc_238 N_10_29 N_9_18 0.001937f $X=0.999 $Y=0.1085
cc_239 N_10_2 N_9_18 0.000307282f $X=0.9895 $Y=0.136
cc_240 N_10_27 N_9_4 0.000372453f $X=0.848 $Y=0.162
cc_241 N_10_21 N_9_18 0.00126189f $X=0.891 $Y=0.1575
cc_242 N_10_11 N_9_3 0.000396596f $X=0.837 $Y=0.0245
cc_243 N_10_11 N_9_4 0.000538562f $X=0.837 $Y=0.0245
cc_244 N_10_1 N_9_1 0.000606623f $X=0.837 $Y=0.1245
cc_245 N_10_27 N_9_17 0.000689055f $X=0.848 $Y=0.162
cc_246 N_10_18 N_9_12 0.000791702f $X=0.729 $Y=0.036
cc_247 N_10_26 N_9_15 0.000832677f $X=0.837 $Y=0.118
cc_248 N_10_23 N_9_1 0.000971974f $X=0.729 $Y=0.136
cc_249 N_10_1 N_9_9 0.00109099f $X=0.837 $Y=0.1245
cc_250 N_10_28 N_9_16 0.00113139f $X=0.891 $Y=0.1305
cc_251 N_10_11 N_9_1 0.00118373f $X=0.837 $Y=0.0245
cc_252 N_10_21 N_9_17 0.00121033f $X=0.891 $Y=0.1575
cc_253 N_10_25 N_9_15 0.00148068f $X=0.81 $Y=0.162
cc_254 N_10_30 N_9_18 0.00182857f $X=0.8795 $Y=0.153
cc_255 N_10_11 N_9_10 0.00654703f $X=0.837 $Y=0.0245
cc_256 N_10_11 N_9_11 0.00658391f $X=0.837 $Y=0.0245
cc_257 N_10_23 N_9_15 0.00455718f $X=0.729 $Y=0.136
cc_258 N_10_28 N_9_18 0.00661171f $X=0.891 $Y=0.1305
cc_259 N_10_11 N_9_9 0.0306213f $X=0.837 $Y=0.0245
x_PM_DFFLQNx3_ASAP7_75t_R%12 vss N_M2_d N_M3_s N_12_5 N_12_4 N_12_1
+ PM_DFFLQNx3_ASAP7_75t_R%12
cc_260 N_12_5 N_4_34 0.000183141f $X=0.38 $Y=0.0675
cc_261 N_12_5 N_4_2 0.00194104f $X=0.38 $Y=0.0675
cc_262 N_12_5 N_4_17 0.0721368f $X=0.38 $Y=0.0675
cc_263 N_12_4 N_D_6 0.000706179f $X=0.3095 $Y=0.0675
cc_264 N_12_4 N_D_3 0.0355778f $X=0.3095 $Y=0.0675
cc_265 N_12_5 N_6_20 0.000277752f $X=0.38 $Y=0.0675
cc_266 N_12_5 N_6_1 0.000626124f $X=0.38 $Y=0.0675
cc_267 N_12_5 N_6_11 0.034428f $X=0.38 $Y=0.0675
cc_268 N_12_1 N_8_11 0.000581307f $X=0.351 $Y=0.0675
cc_269 N_12_1 N_8_4 0.00106572f $X=0.351 $Y=0.0675
cc_270 N_12_1 N_8_10 0.0026021f $X=0.351 $Y=0.0675
x_PM_DFFLQNx3_ASAP7_75t_R%16 vss N_M16_d N_M17_s N_16_1
+ PM_DFFLQNx3_ASAP7_75t_R%16
cc_271 N_16_1 N_4_17 0.0169027f $X=0.324 $Y=0.2025
cc_272 N_16_1 N_D_3 0.0167052f $X=0.324 $Y=0.2025

* End of included file DFFLQNx3_ASAP7_75t_R.pex.sp.pxi
.ends

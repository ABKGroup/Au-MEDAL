.subckt PM_SDFHx4_ASAP7_75t_R%CLK vss 14 6 12 3 5 1 4
c1 1 vss 0.00376504f $X=0.081 $Y=0.135
c2 3 vss 0.0901679f $X=0.081 $Y=0.0245
c3 4 vss 0.00166548f $X=0.081 $Y=0.072
c4 5 vss 0.00376695f $X=0.081 $Y=0.116
r1 4 15 3.83327 $w=1.5093e-08 $l=2.15e-08 $layer=M1 $thickness=3.6e-08 $X=0.081
+ $Y=0.072 $X2=0.081 $Y2=0.0935
r2 14 5 4.43061 $w=1.3e-08 $l=1.9e-08 $layer=M1 $thickness=3.6e-08 $X=0.081
+ $Y=0.1345 $X2=0.081 $Y2=0.116
r3 5 15 5.24677 $w=1.3e-08 $l=2.25e-08 $layer=M1 $thickness=3.6e-08 $X=0.081
+ $Y=0.116 $X2=0.081 $Y2=0.0935
r4 1 9 10.4265 $w=1.765e-08 $layer=LIG $thickness=5.2e-08 $X=0.081 $Y=0.135
+ $X2=0.081 $Y2=0.135
r5 14 1 19.3796 $a=3.24e-16 $layer=V0LIG $X=0.081 $Y=0.1345 $X2=0.081 $Y2=0.135
r6 12 11 14.6259 $w=2.1e-08 $l=4.3e-08 $layer=Gate_1 $thickness=5.6e-08
+ $X=0.081 $Y=0.2025 $X2=0.081 $Y2=0.1595
r7 10 11 2.7211 $w=2.1e-08 $l=8e-09 $layer=Gate_1 $thickness=5.6e-08 $X=0.081
+ $Y=0.1515 $X2=0.081 $Y2=0.1595
r8 9 10 5.79936 $w=2.03333e-08 $l=1.65e-08 $layer=Gate_1 $thickness=5.6e-08
+ $X=0.081 $Y=0.135 $X2=0.081 $Y2=0.1515
r9 8 9 5.79936 $w=2.03333e-08 $l=1.65e-08 $layer=Gate_1 $thickness=5.6e-08
+ $X=0.081 $Y=0.1185 $X2=0.081 $Y2=0.135
r10 7 8 2.7211 $w=2.1e-08 $l=8e-09 $layer=Gate_1 $thickness=5.6e-08 $X=0.081
+ $Y=0.1105 $X2=0.081 $Y2=0.1185
r11 6 7 14.6259 $w=2.1e-08 $l=4.3e-08 $layer=Gate_1 $thickness=5.6e-08 $X=0.081
+ $Y=0.0675 $X2=0.081 $Y2=0.1105
r12 6 3 14.6259 $w=2.1e-08 $l=4.3e-08 $layer=Gate_1 $thickness=5.6e-08 $X=0.081
+ $Y=0.0675 $X2=0.081 $Y2=0.0245
.ends

.subckt PM_SDFHx4_ASAP7_75t_R%7 vss 20 24 42 44 19 13 10 14 11 4 1 3 15 12 17 9
+ 18
c1 1 vss 0.00414081f $X=0.513 $Y=0.135
c2 3 vss 0.00890639f $X=0.324 $Y=0.0675
c3 4 vss 0.00828696f $X=0.324 $Y=0.2025
c4 9 vss 0.101471f $X=0.513 $Y=0.0245
c5 10 vss 0.039737f $X=0.3095 $Y=0.0675
c6 11 vss 0.0398139f $X=0.3095 $Y=0.2025
c7 12 vss 0.00600136f $X=0.351 $Y=0.036
c8 13 vss 0.00557434f $X=0.351 $Y=0.234
c9 14 vss 0.000366527f $X=0.351 $Y=0.072
c10 15 vss 0.00272379f $X=0.513 $Y=0.072
c11 16 vss 0.000619673f $X=0.351 $Y=0.054
c12 17 vss 0.00189825f $X=0.351 $Y=0.09
c13 18 vss 0.0122723f $X=0.486 $Y=0.072
c14 19 vss 0.00229682f $X=0.513 $Y=0.1125
r1 11 4 0.154321 $w=8.1e-08 $l=1.25e-08 $layer=P_src_drn $thickness=1e-09
+ $X=0.3095 $Y=0.2025 $X2=0.324 $Y2=0.2025
r2 44 11 0.0308642 $w=8.1e-08 $l=2.5e-09 $layer=P_src_drn $thickness=1e-09
+ $X=0.3066 $Y=0.2025 $X2=0.3095 $Y2=0.2025
r3 10 3 0.154321 $w=8.1e-08 $l=1.25e-08 $layer=N_src_drn $thickness=1e-09
+ $X=0.3095 $Y=0.0675 $X2=0.324 $Y2=0.0675
r4 42 10 0.0308642 $w=8.1e-08 $l=2.5e-09 $layer=N_src_drn $thickness=1e-09
+ $X=0.3066 $Y=0.0675 $X2=0.3095 $Y2=0.0675
r5 4 39 19.3796 $a=3.24e-16 $layer=V0LISD $X=0.324 $Y=0.2025 $X2=0.324 $Y2=0.234
r6 3 36 19.3796 $a=3.24e-16 $layer=V0LISD $X=0.324 $Y=0.0675 $X2=0.324 $Y2=0.036
r7 39 40 3.14806 $w=1.3e-08 $l=1.35e-08 $layer=M1 $thickness=3.6e-08 $X=0.324
+ $Y=0.234 $X2=0.3375 $Y2=0.234
r8 13 34 10.3626 $w=1.39091e-08 $l=4.95e-08 $layer=M1 $thickness=3.6e-08
+ $X=0.351 $Y=0.234 $X2=0.351 $Y2=0.1845
r9 13 40 1.96775 $w=1.63333e-08 $l=1.35e-08 $layer=M1 $thickness=3.6e-08
+ $X=0.351 $Y=0.234 $X2=0.3375 $Y2=0.234
r10 36 37 3.14806 $w=1.3e-08 $l=1.35e-08 $layer=M1 $thickness=3.6e-08 $X=0.324
+ $Y=0.036 $X2=0.3375 $Y2=0.036
r11 12 16 3.01711 $w=1.55e-08 $l=1.8e-08 $layer=M1 $thickness=3.6e-08 $X=0.351
+ $Y=0.036 $X2=0.351 $Y2=0.054
r12 12 37 1.96775 $w=1.63333e-08 $l=1.35e-08 $layer=M1 $thickness=3.6e-08
+ $X=0.351 $Y=0.036 $X2=0.3375 $Y2=0.036
r13 33 34 11.5429 $w=1.3e-08 $l=4.95e-08 $layer=M1 $thickness=3.6e-08 $X=0.351
+ $Y=0.135 $X2=0.351 $Y2=0.1845
r14 32 33 5.24677 $w=1.3e-08 $l=2.25e-08 $layer=M1 $thickness=3.6e-08 $X=0.351
+ $Y=0.1125 $X2=0.351 $Y2=0.135
r15 17 32 5.24677 $w=1.3e-08 $l=2.25e-08 $layer=M1 $thickness=3.6e-08 $X=0.351
+ $Y=0.09 $X2=0.351 $Y2=0.1125
r16 14 31 3.01711 $w=1.55e-08 $l=1.8e-08 $layer=M1 $thickness=3.6e-08 $X=0.351
+ $Y=0.072 $X2=0.369 $Y2=0.072
r17 14 16 3.01711 $w=1.55e-08 $l=1.8e-08 $layer=M1 $thickness=3.6e-08 $X=0.351
+ $Y=0.072 $X2=0.351 $Y2=0.054
r18 14 17 3.01711 $w=1.55e-08 $l=1.8e-08 $layer=M1 $thickness=3.6e-08 $X=0.351
+ $Y=0.072 $X2=0.351 $Y2=0.09
r19 30 31 6.7625 $w=1.3e-08 $l=2.9e-08 $layer=M1 $thickness=3.6e-08 $X=0.398
+ $Y=0.072 $X2=0.369 $Y2=0.072
r20 29 30 10.4935 $w=1.3e-08 $l=4.5e-08 $layer=M1 $thickness=3.6e-08 $X=0.443
+ $Y=0.072 $X2=0.398 $Y2=0.072
r21 18 29 10.0272 $w=1.3e-08 $l=4.3e-08 $layer=M1 $thickness=3.6e-08 $X=0.486
+ $Y=0.072 $X2=0.443 $Y2=0.072
r22 15 28 2.5483 $w=1.79e-08 $l=1.8e-08 $layer=M1 $thickness=3.6e-08 $X=0.513
+ $Y=0.072 $X2=0.513 $Y2=0.09
r23 15 18 4.64701 $w=1.46667e-08 $l=2.7e-08 $layer=M1 $thickness=3.6e-08
+ $X=0.513 $Y=0.072 $X2=0.486 $Y2=0.072
r24 19 26 5.24677 $w=1.3e-08 $l=2.25e-08 $layer=M1 $thickness=3.6e-08 $X=0.513
+ $Y=0.1125 $X2=0.513 $Y2=0.135
r25 19 28 5.24677 $w=1.3e-08 $l=2.25e-08 $layer=M1 $thickness=3.6e-08 $X=0.513
+ $Y=0.1125 $X2=0.513 $Y2=0.09
r26 1 22 10.4265 $w=1.765e-08 $layer=LIG $thickness=5.2e-08 $X=0.513 $Y=0.135
+ $X2=0.513 $Y2=0.135
r27 1 26 19.3796 $a=3.24e-16 $layer=V0LIG $X=0.513 $Y=0.135 $X2=0.513 $Y2=0.135
r28 24 23 16.4967 $w=2.1e-08 $l=4.85e-08 $layer=Gate_1 $thickness=5.6e-08
+ $X=0.513 $Y=0.2025 $X2=0.513 $Y2=0.154
r29 22 23 6.6497 $w=2.04211e-08 $l=1.9e-08 $layer=Gate_1 $thickness=5.6e-08
+ $X=0.513 $Y=0.135 $X2=0.513 $Y2=0.154
r30 21 22 6.6497 $w=2.04211e-08 $l=1.9e-08 $layer=Gate_1 $thickness=5.6e-08
+ $X=0.513 $Y=0.116 $X2=0.513 $Y2=0.135
r31 20 21 16.4967 $w=2.1e-08 $l=4.85e-08 $layer=Gate_1 $thickness=5.6e-08
+ $X=0.513 $Y=0.0675 $X2=0.513 $Y2=0.116
r32 20 9 14.6259 $w=2.1e-08 $l=4.3e-08 $layer=Gate_1 $thickness=5.6e-08
+ $X=0.513 $Y=0.0675 $X2=0.513 $Y2=0.0245
.ends

.subckt PM_SDFHx4_ASAP7_75t_R%SI vss 19 13 17 3 1 4 8 12 7
c1 1 vss 0.00449585f $X=0.621 $Y=0.135
c2 3 vss 0.0641852f $X=0.621 $Y=0.0245
c3 4 vss 0.00192791f $X=0.621 $Y=0.115
c4 5 vss 0.00378866f $X=0.648 $Y=0.072
c5 6 vss 0.00415689f $X=0.702 $Y=0.036
c6 7 vss 0.00139844f $X=0.702 $Y=0.0665
c7 8 vss 0.00107144f $X=0.621 $Y=0.125
c8 9 vss 0.00176142f $X=0.648 $Y=0.0935
c9 10 vss 0.0031997f $X=0.6595 $Y=0.072
c10 11 vss 0.0016937f $X=0.702 $Y=0.054
c11 12 vss 0.00676959f $X=0.7245 $Y=0.036
r1 6 11 2.5483 $w=1.79e-08 $l=1.8e-08 $layer=M1 $thickness=3.6e-08 $X=0.702
+ $Y=0.036 $X2=0.702 $Y2=0.054
r2 6 12 3.59766 $w=1.5e-08 $l=2.25e-08 $layer=M1 $thickness=3.6e-08 $X=0.702
+ $Y=0.036 $X2=0.7245 $Y2=0.036
r3 7 24 1.40651 $w=1.51875e-08 $l=1.45774e-08 $layer=M1 $thickness=3.6e-08
+ $X=0.702 $Y=0.0665 $X2=0.6885 $Y2=0.072
r4 7 11 2.45586 $w=1.44e-08 $l=1.25e-08 $layer=M1 $thickness=3.6e-08 $X=0.702
+ $Y=0.0665 $X2=0.702 $Y2=0.054
r5 23 24 3.61444 $w=1.3e-08 $l=1.55e-08 $layer=M1 $thickness=3.6e-08 $X=0.673
+ $Y=0.072 $X2=0.6885 $Y2=0.072
r6 10 23 3.14806 $w=1.3e-08 $l=1.35e-08 $layer=M1 $thickness=3.6e-08 $X=0.6595
+ $Y=0.072 $X2=0.673 $Y2=0.072
r7 5 9 3.36447 $w=1.71023e-08 $l=2.15e-08 $layer=M1 $thickness=3.6e-08 $X=0.648
+ $Y=0.072 $X2=0.648 $Y2=0.0935
r8 5 10 1.03257 $w=1.6913e-08 $l=1.15e-08 $layer=M1 $thickness=3.6e-08 $X=0.648
+ $Y=0.072 $X2=0.6595 $Y2=0.072
r9 9 22 3.83327 $w=1.5093e-08 $l=2.15e-08 $layer=M1 $thickness=3.6e-08 $X=0.648
+ $Y=0.0935 $X2=0.648 $Y2=0.115
r10 21 22 1.96775 $w=1.63333e-08 $l=1.35e-08 $layer=M1 $thickness=3.6e-08
+ $X=0.6345 $Y=0.115 $X2=0.648 $Y2=0.115
r11 4 8 1.15159 $w=1.75e-08 $l=1e-08 $layer=M1 $thickness=3.6e-08 $X=0.621
+ $Y=0.115 $X2=0.621 $Y2=0.125
r12 4 21 1.96775 $w=1.63333e-08 $l=1.35e-08 $layer=M1 $thickness=3.6e-08
+ $X=0.621 $Y=0.115 $X2=0.6345 $Y2=0.115
r13 19 8 2.3319 $w=1.3e-08 $l=1e-08 $layer=M1 $thickness=3.6e-08 $X=0.621
+ $Y=0.1345 $X2=0.621 $Y2=0.125
r14 1 15 10.4265 $w=1.765e-08 $layer=LIG $thickness=5.2e-08 $X=0.621 $Y=0.135
+ $X2=0.621 $Y2=0.135
r15 19 1 19.3796 $a=3.24e-16 $layer=V0LIG $X=0.621 $Y=0.1345 $X2=0.621 $Y2=0.135
r16 17 16 16.4967 $w=2.1e-08 $l=4.85e-08 $layer=Gate_1 $thickness=5.6e-08
+ $X=0.621 $Y=0.2025 $X2=0.621 $Y2=0.154
r17 15 16 6.6497 $w=2.04211e-08 $l=1.9e-08 $layer=Gate_1 $thickness=5.6e-08
+ $X=0.621 $Y=0.135 $X2=0.621 $Y2=0.154
r18 14 15 6.6497 $w=2.04211e-08 $l=1.9e-08 $layer=Gate_1 $thickness=5.6e-08
+ $X=0.621 $Y=0.116 $X2=0.621 $Y2=0.135
r19 13 14 16.4967 $w=2.1e-08 $l=4.85e-08 $layer=Gate_1 $thickness=5.6e-08
+ $X=0.621 $Y=0.0675 $X2=0.621 $Y2=0.116
r20 13 3 14.6259 $w=2.1e-08 $l=4.3e-08 $layer=Gate_1 $thickness=5.6e-08
+ $X=0.621 $Y=0.0675 $X2=0.621 $Y2=0.0245
.ends

.subckt PM_SDFHx4_ASAP7_75t_R%15 vss 15 34 35 37 12 3 13 11 2 1 10
c1 1 vss 0.0063272f $X=0.432 $Y=0.2025
c2 2 vss 0.00535152f $X=0.54 $Y=0.2025
c3 3 vss 0.00340038f $X=0.648 $Y=0.2025
c4 10 vss 0.0365208f $X=0.434 $Y=0.2025
c5 11 vss 0.00314133f $X=0.5255 $Y=0.2025
c6 12 vss 0.0020161f $X=0.6335 $Y=0.2025
c7 13 vss 0.0050007f $X=0.432 $Y=0.198
r1 12 3 0.154321 $w=8.1e-08 $l=1.25e-08 $layer=P_src_drn $thickness=1e-09
+ $X=0.6335 $Y=0.2025 $X2=0.648 $Y2=0.2025
r2 37 12 0.0308642 $w=8.1e-08 $l=2.5e-09 $layer=P_src_drn $thickness=1e-09
+ $X=0.6306 $Y=0.2025 $X2=0.6335 $Y2=0.2025
r3 35 33 0.0308642 $w=8.1e-08 $l=2.5e-09 $layer=P_src_drn $thickness=1e-09
+ $X=0.5573 $Y=0.2025 $X2=0.5545 $Y2=0.2025
r4 2 33 0.179012 $w=8.1e-08 $l=1.45e-08 $layer=P_src_drn $thickness=1e-09
+ $X=0.54 $Y=0.2025 $X2=0.5545 $Y2=0.2025
r5 11 2 0.179012 $w=8.1e-08 $l=1.45e-08 $layer=P_src_drn $thickness=1e-09
+ $X=0.5255 $Y=0.2025 $X2=0.54 $Y2=0.2025
r6 34 11 0.0308642 $w=8.1e-08 $l=2.5e-09 $layer=P_src_drn $thickness=1e-09
+ $X=0.5226 $Y=0.2025 $X2=0.5255 $Y2=0.2025
r7 3 30 19.3796 $a=3.24e-16 $layer=V0LISD $X=0.648 $Y=0.2025 $X2=0.648 $Y2=0.198
r8 2 22 19.3796 $a=3.24e-16 $layer=V0LISD $X=0.54 $Y=0.2025 $X2=0.54 $Y2=0.198
r9 29 30 3.14806 $w=1.3e-08 $l=1.35e-08 $layer=M1 $thickness=3.6e-08 $X=0.6345
+ $Y=0.198 $X2=0.648 $Y2=0.198
r10 28 29 3.14806 $w=1.3e-08 $l=1.35e-08 $layer=M1 $thickness=3.6e-08 $X=0.621
+ $Y=0.198 $X2=0.6345 $Y2=0.198
r11 27 28 3.61444 $w=1.3e-08 $l=1.55e-08 $layer=M1 $thickness=3.6e-08 $X=0.6055
+ $Y=0.198 $X2=0.621 $Y2=0.198
r12 26 27 3.73104 $w=1.3e-08 $l=1.6e-08 $layer=M1 $thickness=3.6e-08 $X=0.5895
+ $Y=0.198 $X2=0.6055 $Y2=0.198
r13 25 26 2.68168 $w=1.3e-08 $l=1.15e-08 $layer=M1 $thickness=3.6e-08 $X=0.578
+ $Y=0.198 $X2=0.5895 $Y2=0.198
r14 24 25 2.56509 $w=1.3e-08 $l=1.1e-08 $layer=M1 $thickness=3.6e-08 $X=0.567
+ $Y=0.198 $X2=0.578 $Y2=0.198
r15 23 24 3.14806 $w=1.3e-08 $l=1.35e-08 $layer=M1 $thickness=3.6e-08 $X=0.5535
+ $Y=0.198 $X2=0.567 $Y2=0.198
r16 22 23 3.14806 $w=1.3e-08 $l=1.35e-08 $layer=M1 $thickness=3.6e-08 $X=0.54
+ $Y=0.198 $X2=0.5535 $Y2=0.198
r17 21 22 3.14806 $w=1.3e-08 $l=1.35e-08 $layer=M1 $thickness=3.6e-08 $X=0.5265
+ $Y=0.198 $X2=0.54 $Y2=0.198
r18 20 21 3.14806 $w=1.3e-08 $l=1.35e-08 $layer=M1 $thickness=3.6e-08 $X=0.513
+ $Y=0.198 $X2=0.5265 $Y2=0.198
r19 19 20 6.29612 $w=1.3e-08 $l=2.7e-08 $layer=M1 $thickness=3.6e-08 $X=0.486
+ $Y=0.198 $X2=0.513 $Y2=0.198
r20 18 19 5.24677 $w=1.3e-08 $l=2.25e-08 $layer=M1 $thickness=3.6e-08 $X=0.4635
+ $Y=0.198 $X2=0.486 $Y2=0.198
r21 17 18 2.09871 $w=1.3e-08 $l=9e-09 $layer=M1 $thickness=3.6e-08 $X=0.4545
+ $Y=0.198 $X2=0.4635 $Y2=0.198
r22 16 17 2.09871 $w=1.3e-08 $l=9e-09 $layer=M1 $thickness=3.6e-08 $X=0.4455
+ $Y=0.198 $X2=0.4545 $Y2=0.198
r23 13 16 3.14806 $w=1.3e-08 $l=1.35e-08 $layer=M1 $thickness=3.6e-08 $X=0.432
+ $Y=0.198 $X2=0.4455 $Y2=0.198
r24 1 13 19.3796 $a=3.24e-16 $layer=V0LISD $X=0.432 $Y=0.2025 $X2=0.432
+ $Y2=0.198
r25 15 14 0.0308642 $w=8.1e-08 $l=2.5e-09 $layer=P_src_drn $thickness=1e-09
+ $X=0.4493 $Y=0.2025 $X2=0.4465 $Y2=0.2025
r26 10 14 0.154321 $w=8.1e-08 $l=1.25e-08 $layer=P_src_drn $thickness=1e-09
+ $X=0.434 $Y=0.2025 $X2=0.4465 $Y2=0.2025
r27 1 10 1e-05 $l=2e-09 $X=0.432 $Y=0.2025 $X2=0.434 $Y2=0.2025
.ends

.subckt PM_SDFHx4_ASAP7_75t_R%16 vss 12 13 24 9 7 1 8 2
c1 1 vss 0.00412296f $X=0.594 $Y=0.2025
c2 2 vss 0.00519393f $X=0.756 $Y=0.2025
c3 7 vss 0.00198795f $X=0.5795 $Y=0.2025
c4 8 vss 0.035911f $X=0.758 $Y=0.2025
c5 9 vss 0.0149904f $X=0.5825 $Y=0.234
r1 24 23 0.0308642 $w=8.1e-08 $l=2.5e-09 $layer=P_src_drn $thickness=1e-09
+ $X=0.7733 $Y=0.2025 $X2=0.7705 $Y2=0.2025
r2 8 23 0.154321 $w=8.1e-08 $l=1.25e-08 $layer=P_src_drn $thickness=1e-09
+ $X=0.758 $Y=0.2025 $X2=0.7705 $Y2=0.2025
r3 2 21 19.3796 $a=3.24e-16 $layer=V0LISD $X=0.756 $Y=0.2025 $X2=0.756 $Y2=0.234
r4 20 21 3.14806 $w=1.3e-08 $l=1.35e-08 $layer=M1 $thickness=3.6e-08 $X=0.7425
+ $Y=0.234 $X2=0.756 $Y2=0.234
r5 19 20 4.19742 $w=1.3e-08 $l=1.8e-08 $layer=M1 $thickness=3.6e-08 $X=0.7245
+ $Y=0.234 $X2=0.7425 $Y2=0.234
r6 18 19 4.19742 $w=1.3e-08 $l=1.8e-08 $layer=M1 $thickness=3.6e-08 $X=0.7065
+ $Y=0.234 $X2=0.7245 $Y2=0.234
r7 17 18 3.14806 $w=1.3e-08 $l=1.35e-08 $layer=M1 $thickness=3.6e-08 $X=0.693
+ $Y=0.234 $X2=0.7065 $Y2=0.234
r8 16 17 4.6638 $w=1.3e-08 $l=2e-08 $layer=M1 $thickness=3.6e-08 $X=0.673
+ $Y=0.234 $X2=0.693 $Y2=0.234
r9 15 16 9.44419 $w=1.3e-08 $l=4.05e-08 $layer=M1 $thickness=3.6e-08 $X=0.6325
+ $Y=0.234 $X2=0.673 $Y2=0.234
r10 14 15 8.97781 $w=1.3e-08 $l=3.85e-08 $layer=M1 $thickness=3.6e-08 $X=0.594
+ $Y=0.234 $X2=0.6325 $Y2=0.234
r11 9 14 2.68168 $w=1.3e-08 $l=1.15e-08 $layer=M1 $thickness=3.6e-08 $X=0.5825
+ $Y=0.234 $X2=0.594 $Y2=0.234
r12 1 14 19.3796 $a=3.24e-16 $layer=V0LISD $X=0.594 $Y=0.2025 $X2=0.594
+ $Y2=0.234
r13 13 11 0.0308642 $w=8.1e-08 $l=2.5e-09 $layer=P_src_drn $thickness=1e-09
+ $X=0.6113 $Y=0.2025 $X2=0.6085 $Y2=0.2025
r14 1 11 0.179012 $w=8.1e-08 $l=1.45e-08 $layer=P_src_drn $thickness=1e-09
+ $X=0.594 $Y=0.2025 $X2=0.6085 $Y2=0.2025
r15 7 1 0.179012 $w=8.1e-08 $l=1.45e-08 $layer=P_src_drn $thickness=1e-09
+ $X=0.5795 $Y=0.2025 $X2=0.594 $Y2=0.2025
r16 12 7 0.0308642 $w=8.1e-08 $l=2.5e-09 $layer=P_src_drn $thickness=1e-09
+ $X=0.5766 $Y=0.2025 $X2=0.5795 $Y2=0.2025
r17 2 8 1e-05 $l=2e-09 $X=0.756 $Y=0.2025 $X2=0.758 $Y2=0.2025
.ends

.subckt PM_SDFHx4_ASAP7_75t_R%11 vss 23 27 45 46 54 56 13 22 15 14 4 11 19 3 21
+ 18 12 10 1
c1 1 vss 0.00329909f $X=0.945 $Y=0.135
c2 3 vss 0.0109643f $X=0.729 $Y=0.0675
c3 4 vss 0.00340922f $X=0.81 $Y=0.2025
c4 10 vss 0.0840301f $X=0.945 $Y=0.0245
c5 11 vss 0.0372642f $X=0.6875 $Y=0.0675
c6 12 vss 0.0363357f $X=0.758 $Y=0.0675
c7 13 vss 0.00287562f $X=0.7955 $Y=0.2025
c8 14 vss 0.000523918f $X=0.747 $Y=0.198
c9 15 vss 0.000240034f $X=0.81 $Y=0.198
c10 16 vss 0.00246509f $X=0.81 $Y=0.234
c11 17 vss 0.00303767f $X=0.945 $Y=0.234
c12 18 vss 0.00075903f $X=0.747 $Y=0.178
c13 19 vss 0.000871681f $X=0.7965 $Y=0.198
c14 20 vss 0.000249033f $X=0.81 $Y=0.216
c15 21 vss 0.0109725f $X=0.918 $Y=0.234
c16 22 vss 0.00260055f $X=0.945 $Y=0.116
r1 56 55 0.0308642 $w=8.1e-08 $l=2.5e-09 $layer=N_src_drn $thickness=1e-09
+ $X=0.7733 $Y=0.0675 $X2=0.7705 $Y2=0.0675
r2 12 55 0.154321 $w=8.1e-08 $l=1.25e-08 $layer=N_src_drn $thickness=1e-09
+ $X=0.758 $Y=0.0675 $X2=0.7705 $Y2=0.0675
r3 11 3 0.154321 $w=8.1e-08 $l=1.25e-08 $layer=N_src_drn $thickness=1e-09
+ $X=0.6875 $Y=0.0675 $X2=0.729 $Y2=0.0675
r4 54 11 0.0308642 $w=8.1e-08 $l=2.5e-09 $layer=N_src_drn $thickness=1e-09
+ $X=0.6846 $Y=0.0675 $X2=0.6875 $Y2=0.0675
r5 3 50 19.3796 $a=3.24e-16 $layer=V0LISD $X=0.729 $Y=0.0675 $X2=0.747 $Y2=0.09
r6 50 51 2.91487 $w=1.3e-08 $l=1.25e-08 $layer=M1 $thickness=3.6e-08 $X=0.747
+ $Y=0.09 $X2=0.747 $Y2=0.1025
r7 49 51 2.56509 $w=1.3e-08 $l=1.1e-08 $layer=M1 $thickness=3.6e-08 $X=0.747
+ $Y=0.1135 $X2=0.747 $Y2=0.1025
r8 48 49 6.7625 $w=1.3e-08 $l=2.9e-08 $layer=M1 $thickness=3.6e-08 $X=0.747
+ $Y=0.1425 $X2=0.747 $Y2=0.1135
r9 47 48 5.36336 $w=1.3e-08 $l=2.3e-08 $layer=M1 $thickness=3.6e-08 $X=0.747
+ $Y=0.1655 $X2=0.747 $Y2=0.1425
r10 18 47 2.91487 $w=1.3e-08 $l=1.25e-08 $layer=M1 $thickness=3.6e-08 $X=0.747
+ $Y=0.178 $X2=0.747 $Y2=0.1655
r11 14 42 1.73214 $w=1.61034e-08 $l=1.45e-08 $layer=M1 $thickness=3.6e-08
+ $X=0.747 $Y=0.198 $X2=0.7615 $Y2=0.198
r12 14 18 3.01468 $w=1.741e-08 $l=2e-08 $layer=M1 $thickness=3.6e-08 $X=0.747
+ $Y=0.198 $X2=0.747 $Y2=0.178
r13 46 44 0.0308642 $w=8.1e-08 $l=2.5e-09 $layer=P_src_drn $thickness=1e-09
+ $X=0.8273 $Y=0.2025 $X2=0.8245 $Y2=0.2025
r14 4 44 0.179012 $w=8.1e-08 $l=1.45e-08 $layer=P_src_drn $thickness=1e-09
+ $X=0.81 $Y=0.2025 $X2=0.8245 $Y2=0.2025
r15 13 4 0.179012 $w=8.1e-08 $l=1.45e-08 $layer=P_src_drn $thickness=1e-09
+ $X=0.7955 $Y=0.2025 $X2=0.81 $Y2=0.2025
r16 45 13 0.0308642 $w=8.1e-08 $l=2.5e-09 $layer=P_src_drn $thickness=1e-09
+ $X=0.7926 $Y=0.2025 $X2=0.7955 $Y2=0.2025
r17 41 42 1.63233 $w=1.3e-08 $l=7e-09 $layer=M1 $thickness=3.6e-08 $X=0.7685
+ $Y=0.198 $X2=0.7615 $Y2=0.198
r18 40 41 0.816164 $w=1.3e-08 $l=3.5e-09 $layer=M1 $thickness=3.6e-08 $X=0.772
+ $Y=0.198 $X2=0.7685 $Y2=0.198
r19 39 40 2.56509 $w=1.3e-08 $l=1.1e-08 $layer=M1 $thickness=3.6e-08 $X=0.783
+ $Y=0.198 $X2=0.772 $Y2=0.198
r20 19 39 3.14806 $w=1.3e-08 $l=1.35e-08 $layer=M1 $thickness=3.6e-08 $X=0.7965
+ $Y=0.198 $X2=0.783 $Y2=0.198
r21 4 20 19.3796 $a=3.24e-16 $layer=V0LISD $X=0.81 $Y=0.2025 $X2=0.81 $Y2=0.216
r22 15 20 2.5483 $w=1.79e-08 $l=1.8e-08 $layer=M1 $thickness=3.6e-08 $X=0.81
+ $Y=0.198 $X2=0.81 $Y2=0.216
r23 15 19 1.49895 $w=1.63333e-08 $l=1.35e-08 $layer=M1 $thickness=3.6e-08
+ $X=0.81 $Y=0.198 $X2=0.7965 $Y2=0.198
r24 16 38 1.49895 $w=1.63333e-08 $l=1.35e-08 $layer=M1 $thickness=3.6e-08
+ $X=0.81 $Y=0.234 $X2=0.8235 $Y2=0.234
r25 16 20 2.5483 $w=1.79e-08 $l=1.8e-08 $layer=M1 $thickness=3.6e-08 $X=0.81
+ $Y=0.234 $X2=0.81 $Y2=0.216
r26 37 38 3.14806 $w=1.3e-08 $l=1.35e-08 $layer=M1 $thickness=3.6e-08 $X=0.837
+ $Y=0.234 $X2=0.8235 $Y2=0.234
r27 36 37 6.29612 $w=1.3e-08 $l=2.7e-08 $layer=M1 $thickness=3.6e-08 $X=0.864
+ $Y=0.234 $X2=0.837 $Y2=0.234
r28 35 36 6.29612 $w=1.3e-08 $l=2.7e-08 $layer=M1 $thickness=3.6e-08 $X=0.891
+ $Y=0.234 $X2=0.864 $Y2=0.234
r29 21 35 6.29612 $w=1.3e-08 $l=2.7e-08 $layer=M1 $thickness=3.6e-08 $X=0.918
+ $Y=0.234 $X2=0.891 $Y2=0.234
r30 17 34 3.36447 $w=1.71023e-08 $l=2.15e-08 $layer=M1 $thickness=3.6e-08
+ $X=0.945 $Y=0.234 $X2=0.945 $Y2=0.2125
r31 17 21 4.64701 $w=1.46667e-08 $l=2.7e-08 $layer=M1 $thickness=3.6e-08
+ $X=0.945 $Y=0.234 $X2=0.918 $Y2=0.234
r32 33 34 4.19742 $w=1.3e-08 $l=1.8e-08 $layer=M1 $thickness=3.6e-08 $X=0.945
+ $Y=0.1945 $X2=0.945 $Y2=0.2125
r33 32 33 3.84763 $w=1.3e-08 $l=1.65e-08 $layer=M1 $thickness=3.6e-08 $X=0.945
+ $Y=0.178 $X2=0.945 $Y2=0.1945
r34 31 32 2.91487 $w=1.3e-08 $l=1.25e-08 $layer=M1 $thickness=3.6e-08 $X=0.945
+ $Y=0.1655 $X2=0.945 $Y2=0.178
r35 30 31 2.68168 $w=1.3e-08 $l=1.15e-08 $layer=M1 $thickness=3.6e-08 $X=0.945
+ $Y=0.154 $X2=0.945 $Y2=0.1655
r36 29 30 4.43061 $w=1.3e-08 $l=1.9e-08 $layer=M1 $thickness=3.6e-08 $X=0.945
+ $Y=0.135 $X2=0.945 $Y2=0.154
r37 22 29 4.43061 $w=1.3e-08 $l=1.9e-08 $layer=M1 $thickness=3.6e-08 $X=0.945
+ $Y=0.116 $X2=0.945 $Y2=0.135
r38 1 25 10.4265 $w=1.765e-08 $layer=LIG $thickness=5.2e-08 $X=0.945 $Y=0.135
+ $X2=0.945 $Y2=0.135
r39 1 29 19.3796 $a=3.24e-16 $layer=V0LIG $X=0.945 $Y=0.135 $X2=0.945 $Y2=0.135
r40 27 26 16.4967 $w=2.1e-08 $l=4.85e-08 $layer=Gate_1 $thickness=5.6e-08
+ $X=0.945 $Y=0.2025 $X2=0.945 $Y2=0.154
r41 25 26 6.6497 $w=2.04211e-08 $l=1.9e-08 $layer=Gate_1 $thickness=5.6e-08
+ $X=0.945 $Y=0.135 $X2=0.945 $Y2=0.154
r42 24 25 6.6497 $w=2.04211e-08 $l=1.9e-08 $layer=Gate_1 $thickness=5.6e-08
+ $X=0.945 $Y=0.116 $X2=0.945 $Y2=0.135
r43 23 24 16.4967 $w=2.1e-08 $l=4.85e-08 $layer=Gate_1 $thickness=5.6e-08
+ $X=0.945 $Y=0.0675 $X2=0.945 $Y2=0.116
r44 23 10 14.6259 $w=2.1e-08 $l=4.3e-08 $layer=Gate_1 $thickness=5.6e-08
+ $X=0.945 $Y=0.0675 $X2=0.945 $Y2=0.0245
r45 3 12 1e-05 $l=2.9e-08 $X=0.729 $Y=0.0675 $X2=0.758 $Y2=0.0675
.ends

.subckt PM_SDFHx4_ASAP7_75t_R%22 vss 2 3 1
c1 1 vss 0.000831776f $X=1.188 $Y=0.0675
r1 2 1 0.209877 $w=8.1e-08 $l=1.7e-08 $layer=N_src_drn $thickness=1e-09
+ $X=1.1706 $Y=0.0675 $X2=1.188 $Y2=0.0675
r2 3 1 0.209877 $w=8.1e-08 $l=1.7e-08 $layer=N_src_drn $thickness=1e-09
+ $X=1.2053 $Y=0.0675 $X2=1.188 $Y2=0.0675
.ends

.subckt PM_SDFHx4_ASAP7_75t_R%18 vss 7 9 4 5 1
c1 1 vss 0.00880431f $X=0.837 $Y=0.0675
c2 4 vss 0.00176461f $X=0.7955 $Y=0.0675
c3 5 vss 0.00290566f $X=0.866 $Y=0.0675
r1 9 8 0.0308642 $w=8.1e-08 $l=2.5e-09 $layer=N_src_drn $thickness=1e-09
+ $X=0.8813 $Y=0.0675 $X2=0.8785 $Y2=0.0675
r2 5 8 0.154321 $w=8.1e-08 $l=1.25e-08 $layer=N_src_drn $thickness=1e-09
+ $X=0.866 $Y=0.0675 $X2=0.8785 $Y2=0.0675
r3 4 1 0.154321 $w=8.1e-08 $l=1.25e-08 $layer=N_src_drn $thickness=1e-09
+ $X=0.7955 $Y=0.0675 $X2=0.837 $Y2=0.0675
r4 7 4 0.0308642 $w=8.1e-08 $l=2.5e-09 $layer=N_src_drn $thickness=1e-09
+ $X=0.7926 $Y=0.0675 $X2=0.7955 $Y2=0.0675
r5 1 5 1e-05 $l=2.9e-08 $X=0.837 $Y=0.0675 $X2=0.866 $Y2=0.0675
.ends

.subckt PM_SDFHx4_ASAP7_75t_R%19 vss 7 9 4 5 1
c1 1 vss 0.00743573f $X=1.161 $Y=0.2025
c2 4 vss 0.00175451f $X=1.1195 $Y=0.2025
c3 5 vss 0.00289525f $X=1.19 $Y=0.2025
r1 9 8 0.0308642 $w=8.1e-08 $l=2.5e-09 $layer=P_src_drn $thickness=1e-09
+ $X=1.2053 $Y=0.2025 $X2=1.2025 $Y2=0.2025
r2 5 8 0.154321 $w=8.1e-08 $l=1.25e-08 $layer=P_src_drn $thickness=1e-09
+ $X=1.19 $Y=0.2025 $X2=1.2025 $Y2=0.2025
r3 4 1 0.154321 $w=8.1e-08 $l=1.25e-08 $layer=P_src_drn $thickness=1e-09
+ $X=1.1195 $Y=0.2025 $X2=1.161 $Y2=0.2025
r4 7 4 0.0308642 $w=8.1e-08 $l=2.5e-09 $layer=P_src_drn $thickness=1e-09
+ $X=1.1166 $Y=0.2025 $X2=1.1195 $Y2=0.2025
r5 1 5 1e-05 $l=2.9e-08 $X=1.161 $Y=0.2025 $X2=1.19 $Y2=0.2025
.ends

.subckt PM_SDFHx4_ASAP7_75t_R%12 vss 18 22 33 37 9 1 15 10 17 4 3 14 13 11 16 12
c1 1 vss 0.00375524f $X=1.215 $Y=0.135
c2 3 vss 0.01171f $X=1.3055 $Y=0.0675
c3 4 vss 0.00689012f $X=1.296 $Y=0.2025
c4 9 vss 0.0826222f $X=1.215 $Y=0.0245
c5 10 vss 0.0395013f $X=1.2815 $Y=0.0675
c6 11 vss 0.040663f $X=1.2815 $Y=0.2025
c7 12 vss 0.00059507f $X=1.215 $Y=0.191
c8 13 vss 0.000964075f $X=1.323 $Y=0.09
c9 14 vss 0.000469626f $X=1.323 $Y=0.191
c10 15 vss 0.00165659f $X=1.215 $Y=0.135
c11 16 vss 0.00224676f $X=1.233 $Y=0.191
c12 17 vss 0.00162896f $X=1.323 $Y=0.163
r1 10 3 0.154321 $w=8.1e-08 $l=1.25e-08 $layer=N_src_drn $thickness=1e-09
+ $X=1.2815 $Y=0.0675 $X2=1.3055 $Y2=0.0675
r2 37 10 0.0308642 $w=8.1e-08 $l=2.5e-09 $layer=N_src_drn $thickness=1e-09
+ $X=1.2786 $Y=0.0675 $X2=1.2815 $Y2=0.0675
r3 3 34 19.3796 $a=3.24e-16 $layer=V0LISD $X=1.3055 $Y=0.0675 $X2=1.296 $Y2=0.09
r4 34 35 3.14806 $w=1.3e-08 $l=1.35e-08 $layer=M1 $thickness=3.6e-08 $X=1.296
+ $Y=0.09 $X2=1.3095 $Y2=0.09
r5 13 31 4.06646 $w=1.5e-08 $l=2.25e-08 $layer=M1 $thickness=3.6e-08 $X=1.323
+ $Y=0.09 $X2=1.323 $Y2=0.1125
r6 13 35 1.96775 $w=1.63333e-08 $l=1.35e-08 $layer=M1 $thickness=3.6e-08
+ $X=1.323 $Y=0.09 $X2=1.3095 $Y2=0.09
r7 11 4 0.154321 $w=8.1e-08 $l=1.25e-08 $layer=P_src_drn $thickness=1e-09
+ $X=1.2815 $Y=0.2025 $X2=1.296 $Y2=0.2025
r8 33 11 0.0308642 $w=8.1e-08 $l=2.5e-09 $layer=P_src_drn $thickness=1e-09
+ $X=1.2786 $Y=0.2025 $X2=1.2815 $Y2=0.2025
r9 30 31 5.24677 $w=1.3e-08 $l=2.25e-08 $layer=M1 $thickness=3.6e-08 $X=1.323
+ $Y=0.135 $X2=1.323 $Y2=0.1125
r10 17 30 6.52931 $w=1.3e-08 $l=2.8e-08 $layer=M1 $thickness=3.6e-08 $X=1.323
+ $Y=0.163 $X2=1.323 $Y2=0.135
r11 4 28 19.3796 $a=3.24e-16 $layer=V0LISD $X=1.296 $Y=0.2025 $X2=1.296
+ $Y2=0.191
r12 14 29 1.49895 $w=1.63333e-08 $l=1.35e-08 $layer=M1 $thickness=3.6e-08
+ $X=1.323 $Y=0.191 $X2=1.3095 $Y2=0.191
r13 14 17 4.8802 $w=1.615e-08 $l=2.8e-08 $layer=M1 $thickness=3.6e-08 $X=1.323
+ $Y=0.191 $X2=1.323 $Y2=0.163
r14 28 29 3.14806 $w=1.3e-08 $l=1.35e-08 $layer=M1 $thickness=3.6e-08 $X=1.296
+ $Y=0.191 $X2=1.3095 $Y2=0.191
r15 27 28 2.56509 $w=1.3e-08 $l=1.1e-08 $layer=M1 $thickness=3.6e-08 $X=1.285
+ $Y=0.191 $X2=1.296 $Y2=0.191
r16 26 27 5.24677 $w=1.3e-08 $l=2.25e-08 $layer=M1 $thickness=3.6e-08 $X=1.2625
+ $Y=0.191 $X2=1.285 $Y2=0.191
r17 16 26 6.8791 $w=1.3e-08 $l=2.95e-08 $layer=M1 $thickness=3.6e-08 $X=1.233
+ $Y=0.191 $X2=1.2625 $Y2=0.191
r18 12 25 4.8802 $w=1.615e-08 $l=2.8e-08 $layer=M1 $thickness=3.6e-08 $X=1.215
+ $Y=0.191 $X2=1.215 $Y2=0.163
r19 12 16 2.5483 $w=1.55e-08 $l=1.8e-08 $layer=M1 $thickness=3.6e-08 $X=1.215
+ $Y=0.191 $X2=1.233 $Y2=0.191
r20 15 25 6.52931 $w=1.3e-08 $l=2.8e-08 $layer=M1 $thickness=3.6e-08 $X=1.215
+ $Y=0.135 $X2=1.215 $Y2=0.163
r21 1 20 10.4265 $w=1.765e-08 $layer=LIG $thickness=5.2e-08 $X=1.215 $Y=0.135
+ $X2=1.215 $Y2=0.135
r22 1 15 19.3796 $a=3.24e-16 $layer=V0LIG $X=1.215 $Y=0.135 $X2=1.215 $Y2=0.135
r23 22 21 16.4967 $w=2.1e-08 $l=4.85e-08 $layer=Gate_1 $thickness=5.6e-08
+ $X=1.215 $Y=0.2025 $X2=1.215 $Y2=0.154
r24 20 21 6.6497 $w=2.04211e-08 $l=1.9e-08 $layer=Gate_1 $thickness=5.6e-08
+ $X=1.215 $Y=0.135 $X2=1.215 $Y2=0.154
r25 19 20 6.6497 $w=2.04211e-08 $l=1.9e-08 $layer=Gate_1 $thickness=5.6e-08
+ $X=1.215 $Y=0.116 $X2=1.215 $Y2=0.135
r26 18 19 16.4967 $w=2.1e-08 $l=4.85e-08 $layer=Gate_1 $thickness=5.6e-08
+ $X=1.215 $Y=0.0675 $X2=1.215 $Y2=0.116
r27 18 9 14.6259 $w=2.1e-08 $l=4.3e-08 $layer=Gate_1 $thickness=5.6e-08
+ $X=1.215 $Y=0.0675 $X2=1.215 $Y2=0.0245
.ends

.subckt PM_SDFHx4_ASAP7_75t_R%9 vss 25 29 55 58 65 67 18 5 6 17 21 15 14 1 20 2
+ 13 19 12 11 16
c1 1 vss 0.00045581f $X=0.783 $Y=0.135
c2 2 vss 0.000138528f $X=1.107 $Y=0.135
c3 5 vss 0.00842426f $X=0.162 $Y=0.0675
c4 6 vss 0.00881413f $X=0.162 $Y=0.2025
c5 11 vss 0.00844669f $X=0.783 $Y=0.135
c6 12 vss 0.00712555f $X=1.107 $Y=0.0245
c7 13 vss 0.0442005f $X=0.1475 $Y=0.0675
c8 14 vss 0.0445515f $X=0.1475 $Y=0.2025
c9 15 vss 0.00609926f $X=0.189 $Y=0.234
c10 16 vss 0.00284419f $X=0.189 $Y=0.036
c11 17 vss 0.00591838f $X=0.1505 $Y=0.036
c12 18 vss 0.00450291f $X=0.189 $Y=0.0935
c13 19 vss 0.00137875f $X=0.783 $Y=0.089
c14 20 vss 0.00200216f $X=1.107 $Y=0.107
c15 21 vss 0.0334609f $X=0.6775 $Y=0.117
r1 13 5 0.154321 $w=8.1e-08 $l=1.25e-08 $layer=N_src_drn $thickness=1e-09
+ $X=0.1475 $Y=0.0675 $X2=0.162 $Y2=0.0675
r2 67 13 0.0308642 $w=8.1e-08 $l=2.5e-09 $layer=N_src_drn $thickness=1e-09
+ $X=0.1446 $Y=0.0675 $X2=0.1475 $Y2=0.0675
r3 14 6 0.154321 $w=8.1e-08 $l=1.25e-08 $layer=P_src_drn $thickness=1e-09
+ $X=0.1475 $Y=0.2025 $X2=0.162 $Y2=0.2025
r4 65 14 0.0308642 $w=8.1e-08 $l=2.5e-09 $layer=P_src_drn $thickness=1e-09
+ $X=0.1446 $Y=0.2025 $X2=0.1475 $Y2=0.2025
r5 5 60 19.3796 $a=3.24e-16 $layer=V0LISD $X=0.162 $Y=0.0675 $X2=0.162 $Y2=0.036
r6 6 52 19.3796 $a=3.24e-16 $layer=V0LISD $X=0.162 $Y=0.2025 $X2=0.162 $Y2=0.234
r7 60 61 3.14806 $w=1.3e-08 $l=1.35e-08 $layer=M1 $thickness=3.6e-08 $X=0.162
+ $Y=0.036 $X2=0.1755 $Y2=0.036
r8 17 60 2.68168 $w=1.3e-08 $l=1.15e-08 $layer=M1 $thickness=3.6e-08 $X=0.1505
+ $Y=0.036 $X2=0.162 $Y2=0.036
r9 58 57 16.4967 $w=2.1e-08 $l=4.85e-08 $layer=Gate_1 $thickness=5.6e-08
+ $X=0.783 $Y=0.2025 $X2=0.783 $Y2=0.154
r10 55 56 16.4967 $w=2.1e-08 $l=4.85e-08 $layer=Gate_1 $thickness=5.6e-08
+ $X=0.783 $Y=0.0675 $X2=0.783 $Y2=0.116
r11 11 56 6.6497 $w=2.04211e-08 $l=1.9e-08 $layer=Gate_1 $thickness=5.6e-08
+ $X=0.783 $Y=0.135 $X2=0.783 $Y2=0.116
r12 11 57 6.6497 $w=2.04211e-08 $l=1.9e-08 $layer=Gate_1 $thickness=5.6e-08
+ $X=0.783 $Y=0.135 $X2=0.783 $Y2=0.154
r13 52 53 3.14806 $w=1.3e-08 $l=1.35e-08 $layer=M1 $thickness=3.6e-08 $X=0.162
+ $Y=0.234 $X2=0.1755 $Y2=0.234
r14 15 50 3.83327 $w=1.5093e-08 $l=2.15e-08 $layer=M1 $thickness=3.6e-08
+ $X=0.189 $Y=0.234 $X2=0.189 $Y2=0.2125
r15 15 53 1.96775 $w=1.63333e-08 $l=1.35e-08 $layer=M1 $thickness=3.6e-08
+ $X=0.189 $Y=0.234 $X2=0.1755 $Y2=0.234
r16 16 46 2.5483 $w=1.79e-08 $l=1.8e-08 $layer=M1 $thickness=3.6e-08 $X=0.189
+ $Y=0.036 $X2=0.189 $Y2=0.054
r17 16 61 1.49895 $w=1.63333e-08 $l=1.35e-08 $layer=M1 $thickness=3.6e-08
+ $X=0.189 $Y=0.036 $X2=0.1755 $Y2=0.036
r18 1 43 19.3796 $a=3.24e-16 $layer=V0LIG $X=0.783 $Y=0.135 $X2=0.783 $Y2=0.126
r19 1 11 10.4265 $w=1.765e-08 $layer=LIG $thickness=5.2e-08 $X=0.783 $Y=0.135
+ $X2=0.783 $Y2=0.135
r20 49 50 11.5429 $w=1.3e-08 $l=4.95e-08 $layer=M1 $thickness=3.6e-08 $X=0.189
+ $Y=0.163 $X2=0.189 $Y2=0.2125
r21 48 49 10.7267 $w=1.3e-08 $l=4.6e-08 $layer=M1 $thickness=3.6e-08 $X=0.189
+ $Y=0.117 $X2=0.189 $Y2=0.163
r22 47 48 2.3319 $w=1.3e-08 $l=1e-08 $layer=M1 $thickness=3.6e-08 $X=0.189
+ $Y=0.107 $X2=0.189 $Y2=0.117
r23 45 46 4.19742 $w=1.3e-08 $l=1.8e-08 $layer=M1 $thickness=3.6e-08 $X=0.189
+ $Y=0.072 $X2=0.189 $Y2=0.054
r24 18 45 5.01358 $w=1.3e-08 $l=2.15e-08 $layer=M1 $thickness=3.6e-08 $X=0.189
+ $Y=0.0935 $X2=0.189 $Y2=0.072
r25 18 47 3.14806 $w=1.3e-08 $l=1.35e-08 $layer=M1 $thickness=3.6e-08 $X=0.189
+ $Y=0.0935 $X2=0.189 $Y2=0.107
r26 19 43 8.62802 $w=1.3e-08 $l=3.7e-08 $layer=M1 $thickness=3.6e-08 $X=0.783
+ $Y=0.089 $X2=0.783 $Y2=0.126
r27 41 42 5.71315 $w=1.3e-08 $l=2.45e-08 $layer=M2 $thickness=3.6e-08 $X=0.189
+ $Y=0.117 $X2=0.2135 $Y2=0.117
r28 41 48 19.5347 $a=3.24e-16 $layer=V1 $X=0.189 $Y=0.117 $X2=0.189 $Y2=0.117
r29 39 42 44.6558 $w=1.3e-08 $l=1.915e-07 $layer=M2 $thickness=3.6e-08 $X=0.405
+ $Y=0.117 $X2=0.2135 $Y2=0.117
r30 36 37 37.7767 $w=1.3e-08 $l=1.62e-07 $layer=M2 $thickness=3.6e-08 $X=0.945
+ $Y=0.117 $X2=1.107 $Y2=0.117
r31 35 36 37.7767 $w=1.3e-08 $l=1.62e-07 $layer=M2 $thickness=3.6e-08 $X=0.783
+ $Y=0.117 $X2=0.945 $Y2=0.117
r32 35 43 19.5347 $a=3.24e-16 $layer=V1 $X=0.783 $Y=0.117 $X2=0.783 $Y2=0.126
r33 21 35 24.6015 $w=1.3e-08 $l=1.055e-07 $layer=M2 $thickness=3.6e-08
+ $X=0.6775 $Y=0.117 $X2=0.783 $Y2=0.117
r34 21 39 63.5442 $w=1.3e-08 $l=2.725e-07 $layer=M2 $thickness=3.6e-08
+ $X=0.6775 $Y=0.117 $X2=0.405 $Y2=0.117
r35 31 37 19.5347 $a=3.24e-16 $layer=V1 $X=1.107 $Y=0.126 $X2=1.107 $Y2=0.117
r36 20 31 4.43061 $w=1.3e-08 $l=1.9e-08 $layer=M1 $thickness=3.6e-08 $X=1.107
+ $Y=0.107 $X2=1.107 $Y2=0.126
r37 2 27 10.4265 $w=1.765e-08 $layer=LIG $thickness=5.2e-08 $X=1.107 $Y=0.135
+ $X2=1.107 $Y2=0.135
r38 2 31 19.3796 $a=3.24e-16 $layer=V0LIG $X=1.107 $Y=0.135 $X2=1.107 $Y2=0.126
r39 29 28 16.4967 $w=2.1e-08 $l=4.85e-08 $layer=Gate_1 $thickness=5.6e-08
+ $X=1.107 $Y=0.2025 $X2=1.107 $Y2=0.154
r40 27 28 6.6497 $w=2.04211e-08 $l=1.9e-08 $layer=Gate_1 $thickness=5.6e-08
+ $X=1.107 $Y=0.135 $X2=1.107 $Y2=0.154
r41 26 27 6.6497 $w=2.04211e-08 $l=1.9e-08 $layer=Gate_1 $thickness=5.6e-08
+ $X=1.107 $Y=0.116 $X2=1.107 $Y2=0.135
r42 25 26 16.4967 $w=2.1e-08 $l=4.85e-08 $layer=Gate_1 $thickness=5.6e-08
+ $X=1.107 $Y=0.0675 $X2=1.107 $Y2=0.116
r43 25 12 14.6259 $w=2.1e-08 $l=4.3e-08 $layer=Gate_1 $thickness=5.6e-08
+ $X=1.107 $Y=0.0675 $X2=1.107 $Y2=0.0245
.ends

.subckt PM_SDFHx4_ASAP7_75t_R%4 vss 43 86 91 95 99 103 114 116 12 31 11 25 1 28
+ 23 30 27 36 17 29 22 32 33 2 18 35 5 34 4 3 20 19 21
c1 1 vss 0.00379469f $X=0.135 $Y=0.135
c2 2 vss 0.00351079f $X=0.6745 $Y=0.135
c3 3 vss 0.00046098f $X=0.837 $Y=0.135
c4 4 vss 0.000268938f $X=1.053 $Y=0.135
c5 5 vss 0.000459699f $X=1.161 $Y=0.135
c6 11 vss 0.00886955f $X=0.054 $Y=0.0675
c7 12 vss 0.00910781f $X=0.054 $Y=0.2025
c8 17 vss 0.0874807f $X=0.135 $Y=0.135
c9 18 vss 0.0573819f $X=0.675 $Y=0.135
c10 19 vss 0.0079468f $X=0.837 $Y=0.135
c11 20 vss 0.0172489f $X=1.053 $Y=0.135
c12 21 vss 0.00767078f $X=1.161 $Y=0.0245
c13 22 vss 0.0429279f $X=0.056 $Y=0.0675
c14 23 vss 0.0429497f $X=0.056 $Y=0.2025
c15 24 vss 0.00379747f $X=0.018 $Y=0.036
c16 25 vss 0.00234361f $X=0.0165 $Y=0.153
c17 26 vss 0.00385292f $X=0.018 $Y=0.234
c18 27 vss 0.00709576f $X=0.018 $Y=0.1125
c19 28 vss 0.0045872f $X=0.018 $Y=0.181
c20 29 vss 0.00689243f $X=0.036 $Y=0.036
c21 30 vss 0.0047675f $X=0.036 $Y=0.234
c22 31 vss 0.00237381f $X=0.135 $Y=0.116
c23 32 vss 0.000541982f $X=0.693 $Y=0.125
c24 33 vss 0.00174663f $X=0.837 $Y=0.098
c25 34 vss 0.00203233f $X=1.053 $Y=0.116
c26 35 vss 0.00182501f $X=1.161 $Y=0.116
c27 36 vss 0.0418333f $X=1.1365 $Y=0.153
r1 116 115 0.0308642 $w=8.1e-08 $l=2.5e-09 $layer=P_src_drn $thickness=1e-09
+ $X=0.0713 $Y=0.2025 $X2=0.0685 $Y2=0.2025
r2 23 115 0.154321 $w=8.1e-08 $l=1.25e-08 $layer=P_src_drn $thickness=1e-09
+ $X=0.056 $Y=0.2025 $X2=0.0685 $Y2=0.2025
r3 114 113 0.0308642 $w=8.1e-08 $l=2.5e-09 $layer=N_src_drn $thickness=1e-09
+ $X=0.0713 $Y=0.0675 $X2=0.0685 $Y2=0.0675
r4 22 113 0.154321 $w=8.1e-08 $l=1.25e-08 $layer=N_src_drn $thickness=1e-09
+ $X=0.056 $Y=0.0675 $X2=0.0685 $Y2=0.0675
r5 12 111 19.3796 $a=3.24e-16 $layer=V0LISD $X=0.054 $Y=0.2025 $X2=0.055
+ $Y2=0.234
r6 11 106 19.3796 $a=3.24e-16 $layer=V0LISD $X=0.054 $Y=0.0675 $X2=0.055
+ $Y2=0.036
r7 110 111 2.09871 $w=1.3e-08 $l=9e-09 $layer=M1 $thickness=3.6e-08 $X=0.046
+ $Y=0.234 $X2=0.055 $Y2=0.234
r8 30 110 2.3319 $w=1.3e-08 $l=1e-08 $layer=M1 $thickness=3.6e-08 $X=0.036
+ $Y=0.234 $X2=0.046 $Y2=0.234
r9 105 106 2.09871 $w=1.3e-08 $l=9e-09 $layer=M1 $thickness=3.6e-08 $X=0.046
+ $Y=0.036 $X2=0.055 $Y2=0.036
r10 29 105 2.3319 $w=1.3e-08 $l=1e-08 $layer=M1 $thickness=3.6e-08 $X=0.036
+ $Y=0.036 $X2=0.046 $Y2=0.036
r11 103 102 14.6259 $w=2.1e-08 $l=4.3e-08 $layer=Gate_1 $thickness=5.6e-08
+ $X=0.135 $Y=0.2025 $X2=0.135 $Y2=0.1595
r12 101 102 2.7211 $w=2.1e-08 $l=8e-09 $layer=Gate_1 $thickness=5.6e-08
+ $X=0.135 $Y=0.1515 $X2=0.135 $Y2=0.1595
r13 99 100 14.6259 $w=2.1e-08 $l=4.3e-08 $layer=Gate_1 $thickness=5.6e-08
+ $X=0.135 $Y=0.0675 $X2=0.135 $Y2=0.1105
r14 97 100 2.7211 $w=2.1e-08 $l=8e-09 $layer=Gate_1 $thickness=5.6e-08 $X=0.135
+ $Y=0.1185 $X2=0.135 $Y2=0.1105
r15 17 97 5.79936 $w=2.03333e-08 $l=1.65e-08 $layer=Gate_1 $thickness=5.6e-08
+ $X=0.135 $Y=0.135 $X2=0.135 $Y2=0.1185
r16 17 101 5.79936 $w=2.03333e-08 $l=1.65e-08 $layer=Gate_1 $thickness=5.6e-08
+ $X=0.135 $Y=0.135 $X2=0.135 $Y2=0.1515
r17 26 84 3.36447 $w=1.71023e-08 $l=2.15e-08 $layer=M1 $thickness=3.6e-08
+ $X=0.018 $Y=0.234 $X2=0.018 $Y2=0.2125
r18 26 30 2.5483 $w=1.55e-08 $l=1.8e-08 $layer=M1 $thickness=3.6e-08 $X=0.018
+ $Y=0.234 $X2=0.036 $Y2=0.234
r19 24 83 2.5483 $w=1.79e-08 $l=1.8e-08 $layer=M1 $thickness=3.6e-08 $X=0.018
+ $Y=0.036 $X2=0.018 $Y2=0.054
r20 24 29 2.5483 $w=1.55e-08 $l=1.8e-08 $layer=M1 $thickness=3.6e-08 $X=0.018
+ $Y=0.036 $X2=0.036 $Y2=0.036
r21 95 94 16.4967 $w=2.1e-08 $l=4.85e-08 $layer=Gate_1 $thickness=5.6e-08
+ $X=1.053 $Y=0.2025 $X2=1.053 $Y2=0.154
r22 20 94 6.6497 $w=2.04211e-08 $l=1.9e-08 $layer=Gate_1 $thickness=5.6e-08
+ $X=1.053 $Y=0.135 $X2=1.053 $Y2=0.154
r23 91 90 16.4967 $w=2.1e-08 $l=4.85e-08 $layer=Gate_1 $thickness=5.6e-08
+ $X=0.837 $Y=0.2025 $X2=0.837 $Y2=0.154
r24 19 90 6.6497 $w=2.04211e-08 $l=1.9e-08 $layer=Gate_1 $thickness=5.6e-08
+ $X=0.837 $Y=0.135 $X2=0.837 $Y2=0.154
r25 86 87 16.4967 $w=2.1e-08 $l=4.85e-08 $layer=Gate_1 $thickness=5.6e-08
+ $X=0.675 $Y=0.0675 $X2=0.675 $Y2=0.116
r26 18 87 6.6497 $w=2.04211e-08 $l=1.9e-08 $layer=Gate_1 $thickness=5.6e-08
+ $X=0.675 $Y=0.135 $X2=0.675 $Y2=0.116
r27 1 77 19.3796 $a=3.24e-16 $layer=V0LIG $X=0.135 $Y=0.135 $X2=0.135 $Y2=0.144
r28 1 17 10.4265 $w=1.765e-08 $layer=LIG $thickness=5.2e-08 $X=0.135 $Y=0.135
+ $X2=0.135 $Y2=0.135
r29 28 84 7.34548 $w=1.3e-08 $l=3.15e-08 $layer=M1 $thickness=3.6e-08 $X=0.018
+ $Y=0.181 $X2=0.018 $Y2=0.2125
r30 82 83 4.19742 $w=1.3e-08 $l=1.8e-08 $layer=M1 $thickness=3.6e-08 $X=0.018
+ $Y=0.072 $X2=0.018 $Y2=0.054
r31 27 82 9.44419 $w=1.3e-08 $l=4.05e-08 $layer=M1 $thickness=3.6e-08 $X=0.018
+ $Y=0.1125 $X2=0.018 $Y2=0.072
r32 4 71 19.3796 $a=3.24e-16 $layer=V0LIG $X=1.053 $Y=0.135 $X2=1.053 $Y2=0.144
r33 4 20 10.4265 $w=1.765e-08 $layer=LIG $thickness=5.2e-08 $X=1.053 $Y=0.135
+ $X2=1.053 $Y2=0.135
r34 3 68 19.3796 $a=3.24e-16 $layer=V0LIG $X=0.837 $Y=0.135 $X2=0.837 $Y2=0.144
r35 3 19 10.4265 $w=1.765e-08 $layer=LIG $thickness=5.2e-08 $X=0.837 $Y=0.135
+ $X2=0.837 $Y2=0.135
r36 79 81 5.15173 $w=1.56722e-08 $l=9e-09 $layer=LIG $thickness=4.8e-08
+ $X=0.6845 $Y=0.135 $X2=0.6935 $Y2=0.135
r37 2 79 2.6116 $w=2.2e-08 $l=1e-08 $layer=LIG $thickness=4.8e-08 $X=0.6745
+ $Y=0.135 $X2=0.6845 $Y2=0.135
r38 2 18 6.40962 $w=2.09268e-08 $l=5e-10 $layer=Gate_1 $thickness=5.22927e-08
+ $X=0.6745 $Y=0.135 $X2=0.675 $Y2=0.135
r39 31 77 6.52931 $w=1.3e-08 $l=2.8e-08 $layer=M1 $thickness=3.6e-08 $X=0.135
+ $Y=0.116 $X2=0.135 $Y2=0.144
r40 74 75 1.90199 $w=1.38333e-08 $l=9e-09 $layer=M1 $thickness=3.6e-08
+ $X=0.0255 $Y=0.153 $X2=0.0345 $Y2=0.153
r41 25 74 0.9184 $w=1.8e-08 $l=9e-09 $layer=M1 $thickness=3.6e-08 $X=0.0165
+ $Y=0.153 $X2=0.0255 $Y2=0.153
r42 25 27 8.11081 $w=1.39615e-08 $l=4.05278e-08 $layer=M1 $thickness=3.6e-08
+ $X=0.0165 $Y=0.153 $X2=0.018 $Y2=0.1125
r43 25 28 5.19594 $w=1.44151e-08 $l=2.80401e-08 $layer=M1 $thickness=3.6e-08
+ $X=0.0165 $Y=0.153 $X2=0.018 $Y2=0.181
r44 34 71 6.52931 $w=1.3e-08 $l=2.8e-08 $layer=M1 $thickness=3.6e-08 $X=1.053
+ $Y=0.116 $X2=1.053 $Y2=0.144
r45 33 68 10.7267 $w=1.3e-08 $l=4.6e-08 $layer=M1 $thickness=3.6e-08 $X=0.837
+ $Y=0.098 $X2=0.837 $Y2=0.144
r46 64 81 19.3796 $a=3.24e-16 $layer=V0LIG $X=0.693 $Y=0.144 $X2=0.6935
+ $Y2=0.135
r47 32 64 4.43061 $w=1.3e-08 $l=1.9e-08 $layer=M1 $thickness=3.6e-08 $X=0.693
+ $Y=0.125 $X2=0.693 $Y2=0.144
r48 62 63 5.71315 $w=1.3e-08 $l=2.45e-08 $layer=M2 $thickness=3.6e-08 $X=0.135
+ $Y=0.153 $X2=0.1595 $Y2=0.153
r49 62 77 19.5347 $a=3.24e-16 $layer=V1 $X=0.135 $Y=0.153 $X2=0.135 $Y2=0.144
r50 61 62 11.8927 $w=1.3e-08 $l=5.1e-08 $layer=M2 $thickness=3.6e-08 $X=0.084
+ $Y=0.153 $X2=0.135 $Y2=0.153
r51 60 61 11.8927 $w=1.3e-08 $l=5.1e-08 $layer=M2 $thickness=3.6e-08 $X=0.033
+ $Y=0.153 $X2=0.084 $Y2=0.153
r52 60 75 19.5347 $a=3.24e-16 $layer=V1 $X=0.033 $Y=0.153 $X2=0.0345 $Y2=0.153
r53 57 58 8.97781 $w=1.3e-08 $l=3.85e-08 $layer=M2 $thickness=3.6e-08 $X=1.053
+ $Y=0.153 $X2=1.0915 $Y2=0.153
r54 57 71 19.5347 $a=3.24e-16 $layer=V1 $X=1.053 $Y=0.153 $X2=1.053 $Y2=0.144
r55 56 57 25.1845 $w=1.3e-08 $l=1.08e-07 $layer=M2 $thickness=3.6e-08 $X=0.945
+ $Y=0.153 $X2=1.053 $Y2=0.153
r56 55 56 25.1845 $w=1.3e-08 $l=1.08e-07 $layer=M2 $thickness=3.6e-08 $X=0.837
+ $Y=0.153 $X2=0.945 $Y2=0.153
r57 55 68 19.5347 $a=3.24e-16 $layer=V1 $X=0.837 $Y=0.153 $X2=0.837 $Y2=0.144
r58 54 55 16.7897 $w=1.3e-08 $l=7.2e-08 $layer=M2 $thickness=3.6e-08 $X=0.765
+ $Y=0.153 $X2=0.837 $Y2=0.153
r59 53 54 16.7897 $w=1.3e-08 $l=7.2e-08 $layer=M2 $thickness=3.6e-08 $X=0.693
+ $Y=0.153 $X2=0.765 $Y2=0.153
r60 53 64 19.5347 $a=3.24e-16 $layer=V1 $X=0.693 $Y=0.153 $X2=0.693 $Y2=0.144
r61 52 53 61.4455 $w=1.3e-08 $l=2.635e-07 $layer=M2 $thickness=3.6e-08
+ $X=0.4295 $Y=0.153 $X2=0.693 $Y2=0.153
r62 52 63 62.9612 $w=1.3e-08 $l=2.7e-07 $layer=M2 $thickness=3.6e-08 $X=0.4295
+ $Y=0.153 $X2=0.1595 $Y2=0.153
r63 36 50 5.71315 $w=1.3e-08 $l=2.45e-08 $layer=M2 $thickness=3.6e-08 $X=1.1365
+ $Y=0.153 $X2=1.161 $Y2=0.153
r64 36 58 10.4935 $w=1.3e-08 $l=4.5e-08 $layer=M2 $thickness=3.6e-08 $X=1.1365
+ $Y=0.153 $X2=1.0915 $Y2=0.153
r65 47 50 19.5347 $a=3.24e-16 $layer=V1 $X=1.161 $Y=0.144 $X2=1.161 $Y2=0.153
r66 35 47 6.52931 $w=1.3e-08 $l=2.8e-08 $layer=M1 $thickness=3.6e-08 $X=1.161
+ $Y=0.116 $X2=1.161 $Y2=0.144
r67 5 45 10.4265 $w=1.765e-08 $layer=LIG $thickness=5.2e-08 $X=1.161 $Y=0.135
+ $X2=1.161 $Y2=0.135
r68 5 47 19.3796 $a=3.24e-16 $layer=V0LIG $X=1.161 $Y=0.135 $X2=1.161 $Y2=0.144
r69 44 45 6.6497 $w=2.04211e-08 $l=1.9e-08 $layer=Gate_1 $thickness=5.6e-08
+ $X=1.161 $Y=0.116 $X2=1.161 $Y2=0.135
r70 43 44 16.4967 $w=2.1e-08 $l=4.85e-08 $layer=Gate_1 $thickness=5.6e-08
+ $X=1.161 $Y=0.0675 $X2=1.161 $Y2=0.116
r71 43 21 14.6259 $w=2.1e-08 $l=4.3e-08 $layer=Gate_1 $thickness=5.6e-08
+ $X=1.161 $Y=0.0675 $X2=1.161 $Y2=0.0245
r72 12 23 1e-05 $l=2e-09 $X=0.054 $Y=0.2025 $X2=0.056 $Y2=0.2025
r73 11 22 1e-05 $l=2e-09 $X=0.054 $Y=0.0675 $X2=0.056 $Y2=0.0675
.ends

.subckt PM_SDFHx4_ASAP7_75t_R%23 vss 2 3 1
c1 1 vss 0.000815647f $X=0.864 $Y=0.2025
r1 2 1 0.209877 $w=8.1e-08 $l=1.7e-08 $layer=P_src_drn $thickness=1e-09
+ $X=0.8466 $Y=0.2025 $X2=0.864 $Y2=0.2025
r2 3 1 0.209877 $w=8.1e-08 $l=1.7e-08 $layer=P_src_drn $thickness=1e-09
+ $X=0.8813 $Y=0.2025 $X2=0.864 $Y2=0.2025
.ends

.subckt PM_SDFHx4_ASAP7_75t_R%10 vss 19 23 38 40 42 44 15 1 13 3 18 5 4 17 11
+ 12 14
c1 1 vss 0.00361811f $X=0.891 $Y=0.135
c2 3 vss 0.0189074f $X=0.968 $Y=0.0675
c3 4 vss 0.0105158f $X=0.999 $Y=0.2025
c4 5 vss 0.00298159f $X=0.9985 $Y=0.135
c5 11 vss 0.0816112f $X=0.891 $Y=0.0245
c6 12 vss 0.0374789f $X=0.9575 $Y=0.0675
c7 13 vss 0.00225635f $X=1.082 $Y=0.0675
c8 14 vss 0.0372309f $X=0.9575 $Y=0.2025
c9 15 vss 0.0358049f $X=1.028 $Y=0.2025
c10 16 vss 0.00126836f $X=0.891 $Y=0.0755
c11 17 vss 0.0012685f $X=0.891 $Y=0.116
c12 18 vss 0.00388477f $X=0.918 $Y=0.072
r1 44 43 0.0308642 $w=8.1e-08 $l=2.5e-09 $layer=P_src_drn $thickness=1e-09
+ $X=1.0433 $Y=0.2025 $X2=1.0405 $Y2=0.2025
r2 15 43 0.154321 $w=8.1e-08 $l=1.25e-08 $layer=P_src_drn $thickness=1e-09
+ $X=1.028 $Y=0.2025 $X2=1.0405 $Y2=0.2025
r3 14 4 0.154321 $w=8.1e-08 $l=1.25e-08 $layer=P_src_drn $thickness=1e-09
+ $X=0.9575 $Y=0.2025 $X2=0.999 $Y2=0.2025
r4 42 14 0.0308642 $w=8.1e-08 $l=2.5e-09 $layer=P_src_drn $thickness=1e-09
+ $X=0.9546 $Y=0.2025 $X2=0.9575 $Y2=0.2025
r5 4 5 8.98133 $w=6.1e-08 $l=6.75018e-08 $layer=LISD $thickness=2.7e-08
+ $X=0.999 $Y=0.2025 $X2=0.9985 $Y2=0.135
r6 40 39 0.0308642 $w=8.1e-08 $l=2.5e-09 $layer=N_src_drn $thickness=1e-09
+ $X=1.0973 $Y=0.0675 $X2=1.0945 $Y2=0.0675
r7 13 39 0.154321 $w=8.1e-08 $l=1.25e-08 $layer=N_src_drn $thickness=1e-09
+ $X=1.082 $Y=0.0675 $X2=1.0945 $Y2=0.0675
r8 5 33 6.79656 $w=5.73824e-08 $l=6.76184e-08 $layer=LISD $thickness=2.7e-08
+ $X=0.9985 $Y=0.135 $X2=1.0025 $Y2=0.0675
r9 12 3 0.154321 $w=8.1e-08 $l=1.25e-08 $layer=N_src_drn $thickness=1e-09
+ $X=0.9575 $Y=0.0675 $X2=0.968 $Y2=0.0675
r10 38 12 0.0308642 $w=8.1e-08 $l=2.5e-09 $layer=N_src_drn $thickness=1e-09
+ $X=0.9546 $Y=0.0675 $X2=0.9575 $Y2=0.0675
r11 35 13 2.35445 $w=7.72e-08 $l=2.7e-08 $layer=LISD $thickness=2.7e-08
+ $X=1.053 $Y=0.0675 $X2=1.082 $Y2=0.0675
r12 34 35 2.04924 $w=7.72e-08 $l=2.35e-08 $layer=LISD $thickness=2.7e-08
+ $X=1.0295 $Y=0.0675 $X2=1.053 $Y2=0.0675
r13 33 34 2.26219 $w=7.98037e-08 $l=2.7e-08 $layer=LISD $thickness=2.7e-08
+ $X=1.0025 $Y=0.0675 $X2=1.0295 $Y2=0.0675
r14 32 33 1.84983 $w=8.1e-08 $l=2.25e-08 $layer=LISD $thickness=2.7e-08 $X=0.98
+ $Y=0.0675 $X2=1.0025 $Y2=0.0675
r15 3 31 19.3796 $a=3.24e-16 $layer=V0LISD $X=0.968 $Y=0.0675 $X2=0.972
+ $Y2=0.072
r16 3 32 1.02647 $w=7.84667e-08 $l=1.2e-08 $layer=LISD $thickness=2.7e-08
+ $X=0.968 $Y=0.0675 $X2=0.98 $Y2=0.0675
r17 30 31 3.14806 $w=1.3e-08 $l=1.35e-08 $layer=M1 $thickness=3.6e-08 $X=0.9585
+ $Y=0.072 $X2=0.972 $Y2=0.072
r18 29 30 3.14806 $w=1.3e-08 $l=1.35e-08 $layer=M1 $thickness=3.6e-08 $X=0.945
+ $Y=0.072 $X2=0.9585 $Y2=0.072
r19 18 29 6.29612 $w=1.3e-08 $l=2.7e-08 $layer=M1 $thickness=3.6e-08 $X=0.918
+ $Y=0.072 $X2=0.945 $Y2=0.072
r20 16 27 3.47612 $w=1.45278e-08 $l=1.8e-08 $layer=M1 $thickness=3.6e-08
+ $X=0.891 $Y=0.0755 $X2=0.891 $Y2=0.0935
r21 16 18 4.75866 $w=1.41702e-08 $l=2.72259e-08 $layer=M1 $thickness=3.6e-08
+ $X=0.891 $Y=0.0755 $X2=0.918 $Y2=0.072
r22 17 25 4.43061 $w=1.3e-08 $l=1.9e-08 $layer=M1 $thickness=3.6e-08 $X=0.891
+ $Y=0.116 $X2=0.891 $Y2=0.135
r23 17 27 5.24677 $w=1.3e-08 $l=2.25e-08 $layer=M1 $thickness=3.6e-08 $X=0.891
+ $Y=0.116 $X2=0.891 $Y2=0.0935
r24 1 21 10.4265 $w=1.765e-08 $layer=LIG $thickness=5.2e-08 $X=0.891 $Y=0.135
+ $X2=0.891 $Y2=0.135
r25 1 25 19.3796 $a=3.24e-16 $layer=V0LIG $X=0.891 $Y=0.135 $X2=0.891 $Y2=0.135
r26 23 22 16.4967 $w=2.1e-08 $l=4.85e-08 $layer=Gate_1 $thickness=5.6e-08
+ $X=0.891 $Y=0.2025 $X2=0.891 $Y2=0.154
r27 21 22 6.6497 $w=2.04211e-08 $l=1.9e-08 $layer=Gate_1 $thickness=5.6e-08
+ $X=0.891 $Y=0.135 $X2=0.891 $Y2=0.154
r28 20 21 6.6497 $w=2.04211e-08 $l=1.9e-08 $layer=Gate_1 $thickness=5.6e-08
+ $X=0.891 $Y=0.116 $X2=0.891 $Y2=0.135
r29 19 20 16.4967 $w=2.1e-08 $l=4.85e-08 $layer=Gate_1 $thickness=5.6e-08
+ $X=0.891 $Y=0.0675 $X2=0.891 $Y2=0.116
r30 19 11 14.6259 $w=2.1e-08 $l=4.3e-08 $layer=Gate_1 $thickness=5.6e-08
+ $X=0.891 $Y=0.0675 $X2=0.891 $Y2=0.0245
r31 4 15 1e-05 $l=2.9e-08 $X=0.999 $Y=0.2025 $X2=1.028 $Y2=0.2025
.ends

.subckt PM_SDFHx4_ASAP7_75t_R%13 vss 30 36 57 58 86 90 93 96 99 102 106 110 114
+ 115 16 6 28 23 25 5 19 17 24 21 1 11 26 27 20 22 2 14 13 29 15 12
c1 1 vss 0.00369785f $X=1.269 $Y=0.135
c2 2 vss 0.0192301f $X=1.4215 $Y=0.135
c3 5 vss 0.00427493f $X=1.08 $Y=0.2025
c4 6 vss 0.00512797f $X=1.134 $Y=0.0675
c5 11 vss 0.0892049f $X=1.269 $Y=0.0245
c6 12 vss 0.0891036f $X=1.431 $Y=0.135
c7 13 vss 0.0805458f $X=1.485 $Y=0.135
c8 14 vss 0.0811015f $X=1.539 $Y=0.135
c9 15 vss 0.0886743f $X=1.593 $Y=0.135
c10 16 vss 0.00831408f $X=1.1195 $Y=0.0675
c11 17 vss 0.00683129f $X=1.0655 $Y=0.2025
c12 18 vss 0.00229473f $X=1.251 $Y=0.036
c13 19 vss 0.000578045f $X=1.251 $Y=0.135
c14 20 vss 0.00329826f $X=1.377 $Y=0.036
c15 21 vss 0.0003916f $X=1.377 $Y=0.135
c16 22 vss 0.00328369f $X=1.377 $Y=0.234
c17 23 vss 0.0322109f $X=1.35 $Y=0.234
c18 24 vss 0.0134507f $X=1.233 $Y=0.036
c19 25 vss 0.00285269f $X=1.251 $Y=0.116
c20 26 vss 0.0110592f $X=1.2715 $Y=0.036
c21 27 vss 0.0044967f $X=1.377 $Y=0.063
c22 28 vss 0.00473219f $X=1.377 $Y=0.172
c23 29 vss 0.00376709f $X=1.404 $Y=0.135
r1 115 113 0.0308642 $w=8.1e-08 $l=2.5e-09 $layer=P_src_drn $thickness=1e-09
+ $X=1.0973 $Y=0.2025 $X2=1.0945 $Y2=0.2025
r2 5 113 0.179012 $w=8.1e-08 $l=1.45e-08 $layer=P_src_drn $thickness=1e-09
+ $X=1.08 $Y=0.2025 $X2=1.0945 $Y2=0.2025
r3 17 5 0.179012 $w=8.1e-08 $l=1.45e-08 $layer=P_src_drn $thickness=1e-09
+ $X=1.0655 $Y=0.2025 $X2=1.08 $Y2=0.2025
r4 114 17 0.0308642 $w=8.1e-08 $l=2.5e-09 $layer=P_src_drn $thickness=1e-09
+ $X=1.0626 $Y=0.2025 $X2=1.0655 $Y2=0.2025
r5 5 81 19.3796 $a=3.24e-16 $layer=V0LISD $X=1.08 $Y=0.2025 $X2=1.08 $Y2=0.234
r6 110 109 14.6259 $w=2.1e-08 $l=4.3e-08 $layer=Gate_1 $thickness=5.6e-08
+ $X=1.593 $Y=0.2025 $X2=1.593 $Y2=0.1595
r7 108 109 2.7211 $w=2.1e-08 $l=8e-09 $layer=Gate_1 $thickness=5.6e-08 $X=1.593
+ $Y=0.1515 $X2=1.593 $Y2=0.1595
r8 106 107 14.6259 $w=2.1e-08 $l=4.3e-08 $layer=Gate_1 $thickness=5.6e-08
+ $X=1.593 $Y=0.0675 $X2=1.593 $Y2=0.1105
r9 104 107 2.7211 $w=2.1e-08 $l=8e-09 $layer=Gate_1 $thickness=5.6e-08 $X=1.593
+ $Y=0.1185 $X2=1.593 $Y2=0.1105
r10 15 73 6.54019 $w=2.09524e-08 $layer=Gate_1 $thickness=5.21905e-08 $X=1.593
+ $Y=0.135 $X2=1.593 $Y2=0.135
r11 15 104 5.79936 $w=2.03333e-08 $l=1.65e-08 $layer=Gate_1 $thickness=5.6e-08
+ $X=1.593 $Y=0.135 $X2=1.593 $Y2=0.1185
r12 15 108 5.79936 $w=2.03333e-08 $l=1.65e-08 $layer=Gate_1 $thickness=5.6e-08
+ $X=1.593 $Y=0.135 $X2=1.593 $Y2=0.1515
r13 102 101 16.4967 $w=2.1e-08 $l=4.85e-08 $layer=Gate_1 $thickness=5.6e-08
+ $X=1.539 $Y=0.2025 $X2=1.539 $Y2=0.154
r14 99 100 16.4967 $w=2.1e-08 $l=4.85e-08 $layer=Gate_1 $thickness=5.6e-08
+ $X=1.539 $Y=0.0675 $X2=1.539 $Y2=0.116
r15 14 71 6.54019 $w=2.09524e-08 $layer=Gate_1 $thickness=5.21905e-08 $X=1.539
+ $Y=0.135 $X2=1.539 $Y2=0.135
r16 14 100 6.6497 $w=2.04211e-08 $l=1.9e-08 $layer=Gate_1 $thickness=5.6e-08
+ $X=1.539 $Y=0.135 $X2=1.539 $Y2=0.116
r17 14 101 6.6497 $w=2.04211e-08 $l=1.9e-08 $layer=Gate_1 $thickness=5.6e-08
+ $X=1.539 $Y=0.135 $X2=1.539 $Y2=0.154
r18 96 95 16.4967 $w=2.1e-08 $l=4.85e-08 $layer=Gate_1 $thickness=5.6e-08
+ $X=1.485 $Y=0.2025 $X2=1.485 $Y2=0.154
r19 93 94 16.4967 $w=2.1e-08 $l=4.85e-08 $layer=Gate_1 $thickness=5.6e-08
+ $X=1.485 $Y=0.0675 $X2=1.485 $Y2=0.116
r20 13 69 6.54019 $w=2.09524e-08 $layer=Gate_1 $thickness=5.21905e-08 $X=1.485
+ $Y=0.135 $X2=1.485 $Y2=0.135
r21 13 94 6.6497 $w=2.04211e-08 $l=1.9e-08 $layer=Gate_1 $thickness=5.6e-08
+ $X=1.485 $Y=0.135 $X2=1.485 $Y2=0.116
r22 13 95 6.6497 $w=2.04211e-08 $l=1.9e-08 $layer=Gate_1 $thickness=5.6e-08
+ $X=1.485 $Y=0.135 $X2=1.485 $Y2=0.154
r23 90 89 14.6259 $w=2.1e-08 $l=4.3e-08 $layer=Gate_1 $thickness=5.6e-08
+ $X=1.431 $Y=0.2025 $X2=1.431 $Y2=0.1595
r24 88 89 2.7211 $w=2.1e-08 $l=8e-09 $layer=Gate_1 $thickness=5.6e-08 $X=1.431
+ $Y=0.1515 $X2=1.431 $Y2=0.1595
r25 86 87 14.6259 $w=2.1e-08 $l=4.3e-08 $layer=Gate_1 $thickness=5.6e-08
+ $X=1.431 $Y=0.0675 $X2=1.431 $Y2=0.1105
r26 84 87 2.7211 $w=2.1e-08 $l=8e-09 $layer=Gate_1 $thickness=5.6e-08 $X=1.431
+ $Y=0.1185 $X2=1.431 $Y2=0.1105
r27 12 65 6.27904 $w=2.09e-08 $layer=Gate_1 $thickness=5.24e-08 $X=1.431
+ $Y=0.135 $X2=1.431 $Y2=0.135
r28 12 84 5.79936 $w=2.03333e-08 $l=1.65e-08 $layer=Gate_1 $thickness=5.6e-08
+ $X=1.431 $Y=0.135 $X2=1.431 $Y2=0.1185
r29 12 88 5.79936 $w=2.03333e-08 $l=1.65e-08 $layer=Gate_1 $thickness=5.6e-08
+ $X=1.431 $Y=0.135 $X2=1.431 $Y2=0.1515
r30 81 82 3.14806 $w=1.3e-08 $l=1.35e-08 $layer=M1 $thickness=3.6e-08 $X=1.08
+ $Y=0.234 $X2=1.0935 $Y2=0.234
r31 79 82 3.14806 $w=1.3e-08 $l=1.35e-08 $layer=M1 $thickness=3.6e-08 $X=1.107
+ $Y=0.234 $X2=1.0935 $Y2=0.234
r32 78 79 6.29612 $w=1.3e-08 $l=2.7e-08 $layer=M1 $thickness=3.6e-08 $X=1.134
+ $Y=0.234 $X2=1.107 $Y2=0.234
r33 77 78 6.29612 $w=1.3e-08 $l=2.7e-08 $layer=M1 $thickness=3.6e-08 $X=1.161
+ $Y=0.234 $X2=1.134 $Y2=0.234
r34 76 77 6.29612 $w=1.3e-08 $l=2.7e-08 $layer=M1 $thickness=3.6e-08 $X=1.188
+ $Y=0.234 $X2=1.161 $Y2=0.234
r35 75 76 18.8884 $w=1.3e-08 $l=8.1e-08 $layer=M1 $thickness=3.6e-08 $X=1.269
+ $Y=0.234 $X2=1.188 $Y2=0.234
r36 23 75 18.8884 $w=1.3e-08 $l=8.1e-08 $layer=M1 $thickness=3.6e-08 $X=1.35
+ $Y=0.234 $X2=1.269 $Y2=0.234
r37 72 73 12.6539 $w=1.77815e-08 $l=2.7e-08 $layer=LIG $thickness=4.8e-08
+ $X=1.566 $Y=0.135 $X2=1.593 $Y2=0.135
r38 71 72 12.6539 $w=1.77815e-08 $l=2.7e-08 $layer=LIG $thickness=4.8e-08
+ $X=1.539 $Y=0.135 $X2=1.566 $Y2=0.135
r39 70 71 12.6539 $w=1.77815e-08 $l=2.7e-08 $layer=LIG $thickness=4.8e-08
+ $X=1.512 $Y=0.135 $X2=1.539 $Y2=0.135
r40 69 70 12.6539 $w=1.77815e-08 $l=2.7e-08 $layer=LIG $thickness=4.8e-08
+ $X=1.485 $Y=0.135 $X2=1.512 $Y2=0.135
r41 68 69 12.6539 $w=1.77815e-08 $l=2.7e-08 $layer=LIG $thickness=4.8e-08
+ $X=1.458 $Y=0.135 $X2=1.485 $Y2=0.135
r42 66 68 10.1729 $w=1.54914e-08 $l=1.75e-08 $layer=LIG $thickness=4.8e-08
+ $X=1.4405 $Y=0.135 $X2=1.458 $Y2=0.135
r43 65 66 2.48102 $w=2.2e-08 $l=9.5e-09 $layer=LIG $thickness=4.8e-08 $X=1.431
+ $Y=0.135 $X2=1.4405 $Y2=0.135
r44 2 65 2.48102 $w=2.2e-08 $l=9.5e-09 $layer=LIG $thickness=4.8e-08 $X=1.4215
+ $Y=0.135 $X2=1.431 $Y2=0.135
r45 22 61 3.36447 $w=1.71023e-08 $l=2.15e-08 $layer=M1 $thickness=3.6e-08
+ $X=1.377 $Y=0.234 $X2=1.377 $Y2=0.2125
r46 22 23 4.64701 $w=1.46667e-08 $l=2.7e-08 $layer=M1 $thickness=3.6e-08
+ $X=1.377 $Y=0.234 $X2=1.35 $Y2=0.234
r47 62 65 19.3796 $a=3.24e-16 $layer=V0LIG $X=1.431 $Y=0.135 $X2=1.431 $Y2=0.135
r48 29 62 6.29612 $w=1.3e-08 $l=2.7e-08 $layer=M1 $thickness=3.6e-08 $X=1.404
+ $Y=0.135 $X2=1.431 $Y2=0.135
r49 28 61 9.44419 $w=1.3e-08 $l=4.05e-08 $layer=M1 $thickness=3.6e-08 $X=1.377
+ $Y=0.172 $X2=1.377 $Y2=0.2125
r50 21 60 4.06646 $w=1.5e-08 $l=2.25e-08 $layer=M1 $thickness=3.6e-08 $X=1.377
+ $Y=0.135 $X2=1.377 $Y2=0.1125
r51 21 28 7.44771 $w=1.42162e-08 $l=3.7e-08 $layer=M1 $thickness=3.6e-08
+ $X=1.377 $Y=0.135 $X2=1.377 $Y2=0.172
r52 21 29 5.11582 $w=1.46667e-08 $l=2.7e-08 $layer=M1 $thickness=3.6e-08
+ $X=1.377 $Y=0.135 $X2=1.404 $Y2=0.135
r53 59 60 5.24677 $w=1.3e-08 $l=2.25e-08 $layer=M1 $thickness=3.6e-08 $X=1.377
+ $Y=0.09 $X2=1.377 $Y2=0.1125
r54 27 59 6.29612 $w=1.3e-08 $l=2.7e-08 $layer=M1 $thickness=3.6e-08 $X=1.377
+ $Y=0.063 $X2=1.377 $Y2=0.09
r55 58 56 0.0308642 $w=8.1e-08 $l=2.5e-09 $layer=N_src_drn $thickness=1e-09
+ $X=1.1513 $Y=0.0675 $X2=1.1485 $Y2=0.0675
r56 6 56 0.179012 $w=8.1e-08 $l=1.45e-08 $layer=N_src_drn $thickness=1e-09
+ $X=1.134 $Y=0.0675 $X2=1.1485 $Y2=0.0675
r57 16 6 0.179012 $w=8.1e-08 $l=1.45e-08 $layer=N_src_drn $thickness=1e-09
+ $X=1.1195 $Y=0.0675 $X2=1.134 $Y2=0.0675
r58 57 16 0.0308642 $w=8.1e-08 $l=2.5e-09 $layer=N_src_drn $thickness=1e-09
+ $X=1.1166 $Y=0.0675 $X2=1.1195 $Y2=0.0675
r59 20 54 4.64701 $w=1.46667e-08 $l=2.7e-08 $layer=M1 $thickness=3.6e-08
+ $X=1.377 $Y=0.036 $X2=1.35 $Y2=0.036
r60 20 27 4.64701 $w=1.62667e-08 $l=2.7e-08 $layer=M1 $thickness=3.6e-08
+ $X=1.377 $Y=0.036 $X2=1.377 $Y2=0.063
r61 6 49 19.3796 $a=3.24e-16 $layer=V0LISD $X=1.134 $Y=0.0675 $X2=1.134
+ $Y2=0.036
r62 53 54 9.44419 $w=1.3e-08 $l=4.05e-08 $layer=M1 $thickness=3.6e-08 $X=1.3095
+ $Y=0.036 $X2=1.35 $Y2=0.036
r63 52 53 5.71315 $w=1.3e-08 $l=2.45e-08 $layer=M1 $thickness=3.6e-08 $X=1.285
+ $Y=0.036 $X2=1.3095 $Y2=0.036
r64 26 52 3.14806 $w=1.3e-08 $l=1.35e-08 $layer=M1 $thickness=3.6e-08 $X=1.2715
+ $Y=0.036 $X2=1.285 $Y2=0.036
r65 49 50 3.14806 $w=1.3e-08 $l=1.35e-08 $layer=M1 $thickness=3.6e-08 $X=1.134
+ $Y=0.036 $X2=1.1475 $Y2=0.036
r66 47 50 3.14806 $w=1.3e-08 $l=1.35e-08 $layer=M1 $thickness=3.6e-08 $X=1.161
+ $Y=0.036 $X2=1.1475 $Y2=0.036
r67 46 47 6.29612 $w=1.3e-08 $l=2.7e-08 $layer=M1 $thickness=3.6e-08 $X=1.188
+ $Y=0.036 $X2=1.161 $Y2=0.036
r68 45 46 6.29612 $w=1.3e-08 $l=2.7e-08 $layer=M1 $thickness=3.6e-08 $X=1.215
+ $Y=0.036 $X2=1.188 $Y2=0.036
r69 24 45 4.19742 $w=1.3e-08 $l=1.8e-08 $layer=M1 $thickness=3.6e-08 $X=1.233
+ $Y=0.036 $X2=1.215 $Y2=0.036
r70 18 44 3.01711 $w=1.55e-08 $l=1.8e-08 $layer=M1 $thickness=3.6e-08 $X=1.251
+ $Y=0.036 $X2=1.251 $Y2=0.054
r71 18 24 3.01711 $w=1.55e-08 $l=1.8e-08 $layer=M1 $thickness=3.6e-08 $X=1.251
+ $Y=0.036 $X2=1.233 $Y2=0.036
r72 18 26 3.60008 $w=1.51951e-08 $l=2.05e-08 $layer=M1 $thickness=3.6e-08
+ $X=1.251 $Y=0.036 $X2=1.2715 $Y2=0.036
r73 43 44 2.91487 $w=1.3e-08 $l=1.25e-08 $layer=M1 $thickness=3.6e-08 $X=1.251
+ $Y=0.0665 $X2=1.251 $Y2=0.054
r74 42 43 2.09871 $w=1.3e-08 $l=9e-09 $layer=M1 $thickness=3.6e-08 $X=1.251
+ $Y=0.0755 $X2=1.251 $Y2=0.0665
r75 41 42 3.38125 $w=1.3e-08 $l=1.45e-08 $layer=M1 $thickness=3.6e-08 $X=1.251
+ $Y=0.09 $X2=1.251 $Y2=0.0755
r76 40 41 2.91487 $w=1.3e-08 $l=1.25e-08 $layer=M1 $thickness=3.6e-08 $X=1.251
+ $Y=0.1025 $X2=1.251 $Y2=0.09
r77 25 40 3.14806 $w=1.3e-08 $l=1.35e-08 $layer=M1 $thickness=3.6e-08 $X=1.251
+ $Y=0.116 $X2=1.251 $Y2=0.1025
r78 19 38 3.01711 $w=1.55e-08 $l=1.8e-08 $layer=M1 $thickness=3.6e-08 $X=1.251
+ $Y=0.135 $X2=1.269 $Y2=0.135
r79 19 25 3.2503 $w=1.53684e-08 $l=1.9e-08 $layer=M1 $thickness=3.6e-08
+ $X=1.251 $Y=0.135 $X2=1.251 $Y2=0.116
r80 1 33 10.4265 $w=1.765e-08 $layer=LIG $thickness=5.2e-08 $X=1.269 $Y=0.135
+ $X2=1.269 $Y2=0.135
r81 1 38 19.3796 $a=3.24e-16 $layer=V0LIG $X=1.269 $Y=0.135 $X2=1.269 $Y2=0.135
r82 36 35 14.6259 $w=2.1e-08 $l=4.3e-08 $layer=Gate_1 $thickness=5.6e-08
+ $X=1.269 $Y=0.2025 $X2=1.269 $Y2=0.1595
r83 34 35 2.7211 $w=2.1e-08 $l=8e-09 $layer=Gate_1 $thickness=5.6e-08 $X=1.269
+ $Y=0.1515 $X2=1.269 $Y2=0.1595
r84 33 34 5.79936 $w=2.03333e-08 $l=1.65e-08 $layer=Gate_1 $thickness=5.6e-08
+ $X=1.269 $Y=0.135 $X2=1.269 $Y2=0.1515
r85 32 33 5.79936 $w=2.03333e-08 $l=1.65e-08 $layer=Gate_1 $thickness=5.6e-08
+ $X=1.269 $Y=0.1185 $X2=1.269 $Y2=0.135
r86 31 32 2.7211 $w=2.1e-08 $l=8e-09 $layer=Gate_1 $thickness=5.6e-08 $X=1.269
+ $Y=0.1105 $X2=1.269 $Y2=0.1185
r87 30 31 14.6259 $w=2.1e-08 $l=4.3e-08 $layer=Gate_1 $thickness=5.6e-08
+ $X=1.269 $Y=0.0675 $X2=1.269 $Y2=0.1105
r88 30 11 14.6259 $w=2.1e-08 $l=4.3e-08 $layer=Gate_1 $thickness=5.6e-08
+ $X=1.269 $Y=0.0675 $X2=1.269 $Y2=0.0245
.ends

.subckt PM_SDFHx4_ASAP7_75t_R%QN vss 31 24 25 35 36 44 45 48 49 13 3 4 1 2 15
+ 14 16
c1 1 vss 0.00856509f $X=1.458 $Y=0.0675
c2 2 vss 0.00862501f $X=1.458 $Y=0.2025
c3 3 vss 0.00853734f $X=1.566 $Y=0.0675
c4 4 vss 0.00853734f $X=1.566 $Y=0.2025
c5 13 vss 0.00439214f $X=1.4435 $Y=0.0675
c6 14 vss 0.00431168f $X=1.5515 $Y=0.0675
c7 15 vss 0.00438794f $X=1.4435 $Y=0.2025
c8 16 vss 0.00430861f $X=1.5515 $Y=0.2025
c9 17 vss 0.00298982f $X=1.6465 $Y=0.036
c10 18 vss 0.00298982f $X=1.6465 $Y=0.234
c11 19 vss 0.018203f $X=1.4455 $Y=0.036
c12 20 vss 0.0182678f $X=1.448 $Y=0.234
c13 21 vss 0.00879741f $X=1.6465 $Y=0.0855
r1 49 47 0.0308642 $w=8.1e-08 $l=2.5e-09 $layer=P_src_drn $thickness=1e-09
+ $X=1.5833 $Y=0.2025 $X2=1.5805 $Y2=0.2025
r2 4 47 0.179012 $w=8.1e-08 $l=1.45e-08 $layer=P_src_drn $thickness=1e-09
+ $X=1.566 $Y=0.2025 $X2=1.5805 $Y2=0.2025
r3 16 4 0.179012 $w=8.1e-08 $l=1.45e-08 $layer=P_src_drn $thickness=1e-09
+ $X=1.5515 $Y=0.2025 $X2=1.566 $Y2=0.2025
r4 48 16 0.0308642 $w=8.1e-08 $l=2.5e-09 $layer=P_src_drn $thickness=1e-09
+ $X=1.5486 $Y=0.2025 $X2=1.5515 $Y2=0.2025
r5 45 43 0.0308642 $w=8.1e-08 $l=2.5e-09 $layer=P_src_drn $thickness=1e-09
+ $X=1.4753 $Y=0.2025 $X2=1.4725 $Y2=0.2025
r6 2 43 0.179012 $w=8.1e-08 $l=1.45e-08 $layer=P_src_drn $thickness=1e-09
+ $X=1.458 $Y=0.2025 $X2=1.4725 $Y2=0.2025
r7 15 2 0.179012 $w=8.1e-08 $l=1.45e-08 $layer=P_src_drn $thickness=1e-09
+ $X=1.4435 $Y=0.2025 $X2=1.458 $Y2=0.2025
r8 44 15 0.0308642 $w=8.1e-08 $l=2.5e-09 $layer=P_src_drn $thickness=1e-09
+ $X=1.4406 $Y=0.2025 $X2=1.4435 $Y2=0.2025
r9 4 39 19.3796 $a=3.24e-16 $layer=V0LISD $X=1.566 $Y=0.2025 $X2=1.566 $Y2=0.234
r10 2 37 19.3796 $a=3.24e-16 $layer=V0LISD $X=1.458 $Y=0.2025 $X2=1.458
+ $Y2=0.234
r11 39 40 9.32759 $w=1.3e-08 $l=4e-08 $layer=M1 $thickness=3.6e-08 $X=1.566
+ $Y=0.234 $X2=1.606 $Y2=0.234
r12 38 39 12.5922 $w=1.3e-08 $l=5.4e-08 $layer=M1 $thickness=3.6e-08 $X=1.512
+ $Y=0.234 $X2=1.566 $Y2=0.234
r13 37 38 12.5922 $w=1.3e-08 $l=5.4e-08 $layer=M1 $thickness=3.6e-08 $X=1.458
+ $Y=0.234 $X2=1.512 $Y2=0.234
r14 20 37 2.3319 $w=1.3e-08 $l=1e-08 $layer=M1 $thickness=3.6e-08 $X=1.448
+ $Y=0.234 $X2=1.458 $Y2=0.234
r15 18 32 8.52248 $w=1.49091e-08 $l=4.95e-08 $layer=M1 $thickness=3.6e-08
+ $X=1.6465 $Y=0.234 $X2=1.6465 $Y2=0.1845
r16 18 40 7.67296 $w=1.54395e-08 $l=4.05e-08 $layer=M1 $thickness=3.6e-08
+ $X=1.6465 $Y=0.234 $X2=1.606 $Y2=0.234
r17 36 34 0.0308642 $w=8.1e-08 $l=2.5e-09 $layer=N_src_drn $thickness=1e-09
+ $X=1.5833 $Y=0.0675 $X2=1.5805 $Y2=0.0675
r18 3 34 0.179012 $w=8.1e-08 $l=1.45e-08 $layer=N_src_drn $thickness=1e-09
+ $X=1.566 $Y=0.0675 $X2=1.5805 $Y2=0.0675
r19 14 3 0.179012 $w=8.1e-08 $l=1.45e-08 $layer=N_src_drn $thickness=1e-09
+ $X=1.5515 $Y=0.0675 $X2=1.566 $Y2=0.0675
r20 35 14 0.0308642 $w=8.1e-08 $l=2.5e-09 $layer=N_src_drn $thickness=1e-09
+ $X=1.5486 $Y=0.0675 $X2=1.5515 $Y2=0.0675
r21 31 32 9.8736 $w=1.4e-08 $l=4.95e-08 $layer=M1 $thickness=3.6e-08 $X=1.646
+ $Y=0.1345 $X2=1.6465 $Y2=0.1845
r22 31 21 9.8736 $w=1.4e-08 $l=4.95e-08 $layer=M1 $thickness=3.6e-08 $X=1.646
+ $Y=0.1345 $X2=1.6465 $Y2=0.0855
r23 3 29 19.3796 $a=3.24e-16 $layer=V0LISD $X=1.566 $Y=0.0675 $X2=1.566
+ $Y2=0.036
r24 17 30 7.67296 $w=1.54395e-08 $l=4.05e-08 $layer=M1 $thickness=3.6e-08
+ $X=1.6465 $Y=0.036 $X2=1.606 $Y2=0.036
r25 17 21 8.52248 $w=1.49091e-08 $l=4.95e-08 $layer=M1 $thickness=3.6e-08
+ $X=1.6465 $Y=0.036 $X2=1.6465 $Y2=0.0855
r26 29 30 9.32759 $w=1.3e-08 $l=4e-08 $layer=M1 $thickness=3.6e-08 $X=1.566
+ $Y=0.036 $X2=1.606 $Y2=0.036
r27 28 29 12.5922 $w=1.3e-08 $l=5.4e-08 $layer=M1 $thickness=3.6e-08 $X=1.512
+ $Y=0.036 $X2=1.566 $Y2=0.036
r28 27 28 12.5922 $w=1.3e-08 $l=5.4e-08 $layer=M1 $thickness=3.6e-08 $X=1.458
+ $Y=0.036 $X2=1.512 $Y2=0.036
r29 26 27 2.3319 $w=1.3e-08 $l=1e-08 $layer=M1 $thickness=3.6e-08 $X=1.448
+ $Y=0.036 $X2=1.458 $Y2=0.036
r30 19 26 0.582974 $w=1.3e-08 $l=2.5e-09 $layer=M1 $thickness=3.6e-08 $X=1.4455
+ $Y=0.036 $X2=1.448 $Y2=0.036
r31 1 27 19.3796 $a=3.24e-16 $layer=V0LISD $X=1.458 $Y=0.0675 $X2=1.458
+ $Y2=0.036
r32 25 23 0.0308642 $w=8.1e-08 $l=2.5e-09 $layer=N_src_drn $thickness=1e-09
+ $X=1.4753 $Y=0.0675 $X2=1.4725 $Y2=0.0675
r33 1 23 0.179012 $w=8.1e-08 $l=1.45e-08 $layer=N_src_drn $thickness=1e-09
+ $X=1.458 $Y=0.0675 $X2=1.4725 $Y2=0.0675
r34 13 1 0.179012 $w=8.1e-08 $l=1.45e-08 $layer=N_src_drn $thickness=1e-09
+ $X=1.4435 $Y=0.0675 $X2=1.458 $Y2=0.0675
r35 24 13 0.0308642 $w=8.1e-08 $l=2.5e-09 $layer=N_src_drn $thickness=1e-09
+ $X=1.4406 $Y=0.0675 $X2=1.4435 $Y2=0.0675
.ends

.subckt PM_SDFHx4_ASAP7_75t_R%D vss 19 11 17 7 1 6 4 5 10 3 8 9
c1 1 vss 0.00518876f $X=0.459 $Y=0.135
c2 3 vss 0.108527f $X=0.459 $Y=0.0245
c3 4 vss 0.000832286f $X=0.387 $Y=0.108
c4 5 vss 0.00256442f $X=0.387 $Y=0.234
c5 6 vss 0.000784976f $X=0.459 $Y=0.108
c6 7 vss 0.00221805f $X=0.387 $Y=0.1405
c7 8 vss 0.00202703f $X=0.4365 $Y=0.108
c8 9 vss 0.00737656f $X=0.4095 $Y=0.234
c9 10 vss 0.000791072f $X=0.459 $Y=0.1215
r1 5 24 2.5483 $w=1.79e-08 $l=1.8e-08 $layer=M1 $thickness=3.6e-08 $X=0.387
+ $Y=0.234 $X2=0.387 $Y2=0.216
r2 5 9 3.59766 $w=1.5e-08 $l=2.25e-08 $layer=M1 $thickness=3.6e-08 $X=0.387
+ $Y=0.234 $X2=0.4095 $Y2=0.234
r3 23 24 4.19742 $w=1.3e-08 $l=1.8e-08 $layer=M1 $thickness=3.6e-08 $X=0.387
+ $Y=0.198 $X2=0.387 $Y2=0.216
r4 22 23 5.01358 $w=1.3e-08 $l=2.15e-08 $layer=M1 $thickness=3.6e-08 $X=0.387
+ $Y=0.1765 $X2=0.387 $Y2=0.198
r5 7 22 8.39483 $w=1.3e-08 $l=3.6e-08 $layer=M1 $thickness=3.6e-08 $X=0.387
+ $Y=0.1405 $X2=0.387 $Y2=0.1765
r6 4 21 3.59766 $w=1.5e-08 $l=2.25e-08 $layer=M1 $thickness=3.6e-08 $X=0.387
+ $Y=0.108 $X2=0.4095 $Y2=0.108
r7 4 7 5.92955 $w=1.57138e-08 $l=3.25e-08 $layer=M1 $thickness=3.6e-08 $X=0.387
+ $Y=0.108 $X2=0.387 $Y2=0.1405
r8 8 21 6.29612 $w=1.3e-08 $l=2.7e-08 $layer=M1 $thickness=3.6e-08 $X=0.4365
+ $Y=0.108 $X2=0.4095 $Y2=0.108
r9 6 10 1.49895 $w=1.95333e-08 $l=1.35e-08 $layer=M1 $thickness=3.6e-08
+ $X=0.459 $Y=0.108 $X2=0.459 $Y2=0.1215
r10 6 8 3.59766 $w=1.5e-08 $l=2.25e-08 $layer=M1 $thickness=3.6e-08 $X=0.459
+ $Y=0.108 $X2=0.4365 $Y2=0.108
r11 19 10 3.14806 $w=1.3e-08 $l=1.35e-08 $layer=M1 $thickness=3.6e-08 $X=0.459
+ $Y=0.1345 $X2=0.459 $Y2=0.1215
r12 1 14 10.4265 $w=1.765e-08 $layer=LIG $thickness=5.2e-08 $X=0.459 $Y=0.135
+ $X2=0.459 $Y2=0.135
r13 19 1 19.3796 $a=3.24e-16 $layer=V0LIG $X=0.459 $Y=0.1345 $X2=0.459 $Y2=0.135
r14 17 16 14.6259 $w=2.1e-08 $l=4.3e-08 $layer=Gate_1 $thickness=5.6e-08
+ $X=0.459 $Y=0.2025 $X2=0.459 $Y2=0.1595
r15 15 16 2.7211 $w=2.1e-08 $l=8e-09 $layer=Gate_1 $thickness=5.6e-08 $X=0.459
+ $Y=0.1515 $X2=0.459 $Y2=0.1595
r16 14 15 5.79936 $w=2.03333e-08 $l=1.65e-08 $layer=Gate_1 $thickness=5.6e-08
+ $X=0.459 $Y=0.135 $X2=0.459 $Y2=0.1515
r17 13 14 5.79936 $w=2.03333e-08 $l=1.65e-08 $layer=Gate_1 $thickness=5.6e-08
+ $X=0.459 $Y=0.1185 $X2=0.459 $Y2=0.135
r18 12 13 2.7211 $w=2.1e-08 $l=8e-09 $layer=Gate_1 $thickness=5.6e-08 $X=0.459
+ $Y=0.1105 $X2=0.459 $Y2=0.1185
r19 11 12 14.6259 $w=2.1e-08 $l=4.3e-08 $layer=Gate_1 $thickness=5.6e-08
+ $X=0.459 $Y=0.0675 $X2=0.459 $Y2=0.1105
r20 11 3 14.6259 $w=2.1e-08 $l=4.3e-08 $layer=Gate_1 $thickness=5.6e-08
+ $X=0.459 $Y=0.0675 $X2=0.459 $Y2=0.0245
.ends

.subckt PM_SDFHx4_ASAP7_75t_R%SE vss 30 18 24 46 49 8 12 9 13 15 14 7 11 5 1 2
+ 10 6
c1 1 vss 0.00970832f $X=0.288 $Y=0.135
c2 2 vss 0.00272633f $X=0.567 $Y=0.135
c3 5 vss 0.0940564f $X=0.297 $Y=0.0245
c4 6 vss 0.0651544f $X=0.567 $Y=0.135
c5 7 vss 0.00578816f $X=0.243 $Y=0.036
c6 8 vss 0.000363659f $X=0.243 $Y=0.135
c7 9 vss 0.00597165f $X=0.243 $Y=0.234
c8 10 vss 0.00640361f $X=0.567 $Y=0.072
c9 11 vss 0.00292709f $X=0.243 $Y=0.0585
c10 12 vss 0.00334025f $X=0.243 $Y=0.1845
c11 13 vss 0.000638594f $X=0.2615 $Y=0.135
c12 14 vss 0.00135705f $X=0.567 $Y=0.0855
c13 15 vss 0.0173704f $X=0.2315 $Y=0.081
r1 49 48 16.4967 $w=2.1e-08 $l=4.85e-08 $layer=Gate_1 $thickness=5.6e-08
+ $X=0.567 $Y=0.2025 $X2=0.567 $Y2=0.154
r2 46 47 16.4967 $w=2.1e-08 $l=4.85e-08 $layer=Gate_1 $thickness=5.6e-08
+ $X=0.567 $Y=0.0675 $X2=0.567 $Y2=0.116
r3 6 47 6.6497 $w=2.04211e-08 $l=1.9e-08 $layer=Gate_1 $thickness=5.6e-08
+ $X=0.567 $Y=0.135 $X2=0.567 $Y2=0.116
r4 6 48 6.6497 $w=2.04211e-08 $l=1.9e-08 $layer=Gate_1 $thickness=5.6e-08
+ $X=0.567 $Y=0.135 $X2=0.567 $Y2=0.154
r5 2 43 19.3796 $a=3.24e-16 $layer=V0LIG $X=0.567 $Y=0.135 $X2=0.567 $Y2=0.135
r6 2 6 10.4265 $w=1.765e-08 $layer=LIG $thickness=5.2e-08 $X=0.567 $Y=0.135
+ $X2=0.567 $Y2=0.135
r7 42 43 2.3319 $w=1.3e-08 $l=1e-08 $layer=M1 $thickness=3.6e-08 $X=0.567
+ $Y=0.125 $X2=0.567 $Y2=0.135
r8 41 42 2.3319 $w=1.3e-08 $l=1e-08 $layer=M1 $thickness=3.6e-08 $X=0.567
+ $Y=0.115 $X2=0.567 $Y2=0.125
r9 40 41 3.96423 $w=1.3e-08 $l=1.7e-08 $layer=M1 $thickness=3.6e-08 $X=0.567
+ $Y=0.098 $X2=0.567 $Y2=0.115
r10 14 40 2.91487 $w=1.3e-08 $l=1.25e-08 $layer=M1 $thickness=3.6e-08 $X=0.567
+ $Y=0.0855 $X2=0.567 $Y2=0.098
r11 14 36 39.0693 $a=1.62e-16 $layer=V1 $X=0.567 $Y=0.0855 $X2=0.567 $Y2=0.081
r12 10 36 39.0693 $a=1.62e-16 $layer=V1 $X=0.567 $Y=0.072 $X2=0.567 $Y2=0.081
r13 10 14 1.96775 $w=1.63333e-08 $l=1.35e-08 $layer=M1 $thickness=3.6e-08
+ $X=0.567 $Y=0.072 $X2=0.567 $Y2=0.0855
r14 9 12 10.3626 $w=1.39091e-08 $l=4.95e-08 $layer=M1 $thickness=3.6e-08
+ $X=0.243 $Y=0.234 $X2=0.243 $Y2=0.1845
r15 35 36 37.7767 $w=1.3e-08 $l=1.62e-07 $layer=M2 $thickness=3.6e-08 $X=0.405
+ $Y=0.081 $X2=0.567 $Y2=0.081
r16 34 35 37.7767 $w=1.3e-08 $l=1.62e-07 $layer=M2 $thickness=3.6e-08 $X=0.243
+ $Y=0.081 $X2=0.405 $Y2=0.081
r17 15 34 2.68168 $w=1.3e-08 $l=1.15e-08 $layer=M2 $thickness=3.6e-08 $X=0.2315
+ $Y=0.081 $X2=0.243 $Y2=0.081
r18 7 11 4.06646 $w=1.5e-08 $l=2.25e-08 $layer=M1 $thickness=3.6e-08 $X=0.243
+ $Y=0.036 $X2=0.243 $Y2=0.0585
r19 31 32 6.29612 $w=1.3e-08 $l=2.7e-08 $layer=M1 $thickness=3.6e-08 $X=0.243
+ $Y=0.081 $X2=0.243 $Y2=0.108
r20 31 34 19.5347 $a=3.24e-16 $layer=V1 $X=0.243 $Y=0.081 $X2=0.243 $Y2=0.081
r21 11 31 5.24677 $w=1.3e-08 $l=2.25e-08 $layer=M1 $thickness=3.6e-08 $X=0.243
+ $Y=0.0585 $X2=0.243 $Y2=0.081
r22 8 13 3.1337 $w=1.54324e-08 $l=1.85e-08 $layer=M1 $thickness=3.6e-08
+ $X=0.243 $Y=0.135 $X2=0.2615 $Y2=0.135
r23 8 32 5.11582 $w=1.46667e-08 $l=2.7e-08 $layer=M1 $thickness=3.6e-08
+ $X=0.243 $Y=0.135 $X2=0.243 $Y2=0.108
r24 8 12 10.3626 $w=1.39091e-08 $l=4.95e-08 $layer=M1 $thickness=3.6e-08
+ $X=0.243 $Y=0.135 $X2=0.243 $Y2=0.1845
r25 30 13 4.31401 $w=1.3e-08 $l=1.85e-08 $layer=M1 $thickness=3.6e-08 $X=0.278
+ $Y=0.1345 $X2=0.2615 $Y2=0.135
r26 30 28 19.3796 $a=3.24e-16 $layer=V0LIG $X=0.278 $Y=0.1345 $X2=0.279
+ $Y2=0.135
r27 1 26 2.6116 $w=2.2e-08 $l=1e-08 $layer=LIG $thickness=4.8e-08 $X=0.288
+ $Y=0.135 $X2=0.298 $Y2=0.135
r28 1 28 4.98695 $w=1.60444e-08 $l=9e-09 $layer=LIG $thickness=4.8e-08 $X=0.288
+ $Y=0.135 $X2=0.279 $Y2=0.135
r29 24 23 14.6259 $w=2.1e-08 $l=4.3e-08 $layer=Gate_1 $thickness=5.6e-08
+ $X=0.297 $Y=0.2025 $X2=0.297 $Y2=0.1595
r30 22 23 2.72111 $w=2.1e-08 $l=8e-09 $layer=Gate_1 $thickness=5.6e-08 $X=0.297
+ $Y=0.1515 $X2=0.297 $Y2=0.1595
r31 21 22 5.79936 $w=2.03333e-08 $l=1.65e-08 $layer=Gate_1 $thickness=5.6e-08
+ $X=0.297 $Y=0.135 $X2=0.297 $Y2=0.1515
r32 21 26 6.27904 $w=2.09e-08 $l=1e-09 $layer=Gate_1 $thickness=5.24e-08
+ $X=0.297 $Y=0.135 $X2=0.298 $Y2=0.135
r33 20 21 5.79936 $w=2.03333e-08 $l=1.65e-08 $layer=Gate_1 $thickness=5.6e-08
+ $X=0.297 $Y=0.1185 $X2=0.297 $Y2=0.135
r34 19 20 2.72111 $w=2.1e-08 $l=8e-09 $layer=Gate_1 $thickness=5.6e-08 $X=0.297
+ $Y=0.1105 $X2=0.297 $Y2=0.1185
r35 18 19 14.6259 $w=2.1e-08 $l=4.3e-08 $layer=Gate_1 $thickness=5.6e-08
+ $X=0.297 $Y=0.0675 $X2=0.297 $Y2=0.1105
r36 18 5 14.6259 $w=2.1e-08 $l=4.3e-08 $layer=Gate_1 $thickness=5.6e-08
+ $X=0.297 $Y=0.0675 $X2=0.297 $Y2=0.0245
.ends

* End of included file SDFHx4_ASAP7_75t_R.pex.sp.pex

*
.subckt SDFHx4_ASAP7_75t_CUSTOM_4_25_0_7 VSS VDD CLK SE D SI QN
*
* VSS VSS
* VDD VDD
* CLK CLK
* SE SE
* D D
* SI SI
* QN QN
*
*

M0 VSS N_M0_g N_M0_s VSS nmos_rvt L=2e-08 W=8.1e-08 nfin=3 $X=0.071 $Y=0.027
M1 N_M1_d N_M1_g VSS VSS nmos_rvt L=2e-08 W=8.1e-08 nfin=3 $X=0.125 $Y=0.027
M2 N_M2_d N_M2_g VSS VSS nmos_rvt L=2e-08 W=8.1e-08 nfin=3 $X=0.287 $Y=0.027
M3 noxref_20 N_M3_g noxref_14 VSS nmos_rvt L=2e-08 W=8.1e-08 nfin=3 $X=0.449
+ $Y=0.027
M4 VSS N_M4_g noxref_20 VSS nmos_rvt L=2e-08 W=8.1e-08 nfin=3 $X=0.503 $Y=0.027
M5 noxref_21 N_M5_g VSS VSS nmos_rvt L=2e-08 W=8.1e-08 nfin=3 $X=0.557 $Y=0.027
M6 noxref_14 N_M6_g noxref_21 VSS nmos_rvt L=2e-08 W=8.1e-08 nfin=3 $X=0.611
+ $Y=0.027
M7 N_M7_d N_M7_g noxref_14 VSS nmos_rvt L=2e-08 W=8.1e-08 nfin=3 $X=0.665
+ $Y=0.027
M8 N_M8_d N_M8_g N_M8_s VSS nmos_rvt L=2e-08 W=8.1e-08 nfin=3 $X=0.773 $Y=0.027
M9 VSS N_M9_g N_M9_s VSS nmos_rvt L=2e-08 W=8.1e-08 nfin=3 $X=0.881 $Y=0.027
M10 N_M10_d N_M10_g VSS VSS nmos_rvt L=2e-08 W=8.1e-08 nfin=3 $X=0.935 $Y=0.027
M11 N_M11_d N_M11_g N_M11_s VSS nmos_rvt L=2e-08 W=8.1e-08 nfin=3 $X=1.097
+ $Y=0.027
M12 N_M12_d N_M12_g N_M12_s VSS nmos_rvt L=2e-08 W=8.1e-08 nfin=3 $X=1.151
+ $Y=0.027
M13 VSS N_M13_g N_M13_s VSS nmos_rvt L=2e-08 W=8.1e-08 nfin=3 $X=1.205 $Y=0.027
M14 N_M14_d N_M14_g VSS VSS nmos_rvt L=2e-08 W=8.1e-08 nfin=3 $X=1.259 $Y=0.027
M15 N_M15_d N_M15_g VSS VSS nmos_rvt L=2e-08 W=8.1e-08 nfin=3 $X=1.421 $Y=0.027
M16 N_M16_d N_M16_g VSS VSS nmos_rvt L=2e-08 W=8.1e-08 nfin=3 $X=1.475 $Y=0.027
M17 N_M17_d N_M17_g VSS VSS nmos_rvt L=2e-08 W=8.1e-08 nfin=3 $X=1.529 $Y=0.027
M18 N_M18_d N_M18_g VSS VSS nmos_rvt L=2e-08 W=8.1e-08 nfin=3 $X=1.583 $Y=0.027
M19 VDD N_M19_g N_M19_s VDD pmos_rvt L=2e-08 W=8.1e-08 nfin=3 $X=0.071 $Y=0.162
M20 N_M20_d N_M20_g VDD VDD pmos_rvt L=2e-08 W=8.1e-08 nfin=3 $X=0.125 $Y=0.162
M21 N_M21_d N_M21_g VDD VDD pmos_rvt L=2e-08 W=8.1e-08 nfin=3 $X=0.287 $Y=0.162
M22 VDD N_M22_g N_M22_s VDD pmos_rvt L=2e-08 W=8.1e-08 nfin=3 $X=0.449 $Y=0.162
M23 N_M23_d N_M23_g VDD VDD pmos_rvt L=2e-08 W=8.1e-08 nfin=3 $X=0.503 $Y=0.162
M24 N_M24_d N_M24_g N_M24_s VDD pmos_rvt L=2e-08 W=8.1e-08 nfin=3 $X=0.557
+ $Y=0.162
M25 N_M25_d N_M25_g N_M25_s VDD pmos_rvt L=2e-08 W=8.1e-08 nfin=3 $X=0.611
+ $Y=0.162
M26 N_M26_d N_M26_g N_M26_s VDD pmos_rvt L=2e-08 W=8.1e-08 nfin=3 $X=0.773
+ $Y=0.162
M27 N_M27_d N_M27_g N_M27_s VDD pmos_rvt L=2e-08 W=8.1e-08 nfin=3 $X=0.827
+ $Y=0.162
M28 VDD N_M28_g N_M28_s VDD pmos_rvt L=2e-08 W=8.1e-08 nfin=3 $X=0.881 $Y=0.162
M29 N_M29_d N_M29_g VDD VDD pmos_rvt L=2e-08 W=8.1e-08 nfin=3 $X=0.935 $Y=0.162
M30 N_M30_d N_M30_g N_M30_s VDD pmos_rvt L=2e-08 W=8.1e-08 nfin=3 $X=1.043
+ $Y=0.162
M31 N_M31_d N_M31_g N_M31_s VDD pmos_rvt L=2e-08 W=8.1e-08 nfin=3 $X=1.097
+ $Y=0.162
M32 VDD N_M32_g N_M32_s VDD pmos_rvt L=2e-08 W=8.1e-08 nfin=3 $X=1.205 $Y=0.162
M33 N_M33_d N_M33_g VDD VDD pmos_rvt L=2e-08 W=8.1e-08 nfin=3 $X=1.259 $Y=0.162
M34 N_M34_d N_M34_g VDD VDD pmos_rvt L=2e-08 W=8.1e-08 nfin=3 $X=1.421 $Y=0.162
M35 N_M35_d N_M35_g VDD VDD pmos_rvt L=2e-08 W=8.1e-08 nfin=3 $X=1.475 $Y=0.162
M36 N_M36_d N_M36_g VDD VDD pmos_rvt L=2e-08 W=8.1e-08 nfin=3 $X=1.529 $Y=0.162
M37 N_M37_d N_M37_g VDD VDD pmos_rvt L=2e-08 W=8.1e-08 nfin=3 $X=1.583 $Y=0.162

* .include "SDFHx4_ASAP7_75t_R.pex.sp.pxi"

* Start of included file SDFHx4_ASAP7_75t_R.pex.sp.pxi
x_PM_SDFHx4_ASAP7_75t_R%CLK vss CLK N_M0_g N_M19_g N_CLK_3 N_CLK_5 N_CLK_1
+ N_CLK_4 PM_SDFHx4_ASAP7_75t_R%CLK
x_PM_SDFHx4_ASAP7_75t_R%7 vss N_M4_g N_M23_g N_M2_d N_M21_d N_7_19 N_7_13
+ N_7_10 N_7_14 N_7_11 N_7_4 N_7_1 N_7_3 N_7_15 N_7_12 N_7_17 N_7_9 N_7_18
+ PM_SDFHx4_ASAP7_75t_R%7
cc_1 N_7_19 N_4_36 0.00126159f $X=0.513 $Y=0.1125
cc_2 N_7_13 N_4_36 0.0027344f $X=0.351 $Y=0.234
cc_3 N_7_10 N_SE_7 0.000182219f $X=0.3095 $Y=0.0675
cc_4 N_7_10 N_SE_15 0.000267243f $X=0.3095 $Y=0.0675
cc_5 N_7_10 N_SE_11 0.000291515f $X=0.3095 $Y=0.0675
cc_6 N_7_10 N_SE_12 0.00034554f $X=0.3095 $Y=0.0675
cc_7 N_7_14 N_SE_15 0.000365159f $X=0.351 $Y=0.072
cc_8 N_7_11 N_SE_5 0.0152572f $X=0.3095 $Y=0.2025
cc_9 N_7_4 N_SE_1 0.000554258f $X=0.324 $Y=0.2025
cc_10 N_7_1 N_SE_2 0.00165903f $X=0.513 $Y=0.135
cc_11 N_7_13 N_SE_9 0.000909643f $X=0.351 $Y=0.234
cc_12 N_7_4 N_SE_5 0.000976573f $X=0.324 $Y=0.2025
cc_13 N_7_3 N_SE_5 0.00100021f $X=0.324 $Y=0.0675
cc_14 N_7_15 N_SE_10 0.00113729f $X=0.513 $Y=0.072
cc_15 N_7_12 N_SE_7 0.00128313f $X=0.351 $Y=0.036
cc_16 N_7_17 N_SE_13 0.00187562f $X=0.351 $Y=0.09
cc_17 N_7_10 N_SE_1 0.00211007f $X=0.3095 $Y=0.0675
cc_18 N_7_19 N_SE_14 0.00262482f $X=0.513 $Y=0.1125
cc_19 N_7_9 N_SE_6 0.00315808f $X=0.513 $Y=0.0245
cc_20 N_7_18 N_SE_15 0.00399922f $X=0.486 $Y=0.072
cc_21 N_7_10 N_SE_5 0.0538179f $X=0.3095 $Y=0.0675
cc_22 N_7_1 N_D_1 0.00127839f $X=0.513 $Y=0.135
cc_23 N_7_18 N_D_6 0.00128032f $X=0.486 $Y=0.072
cc_24 N_7_18 N_D_4 0.00145923f $X=0.486 $Y=0.072
cc_25 N_7_13 N_D_5 0.00149539f $X=0.351 $Y=0.234
cc_26 N_7_19 N_D_10 0.00153398f $X=0.513 $Y=0.1125
cc_27 N_7_9 N_D_3 0.00508604f $X=0.513 $Y=0.0245
cc_28 N_7_18 N_D_8 0.00526203f $X=0.486 $Y=0.072
cc_29 N_7_17 N_D_7 0.00981215f $X=0.351 $Y=0.09
x_PM_SDFHx4_ASAP7_75t_R%SI vss SI N_M6_g N_M25_g N_SI_3 N_SI_1 N_SI_4 N_SI_8
+ N_SI_12 N_SI_7 PM_SDFHx4_ASAP7_75t_R%SI
cc_30 N_SI_3 N_4_32 0.00109026f $X=0.621 $Y=0.0245
cc_31 N_SI_3 N_4_36 0.000103004f $X=0.621 $Y=0.0245
cc_32 N_SI_3 N_4_33 0.000120157f $X=0.621 $Y=0.0245
cc_33 N_SI_1 N_4_2 0.00164804f $X=0.621 $Y=0.135
cc_34 N_SI_4 N_4_2 0.000514131f $X=0.621 $Y=0.115
cc_35 N_SI_8 N_4_36 0.0013681f $X=0.621 $Y=0.125
cc_36 N_SI_4 N_4_32 0.00184482f $X=0.621 $Y=0.115
cc_37 N_SI_3 N_4_18 0.00327117f $X=0.621 $Y=0.0245
cc_38 N_SI_3 N_SE_10 0.000322625f $X=0.621 $Y=0.0245
cc_39 N_SI_3 N_SE_14 0.000612577f $X=0.621 $Y=0.0245
cc_40 N_SI_1 N_SE_2 0.00200318f $X=0.621 $Y=0.135
cc_41 N_SI_4 N_SE_10 0.00148224f $X=0.621 $Y=0.115
cc_42 N_SI_4 N_SE_14 0.00151479f $X=0.621 $Y=0.115
cc_43 N_SI_3 N_SE_6 0.00548036f $X=0.621 $Y=0.0245
x_PM_SDFHx4_ASAP7_75t_R%15 vss N_M22_s N_M23_d N_M24_s N_M25_d N_15_12 N_15_3
+ N_15_13 N_15_11 N_15_2 N_15_1 N_15_10 PM_SDFHx4_ASAP7_75t_R%15
cc_44 N_15_12 N_4_32 0.000760236f $X=0.6335 $Y=0.2025
cc_45 N_15_12 N_4_2 0.00107736f $X=0.6335 $Y=0.2025
cc_46 N_15_3 N_4_18 0.00106902f $X=0.648 $Y=0.2025
cc_47 N_15_13 N_4_36 0.00389707f $X=0.432 $Y=0.198
cc_48 N_15_12 N_4_18 0.0362155f $X=0.6335 $Y=0.2025
cc_49 N_15_11 N_SE_2 0.000710382f $X=0.5255 $Y=0.2025
cc_50 N_15_2 N_SE_6 0.000757917f $X=0.54 $Y=0.2025
cc_51 N_15_13 N_SE_14 0.00208738f $X=0.432 $Y=0.198
cc_52 N_15_11 N_SE_6 0.0335802f $X=0.5255 $Y=0.2025
cc_53 N_15_1 N_D_9 0.00109692f $X=0.432 $Y=0.2025
cc_54 N_15_13 N_D_7 0.00122314f $X=0.432 $Y=0.198
cc_55 N_15_1 N_D_3 0.00185821f $X=0.432 $Y=0.2025
cc_56 N_15_13 N_D_9 0.00222023f $X=0.432 $Y=0.198
cc_57 N_15_13 N_D_10 0.00450662f $X=0.432 $Y=0.198
cc_58 N_15_10 N_D_3 0.0348764f $X=0.434 $Y=0.2025
cc_59 N_15_1 N_7_18 0.00045984f $X=0.432 $Y=0.2025
cc_60 N_15_11 N_7_1 0.000680877f $X=0.5255 $Y=0.2025
cc_61 N_15_2 N_7_9 0.000794729f $X=0.54 $Y=0.2025
cc_62 N_15_13 N_7_19 0.00225146f $X=0.432 $Y=0.198
cc_63 N_15_11 N_7_9 0.0346506f $X=0.5255 $Y=0.2025
cc_64 N_15_12 N_SI_1 0.000700285f $X=0.6335 $Y=0.2025
cc_65 N_15_3 N_SI_3 0.000817119f $X=0.648 $Y=0.2025
cc_66 N_15_13 N_SI_8 0.0020947f $X=0.432 $Y=0.198
cc_67 N_15_12 N_SI_3 0.0340147f $X=0.6335 $Y=0.2025
x_PM_SDFHx4_ASAP7_75t_R%16 vss N_M24_d N_M25_s N_M26_s N_16_9 N_16_7 N_16_1
+ N_16_8 N_16_2 PM_SDFHx4_ASAP7_75t_R%16
cc_68 N_16_9 N_4_2 0.000547252f $X=0.5825 $Y=0.234
cc_69 N_16_9 N_4_18 0.000432486f $X=0.5825 $Y=0.234
cc_70 N_16_9 N_4_36 0.000501296f $X=0.5825 $Y=0.234
cc_71 N_16_9 N_4_32 0.00169365f $X=0.5825 $Y=0.234
cc_72 N_16_7 N_SE_2 0.000686564f $X=0.5795 $Y=0.2025
cc_73 N_16_1 N_SE_6 0.000774408f $X=0.594 $Y=0.2025
cc_74 N_16_7 N_SE_6 0.0336968f $X=0.5795 $Y=0.2025
cc_75 N_16_1 N_SI_3 0.00077341f $X=0.594 $Y=0.2025
cc_76 N_16_7 N_SI_3 0.0344155f $X=0.5795 $Y=0.2025
cc_77 N_16_8 N_9_1 0.000868965f $X=0.758 $Y=0.2025
cc_78 N_16_8 N_9_21 0.000239772f $X=0.758 $Y=0.2025
cc_79 N_16_2 N_9_11 0.000724758f $X=0.756 $Y=0.2025
cc_80 N_16_8 N_9_11 0.0332722f $X=0.758 $Y=0.2025
cc_81 N_16_8 N_11_13 0.00129101f $X=0.758 $Y=0.2025
cc_82 N_16_2 N_11_18 0.000611629f $X=0.756 $Y=0.2025
cc_83 N_16_2 N_11_14 0.000624447f $X=0.756 $Y=0.2025
cc_84 N_16_9 N_11_19 0.00101371f $X=0.5825 $Y=0.234
cc_85 N_16_9 N_11_14 0.00328675f $X=0.5825 $Y=0.234
cc_86 N_16_2 N_11_4 0.00445292f $X=0.756 $Y=0.2025
cc_87 N_16_7 N_15_12 0.000642593f $X=0.5795 $Y=0.2025
cc_88 N_16_1 N_15_13 0.000833124f $X=0.594 $Y=0.2025
cc_89 N_16_7 N_15_11 0.00119124f $X=0.5795 $Y=0.2025
cc_90 N_16_1 N_15_3 0.00177057f $X=0.594 $Y=0.2025
cc_91 N_16_1 N_15_2 0.00394902f $X=0.594 $Y=0.2025
cc_92 N_16_9 N_15_13 0.00978164f $X=0.5825 $Y=0.234
x_PM_SDFHx4_ASAP7_75t_R%11 vss N_M10_g N_M29_g N_M26_d N_M27_s N_M7_d N_M8_s
+ N_11_13 N_11_22 N_11_15 N_11_14 N_11_4 N_11_11 N_11_19 N_11_3 N_11_21 N_11_18
+ N_11_12 N_11_10 N_11_1 PM_SDFHx4_ASAP7_75t_R%11
cc_93 N_11_13 N_4_4 6.70929e-20 $X=0.7955 $Y=0.2025
cc_94 N_11_13 N_4_36 0.000319127f $X=0.7955 $Y=0.2025
cc_95 N_11_13 N_4_33 0.000458015f $X=0.7955 $Y=0.2025
cc_96 N_11_13 N_4_32 0.000435404f $X=0.7955 $Y=0.2025
cc_97 N_11_22 N_4_34 0.000265519f $X=0.945 $Y=0.116
cc_98 N_11_15 N_4_33 0.00104804f $X=0.81 $Y=0.198
cc_99 N_11_14 N_4_32 0.000364367f $X=0.747 $Y=0.198
cc_100 N_11_4 N_4_3 0.000386391f $X=0.81 $Y=0.2025
cc_101 N_11_11 N_4_18 0.034778f $X=0.6875 $Y=0.0675
cc_102 N_11_19 N_4_33 0.000535217f $X=0.7965 $Y=0.198
cc_103 N_11_3 N_4_2 0.000663302f $X=0.729 $Y=0.0675
cc_104 N_11_13 N_4_3 0.000825252f $X=0.7955 $Y=0.2025
cc_105 N_11_21 N_4_33 0.000840352f $X=0.918 $Y=0.234
cc_106 N_11_18 N_4_36 0.000923662f $X=0.747 $Y=0.178
cc_107 N_11_4 N_4_33 0.00111699f $X=0.81 $Y=0.2025
cc_108 N_11_4 N_4_19 0.00122271f $X=0.81 $Y=0.2025
cc_109 N_11_3 N_4_18 0.0013661f $X=0.729 $Y=0.0675
cc_110 N_11_11 N_4_2 0.00177138f $X=0.6875 $Y=0.0675
cc_111 N_11_18 N_4_32 0.00299041f $X=0.747 $Y=0.178
cc_112 N_11_22 N_4_36 0.003487f $X=0.945 $Y=0.116
cc_113 N_11_13 N_4_19 0.0349416f $X=0.7955 $Y=0.2025
cc_114 N_11_18 N_SI_12 0.00140435f $X=0.747 $Y=0.178
cc_115 N_11_3 N_SI_7 0.00188764f $X=0.729 $Y=0.0675
cc_116 N_11_18 N_SI_7 0.00399254f $X=0.747 $Y=0.178
cc_117 N_11_13 N_9_19 0.00100363f $X=0.7955 $Y=0.2025
cc_118 N_11_12 N_9_11 0.0153099f $X=0.758 $Y=0.0675
cc_119 N_11_19 N_9_19 0.000641316f $X=0.7965 $Y=0.198
cc_120 N_11_4 N_9_11 0.000851182f $X=0.81 $Y=0.2025
cc_121 N_11_18 N_9_1 0.000893448f $X=0.747 $Y=0.178
cc_122 N_11_3 N_9_11 0.00118874f $X=0.729 $Y=0.0675
cc_123 N_11_12 N_9_1 0.00156248f $X=0.758 $Y=0.0675
cc_124 N_11_22 N_9_21 0.00214986f $X=0.945 $Y=0.116
cc_125 N_11_18 N_9_19 0.00768783f $X=0.747 $Y=0.178
cc_126 N_11_13 N_9_11 0.0532861f $X=0.7955 $Y=0.2025
cc_127 N_11_10 N_10_12 0.0150993f $X=0.945 $Y=0.0245
cc_128 N_11_21 N_10_17 0.000462111f $X=0.918 $Y=0.234
cc_129 N_11_1 N_10_1 0.00114641f $X=0.945 $Y=0.135
cc_130 N_11_10 N_10_3 0.00077451f $X=0.945 $Y=0.0245
cc_131 N_11_22 N_10_18 0.000951766f $X=0.945 $Y=0.116
cc_132 N_11_1 N_10_5 0.0023531f $X=0.945 $Y=0.135
cc_133 N_11_10 N_10_4 0.00172693f $X=0.945 $Y=0.0245
cc_134 N_11_10 N_10_11 0.00190267f $X=0.945 $Y=0.0245
cc_135 N_11_1 N_10_12 0.00251899f $X=0.945 $Y=0.135
cc_136 N_11_22 N_10_17 0.00509647f $X=0.945 $Y=0.116
cc_137 N_11_10 N_10_14 0.0554477f $X=0.945 $Y=0.0245
x_PM_SDFHx4_ASAP7_75t_R%22 vss N_M12_d N_M13_s N_22_1 PM_SDFHx4_ASAP7_75t_R%22
cc_138 N_22_1 N_4_21 0.0168266f $X=1.188 $Y=0.0675
cc_139 N_22_1 N_12_9 0.0166598f $X=1.188 $Y=0.0675
x_PM_SDFHx4_ASAP7_75t_R%18 vss N_M8_d N_M9_s N_18_4 N_18_5 N_18_1
+ PM_SDFHx4_ASAP7_75t_R%18
cc_140 N_18_4 N_4_3 0.00181927f $X=0.7955 $Y=0.0675
cc_141 N_18_4 N_4_33 0.00101461f $X=0.7955 $Y=0.0675
cc_142 N_18_4 N_4_19 0.0731325f $X=0.7955 $Y=0.0675
cc_143 N_18_4 N_9_19 0.000440115f $X=0.7955 $Y=0.0675
cc_144 N_18_4 N_9_1 0.000619788f $X=0.7955 $Y=0.0675
cc_145 N_18_4 N_9_11 0.0339841f $X=0.7955 $Y=0.0675
cc_146 N_18_5 N_10_1 0.000666419f $X=0.866 $Y=0.0675
cc_147 N_18_5 N_10_11 0.0349069f $X=0.866 $Y=0.0675
cc_148 N_18_1 N_11_3 0.00107264f $X=0.837 $Y=0.0675
cc_149 N_18_1 N_11_12 0.00264456f $X=0.837 $Y=0.0675
x_PM_SDFHx4_ASAP7_75t_R%19 vss N_M31_d N_M32_s N_19_4 N_19_5 N_19_1
+ PM_SDFHx4_ASAP7_75t_R%19
cc_150 N_19_4 N_4_5 0.00181808f $X=1.1195 $Y=0.2025
cc_151 N_19_4 N_4_35 0.000904634f $X=1.1195 $Y=0.2025
cc_152 N_19_4 N_4_21 0.0733769f $X=1.1195 $Y=0.2025
cc_153 N_19_4 N_9_20 0.000191653f $X=1.1195 $Y=0.2025
cc_154 N_19_4 N_9_2 0.000621942f $X=1.1195 $Y=0.2025
cc_155 N_19_4 N_9_12 0.0340038f $X=1.1195 $Y=0.2025
cc_156 N_19_5 N_12_9 0.0351515f $X=1.19 $Y=0.2025
cc_157 N_19_1 N_13_17 0.00115308f $X=1.161 $Y=0.2025
cc_158 N_19_1 N_13_5 0.00104995f $X=1.161 $Y=0.2025
cc_159 N_19_1 N_13_23 0.00431333f $X=1.161 $Y=0.2025
x_PM_SDFHx4_ASAP7_75t_R%12 vss N_M13_g N_M32_g N_M33_d N_M14_d N_12_9 N_12_1
+ N_12_15 N_12_10 N_12_17 N_12_4 N_12_3 N_12_14 N_12_13 N_12_11 N_12_16 N_12_12
+ PM_SDFHx4_ASAP7_75t_R%12
cc_160 N_12_9 N_4_35 0.000955221f $X=1.215 $Y=0.0245
cc_161 N_12_9 N_4_36 0.000428573f $X=1.215 $Y=0.0245
cc_162 N_12_9 N_4_5 0.000721058f $X=1.215 $Y=0.0245
cc_163 N_12_1 N_4_5 0.00128123f $X=1.215 $Y=0.135
cc_164 N_12_15 N_4_35 0.00310116f $X=1.215 $Y=0.135
cc_165 N_12_9 N_4_21 0.00506687f $X=1.215 $Y=0.0245
x_PM_SDFHx4_ASAP7_75t_R%9 vss N_M11_g N_M31_g N_M8_g N_M26_g N_M20_d N_M1_d
+ N_9_18 N_9_5 N_9_6 N_9_17 N_9_21 N_9_15 N_9_14 N_9_1 N_9_20 N_9_2 N_9_13
+ N_9_19 N_9_12 N_9_11 N_9_16 PM_SDFHx4_ASAP7_75t_R%9
cc_166 N_9_18 N_CLK_4 0.000225291f $X=0.189 $Y=0.0935
cc_167 N_9_5 N_CLK_4 0.000101081f $X=0.162 $Y=0.0675
cc_168 N_9_6 N_CLK_4 0.000304016f $X=0.162 $Y=0.2025
cc_169 N_9_17 N_CLK_4 0.00135695f $X=0.1505 $Y=0.036
cc_170 N_9_21 N_4_11 4.3048e-20 $X=0.6775 $Y=0.117
cc_171 N_9_21 N_4_2 5.23191e-20 $X=0.6775 $Y=0.117
cc_172 N_9_21 N_4_31 5.28132e-20 $X=0.6775 $Y=0.117
cc_173 N_9_17 N_4_11 6.68758e-20 $X=0.1505 $Y=0.036
cc_174 N_9_15 N_4_12 6.9712e-20 $X=0.189 $Y=0.234
cc_175 N_9_17 N_4_27 7.32731e-20 $X=0.1505 $Y=0.036
cc_176 N_9_15 N_4_30 7.39731e-20 $X=0.189 $Y=0.234
cc_177 N_9_14 N_4_12 8.15668e-20 $X=0.1475 $Y=0.2025
cc_178 N_9_1 N_4_2 9.9183e-20 $X=0.783 $Y=0.135
cc_179 N_9_5 N_4_17 0.00125186f $X=0.162 $Y=0.0675
cc_180 N_9_20 N_4_35 0.0016758f $X=1.107 $Y=0.107
cc_181 N_9_6 N_4_31 0.000260169f $X=0.162 $Y=0.2025
cc_182 N_9_2 N_4_5 0.00191258f $X=1.107 $Y=0.135
cc_183 N_9_18 N_4_31 0.00632107f $X=0.189 $Y=0.0935
cc_184 N_9_21 N_4_32 0.00082279f $X=0.6775 $Y=0.117
cc_185 N_9_13 N_4_17 0.0153197f $X=0.1475 $Y=0.0675
cc_186 N_9_14 N_4_17 0.0534508f $X=0.1475 $Y=0.2025
cc_187 N_9_21 N_4_33 0.000510237f $X=0.6775 $Y=0.117
cc_188 N_9_21 N_4_34 0.000531995f $X=0.6775 $Y=0.117
cc_189 N_9_2 N_4_4 0.00162095f $X=1.107 $Y=0.135
cc_190 N_9_19 N_4_36 0.000564931f $X=0.783 $Y=0.089
cc_191 N_9_18 N_4_36 0.000621599f $X=0.189 $Y=0.0935
cc_192 N_9_6 N_4_1 0.000739681f $X=0.162 $Y=0.2025
cc_193 N_9_20 N_4_36 0.000779872f $X=1.107 $Y=0.107
cc_194 N_9_1 N_4_3 0.00190267f $X=0.783 $Y=0.135
cc_195 N_9_17 N_4_29 0.000858039f $X=0.1505 $Y=0.036
cc_196 N_9_15 N_4_31 0.000890804f $X=0.189 $Y=0.234
cc_197 N_9_6 N_4_17 0.0013224f $X=0.162 $Y=0.2025
cc_198 N_9_12 N_4_20 0.00142792f $X=1.107 $Y=0.0245
cc_199 N_9_14 N_4_1 0.00164263f $X=0.1475 $Y=0.2025
cc_200 N_9_11 N_4_19 0.00327086f $X=0.783 $Y=0.135
cc_201 N_9_19 N_4_33 0.00393973f $X=0.783 $Y=0.089
cc_202 N_9_12 N_4_21 0.00483705f $X=1.107 $Y=0.0245
cc_203 N_9_20 N_4_34 0.00508182f $X=1.107 $Y=0.107
cc_204 N_9_21 N_4_36 0.0683097f $X=0.6775 $Y=0.117
cc_205 N_9_17 N_SE_15 0.000164255f $X=0.1505 $Y=0.036
cc_206 N_9_6 N_SE_12 0.000195485f $X=0.162 $Y=0.2025
cc_207 N_9_5 N_SE_11 0.000215521f $X=0.162 $Y=0.0675
cc_208 N_9_18 N_SE_11 0.00217335f $X=0.189 $Y=0.0935
cc_209 N_9_21 N_SE_10 0.000418561f $X=0.6775 $Y=0.117
cc_210 N_9_21 N_SE_13 0.000450966f $X=0.6775 $Y=0.117
cc_211 N_9_21 N_SE_14 0.00050645f $X=0.6775 $Y=0.117
cc_212 N_9_21 N_SE_11 0.000678794f $X=0.6775 $Y=0.117
cc_213 N_9_15 N_SE_9 0.000794396f $X=0.189 $Y=0.234
cc_214 N_9_16 N_SE_7 0.000889737f $X=0.189 $Y=0.036
cc_215 N_9_18 N_SE_12 0.00162266f $X=0.189 $Y=0.0935
cc_216 N_9_18 N_SE_8 0.00379138f $X=0.189 $Y=0.0935
cc_217 N_9_21 N_SE_15 0.026449f $X=0.6775 $Y=0.117
cc_218 N_9_21 N_D_8 0.00246042f $X=0.6775 $Y=0.117
cc_219 N_9_21 N_SI_12 0.000925651f $X=0.6775 $Y=0.117
cc_220 N_9_19 N_SI_12 0.0011241f $X=0.783 $Y=0.089
cc_221 N_9_21 N_SI_4 0.00262231f $X=0.6775 $Y=0.117
x_PM_SDFHx4_ASAP7_75t_R%4 vss N_M12_g N_M7_g N_M27_g N_M30_g N_M1_g N_M20_g
+ N_M0_s N_M19_s N_4_12 N_4_31 N_4_11 N_4_25 N_4_1 N_4_28 N_4_23 N_4_30 N_4_27
+ N_4_36 N_4_17 N_4_29 N_4_22 N_4_32 N_4_33 N_4_2 N_4_18 N_4_35 N_4_5 N_4_34
+ N_4_4 N_4_3 N_4_20 N_4_19 N_4_21 PM_SDFHx4_ASAP7_75t_R%4
cc_222 N_4_12 N_CLK_3 0.00141196f $X=0.054 $Y=0.2025
cc_223 N_4_31 N_CLK_3 0.000198263f $X=0.135 $Y=0.116
cc_224 N_4_11 N_CLK_3 0.00152084f $X=0.054 $Y=0.0675
cc_225 N_4_25 N_CLK_3 0.000270594f $X=0.0165 $Y=0.153
cc_226 N_4_1 N_CLK_3 0.000958952f $X=0.135 $Y=0.135
cc_227 N_4_28 N_CLK_3 0.000414972f $X=0.018 $Y=0.181
cc_228 N_4_23 N_CLK_3 0.0153056f $X=0.056 $Y=0.2025
cc_229 N_4_30 N_CLK_3 0.000437902f $X=0.036 $Y=0.234
cc_230 N_4_27 N_CLK_3 0.000923189f $X=0.018 $Y=0.1125
cc_231 N_4_36 N_CLK_5 0.00110867f $X=1.1365 $Y=0.153
cc_232 N_4_12 N_CLK_1 0.00117907f $X=0.054 $Y=0.2025
cc_233 N_4_17 N_CLK_3 0.00168357f $X=0.135 $Y=0.135
cc_234 N_4_31 N_CLK_5 0.00181287f $X=0.135 $Y=0.116
cc_235 N_4_23 N_CLK_1 0.00219383f $X=0.056 $Y=0.2025
cc_236 N_4_29 N_CLK_4 0.00373205f $X=0.036 $Y=0.036
cc_237 N_4_25 N_CLK_5 0.00711619f $X=0.0165 $Y=0.153
cc_238 N_4_22 N_CLK_3 0.0552203f $X=0.056 $Y=0.0675
x_PM_SDFHx4_ASAP7_75t_R%23 vss N_M27_d N_M28_s N_23_1 PM_SDFHx4_ASAP7_75t_R%23
cc_239 N_23_1 N_4_19 0.0168396f $X=0.864 $Y=0.2025
cc_240 N_23_1 N_10_11 0.0166674f $X=0.864 $Y=0.2025
x_PM_SDFHx4_ASAP7_75t_R%10 vss N_M9_g N_M28_g N_M10_d N_M11_s N_M29_d N_M30_s
+ N_10_15 N_10_1 N_10_13 N_10_3 N_10_18 N_10_5 N_10_4 N_10_17 N_10_11 N_10_12
+ N_10_14 PM_SDFHx4_ASAP7_75t_R%10
cc_241 N_10_15 N_4_34 8.65351e-20 $X=1.028 $Y=0.2025
cc_242 N_10_15 N_4_33 0.000564373f $X=1.028 $Y=0.2025
cc_243 N_10_1 N_4_3 0.00200033f $X=0.891 $Y=0.135
cc_244 N_10_13 N_4_20 0.0172229f $X=1.082 $Y=0.0675
cc_245 N_10_3 N_4_4 0.00352809f $X=0.968 $Y=0.0675
cc_246 N_10_18 N_4_36 0.00108936f $X=0.918 $Y=0.072
cc_247 N_10_5 N_4_4 0.00131462f $X=0.9985 $Y=0.135
cc_248 N_10_4 N_4_20 0.00152799f $X=0.999 $Y=0.2025
cc_249 N_10_4 N_4_34 0.00158567f $X=0.999 $Y=0.2025
cc_250 N_10_17 N_4_33 0.00344182f $X=0.891 $Y=0.116
cc_251 N_10_3 N_4_20 0.00402483f $X=0.968 $Y=0.0675
cc_252 N_10_11 N_4_19 0.00493589f $X=0.891 $Y=0.0245
cc_253 N_10_15 N_4_20 0.0557144f $X=1.028 $Y=0.2025
cc_254 N_10_13 N_9_19 0.000152205f $X=1.082 $Y=0.0675
cc_255 N_10_13 N_9_2 0.00101272f $X=1.082 $Y=0.0675
cc_256 N_10_13 N_9_21 0.000269665f $X=1.082 $Y=0.0675
cc_257 N_10_3 N_9_20 0.000706825f $X=0.968 $Y=0.0675
cc_258 N_10_18 N_9_21 0.000891142f $X=0.918 $Y=0.072
cc_259 N_10_3 N_9_12 0.00135855f $X=0.968 $Y=0.0675
cc_260 N_10_17 N_9_21 0.00258873f $X=0.891 $Y=0.116
cc_261 N_10_13 N_9_12 0.0346058f $X=1.082 $Y=0.0675
x_PM_SDFHx4_ASAP7_75t_R%13 vss N_M14_g N_M33_g N_M11_d N_M12_s N_M15_g N_M34_g
+ N_M16_g N_M35_g N_M17_g N_M36_g N_M18_g N_M37_g N_M30_d N_M31_s N_13_16
+ N_13_6 N_13_28 N_13_23 N_13_25 N_13_5 N_13_19 N_13_17 N_13_24 N_13_21 N_13_1
+ N_13_11 N_13_26 N_13_27 N_13_20 N_13_22 N_13_2 N_13_14 N_13_13 N_13_29
+ N_13_15 N_13_12 PM_SDFHx4_ASAP7_75t_R%13
cc_262 N_13_16 N_4_35 0.000255179f $X=1.1195 $Y=0.0675
cc_263 N_13_6 N_4_21 0.00131998f $X=1.134 $Y=0.0675
cc_264 N_13_28 N_4_35 0.000148114f $X=1.377 $Y=0.172
cc_265 N_13_23 N_4_35 0.00276868f $X=1.35 $Y=0.234
cc_266 N_13_25 N_4_35 0.000193201f $X=1.251 $Y=0.116
cc_267 N_13_5 N_4_4 0.000212749f $X=1.08 $Y=0.2025
cc_268 N_13_19 N_4_35 0.000237145f $X=1.251 $Y=0.135
cc_269 N_13_5 N_4_34 0.00136231f $X=1.08 $Y=0.2025
cc_270 N_13_6 N_4_5 0.000386391f $X=1.134 $Y=0.0675
cc_271 N_13_17 N_4_20 0.0343744f $X=1.0655 $Y=0.2025
cc_272 N_13_17 N_4_4 0.000655234f $X=1.0655 $Y=0.2025
cc_273 N_13_24 N_4_35 0.00066648f $X=1.233 $Y=0.036
cc_274 N_13_16 N_4_5 0.000825508f $X=1.1195 $Y=0.0675
cc_275 N_13_23 N_4_36 0.000944313f $X=1.35 $Y=0.234
cc_276 N_13_5 N_4_20 0.00131406f $X=1.08 $Y=0.2025
cc_277 N_13_6 N_4_35 0.0019318f $X=1.134 $Y=0.0675
cc_278 N_13_16 N_4_21 0.0349533f $X=1.1195 $Y=0.0675
cc_279 N_13_16 N_9_20 9.87103e-20 $X=1.1195 $Y=0.0675
cc_280 N_13_6 N_9_20 0.0019167f $X=1.134 $Y=0.0675
cc_281 N_13_23 N_9_20 0.000378937f $X=1.35 $Y=0.234
cc_282 N_13_23 N_9_21 0.000386322f $X=1.35 $Y=0.234
cc_283 N_13_5 N_9_2 0.000438555f $X=1.08 $Y=0.2025
cc_284 N_13_17 N_9_12 0.0153152f $X=1.0655 $Y=0.2025
cc_285 N_13_5 N_9_12 0.000910608f $X=1.08 $Y=0.2025
cc_286 N_13_24 N_9_20 0.000975738f $X=1.233 $Y=0.036
cc_287 N_13_6 N_9_12 0.00113599f $X=1.134 $Y=0.0675
cc_288 N_13_16 N_9_2 0.00130701f $X=1.1195 $Y=0.0675
cc_289 N_13_16 N_9_12 0.0538403f $X=1.1195 $Y=0.0675
cc_290 N_13_6 N_10_3 0.00126007f $X=1.134 $Y=0.0675
cc_291 N_13_5 N_10_3 0.000178423f $X=1.08 $Y=0.2025
cc_292 N_13_24 N_10_3 0.000195369f $X=1.233 $Y=0.036
cc_293 N_13_17 N_10_3 0.000558631f $X=1.0655 $Y=0.2025
cc_294 N_13_16 N_10_13 0.00118967f $X=1.1195 $Y=0.0675
cc_295 N_13_17 N_10_15 0.000593687f $X=1.0655 $Y=0.2025
cc_296 N_13_5 N_10_4 0.00112728f $X=1.08 $Y=0.2025
cc_297 N_13_17 N_10_4 0.00135848f $X=1.0655 $Y=0.2025
cc_298 N_13_16 N_10_3 0.00206645f $X=1.1195 $Y=0.0675
cc_299 N_13_6 N_12_10 0.000233561f $X=1.134 $Y=0.0675
cc_300 N_13_24 N_12_10 0.00042233f $X=1.233 $Y=0.036
cc_301 N_13_21 N_12_17 0.000522072f $X=1.377 $Y=0.135
cc_302 N_13_23 N_12_4 0.000605319f $X=1.35 $Y=0.234
cc_303 N_13_19 N_12_1 0.000621183f $X=1.251 $Y=0.135
cc_304 N_13_1 N_12_1 0.000675377f $X=1.269 $Y=0.135
cc_305 N_13_25 N_12_3 0.000937384f $X=1.251 $Y=0.116
cc_306 N_13_1 N_12_3 0.00123309f $X=1.269 $Y=0.135
cc_307 N_13_28 N_12_14 0.00130609f $X=1.377 $Y=0.172
cc_308 N_13_23 N_12_14 0.00136353f $X=1.35 $Y=0.234
cc_309 N_13_11 N_12_4 0.00174953f $X=1.269 $Y=0.0245
cc_310 N_13_11 N_12_9 0.00191156f $X=1.269 $Y=0.0245
cc_311 N_13_26 N_12_13 0.00198397f $X=1.2715 $Y=0.036
cc_312 N_13_1 N_12_11 0.0022115f $X=1.269 $Y=0.135
cc_313 N_13_27 N_12_13 0.00232657f $X=1.377 $Y=0.063
cc_314 N_13_25 N_12_15 0.00238098f $X=1.251 $Y=0.116
cc_315 N_13_11 N_12_3 0.00247663f $X=1.269 $Y=0.0245
cc_316 N_13_19 N_12_17 0.00277814f $X=1.251 $Y=0.135
cc_317 N_13_19 N_12_13 0.00302517f $X=1.251 $Y=0.135
cc_318 N_13_23 N_12_16 0.00303023f $X=1.35 $Y=0.234
cc_319 N_13_19 N_12_15 0.00362688f $X=1.251 $Y=0.135
cc_320 N_13_11 N_12_11 0.0149912f $X=1.269 $Y=0.0245
cc_321 N_13_23 N_12_12 0.00534265f $X=1.35 $Y=0.234
cc_322 N_13_11 N_12_10 0.055948f $X=1.269 $Y=0.0245
x_PM_SDFHx4_ASAP7_75t_R%QN vss QN N_M15_d N_M16_d N_M17_d N_M18_d N_M34_d
+ N_M35_d N_M36_d N_M37_d N_QN_13 N_QN_3 N_QN_4 N_QN_1 N_QN_2 N_QN_15 N_QN_14
+ N_QN_16 PM_SDFHx4_ASAP7_75t_R%QN
cc_323 N_QN_13 N_13_26 0.0001044f $X=1.4435 $Y=0.0675
cc_324 N_QN_13 N_13_20 0.000146997f $X=1.4435 $Y=0.0675
cc_325 N_QN_13 N_13_22 0.000147072f $X=1.4435 $Y=0.0675
cc_326 N_QN_13 N_13_28 0.000406077f $X=1.4435 $Y=0.0675
cc_327 N_QN_13 N_13_2 0.000961209f $X=1.4435 $Y=0.0675
cc_328 N_QN_13 N_13_27 0.000446271f $X=1.4435 $Y=0.0675
cc_329 N_QN_13 N_13_14 0.00336083f $X=1.4435 $Y=0.0675
cc_330 N_QN_13 N_13_13 0.0379336f $X=1.4435 $Y=0.0675
cc_331 N_QN_13 N_13_29 0.000909987f $X=1.4435 $Y=0.0675
cc_332 N_QN_3 N_13_15 0.00162014f $X=1.566 $Y=0.0675
cc_333 N_QN_4 N_13_15 0.00162014f $X=1.566 $Y=0.2025
cc_334 N_QN_1 N_13_12 0.00191101f $X=1.458 $Y=0.0675
cc_335 N_QN_2 N_13_12 0.00191101f $X=1.458 $Y=0.2025
cc_336 N_QN_15 N_13_2 0.00992903f $X=1.4435 $Y=0.2025
cc_337 N_QN_15 N_13_12 0.0281557f $X=1.4435 $Y=0.2025
cc_338 N_QN_14 N_13_15 0.0102817f $X=1.5515 $Y=0.0675
cc_339 N_QN_16 N_13_14 0.0102819f $X=1.5515 $Y=0.2025
cc_340 N_QN_16 N_13_15 0.0544588f $X=1.5515 $Y=0.2025
cc_341 N_QN_14 N_13_14 0.0546415f $X=1.5515 $Y=0.0675
cc_342 N_QN_13 N_13_12 0.0646193f $X=1.4435 $Y=0.0675
x_PM_SDFHx4_ASAP7_75t_R%D vss D N_M3_g N_M22_g N_D_7 N_D_1 N_D_6 N_D_4 N_D_5
+ N_D_10 N_D_3 N_D_8 N_D_9 PM_SDFHx4_ASAP7_75t_R%D
cc_343 N_D_7 N_4_36 0.00355799f $X=0.387 $Y=0.1405
x_PM_SDFHx4_ASAP7_75t_R%SE vss SE N_M2_g N_M21_g N_M5_g N_M24_g N_SE_8 N_SE_12
+ N_SE_9 N_SE_13 N_SE_15 N_SE_14 N_SE_7 N_SE_11 N_SE_5 N_SE_1 N_SE_2 N_SE_10
+ N_SE_6 PM_SDFHx4_ASAP7_75t_R%SE
cc_344 N_SE_8 N_4_36 0.000190427f $X=0.243 $Y=0.135
cc_345 N_SE_12 N_4_31 0.000215255f $X=0.243 $Y=0.1845
cc_346 N_SE_9 N_4_36 0.000263461f $X=0.243 $Y=0.234
cc_347 N_SE_13 N_4_36 0.000421778f $X=0.2615 $Y=0.135
cc_348 N_SE_15 N_4_36 0.00114849f $X=0.2315 $Y=0.081
cc_349 N_SE_14 N_4_36 0.00156729f $X=0.567 $Y=0.0855
cc_350 N_SE_12 N_4_36 0.0033995f $X=0.243 $Y=0.1845

* End of included file SDFHx4_ASAP7_75t_R.pex.sp.pxi
.ends

.subckt PM_ICGx3_ASAP7_75t_R%5 vss 17 21 46 47 49 16 15 4 11 3 14 10 1 9
c1 1 vss 0.0034539f $X=0.189 $Y=0.134
c2 3 vss 0.00751555f $X=0.054 $Y=0.216
c3 4 vss 0.00832295f $X=0.108 $Y=0.054
c4 9 vss 0.107188f $X=0.189 $Y=0.0245
c5 10 vss 0.00668265f $X=0.0935 $Y=0.054
c6 11 vss 0.0315394f $X=0.056 $Y=0.216
c7 12 vss 0.0033128f $X=0.189 $Y=0.036
c8 13 vss 0.00335004f $X=0.189 $Y=0.2325
c9 14 vss 0.0175976f $X=0.162 $Y=0.233
c10 15 vss 0.0107189f $X=0.162 $Y=0.036
c11 16 vss 0.00701267f $X=0.189 $Y=0.1045
r1 49 48 0.0462963 $w=5.4e-08 $l=2.5e-09 $layer=P_src_drn $thickness=1e-09
+ $X=0.0713 $Y=0.216 $X2=0.0685 $Y2=0.216
r2 11 48 0.231482 $w=5.4e-08 $l=1.25e-08 $layer=P_src_drn $thickness=1e-09
+ $X=0.056 $Y=0.216 $X2=0.0685 $Y2=0.216
r3 47 45 0.0462963 $w=5.4e-08 $l=2.5e-09 $layer=N_src_drn $thickness=1e-09
+ $X=0.1253 $Y=0.054 $X2=0.1225 $Y2=0.054
r4 4 45 0.268519 $w=5.4e-08 $l=1.45e-08 $layer=N_src_drn $thickness=1e-09
+ $X=0.108 $Y=0.054 $X2=0.1225 $Y2=0.054
r5 10 4 0.268519 $w=5.4e-08 $l=1.45e-08 $layer=N_src_drn $thickness=1e-09
+ $X=0.0935 $Y=0.054 $X2=0.108 $Y2=0.054
r6 46 10 0.0462963 $w=5.4e-08 $l=2.5e-09 $layer=N_src_drn $thickness=1e-09
+ $X=0.0906 $Y=0.054 $X2=0.0935 $Y2=0.054
r7 3 42 19.3796 $a=3.24e-16 $layer=V0LISD $X=0.054 $Y=0.216 $X2=0.054 $Y2=0.233
r8 4 35 19.3796 $a=3.24e-16 $layer=V0LISD $X=0.108 $Y=0.054 $X2=0.108 $Y2=0.036
r9 42 43 3.14806 $w=1.3e-08 $l=1.35e-08 $layer=M1 $thickness=3.6e-08 $X=0.054
+ $Y=0.233 $X2=0.0675 $Y2=0.233
r10 40 43 3.14806 $w=1.3e-08 $l=1.35e-08 $layer=M1 $thickness=3.6e-08 $X=0.081
+ $Y=0.233 $X2=0.0675 $Y2=0.233
r11 39 40 6.29612 $w=1.3e-08 $l=2.7e-08 $layer=M1 $thickness=3.6e-08 $X=0.108
+ $Y=0.233 $X2=0.081 $Y2=0.233
r12 38 39 6.29612 $w=1.3e-08 $l=2.7e-08 $layer=M1 $thickness=3.6e-08 $X=0.135
+ $Y=0.233 $X2=0.108 $Y2=0.233
r13 14 38 6.29612 $w=1.3e-08 $l=2.7e-08 $layer=M1 $thickness=3.6e-08 $X=0.162
+ $Y=0.233 $X2=0.135 $Y2=0.233
r14 35 36 3.14806 $w=1.3e-08 $l=1.35e-08 $layer=M1 $thickness=3.6e-08 $X=0.108
+ $Y=0.036 $X2=0.1215 $Y2=0.036
r15 33 36 3.14806 $w=1.3e-08 $l=1.35e-08 $layer=M1 $thickness=3.6e-08 $X=0.135
+ $Y=0.036 $X2=0.1215 $Y2=0.036
r16 15 33 6.29612 $w=1.3e-08 $l=2.7e-08 $layer=M1 $thickness=3.6e-08 $X=0.162
+ $Y=0.036 $X2=0.135 $Y2=0.036
r17 13 31 0.983973 $w=1.77222e-08 $l=9e-09 $layer=M1 $thickness=3.6e-08
+ $X=0.189 $Y=0.2325 $X2=0.189 $Y2=0.2235
r18 13 14 5.06479 $w=1.46038e-08 $l=2.70046e-08 $layer=M1 $thickness=3.6e-08
+ $X=0.189 $Y=0.2325 $X2=0.162 $Y2=0.233
r19 12 26 3.36447 $w=1.71023e-08 $l=2.15e-08 $layer=M1 $thickness=3.6e-08
+ $X=0.189 $Y=0.036 $X2=0.189 $Y2=0.0575
r20 12 15 4.64701 $w=1.46667e-08 $l=2.7e-08 $layer=M1 $thickness=3.6e-08
+ $X=0.189 $Y=0.036 $X2=0.162 $Y2=0.036
r21 30 31 2.91487 $w=1.3e-08 $l=1.25e-08 $layer=M1 $thickness=3.6e-08 $X=0.189
+ $Y=0.211 $X2=0.189 $Y2=0.2235
r22 29 30 2.91487 $w=1.3e-08 $l=1.25e-08 $layer=M1 $thickness=3.6e-08 $X=0.189
+ $Y=0.1985 $X2=0.189 $Y2=0.211
r23 28 29 1.74892 $w=1.3e-08 $l=7.5e-09 $layer=M1 $thickness=3.6e-08 $X=0.189
+ $Y=0.191 $X2=0.189 $Y2=0.1985
r24 27 28 9.211 $w=1.3e-08 $l=3.95e-08 $layer=M1 $thickness=3.6e-08 $X=0.189
+ $Y=0.1515 $X2=0.189 $Y2=0.191
r25 25 26 3.14806 $w=1.3e-08 $l=1.35e-08 $layer=M1 $thickness=3.6e-08 $X=0.189
+ $Y=0.071 $X2=0.189 $Y2=0.0575
r26 24 25 2.3319 $w=1.3e-08 $l=1e-08 $layer=M1 $thickness=3.6e-08 $X=0.189
+ $Y=0.081 $X2=0.189 $Y2=0.071
r27 16 24 5.47996 $w=1.3e-08 $l=2.35e-08 $layer=M1 $thickness=3.6e-08 $X=0.189
+ $Y=0.1045 $X2=0.189 $Y2=0.081
r28 16 27 10.9599 $w=1.3e-08 $l=4.7e-08 $layer=M1 $thickness=3.6e-08 $X=0.189
+ $Y=0.1045 $X2=0.189 $Y2=0.1515
r29 1 19 9.83583 $w=1.77619e-08 $l=1e-09 $layer=LIG $thickness=5.21905e-08
+ $X=0.189 $Y=0.134 $X2=0.189 $Y2=0.135
r30 1 27 19.3796 $a=3.24e-16 $layer=V0LIG $X=0.189 $Y=0.134 $X2=0.189 $Y2=0.1515
r31 21 20 16.4967 $w=2.1e-08 $l=4.85e-08 $layer=Gate_1 $thickness=5.6e-08
+ $X=0.189 $Y=0.2025 $X2=0.189 $Y2=0.154
r32 19 20 6.6497 $w=2.04211e-08 $l=1.9e-08 $layer=Gate_1 $thickness=5.6e-08
+ $X=0.189 $Y=0.135 $X2=0.189 $Y2=0.154
r33 18 19 6.6497 $w=2.04211e-08 $l=1.9e-08 $layer=Gate_1 $thickness=5.6e-08
+ $X=0.189 $Y=0.116 $X2=0.189 $Y2=0.135
r34 17 18 16.4967 $w=2.1e-08 $l=4.85e-08 $layer=Gate_1 $thickness=5.6e-08
+ $X=0.189 $Y=0.0675 $X2=0.189 $Y2=0.116
r35 17 9 14.6259 $w=2.1e-08 $l=4.3e-08 $layer=Gate_1 $thickness=5.6e-08
+ $X=0.189 $Y=0.0675 $X2=0.189 $Y2=0.0245
r36 3 11 1e-05 $l=2e-09 $X=0.054 $Y=0.216 $X2=0.056 $Y2=0.216
.ends

.subckt PM_ICGx3_ASAP7_75t_R%SE vss 13 5 9 3 4 1
c1 1 vss 0.00405531f $X=0.135 $Y=0.135
c2 3 vss 0.0941192f $X=0.135 $Y=0.0245
c3 4 vss 0.00331052f $X=0.135 $Y=0.0972
r1 14 15 2.3902 $w=1.3e-08 $l=1.03e-08 $layer=M1 $thickness=3.6e-08 $X=0.135
+ $Y=0.1267 $X2=0.135 $Y2=0.137
r2 13 14 0.408082 $w=1.3e-08 $l=1.7e-09 $layer=M1 $thickness=3.6e-08 $X=0.135
+ $Y=0.125 $X2=0.135 $Y2=0.1267
r3 13 4 6.47102 $w=1.3e-08 $l=2.78e-08 $layer=M1 $thickness=3.6e-08 $X=0.135
+ $Y=0.125 $X2=0.135 $Y2=0.0972
r4 1 7 6.54019 $w=2.09524e-08 $layer=Gate_1 $thickness=5.21905e-08 $X=0.135
+ $Y=0.135 $X2=0.135 $Y2=0.135
r5 1 15 19.3796 $a=3.24e-16 $layer=V0LIG $X=0.135 $Y=0.135 $X2=0.135 $Y2=0.137
r6 9 8 16.4967 $w=2.1e-08 $l=4.85e-08 $layer=Gate_1 $thickness=5.6e-08 $X=0.135
+ $Y=0.216 $X2=0.135 $Y2=0.1675
r7 7 8 11.2416 $w=2.06615e-08 $l=3.25e-08 $layer=Gate_1 $thickness=5.6e-08
+ $X=0.135 $Y=0.135 $X2=0.135 $Y2=0.1675
r8 6 7 11.2416 $w=2.06615e-08 $l=3.25e-08 $layer=Gate_1 $thickness=5.6e-08
+ $X=0.135 $Y=0.1025 $X2=0.135 $Y2=0.135
r9 5 6 16.4967 $w=2.1e-08 $l=4.85e-08 $layer=Gate_1 $thickness=5.6e-08 $X=0.135
+ $Y=0.054 $X2=0.135 $Y2=0.1025
r10 5 3 10.0341 $w=2.1e-08 $l=2.95e-08 $layer=Gate_1 $thickness=5.6e-08
+ $X=0.135 $Y=0.054 $X2=0.135 $Y2=0.0245
.ends

.subckt PM_ICGx3_ASAP7_75t_R%GCLK vss 32 24 25 36 44 45 47 13 1 2 20 19 16 15 14
c1 1 vss 0.00861775f $X=0.918 $Y=0.0675
c2 2 vss 0.00854344f $X=0.918 $Y=0.2025
c3 3 vss 0.00815289f $X=1.026 $Y=0.0675
c4 4 vss 0.00812159f $X=1.026 $Y=0.2025
c5 13 vss 0.00448631f $X=0.9035 $Y=0.0675
c6 14 vss 0.0369334f $X=1.0115 $Y=0.0675
c7 15 vss 0.00449529f $X=0.9035 $Y=0.2025
c8 16 vss 0.036959f $X=1.0115 $Y=0.2025
c9 17 vss 0.00264621f $X=1.053 $Y=0.036
c10 18 vss 0.00264621f $X=1.053 $Y=0.234
c11 19 vss 0.0151733f $X=0.8895 $Y=0.036
c12 20 vss 0.0131105f $X=0.9045 $Y=0.234
c13 21 vss 0.0050313f $X=1.053 $Y=0.054
r1 16 4 0.154321 $w=8.1e-08 $l=1.25e-08 $layer=P_src_drn $thickness=1e-09
+ $X=1.0115 $Y=0.2025 $X2=1.026 $Y2=0.2025
r2 47 16 0.0308642 $w=8.1e-08 $l=2.5e-09 $layer=P_src_drn $thickness=1e-09
+ $X=1.0086 $Y=0.2025 $X2=1.0115 $Y2=0.2025
r3 45 43 0.0308642 $w=8.1e-08 $l=2.5e-09 $layer=P_src_drn $thickness=1e-09
+ $X=0.9353 $Y=0.2025 $X2=0.9325 $Y2=0.2025
r4 2 43 0.179012 $w=8.1e-08 $l=1.45e-08 $layer=P_src_drn $thickness=1e-09
+ $X=0.918 $Y=0.2025 $X2=0.9325 $Y2=0.2025
r5 15 2 0.179012 $w=8.1e-08 $l=1.45e-08 $layer=P_src_drn $thickness=1e-09
+ $X=0.9035 $Y=0.2025 $X2=0.918 $Y2=0.2025
r6 44 15 0.0308642 $w=8.1e-08 $l=2.5e-09 $layer=P_src_drn $thickness=1e-09
+ $X=0.9006 $Y=0.2025 $X2=0.9035 $Y2=0.2025
r7 4 39 19.3796 $a=3.24e-16 $layer=V0LISD $X=1.026 $Y=0.2025 $X2=1.026 $Y2=0.234
r8 2 37 19.3796 $a=3.24e-16 $layer=V0LISD $X=0.918 $Y=0.2025 $X2=0.918 $Y2=0.234
r9 39 40 3.14806 $w=1.3e-08 $l=1.35e-08 $layer=M1 $thickness=3.6e-08 $X=1.026
+ $Y=0.234 $X2=1.0395 $Y2=0.234
r10 38 39 12.5922 $w=1.3e-08 $l=5.4e-08 $layer=M1 $thickness=3.6e-08 $X=0.972
+ $Y=0.234 $X2=1.026 $Y2=0.234
r11 37 38 12.5922 $w=1.3e-08 $l=5.4e-08 $layer=M1 $thickness=3.6e-08 $X=0.918
+ $Y=0.234 $X2=0.972 $Y2=0.234
r12 20 37 3.14806 $w=1.3e-08 $l=1.35e-08 $layer=M1 $thickness=3.6e-08 $X=0.9045
+ $Y=0.234 $X2=0.918 $Y2=0.234
r13 18 34 2.6649 $w=1.77676e-08 $l=1.85e-08 $layer=M1 $thickness=3.6e-08
+ $X=1.053 $Y=0.234 $X2=1.053 $Y2=0.2155
r14 18 40 1.49895 $w=1.63333e-08 $l=1.35e-08 $layer=M1 $thickness=3.6e-08
+ $X=1.053 $Y=0.234 $X2=1.0395 $Y2=0.234
r15 14 3 0.154321 $w=8.1e-08 $l=1.25e-08 $layer=N_src_drn $thickness=1e-09
+ $X=1.0115 $Y=0.0675 $X2=1.026 $Y2=0.0675
r16 36 14 0.0308642 $w=8.1e-08 $l=2.5e-09 $layer=N_src_drn $thickness=1e-09
+ $X=1.0086 $Y=0.0675 $X2=1.0115 $Y2=0.0675
r17 33 34 6.8208 $w=1.3e-08 $l=2.93e-08 $layer=M1 $thickness=3.6e-08 $X=1.053
+ $Y=0.1862 $X2=1.053 $Y2=0.2155
r18 32 33 4.72209 $w=1.3e-08 $l=2.02e-08 $layer=M1 $thickness=3.6e-08 $X=1.057
+ $Y=0.166 $X2=1.053 $Y2=0.1862
r19 32 31 12.0676 $w=1.3e-08 $l=5.18e-08 $layer=M1 $thickness=3.6e-08 $X=1.057
+ $Y=0.166 $X2=1.053 $Y2=0.1142
r20 21 31 14.0497 $w=1.3e-08 $l=6.02e-08 $layer=M1 $thickness=3.6e-08 $X=1.053
+ $Y=0.054 $X2=1.053 $Y2=0.1142
r21 3 29 19.3796 $a=3.24e-16 $layer=V0LISD $X=1.026 $Y=0.0675 $X2=1.026
+ $Y2=0.036
r22 17 30 1.49895 $w=1.63333e-08 $l=1.35e-08 $layer=M1 $thickness=3.6e-08
+ $X=1.053 $Y=0.036 $X2=1.0395 $Y2=0.036
r23 17 21 2.5483 $w=1.79e-08 $l=1.8e-08 $layer=M1 $thickness=3.6e-08 $X=1.053
+ $Y=0.036 $X2=1.053 $Y2=0.054
r24 29 30 3.14806 $w=1.3e-08 $l=1.35e-08 $layer=M1 $thickness=3.6e-08 $X=1.026
+ $Y=0.036 $X2=1.0395 $Y2=0.036
r25 28 29 12.5922 $w=1.3e-08 $l=5.4e-08 $layer=M1 $thickness=3.6e-08 $X=0.972
+ $Y=0.036 $X2=1.026 $Y2=0.036
r26 27 28 12.5922 $w=1.3e-08 $l=5.4e-08 $layer=M1 $thickness=3.6e-08 $X=0.918
+ $Y=0.036 $X2=0.972 $Y2=0.036
r27 26 27 3.14806 $w=1.3e-08 $l=1.35e-08 $layer=M1 $thickness=3.6e-08 $X=0.9045
+ $Y=0.036 $X2=0.918 $Y2=0.036
r28 19 26 3.49785 $w=1.3e-08 $l=1.5e-08 $layer=M1 $thickness=3.6e-08 $X=0.8895
+ $Y=0.036 $X2=0.9045 $Y2=0.036
r29 1 27 19.3796 $a=3.24e-16 $layer=V0LISD $X=0.918 $Y=0.0675 $X2=0.918
+ $Y2=0.036
r30 25 23 0.0308642 $w=8.1e-08 $l=2.5e-09 $layer=N_src_drn $thickness=1e-09
+ $X=0.9353 $Y=0.0675 $X2=0.9325 $Y2=0.0675
r31 1 23 0.179012 $w=8.1e-08 $l=1.45e-08 $layer=N_src_drn $thickness=1e-09
+ $X=0.918 $Y=0.0675 $X2=0.9325 $Y2=0.0675
r32 13 1 0.179012 $w=8.1e-08 $l=1.45e-08 $layer=N_src_drn $thickness=1e-09
+ $X=0.9035 $Y=0.0675 $X2=0.918 $Y2=0.0675
r33 24 13 0.0308642 $w=8.1e-08 $l=2.5e-09 $layer=N_src_drn $thickness=1e-09
+ $X=0.9006 $Y=0.0675 $X2=0.9035 $Y2=0.0675
.ends

.subckt PM_ICGx3_ASAP7_75t_R%CLK vss 55 27 31 41 44 75 79 93 98 23 1 10 19 17
+ 15 20 16 8 12 21 2 3 11 18 4 14 22 13
c1 1 vss 0.000473733f $X=0.243 $Y=0.1335
c2 2 vss 0.000208285f $X=0.352 $Y=0.1335
c3 3 vss 0.00580998f $X=0.621 $Y=0.135
c4 4 vss 0.00544223f $X=0.783 $Y=0.162
c5 8 vss 0.00219845f $X=0.393 $Y=0.1335
c6 10 vss 0.00740068f $X=0.243 $Y=0.1335
c7 11 vss 0.00615939f $X=0.351 $Y=0.1335
c8 12 vss 0.0975205f $X=0.621 $Y=0.135
c9 13 vss 0.034709f $X=0.729 $Y=0.162
c10 14 vss 0.0345918f $X=0.783 $Y=0.0245
c11 15 vss 0.000502368f $X=0.405 $Y=0.153
c12 16 vss 0.00084004f $X=0.423 $Y=0.153
c13 17 vss 0.00071805f $X=0.621 $Y=0.187
c14 18 vss 0.000616326f $X=0.756 $Y=0.183
c15 19 vss 0.00345328f $X=0.243 $Y=0.1215
c16 20 vss 0.00189561f $X=0.621 $Y=0.1545
c17 21 vss 0.00545393f $X=0.7175 $Y=0.187
c18 22 vss 0.00145367f $X=0.756 $Y=0.1445
c19 23 vss 0.0379342f $X=0.5872 $Y=0.153
r1 98 99 16.3266 $w=2.1e-08 $l=4.8e-08 $layer=Gate_1 $thickness=5.6e-08
+ $X=0.351 $Y=0.0405 $X2=0.351 $Y2=0.0885
r2 11 95 3.75002 $w=2e-08 $layer=Gate_1 $thickness=5.6e-08 $X=0.351 $Y=0.1335
+ $X2=0.351 $Y2=0.1335
r3 11 99 15.4848 $w=2.07667e-08 $l=4.5e-08 $layer=Gate_1 $thickness=5.6e-08
+ $X=0.351 $Y=0.1335 $X2=0.351 $Y2=0.0885
r4 2 90 3.16825 $w=2.1e-08 $l=3.5e-09 $layer=LIG $thickness=4.8e-08 $X=0.352
+ $Y=0.1335 $X2=0.3555 $Y2=0.1335
r5 2 95 3.16825 $w=2.1e-08 $l=1e-09 $layer=LIG $thickness=4.8e-08 $X=0.352
+ $Y=0.1335 $X2=0.351 $Y2=0.1335
r6 93 92 16.8368 $w=2.1e-08 $l=4.95e-08 $layer=Gate_1 $thickness=5.6e-08
+ $X=0.243 $Y=0.2025 $X2=0.243 $Y2=0.153
r7 10 92 6.81127 $w=2.04615e-08 $l=1.95e-08 $layer=Gate_1 $thickness=5.6e-08
+ $X=0.243 $Y=0.1335 $X2=0.243 $Y2=0.153
r8 89 90 4.91375 $w=2.12e-08 $l=1.5e-09 $layer=LISD $thickness=2.7e-08 $X=0.357
+ $Y=0.1335 $X2=0.3555 $Y2=0.1335
r9 88 89 11.4654 $w=2.12e-08 $l=2.1e-08 $layer=LISD $thickness=2.7e-08 $X=0.378
+ $Y=0.1335 $X2=0.357 $Y2=0.1335
r10 8 86 6.55166 $w=2.12e-08 $l=1.2e-08 $layer=LISD $thickness=2.7e-08 $X=0.393
+ $Y=0.1335 $X2=0.405 $Y2=0.1335
r11 8 88 8.18958 $w=2.12e-08 $l=1.5e-08 $layer=LISD $thickness=2.7e-08 $X=0.393
+ $Y=0.1335 $X2=0.378 $Y2=0.1335
r12 1 68 19.3796 $a=3.24e-16 $layer=V0LIG $X=0.243 $Y=0.1335 $X2=0.243 $Y2=0.133
r13 1 10 6.63025 $w=2.04878e-08 $layer=Gate_1 $thickness=5.20976e-08 $X=0.243
+ $Y=0.1335 $X2=0.243 $Y2=0.1335
r14 82 83 2.2153 $w=1.3e-08 $l=9.5e-09 $layer=M1 $thickness=3.6e-08 $X=0.405
+ $Y=0.134 $X2=0.405 $Y2=0.1435
r15 82 86 19.3796 $a=3.24e-16 $layer=V0LISD $X=0.405 $Y=0.134 $X2=0.405
+ $Y2=0.1335
r16 15 16 3.01711 $w=1.55e-08 $l=1.8e-08 $layer=M1 $thickness=3.6e-08 $X=0.405
+ $Y=0.153 $X2=0.423 $Y2=0.153
r17 15 83 1.03499 $w=1.77368e-08 $l=9.5e-09 $layer=M1 $thickness=3.6e-08
+ $X=0.405 $Y=0.153 $X2=0.405 $Y2=0.1435
r18 79 78 14.6259 $w=2.1e-08 $l=4.3e-08 $layer=Gate_1 $thickness=5.6e-08
+ $X=0.621 $Y=0.2025 $X2=0.621 $Y2=0.1595
r19 77 78 2.7211 $w=2.1e-08 $l=8e-09 $layer=Gate_1 $thickness=5.6e-08 $X=0.621
+ $Y=0.1515 $X2=0.621 $Y2=0.1595
r20 75 76 14.6259 $w=2.1e-08 $l=4.3e-08 $layer=Gate_1 $thickness=5.6e-08
+ $X=0.621 $Y=0.0675 $X2=0.621 $Y2=0.1105
r21 73 76 2.7211 $w=2.1e-08 $l=8e-09 $layer=Gate_1 $thickness=5.6e-08 $X=0.621
+ $Y=0.1185 $X2=0.621 $Y2=0.1105
r22 12 73 5.79936 $w=2.03333e-08 $l=1.65e-08 $layer=Gate_1 $thickness=5.6e-08
+ $X=0.621 $Y=0.135 $X2=0.621 $Y2=0.1185
r23 12 77 5.79936 $w=2.03333e-08 $l=1.65e-08 $layer=Gate_1 $thickness=5.6e-08
+ $X=0.621 $Y=0.135 $X2=0.621 $Y2=0.1515
r24 69 70 2.3319 $w=1.3e-08 $l=1e-08 $layer=M1 $thickness=3.6e-08 $X=0.243
+ $Y=0.143 $X2=0.243 $Y2=0.153
r25 68 69 2.3319 $w=1.3e-08 $l=1e-08 $layer=M1 $thickness=3.6e-08 $X=0.243
+ $Y=0.133 $X2=0.243 $Y2=0.143
r26 19 68 2.68168 $w=1.3e-08 $l=1.15e-08 $layer=M1 $thickness=3.6e-08 $X=0.243
+ $Y=0.1215 $X2=0.243 $Y2=0.133
r27 16 60 19.5347 $a=3.24e-16 $layer=V1 $X=0.423 $Y=0.153 $X2=0.423 $Y2=0.153
r28 3 52 19.3796 $a=3.24e-16 $layer=V0LIG $X=0.621 $Y=0.135 $X2=0.621 $Y2=0.133
r29 3 12 6.54019 $w=2.09524e-08 $layer=Gate_1 $thickness=5.21905e-08 $X=0.621
+ $Y=0.135 $X2=0.621 $Y2=0.135
r30 63 64 7.22888 $w=1.3e-08 $l=3.1e-08 $layer=M2 $thickness=3.6e-08 $X=0.243
+ $Y=0.153 $X2=0.274 $Y2=0.153
r31 63 70 19.5347 $a=3.24e-16 $layer=V1 $X=0.243 $Y=0.153 $X2=0.243 $Y2=0.153
r32 60 61 19.5879 $w=1.3e-08 $l=8.4e-08 $layer=M2 $thickness=3.6e-08 $X=0.423
+ $Y=0.153 $X2=0.507 $Y2=0.153
r33 59 60 15.8569 $w=1.3e-08 $l=6.8e-08 $layer=M2 $thickness=3.6e-08 $X=0.355
+ $Y=0.153 $X2=0.423 $Y2=0.153
r34 59 64 18.8884 $w=1.3e-08 $l=8.1e-08 $layer=M2 $thickness=3.6e-08 $X=0.355
+ $Y=0.153 $X2=0.274 $Y2=0.153
r35 56 57 4.25571 $w=1.3e-08 $l=1.83e-08 $layer=M2 $thickness=3.6e-08 $X=0.6027
+ $Y=0.153 $X2=0.621 $Y2=0.153
r36 55 56 2.2736 $w=1.3e-08 $l=9.7e-09 $layer=M2 $thickness=3.6e-08 $X=0.593
+ $Y=0.15 $X2=0.6027 $Y2=0.153
r37 55 23 1.34084 $w=1.3e-08 $l=5.8e-09 $layer=M2 $thickness=3.6e-08 $X=0.593
+ $Y=0.15 $X2=0.5872 $Y2=0.153
r38 23 61 18.7135 $w=1.3e-08 $l=8.02e-08 $layer=M2 $thickness=3.6e-08 $X=0.5872
+ $Y=0.153 $X2=0.507 $Y2=0.153
r39 53 54 0.582974 $w=1.3e-08 $l=2.5e-09 $layer=M1 $thickness=3.6e-08 $X=0.621
+ $Y=0.143 $X2=0.621 $Y2=0.1455
r40 52 53 2.3319 $w=1.3e-08 $l=1e-08 $layer=M1 $thickness=3.6e-08 $X=0.621
+ $Y=0.133 $X2=0.621 $Y2=0.143
r41 20 50 3.61444 $w=1.3e-08 $l=1.55e-08 $layer=M1 $thickness=3.6e-08 $X=0.621
+ $Y=0.1545 $X2=0.621 $Y2=0.17
r42 20 54 2.09871 $w=1.3e-08 $l=9e-09 $layer=M1 $thickness=3.6e-08 $X=0.621
+ $Y=0.1545 $X2=0.621 $Y2=0.1455
r43 20 57 19.5347 $a=3.24e-16 $layer=V1 $X=0.621 $Y=0.1545 $X2=0.621 $Y2=0.153
r44 17 49 4.64701 $w=1.46667e-08 $l=2.7e-08 $layer=M1 $thickness=3.6e-08
+ $X=0.621 $Y=0.187 $X2=0.648 $Y2=0.187
r45 17 50 2.31511 $w=1.81882e-08 $l=1.7e-08 $layer=M1 $thickness=3.6e-08
+ $X=0.621 $Y=0.187 $X2=0.621 $Y2=0.17
r46 48 49 6.29612 $w=1.3e-08 $l=2.7e-08 $layer=M1 $thickness=3.6e-08 $X=0.675
+ $Y=0.187 $X2=0.648 $Y2=0.187
r47 47 48 2.56509 $w=1.3e-08 $l=1.1e-08 $layer=M1 $thickness=3.6e-08 $X=0.686
+ $Y=0.187 $X2=0.675 $Y2=0.187
r48 21 47 7.34548 $w=1.3e-08 $l=3.15e-08 $layer=M1 $thickness=3.6e-08 $X=0.7175
+ $Y=0.187 $X2=0.686 $Y2=0.187
r49 18 39 1.32639 $w=1.59412e-08 $l=8.5e-09 $layer=M1 $thickness=3.6e-08
+ $X=0.756 $Y=0.183 $X2=0.756 $Y2=0.1745
r50 18 21 7.38932 $w=1.37246e-08 $l=3.87072e-08 $layer=M1 $thickness=3.6e-08
+ $X=0.756 $Y=0.183 $X2=0.7175 $Y2=0.187
r51 44 43 11.9048 $w=2.1e-08 $l=3.5e-08 $layer=Gate_1 $thickness=5.6e-08
+ $X=0.729 $Y=0.216 $X2=0.729 $Y2=0.181
r52 41 42 21.0886 $w=2.1e-08 $l=6.2e-08 $layer=Gate_1 $thickness=5.6e-08
+ $X=0.729 $Y=0.0675 $X2=0.729 $Y2=0.1295
r53 13 34 6.54019 $w=2.09524e-08 $layer=Gate_1 $thickness=5.21905e-08 $X=0.729
+ $Y=0.162 $X2=0.729 $Y2=0.162
r54 13 42 11.2416 $w=2.06615e-08 $l=3.25e-08 $layer=Gate_1 $thickness=5.6e-08
+ $X=0.729 $Y=0.162 $X2=0.729 $Y2=0.1295
r55 13 43 6.6497 $w=2.04211e-08 $l=1.9e-08 $layer=Gate_1 $thickness=5.6e-08
+ $X=0.729 $Y=0.162 $X2=0.729 $Y2=0.181
r56 38 39 2.91487 $w=1.3e-08 $l=1.25e-08 $layer=M1 $thickness=3.6e-08 $X=0.756
+ $Y=0.162 $X2=0.756 $Y2=0.1745
r57 37 38 2.79828 $w=1.3e-08 $l=1.2e-08 $layer=M1 $thickness=3.6e-08 $X=0.756
+ $Y=0.15 $X2=0.756 $Y2=0.162
r58 22 37 1.28254 $w=1.3e-08 $l=5.5e-09 $layer=M1 $thickness=3.6e-08 $X=0.756
+ $Y=0.1445 $X2=0.756 $Y2=0.15
r59 33 34 12.6539 $w=1.77815e-08 $l=2.7e-08 $layer=LIG $thickness=4.8e-08
+ $X=0.756 $Y=0.162 $X2=0.729 $Y2=0.162
r60 33 38 19.3796 $a=3.24e-16 $layer=V0LIG $X=0.756 $Y=0.162 $X2=0.756 $Y2=0.162
r61 4 29 6.54019 $w=2.09524e-08 $layer=Gate_1 $thickness=5.21905e-08 $X=0.783
+ $Y=0.162 $X2=0.783 $Y2=0.162
r62 4 33 12.6539 $w=1.77815e-08 $l=2.7e-08 $layer=LIG $thickness=4.8e-08
+ $X=0.783 $Y=0.162 $X2=0.756 $Y2=0.162
r63 31 30 11.9048 $w=2.1e-08 $l=3.5e-08 $layer=Gate_1 $thickness=5.6e-08
+ $X=0.783 $Y=0.216 $X2=0.783 $Y2=0.181
r64 29 30 6.6497 $w=2.04211e-08 $l=1.9e-08 $layer=Gate_1 $thickness=5.6e-08
+ $X=0.783 $Y=0.162 $X2=0.783 $Y2=0.181
r65 28 29 11.2416 $w=2.06615e-08 $l=3.25e-08 $layer=Gate_1 $thickness=5.6e-08
+ $X=0.783 $Y=0.1295 $X2=0.783 $Y2=0.162
r66 27 28 21.0886 $w=2.1e-08 $l=6.2e-08 $layer=Gate_1 $thickness=5.6e-08
+ $X=0.783 $Y=0.0675 $X2=0.783 $Y2=0.1295
r67 27 14 14.6259 $w=2.1e-08 $l=4.3e-08 $layer=Gate_1 $thickness=5.6e-08
+ $X=0.783 $Y=0.0675 $X2=0.783 $Y2=0.0245
.ends

.subckt PM_ICGx3_ASAP7_75t_R%7 vss 21 25 55 57 10 16 3 17 18 1 11 15 13 12 14 4
+ 9
c1 1 vss 0.00037749f $X=0.297 $Y=0.1335
c2 3 vss 0.00673349f $X=0.594 $Y=0.0605
c3 4 vss 0.00836913f $X=0.594 $Y=0.2295
c4 9 vss 0.00763878f $X=0.297 $Y=0.0245
c5 10 vss 0.0456443f $X=0.596 $Y=0.0675
c6 11 vss 0.0450815f $X=0.596 $Y=0.2025
c7 12 vss 0.00317808f $X=0.297 $Y=0.081
c8 13 vss 0.000735079f $X=0.2945 $Y=0.189
c9 14 vss 0.00136138f $X=0.568 $Y=0.086
c10 15 vss 0.0060096f $X=0.568 $Y=0.232
c11 16 vss 0.00112432f $X=0.297 $Y=0.1045
c12 17 vss 0.00207925f $X=0.568 $Y=0.148
c13 18 vss 0.0148681f $X=0.2985 $Y=0.189
r1 57 56 0.0308642 $w=8.1e-08 $l=2.5e-09 $layer=P_src_drn $thickness=1e-09
+ $X=0.6113 $Y=0.2025 $X2=0.6085 $Y2=0.2025
r2 11 56 0.154321 $w=8.1e-08 $l=1.25e-08 $layer=P_src_drn $thickness=1e-09
+ $X=0.596 $Y=0.2025 $X2=0.6085 $Y2=0.2025
r3 55 54 0.0308642 $w=8.1e-08 $l=2.5e-09 $layer=N_src_drn $thickness=1e-09
+ $X=0.6113 $Y=0.0675 $X2=0.6085 $Y2=0.0675
r4 10 54 0.154321 $w=8.1e-08 $l=1.25e-08 $layer=N_src_drn $thickness=1e-09
+ $X=0.596 $Y=0.0675 $X2=0.6085 $Y2=0.0675
r5 4 50 19.3796 $a=3.24e-16 $layer=V0LISD $X=0.594 $Y=0.2295 $X2=0.594 $Y2=0.232
r6 4 11 23.8708 $w=2.02e-08 $l=4.05e-08 $layer=LISD $thickness=2.7e-08 $X=0.594
+ $Y=0.2295 $X2=0.596 $Y2=0.2025
r7 3 47 19.3796 $a=3.24e-16 $layer=V0LISD $X=0.594 $Y=0.0605 $X2=0.594 $Y2=0.086
r8 49 50 3.03147 $w=1.3e-08 $l=1.3e-08 $layer=M1 $thickness=3.6e-08 $X=0.581
+ $Y=0.232 $X2=0.594 $Y2=0.232
r9 15 45 1.03499 $w=1.77368e-08 $l=9.5e-09 $layer=M1 $thickness=3.6e-08
+ $X=0.568 $Y=0.232 $X2=0.568 $Y2=0.2225
r10 15 49 1.85116 $w=1.64615e-08 $l=1.3e-08 $layer=M1 $thickness=3.6e-08
+ $X=0.568 $Y=0.232 $X2=0.581 $Y2=0.232
r11 46 47 3.03147 $w=1.3e-08 $l=1.3e-08 $layer=M1 $thickness=3.6e-08 $X=0.581
+ $Y=0.086 $X2=0.594 $Y2=0.086
r12 14 42 3.36689 $w=1.53077e-08 $l=1.95e-08 $layer=M1 $thickness=3.6e-08
+ $X=0.568 $Y=0.086 $X2=0.568 $Y2=0.1055
r13 14 46 1.85116 $w=1.64615e-08 $l=1.3e-08 $layer=M1 $thickness=3.6e-08
+ $X=0.568 $Y=0.086 $X2=0.581 $Y2=0.086
r14 44 45 2.91487 $w=1.3e-08 $l=1.25e-08 $layer=M1 $thickness=3.6e-08 $X=0.568
+ $Y=0.21 $X2=0.568 $Y2=0.2225
r15 43 44 3.03147 $w=1.3e-08 $l=1.3e-08 $layer=M1 $thickness=3.6e-08 $X=0.568
+ $Y=0.197 $X2=0.568 $Y2=0.21
r16 41 43 2.09871 $w=1.3e-08 $l=9e-09 $layer=M1 $thickness=3.6e-08 $X=0.568
+ $Y=0.188 $X2=0.568 $Y2=0.197
r17 17 41 9.32759 $w=1.3e-08 $l=4e-08 $layer=M1 $thickness=3.6e-08 $X=0.568
+ $Y=0.148 $X2=0.568 $Y2=0.188
r18 17 42 9.91056 $w=1.3e-08 $l=4.25e-08 $layer=M1 $thickness=3.6e-08 $X=0.568
+ $Y=0.148 $X2=0.568 $Y2=0.1055
r19 39 41 19.5347 $a=3.24e-16 $layer=V1 $X=0.568 $Y=0.189 $X2=0.568 $Y2=0.188
r20 38 39 30.0815 $w=1.3e-08 $l=1.29e-07 $layer=M2 $thickness=3.6e-08 $X=0.439
+ $Y=0.189 $X2=0.568 $Y2=0.189
r21 37 38 30.0815 $w=1.3e-08 $l=1.29e-07 $layer=M2 $thickness=3.6e-08 $X=0.31
+ $Y=0.189 $X2=0.439 $Y2=0.189
r22 18 37 2.68168 $w=1.3e-08 $l=1.15e-08 $layer=M2 $thickness=3.6e-08 $X=0.2985
+ $Y=0.189 $X2=0.31 $Y2=0.189
r23 35 37 19.5347 $a=3.24e-16 $layer=V1 $X=0.3145 $Y=0.189 $X2=0.31 $Y2=0.189
r24 34 35 1.51573 $w=1.3e-08 $l=6.5e-09 $layer=M1 $thickness=3.6e-08 $X=0.308
+ $Y=0.189 $X2=0.3145 $Y2=0.189
r25 33 34 0.721491 $w=1.57778e-08 $l=4.5e-09 $layer=M1 $thickness=3.6e-08
+ $X=0.3035 $Y=0.189 $X2=0.308 $Y2=0.189
r26 13 33 0.9184 $w=1.8e-08 $l=9e-09 $layer=M1 $thickness=3.6e-08 $X=0.2945
+ $Y=0.189 $X2=0.3035 $Y2=0.189
r27 12 16 4.29965 $w=1.49149e-08 $l=2.35e-08 $layer=M1 $thickness=3.6e-08
+ $X=0.297 $Y=0.081 $X2=0.297 $Y2=0.1045
r28 31 33 4.68572 $w=1.35814e-08 $l=2.87446e-08 $layer=M1 $thickness=3.6e-08
+ $X=0.297 $Y=0.161 $X2=0.3035 $Y2=0.189
r29 30 31 6.52931 $w=1.3e-08 $l=2.8e-08 $layer=M1 $thickness=3.6e-08 $X=0.297
+ $Y=0.133 $X2=0.297 $Y2=0.161
r30 29 30 2.68168 $w=1.3e-08 $l=1.15e-08 $layer=M1 $thickness=3.6e-08 $X=0.297
+ $Y=0.1215 $X2=0.297 $Y2=0.133
r31 16 29 3.96423 $w=1.3e-08 $l=1.7e-08 $layer=M1 $thickness=3.6e-08 $X=0.297
+ $Y=0.1045 $X2=0.297 $Y2=0.1215
r32 1 23 6.63025 $w=2.04878e-08 $layer=Gate_1 $thickness=5.20976e-08 $X=0.297
+ $Y=0.1335 $X2=0.297 $Y2=0.1335
r33 1 30 19.3796 $a=3.24e-16 $layer=V0LIG $X=0.297 $Y=0.1335 $X2=0.297 $Y2=0.133
r34 25 24 16.8368 $w=2.1e-08 $l=4.95e-08 $layer=Gate_1 $thickness=5.6e-08
+ $X=0.297 $Y=0.2295 $X2=0.297 $Y2=0.18
r35 23 24 15.995 $w=2.07742e-08 $l=4.65e-08 $layer=Gate_1 $thickness=5.6e-08
+ $X=0.297 $Y=0.1335 $X2=0.297 $Y2=0.18
r36 22 23 6.30106 $w=2.04167e-08 $l=1.8e-08 $layer=Gate_1 $thickness=5.6e-08
+ $X=0.297 $Y=0.1155 $X2=0.297 $Y2=0.1335
r37 21 22 16.3266 $w=2.1e-08 $l=4.8e-08 $layer=Gate_1 $thickness=5.6e-08
+ $X=0.297 $Y=0.0675 $X2=0.297 $Y2=0.1155
r38 21 9 14.6259 $w=2.1e-08 $l=4.3e-08 $layer=Gate_1 $thickness=5.6e-08
+ $X=0.297 $Y=0.0675 $X2=0.297 $Y2=0.0245
r39 3 10 1e-05 $l=7.28011e-09 $X=0.594 $Y=0.0605 $X2=0.596 $Y2=0.0675
.ends

.subckt PM_ICGx3_ASAP7_75t_R%8 vss 16 20 44 50 9 1 14 15 12 13 4 11 3 10
c1 1 vss 0.00262169f $X=0.396 $Y=0.082
c2 3 vss 0.00737627f $X=0.486 $Y=0.0635
c3 4 vss 0.00604927f $X=0.486 $Y=0.2295
c4 9 vss 0.0591522f $X=0.405 $Y=0.0245
c5 10 vss 0.0218747f $X=0.4715 $Y=0.0405
c6 11 vss 0.0223902f $X=0.4715 $Y=0.2295
c7 12 vss 0.00647469f $X=0.5125 $Y=0.233
c8 13 vss 0.000610414f $X=0.5125 $Y=0.082
c9 14 vss 0.00268714f $X=0.3965 $Y=0.082
c10 15 vss 0.00188316f $X=0.5125 $Y=0.093
r1 11 4 0.462963 $w=2.7e-08 $l=1.25e-08 $layer=P_src_drn $thickness=1e-09
+ $X=0.4715 $Y=0.2295 $X2=0.486 $Y2=0.2295
r2 50 11 0.0925926 $w=2.7e-08 $l=2.5e-09 $layer=P_src_drn $thickness=1e-09
+ $X=0.4686 $Y=0.2295 $X2=0.4715 $Y2=0.2295
r3 4 46 19.3796 $a=3.24e-16 $layer=V0LISD $X=0.486 $Y=0.2295 $X2=0.486 $Y2=0.233
r4 46 47 3.03147 $w=1.3e-08 $l=1.3e-08 $layer=M1 $thickness=3.6e-08 $X=0.486
+ $Y=0.233 $X2=0.499 $Y2=0.233
r5 12 42 1.06916 $w=1.78e-08 $l=9.5e-09 $layer=M1 $thickness=3.6e-08 $X=0.5125
+ $Y=0.233 $X2=0.5125 $Y2=0.2235
r6 12 47 1.90218 $w=1.65185e-08 $l=1.35e-08 $layer=M1 $thickness=3.6e-08
+ $X=0.5125 $Y=0.233 $X2=0.499 $Y2=0.233
r7 10 35 0.462963 $w=2.7e-08 $l=1.25e-08 $layer=N_src_drn $thickness=1e-09
+ $X=0.4715 $Y=0.0405 $X2=0.486 $Y2=0.0405
r8 44 10 0.0925926 $w=2.7e-08 $l=2.5e-09 $layer=N_src_drn $thickness=1e-09
+ $X=0.4686 $Y=0.0405 $X2=0.4715 $Y2=0.0405
r9 41 42 2.49333 $w=1.4e-08 $l=1.25e-08 $layer=M1 $thickness=3.6e-08 $X=0.5125
+ $Y=0.211 $X2=0.5125 $Y2=0.2235
r10 40 41 4.1888 $w=1.4e-08 $l=2.1e-08 $layer=M1 $thickness=3.6e-08 $X=0.5125
+ $Y=0.19 $X2=0.5125 $Y2=0.211
r11 39 40 3.69013 $w=1.4e-08 $l=1.85e-08 $layer=M1 $thickness=3.6e-08 $X=0.5125
+ $Y=0.1715 $X2=0.5125 $Y2=0.19
r12 38 39 3.69013 $w=1.4e-08 $l=1.85e-08 $layer=M1 $thickness=3.6e-08 $X=0.5125
+ $Y=0.153 $X2=0.5125 $Y2=0.1715
r13 37 38 4.1888 $w=1.4e-08 $l=2.1e-08 $layer=M1 $thickness=3.6e-08 $X=0.5125
+ $Y=0.132 $X2=0.5125 $Y2=0.153
r14 36 37 4.88693 $w=1.4e-08 $l=2.45e-08 $layer=M1 $thickness=3.6e-08 $X=0.5125
+ $Y=0.1075 $X2=0.5125 $Y2=0.132
r15 15 36 2.89227 $w=1.4e-08 $l=1.45e-08 $layer=M1 $thickness=3.6e-08 $X=0.5125
+ $Y=0.093 $X2=0.5125 $Y2=0.1075
r16 3 33 10.904 $w=2.02e-08 $l=1.85e-08 $layer=LISD $thickness=2.7e-08 $X=0.486
+ $Y=0.0635 $X2=0.486 $Y2=0.082
r17 3 35 13.5563 $w=2.02e-08 $l=2.3e-08 $layer=LISD $thickness=2.7e-08 $X=0.486
+ $Y=0.0635 $X2=0.486 $Y2=0.0405
r18 13 32 1.37684 $w=2.03185e-08 $l=1.35e-08 $layer=M1 $thickness=3.6e-08
+ $X=0.5125 $Y=0.082 $X2=0.499 $Y2=0.082
r19 13 15 0.843012 $w=1.80909e-08 $l=1.1e-08 $layer=M1 $thickness=3.6e-08
+ $X=0.5125 $Y=0.082 $X2=0.5125 $Y2=0.093
r20 31 32 3.03147 $w=1.3e-08 $l=1.3e-08 $layer=M1 $thickness=3.6e-08 $X=0.486
+ $Y=0.082 $X2=0.499 $Y2=0.082
r21 31 33 19.3796 $a=3.24e-16 $layer=V0LISD $X=0.486 $Y=0.082 $X2=0.486
+ $Y2=0.082
r22 30 31 2.56509 $w=1.3e-08 $l=1.1e-08 $layer=M1 $thickness=3.6e-08 $X=0.475
+ $Y=0.082 $X2=0.486 $Y2=0.082
r23 29 30 3.49785 $w=1.3e-08 $l=1.5e-08 $layer=M1 $thickness=3.6e-08 $X=0.46
+ $Y=0.082 $X2=0.475 $Y2=0.082
r24 28 29 6.7625 $w=1.3e-08 $l=2.9e-08 $layer=M1 $thickness=3.6e-08 $X=0.431
+ $Y=0.082 $X2=0.46 $Y2=0.082
r25 27 28 3.84763 $w=1.3e-08 $l=1.65e-08 $layer=M1 $thickness=3.6e-08 $X=0.4145
+ $Y=0.082 $X2=0.431 $Y2=0.082
r26 25 27 2.09871 $w=1.3e-08 $l=9e-09 $layer=M1 $thickness=3.6e-08 $X=0.4055
+ $Y=0.082 $X2=0.4145 $Y2=0.082
r27 14 25 2.09871 $w=1.3e-08 $l=9e-09 $layer=M1 $thickness=3.6e-08 $X=0.3965
+ $Y=0.082 $X2=0.4055 $Y2=0.082
r28 22 25 19.3796 $a=3.24e-16 $layer=V0LIG $X=0.406 $Y=0.082 $X2=0.4055
+ $Y2=0.082
r29 1 22 2.6116 $w=2.2e-08 $l=1e-08 $layer=LIG $thickness=4.8e-08 $X=0.396
+ $Y=0.082 $X2=0.406 $Y2=0.082
r30 20 19 25.5104 $w=2.1e-08 $l=7.5e-08 $layer=Gate_1 $thickness=5.6e-08
+ $X=0.405 $Y=0.2295 $X2=0.405 $Y2=0.1545
r31 18 19 24.8471 $w=2.08483e-08 $l=7.25e-08 $layer=Gate_1 $thickness=5.6e-08
+ $X=0.405 $Y=0.082 $X2=0.405 $Y2=0.1545
r32 18 22 6.27904 $w=2.09e-08 $l=1e-09 $layer=Gate_1 $thickness=5.24e-08
+ $X=0.405 $Y=0.082 $X2=0.406 $Y2=0.082
r33 17 18 6.81977 $w=2.04359e-08 $l=1.95e-08 $layer=Gate_1 $thickness=5.6e-08
+ $X=0.405 $Y=0.0625 $X2=0.405 $Y2=0.082
r34 16 17 7.48304 $w=2.1e-08 $l=2.2e-08 $layer=Gate_1 $thickness=5.6e-08
+ $X=0.405 $Y=0.0405 $X2=0.405 $Y2=0.0625
r35 16 9 5.44221 $w=2.1e-08 $l=1.6e-08 $layer=Gate_1 $thickness=5.6e-08
+ $X=0.405 $Y=0.0405 $X2=0.405 $Y2=0.0245
.ends

.subckt PM_ICGx3_ASAP7_75t_R%10 vss 25 29 44 47 51 55 68 69 77 78 81 82 15 16
+ 22 3 5 21 4 17 18 1 24 12 14 13 20 19
c1 1 vss 0.0136006f $X=0.8815 $Y=0.136
c2 3 vss 0.00754441f $X=0.702 $Y=0.216
c3 4 vss 0.00475648f $X=0.756 $Y=0.0675
c4 5 vss 0.00717402f $X=0.81 $Y=0.216
c5 12 vss 0.1139f $X=0.891 $Y=0.0245
c6 13 vss 0.080498f $X=0.945 $Y=0.136
c7 14 vss 0.0856964f $X=0.999 $Y=0.136
c8 15 vss 0.00659232f $X=0.7415 $Y=0.0675
c9 16 vss 0.00655748f $X=0.6875 $Y=0.216
c10 17 vss 0.00649437f $X=0.7955 $Y=0.216
c11 18 vss 0.00343512f $X=0.837 $Y=0.192
c12 19 vss 0.000880118f $X=0.891 $Y=0.072
c13 20 vss 0.00103403f $X=0.891 $Y=0.197
c14 21 vss 0.0134916f $X=0.783 $Y=0.231
c15 22 vss 0.00736022f $X=0.8805 $Y=0.072
c16 23 vss 0.00183019f $X=0.864 $Y=0.197
c17 24 vss 0.00375623f $X=0.891 $Y=0.113
r1 82 80 0.0462963 $w=5.4e-08 $l=2.5e-09 $layer=P_src_drn $thickness=1e-09
+ $X=0.7193 $Y=0.216 $X2=0.7165 $Y2=0.216
r2 3 80 0.268519 $w=5.4e-08 $l=1.45e-08 $layer=P_src_drn $thickness=1e-09
+ $X=0.702 $Y=0.216 $X2=0.7165 $Y2=0.216
r3 16 3 0.268519 $w=5.4e-08 $l=1.45e-08 $layer=P_src_drn $thickness=1e-09
+ $X=0.6875 $Y=0.216 $X2=0.702 $Y2=0.216
r4 81 16 0.0462963 $w=5.4e-08 $l=2.5e-09 $layer=P_src_drn $thickness=1e-09
+ $X=0.6846 $Y=0.216 $X2=0.6875 $Y2=0.216
r5 78 76 0.0462963 $w=5.4e-08 $l=2.5e-09 $layer=P_src_drn $thickness=1e-09
+ $X=0.8273 $Y=0.216 $X2=0.8245 $Y2=0.216
r6 5 76 0.268519 $w=5.4e-08 $l=1.45e-08 $layer=P_src_drn $thickness=1e-09
+ $X=0.81 $Y=0.216 $X2=0.8245 $Y2=0.216
r7 17 5 0.268519 $w=5.4e-08 $l=1.45e-08 $layer=P_src_drn $thickness=1e-09
+ $X=0.7955 $Y=0.216 $X2=0.81 $Y2=0.216
r8 77 17 0.0462963 $w=5.4e-08 $l=2.5e-09 $layer=P_src_drn $thickness=1e-09
+ $X=0.7926 $Y=0.216 $X2=0.7955 $Y2=0.216
r9 3 73 19.3796 $a=3.24e-16 $layer=V0LISD $X=0.702 $Y=0.216 $X2=0.702 $Y2=0.231
r10 5 70 19.3796 $a=3.24e-16 $layer=V0LISD $X=0.81 $Y=0.216 $X2=0.81 $Y2=0.231
r11 73 74 8.39483 $w=1.3e-08 $l=3.6e-08 $layer=M1 $thickness=3.6e-08 $X=0.702
+ $Y=0.231 $X2=0.738 $Y2=0.231
r12 70 71 3.14806 $w=1.3e-08 $l=1.35e-08 $layer=M1 $thickness=3.6e-08 $X=0.81
+ $Y=0.231 $X2=0.8235 $Y2=0.231
r13 21 70 6.29612 $w=1.3e-08 $l=2.7e-08 $layer=M1 $thickness=3.6e-08 $X=0.783
+ $Y=0.231 $X2=0.81 $Y2=0.231
r14 21 74 10.4935 $w=1.3e-08 $l=4.5e-08 $layer=M1 $thickness=3.6e-08 $X=0.783
+ $Y=0.231 $X2=0.738 $Y2=0.231
r15 68 67 0.0308642 $w=8.1e-08 $l=2.5e-09 $layer=N_src_drn $thickness=1e-09
+ $X=0.7733 $Y=0.0675 $X2=0.7705 $Y2=0.0675
r16 4 67 0.179012 $w=8.1e-08 $l=1.45e-08 $layer=N_src_drn $thickness=1e-09
+ $X=0.756 $Y=0.0675 $X2=0.7705 $Y2=0.0675
r17 15 4 0.179012 $w=8.1e-08 $l=1.45e-08 $layer=N_src_drn $thickness=1e-09
+ $X=0.7415 $Y=0.0675 $X2=0.756 $Y2=0.0675
r18 69 15 0.0308642 $w=8.1e-08 $l=2.5e-09 $layer=N_src_drn $thickness=1e-09
+ $X=0.7386 $Y=0.0675 $X2=0.7415 $Y2=0.0675
r19 64 71 1.20242 $w=1.425e-08 $l=1.54434e-08 $layer=M1 $thickness=3.6e-08
+ $X=0.837 $Y=0.2235 $X2=0.8235 $Y2=0.231
r20 63 64 2.01858 $w=1.37895e-08 $l=9.5e-09 $layer=M1 $thickness=3.6e-08
+ $X=0.837 $Y=0.214 $X2=0.837 $Y2=0.2235
r21 62 63 2.37574 $w=1.49231e-08 $l=1.3e-08 $layer=M1 $thickness=3.6e-08
+ $X=0.837 $Y=0.201 $X2=0.837 $Y2=0.214
r22 18 23 4.60559 $w=1.39091e-08 $l=2.74591e-08 $layer=M1 $thickness=3.6e-08
+ $X=0.837 $Y=0.192 $X2=0.864 $Y2=0.197
r23 18 62 0.9184 $w=1.8e-08 $l=9e-09 $layer=M1 $thickness=3.6e-08 $X=0.837
+ $Y=0.192 $X2=0.837 $Y2=0.201
r24 4 60 19.3796 $a=3.24e-16 $layer=V0LISD $X=0.756 $Y=0.0675 $X2=0.756
+ $Y2=0.072
r25 60 61 9.44419 $w=1.3e-08 $l=4.05e-08 $layer=M1 $thickness=3.6e-08 $X=0.756
+ $Y=0.072 $X2=0.7965 $Y2=0.072
r26 58 61 9.44419 $w=1.3e-08 $l=4.05e-08 $layer=M1 $thickness=3.6e-08 $X=0.837
+ $Y=0.072 $X2=0.7965 $Y2=0.072
r27 57 58 5.94634 $w=1.3e-08 $l=2.55e-08 $layer=M1 $thickness=3.6e-08 $X=0.8625
+ $Y=0.072 $X2=0.837 $Y2=0.072
r28 22 57 4.19742 $w=1.3e-08 $l=1.8e-08 $layer=M1 $thickness=3.6e-08 $X=0.8805
+ $Y=0.072 $X2=0.8625 $Y2=0.072
r29 20 42 5.22999 $w=1.59898e-08 $l=2.95e-08 $layer=M1 $thickness=3.6e-08
+ $X=0.891 $Y=0.197 $X2=0.891 $Y2=0.1675
r30 20 23 4.64701 $w=1.46667e-08 $l=2.7e-08 $layer=M1 $thickness=3.6e-08
+ $X=0.891 $Y=0.197 $X2=0.864 $Y2=0.197
r31 19 41 2.5483 $w=1.79e-08 $l=1.8e-08 $layer=M1 $thickness=3.6e-08 $X=0.891
+ $Y=0.072 $X2=0.891 $Y2=0.09
r32 19 22 0.79938 $w=1.72857e-08 $l=1.05e-08 $layer=M1 $thickness=3.6e-08
+ $X=0.891 $Y=0.072 $X2=0.8805 $Y2=0.072
r33 55 54 14.6259 $w=2.1e-08 $l=4.3e-08 $layer=Gate_1 $thickness=5.6e-08
+ $X=0.999 $Y=0.2025 $X2=0.999 $Y2=0.1595
r34 53 54 2.55104 $w=2.1e-08 $l=7.5e-09 $layer=Gate_1 $thickness=5.6e-08
+ $X=0.999 $Y=0.152 $X2=0.999 $Y2=0.1595
r35 51 52 14.6259 $w=2.1e-08 $l=4.3e-08 $layer=Gate_1 $thickness=5.6e-08
+ $X=0.999 $Y=0.0675 $X2=0.999 $Y2=0.1105
r36 49 52 2.89117 $w=2.1e-08 $l=8.5e-09 $layer=Gate_1 $thickness=5.6e-08
+ $X=0.999 $Y=0.119 $X2=0.999 $Y2=0.1105
r37 14 37 6.54019 $w=2.09524e-08 $layer=Gate_1 $thickness=5.21905e-08 $X=0.999
+ $Y=0.136 $X2=0.999 $Y2=0.136
r38 14 49 5.96942 $w=2.03529e-08 $l=1.7e-08 $layer=Gate_1 $thickness=5.6e-08
+ $X=0.999 $Y=0.136 $X2=0.999 $Y2=0.119
r39 14 53 5.62929 $w=2.03125e-08 $l=1.6e-08 $layer=Gate_1 $thickness=5.6e-08
+ $X=0.999 $Y=0.136 $X2=0.999 $Y2=0.152
r40 47 46 16.3266 $w=2.1e-08 $l=4.8e-08 $layer=Gate_1 $thickness=5.6e-08
+ $X=0.945 $Y=0.2025 $X2=0.945 $Y2=0.1545
r41 44 45 16.6668 $w=2.1e-08 $l=4.9e-08 $layer=Gate_1 $thickness=5.6e-08
+ $X=0.945 $Y=0.0675 $X2=0.945 $Y2=0.1165
r42 13 35 6.54019 $w=2.09524e-08 $layer=Gate_1 $thickness=5.21905e-08 $X=0.945
+ $Y=0.136 $X2=0.945 $Y2=0.136
r43 13 45 6.81977 $w=2.04359e-08 $l=1.95e-08 $layer=Gate_1 $thickness=5.6e-08
+ $X=0.945 $Y=0.136 $X2=0.945 $Y2=0.1165
r44 13 46 6.47963 $w=2.04054e-08 $l=1.85e-08 $layer=Gate_1 $thickness=5.6e-08
+ $X=0.945 $Y=0.136 $X2=0.945 $Y2=0.1545
r45 40 42 5.01358 $w=1.3e-08 $l=2.15e-08 $layer=M1 $thickness=3.6e-08 $X=0.891
+ $Y=0.146 $X2=0.891 $Y2=0.1675
r46 39 40 2.3319 $w=1.3e-08 $l=1e-08 $layer=M1 $thickness=3.6e-08 $X=0.891
+ $Y=0.136 $X2=0.891 $Y2=0.146
r47 24 39 5.36336 $w=1.3e-08 $l=2.3e-08 $layer=M1 $thickness=3.6e-08 $X=0.891
+ $Y=0.113 $X2=0.891 $Y2=0.136
r48 24 41 5.36336 $w=1.3e-08 $l=2.3e-08 $layer=M1 $thickness=3.6e-08 $X=0.891
+ $Y=0.113 $X2=0.891 $Y2=0.09
r49 36 37 12.6539 $w=1.77815e-08 $l=2.7e-08 $layer=LIG $thickness=4.8e-08
+ $X=0.972 $Y=0.136 $X2=0.999 $Y2=0.136
r50 35 36 12.6539 $w=1.77815e-08 $l=2.7e-08 $layer=LIG $thickness=4.8e-08
+ $X=0.945 $Y=0.136 $X2=0.972 $Y2=0.136
r51 34 35 12.6539 $w=1.77815e-08 $l=2.7e-08 $layer=LIG $thickness=4.8e-08
+ $X=0.918 $Y=0.136 $X2=0.945 $Y2=0.136
r52 32 34 10.1729 $w=1.54914e-08 $l=1.75e-08 $layer=LIG $thickness=4.8e-08
+ $X=0.9005 $Y=0.136 $X2=0.918 $Y2=0.136
r53 31 32 2.48102 $w=2.2e-08 $l=9.5e-09 $layer=LIG $thickness=4.8e-08 $X=0.891
+ $Y=0.136 $X2=0.9005 $Y2=0.136
r54 31 39 19.3796 $a=3.24e-16 $layer=V0LIG $X=0.891 $Y=0.136 $X2=0.891 $Y2=0.136
r55 1 31 2.48102 $w=2.2e-08 $l=9.5e-09 $layer=LIG $thickness=4.8e-08 $X=0.8815
+ $Y=0.136 $X2=0.891 $Y2=0.136
r56 29 28 16.3266 $w=2.1e-08 $l=4.8e-08 $layer=Gate_1 $thickness=5.6e-08
+ $X=0.891 $Y=0.2025 $X2=0.891 $Y2=0.1545
r57 27 28 6.47963 $w=2.04054e-08 $l=1.85e-08 $layer=Gate_1 $thickness=5.6e-08
+ $X=0.891 $Y=0.136 $X2=0.891 $Y2=0.1545
r58 27 32 4.05918 $w=2.0087e-08 $l=9.5e-09 $layer=Gate_1 $thickness=5.56522e-08
+ $X=0.891 $Y=0.136 $X2=0.9005 $Y2=0.136
r59 27 31 6.27904 $w=2.09e-08 $layer=Gate_1 $thickness=5.24e-08 $X=0.891
+ $Y=0.136 $X2=0.891 $Y2=0.136
r60 26 27 6.81977 $w=2.04359e-08 $l=1.95e-08 $layer=Gate_1 $thickness=5.6e-08
+ $X=0.891 $Y=0.1165 $X2=0.891 $Y2=0.136
r61 25 26 16.6668 $w=2.1e-08 $l=4.9e-08 $layer=Gate_1 $thickness=5.6e-08
+ $X=0.891 $Y=0.0675 $X2=0.891 $Y2=0.1165
r62 25 12 14.6259 $w=2.1e-08 $l=4.3e-08 $layer=Gate_1 $thickness=5.6e-08
+ $X=0.891 $Y=0.0675 $X2=0.891 $Y2=0.0245
.ends

.subckt PM_ICGx3_ASAP7_75t_R%12 vss 7 9 4 5 1
c1 1 vss 0.00812121f $X=0.243 $Y=0.0675
c2 4 vss 0.00293441f $X=0.2015 $Y=0.0675
c3 5 vss 0.00176742f $X=0.272 $Y=0.0675
r1 9 8 0.0308642 $w=8.1e-08 $l=2.5e-09 $layer=N_src_drn $thickness=1e-09
+ $X=0.2873 $Y=0.0675 $X2=0.2845 $Y2=0.0675
r2 5 8 0.154321 $w=8.1e-08 $l=1.25e-08 $layer=N_src_drn $thickness=1e-09
+ $X=0.272 $Y=0.0675 $X2=0.2845 $Y2=0.0675
r3 4 1 0.154321 $w=8.1e-08 $l=1.25e-08 $layer=N_src_drn $thickness=1e-09
+ $X=0.2015 $Y=0.0675 $X2=0.243 $Y2=0.0675
r4 7 4 0.0308642 $w=8.1e-08 $l=2.5e-09 $layer=N_src_drn $thickness=1e-09
+ $X=0.1986 $Y=0.0675 $X2=0.2015 $Y2=0.0675
r5 1 5 1e-05 $l=2.9e-08 $X=0.243 $Y=0.0675 $X2=0.272 $Y2=0.0675
.ends

.subckt PM_ICGx3_ASAP7_75t_R%13 vss 6 7 3 1
c1 1 vss 0.00454254f $X=0.216 $Y=0.2025
c2 3 vss 0.00308269f $X=0.2015 $Y=0.2025
r1 7 5 0.0308642 $w=8.1e-08 $l=2.5e-09 $layer=P_src_drn $thickness=1e-09
+ $X=0.2333 $Y=0.2025 $X2=0.2305 $Y2=0.2025
r2 1 5 0.179012 $w=8.1e-08 $l=1.45e-08 $layer=P_src_drn $thickness=1e-09
+ $X=0.216 $Y=0.2025 $X2=0.2305 $Y2=0.2025
r3 3 1 0.179012 $w=8.1e-08 $l=1.45e-08 $layer=P_src_drn $thickness=1e-09
+ $X=0.2015 $Y=0.2025 $X2=0.216 $Y2=0.2025
r4 6 3 0.0308642 $w=8.1e-08 $l=2.5e-09 $layer=P_src_drn $thickness=1e-09
+ $X=0.1986 $Y=0.2025 $X2=0.2015 $Y2=0.2025
.ends

.subckt PM_ICGx3_ASAP7_75t_R%14 vss 7 12 4 1 5
c1 1 vss 0.00605602f $X=0.324 $Y=0.2295
c2 4 vss 0.00168636f $X=0.3095 $Y=0.2295
c3 5 vss 0.002078f $X=0.38 $Y=0.2295
r1 12 11 0.0925926 $w=2.7e-08 $l=2.5e-09 $layer=P_src_drn $thickness=1e-09
+ $X=0.3953 $Y=0.2295 $X2=0.3925 $Y2=0.2295
r2 5 11 0.462963 $w=2.7e-08 $l=1.25e-08 $layer=P_src_drn $thickness=1e-09
+ $X=0.38 $Y=0.2295 $X2=0.3925 $Y2=0.2295
r3 9 5 9.87715 $w=2.32e-08 $l=2.1e-08 $layer=LISD $thickness=2.7e-08 $X=0.357
+ $Y=0.2295 $X2=0.38 $Y2=0.2295
r4 8 9 7.05511 $w=2.32e-08 $l=1.5e-08 $layer=LISD $thickness=2.7e-08 $X=0.342
+ $Y=0.2295 $X2=0.357 $Y2=0.2295
r5 1 8 8.46613 $w=2.32e-08 $l=1.8e-08 $layer=LISD $thickness=2.7e-08 $X=0.324
+ $Y=0.2295 $X2=0.342 $Y2=0.2295
r6 4 1 0.462963 $w=2.7e-08 $l=1.25e-08 $layer=P_src_drn $thickness=1e-09
+ $X=0.3095 $Y=0.2295 $X2=0.324 $Y2=0.2295
r7 7 4 0.0925926 $w=2.7e-08 $l=2.5e-09 $layer=P_src_drn $thickness=1e-09
+ $X=0.3066 $Y=0.2295 $X2=0.3095 $Y2=0.2295
.ends

.subckt PM_ICGx3_ASAP7_75t_R%15 vss 6 7 3 1
c1 1 vss 0.00266751f $X=0.378 $Y=0.0405
c2 3 vss 0.00214291f $X=0.3635 $Y=0.0405
r1 7 5 0.0925926 $w=2.7e-08 $l=2.5e-09 $layer=N_src_drn $thickness=1e-09
+ $X=0.3953 $Y=0.0405 $X2=0.3925 $Y2=0.0405
r2 1 5 0.537037 $w=2.7e-08 $l=1.45e-08 $layer=N_src_drn $thickness=1e-09
+ $X=0.378 $Y=0.0405 $X2=0.3925 $Y2=0.0405
r3 3 1 0.537037 $w=2.7e-08 $l=1.45e-08 $layer=N_src_drn $thickness=1e-09
+ $X=0.3635 $Y=0.0405 $X2=0.378 $Y2=0.0405
r4 6 3 0.0925926 $w=2.7e-08 $l=2.5e-09 $layer=N_src_drn $thickness=1e-09
+ $X=0.3606 $Y=0.0405 $X2=0.3635 $Y2=0.0405
.ends

.subckt PM_ICGx3_ASAP7_75t_R%16__2 vss 2 3 1
c1 1 vss 0.000765808f $X=0.702 $Y=0.0675
r1 2 1 0.209877 $w=8.1e-08 $l=1.7e-08 $layer=N_src_drn $thickness=1e-09
+ $X=0.6846 $Y=0.0675 $X2=0.702 $Y2=0.0675
r2 3 1 0.209877 $w=8.1e-08 $l=1.7e-08 $layer=N_src_drn $thickness=1e-09
+ $X=0.7193 $Y=0.0675 $X2=0.702 $Y2=0.0675
.ends

.subckt PM_ICGx3_ASAP7_75t_R%17 vss 2 3 1
c1 1 vss 0.000753976f $X=0.81 $Y=0.0675
r1 2 1 0.209877 $w=8.1e-08 $l=1.7e-08 $layer=N_src_drn $thickness=1e-09
+ $X=0.7926 $Y=0.0675 $X2=0.81 $Y2=0.0675
r2 3 1 0.209877 $w=8.1e-08 $l=1.7e-08 $layer=N_src_drn $thickness=1e-09
+ $X=0.8273 $Y=0.0675 $X2=0.81 $Y2=0.0675
.ends

.subckt PM_ICGx3_ASAP7_75t_R%9 vss 34 38 60 63 85 88 102 105 114 117 16 23 22
+ 29 27 18 21 24 33 7 19 25 3 1 31 32 17 26 28 30 13 8 2 15 14
c1 1 vss 0.00289956f $X=0.459 $Y=0.19
c2 2 vss 0.00411818f $X=0.675 $Y=0.135
c3 3 vss 0.00398623f $X=0.837 $Y=0.135
c4 7 vss 0.00481978f $X=0.27 $Y=0.2295
c5 8 vss 0.00424042f $X=0.324 $Y=0.0405
c6 13 vss 0.0499461f $X=0.459 $Y=0.19
c7 14 vss 0.0938196f $X=0.675 $Y=0.135
c8 15 vss 0.093849f $X=0.837 $Y=0.0245
c9 16 vss 0.00214754f $X=0.3095 $Y=0.0405
c10 17 vss 0.00083691f $X=0.3095 $Y=0.081
c11 18 vss 0.00211613f $X=0.2555 $Y=0.2295
c12 19 vss 0.000827834f $X=0.2555 $Y=0.189
c13 20 vss 0.0020394f $X=0.358 $Y=0.036
c14 21 vss 0.000137641f $X=0.358 $Y=0.1895
c15 22 vss 0.00254329f $X=0.358 $Y=0.2235
c16 23 vss 0.00312217f $X=0.675 $Y=0.036
c17 24 vss 0.000751426f $X=0.675 $Y=0.1075
c18 25 vss 0.00112007f $X=0.837 $Y=0.1205
c19 26 vss 0.00763994f $X=0.3365 $Y=0.232
c20 27 vss 0.00395859f $X=0.3285 $Y=0.036
c21 28 vss 0.000881669f $X=0.358 $Y=0.0585
c22 29 vss 0.000436081f $X=0.358 $Y=0.211
c23 30 vss 0.0266725f $X=0.648 $Y=0.036
c24 31 vss 0.00207428f $X=0.3795 $Y=0.19
c25 32 vss 0.00217399f $X=0.675 $Y=0.097
c26 33 vss 0.0020005f $X=0.7965 $Y=0.108
r1 19 112 0.231482 $w=5.4e-08 $l=1.25e-08 $layer=P_src_drn $thickness=1e-09
+ $X=0.2555 $Y=0.189 $X2=0.27 $Y2=0.189
r2 117 116 0.0925926 $w=2.7e-08 $l=2.5e-09 $layer=P_src_drn $thickness=1e-09
+ $X=0.2873 $Y=0.2295 $X2=0.2845 $Y2=0.2295
r3 115 116 0.166667 $w=2.7e-08 $l=4.5e-09 $layer=P_src_drn $thickness=1e-09
+ $X=0.28 $Y=0.2295 $X2=0.2845 $Y2=0.2295
r4 112 115 0.444445 $w=2.7e-08 $l=1.2e-08 $layer=P_src_drn $thickness=1e-09
+ $X=0.27 $Y=0.189 $X2=0.28 $Y2=0.2295
r5 18 112 0.462963 $w=2.7e-08 $l=1.25e-08 $layer=P_src_drn $thickness=1e-09
+ $X=0.2555 $Y=0.2295 $X2=0.27 $Y2=0.189
r6 114 18 0.0925926 $w=2.7e-08 $l=2.5e-09 $layer=P_src_drn $thickness=1e-09
+ $X=0.2526 $Y=0.2025 $X2=0.2555 $Y2=0.2295
r7 7 109 19.3796 $a=3.24e-16 $layer=V0LISD $X=0.27 $Y=0.2295 $X2=0.27 $Y2=0.232
r8 7 112 23.8708 $w=2.02e-08 $l=4.05e-08 $layer=LISD $thickness=2.7e-08 $X=0.27
+ $Y=0.2295 $X2=0.27 $Y2=0.189
r9 109 110 3.14806 $w=1.3e-08 $l=1.35e-08 $layer=M1 $thickness=3.6e-08 $X=0.27
+ $Y=0.232 $X2=0.2835 $Y2=0.232
r10 107 110 5.24677 $w=1.3e-08 $l=2.25e-08 $layer=M1 $thickness=3.6e-08
+ $X=0.306 $Y=0.232 $X2=0.2835 $Y2=0.232
r11 26 107 7.11229 $w=1.3e-08 $l=3.05e-08 $layer=M1 $thickness=3.6e-08
+ $X=0.3365 $Y=0.232 $X2=0.306 $Y2=0.232
r12 105 104 7.31297 $w=2.1e-08 $l=2.15e-08 $layer=Gate_1 $thickness=5.6e-08
+ $X=0.459 $Y=0.2295 $X2=0.459 $Y2=0.208
r13 102 103 14.6259 $w=2.1e-08 $l=4.3e-08 $layer=Gate_1 $thickness=5.6e-08
+ $X=0.459 $Y=0.0405 $X2=0.459 $Y2=0.0835
r14 100 103 17.5171 $w=2.1e-08 $l=5.15e-08 $layer=Gate_1 $thickness=5.6e-08
+ $X=0.459 $Y=0.135 $X2=0.459 $Y2=0.0835
r15 99 100 11.3946 $w=2.1e-08 $l=3.35e-08 $layer=Gate_1 $thickness=5.6e-08
+ $X=0.459 $Y=0.1685 $X2=0.459 $Y2=0.135
r16 13 99 7.48304 $w=2.05349e-08 $l=2.15e-08 $layer=Gate_1 $thickness=5.6e-08
+ $X=0.459 $Y=0.19 $X2=0.459 $Y2=0.1685
r17 13 104 6.29255 $w=2.04444e-08 $l=1.8e-08 $layer=Gate_1 $thickness=5.6e-08
+ $X=0.459 $Y=0.19 $X2=0.459 $Y2=0.208
r18 22 29 2.8493 $w=1.32e-08 $l=1.25e-08 $layer=M1 $thickness=3.6e-08 $X=0.358
+ $Y=0.2235 $X2=0.358 $Y2=0.211
r19 22 26 2.96589 $w=1.31923e-08 $l=2.31193e-08 $layer=M1 $thickness=3.6e-08
+ $X=0.358 $Y=0.2235 $X2=0.3365 $Y2=0.232
r20 1 94 19.3796 $a=3.24e-16 $layer=V0LIG $X=0.459 $Y=0.19 $X2=0.459 $Y2=0.19
r21 1 13 6.74717 $w=2e-08 $layer=Gate_1 $thickness=5.2e-08 $X=0.459 $Y=0.19
+ $X2=0.459 $Y2=0.19
r22 29 83 2.8493 $w=1.32e-08 $l=1.25e-08 $layer=M1 $thickness=3.6e-08 $X=0.358
+ $Y=0.211 $X2=0.358 $Y2=0.1985
r23 93 94 2.44849 $w=1.3e-08 $l=1.05e-08 $layer=M1 $thickness=3.6e-08 $X=0.4485
+ $Y=0.19 $X2=0.459 $Y2=0.19
r24 92 93 4.19742 $w=1.3e-08 $l=1.8e-08 $layer=M1 $thickness=3.6e-08 $X=0.4305
+ $Y=0.19 $X2=0.4485 $Y2=0.19
r25 91 92 5.94634 $w=1.3e-08 $l=2.55e-08 $layer=M1 $thickness=3.6e-08 $X=0.405
+ $Y=0.19 $X2=0.4305 $Y2=0.19
r26 90 91 2.56509 $w=1.3e-08 $l=1.1e-08 $layer=M1 $thickness=3.6e-08 $X=0.394
+ $Y=0.19 $X2=0.405 $Y2=0.19
r27 31 90 3.38125 $w=1.3e-08 $l=1.45e-08 $layer=M1 $thickness=3.6e-08 $X=0.3795
+ $Y=0.19 $X2=0.394 $Y2=0.19
r28 17 81 0.231482 $w=5.4e-08 $l=1.25e-08 $layer=N_src_drn $thickness=1e-09
+ $X=0.3095 $Y=0.081 $X2=0.324 $Y2=0.074
r29 88 87 0.0925926 $w=2.7e-08 $l=2.5e-09 $layer=N_src_drn $thickness=1e-09
+ $X=0.3413 $Y=0.0405 $X2=0.3385 $Y2=0.0405
r30 86 87 0.166667 $w=2.7e-08 $l=4.5e-09 $layer=N_src_drn $thickness=1e-09
+ $X=0.334 $Y=0.0405 $X2=0.3385 $Y2=0.0405
r31 81 86 0.444445 $w=2.7e-08 $l=1.2e-08 $layer=N_src_drn $thickness=1e-09
+ $X=0.324 $Y=0.074 $X2=0.334 $Y2=0.0405
r32 16 81 0.462963 $w=2.7e-08 $l=1.25e-08 $layer=N_src_drn $thickness=1e-09
+ $X=0.3095 $Y=0.0405 $X2=0.324 $Y2=0.074
r33 85 16 0.0925926 $w=2.7e-08 $l=2.5e-09 $layer=N_src_drn $thickness=1e-09
+ $X=0.3066 $Y=0.0675 $X2=0.3095 $Y2=0.0405
r34 21 80 0.983973 $w=1.77222e-08 $l=9e-09 $layer=M1 $thickness=3.6e-08
+ $X=0.358 $Y=0.1895 $X2=0.358 $Y2=0.1805
r35 21 83 0.9184 $w=1.8e-08 $l=9e-09 $layer=M1 $thickness=3.6e-08 $X=0.358
+ $Y=0.1895 $X2=0.358 $Y2=0.1985
r36 21 31 3.78225 $w=1.50238e-08 $l=2.15058e-08 $layer=M1 $thickness=3.6e-08
+ $X=0.358 $Y=0.1895 $X2=0.3795 $Y2=0.19
r37 8 73 19.3796 $a=3.24e-16 $layer=V0LISD $X=0.324 $Y=0.0405 $X2=0.3195
+ $Y2=0.036
r38 8 81 19.745 $w=2.02e-08 $l=3.35e-08 $layer=LISD $thickness=2.7e-08 $X=0.324
+ $Y=0.0405 $X2=0.324 $Y2=0.074
r39 79 80 2.2153 $w=1.3e-08 $l=9.5e-09 $layer=M1 $thickness=3.6e-08 $X=0.358
+ $Y=0.171 $X2=0.358 $Y2=0.1805
r40 78 79 6.99569 $w=1.3e-08 $l=3e-08 $layer=M1 $thickness=3.6e-08 $X=0.358
+ $Y=0.141 $X2=0.358 $Y2=0.171
r41 77 78 8.27824 $w=1.3e-08 $l=3.55e-08 $layer=M1 $thickness=3.6e-08 $X=0.358
+ $Y=0.1055 $X2=0.358 $Y2=0.141
r42 76 77 3.49785 $w=1.3e-08 $l=1.5e-08 $layer=M1 $thickness=3.6e-08 $X=0.358
+ $Y=0.0905 $X2=0.358 $Y2=0.1055
r43 75 76 2.09871 $w=1.3e-08 $l=9e-09 $layer=M1 $thickness=3.6e-08 $X=0.358
+ $Y=0.0815 $X2=0.358 $Y2=0.0905
r44 74 75 2.09871 $w=1.3e-08 $l=9e-09 $layer=M1 $thickness=3.6e-08 $X=0.358
+ $Y=0.0725 $X2=0.358 $Y2=0.0815
r45 28 74 3.26466 $w=1.3e-08 $l=1.4e-08 $layer=M1 $thickness=3.6e-08 $X=0.358
+ $Y=0.0585 $X2=0.358 $Y2=0.0725
r46 27 71 2.91487 $w=1.3e-08 $l=1.25e-08 $layer=M1 $thickness=3.6e-08 $X=0.3285
+ $Y=0.036 $X2=0.341 $Y2=0.036
r47 27 73 2.09871 $w=1.3e-08 $l=9e-09 $layer=M1 $thickness=3.6e-08 $X=0.3285
+ $Y=0.036 $X2=0.3195 $Y2=0.036
r48 20 70 3.83327 $w=1.5093e-08 $l=2.15e-08 $layer=M1 $thickness=3.6e-08
+ $X=0.358 $Y=0.036 $X2=0.3795 $Y2=0.036
r49 20 71 2.78392 $w=1.56471e-08 $l=1.7e-08 $layer=M1 $thickness=3.6e-08
+ $X=0.358 $Y=0.036 $X2=0.341 $Y2=0.036
r50 20 28 4.06646 $w=1.5e-08 $l=2.25e-08 $layer=M1 $thickness=3.6e-08 $X=0.358
+ $Y=0.036 $X2=0.358 $Y2=0.0585
r51 69 70 18.0722 $w=1.3e-08 $l=7.75e-08 $layer=M1 $thickness=3.6e-08 $X=0.457
+ $Y=0.036 $X2=0.3795 $Y2=0.036
r52 68 69 19.4713 $w=1.3e-08 $l=8.35e-08 $layer=M1 $thickness=3.6e-08 $X=0.5405
+ $Y=0.036 $X2=0.457 $Y2=0.036
r53 67 68 10.1438 $w=1.3e-08 $l=4.35e-08 $layer=M1 $thickness=3.6e-08 $X=0.584
+ $Y=0.036 $X2=0.5405 $Y2=0.036
r54 66 67 6.17953 $w=1.3e-08 $l=2.65e-08 $layer=M1 $thickness=3.6e-08 $X=0.6105
+ $Y=0.036 $X2=0.584 $Y2=0.036
r55 65 66 2.44849 $w=1.3e-08 $l=1.05e-08 $layer=M1 $thickness=3.6e-08 $X=0.621
+ $Y=0.036 $X2=0.6105 $Y2=0.036
r56 30 65 6.29612 $w=1.3e-08 $l=2.7e-08 $layer=M1 $thickness=3.6e-08 $X=0.648
+ $Y=0.036 $X2=0.621 $Y2=0.036
r57 63 62 16.4967 $w=2.1e-08 $l=4.85e-08 $layer=Gate_1 $thickness=5.6e-08
+ $X=0.675 $Y=0.216 $X2=0.675 $Y2=0.1675
r58 60 61 16.4967 $w=2.1e-08 $l=4.85e-08 $layer=Gate_1 $thickness=5.6e-08
+ $X=0.675 $Y=0.0675 $X2=0.675 $Y2=0.116
r59 14 61 6.6497 $w=2.04211e-08 $l=1.9e-08 $layer=Gate_1 $thickness=5.6e-08
+ $X=0.675 $Y=0.135 $X2=0.675 $Y2=0.116
r60 14 62 11.2416 $w=2.06615e-08 $l=3.25e-08 $layer=Gate_1 $thickness=5.6e-08
+ $X=0.675 $Y=0.135 $X2=0.675 $Y2=0.1675
r61 23 56 2.5483 $w=1.79e-08 $l=1.8e-08 $layer=M1 $thickness=3.6e-08 $X=0.675
+ $Y=0.036 $X2=0.675 $Y2=0.054
r62 23 30 4.64701 $w=1.46667e-08 $l=2.7e-08 $layer=M1 $thickness=3.6e-08
+ $X=0.675 $Y=0.036 $X2=0.648 $Y2=0.036
r63 2 50 19.3796 $a=3.24e-16 $layer=V0LIG $X=0.675 $Y=0.135 $X2=0.675 $Y2=0.133
r64 2 14 6.54019 $w=2.09524e-08 $layer=Gate_1 $thickness=5.21905e-08 $X=0.675
+ $Y=0.135 $X2=0.675 $Y2=0.135
r65 55 56 3.26466 $w=1.3e-08 $l=1.4e-08 $layer=M1 $thickness=3.6e-08 $X=0.675
+ $Y=0.068 $X2=0.675 $Y2=0.054
r66 54 55 1.63233 $w=1.3e-08 $l=7e-09 $layer=M1 $thickness=3.6e-08 $X=0.675
+ $Y=0.075 $X2=0.675 $Y2=0.068
r67 53 54 0.932759 $w=1.3e-08 $l=4e-09 $layer=M1 $thickness=3.6e-08 $X=0.675
+ $Y=0.079 $X2=0.675 $Y2=0.075
r68 52 53 2.09871 $w=1.3e-08 $l=9e-09 $layer=M1 $thickness=3.6e-08 $X=0.675
+ $Y=0.088 $X2=0.675 $Y2=0.079
r69 32 52 2.09871 $w=1.3e-08 $l=9e-09 $layer=M1 $thickness=3.6e-08 $X=0.675
+ $Y=0.097 $X2=0.675 $Y2=0.088
r70 49 50 2.91487 $w=1.3e-08 $l=1.25e-08 $layer=M1 $thickness=3.6e-08 $X=0.675
+ $Y=0.1205 $X2=0.675 $Y2=0.133
r71 48 49 0.867186 $w=1.3625e-08 $l=4e-09 $layer=M1 $thickness=3.6e-08 $X=0.675
+ $Y=0.1165 $X2=0.675 $Y2=0.1205
r72 24 48 0.9184 $w=1.8e-08 $l=9e-09 $layer=M1 $thickness=3.6e-08 $X=0.675
+ $Y=0.1075 $X2=0.675 $Y2=0.1165
r73 24 32 1.33376 $w=1.70476e-08 $l=1.05e-08 $layer=M1 $thickness=3.6e-08
+ $X=0.675 $Y=0.1075 $X2=0.675 $Y2=0.097
r74 47 48 6.81353 $w=1.30847e-08 $l=3.89391e-08 $layer=M1 $thickness=3.6e-08
+ $X=0.713 $Y=0.108 $X2=0.675 $Y2=0.1165
r75 46 47 7.34548 $w=1.3e-08 $l=3.15e-08 $layer=M1 $thickness=3.6e-08 $X=0.7445
+ $Y=0.108 $X2=0.713 $Y2=0.108
r76 45 46 2.68168 $w=1.3e-08 $l=1.15e-08 $layer=M1 $thickness=3.6e-08 $X=0.756
+ $Y=0.108 $X2=0.7445 $Y2=0.108
r77 33 43 8.26388 $w=1.41111e-08 $l=4.05e-08 $layer=M1 $thickness=3.6e-08
+ $X=0.7965 $Y=0.108 $X2=0.837 $Y2=0.108
r78 33 45 9.44419 $w=1.3e-08 $l=4.05e-08 $layer=M1 $thickness=3.6e-08 $X=0.7965
+ $Y=0.108 $X2=0.756 $Y2=0.108
r79 25 42 2.91487 $w=1.3e-08 $l=1.25e-08 $layer=M1 $thickness=3.6e-08 $X=0.837
+ $Y=0.1205 $X2=0.837 $Y2=0.133
r80 25 43 1.73456 $w=1.66e-08 $l=1.25e-08 $layer=M1 $thickness=3.6e-08 $X=0.837
+ $Y=0.1205 $X2=0.837 $Y2=0.108
r81 3 36 6.54019 $w=2.09524e-08 $layer=Gate_1 $thickness=5.21905e-08 $X=0.837
+ $Y=0.135 $X2=0.837 $Y2=0.135
r82 3 42 19.3796 $a=3.24e-16 $layer=V0LIG $X=0.837 $Y=0.135 $X2=0.837 $Y2=0.133
r83 38 37 16.4967 $w=2.1e-08 $l=4.85e-08 $layer=Gate_1 $thickness=5.6e-08
+ $X=0.837 $Y=0.216 $X2=0.837 $Y2=0.1675
r84 36 37 11.2416 $w=2.06615e-08 $l=3.25e-08 $layer=Gate_1 $thickness=5.6e-08
+ $X=0.837 $Y=0.135 $X2=0.837 $Y2=0.1675
r85 35 36 6.6497 $w=2.04211e-08 $l=1.9e-08 $layer=Gate_1 $thickness=5.6e-08
+ $X=0.837 $Y=0.116 $X2=0.837 $Y2=0.135
r86 34 35 16.4967 $w=2.1e-08 $l=4.85e-08 $layer=Gate_1 $thickness=5.6e-08
+ $X=0.837 $Y=0.0675 $X2=0.837 $Y2=0.116
r87 34 15 14.6259 $w=2.1e-08 $l=4.3e-08 $layer=Gate_1 $thickness=5.6e-08
+ $X=0.837 $Y=0.0675 $X2=0.837 $Y2=0.0245
.ends

.subckt PM_ICGx3_ASAP7_75t_R%ENA vss 15 5 11 1 4 3
c1 1 vss 0.00298155f $X=0.081 $Y=0.135
c2 3 vss 0.0423166f $X=0.081 $Y=0.0245
c3 4 vss 0.00954759f $X=0.081 $Y=0.0972
r1 16 17 2.3902 $w=1.3e-08 $l=1.03e-08 $layer=M1 $thickness=3.6e-08 $X=0.081
+ $Y=0.1267 $X2=0.081 $Y2=0.137
r2 15 16 0.408082 $w=1.3e-08 $l=1.7e-09 $layer=M1 $thickness=3.6e-08 $X=0.082
+ $Y=0.125 $X2=0.081 $Y2=0.1267
r3 15 4 6.47102 $w=1.3e-08 $l=2.78e-08 $layer=M1 $thickness=3.6e-08 $X=0.082
+ $Y=0.125 $X2=0.081 $Y2=0.0972
r4 1 8 6.54019 $w=2.09524e-08 $layer=Gate_1 $thickness=5.21905e-08 $X=0.081
+ $Y=0.135 $X2=0.081 $Y2=0.135
r5 1 17 19.3796 $a=3.24e-16 $layer=V0LIG $X=0.081 $Y=0.135 $X2=0.081 $Y2=0.137
r6 11 10 14.6259 $w=2.1e-08 $l=4.3e-08 $layer=Gate_1 $thickness=5.6e-08
+ $X=0.081 $Y=0.216 $X2=0.081 $Y2=0.173
r7 9 10 7.31297 $w=2.1e-08 $l=2.15e-08 $layer=Gate_1 $thickness=5.6e-08
+ $X=0.081 $Y=0.1515 $X2=0.081 $Y2=0.173
r8 8 9 5.79936 $w=2.03333e-08 $l=1.65e-08 $layer=Gate_1 $thickness=5.6e-08
+ $X=0.081 $Y=0.135 $X2=0.081 $Y2=0.1515
r9 7 8 5.79936 $w=2.03333e-08 $l=1.65e-08 $layer=Gate_1 $thickness=5.6e-08
+ $X=0.081 $Y=0.1185 $X2=0.081 $Y2=0.135
r10 6 7 7.31297 $w=2.1e-08 $l=2.15e-08 $layer=Gate_1 $thickness=5.6e-08
+ $X=0.081 $Y=0.097 $X2=0.081 $Y2=0.1185
r11 5 6 14.6259 $w=2.1e-08 $l=4.3e-08 $layer=Gate_1 $thickness=5.6e-08 $X=0.081
+ $Y=0.054 $X2=0.081 $Y2=0.097
r12 5 3 10.0341 $w=2.1e-08 $l=2.95e-08 $layer=Gate_1 $thickness=5.6e-08
+ $X=0.081 $Y=0.054 $X2=0.081 $Y2=0.0245
.ends

.subckt PM_ICGx3_ASAP7_75t_R%18 vss 2 3 1
c1 1 vss 0.00667822f $X=0.108 $Y=0.216
r1 2 1 0.314815 $w=5.4e-08 $l=1.7e-08 $layer=P_src_drn $thickness=1e-09
+ $X=0.0906 $Y=0.216 $X2=0.108 $Y2=0.216
r2 3 1 0.314815 $w=5.4e-08 $l=1.7e-08 $layer=P_src_drn $thickness=1e-09
+ $X=0.1253 $Y=0.216 $X2=0.108 $Y2=0.216
.ends

* End of included file ICGx3_ASAP7_75t_R.pex.sp.pex

*
.subckt ICGx3_ASAP7_75t_CUSTOM_4_25_0_7 VSS VDD ENA SE CLK GCLK
*
* VSS VSS
* VDD VDD
* ENA ENA
* SE SE
* CLK CLK
* GCLK GCLK
*
*

M0 N_M0_d N_M0_g VSS VSS nmos_rvt L=2e-08 W=5.4e-08 nfin=2 $X=0.071 $Y=0.027
M1 VSS N_M1_g N_M1_s VSS nmos_rvt L=2e-08 W=5.4e-08 nfin=2 $X=0.125 $Y=0.027
M2 N_M2_d N_M2_g VSS VSS nmos_rvt L=2e-08 W=8.1e-08 nfin=3 $X=0.179 $Y=0.027
M3 N_M3_d N_M3_g N_M3_s VSS nmos_rvt L=2e-08 W=8.1e-08 nfin=3 $X=0.287 $Y=0.027
M4 N_M4_d N_M4_g N_M4_s VSS nmos_rvt L=2e-08 W=2.7e-08 nfin=1 $X=0.341 $Y=0.027
M5 VSS N_M5_g N_M5_s VSS nmos_rvt L=2e-08 W=2.7e-08 nfin=1 $X=0.395 $Y=0.027
M6 N_M6_d N_M6_g VSS VSS nmos_rvt L=2e-08 W=2.7e-08 nfin=1 $X=0.449 $Y=0.027
M7 VSS N_M7_g N_M7_s VSS nmos_rvt L=2e-08 W=8.1e-08 nfin=3 $X=0.611 $Y=0.027
M8 VSS N_M8_g N_M8_s VSS nmos_rvt L=2e-08 W=8.1e-08 nfin=3 $X=0.665 $Y=0.027
M9 N_M9_d N_M9_g N_M9_s VSS nmos_rvt L=2e-08 W=8.1e-08 nfin=3 $X=0.719 $Y=0.027
M10 N_M10_d N_M10_g N_M10_s VSS nmos_rvt L=2e-08 W=8.1e-08 nfin=3 $X=0.773
+ $Y=0.027
M11 VSS N_M11_g N_M11_s VSS nmos_rvt L=2e-08 W=8.1e-08 nfin=3 $X=0.827 $Y=0.027
M12 N_M12_d N_M12_g VSS VSS nmos_rvt L=2e-08 W=8.1e-08 nfin=3 $X=0.881 $Y=0.027
M13 N_M13_d N_M13_g VSS VSS nmos_rvt L=2e-08 W=8.1e-08 nfin=3 $X=0.935 $Y=0.027
M14 N_M14_d N_M14_g VSS VSS nmos_rvt L=2e-08 W=8.1e-08 nfin=3 $X=0.989 $Y=0.027
M15 N_M15_d N_M15_g N_M15_s VDD pmos_rvt L=2e-08 W=5.4e-08 nfin=2 $X=0.071
+ $Y=0.189
M16 VDD N_M16_g N_M16_s VDD pmos_rvt L=2e-08 W=5.4e-08 nfin=2 $X=0.125 $Y=0.189
M17 N_M17_d N_M17_g VDD VDD pmos_rvt L=2e-08 W=8.1e-08 nfin=3 $X=0.179 $Y=0.162
M18 N_M18_d N_M18_g N_M18_s VDD pmos_rvt L=2e-08 W=8.1e-08 nfin=3 $X=0.233
+ $Y=0.162
M19 N_M19_d N_M19_g N_M19_s VDD pmos_rvt L=2e-08 W=2.7e-08 nfin=1 $X=0.287
+ $Y=0.216
M20 VDD N_M20_g N_M20_s VDD pmos_rvt L=2e-08 W=2.7e-08 nfin=1 $X=0.395 $Y=0.216
M21 N_M21_d N_M21_g VDD VDD pmos_rvt L=2e-08 W=2.7e-08 nfin=1 $X=0.449 $Y=0.216
M22 VDD N_M22_g N_M22_s VDD pmos_rvt L=2e-08 W=8.1e-08 nfin=3 $X=0.611 $Y=0.162
M23 N_M23_d N_M23_g VDD VDD pmos_rvt L=2e-08 W=5.4e-08 nfin=2 $X=0.665 $Y=0.189
M24 VDD N_M24_g N_M24_s VDD pmos_rvt L=2e-08 W=5.4e-08 nfin=2 $X=0.719 $Y=0.189
M25 VDD N_M25_g N_M25_s VDD pmos_rvt L=2e-08 W=5.4e-08 nfin=2 $X=0.773 $Y=0.189
M26 N_M26_d N_M26_g VDD VDD pmos_rvt L=2e-08 W=5.4e-08 nfin=2 $X=0.827 $Y=0.189
M27 N_M27_d N_M27_g VDD VDD pmos_rvt L=2e-08 W=8.1e-08 nfin=3 $X=0.881 $Y=0.162
M28 N_M28_d N_M28_g VDD VDD pmos_rvt L=2e-08 W=8.1e-08 nfin=3 $X=0.935 $Y=0.162
M29 N_M29_d N_M29_g VDD VDD pmos_rvt L=2e-08 W=8.1e-08 nfin=3 $X=0.989 $Y=0.162

* .include "ICGx3_ASAP7_75t_R.pex.sp.pxi"

* Start of included file ICGx3_ASAP7_75t_R.pex.sp.pxi
x_PM_ICGx3_ASAP7_75t_R%5 vss N_M2_g N_M17_g N_M0_d N_M1_s N_M15_s N_5_16 N_5_15
+ N_5_4 N_5_11 N_5_3 N_5_14 N_5_10 N_5_1 N_5_9 PM_ICGx3_ASAP7_75t_R%5
cc_1 N_5_16 N_ENA_3 0.000406194f $X=0.189 $Y=0.1045
cc_2 N_5_15 N_ENA_4 0.000636074f $X=0.162 $Y=0.036
cc_3 N_5_4 N_ENA_3 0.000690733f $X=0.108 $Y=0.054
cc_4 N_5_11 N_ENA_1 0.000728847f $X=0.056 $Y=0.216
cc_5 N_5_3 N_ENA_3 0.00108554f $X=0.054 $Y=0.216
cc_6 N_5_14 N_ENA_4 0.00131644f $X=0.162 $Y=0.233
cc_7 N_5_4 N_ENA_4 0.00294813f $X=0.108 $Y=0.054
cc_8 N_5_10 N_ENA_3 0.010607f $X=0.0935 $Y=0.054
cc_9 N_5_11 N_ENA_3 0.0407112f $X=0.056 $Y=0.216
cc_10 N_5_1 N_SE_3 0.000920652f $X=0.189 $Y=0.134
cc_11 N_5_15 N_SE_4 0.000964347f $X=0.162 $Y=0.036
cc_12 N_5_14 N_SE_4 0.00116321f $X=0.162 $Y=0.233
cc_13 N_5_1 N_SE_1 0.0013353f $X=0.189 $Y=0.134
cc_14 N_5_10 N_SE_3 0.0104663f $X=0.0935 $Y=0.054
cc_15 N_5_16 N_SE_4 0.00699926f $X=0.189 $Y=0.1045
cc_16 N_5_9 N_SE_3 0.0140572f $X=0.189 $Y=0.0245
x_PM_ICGx3_ASAP7_75t_R%SE vss SE N_M1_g N_M16_g N_SE_3 N_SE_4 N_SE_1
+ PM_ICGx3_ASAP7_75t_R%SE
cc_17 N_SE_3 N_ENA_1 0.00152386f $X=0.135 $Y=0.0245
cc_18 N_SE_4 N_ENA_4 0.0046311f $X=0.135 $Y=0.0972
cc_19 N_SE_3 N_ENA_3 0.0125552f $X=0.135 $Y=0.0245
x_PM_ICGx3_ASAP7_75t_R%GCLK vss GCLK N_M12_d N_M13_d N_M14_d N_M27_d N_M28_d
+ N_M29_d N_GCLK_13 N_GCLK_1 N_GCLK_2 N_GCLK_20 N_GCLK_19 N_GCLK_16 N_GCLK_15
+ N_GCLK_14 PM_ICGx3_ASAP7_75t_R%GCLK
cc_20 N_GCLK_13 N_10_1 0.000911453f $X=0.9035 $Y=0.0675
cc_21 N_GCLK_13 N_10_18 0.00039878f $X=0.9035 $Y=0.0675
cc_22 N_GCLK_13 N_10_14 0.00244117f $X=0.9035 $Y=0.0675
cc_23 N_GCLK_13 N_10_22 0.000861421f $X=0.9035 $Y=0.0675
cc_24 N_GCLK_13 N_10_24 0.00155119f $X=0.9035 $Y=0.0675
cc_25 N_GCLK_1 N_10_13 0.00211493f $X=0.918 $Y=0.0675
cc_26 N_GCLK_2 N_10_12 0.00220933f $X=0.918 $Y=0.2025
cc_27 N_GCLK_20 N_10_20 0.00224429f $X=0.9045 $Y=0.234
cc_28 N_GCLK_19 N_10_19 0.00331642f $X=0.8895 $Y=0.036
cc_29 N_GCLK_16 N_10_14 0.0144944f $X=1.0115 $Y=0.2025
cc_30 N_GCLK_15 N_10_1 0.00698337f $X=0.9035 $Y=0.2025
cc_31 N_GCLK_14 N_10_14 0.0519196f $X=1.0115 $Y=0.0675
cc_32 N_GCLK_15 N_10_13 0.0288416f $X=0.9035 $Y=0.2025
cc_33 N_GCLK_15 N_10_12 0.0378922f $X=0.9035 $Y=0.2025
cc_34 N_GCLK_13 N_10_13 0.068361f $X=0.9035 $Y=0.0675
x_PM_ICGx3_ASAP7_75t_R%CLK vss CLK N_M10_g N_M25_g N_M9_g N_M24_g N_M7_g
+ N_M22_g N_M18_g N_M4_g N_CLK_23 N_CLK_1 N_CLK_10 N_CLK_19 N_CLK_17 N_CLK_15
+ N_CLK_20 N_CLK_16 N_CLK_8 N_CLK_12 N_CLK_21 N_CLK_2 N_CLK_3 N_CLK_11 N_CLK_18
+ N_CLK_4 N_CLK_14 N_CLK_22 N_CLK_13 PM_ICGx3_ASAP7_75t_R%CLK
cc_35 N_CLK_23 N_5_16 0.000603606f $X=0.5872 $Y=0.153
cc_36 N_CLK_1 N_5_1 0.00184411f $X=0.243 $Y=0.1335
cc_37 N_CLK_10 N_5_9 0.00322627f $X=0.243 $Y=0.1335
cc_38 N_CLK_19 N_5_16 0.00450299f $X=0.243 $Y=0.1215
x_PM_ICGx3_ASAP7_75t_R%7 vss N_M3_g N_M19_g N_M7_s N_M22_s N_7_10 N_7_16 N_7_3
+ N_7_17 N_7_18 N_7_1 N_7_11 N_7_15 N_7_13 N_7_12 N_7_14 N_7_4 N_7_9
+ PM_ICGx3_ASAP7_75t_R%7
cc_39 N_7_10 N_CLK_17 0.00035076f $X=0.596 $Y=0.0675
cc_40 N_7_10 N_CLK_23 0.000159389f $X=0.596 $Y=0.0675
cc_41 N_7_10 N_CLK_15 0.000165392f $X=0.596 $Y=0.0675
cc_42 N_7_16 N_CLK_19 0.00387201f $X=0.297 $Y=0.1045
cc_43 N_7_3 N_CLK_20 0.000312186f $X=0.594 $Y=0.0605
cc_44 N_7_17 N_CLK_20 0.00438821f $X=0.568 $Y=0.148
cc_45 N_7_18 N_CLK_16 0.000390719f $X=0.2985 $Y=0.189
cc_46 N_7_1 N_CLK_8 0.000400588f $X=0.297 $Y=0.1335
cc_47 N_7_11 N_CLK_12 0.0152721f $X=0.596 $Y=0.2025
cc_48 N_7_15 N_CLK_21 0.000441467f $X=0.568 $Y=0.232
cc_49 N_7_13 N_CLK_19 0.000454351f $X=0.2945 $Y=0.189
cc_50 N_7_13 N_CLK_23 0.000584547f $X=0.2945 $Y=0.189
cc_51 N_7_1 N_CLK_2 0.000585725f $X=0.297 $Y=0.1335
cc_52 N_7_17 N_CLK_23 0.000631809f $X=0.568 $Y=0.148
cc_53 N_7_3 N_CLK_3 0.000806492f $X=0.594 $Y=0.0605
cc_54 N_7_12 N_CLK_19 0.000926817f $X=0.297 $Y=0.081
cc_55 N_7_3 N_CLK_12 0.000943874f $X=0.594 $Y=0.0605
cc_56 N_7_14 N_CLK_20 0.000976986f $X=0.568 $Y=0.086
cc_57 N_7_1 N_CLK_1 0.00255651f $X=0.297 $Y=0.1335
cc_58 N_7_4 N_CLK_12 0.00135412f $X=0.594 $Y=0.2295
cc_59 N_7_15 N_CLK_17 0.00172918f $X=0.568 $Y=0.232
cc_60 N_7_10 N_CLK_3 0.00175707f $X=0.596 $Y=0.0675
cc_61 N_7_9 N_CLK_11 0.00357948f $X=0.297 $Y=0.0245
cc_62 N_7_9 N_CLK_10 0.00686003f $X=0.297 $Y=0.0245
cc_63 N_7_18 N_CLK_23 0.0238117f $X=0.2985 $Y=0.189
cc_64 N_7_10 N_CLK_12 0.0427985f $X=0.596 $Y=0.0675
x_PM_ICGx3_ASAP7_75t_R%8 vss N_M5_g N_M20_g N_M6_d N_M21_d N_8_9 N_8_1 N_8_14
+ N_8_15 N_8_12 N_8_13 N_8_4 N_8_11 N_8_3 N_8_10 PM_ICGx3_ASAP7_75t_R%8
cc_65 N_8_9 N_CLK_20 8.51921e-20 $X=0.405 $Y=0.0245
cc_66 N_8_9 N_CLK_16 0.000324887f $X=0.405 $Y=0.0245
cc_67 N_8_9 N_CLK_23 0.000173783f $X=0.405 $Y=0.0245
cc_68 N_8_9 N_CLK_8 0.00285646f $X=0.405 $Y=0.0245
cc_69 N_8_9 N_CLK_15 0.000466423f $X=0.405 $Y=0.0245
cc_70 N_8_1 N_CLK_8 0.00141587f $X=0.396 $Y=0.082
cc_71 N_8_14 N_CLK_16 0.000642637f $X=0.3965 $Y=0.082
cc_72 N_8_14 N_CLK_23 0.00155106f $X=0.3965 $Y=0.082
cc_73 N_8_15 N_CLK_23 0.00157823f $X=0.5125 $Y=0.093
cc_74 N_8_14 N_CLK_15 0.00247206f $X=0.3965 $Y=0.082
cc_75 N_8_9 N_CLK_11 0.0127677f $X=0.405 $Y=0.0245
cc_76 N_8_15 N_7_14 0.000228667f $X=0.5125 $Y=0.093
cc_77 N_8_15 N_7_3 0.000280756f $X=0.5125 $Y=0.093
cc_78 N_8_15 N_7_4 0.000292444f $X=0.5125 $Y=0.093
cc_79 N_8_12 N_7_15 0.000806226f $X=0.5125 $Y=0.233
cc_80 N_8_13 N_7_14 0.000937378f $X=0.5125 $Y=0.082
cc_81 N_8_12 N_7_18 0.00155786f $X=0.5125 $Y=0.233
cc_82 N_8_15 N_7_17 0.00617358f $X=0.5125 $Y=0.093
x_PM_ICGx3_ASAP7_75t_R%10 vss N_M12_g N_M27_g N_M13_g N_M28_g N_M14_g N_M29_g
+ N_M10_s N_M9_s N_M25_s N_M26_d N_M23_d N_M24_s N_10_15 N_10_16 N_10_22 N_10_3
+ N_10_5 N_10_21 N_10_4 N_10_17 N_10_18 N_10_1 N_10_24 N_10_12 N_10_14 N_10_13
+ N_10_20 N_10_19 PM_ICGx3_ASAP7_75t_R%10
cc_83 N_10_15 N_CLK_18 0.000365617f $X=0.7415 $Y=0.0675
cc_84 N_10_15 N_CLK_4 0.000231741f $X=0.7415 $Y=0.0675
cc_85 N_10_15 N_CLK_14 0.0344827f $X=0.7415 $Y=0.0675
cc_86 N_10_16 N_CLK_13 0.0111341f $X=0.6875 $Y=0.216
cc_87 N_10_22 N_CLK_22 0.000375953f $X=0.8805 $Y=0.072
cc_88 N_10_3 N_CLK_21 0.000421158f $X=0.702 $Y=0.216
cc_89 N_10_5 N_CLK_4 0.000438723f $X=0.81 $Y=0.216
cc_90 N_10_21 N_CLK_22 0.000465256f $X=0.783 $Y=0.231
cc_91 N_10_5 N_CLK_14 0.000760379f $X=0.81 $Y=0.216
cc_92 N_10_3 N_CLK_13 0.00114541f $X=0.702 $Y=0.216
cc_93 N_10_4 N_CLK_13 0.00141691f $X=0.756 $Y=0.0675
cc_94 N_10_16 N_CLK_4 0.00247625f $X=0.6875 $Y=0.216
cc_95 N_10_21 N_CLK_21 0.00248937f $X=0.783 $Y=0.231
cc_96 N_10_21 N_CLK_18 0.0036694f $X=0.783 $Y=0.231
cc_97 N_10_17 N_CLK_14 0.0108532f $X=0.7955 $Y=0.216
cc_98 N_10_15 N_CLK_13 0.0650115f $X=0.7415 $Y=0.0675
cc_99 N_10_16 N_9_25 0.000550951f $X=0.6875 $Y=0.216
cc_100 N_10_16 N_9_24 0.000132989f $X=0.6875 $Y=0.216
cc_101 N_10_16 N_9_23 0.000135419f $X=0.6875 $Y=0.216
cc_102 N_10_16 N_9_2 0.000148965f $X=0.6875 $Y=0.216
cc_103 N_10_15 N_9_15 0.000291403f $X=0.7415 $Y=0.0675
cc_104 N_10_17 N_9_15 0.0110116f $X=0.7955 $Y=0.216
cc_105 N_10_3 N_9_14 0.000354555f $X=0.702 $Y=0.216
cc_106 N_10_22 N_9_32 0.000378516f $X=0.8805 $Y=0.072
cc_107 N_10_5 N_9_15 0.000402574f $X=0.81 $Y=0.216
cc_108 N_10_18 N_9_25 0.000478343f $X=0.837 $Y=0.192
cc_109 N_10_4 N_9_33 0.00196944f $X=0.756 $Y=0.0675
cc_110 N_10_22 N_9_25 0.00136562f $X=0.8805 $Y=0.072
cc_111 N_10_1 N_9_3 0.00312182f $X=0.8815 $Y=0.136
cc_112 N_10_24 N_9_25 0.00249347f $X=0.891 $Y=0.113
cc_113 N_10_22 N_9_33 0.00896956f $X=0.8805 $Y=0.072
cc_114 N_10_12 N_9_15 0.0173884f $X=0.891 $Y=0.0245
cc_115 N_10_16 N_9_14 0.0253131f $X=0.6875 $Y=0.216
x_PM_ICGx3_ASAP7_75t_R%12 vss N_M2_d N_M3_s N_12_4 N_12_5 N_12_1
+ PM_ICGx3_ASAP7_75t_R%12
cc_116 N_12_4 N_5_16 0.00066533f $X=0.2015 $Y=0.0675
cc_117 N_12_4 N_5_9 0.0360328f $X=0.2015 $Y=0.0675
cc_118 N_12_4 N_CLK_1 0.00203129f $X=0.2015 $Y=0.0675
cc_119 N_12_4 N_CLK_10 0.0731245f $X=0.2015 $Y=0.0675
cc_120 N_12_5 N_7_1 0.000676524f $X=0.272 $Y=0.0675
cc_121 N_12_5 N_7_12 0.00284153f $X=0.272 $Y=0.0675
cc_122 N_12_5 N_7_9 0.0335657f $X=0.272 $Y=0.0675
cc_123 N_12_1 N_9_8 0.00113954f $X=0.243 $Y=0.0675
cc_124 N_12_1 N_9_17 0.000593825f $X=0.243 $Y=0.0675
cc_125 N_12_1 N_9_16 0.00194052f $X=0.243 $Y=0.0675
x_PM_ICGx3_ASAP7_75t_R%13 vss N_M17_d N_M18_s N_13_3 N_13_1
+ PM_ICGx3_ASAP7_75t_R%13
cc_126 N_13_3 N_5_1 0.000618688f $X=0.2015 $Y=0.2025
cc_127 N_13_3 N_5_9 0.0347183f $X=0.2015 $Y=0.2025
cc_128 N_13_3 N_CLK_19 0.000321453f $X=0.2015 $Y=0.2025
cc_129 N_13_3 N_CLK_1 0.000533719f $X=0.2015 $Y=0.2025
cc_130 N_13_3 N_CLK_10 0.0332649f $X=0.2015 $Y=0.2025
cc_131 N_13_1 N_9_18 0.000524865f $X=0.216 $Y=0.2025
cc_132 N_13_1 N_9_19 0.000566586f $X=0.216 $Y=0.2025
cc_133 N_13_1 N_9_7 0.00255582f $X=0.216 $Y=0.2025
x_PM_ICGx3_ASAP7_75t_R%14 vss N_M19_d N_M20_s N_14_4 N_14_1 N_14_5
+ PM_ICGx3_ASAP7_75t_R%14
cc_134 N_14_4 N_CLK_2 0.000155065f $X=0.3095 $Y=0.2295
cc_135 N_14_1 N_CLK_11 0.000839882f $X=0.324 $Y=0.2295
cc_136 N_14_5 N_CLK_11 0.00642618f $X=0.38 $Y=0.2295
cc_137 N_14_4 N_CLK_11 0.0251248f $X=0.3095 $Y=0.2295
cc_138 N_14_1 N_7_9 0.000405231f $X=0.324 $Y=0.2295
cc_139 N_14_4 N_7_9 0.0143342f $X=0.3095 $Y=0.2295
cc_140 N_14_5 N_8_9 0.016086f $X=0.38 $Y=0.2295
cc_141 N_14_1 N_9_28 0.000138205f $X=0.324 $Y=0.2295
cc_142 N_14_1 N_9_29 0.000212395f $X=0.324 $Y=0.2295
cc_143 N_14_1 N_9_31 0.000277965f $X=0.324 $Y=0.2295
cc_144 N_14_4 N_9_18 0.000278412f $X=0.3095 $Y=0.2295
cc_145 N_14_4 N_9_19 0.000308342f $X=0.3095 $Y=0.2295
cc_146 N_14_1 N_9_26 0.000455596f $X=0.324 $Y=0.2295
cc_147 N_14_4 N_9_7 0.00050902f $X=0.3095 $Y=0.2295
cc_148 N_14_1 N_9_22 0.00250522f $X=0.324 $Y=0.2295
x_PM_ICGx3_ASAP7_75t_R%15 vss N_M4_d N_M5_s N_15_3 N_15_1
+ PM_ICGx3_ASAP7_75t_R%15
cc_149 N_15_3 N_CLK_11 0.0133668f $X=0.3635 $Y=0.0405
cc_150 N_15_3 N_8_9 0.0177565f $X=0.3635 $Y=0.0405
cc_151 N_15_1 N_9_28 0.000147616f $X=0.378 $Y=0.0405
cc_152 N_15_1 N_9_30 0.000230869f $X=0.378 $Y=0.0405
cc_153 N_15_1 N_9_16 0.000261607f $X=0.378 $Y=0.0405
cc_154 N_15_1 N_9_17 0.000309093f $X=0.378 $Y=0.0405
cc_155 N_15_1 N_9_8 0.00168516f $X=0.378 $Y=0.0405
x_PM_ICGx3_ASAP7_75t_R%16__2 vss N_M8_s N_M9_d N_16__2_1
+ PM_ICGx3_ASAP7_75t_R%16__2
cc_156 N_16__2_1 N_CLK_13 0.0169615f $X=0.702 $Y=0.0675
cc_157 N_16__2_1 N_9_14 0.0169136f $X=0.702 $Y=0.0675
x_PM_ICGx3_ASAP7_75t_R%17 vss N_M10_d N_M11_s N_17_1 PM_ICGx3_ASAP7_75t_R%17
cc_158 N_17_1 N_CLK_14 0.0169763f $X=0.81 $Y=0.0675
cc_159 N_17_1 N_9_15 0.0169108f $X=0.81 $Y=0.0675
x_PM_ICGx3_ASAP7_75t_R%9 vss N_M11_g N_M26_g N_M8_g N_M23_g N_M3_d N_M4_s
+ N_M6_g N_M21_g N_M18_d N_M19_s N_9_16 N_9_23 N_9_22 N_9_29 N_9_27 N_9_18
+ N_9_21 N_9_24 N_9_33 N_9_7 N_9_19 N_9_25 N_9_3 N_9_1 N_9_31 N_9_32 N_9_17
+ N_9_26 N_9_28 N_9_30 N_9_13 N_9_8 N_9_2 N_9_15 N_9_14 PM_ICGx3_ASAP7_75t_R%9
cc_160 N_9_16 N_CLK_19 6.02313e-20 $X=0.3095 $Y=0.0405
cc_161 N_9_23 N_CLK_20 6.78246e-20 $X=0.675 $Y=0.036
cc_162 N_9_22 N_CLK_15 7.44739e-20 $X=0.358 $Y=0.2235
cc_163 N_9_29 N_CLK_15 8.98681e-20 $X=0.358 $Y=0.211
cc_164 N_9_27 N_CLK_11 0.000144993f $X=0.3285 $Y=0.036
cc_165 N_9_18 N_CLK_10 0.00979901f $X=0.2555 $Y=0.2295
cc_166 N_9_21 N_CLK_15 0.000181462f $X=0.358 $Y=0.1895
cc_167 N_9_24 N_CLK_20 0.00327951f $X=0.675 $Y=0.1075
cc_168 N_9_33 N_CLK_18 0.000208148f $X=0.7965 $Y=0.108
cc_169 N_9_7 N_CLK_19 0.000969525f $X=0.27 $Y=0.2295
cc_170 N_9_19 N_CLK_10 0.0241891f $X=0.2555 $Y=0.189
cc_171 N_9_25 N_CLK_4 0.000258895f $X=0.837 $Y=0.1205
cc_172 N_9_7 N_CLK_1 0.000263747f $X=0.27 $Y=0.2295
cc_173 N_9_3 N_CLK_4 0.000272864f $X=0.837 $Y=0.135
cc_174 N_9_1 N_CLK_8 0.000351617f $X=0.459 $Y=0.19
cc_175 N_9_33 N_CLK_4 0.000391601f $X=0.7965 $Y=0.108
cc_176 N_9_31 N_CLK_16 0.00497419f $X=0.3795 $Y=0.19
cc_177 N_9_1 N_CLK_16 0.000426476f $X=0.459 $Y=0.19
cc_178 N_9_32 N_CLK_20 0.00043046f $X=0.675 $Y=0.097
cc_179 N_9_17 N_CLK_11 0.00558743f $X=0.3095 $Y=0.081
cc_180 N_9_26 N_CLK_19 0.000468838f $X=0.3365 $Y=0.232
cc_181 N_9_28 N_CLK_8 0.00261528f $X=0.358 $Y=0.0585
cc_182 N_9_18 N_CLK_1 0.000596496f $X=0.2555 $Y=0.2295
cc_183 N_9_3 N_CLK_14 0.000621889f $X=0.837 $Y=0.135
cc_184 N_9_30 N_CLK_23 0.000794662f $X=0.648 $Y=0.036
cc_185 N_9_13 N_CLK_8 0.000851751f $X=0.459 $Y=0.19
cc_186 N_9_8 N_CLK_11 0.000883182f $X=0.324 $Y=0.0405
cc_187 N_9_16 N_CLK_2 0.00093465f $X=0.3095 $Y=0.0405
cc_188 N_9_7 N_CLK_10 0.00114478f $X=0.27 $Y=0.2295
cc_189 N_9_31 N_CLK_15 0.00120323f $X=0.3795 $Y=0.19
cc_190 N_9_2 N_CLK_3 0.00344722f $X=0.675 $Y=0.135
cc_191 N_9_24 N_CLK_21 0.0013982f $X=0.675 $Y=0.1075
cc_192 N_9_15 N_CLK_4 0.00200903f $X=0.837 $Y=0.0245
cc_193 N_9_31 N_CLK_23 0.00227011f $X=0.3795 $Y=0.19
cc_194 N_9_33 N_CLK_22 0.0035553f $X=0.7965 $Y=0.108
cc_195 N_9_14 N_CLK_13 0.00368134f $X=0.675 $Y=0.135
cc_196 N_9_28 N_CLK_15 0.00390573f $X=0.358 $Y=0.0585
cc_197 N_9_14 N_CLK_12 0.0068988f $X=0.675 $Y=0.135
cc_198 N_9_15 N_CLK_14 0.00708218f $X=0.837 $Y=0.0245
cc_199 N_9_16 N_CLK_11 0.0314717f $X=0.3095 $Y=0.0405
cc_200 N_9_1 N_7_9 0.000198409f $X=0.459 $Y=0.19
cc_201 N_9_33 N_7_9 0.000113805f $X=0.7965 $Y=0.108
cc_202 N_9_16 N_7_9 0.00982922f $X=0.3095 $Y=0.0405
cc_203 N_9_18 N_7_9 0.0109484f $X=0.2555 $Y=0.2295
cc_204 N_9_7 N_7_9 0.00148028f $X=0.27 $Y=0.2295
cc_205 N_9_8 N_7_12 0.0002143f $X=0.324 $Y=0.0405
cc_206 N_9_24 N_7_14 0.000228503f $X=0.675 $Y=0.1075
cc_207 N_9_22 N_7_13 0.000242723f $X=0.358 $Y=0.2235
cc_208 N_9_32 N_7_14 0.000266754f $X=0.675 $Y=0.097
cc_209 N_9_30 N_7_3 0.00112818f $X=0.648 $Y=0.036
cc_210 N_9_19 N_7_9 0.00556698f $X=0.2555 $Y=0.189
cc_211 N_9_31 N_7_17 0.000497559f $X=0.3795 $Y=0.19
cc_212 N_9_26 N_7_13 0.00454494f $X=0.3365 $Y=0.232
cc_213 N_9_29 N_7_13 0.00052119f $X=0.358 $Y=0.211
cc_214 N_9_21 N_7_13 0.000634201f $X=0.358 $Y=0.1895
cc_215 N_9_8 N_7_1 0.000695191f $X=0.324 $Y=0.0405
cc_216 N_9_8 N_7_9 0.00136079f $X=0.324 $Y=0.0405
cc_217 N_9_16 N_7_1 0.00154494f $X=0.3095 $Y=0.0405
cc_218 N_9_27 N_7_12 0.0017854f $X=0.3285 $Y=0.036
cc_219 N_9_31 N_7_18 0.0034118f $X=0.3795 $Y=0.19
cc_220 N_9_28 N_7_16 0.00362367f $X=0.358 $Y=0.0585
cc_221 N_9_30 N_7_14 0.00412414f $X=0.648 $Y=0.036
cc_222 N_9_17 N_7_9 0.0453363f $X=0.3095 $Y=0.081
cc_223 N_9_8 N_8_9 0.000281101f $X=0.324 $Y=0.0405
cc_224 N_9_1 N_8_9 0.000375515f $X=0.459 $Y=0.19
cc_225 N_9_30 N_8_9 0.000378543f $X=0.648 $Y=0.036
cc_226 N_9_13 N_8_1 0.000671617f $X=0.459 $Y=0.19
cc_227 N_9_30 N_8_1 0.000730946f $X=0.648 $Y=0.036
cc_228 N_9_1 N_8_4 0.00157746f $X=0.459 $Y=0.19
cc_229 N_9_1 N_8_11 0.00124276f $X=0.459 $Y=0.19
cc_230 N_9_28 N_8_14 0.00131585f $X=0.358 $Y=0.0585
cc_231 N_9_31 N_8_15 0.00153361f $X=0.3795 $Y=0.19
cc_232 N_9_13 N_8_3 0.00164165f $X=0.459 $Y=0.19
cc_233 N_9_31 N_8_12 0.00219521f $X=0.3795 $Y=0.19
cc_234 N_9_13 N_8_10 0.00636915f $X=0.459 $Y=0.19
cc_235 N_9_13 N_8_11 0.00663383f $X=0.459 $Y=0.19
cc_236 N_9_30 N_8_14 0.00361753f $X=0.648 $Y=0.036
cc_237 N_9_30 N_8_13 0.00509569f $X=0.648 $Y=0.036
cc_238 N_9_13 N_8_9 0.0302546f $X=0.459 $Y=0.19
x_PM_ICGx3_ASAP7_75t_R%ENA vss ENA N_M0_g N_M15_g N_ENA_1 N_ENA_4 N_ENA_3
+ PM_ICGx3_ASAP7_75t_R%ENA
x_PM_ICGx3_ASAP7_75t_R%18 vss N_M15_d N_M16_s N_18_1 PM_ICGx3_ASAP7_75t_R%18
cc_239 N_18_1 N_ENA_3 0.0126058f $X=0.108 $Y=0.216
cc_240 N_18_1 N_SE_3 0.005658f $X=0.108 $Y=0.216

* End of included file ICGx3_ASAP7_75t_R.pex.sp.pxi
.ends

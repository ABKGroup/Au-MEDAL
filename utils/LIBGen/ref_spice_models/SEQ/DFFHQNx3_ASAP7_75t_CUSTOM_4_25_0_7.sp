.subckt PM_DFFHQNx3_ASAP7_75t_R%12 vss 7 9 5 4 1
c1 1 vss 0.00906791f $X=0.351 $Y=0.0675
c2 4 vss 0.00288355f $X=0.3095 $Y=0.0675
c3 5 vss 0.00175851f $X=0.38 $Y=0.0675
r1 9 8 0.0308642 $w=8.1e-08 $l=2.5e-09 $layer=N_src_drn $thickness=1e-09
+ $X=0.3953 $Y=0.0675 $X2=0.3925 $Y2=0.0675
r2 5 8 0.154321 $w=8.1e-08 $l=1.25e-08 $layer=N_src_drn $thickness=1e-09
+ $X=0.38 $Y=0.0675 $X2=0.3925 $Y2=0.0675
r3 4 1 0.154321 $w=8.1e-08 $l=1.25e-08 $layer=N_src_drn $thickness=1e-09
+ $X=0.3095 $Y=0.0675 $X2=0.351 $Y2=0.0675
r4 7 4 0.0308642 $w=8.1e-08 $l=2.5e-09 $layer=N_src_drn $thickness=1e-09
+ $X=0.3066 $Y=0.0675 $X2=0.3095 $Y2=0.0675
r5 1 5 1e-05 $l=2.9e-08 $X=0.351 $Y=0.0675 $X2=0.38 $Y2=0.0675
.ends

.subckt PM_DFFHQNx3_ASAP7_75t_R%15 vss 2 3 1
c1 1 vss 0.000540528f $X=0.486 $Y=0.0405
r1 2 1 0.62963 $w=2.7e-08 $l=1.7e-08 $layer=N_src_drn $thickness=1e-09
+ $X=0.4686 $Y=0.0405 $X2=0.486 $Y2=0.0405
r2 3 1 0.62963 $w=2.7e-08 $l=1.7e-08 $layer=N_src_drn $thickness=1e-09
+ $X=0.5033 $Y=0.0405 $X2=0.486 $Y2=0.0405
.ends

.subckt PM_DFFHQNx3_ASAP7_75t_R%17 vss 2 3 1
c1 1 vss 0.000558387f $X=0.756 $Y=0.2295
r1 2 1 0.62963 $w=2.7e-08 $l=1.7e-08 $layer=P_src_drn $thickness=1e-09
+ $X=0.7386 $Y=0.2295 $X2=0.756 $Y2=0.2295
r2 3 1 0.62963 $w=2.7e-08 $l=1.7e-08 $layer=P_src_drn $thickness=1e-09
+ $X=0.7733 $Y=0.2295 $X2=0.756 $Y2=0.2295
.ends

.subckt PM_DFFHQNx3_ASAP7_75t_R%8 vss 21 25 52 55 61 64 11 19 13 14 4 18 3 10
+ 15 20 12 16 1 17 9
c1 1 vss 0.000445252f $X=0.567 $Y=0.1305
c2 3 vss 0.00514257f $X=0.378 $Y=0.2295
c3 4 vss 0.00478333f $X=0.432 $Y=0.0405
c4 9 vss 0.0387345f $X=0.567 $Y=0.0245
c5 10 vss 0.00195251f $X=0.4175 $Y=0.0405
c6 11 vss 0.000320306f $X=0.4175 $Y=0.081
c7 12 vss 0.00223715f $X=0.3635 $Y=0.2295
c8 13 vss 0.00038315f $X=0.3635 $Y=0.189
c9 14 vss 0.00602349f $X=0.459 $Y=0.036
c10 15 vss 1.31731e-20 $X=0.459 $Y=0.131
c11 16 vss 0.00260142f $X=0.459 $Y=0.234
c12 17 vss 0.00707484f $X=0.434 $Y=0.234
c13 18 vss 0.00127914f $X=0.459 $Y=0.114
c14 19 vss 0.000588419f $X=0.459 $Y=0.1525
c15 20 vss 0.000777371f $X=0.54 $Y=0.131
r1 13 3 0.231482 $w=5.4e-08 $l=1.25e-08 $layer=P_src_drn $thickness=1e-09
+ $X=0.3635 $Y=0.189 $X2=0.378 $Y2=0.2295
r2 64 63 0.0925926 $w=2.7e-08 $l=2.5e-09 $layer=P_src_drn $thickness=1e-09
+ $X=0.3953 $Y=0.2295 $X2=0.3925 $Y2=0.2295
r3 62 63 0.166667 $w=2.7e-08 $l=4.5e-09 $layer=P_src_drn $thickness=1e-09
+ $X=0.388 $Y=0.2295 $X2=0.3925 $Y2=0.2295
r4 3 62 0.444445 $w=2.7e-08 $l=1.2e-08 $layer=P_src_drn $thickness=1e-09
+ $X=0.378 $Y=0.2295 $X2=0.388 $Y2=0.2295
r5 12 3 0.462963 $w=2.7e-08 $l=1.25e-08 $layer=P_src_drn $thickness=1e-09
+ $X=0.3635 $Y=0.2295 $X2=0.378 $Y2=0.2295
r6 61 12 0.0925926 $w=2.7e-08 $l=2.5e-09 $layer=P_src_drn $thickness=1e-09
+ $X=0.3606 $Y=0.2025 $X2=0.3635 $Y2=0.2295
r7 3 48 19.3796 $a=3.24e-16 $layer=V0LISD $X=0.378 $Y=0.2295 $X2=0.378 $Y2=0.234
r8 11 4 0.231482 $w=5.4e-08 $l=1.25e-08 $layer=N_src_drn $thickness=1e-09
+ $X=0.4175 $Y=0.081 $X2=0.432 $Y2=0.0405
r9 55 54 0.0925926 $w=2.7e-08 $l=2.5e-09 $layer=N_src_drn $thickness=1e-09
+ $X=0.4493 $Y=0.0405 $X2=0.4465 $Y2=0.0405
r10 53 54 0.166667 $w=2.7e-08 $l=4.5e-09 $layer=N_src_drn $thickness=1e-09
+ $X=0.442 $Y=0.0405 $X2=0.4465 $Y2=0.0405
r11 4 53 0.444445 $w=2.7e-08 $l=1.2e-08 $layer=N_src_drn $thickness=1e-09
+ $X=0.432 $Y=0.0405 $X2=0.442 $Y2=0.0405
r12 10 4 0.462963 $w=2.7e-08 $l=1.25e-08 $layer=N_src_drn $thickness=1e-09
+ $X=0.4175 $Y=0.0405 $X2=0.432 $Y2=0.0405
r13 52 10 0.0925926 $w=2.7e-08 $l=2.5e-09 $layer=N_src_drn $thickness=1e-09
+ $X=0.4146 $Y=0.0675 $X2=0.4175 $Y2=0.0405
r14 48 49 3.14806 $w=1.3e-08 $l=1.35e-08 $layer=M1 $thickness=3.6e-08 $X=0.378
+ $Y=0.234 $X2=0.3915 $Y2=0.234
r15 46 49 3.14806 $w=1.3e-08 $l=1.35e-08 $layer=M1 $thickness=3.6e-08 $X=0.405
+ $Y=0.234 $X2=0.3915 $Y2=0.234
r16 45 46 2.56509 $w=1.3e-08 $l=1.1e-08 $layer=M1 $thickness=3.6e-08 $X=0.416
+ $Y=0.234 $X2=0.405 $Y2=0.234
r17 17 45 4.19742 $w=1.3e-08 $l=1.8e-08 $layer=M1 $thickness=3.6e-08 $X=0.434
+ $Y=0.234 $X2=0.416 $Y2=0.234
r18 4 40 19.3796 $a=3.24e-16 $layer=V0LISD $X=0.432 $Y=0.0405 $X2=0.432
+ $Y2=0.036
r19 16 38 3.01468 $w=1.741e-08 $l=2e-08 $layer=M1 $thickness=3.6e-08 $X=0.459
+ $Y=0.234 $X2=0.459 $Y2=0.214
r20 16 17 4.18063 $w=1.48e-08 $l=2.5e-08 $layer=M1 $thickness=3.6e-08 $X=0.459
+ $Y=0.234 $X2=0.434 $Y2=0.234
r21 40 41 3.14806 $w=1.3e-08 $l=1.35e-08 $layer=M1 $thickness=3.6e-08 $X=0.432
+ $Y=0.036 $X2=0.4455 $Y2=0.036
r22 14 35 5.11582 $w=1.46667e-08 $l=2.7e-08 $layer=M1 $thickness=3.6e-08
+ $X=0.459 $Y=0.036 $X2=0.459 $Y2=0.063
r23 14 41 1.96775 $w=1.63333e-08 $l=1.35e-08 $layer=M1 $thickness=3.6e-08
+ $X=0.459 $Y=0.036 $X2=0.4455 $Y2=0.036
r24 37 38 6.7625 $w=1.3e-08 $l=2.9e-08 $layer=M1 $thickness=3.6e-08 $X=0.459
+ $Y=0.185 $X2=0.459 $Y2=0.214
r25 36 37 4.43061 $w=1.3e-08 $l=1.9e-08 $layer=M1 $thickness=3.6e-08 $X=0.459
+ $Y=0.166 $X2=0.459 $Y2=0.185
r26 19 36 3.14806 $w=1.3e-08 $l=1.35e-08 $layer=M1 $thickness=3.6e-08 $X=0.459
+ $Y=0.1525 $X2=0.459 $Y2=0.166
r27 34 35 6.29612 $w=1.3e-08 $l=2.7e-08 $layer=M1 $thickness=3.6e-08 $X=0.459
+ $Y=0.09 $X2=0.459 $Y2=0.063
r28 33 34 2.91487 $w=1.3e-08 $l=1.25e-08 $layer=M1 $thickness=3.6e-08 $X=0.459
+ $Y=0.1025 $X2=0.459 $Y2=0.09
r29 18 33 2.68168 $w=1.3e-08 $l=1.15e-08 $layer=M1 $thickness=3.6e-08 $X=0.459
+ $Y=0.114 $X2=0.459 $Y2=0.1025
r30 15 32 4.18306 $w=1.49565e-08 $l=2.3e-08 $layer=M1 $thickness=3.6e-08
+ $X=0.459 $Y=0.131 $X2=0.482 $Y2=0.131
r31 15 18 2.78392 $w=1.56471e-08 $l=1.7e-08 $layer=M1 $thickness=3.6e-08
+ $X=0.459 $Y=0.131 $X2=0.459 $Y2=0.114
r32 15 19 3.83327 $w=1.5093e-08 $l=2.15e-08 $layer=M1 $thickness=3.6e-08
+ $X=0.459 $Y=0.131 $X2=0.459 $Y2=0.1525
r33 31 32 4.19742 $w=1.3e-08 $l=1.8e-08 $layer=M1 $thickness=3.6e-08 $X=0.5
+ $Y=0.131 $X2=0.482 $Y2=0.131
r34 30 31 3.03147 $w=1.3e-08 $l=1.3e-08 $layer=M1 $thickness=3.6e-08 $X=0.513
+ $Y=0.131 $X2=0.5 $Y2=0.131
r35 20 29 6.29612 $w=1.3e-08 $l=2.7e-08 $layer=M1 $thickness=3.6e-08 $X=0.54
+ $Y=0.131 $X2=0.567 $Y2=0.131
r36 20 30 6.29612 $w=1.3e-08 $l=2.7e-08 $layer=M1 $thickness=3.6e-08 $X=0.54
+ $Y=0.131 $X2=0.513 $Y2=0.131
r37 1 23 6.4735 $w=2.13953e-08 $layer=Gate_1 $thickness=5.22791e-08 $X=0.567
+ $Y=0.1305 $X2=0.567 $Y2=0.1305
r38 1 29 19.3796 $a=3.24e-16 $layer=V0LIG $X=0.567 $Y=0.1305 $X2=0.567 $Y2=0.131
r39 25 24 17.177 $w=2.1e-08 $l=5.05e-08 $layer=Gate_1 $thickness=5.6e-08
+ $X=0.567 $Y=0.2295 $X2=0.567 $Y2=0.179
r40 23 24 16.6923 $w=2.07629e-08 $l=4.85e-08 $layer=Gate_1 $thickness=5.6e-08
+ $X=0.567 $Y=0.1305 $X2=0.567 $Y2=0.179
r41 22 23 15.1617 $w=2.07386e-08 $l=4.4e-08 $layer=Gate_1 $thickness=5.6e-08
+ $X=0.567 $Y=0.0865 $X2=0.567 $Y2=0.1305
r42 21 22 15.6464 $w=2.1e-08 $l=4.6e-08 $layer=Gate_1 $thickness=5.6e-08
+ $X=0.567 $Y=0.0405 $X2=0.567 $Y2=0.0865
r43 21 9 5.44221 $w=2.1e-08 $l=1.6e-08 $layer=Gate_1 $thickness=5.6e-08
+ $X=0.567 $Y=0.0405 $X2=0.567 $Y2=0.0245
.ends

.subckt PM_DFFHQNx3_ASAP7_75t_R%D vss 25 10 16 8 3 9 6 1 7 5
c1 1 vss 0.00940207f $X=0.2885 $Y=0.135
c2 3 vss 0.0906122f $X=0.297 $Y=0.0245
c3 4 vss 0.00668106f $X=0.243 $Y=0.036
c4 5 vss 0.000457004f $X=0.243 $Y=0.135
c5 6 vss 0.00644204f $X=0.243 $Y=0.234
c6 7 vss 0.00397732f $X=0.243 $Y=0.116
c7 8 vss 0.00297774f $X=0.243 $Y=0.1735
c8 9 vss 0.000924016f $X=0.2615 $Y=0.135
r1 6 27 3.48349 $w=1.525e-08 $l=2e-08 $layer=M1 $thickness=3.6e-08 $X=0.243
+ $Y=0.234 $X2=0.243 $Y2=0.214
r2 4 24 5.17411 $w=1.46514e-08 $l=2.72e-08 $layer=M1 $thickness=3.6e-08
+ $X=0.243 $Y=0.036 $X2=0.243 $Y2=0.0632
r3 8 27 9.44419 $w=1.3e-08 $l=4.05e-08 $layer=M1 $thickness=3.6e-08 $X=0.243
+ $Y=0.1735 $X2=0.243 $Y2=0.214
r4 25 26 2.85657 $w=1.3e-08 $l=1.22e-08 $layer=M1 $thickness=3.6e-08 $X=0.244
+ $Y=0.082 $X2=0.243 $Y2=0.0942
r5 25 24 4.37231 $w=1.3e-08 $l=1.88e-08 $layer=M1 $thickness=3.6e-08 $X=0.244
+ $Y=0.082 $X2=0.243 $Y2=0.0632
r6 7 26 5.07188 $w=1.3e-08 $l=2.18e-08 $layer=M1 $thickness=3.6e-08 $X=0.243
+ $Y=0.116 $X2=0.243 $Y2=0.0942
r7 5 9 3.1337 $w=1.54324e-08 $l=1.85e-08 $layer=M1 $thickness=3.6e-08 $X=0.243
+ $Y=0.135 $X2=0.2615 $Y2=0.135
r8 5 7 3.2503 $w=1.53684e-08 $l=1.9e-08 $layer=M1 $thickness=3.6e-08 $X=0.243
+ $Y=0.135 $X2=0.243 $Y2=0.116
r9 5 8 7.7975 $w=1.41688e-08 $l=3.85e-08 $layer=M1 $thickness=3.6e-08 $X=0.243
+ $Y=0.135 $X2=0.243 $Y2=0.1735
r10 22 23 2.2153 $w=1.3e-08 $l=9.5e-09 $layer=M1 $thickness=3.6e-08 $X=0.2715
+ $Y=0.135 $X2=0.281 $Y2=0.135
r11 9 22 2.3319 $w=1.3e-08 $l=1e-08 $layer=M1 $thickness=3.6e-08 $X=0.2615
+ $Y=0.135 $X2=0.2715 $Y2=0.135
r12 20 23 19.3796 $a=3.24e-16 $layer=V0LIG $X=0.2795 $Y=0.135 $X2=0.281
+ $Y2=0.135
r13 1 18 2.6116 $w=2.2e-08 $l=1e-08 $layer=LIG $thickness=4.8e-08 $X=0.2885
+ $Y=0.135 $X2=0.2985 $Y2=0.135
r14 1 20 4.82216 $w=1.64167e-08 $l=9e-09 $layer=LIG $thickness=4.8e-08
+ $X=0.2885 $Y=0.135 $X2=0.2795 $Y2=0.135
r15 16 15 14.6259 $w=2.1e-08 $l=4.3e-08 $layer=Gate_1 $thickness=5.6e-08
+ $X=0.297 $Y=0.2025 $X2=0.297 $Y2=0.1595
r16 14 15 2.7211 $w=2.1e-08 $l=8e-09 $layer=Gate_1 $thickness=5.6e-08 $X=0.297
+ $Y=0.1515 $X2=0.297 $Y2=0.1595
r17 13 14 5.79936 $w=2.03333e-08 $l=1.65e-08 $layer=Gate_1 $thickness=5.6e-08
+ $X=0.297 $Y=0.135 $X2=0.297 $Y2=0.1515
r18 13 18 6.14846 $w=2.08718e-08 $l=1.5e-09 $layer=Gate_1
+ $thickness=5.25128e-08 $X=0.297 $Y=0.135 $X2=0.2985 $Y2=0.135
r19 12 13 5.79936 $w=2.03333e-08 $l=1.65e-08 $layer=Gate_1 $thickness=5.6e-08
+ $X=0.297 $Y=0.1185 $X2=0.297 $Y2=0.135
r20 11 12 2.7211 $w=2.1e-08 $l=8e-09 $layer=Gate_1 $thickness=5.6e-08 $X=0.297
+ $Y=0.1105 $X2=0.297 $Y2=0.1185
r21 10 11 14.6259 $w=2.1e-08 $l=4.3e-08 $layer=Gate_1 $thickness=5.6e-08
+ $X=0.297 $Y=0.0675 $X2=0.297 $Y2=0.1105
r22 10 3 14.6259 $w=2.1e-08 $l=4.3e-08 $layer=Gate_1 $thickness=5.6e-08
+ $X=0.297 $Y=0.0675 $X2=0.297 $Y2=0.0245
.ends

.subckt PM_DFFHQNx3_ASAP7_75t_R%16 vss 2 3 1
c1 1 vss 0.000752541f $X=0.324 $Y=0.2025
r1 2 1 0.209877 $w=8.1e-08 $l=1.7e-08 $layer=P_src_drn $thickness=1e-09
+ $X=0.3066 $Y=0.2025 $X2=0.324 $Y2=0.2025
r2 3 1 0.209877 $w=8.1e-08 $l=1.7e-08 $layer=P_src_drn $thickness=1e-09
+ $X=0.3413 $Y=0.2025 $X2=0.324 $Y2=0.2025
.ends

.subckt PM_DFFHQNx3_ASAP7_75t_R%4 vss 33 39 75 78 81 84 93 95 8 7 25 19 17 16 1
+ 22 24 23 21 28 13 14 26 15 2 3 27
c1 1 vss 0.00338506f $X=0.1335 $Y=0.135
c2 2 vss 0.000116099f $X=0.405 $Y=0.135
c3 3 vss 0.000501997f $X=0.675 $Y=0.135
c4 7 vss 0.00795041f $X=0.054 $Y=0.054
c5 8 vss 0.00789433f $X=0.054 $Y=0.216
c6 13 vss 0.0686525f $X=0.135 $Y=0.0245
c7 14 vss 0.00714092f $X=0.405 $Y=0.135
c8 15 vss 0.00730051f $X=0.675 $Y=0.135
c9 16 vss 0.0311383f $X=0.056 $Y=0.054
c10 17 vss 0.0311153f $X=0.056 $Y=0.216
c11 18 vss 0.00366892f $X=0.018 $Y=0.036
c12 19 vss 0.00214435f $X=0.0165 $Y=0.153
c13 20 vss 0.00360363f $X=0.018 $Y=0.234
c14 21 vss 0.00666166f $X=0.018 $Y=0.125
c15 22 vss 0.00421114f $X=0.018 $Y=0.163
c16 23 vss 0.00461076f $X=0.036 $Y=0.036
c17 24 vss 0.00421096f $X=0.036 $Y=0.234
c18 25 vss 0.00104135f $X=0.151 $Y=0.116
c19 26 vss 0.000774764f $X=0.405 $Y=0.135
c20 27 vss 0.00171448f $X=0.675 $Y=0.1135
c21 28 vss 0.0268757f $X=0.0215 $Y=0.153
r1 95 94 0.0462963 $w=5.4e-08 $l=2.5e-09 $layer=P_src_drn $thickness=1e-09
+ $X=0.0713 $Y=0.216 $X2=0.0685 $Y2=0.216
r2 17 94 0.231482 $w=5.4e-08 $l=1.25e-08 $layer=P_src_drn $thickness=1e-09
+ $X=0.056 $Y=0.216 $X2=0.0685 $Y2=0.216
r3 93 92 0.0462963 $w=5.4e-08 $l=2.5e-09 $layer=N_src_drn $thickness=1e-09
+ $X=0.0713 $Y=0.054 $X2=0.0685 $Y2=0.054
r4 16 92 0.231482 $w=5.4e-08 $l=1.25e-08 $layer=N_src_drn $thickness=1e-09
+ $X=0.056 $Y=0.054 $X2=0.0685 $Y2=0.054
r5 8 90 19.3796 $a=3.24e-16 $layer=V0LISD $X=0.054 $Y=0.216 $X2=0.055 $Y2=0.234
r6 7 87 19.3796 $a=3.24e-16 $layer=V0LISD $X=0.054 $Y=0.054 $X2=0.055 $Y2=0.036
r7 89 90 2.09871 $w=1.3e-08 $l=9e-09 $layer=M1 $thickness=3.6e-08 $X=0.046
+ $Y=0.234 $X2=0.055 $Y2=0.234
r8 24 89 2.3319 $w=1.3e-08 $l=1e-08 $layer=M1 $thickness=3.6e-08 $X=0.036
+ $Y=0.234 $X2=0.046 $Y2=0.234
r9 86 87 2.09871 $w=1.3e-08 $l=9e-09 $layer=M1 $thickness=3.6e-08 $X=0.046
+ $Y=0.036 $X2=0.055 $Y2=0.036
r10 23 86 2.3319 $w=1.3e-08 $l=1e-08 $layer=M1 $thickness=3.6e-08 $X=0.036
+ $Y=0.036 $X2=0.046 $Y2=0.036
r11 84 83 16.4967 $w=2.1e-08 $l=4.85e-08 $layer=Gate_1 $thickness=5.6e-08
+ $X=0.675 $Y=0.2295 $X2=0.675 $Y2=0.181
r12 81 82 16.4967 $w=2.1e-08 $l=4.85e-08 $layer=Gate_1 $thickness=5.6e-08
+ $X=0.675 $Y=0.0405 $X2=0.675 $Y2=0.089
r13 15 82 15.8334 $w=2.07609e-08 $l=4.6e-08 $layer=Gate_1 $thickness=5.6e-08
+ $X=0.675 $Y=0.135 $X2=0.675 $Y2=0.089
r14 15 83 15.8334 $w=2.07609e-08 $l=4.6e-08 $layer=Gate_1 $thickness=5.6e-08
+ $X=0.675 $Y=0.135 $X2=0.675 $Y2=0.181
r15 78 77 16.4967 $w=2.1e-08 $l=4.85e-08 $layer=Gate_1 $thickness=5.6e-08
+ $X=0.405 $Y=0.2295 $X2=0.405 $Y2=0.181
r16 75 76 16.4967 $w=2.1e-08 $l=4.85e-08 $layer=Gate_1 $thickness=5.6e-08
+ $X=0.405 $Y=0.0675 $X2=0.405 $Y2=0.116
r17 14 76 6.6497 $w=2.04211e-08 $l=1.9e-08 $layer=Gate_1 $thickness=5.6e-08
+ $X=0.405 $Y=0.135 $X2=0.405 $Y2=0.116
r18 14 77 15.8334 $w=2.07609e-08 $l=4.6e-08 $layer=Gate_1 $thickness=5.6e-08
+ $X=0.405 $Y=0.135 $X2=0.405 $Y2=0.181
r19 20 69 3.36447 $w=1.71023e-08 $l=2.15e-08 $layer=M1 $thickness=3.6e-08
+ $X=0.018 $Y=0.234 $X2=0.018 $Y2=0.2125
r20 20 24 2.5483 $w=1.55e-08 $l=1.8e-08 $layer=M1 $thickness=3.6e-08 $X=0.018
+ $Y=0.234 $X2=0.036 $Y2=0.234
r21 18 67 3.36447 $w=1.71023e-08 $l=2.15e-08 $layer=M1 $thickness=3.6e-08
+ $X=0.018 $Y=0.036 $X2=0.018 $Y2=0.0575
r22 18 23 2.5483 $w=1.55e-08 $l=1.8e-08 $layer=M1 $thickness=3.6e-08 $X=0.018
+ $Y=0.036 $X2=0.036 $Y2=0.036
r23 3 64 19.3796 $a=3.24e-16 $layer=V0LIG $X=0.675 $Y=0.135 $X2=0.675 $Y2=0.144
r24 3 15 6.54019 $w=2.09524e-08 $layer=Gate_1 $thickness=5.21905e-08 $X=0.675
+ $Y=0.135 $X2=0.675 $Y2=0.135
r25 2 26 19.3796 $a=3.24e-16 $layer=V0LIG $X=0.405 $Y=0.135 $X2=0.405 $Y2=0.135
r26 2 14 6.54019 $w=2.09524e-08 $layer=Gate_1 $thickness=5.21905e-08 $X=0.405
+ $Y=0.135 $X2=0.405 $Y2=0.135
r27 68 69 7.11229 $w=1.3e-08 $l=3.05e-08 $layer=M1 $thickness=3.6e-08 $X=0.018
+ $Y=0.182 $X2=0.018 $Y2=0.2125
r28 22 68 4.43061 $w=1.3e-08 $l=1.9e-08 $layer=M1 $thickness=3.6e-08 $X=0.018
+ $Y=0.163 $X2=0.018 $Y2=0.182
r29 66 67 7.11229 $w=1.3e-08 $l=3.05e-08 $layer=M1 $thickness=3.6e-08 $X=0.018
+ $Y=0.088 $X2=0.018 $Y2=0.0575
r30 21 66 8.62802 $w=1.3e-08 $l=3.7e-08 $layer=M1 $thickness=3.6e-08 $X=0.018
+ $Y=0.125 $X2=0.018 $Y2=0.088
r31 27 64 7.11229 $w=1.3e-08 $l=3.05e-08 $layer=M1 $thickness=3.6e-08 $X=0.675
+ $Y=0.1135 $X2=0.675 $Y2=0.144
r32 26 62 4.19742 $w=1.3e-08 $l=1.8e-08 $layer=M1 $thickness=3.6e-08 $X=0.405
+ $Y=0.135 $X2=0.405 $Y2=0.153
r33 58 59 1.90199 $w=1.38333e-08 $l=9e-09 $layer=M1 $thickness=3.6e-08
+ $X=0.0255 $Y=0.153 $X2=0.0345 $Y2=0.153
r34 19 58 0.9184 $w=1.8e-08 $l=9e-09 $layer=M1 $thickness=3.6e-08 $X=0.0165
+ $Y=0.153 $X2=0.0255 $Y2=0.153
r35 19 21 5.19594 $w=1.44151e-08 $l=2.80401e-08 $layer=M1 $thickness=3.6e-08
+ $X=0.0165 $Y=0.153 $X2=0.018 $Y2=0.125
r36 19 22 0.998523 $w=1.74118e-08 $l=1.01119e-08 $layer=M1 $thickness=3.6e-08
+ $X=0.0165 $Y=0.153 $X2=0.018 $Y2=0.163
r37 56 64 19.5347 $a=3.24e-16 $layer=V1 $X=0.675 $Y=0.153 $X2=0.675 $Y2=0.144
r38 55 56 18.3054 $w=1.3e-08 $l=7.85e-08 $layer=M2 $thickness=3.6e-08 $X=0.5965
+ $Y=0.153 $X2=0.675 $Y2=0.153
r39 54 55 29.3819 $w=1.3e-08 $l=1.26e-07 $layer=M2 $thickness=3.6e-08 $X=0.4705
+ $Y=0.153 $X2=0.5965 $Y2=0.153
r40 53 54 15.2739 $w=1.3e-08 $l=6.55e-08 $layer=M2 $thickness=3.6e-08 $X=0.405
+ $Y=0.153 $X2=0.4705 $Y2=0.153
r41 53 62 19.5347 $a=3.24e-16 $layer=V1 $X=0.405 $Y=0.153 $X2=0.405 $Y2=0.153
r42 52 53 27.8662 $w=1.3e-08 $l=1.195e-07 $layer=M2 $thickness=3.6e-08
+ $X=0.2855 $Y=0.153 $X2=0.405 $Y2=0.153
r43 51 52 27.5164 $w=1.3e-08 $l=1.18e-07 $layer=M2 $thickness=3.6e-08 $X=0.1675
+ $Y=0.153 $X2=0.2855 $Y2=0.153
r44 50 51 3.84763 $w=1.3e-08 $l=1.65e-08 $layer=M2 $thickness=3.6e-08 $X=0.151
+ $Y=0.153 $X2=0.1675 $Y2=0.153
r45 49 50 13.7582 $w=1.3e-08 $l=5.9e-08 $layer=M2 $thickness=3.6e-08 $X=0.092
+ $Y=0.153 $X2=0.151 $Y2=0.153
r46 48 49 13.7582 $w=1.3e-08 $l=5.9e-08 $layer=M2 $thickness=3.6e-08 $X=0.033
+ $Y=0.153 $X2=0.092 $Y2=0.153
r47 48 59 19.5347 $a=3.24e-16 $layer=V1 $X=0.033 $Y=0.153 $X2=0.0345 $Y2=0.153
r48 28 48 2.68168 $w=1.3e-08 $l=1.15e-08 $layer=M2 $thickness=3.6e-08 $X=0.0215
+ $Y=0.153 $X2=0.033 $Y2=0.153
r49 45 50 19.5347 $a=3.24e-16 $layer=V1 $X=0.151 $Y=0.144 $X2=0.151 $Y2=0.153
r50 25 45 6.52931 $w=1.3e-08 $l=2.8e-08 $layer=M1 $thickness=3.6e-08 $X=0.151
+ $Y=0.116 $X2=0.151 $Y2=0.144
r51 43 45 19.3796 $a=3.24e-16 $layer=V0LIG $X=0.1525 $Y=0.135 $X2=0.151
+ $Y2=0.144
r52 41 43 4.82216 $w=1.64167e-08 $l=9e-09 $layer=LIG $thickness=4.8e-08
+ $X=0.1435 $Y=0.135 $X2=0.1525 $Y2=0.135
r53 1 41 2.6116 $w=2.2e-08 $l=1e-08 $layer=LIG $thickness=4.8e-08 $X=0.1335
+ $Y=0.135 $X2=0.1435 $Y2=0.135
r54 1 36 6.14846 $w=2.08718e-08 $l=1.5e-09 $layer=Gate_1 $thickness=5.25128e-08
+ $X=0.1335 $Y=0.135 $X2=0.135 $Y2=0.135
r55 39 38 14.6259 $w=2.1e-08 $l=4.3e-08 $layer=Gate_1 $thickness=5.6e-08
+ $X=0.135 $Y=0.216 $X2=0.135 $Y2=0.173
r56 37 38 7.31297 $w=2.1e-08 $l=2.15e-08 $layer=Gate_1 $thickness=5.6e-08
+ $X=0.135 $Y=0.1515 $X2=0.135 $Y2=0.173
r57 36 37 5.79936 $w=2.03333e-08 $l=1.65e-08 $layer=Gate_1 $thickness=5.6e-08
+ $X=0.135 $Y=0.135 $X2=0.135 $Y2=0.1515
r58 36 41 4.32033 $w=2.024e-08 $l=8.5e-09 $layer=Gate_1 $thickness=5.504e-08
+ $X=0.135 $Y=0.135 $X2=0.1435 $Y2=0.135
r59 35 36 5.79936 $w=2.03333e-08 $l=1.65e-08 $layer=Gate_1 $thickness=5.6e-08
+ $X=0.135 $Y=0.1185 $X2=0.135 $Y2=0.135
r60 34 35 7.31297 $w=2.1e-08 $l=2.15e-08 $layer=Gate_1 $thickness=5.6e-08
+ $X=0.135 $Y=0.097 $X2=0.135 $Y2=0.1185
r61 33 34 14.6259 $w=2.1e-08 $l=4.3e-08 $layer=Gate_1 $thickness=5.6e-08
+ $X=0.135 $Y=0.054 $X2=0.135 $Y2=0.097
r62 33 13 10.0341 $w=2.1e-08 $l=2.95e-08 $layer=Gate_1 $thickness=5.6e-08
+ $X=0.135 $Y=0.054 $X2=0.135 $Y2=0.0245
r63 8 17 1e-05 $l=2e-09 $X=0.054 $Y=0.216 $X2=0.056 $Y2=0.216
r64 7 16 1e-05 $l=2e-09 $X=0.054 $Y=0.054 $X2=0.056 $Y2=0.054
.ends

.subckt PM_DFFHQNx3_ASAP7_75t_R%6 vss 32 79 81 83 87 92 7 6 23 21 20 18 19 3 4
+ 22 25 1 8 2 24 26 15 17 14 16
c1 1 vss 0.000928613f $X=0.351 $Y=0.135
c2 2 vss 7.67949e-20 $X=0.459 $Y=0.178
c3 3 vss 4.38325e-20 $X=0.621 $Y=0.178
c4 4 vss 0.000976264f $X=0.729 $Y=0.178
c5 6 vss 0.00762171f $X=0.162 $Y=0.054
c6 7 vss 0.00762088f $X=0.162 $Y=0.216
c7 8 vss 0.00485507f $X=0.501 $Y=0.178
c8 14 vss 0.00835212f $X=0.351 $Y=0.073
c9 15 vss 0.00696514f $X=0.459 $Y=0.178
c10 16 vss 0.0064041f $X=0.621 $Y=0.178
c11 17 vss 0.0078598f $X=0.729 $Y=0.178
c12 18 vss 0.0365716f $X=0.1475 $Y=0.054
c13 19 vss 0.035979f $X=0.1475 $Y=0.216
c14 20 vss 0.00626028f $X=0.189 $Y=0.036
c15 21 vss 0.00600247f $X=0.189 $Y=0.234
c16 22 vss 0.00116284f $X=0.3375 $Y=0.135
c17 23 vss 0.00626836f $X=0.189 $Y=0.1735
c18 24 vss 0.00242675f $X=0.324 $Y=0.1555
c19 25 vss 0.00150725f $X=0.513 $Y=0.168
c20 26 vss 0.0262923f $X=0.1775 $Y=0.189
r1 92 91 8.84359 $w=2.1e-08 $l=2.6e-08 $layer=Gate_1 $thickness=5.6e-08
+ $X=0.729 $Y=0.2295 $X2=0.729 $Y2=0.2035
r2 17 91 8.89461 $w=2.04902e-08 $l=2.55e-08 $layer=Gate_1 $thickness=5.6e-08
+ $X=0.729 $Y=0.178 $X2=0.729 $Y2=0.2035
r3 87 88 23.4695 $w=2.1e-08 $l=6.9e-08 $layer=Gate_1 $thickness=5.6e-08
+ $X=0.621 $Y=0.0405 $X2=0.621 $Y2=0.1095
r4 16 88 23.5205 $w=2.08102e-08 $l=6.85e-08 $layer=Gate_1 $thickness=5.6e-08
+ $X=0.621 $Y=0.178 $X2=0.621 $Y2=0.1095
r5 83 84 23.4695 $w=2.1e-08 $l=6.9e-08 $layer=Gate_1 $thickness=5.6e-08
+ $X=0.459 $Y=0.0405 $X2=0.459 $Y2=0.1095
r6 15 84 23.5205 $w=2.08102e-08 $l=6.85e-08 $layer=Gate_1 $thickness=5.6e-08
+ $X=0.459 $Y=0.178 $X2=0.459 $Y2=0.1095
r7 19 7 0.231482 $w=5.4e-08 $l=1.25e-08 $layer=P_src_drn $thickness=1e-09
+ $X=0.1475 $Y=0.216 $X2=0.162 $Y2=0.216
r8 81 19 0.0462963 $w=5.4e-08 $l=2.5e-09 $layer=P_src_drn $thickness=1e-09
+ $X=0.1446 $Y=0.216 $X2=0.1475 $Y2=0.216
r9 18 6 0.231482 $w=5.4e-08 $l=1.25e-08 $layer=N_src_drn $thickness=1e-09
+ $X=0.1475 $Y=0.054 $X2=0.162 $Y2=0.054
r10 79 18 0.0462963 $w=5.4e-08 $l=2.5e-09 $layer=N_src_drn $thickness=1e-09
+ $X=0.1446 $Y=0.054 $X2=0.1475 $Y2=0.054
r11 4 77 2.78395 $w=2.4e-08 $l=4e-09 $layer=LIG $thickness=4.8e-08 $X=0.729
+ $Y=0.178 $X2=0.725 $Y2=0.178
r12 4 17 7.42683 $w=2.2e-08 $layer=Gate_1 $thickness=5.2e-08 $X=0.729 $Y=0.178
+ $X2=0.729 $Y2=0.178
r13 3 72 10.3807 $w=2.30357e-08 $layer=LISD $thickness=3.675e-08 $X=0.621
+ $Y=0.178 $X2=0.621 $Y2=0.178
r14 3 16 7.42683 $w=2.2e-08 $layer=Gate_1 $thickness=5.2e-08 $X=0.621 $Y=0.178
+ $X2=0.621 $Y2=0.178
r15 2 68 2.78395 $w=2.4e-08 $l=5e-09 $layer=LIG $thickness=4.8e-08 $X=0.459
+ $Y=0.178 $X2=0.464 $Y2=0.178
r16 2 15 7.42683 $w=2.2e-08 $layer=Gate_1 $thickness=5.2e-08 $X=0.459 $Y=0.178
+ $X2=0.459 $Y2=0.178
r17 7 61 19.3796 $a=3.24e-16 $layer=V0LISD $X=0.162 $Y=0.216 $X2=0.1655
+ $Y2=0.234
r18 6 57 19.3796 $a=3.24e-16 $layer=V0LISD $X=0.162 $Y=0.054 $X2=0.1655
+ $Y2=0.036
r19 76 77 4.8113 $w=2.22e-08 $l=1.5e-09 $layer=LISD $thickness=2.7e-08
+ $X=0.7235 $Y=0.178 $X2=0.725 $Y2=0.178
r20 75 76 10.8887 $w=2.22e-08 $l=2.15e-08 $layer=LISD $thickness=2.7e-08
+ $X=0.702 $Y=0.178 $X2=0.7235 $Y2=0.178
r21 74 75 13.6742 $w=2.22e-08 $l=2.7e-08 $layer=LISD $thickness=2.7e-08
+ $X=0.675 $Y=0.178 $X2=0.702 $Y2=0.178
r22 73 74 13.6742 $w=2.22e-08 $l=2.7e-08 $layer=LISD $thickness=2.7e-08
+ $X=0.648 $Y=0.178 $X2=0.675 $Y2=0.178
r23 72 73 13.6742 $w=2.22e-08 $l=2.7e-08 $layer=LISD $thickness=2.7e-08
+ $X=0.621 $Y=0.178 $X2=0.648 $Y2=0.178
r24 71 72 13.6742 $w=2.22e-08 $l=2.7e-08 $layer=LISD $thickness=2.7e-08
+ $X=0.594 $Y=0.178 $X2=0.621 $Y2=0.178
r25 70 71 13.6742 $w=2.22e-08 $l=2.7e-08 $layer=LISD $thickness=2.7e-08
+ $X=0.567 $Y=0.178 $X2=0.594 $Y2=0.178
r26 69 70 13.6742 $w=2.22e-08 $l=2.7e-08 $layer=LISD $thickness=2.7e-08 $X=0.54
+ $Y=0.178 $X2=0.567 $Y2=0.178
r27 67 68 10.3823 $w=2.22e-08 $l=1.35e-08 $layer=LISD $thickness=2.7e-08
+ $X=0.4775 $Y=0.178 $X2=0.464 $Y2=0.178
r28 66 69 7.59679 $w=2.22e-08 $l=1.5e-08 $layer=LISD $thickness=2.7e-08
+ $X=0.525 $Y=0.178 $X2=0.54 $Y2=0.178
r29 65 66 6.07743 $w=2.22e-08 $l=1.2e-08 $layer=LISD $thickness=2.7e-08
+ $X=0.513 $Y=0.178 $X2=0.525 $Y2=0.178
r30 8 65 6.07743 $w=2.22e-08 $l=1.2e-08 $layer=LISD $thickness=2.7e-08 $X=0.501
+ $Y=0.178 $X2=0.513 $Y2=0.178
r31 8 67 11.9016 $w=2.22e-08 $l=2.35e-08 $layer=LISD $thickness=2.7e-08
+ $X=0.501 $Y=0.178 $X2=0.4775 $Y2=0.178
r32 61 62 2.3319 $w=1.3e-08 $l=1e-08 $layer=M1 $thickness=3.6e-08 $X=0.1655
+ $Y=0.234 $X2=0.1755 $Y2=0.234
r33 21 54 3.83327 $w=1.5093e-08 $l=2.15e-08 $layer=M1 $thickness=3.6e-08
+ $X=0.189 $Y=0.234 $X2=0.189 $Y2=0.2125
r34 21 62 1.96775 $w=1.63333e-08 $l=1.35e-08 $layer=M1 $thickness=3.6e-08
+ $X=0.189 $Y=0.234 $X2=0.1755 $Y2=0.234
r35 57 58 2.3319 $w=1.3e-08 $l=1e-08 $layer=M1 $thickness=3.6e-08 $X=0.1655
+ $Y=0.036 $X2=0.1755 $Y2=0.036
r36 20 53 3.83327 $w=1.5093e-08 $l=2.15e-08 $layer=M1 $thickness=3.6e-08
+ $X=0.189 $Y=0.036 $X2=0.189 $Y2=0.0575
r37 20 58 1.96775 $w=1.63333e-08 $l=1.35e-08 $layer=M1 $thickness=3.6e-08
+ $X=0.189 $Y=0.036 $X2=0.1755 $Y2=0.036
r38 55 65 19.3796 $a=3.24e-16 $layer=V0LISD $X=0.513 $Y=0.1845 $X2=0.513
+ $Y2=0.178
r39 25 55 3.84763 $w=1.3e-08 $l=1.65e-08 $layer=M1 $thickness=3.6e-08 $X=0.513
+ $Y=0.168 $X2=0.513 $Y2=0.1845
r40 52 53 7.11229 $w=1.3e-08 $l=3.05e-08 $layer=M1 $thickness=3.6e-08 $X=0.189
+ $Y=0.088 $X2=0.189 $Y2=0.0575
r41 51 52 11.3097 $w=1.3e-08 $l=4.85e-08 $layer=M1 $thickness=3.6e-08 $X=0.189
+ $Y=0.1365 $X2=0.189 $Y2=0.088
r42 50 54 3.14806 $w=1.3e-08 $l=1.35e-08 $layer=M1 $thickness=3.6e-08 $X=0.189
+ $Y=0.199 $X2=0.189 $Y2=0.2125
r43 49 50 2.3319 $w=1.3e-08 $l=1e-08 $layer=M1 $thickness=3.6e-08 $X=0.189
+ $Y=0.189 $X2=0.189 $Y2=0.199
r44 23 49 3.61444 $w=1.3e-08 $l=1.55e-08 $layer=M1 $thickness=3.6e-08 $X=0.189
+ $Y=0.1735 $X2=0.189 $Y2=0.189
r45 23 51 8.62802 $w=1.3e-08 $l=3.7e-08 $layer=M1 $thickness=3.6e-08 $X=0.189
+ $Y=0.1735 $X2=0.189 $Y2=0.1365
r46 47 55 19.5347 $a=3.24e-16 $layer=V1 $X=0.513 $Y=0.189 $X2=0.513 $Y2=0.1845
r47 46 47 22.0364 $w=1.3e-08 $l=9.45e-08 $layer=M2 $thickness=3.6e-08 $X=0.4185
+ $Y=0.189 $X2=0.513 $Y2=0.189
r48 45 46 22.0364 $w=1.3e-08 $l=9.45e-08 $layer=M2 $thickness=3.6e-08 $X=0.324
+ $Y=0.189 $X2=0.4185 $Y2=0.189
r49 44 45 15.7403 $w=1.3e-08 $l=6.75e-08 $layer=M2 $thickness=3.6e-08 $X=0.2565
+ $Y=0.189 $X2=0.324 $Y2=0.189
r50 43 44 15.7403 $w=1.3e-08 $l=6.75e-08 $layer=M2 $thickness=3.6e-08 $X=0.189
+ $Y=0.189 $X2=0.2565 $Y2=0.189
r51 43 49 19.5347 $a=3.24e-16 $layer=V1 $X=0.189 $Y=0.189 $X2=0.189 $Y2=0.189
r52 26 43 2.68168 $w=1.3e-08 $l=1.15e-08 $layer=M2 $thickness=3.6e-08 $X=0.1775
+ $Y=0.189 $X2=0.189 $Y2=0.189
r53 41 45 19.5347 $a=3.24e-16 $layer=V1 $X=0.324 $Y=0.189 $X2=0.324 $Y2=0.189
r54 40 41 3.61444 $w=1.3e-08 $l=1.55e-08 $layer=M1 $thickness=3.6e-08 $X=0.324
+ $Y=0.1735 $X2=0.324 $Y2=0.189
r55 24 38 3.60008 $w=1.51951e-08 $l=2.05e-08 $layer=M1 $thickness=3.6e-08
+ $X=0.324 $Y=0.1555 $X2=0.324 $Y2=0.135
r56 24 40 4.19742 $w=1.3e-08 $l=1.8e-08 $layer=M1 $thickness=3.6e-08 $X=0.324
+ $Y=0.1555 $X2=0.324 $Y2=0.1735
r57 22 36 3.14806 $w=1.3e-08 $l=1.35e-08 $layer=M1 $thickness=3.6e-08 $X=0.3375
+ $Y=0.135 $X2=0.351 $Y2=0.135
r58 22 38 1.96775 $w=1.63333e-08 $l=1.35e-08 $layer=M1 $thickness=3.6e-08
+ $X=0.3375 $Y=0.135 $X2=0.324 $Y2=0.135
r59 1 30 6.54019 $w=2.09524e-08 $layer=Gate_1 $thickness=5.21905e-08 $X=0.351
+ $Y=0.135 $X2=0.351 $Y2=0.135
r60 1 36 19.3796 $a=3.24e-16 $layer=V0LIG $X=0.351 $Y=0.135 $X2=0.351 $Y2=0.135
r61 32 31 16.4967 $w=2.1e-08 $l=4.85e-08 $layer=Gate_1 $thickness=5.6e-08
+ $X=0.351 $Y=0.2025 $X2=0.351 $Y2=0.154
r62 30 31 6.6497 $w=2.04211e-08 $l=1.9e-08 $layer=Gate_1 $thickness=5.6e-08
+ $X=0.351 $Y=0.135 $X2=0.351 $Y2=0.154
r63 14 30 21.2756 $w=2.08226e-08 $l=6.2e-08 $layer=Gate_1 $thickness=5.6e-08
+ $X=0.351 $Y=0.073 $X2=0.351 $Y2=0.135
.ends

.subckt PM_DFFHQNx3_ASAP7_75t_R%7 vss 20 24 46 47 51 53 13 17 19 14 16 3 4 1 12
+ 11 10 18
c1 1 vss 0.00225666f $X=0.513 $Y=0.09
c2 3 vss 0.00487415f $X=0.594 $Y=0.0405
c3 4 vss 0.00839176f $X=0.594 $Y=0.2295
c4 10 vss 0.0523365f $X=0.513 $Y=0.0245
c5 11 vss 0.00384844f $X=0.5795 $Y=0.0405
c6 12 vss 0.00362374f $X=0.5795 $Y=0.2295
c7 13 vss 0.00324506f $X=0.65 $Y=0.2295
c8 14 vss 0.000542471f $X=0.594 $Y=0.09
c9 15 vss 0.00263857f $X=0.621 $Y=0.2335
c10 16 vss 0.00236326f $X=0.5 $Y=0.09
c11 17 vss 0.00395074f $X=0.594 $Y=0.234
c12 18 vss 0.00192431f $X=0.594 $Y=0.054
c13 19 vss 0.00141621f $X=0.621 $Y=0.1
r1 53 52 0.0925926 $w=2.7e-08 $l=2.5e-09 $layer=P_src_drn $thickness=1e-09
+ $X=0.6653 $Y=0.2295 $X2=0.6625 $Y2=0.2295
r2 13 52 0.462963 $w=2.7e-08 $l=1.25e-08 $layer=P_src_drn $thickness=1e-09
+ $X=0.65 $Y=0.2295 $X2=0.6625 $Y2=0.2295
r3 12 4 0.462963 $w=2.7e-08 $l=1.25e-08 $layer=P_src_drn $thickness=1e-09
+ $X=0.5795 $Y=0.2295 $X2=0.594 $Y2=0.2295
r4 51 12 0.0925926 $w=2.7e-08 $l=2.5e-09 $layer=P_src_drn $thickness=1e-09
+ $X=0.5766 $Y=0.2295 $X2=0.5795 $Y2=0.2295
r5 48 13 12.6992 $w=2.32e-08 $l=2.7e-08 $layer=LISD $thickness=2.7e-08 $X=0.621
+ $Y=0.2295 $X2=0.65 $Y2=0.2295
r6 4 48 12.6992 $w=2.32e-08 $l=2.7e-08 $layer=LISD $thickness=2.7e-08 $X=0.594
+ $Y=0.2295 $X2=0.621 $Y2=0.2295
r7 4 17 19.3796 $a=3.24e-16 $layer=V0LISD $X=0.594 $Y=0.2295 $X2=0.594 $Y2=0.234
r8 47 45 0.0925926 $w=2.7e-08 $l=2.5e-09 $layer=N_src_drn $thickness=1e-09
+ $X=0.6113 $Y=0.0405 $X2=0.6085 $Y2=0.0405
r9 3 45 0.537037 $w=2.7e-08 $l=1.45e-08 $layer=N_src_drn $thickness=1e-09
+ $X=0.594 $Y=0.0405 $X2=0.6085 $Y2=0.0405
r10 11 3 0.537037 $w=2.7e-08 $l=1.45e-08 $layer=N_src_drn $thickness=1e-09
+ $X=0.5795 $Y=0.0405 $X2=0.594 $Y2=0.0405
r11 46 11 0.0925926 $w=2.7e-08 $l=2.5e-09 $layer=N_src_drn $thickness=1e-09
+ $X=0.5766 $Y=0.0405 $X2=0.5795 $Y2=0.0405
r12 15 40 0.983973 $w=1.77222e-08 $l=9e-09 $layer=M1 $thickness=3.6e-08
+ $X=0.621 $Y=0.2335 $X2=0.621 $Y2=0.2245
r13 15 17 5.06479 $w=1.46038e-08 $l=2.70046e-08 $layer=M1 $thickness=3.6e-08
+ $X=0.621 $Y=0.2335 $X2=0.594 $Y2=0.234
r14 3 18 19.3796 $a=3.24e-16 $layer=V0LISD $X=0.594 $Y=0.0405 $X2=0.594
+ $Y2=0.054
r15 39 40 2.56509 $w=1.3e-08 $l=1.1e-08 $layer=M1 $thickness=3.6e-08 $X=0.621
+ $Y=0.2135 $X2=0.621 $Y2=0.2245
r16 38 39 6.64591 $w=1.3e-08 $l=2.85e-08 $layer=M1 $thickness=3.6e-08 $X=0.621
+ $Y=0.185 $X2=0.621 $Y2=0.2135
r17 37 38 4.43061 $w=1.3e-08 $l=1.9e-08 $layer=M1 $thickness=3.6e-08 $X=0.621
+ $Y=0.166 $X2=0.621 $Y2=0.185
r18 36 37 3.14806 $w=1.3e-08 $l=1.35e-08 $layer=M1 $thickness=3.6e-08 $X=0.621
+ $Y=0.1525 $X2=0.621 $Y2=0.166
r19 35 36 5.01358 $w=1.3e-08 $l=2.15e-08 $layer=M1 $thickness=3.6e-08 $X=0.621
+ $Y=0.131 $X2=0.621 $Y2=0.1525
r20 34 35 4.5472 $w=1.3e-08 $l=1.95e-08 $layer=M1 $thickness=3.6e-08 $X=0.621
+ $Y=0.1115 $X2=0.621 $Y2=0.131
r21 19 32 1.15159 $w=1.75e-08 $l=1e-08 $layer=M1 $thickness=3.6e-08 $X=0.621
+ $Y=0.1 $X2=0.621 $Y2=0.09
r22 19 34 2.68168 $w=1.3e-08 $l=1.15e-08 $layer=M1 $thickness=3.6e-08 $X=0.621
+ $Y=0.1 $X2=0.621 $Y2=0.1115
r23 18 33 4.19742 $w=1.3e-08 $l=1.8e-08 $layer=M1 $thickness=3.6e-08 $X=0.594
+ $Y=0.054 $X2=0.594 $Y2=0.072
r24 31 32 1.96775 $w=1.63333e-08 $l=1.35e-08 $layer=M1 $thickness=3.6e-08
+ $X=0.6075 $Y=0.09 $X2=0.621 $Y2=0.09
r25 14 30 1.96775 $w=1.63333e-08 $l=1.35e-08 $layer=M1 $thickness=3.6e-08
+ $X=0.594 $Y=0.09 $X2=0.5805 $Y2=0.09
r26 14 31 1.96775 $w=1.63333e-08 $l=1.35e-08 $layer=M1 $thickness=3.6e-08
+ $X=0.594 $Y=0.09 $X2=0.6075 $Y2=0.09
r27 14 33 3.01711 $w=1.55e-08 $l=1.8e-08 $layer=M1 $thickness=3.6e-08 $X=0.594
+ $Y=0.09 $X2=0.594 $Y2=0.072
r28 29 30 7.34548 $w=1.3e-08 $l=3.15e-08 $layer=M1 $thickness=3.6e-08 $X=0.549
+ $Y=0.09 $X2=0.5805 $Y2=0.09
r29 28 29 8.39483 $w=1.3e-08 $l=3.6e-08 $layer=M1 $thickness=3.6e-08 $X=0.513
+ $Y=0.09 $X2=0.549 $Y2=0.09
r30 16 28 3.03147 $w=1.3e-08 $l=1.3e-08 $layer=M1 $thickness=3.6e-08 $X=0.5
+ $Y=0.09 $X2=0.513 $Y2=0.09
r31 1 22 6.54019 $w=2.09524e-08 $layer=Gate_1 $thickness=5.21905e-08 $X=0.513
+ $Y=0.09 $X2=0.513 $Y2=0.09
r32 1 28 19.3796 $a=3.24e-16 $layer=V0LIG $X=0.513 $Y=0.09 $X2=0.513 $Y2=0.09
r33 24 23 24.1498 $w=2.1e-08 $l=7.1e-08 $layer=Gate_1 $thickness=5.6e-08
+ $X=0.513 $Y=0.2295 $X2=0.513 $Y2=0.1585
r34 22 23 23.4865 $w=2.08394e-08 $l=6.85e-08 $layer=Gate_1 $thickness=5.6e-08
+ $X=0.513 $Y=0.09 $X2=0.513 $Y2=0.1585
r35 21 22 8.18032 $w=2.05319e-08 $l=2.35e-08 $layer=Gate_1 $thickness=5.6e-08
+ $X=0.513 $Y=0.0665 $X2=0.513 $Y2=0.09
r36 20 21 8.84359 $w=2.1e-08 $l=2.6e-08 $layer=Gate_1 $thickness=5.6e-08
+ $X=0.513 $Y=0.0405 $X2=0.513 $Y2=0.0665
r37 20 10 5.44221 $w=2.1e-08 $l=1.6e-08 $layer=Gate_1 $thickness=5.6e-08
+ $X=0.513 $Y=0.0405 $X2=0.513 $Y2=0.0245
.ends

.subckt PM_DFFHQNx3_ASAP7_75t_R%9 vss 19 23 35 45 9 14 18 3 4 1 17 12 15 16 10
+ 11
c1 1 vss 0.00162518f $X=0.783 $Y=0.1055
c2 3 vss 0.00645509f $X=0.864 $Y=0.0405
c3 4 vss 0.00665789f $X=0.864 $Y=0.2295
c4 9 vss 0.0413765f $X=0.783 $Y=0.0245
c5 10 vss 0.0188123f $X=0.8495 $Y=0.0405
c6 11 vss 0.0188202f $X=0.8495 $Y=0.2295
c7 12 vss 0.00283228f $X=0.783 $Y=0.036
c8 13 vss 0.00371709f $X=0.945 $Y=0.036
c9 14 vss 0.00365163f $X=0.945 $Y=0.234
c10 15 vss 0.00232148f $X=0.783 $Y=0.0705
c11 16 vss 0.0137767f $X=0.81 $Y=0.036
c12 17 vss 0.00914614f $X=0.918 $Y=0.234
c13 18 vss 0.00877653f $X=0.945 $Y=0.081
r1 11 4 0.462963 $w=2.7e-08 $l=1.25e-08 $layer=P_src_drn $thickness=1e-09
+ $X=0.8495 $Y=0.2295 $X2=0.864 $Y2=0.2295
r2 45 11 0.0925926 $w=2.7e-08 $l=2.5e-09 $layer=P_src_drn $thickness=1e-09
+ $X=0.8466 $Y=0.2295 $X2=0.8495 $Y2=0.2295
r3 4 42 19.3796 $a=3.24e-16 $layer=V0LISD $X=0.864 $Y=0.2295 $X2=0.864 $Y2=0.234
r4 42 43 5.24677 $w=1.3e-08 $l=2.25e-08 $layer=M1 $thickness=3.6e-08 $X=0.864
+ $Y=0.234 $X2=0.8865 $Y2=0.234
r5 17 43 7.34548 $w=1.3e-08 $l=3.15e-08 $layer=M1 $thickness=3.6e-08 $X=0.918
+ $Y=0.234 $X2=0.8865 $Y2=0.234
r6 14 40 0.56619 $w=2.22842e-08 $l=9.5e-09 $layer=M1 $thickness=3.6e-08
+ $X=0.945 $Y=0.234 $X2=0.945 $Y2=0.2245
r7 14 17 4.64701 $w=1.46667e-08 $l=2.7e-08 $layer=M1 $thickness=3.6e-08
+ $X=0.945 $Y=0.234 $X2=0.918 $Y2=0.234
r8 39 40 6.29612 $w=1.3e-08 $l=2.7e-08 $layer=M1 $thickness=3.6e-08 $X=0.945
+ $Y=0.1975 $X2=0.945 $Y2=0.2245
r9 38 39 6.64591 $w=1.3e-08 $l=2.85e-08 $layer=M1 $thickness=3.6e-08 $X=0.945
+ $Y=0.169 $X2=0.945 $Y2=0.1975
r10 37 38 5.71315 $w=1.3e-08 $l=2.45e-08 $layer=M1 $thickness=3.6e-08 $X=0.945
+ $Y=0.1445 $X2=0.945 $Y2=0.169
r11 36 37 5.82974 $w=1.3e-08 $l=2.5e-08 $layer=M1 $thickness=3.6e-08 $X=0.945
+ $Y=0.1195 $X2=0.945 $Y2=0.1445
r12 18 36 8.97781 $w=1.3e-08 $l=3.85e-08 $layer=M1 $thickness=3.6e-08 $X=0.945
+ $Y=0.081 $X2=0.945 $Y2=0.1195
r13 10 3 0.462963 $w=2.7e-08 $l=1.25e-08 $layer=N_src_drn $thickness=1e-09
+ $X=0.8495 $Y=0.0405 $X2=0.864 $Y2=0.0405
r14 35 10 0.0925926 $w=2.7e-08 $l=2.5e-09 $layer=N_src_drn $thickness=1e-09
+ $X=0.8466 $Y=0.0405 $X2=0.8495 $Y2=0.0405
r15 13 33 4.64701 $w=1.46667e-08 $l=2.7e-08 $layer=M1 $thickness=3.6e-08
+ $X=0.945 $Y=0.036 $X2=0.918 $Y2=0.036
r16 13 18 8.84443 $w=1.496e-08 $l=4.5e-08 $layer=M1 $thickness=3.6e-08 $X=0.945
+ $Y=0.036 $X2=0.945 $Y2=0.081
r17 3 31 19.3796 $a=3.24e-16 $layer=V0LISD $X=0.864 $Y=0.0405 $X2=0.864
+ $Y2=0.036
r18 32 33 6.29612 $w=1.3e-08 $l=2.7e-08 $layer=M1 $thickness=3.6e-08 $X=0.891
+ $Y=0.036 $X2=0.918 $Y2=0.036
r19 31 32 6.29612 $w=1.3e-08 $l=2.7e-08 $layer=M1 $thickness=3.6e-08 $X=0.864
+ $Y=0.036 $X2=0.891 $Y2=0.036
r20 30 31 6.29612 $w=1.3e-08 $l=2.7e-08 $layer=M1 $thickness=3.6e-08 $X=0.837
+ $Y=0.036 $X2=0.864 $Y2=0.036
r21 16 30 6.29612 $w=1.3e-08 $l=2.7e-08 $layer=M1 $thickness=3.6e-08 $X=0.81
+ $Y=0.036 $X2=0.837 $Y2=0.036
r22 12 15 6.39593 $w=1.55565e-08 $l=3.45e-08 $layer=M1 $thickness=3.6e-08
+ $X=0.783 $Y=0.036 $X2=0.783 $Y2=0.0705
r23 12 16 4.64701 $w=1.46667e-08 $l=2.7e-08 $layer=M1 $thickness=3.6e-08
+ $X=0.783 $Y=0.036 $X2=0.81 $Y2=0.036
r24 15 27 8.04505 $w=1.3e-08 $l=3.45e-08 $layer=M1 $thickness=3.6e-08 $X=0.783
+ $Y=0.0705 $X2=0.783 $Y2=0.105
r25 1 21 6.4735 $w=2.13953e-08 $layer=Gate_1 $thickness=5.22791e-08 $X=0.783
+ $Y=0.1055 $X2=0.783 $Y2=0.1055
r26 1 27 19.3796 $a=3.24e-16 $layer=V0LIG $X=0.783 $Y=0.1055 $X2=0.783 $Y2=0.105
r27 23 22 21.4287 $w=2.1e-08 $l=6.3e-08 $layer=Gate_1 $thickness=5.6e-08
+ $X=0.783 $Y=0.2295 $X2=0.783 $Y2=0.1665
r28 21 22 20.944 $w=2.08115e-08 $l=6.1e-08 $layer=Gate_1 $thickness=5.6e-08
+ $X=0.783 $Y=0.1055 $X2=0.783 $Y2=0.1665
r29 20 21 10.9099 $w=2.06349e-08 $l=3.15e-08 $layer=Gate_1 $thickness=5.6e-08
+ $X=0.783 $Y=0.074 $X2=0.783 $Y2=0.1055
r30 19 20 11.3946 $w=2.1e-08 $l=3.35e-08 $layer=Gate_1 $thickness=5.6e-08
+ $X=0.783 $Y=0.0405 $X2=0.783 $Y2=0.074
r31 19 9 5.44221 $w=2.1e-08 $l=1.6e-08 $layer=Gate_1 $thickness=5.6e-08
+ $X=0.783 $Y=0.0405 $X2=0.783 $Y2=0.0245
.ends

.subckt PM_DFFHQNx3_ASAP7_75t_R%QN vss 31 24 25 35 42 43 45 15 1 2 14 16 13
c1 1 vss 0.0102f $X=1.026 $Y=0.0675
c2 2 vss 0.00912819f $X=1.026 $Y=0.2025
c3 3 vss 0.00816777f $X=1.134 $Y=0.0675
c4 4 vss 0.0081524f $X=1.134 $Y=0.2025
c5 13 vss 0.00450412f $X=1.0115 $Y=0.0675
c6 14 vss 0.0371365f $X=1.1195 $Y=0.0675
c7 15 vss 0.00452186f $X=1.0115 $Y=0.2025
c8 16 vss 0.0371299f $X=1.1195 $Y=0.2025
c9 17 vss 0.00265706f $X=1.162 $Y=0.036
c10 18 vss 0.00265706f $X=1.162 $Y=0.234
c11 19 vss 0.0133614f $X=1.0145 $Y=0.036
c12 20 vss 0.0134652f $X=1.0145 $Y=0.234
c13 21 vss 0.00501817f $X=1.162 $Y=0.0835
r1 16 4 0.154321 $w=8.1e-08 $l=1.25e-08 $layer=P_src_drn $thickness=1e-09
+ $X=1.1195 $Y=0.2025 $X2=1.134 $Y2=0.2025
r2 45 16 0.0308642 $w=8.1e-08 $l=2.5e-09 $layer=P_src_drn $thickness=1e-09
+ $X=1.1166 $Y=0.2025 $X2=1.1195 $Y2=0.2025
r3 43 41 0.0308642 $w=8.1e-08 $l=2.5e-09 $layer=P_src_drn $thickness=1e-09
+ $X=1.0433 $Y=0.2025 $X2=1.0405 $Y2=0.2025
r4 2 41 0.179012 $w=8.1e-08 $l=1.45e-08 $layer=P_src_drn $thickness=1e-09
+ $X=1.026 $Y=0.2025 $X2=1.0405 $Y2=0.2025
r5 15 2 0.179012 $w=8.1e-08 $l=1.45e-08 $layer=P_src_drn $thickness=1e-09
+ $X=1.0115 $Y=0.2025 $X2=1.026 $Y2=0.2025
r6 42 15 0.0308642 $w=8.1e-08 $l=2.5e-09 $layer=P_src_drn $thickness=1e-09
+ $X=1.0086 $Y=0.2025 $X2=1.0115 $Y2=0.2025
r7 4 38 19.3796 $a=3.24e-16 $layer=V0LISD $X=1.134 $Y=0.2025 $X2=1.134 $Y2=0.234
r8 2 36 19.3796 $a=3.24e-16 $layer=V0LISD $X=1.026 $Y=0.2025 $X2=1.026 $Y2=0.234
r9 38 39 3.26466 $w=1.3e-08 $l=1.4e-08 $layer=M1 $thickness=3.6e-08 $X=1.134
+ $Y=0.234 $X2=1.148 $Y2=0.234
r10 37 38 12.5922 $w=1.3e-08 $l=5.4e-08 $layer=M1 $thickness=3.6e-08 $X=1.08
+ $Y=0.234 $X2=1.134 $Y2=0.234
r11 36 37 12.5922 $w=1.3e-08 $l=5.4e-08 $layer=M1 $thickness=3.6e-08 $X=1.026
+ $Y=0.234 $X2=1.08 $Y2=0.234
r12 20 36 2.68168 $w=1.3e-08 $l=1.15e-08 $layer=M1 $thickness=3.6e-08 $X=1.0145
+ $Y=0.234 $X2=1.026 $Y2=0.234
r13 18 33 7.2121 $w=1.53211e-08 $l=3.8e-08 $layer=M1 $thickness=3.6e-08
+ $X=1.162 $Y=0.234 $X2=1.162 $Y2=0.196
r14 18 39 1.61554 $w=1.62143e-08 $l=1.4e-08 $layer=M1 $thickness=3.6e-08
+ $X=1.162 $Y=0.234 $X2=1.148 $Y2=0.234
r15 14 3 0.154321 $w=8.1e-08 $l=1.25e-08 $layer=N_src_drn $thickness=1e-09
+ $X=1.1195 $Y=0.0675 $X2=1.134 $Y2=0.0675
r16 35 14 0.0308642 $w=8.1e-08 $l=2.5e-09 $layer=N_src_drn $thickness=1e-09
+ $X=1.1166 $Y=0.0675 $X2=1.1195 $Y2=0.0675
r17 32 33 8.80291 $w=1.3e-08 $l=3.78e-08 $layer=M1 $thickness=3.6e-08 $X=1.162
+ $Y=0.1582 $X2=1.162 $Y2=0.196
r18 31 32 2.15701 $w=1.3e-08 $l=9.2e-09 $layer=M1 $thickness=3.6e-08 $X=1.166
+ $Y=0.149 $X2=1.162 $Y2=0.1582
r19 31 30 3.20636 $w=1.3e-08 $l=1.38e-08 $layer=M1 $thickness=3.6e-08 $X=1.166
+ $Y=0.149 $X2=1.162 $Y2=0.1352
r20 21 30 12.0676 $w=1.3e-08 $l=5.17e-08 $layer=M1 $thickness=3.6e-08 $X=1.162
+ $Y=0.0835 $X2=1.162 $Y2=0.1352
r21 3 28 19.3796 $a=3.24e-16 $layer=V0LISD $X=1.134 $Y=0.0675 $X2=1.134
+ $Y2=0.036
r22 17 29 1.61554 $w=1.62143e-08 $l=1.4e-08 $layer=M1 $thickness=3.6e-08
+ $X=1.162 $Y=0.036 $X2=1.148 $Y2=0.036
r23 17 21 9.4274 $w=1.48568e-08 $l=4.75e-08 $layer=M1 $thickness=3.6e-08
+ $X=1.162 $Y=0.036 $X2=1.162 $Y2=0.0835
r24 28 29 3.26466 $w=1.3e-08 $l=1.4e-08 $layer=M1 $thickness=3.6e-08 $X=1.134
+ $Y=0.036 $X2=1.148 $Y2=0.036
r25 27 28 12.5922 $w=1.3e-08 $l=5.4e-08 $layer=M1 $thickness=3.6e-08 $X=1.08
+ $Y=0.036 $X2=1.134 $Y2=0.036
r26 26 27 12.5922 $w=1.3e-08 $l=5.4e-08 $layer=M1 $thickness=3.6e-08 $X=1.026
+ $Y=0.036 $X2=1.08 $Y2=0.036
r27 19 26 2.68168 $w=1.3e-08 $l=1.15e-08 $layer=M1 $thickness=3.6e-08 $X=1.0145
+ $Y=0.036 $X2=1.026 $Y2=0.036
r28 1 26 19.3796 $a=3.24e-16 $layer=V0LISD $X=1.026 $Y=0.0675 $X2=1.026
+ $Y2=0.036
r29 25 23 0.0308642 $w=8.1e-08 $l=2.5e-09 $layer=N_src_drn $thickness=1e-09
+ $X=1.0433 $Y=0.0675 $X2=1.0405 $Y2=0.0675
r30 1 23 0.179012 $w=8.1e-08 $l=1.45e-08 $layer=N_src_drn $thickness=1e-09
+ $X=1.026 $Y=0.0675 $X2=1.0405 $Y2=0.0675
r31 13 1 0.179012 $w=8.1e-08 $l=1.45e-08 $layer=N_src_drn $thickness=1e-09
+ $X=1.0115 $Y=0.0675 $X2=1.026 $Y2=0.0675
r32 24 13 0.0308642 $w=8.1e-08 $l=2.5e-09 $layer=N_src_drn $thickness=1e-09
+ $X=1.0086 $Y=0.0675 $X2=1.0115 $Y2=0.0675
.ends

.subckt PM_DFFHQNx3_ASAP7_75t_R%14 vss 7 12 4 1 5
c1 1 vss 0.00632197f $X=0.702 $Y=0.0405
c2 4 vss 0.00176145f $X=0.6875 $Y=0.0405
c3 5 vss 0.00217491f $X=0.758 $Y=0.0405
r1 12 11 0.0925926 $w=2.7e-08 $l=2.5e-09 $layer=N_src_drn $thickness=1e-09
+ $X=0.7733 $Y=0.0405 $X2=0.7705 $Y2=0.0405
r2 5 11 0.462963 $w=2.7e-08 $l=1.25e-08 $layer=N_src_drn $thickness=1e-09
+ $X=0.758 $Y=0.0405 $X2=0.7705 $Y2=0.0405
r3 9 5 8.23096 $w=2.32e-08 $l=1.75e-08 $layer=LISD $thickness=2.7e-08 $X=0.7385
+ $Y=0.0405 $X2=0.758 $Y2=0.0405
r4 8 9 7.05511 $w=2.32e-08 $l=1.5e-08 $layer=LISD $thickness=2.7e-08 $X=0.7235
+ $Y=0.0405 $X2=0.7385 $Y2=0.0405
r5 1 8 10.1123 $w=2.32e-08 $l=2.15e-08 $layer=LISD $thickness=2.7e-08 $X=0.702
+ $Y=0.0405 $X2=0.7235 $Y2=0.0405
r6 4 1 0.462963 $w=2.7e-08 $l=1.25e-08 $layer=N_src_drn $thickness=1e-09
+ $X=0.6875 $Y=0.0405 $X2=0.702 $Y2=0.0405
r7 7 4 0.0925926 $w=2.7e-08 $l=2.5e-09 $layer=N_src_drn $thickness=1e-09
+ $X=0.6846 $Y=0.0405 $X2=0.6875 $Y2=0.0405
.ends

.subckt PM_DFFHQNx3_ASAP7_75t_R%10 vss 33 39 80 81 84 88 91 94 98 102 106 107
+ 30 6 16 25 15 17 23 19 5 24 22 2 20 28 21 29 11 27 1 18 26 14 13 12
c1 1 vss 0.00174576f $X=0.837 $Y=0.135
c2 2 vss 0.0151848f $X=0.9895 $Y=0.136
c3 5 vss 0.00475466f $X=0.648 $Y=0.0405
c4 6 vss 0.00454691f $X=0.702 $Y=0.2295
c5 11 vss 0.0538317f $X=0.837 $Y=0.0245
c6 12 vss 0.088465f $X=0.999 $Y=0.136
c7 13 vss 0.080648f $X=1.053 $Y=0.136
c8 14 vss 0.0866742f $X=1.107 $Y=0.136
c9 15 vss 0.00444536f $X=0.6335 $Y=0.0405
c10 16 vss 0.0045487f $X=0.6875 $Y=0.2295
c11 17 vss 0.00619122f $X=0.729 $Y=0.233
c12 18 vss 0.00266746f $X=0.729 $Y=0.036
c13 19 vss 0.000178071f $X=0.729 $Y=0.16
c14 20 vss 0.000317315f $X=0.837 $Y=0.162
c15 21 vss 0.00132244f $X=0.891 $Y=0.1575
c16 22 vss 0.0084415f $X=0.704 $Y=0.036
c17 23 vss 0.00203689f $X=0.729 $Y=0.136
c18 24 vss 0.0017585f $X=0.729 $Y=0.1975
c19 25 vss 0.00274727f $X=0.81 $Y=0.162
c20 26 vss 0.000883293f $X=0.837 $Y=0.118
c21 27 vss 0.000783427f $X=0.848 $Y=0.162
c22 28 vss 0.00121704f $X=0.891 $Y=0.1305
c23 29 vss 0.00297942f $X=0.999 $Y=0.1245
c24 30 vss 0.0103164f $X=0.8795 $Y=0.153
r1 107 105 0.0925926 $w=2.7e-08 $l=2.5e-09 $layer=N_src_drn $thickness=1e-09
+ $X=0.6653 $Y=0.0405 $X2=0.6625 $Y2=0.0405
r2 5 105 0.537037 $w=2.7e-08 $l=1.45e-08 $layer=N_src_drn $thickness=1e-09
+ $X=0.648 $Y=0.0405 $X2=0.6625 $Y2=0.0405
r3 15 5 0.537037 $w=2.7e-08 $l=1.45e-08 $layer=N_src_drn $thickness=1e-09
+ $X=0.6335 $Y=0.0405 $X2=0.648 $Y2=0.0405
r4 106 15 0.0925926 $w=2.7e-08 $l=2.5e-09 $layer=N_src_drn $thickness=1e-09
+ $X=0.6306 $Y=0.0405 $X2=0.6335 $Y2=0.0405
r5 102 101 14.6259 $w=2.1e-08 $l=4.3e-08 $layer=Gate_1 $thickness=5.6e-08
+ $X=1.107 $Y=0.2025 $X2=1.107 $Y2=0.1595
r6 100 101 2.55104 $w=2.1e-08 $l=7.5e-09 $layer=Gate_1 $thickness=5.6e-08
+ $X=1.107 $Y=0.152 $X2=1.107 $Y2=0.1595
r7 98 99 14.6259 $w=2.1e-08 $l=4.3e-08 $layer=Gate_1 $thickness=5.6e-08
+ $X=1.107 $Y=0.0675 $X2=1.107 $Y2=0.1105
r8 96 99 2.89117 $w=2.1e-08 $l=8.5e-09 $layer=Gate_1 $thickness=5.6e-08
+ $X=1.107 $Y=0.119 $X2=1.107 $Y2=0.1105
r9 14 74 6.54019 $w=2.09524e-08 $layer=Gate_1 $thickness=5.21905e-08 $X=1.107
+ $Y=0.136 $X2=1.107 $Y2=0.136
r10 14 96 5.96942 $w=2.03529e-08 $l=1.7e-08 $layer=Gate_1 $thickness=5.6e-08
+ $X=1.107 $Y=0.136 $X2=1.107 $Y2=0.119
r11 14 100 5.62929 $w=2.03125e-08 $l=1.6e-08 $layer=Gate_1 $thickness=5.6e-08
+ $X=1.107 $Y=0.136 $X2=1.107 $Y2=0.152
r12 94 93 16.3266 $w=2.1e-08 $l=4.8e-08 $layer=Gate_1 $thickness=5.6e-08
+ $X=1.053 $Y=0.2025 $X2=1.053 $Y2=0.1545
r13 91 92 16.6668 $w=2.1e-08 $l=4.9e-08 $layer=Gate_1 $thickness=5.6e-08
+ $X=1.053 $Y=0.0675 $X2=1.053 $Y2=0.1165
r14 13 72 6.54019 $w=2.09524e-08 $layer=Gate_1 $thickness=5.21905e-08 $X=1.053
+ $Y=0.136 $X2=1.053 $Y2=0.136
r15 13 92 6.81977 $w=2.04359e-08 $l=1.95e-08 $layer=Gate_1 $thickness=5.6e-08
+ $X=1.053 $Y=0.136 $X2=1.053 $Y2=0.1165
r16 13 93 6.47963 $w=2.04054e-08 $l=1.85e-08 $layer=Gate_1 $thickness=5.6e-08
+ $X=1.053 $Y=0.136 $X2=1.053 $Y2=0.1545
r17 88 87 14.6259 $w=2.1e-08 $l=4.3e-08 $layer=Gate_1 $thickness=5.6e-08
+ $X=0.999 $Y=0.2025 $X2=0.999 $Y2=0.1595
r18 86 87 2.55104 $w=2.1e-08 $l=7.5e-09 $layer=Gate_1 $thickness=5.6e-08
+ $X=0.999 $Y=0.152 $X2=0.999 $Y2=0.1595
r19 84 85 14.6259 $w=2.1e-08 $l=4.3e-08 $layer=Gate_1 $thickness=5.6e-08
+ $X=0.999 $Y=0.0675 $X2=0.999 $Y2=0.1105
r20 82 85 2.89117 $w=2.1e-08 $l=8.5e-09 $layer=Gate_1 $thickness=5.6e-08
+ $X=0.999 $Y=0.119 $X2=0.999 $Y2=0.1105
r21 12 68 6.27904 $w=2.09e-08 $layer=Gate_1 $thickness=5.24e-08 $X=0.999
+ $Y=0.136 $X2=0.999 $Y2=0.136
r22 12 82 5.96942 $w=2.03529e-08 $l=1.7e-08 $layer=Gate_1 $thickness=5.6e-08
+ $X=0.999 $Y=0.136 $X2=0.999 $Y2=0.119
r23 12 86 5.62929 $w=2.03125e-08 $l=1.6e-08 $layer=Gate_1 $thickness=5.6e-08
+ $X=0.999 $Y=0.136 $X2=0.999 $Y2=0.152
r24 81 79 0.0925926 $w=2.7e-08 $l=2.5e-09 $layer=P_src_drn $thickness=1e-09
+ $X=0.7193 $Y=0.2295 $X2=0.7165 $Y2=0.2295
r25 6 79 0.537037 $w=2.7e-08 $l=1.45e-08 $layer=P_src_drn $thickness=1e-09
+ $X=0.702 $Y=0.2295 $X2=0.7165 $Y2=0.2295
r26 16 6 0.537037 $w=2.7e-08 $l=1.45e-08 $layer=P_src_drn $thickness=1e-09
+ $X=0.6875 $Y=0.2295 $X2=0.702 $Y2=0.2295
r27 80 16 0.0925926 $w=2.7e-08 $l=2.5e-09 $layer=P_src_drn $thickness=1e-09
+ $X=0.6846 $Y=0.2295 $X2=0.6875 $Y2=0.2295
r28 5 66 19.3796 $a=3.24e-16 $layer=V0LISD $X=0.648 $Y=0.0405 $X2=0.648
+ $Y2=0.036
r29 73 74 12.6539 $w=1.77815e-08 $l=2.7e-08 $layer=LIG $thickness=4.8e-08
+ $X=1.08 $Y=0.136 $X2=1.107 $Y2=0.136
r30 72 73 12.6539 $w=1.77815e-08 $l=2.7e-08 $layer=LIG $thickness=4.8e-08
+ $X=1.053 $Y=0.136 $X2=1.08 $Y2=0.136
r31 71 72 12.6539 $w=1.77815e-08 $l=2.7e-08 $layer=LIG $thickness=4.8e-08
+ $X=1.026 $Y=0.136 $X2=1.053 $Y2=0.136
r32 69 71 10.1729 $w=1.54914e-08 $l=1.75e-08 $layer=LIG $thickness=4.8e-08
+ $X=1.0085 $Y=0.136 $X2=1.026 $Y2=0.136
r33 68 69 2.48102 $w=2.2e-08 $l=9.5e-09 $layer=LIG $thickness=4.8e-08 $X=0.999
+ $Y=0.136 $X2=1.0085 $Y2=0.136
r34 2 68 2.48102 $w=2.2e-08 $l=9.5e-09 $layer=LIG $thickness=4.8e-08 $X=0.9895
+ $Y=0.136 $X2=0.999 $Y2=0.136
r35 6 59 19.3796 $a=3.24e-16 $layer=V0LISD $X=0.702 $Y=0.2295 $X2=0.702
+ $Y2=0.233
r36 66 67 3.14806 $w=1.3e-08 $l=1.35e-08 $layer=M1 $thickness=3.6e-08 $X=0.648
+ $Y=0.036 $X2=0.6615 $Y2=0.036
r37 64 67 3.14806 $w=1.3e-08 $l=1.35e-08 $layer=M1 $thickness=3.6e-08 $X=0.675
+ $Y=0.036 $X2=0.6615 $Y2=0.036
r38 63 64 2.56509 $w=1.3e-08 $l=1.1e-08 $layer=M1 $thickness=3.6e-08 $X=0.686
+ $Y=0.036 $X2=0.675 $Y2=0.036
r39 22 63 4.19742 $w=1.3e-08 $l=1.8e-08 $layer=M1 $thickness=3.6e-08 $X=0.704
+ $Y=0.036 $X2=0.686 $Y2=0.036
r40 61 68 19.3796 $a=3.24e-16 $layer=V0LIG $X=0.999 $Y=0.1445 $X2=0.999
+ $Y2=0.136
r41 29 61 4.6638 $w=1.3e-08 $l=2e-08 $layer=M1 $thickness=3.6e-08 $X=0.999
+ $Y=0.1245 $X2=0.999 $Y2=0.1445
r42 59 60 3.14806 $w=1.3e-08 $l=1.35e-08 $layer=M1 $thickness=3.6e-08 $X=0.702
+ $Y=0.233 $X2=0.7155 $Y2=0.233
r43 17 24 7.09793 $w=1.42676e-08 $l=3.55e-08 $layer=M1 $thickness=3.6e-08
+ $X=0.729 $Y=0.233 $X2=0.729 $Y2=0.1975
r44 17 60 1.96775 $w=1.63333e-08 $l=1.35e-08 $layer=M1 $thickness=3.6e-08
+ $X=0.729 $Y=0.233 $X2=0.7155 $Y2=0.233
r45 18 52 4.64701 $w=1.62667e-08 $l=2.7e-08 $layer=M1 $thickness=3.6e-08
+ $X=0.729 $Y=0.036 $X2=0.729 $Y2=0.063
r46 18 22 4.18063 $w=1.48e-08 $l=2.5e-08 $layer=M1 $thickness=3.6e-08 $X=0.729
+ $Y=0.036 $X2=0.704 $Y2=0.036
r47 56 61 19.5347 $a=3.24e-16 $layer=V1 $X=0.999 $Y=0.153 $X2=0.999 $Y2=0.1445
r48 55 56 12.5922 $w=1.3e-08 $l=5.4e-08 $layer=M2 $thickness=3.6e-08 $X=0.945
+ $Y=0.153 $X2=0.999 $Y2=0.153
r49 54 55 12.5922 $w=1.3e-08 $l=5.4e-08 $layer=M2 $thickness=3.6e-08 $X=0.891
+ $Y=0.153 $X2=0.945 $Y2=0.153
r50 30 54 2.68168 $w=1.3e-08 $l=1.15e-08 $layer=M2 $thickness=3.6e-08 $X=0.8795
+ $Y=0.153 $X2=0.891 $Y2=0.153
r51 53 54 39.0693 $a=1.62e-16 $layer=V1 $X=0.891 $Y=0.1485 $X2=0.891 $Y2=0.153
r52 28 53 4.19742 $w=1.3e-08 $l=1.8e-08 $layer=M1 $thickness=3.6e-08 $X=0.891
+ $Y=0.1305 $X2=0.891 $Y2=0.1485
r53 24 47 6.38362 $w=1.33509e-08 $l=2.85e-08 $layer=M1 $thickness=3.6e-08
+ $X=0.729 $Y=0.1975 $X2=0.729 $Y2=0.169
r54 51 52 6.29612 $w=1.3e-08 $l=2.7e-08 $layer=M1 $thickness=3.6e-08 $X=0.729
+ $Y=0.09 $X2=0.729 $Y2=0.063
r55 50 51 2.3319 $w=1.3e-08 $l=1e-08 $layer=M1 $thickness=3.6e-08 $X=0.729
+ $Y=0.1 $X2=0.729 $Y2=0.09
r56 49 50 2.3319 $w=1.3e-08 $l=1e-08 $layer=M1 $thickness=3.6e-08 $X=0.729
+ $Y=0.11 $X2=0.729 $Y2=0.1
r57 23 49 6.06293 $w=1.3e-08 $l=2.6e-08 $layer=M1 $thickness=3.6e-08 $X=0.729
+ $Y=0.136 $X2=0.729 $Y2=0.11
r58 21 48 0.9184 $w=1.8e-08 $l=9e-09 $layer=M1 $thickness=3.6e-08 $X=0.891
+ $Y=0.1575 $X2=0.891 $Y2=0.1665
r59 21 53 1.50855 $w=1.55e-08 $l=9e-09 $layer=M1 $thickness=3.6e-08 $X=0.891
+ $Y=0.1575 $X2=0.891 $Y2=0.1485
r60 21 54 39.0693 $a=1.62e-16 $layer=V1 $X=0.891 $Y=0.1575 $X2=0.891 $Y2=0.153
r61 19 47 0.9184 $w=1.8e-08 $l=9e-09 $layer=M1 $thickness=3.6e-08 $X=0.729
+ $Y=0.16 $X2=0.729 $Y2=0.169
r62 19 23 4.67854 $w=1.44583e-08 $l=2.4e-08 $layer=M1 $thickness=3.6e-08
+ $X=0.729 $Y=0.16 $X2=0.729 $Y2=0.136
r63 46 48 4.19024 $w=1.156e-08 $l=2.54018e-08 $layer=M1 $thickness=3.6e-08
+ $X=0.866 $Y=0.162 $X2=0.891 $Y2=0.1665
r64 27 46 4.19742 $w=1.3e-08 $l=1.8e-08 $layer=M1 $thickness=3.6e-08 $X=0.848
+ $Y=0.162 $X2=0.866 $Y2=0.162
r65 45 47 4.4015 $w=1.35e-08 $l=2.78927e-08 $layer=M1 $thickness=3.6e-08
+ $X=0.756 $Y=0.162 $X2=0.729 $Y2=0.169
r66 44 45 6.29612 $w=1.3e-08 $l=2.7e-08 $layer=M1 $thickness=3.6e-08 $X=0.783
+ $Y=0.162 $X2=0.756 $Y2=0.162
r67 25 44 6.29612 $w=1.3e-08 $l=2.7e-08 $layer=M1 $thickness=3.6e-08 $X=0.81
+ $Y=0.162 $X2=0.783 $Y2=0.162
r68 20 43 4.88263 $w=1.47308e-08 $l=2.6e-08 $layer=M1 $thickness=3.6e-08
+ $X=0.837 $Y=0.162 $X2=0.837 $Y2=0.136
r69 20 25 5.11582 $w=1.46667e-08 $l=2.7e-08 $layer=M1 $thickness=3.6e-08
+ $X=0.837 $Y=0.162 $X2=0.81 $Y2=0.162
r70 20 27 1.38478 $w=1.70909e-08 $l=1.1e-08 $layer=M1 $thickness=3.6e-08
+ $X=0.837 $Y=0.162 $X2=0.848 $Y2=0.162
r71 26 43 4.19742 $w=1.3e-08 $l=1.8e-08 $layer=M1 $thickness=3.6e-08 $X=0.837
+ $Y=0.118 $X2=0.837 $Y2=0.136
r72 1 36 6.54019 $w=2.09524e-08 $layer=Gate_1 $thickness=5.21905e-08 $X=0.837
+ $Y=0.135 $X2=0.837 $Y2=0.135
r73 1 43 19.3796 $a=3.24e-16 $layer=V0LIG $X=0.837 $Y=0.135 $X2=0.837 $Y2=0.136
r74 39 38 14.6259 $w=2.1e-08 $l=4.3e-08 $layer=Gate_1 $thickness=5.6e-08
+ $X=0.837 $Y=0.2295 $X2=0.837 $Y2=0.1865
r75 37 38 11.9048 $w=2.1e-08 $l=3.5e-08 $layer=Gate_1 $thickness=5.6e-08
+ $X=0.837 $Y=0.1515 $X2=0.837 $Y2=0.1865
r76 36 37 5.79936 $w=2.03333e-08 $l=1.65e-08 $layer=Gate_1 $thickness=5.6e-08
+ $X=0.837 $Y=0.135 $X2=0.837 $Y2=0.1515
r77 35 36 5.79936 $w=2.03333e-08 $l=1.65e-08 $layer=Gate_1 $thickness=5.6e-08
+ $X=0.837 $Y=0.1185 $X2=0.837 $Y2=0.135
r78 34 35 11.9048 $w=2.1e-08 $l=3.5e-08 $layer=Gate_1 $thickness=5.6e-08
+ $X=0.837 $Y=0.0835 $X2=0.837 $Y2=0.1185
r79 33 34 14.6259 $w=2.1e-08 $l=4.3e-08 $layer=Gate_1 $thickness=5.6e-08
+ $X=0.837 $Y=0.0405 $X2=0.837 $Y2=0.0835
r80 33 11 5.44221 $w=2.1e-08 $l=1.6e-08 $layer=Gate_1 $thickness=5.6e-08
+ $X=0.837 $Y=0.0405 $X2=0.837 $Y2=0.0245
.ends

.subckt PM_DFFHQNx3_ASAP7_75t_R%CLK vss 17 9 15 3 1 7 8 4 5 6
c1 1 vss 0.00415485f $X=0.081 $Y=0.135
c2 3 vss 0.0689347f $X=0.081 $Y=0.0245
c3 4 vss 0.00264112f $X=0.081 $Y=0.088
c4 5 vss 0.00254599f $X=0.081 $Y=0.182
c5 6 vss 0.00128581f $X=0.081 $Y=0.1122
c6 7 vss 0.00421217f $X=0.108 $Y=0.0575
c7 8 vss 0.00407481f $X=0.108 $Y=0.2125
r1 8 25 3.22357 $w=2.26279e-08 $l=3.05e-08 $layer=M1 $thickness=3.6e-08
+ $X=0.108 $Y=0.2125 $X2=0.108 $Y2=0.182
r2 7 23 3.22357 $w=2.26279e-08 $l=3.05e-08 $layer=M1 $thickness=3.6e-08
+ $X=0.108 $Y=0.0575 $X2=0.108 $Y2=0.088
r3 24 25 0.502848 $w=3.43333e-08 $l=1.35e-08 $layer=M1 $thickness=3.6e-08
+ $X=0.0945 $Y=0.182 $X2=0.108 $Y2=0.182
r4 5 21 0.54189 $w=3.37e-08 $l=1.9e-08 $layer=M1 $thickness=3.6e-08 $X=0.081
+ $Y=0.182 $X2=0.081 $Y2=0.163
r5 5 24 0.502848 $w=3.43333e-08 $l=1.35e-08 $layer=M1 $thickness=3.6e-08
+ $X=0.081 $Y=0.182 $X2=0.0945 $Y2=0.182
r6 22 23 0.502848 $w=3.43333e-08 $l=1.35e-08 $layer=M1 $thickness=3.6e-08
+ $X=0.0945 $Y=0.088 $X2=0.108 $Y2=0.088
r7 4 6 1.76614 $w=2.65738e-08 $l=2.42e-08 $layer=M1 $thickness=3.6e-08 $X=0.081
+ $Y=0.088 $X2=0.081 $Y2=0.1122
r8 4 22 0.502848 $w=3.43333e-08 $l=1.35e-08 $layer=M1 $thickness=3.6e-08
+ $X=0.081 $Y=0.088 $X2=0.0945 $Y2=0.088
r9 20 21 2.3319 $w=1.3e-08 $l=1e-08 $layer=M1 $thickness=3.6e-08 $X=0.081
+ $Y=0.153 $X2=0.081 $Y2=0.163
r10 19 20 4.19742 $w=1.3e-08 $l=1.8e-08 $layer=M1 $thickness=3.6e-08 $X=0.081
+ $Y=0.135 $X2=0.081 $Y2=0.153
r11 18 19 2.85657 $w=1.3e-08 $l=1.23e-08 $layer=M1 $thickness=3.6e-08 $X=0.081
+ $Y=0.1227 $X2=0.081 $Y2=0.135
r12 17 18 0.874462 $w=1.3e-08 $l=3.7e-09 $layer=M1 $thickness=3.6e-08 $X=0.082
+ $Y=0.119 $X2=0.081 $Y2=0.1227
r13 17 6 1.57403 $w=1.3e-08 $l=6.8e-09 $layer=M1 $thickness=3.6e-08 $X=0.082
+ $Y=0.119 $X2=0.081 $Y2=0.1122
r14 1 12 10.4265 $w=1.765e-08 $layer=LIG $thickness=5.2e-08 $X=0.081 $Y=0.135
+ $X2=0.081 $Y2=0.135
r15 1 19 19.3796 $a=3.24e-16 $layer=V0LIG $X=0.081 $Y=0.135 $X2=0.081 $Y2=0.135
r16 15 14 14.6259 $w=2.1e-08 $l=4.3e-08 $layer=Gate_1 $thickness=5.6e-08
+ $X=0.081 $Y=0.216 $X2=0.081 $Y2=0.173
r17 13 14 7.31297 $w=2.1e-08 $l=2.15e-08 $layer=Gate_1 $thickness=5.6e-08
+ $X=0.081 $Y=0.1515 $X2=0.081 $Y2=0.173
r18 12 13 5.79936 $w=2.03333e-08 $l=1.65e-08 $layer=Gate_1 $thickness=5.6e-08
+ $X=0.081 $Y=0.135 $X2=0.081 $Y2=0.1515
r19 11 12 5.79936 $w=2.03333e-08 $l=1.65e-08 $layer=Gate_1 $thickness=5.6e-08
+ $X=0.081 $Y=0.1185 $X2=0.081 $Y2=0.135
r20 10 11 7.31297 $w=2.1e-08 $l=2.15e-08 $layer=Gate_1 $thickness=5.6e-08
+ $X=0.081 $Y=0.097 $X2=0.081 $Y2=0.1185
r21 9 10 14.6259 $w=2.1e-08 $l=4.3e-08 $layer=Gate_1 $thickness=5.6e-08
+ $X=0.081 $Y=0.054 $X2=0.081 $Y2=0.097
r22 9 3 10.0341 $w=2.1e-08 $l=2.95e-08 $layer=Gate_1 $thickness=5.6e-08
+ $X=0.081 $Y=0.054 $X2=0.081 $Y2=0.0245
.ends

.subckt PM_DFFHQNx3_ASAP7_75t_R%13 vss 7 12 4 1 5
c1 1 vss 0.0058219f $X=0.432 $Y=0.2295
c2 4 vss 0.00164742f $X=0.4175 $Y=0.2295
c3 5 vss 0.00203674f $X=0.488 $Y=0.2295
r1 12 11 0.0925926 $w=2.7e-08 $l=2.5e-09 $layer=P_src_drn $thickness=1e-09
+ $X=0.5033 $Y=0.2295 $X2=0.5005 $Y2=0.2295
r2 5 11 0.462963 $w=2.7e-08 $l=1.25e-08 $layer=P_src_drn $thickness=1e-09
+ $X=0.488 $Y=0.2295 $X2=0.5005 $Y2=0.2295
r3 9 5 9.64198 $w=2.32e-08 $l=2.05e-08 $layer=LISD $thickness=2.7e-08 $X=0.4655
+ $Y=0.2295 $X2=0.488 $Y2=0.2295
r4 8 9 7.05511 $w=2.32e-08 $l=1.5e-08 $layer=LISD $thickness=2.7e-08 $X=0.4505
+ $Y=0.2295 $X2=0.4655 $Y2=0.2295
r5 1 8 8.7013 $w=2.32e-08 $l=1.85e-08 $layer=LISD $thickness=2.7e-08 $X=0.432
+ $Y=0.2295 $X2=0.4505 $Y2=0.2295
r6 4 1 0.462963 $w=2.7e-08 $l=1.25e-08 $layer=P_src_drn $thickness=1e-09
+ $X=0.4175 $Y=0.2295 $X2=0.432 $Y2=0.2295
r7 7 4 0.0925926 $w=2.7e-08 $l=2.5e-09 $layer=P_src_drn $thickness=1e-09
+ $X=0.4146 $Y=0.2295 $X2=0.4175 $Y2=0.2295
.ends

* End of included file DFFHQNx3_ASAP7_75t_R.pex.sp.pex

*
.subckt DFFHQNx3_ASAP7_75t_CUSTOM_4_25_0_7 VSS VDD CLK D QN
*
* VSS VSS
* VDD VDD
* CLK CLK
* D D
* QN QN
*
*

M0 VSS N_M0_g N_M0_s VSS nmos_rvt L=2e-08 W=5.4e-08 nfin=2 $X=0.071 $Y=0.027
M1 N_M1_d N_M1_g VSS VSS nmos_rvt L=2e-08 W=5.4e-08 nfin=2 $X=0.125 $Y=0.027
M2 N_M2_d N_M2_g VSS VSS nmos_rvt L=2e-08 W=8.1e-08 nfin=3 $X=0.287 $Y=0.027
M3 N_M3_d N_M3_g N_M3_s VSS nmos_rvt L=2e-08 W=8.1e-08 nfin=3 $X=0.395 $Y=0.027
M4 N_M4_d N_M4_g N_M4_s VSS nmos_rvt L=2e-08 W=2.7e-08 nfin=1 $X=0.449 $Y=0.027
M5 VSS N_M5_g N_M5_s VSS nmos_rvt L=2e-08 W=2.7e-08 nfin=1 $X=0.503 $Y=0.027
M6 N_M6_d N_M6_g VSS VSS nmos_rvt L=2e-08 W=2.7e-08 nfin=1 $X=0.557 $Y=0.027
M7 N_M7_d N_M7_g N_M7_s VSS nmos_rvt L=2e-08 W=2.7e-08 nfin=1 $X=0.611 $Y=0.027
M8 N_M8_d N_M8_g N_M8_s VSS nmos_rvt L=2e-08 W=2.7e-08 nfin=1 $X=0.665 $Y=0.027
M9 VSS N_M9_g N_M9_s VSS nmos_rvt L=2e-08 W=2.7e-08 nfin=1 $X=0.773 $Y=0.027
M10 N_M10_d N_M10_g VSS VSS nmos_rvt L=2e-08 W=2.7e-08 nfin=1 $X=0.827 $Y=0.027
M11 N_M11_d N_M11_g VSS VSS nmos_rvt L=2e-08 W=8.1e-08 nfin=3 $X=0.989 $Y=0.027
M12 N_M12_d N_M12_g VSS VSS nmos_rvt L=2e-08 W=8.1e-08 nfin=3 $X=1.043 $Y=0.027
M13 N_M13_d N_M13_g VSS VSS nmos_rvt L=2e-08 W=8.1e-08 nfin=3 $X=1.097 $Y=0.027
M14 VDD N_M14_g N_M14_s VDD pmos_rvt L=2e-08 W=5.4e-08 nfin=2 $X=0.071 $Y=0.189
M15 N_M15_d N_M15_g VDD VDD pmos_rvt L=2e-08 W=5.4e-08 nfin=2 $X=0.125 $Y=0.189
M16 N_M16_d N_M16_g VDD VDD pmos_rvt L=2e-08 W=8.1e-08 nfin=3 $X=0.287 $Y=0.162
M17 N_M17_d N_M17_g N_M17_s VDD pmos_rvt L=2e-08 W=8.1e-08 nfin=3 $X=0.341
+ $Y=0.162
M18 N_M18_d N_M18_g N_M18_s VDD pmos_rvt L=2e-08 W=2.7e-08 nfin=1 $X=0.395
+ $Y=0.216
M19 VDD N_M19_g N_M19_s VDD pmos_rvt L=2e-08 W=2.7e-08 nfin=1 $X=0.503 $Y=0.216
M20 N_M20_d N_M20_g VDD VDD pmos_rvt L=2e-08 W=2.7e-08 nfin=1 $X=0.557 $Y=0.216
M21 N_M21_d N_M21_g N_M21_s VDD pmos_rvt L=2e-08 W=2.7e-08 nfin=1 $X=0.665
+ $Y=0.216
M22 N_M22_d N_M22_g N_M22_s VDD pmos_rvt L=2e-08 W=2.7e-08 nfin=1 $X=0.719
+ $Y=0.216
M23 VDD N_M23_g N_M23_s VDD pmos_rvt L=2e-08 W=2.7e-08 nfin=1 $X=0.773 $Y=0.216
M24 N_M24_d N_M24_g VDD VDD pmos_rvt L=2e-08 W=2.7e-08 nfin=1 $X=0.827 $Y=0.216
M25 N_M25_d N_M25_g VDD VDD pmos_rvt L=2e-08 W=8.1e-08 nfin=3 $X=0.989 $Y=0.162
M26 N_M26_d N_M26_g VDD VDD pmos_rvt L=2e-08 W=8.1e-08 nfin=3 $X=1.043 $Y=0.162
M27 N_M27_d N_M27_g VDD VDD pmos_rvt L=2e-08 W=8.1e-08 nfin=3 $X=1.097 $Y=0.162

* .include "DFFHQNx3_ASAP7_75t_R.pex.sp.pxi"

* Start of included file DFFHQNx3_ASAP7_75t_R.pex.sp.pxi
x_PM_DFFHQNx3_ASAP7_75t_R%12 vss N_M2_d N_M3_s N_12_5 N_12_4 N_12_1
+ PM_DFFHQNx3_ASAP7_75t_R%12
cc_1 N_12_5 N_4_26 0.000269961f $X=0.38 $Y=0.0675
cc_2 N_12_5 N_4_2 0.000664819f $X=0.38 $Y=0.0675
cc_3 N_12_5 N_4_14 0.0344827f $X=0.38 $Y=0.0675
cc_4 N_12_4 N_D_3 0.0347218f $X=0.3095 $Y=0.0675
cc_5 N_12_5 N_6_22 0.000356217f $X=0.38 $Y=0.0675
cc_6 N_12_5 N_6_1 0.00191927f $X=0.38 $Y=0.0675
cc_7 N_12_5 N_6_14 0.0728827f $X=0.38 $Y=0.0675
cc_8 N_12_1 N_8_11 0.000582619f $X=0.351 $Y=0.0675
cc_9 N_12_1 N_8_4 0.00107016f $X=0.351 $Y=0.0675
cc_10 N_12_1 N_8_10 0.002684f $X=0.351 $Y=0.0675
x_PM_DFFHQNx3_ASAP7_75t_R%15 vss N_M4_d N_M5_s N_15_1 PM_DFFHQNx3_ASAP7_75t_R%15
cc_11 N_15_1 N_6_15 0.00756207f $X=0.486 $Y=0.0405
cc_12 N_15_1 N_7_10 0.00766117f $X=0.486 $Y=0.0405
x_PM_DFFHQNx3_ASAP7_75t_R%17 vss N_M22_d N_M23_s N_17_1
+ PM_DFFHQNx3_ASAP7_75t_R%17
cc_13 N_17_1 N_6_17 0.00757774f $X=0.756 $Y=0.2295
cc_14 N_17_1 N_9_9 0.00762852f $X=0.756 $Y=0.2295
x_PM_DFFHQNx3_ASAP7_75t_R%8 vss N_M6_g N_M20_g N_M3_d N_M4_s N_M17_d N_M18_s
+ N_8_11 N_8_19 N_8_13 N_8_14 N_8_4 N_8_18 N_8_3 N_8_10 N_8_15 N_8_20 N_8_12
+ N_8_16 N_8_1 N_8_17 N_8_9 PM_DFFHQNx3_ASAP7_75t_R%8
cc_15 N_8_11 N_4_3 0.000149859f $X=0.4175 $Y=0.081
cc_16 N_8_11 N_4_26 0.000266063f $X=0.4175 $Y=0.081
cc_17 N_8_19 N_4_26 0.00160174f $X=0.459 $Y=0.1525
cc_18 N_8_13 N_4_14 0.00541335f $X=0.3635 $Y=0.189
cc_19 N_8_14 N_4_26 0.000466321f $X=0.459 $Y=0.036
cc_20 N_8_4 N_4_2 0.00081817f $X=0.432 $Y=0.0405
cc_21 N_8_4 N_4_14 0.00104485f $X=0.432 $Y=0.0405
cc_22 N_8_18 N_4_26 0.00105762f $X=0.459 $Y=0.114
cc_23 N_8_3 N_4_14 0.00106086f $X=0.378 $Y=0.2295
cc_24 N_8_10 N_4_2 0.00169637f $X=0.4175 $Y=0.0405
cc_25 N_8_15 N_4_26 0.0026751f $X=0.459 $Y=0.131
cc_26 N_8_20 N_4_28 0.00338996f $X=0.54 $Y=0.131
cc_27 N_8_10 N_4_14 0.0093572f $X=0.4175 $Y=0.0405
cc_28 N_8_12 N_4_14 0.0105147f $X=0.3635 $Y=0.2295
cc_29 N_8_11 N_4_14 0.044402f $X=0.4175 $Y=0.081
cc_30 N_8_10 N_6_24 9.89829e-20 $X=0.4175 $Y=0.0405
cc_31 N_8_10 N_6_25 0.000359118f $X=0.4175 $Y=0.0405
cc_32 N_8_10 N_6_14 0.000138053f $X=0.4175 $Y=0.0405
cc_33 N_8_10 N_6_3 0.000168833f $X=0.4175 $Y=0.0405
cc_34 N_8_13 N_6_14 0.0237788f $X=0.3635 $Y=0.189
cc_35 N_8_3 N_6_24 0.000955669f $X=0.378 $Y=0.2295
cc_36 N_8_3 N_6_1 0.00032666f $X=0.378 $Y=0.2295
cc_37 N_8_3 N_6_22 0.000347111f $X=0.378 $Y=0.2295
cc_38 N_8_19 N_6_25 0.00273597f $X=0.459 $Y=0.1525
cc_39 N_8_16 N_6_25 0.000388239f $X=0.459 $Y=0.234
cc_40 N_8_11 N_6_15 0.00545534f $X=0.4175 $Y=0.081
cc_41 N_8_1 N_6_8 0.00208793f $X=0.567 $Y=0.1305
cc_42 N_8_20 N_6_8 0.000590434f $X=0.54 $Y=0.131
cc_43 N_8_4 N_6_15 0.000620417f $X=0.432 $Y=0.0405
cc_44 N_8_12 N_6_1 0.000766671f $X=0.3635 $Y=0.2295
cc_45 N_8_19 N_6_2 0.0010073f $X=0.459 $Y=0.1525
cc_46 N_8_3 N_6_14 0.00160816f $X=0.378 $Y=0.2295
cc_47 N_8_17 N_6_26 0.00289654f $X=0.434 $Y=0.234
cc_48 N_8_20 N_6_25 0.00316497f $X=0.54 $Y=0.131
cc_49 N_8_9 N_6_8 0.00421858f $X=0.567 $Y=0.0245
cc_50 N_8_12 N_6_14 0.00964777f $X=0.3635 $Y=0.2295
cc_51 N_8_9 N_6_16 0.0117192f $X=0.567 $Y=0.0245
cc_52 N_8_10 N_6_15 0.0309512f $X=0.4175 $Y=0.0405
cc_53 N_8_9 N_7_11 0.00635645f $X=0.567 $Y=0.0245
cc_54 N_8_4 N_7_1 0.000329361f $X=0.432 $Y=0.0405
cc_55 N_8_20 N_7_14 0.000423061f $X=0.54 $Y=0.131
cc_56 N_8_20 N_7_1 0.000848549f $X=0.54 $Y=0.131
cc_57 N_8_20 N_7_19 0.00088362f $X=0.54 $Y=0.131
cc_58 N_8_9 N_7_3 0.00103605f $X=0.567 $Y=0.0245
cc_59 N_8_1 N_7_10 0.00109092f $X=0.567 $Y=0.1305
cc_60 N_8_1 N_7_16 0.0010915f $X=0.567 $Y=0.1305
cc_61 N_8_18 N_7_16 0.00111078f $X=0.459 $Y=0.114
cc_62 N_8_9 N_7_1 0.00116127f $X=0.567 $Y=0.0245
cc_63 N_8_9 N_7_12 0.00626722f $X=0.567 $Y=0.0245
cc_64 N_8_20 N_7_16 0.0065981f $X=0.54 $Y=0.131
cc_65 N_8_9 N_7_10 0.0290895f $X=0.567 $Y=0.0245
x_PM_DFFHQNx3_ASAP7_75t_R%D vss D N_M2_g N_M16_g N_D_8 N_D_3 N_D_9 N_D_6 N_D_1
+ N_D_7 N_D_5 PM_DFFHQNx3_ASAP7_75t_R%D
cc_66 N_D_8 N_4_14 0.000100137f $X=0.243 $Y=0.1735
cc_67 N_D_8 N_4_1 0.000355171f $X=0.243 $Y=0.1735
cc_68 N_D_8 N_4_26 0.000158441f $X=0.243 $Y=0.1735
cc_69 N_D_8 N_4_28 0.00383983f $X=0.243 $Y=0.1735
x_PM_DFFHQNx3_ASAP7_75t_R%16 vss N_M16_d N_M17_s N_16_1
+ PM_DFFHQNx3_ASAP7_75t_R%16
cc_70 N_16_1 N_D_3 0.0167482f $X=0.324 $Y=0.2025
cc_71 N_16_1 N_6_14 0.016859f $X=0.324 $Y=0.2025
x_PM_DFFHQNx3_ASAP7_75t_R%4 vss N_M1_g N_M15_g N_M3_g N_M18_g N_M8_g N_M21_g
+ N_M0_s N_M14_s N_4_8 N_4_7 N_4_25 N_4_19 N_4_17 N_4_16 N_4_1 N_4_22 N_4_24
+ N_4_23 N_4_21 N_4_28 N_4_13 N_4_14 N_4_26 N_4_15 N_4_2 N_4_3 N_4_27
+ PM_DFFHQNx3_ASAP7_75t_R%4
cc_72 N_4_8 N_CLK_3 0.00109281f $X=0.054 $Y=0.216
cc_73 N_4_7 N_CLK_3 0.00111041f $X=0.054 $Y=0.054
cc_74 N_4_25 N_CLK_3 0.000287433f $X=0.151 $Y=0.116
cc_75 N_4_19 N_CLK_3 0.000289948f $X=0.0165 $Y=0.153
cc_76 N_4_17 N_CLK_3 0.0110304f $X=0.056 $Y=0.216
cc_77 N_4_16 N_CLK_3 0.0110406f $X=0.056 $Y=0.054
cc_78 N_4_1 N_CLK_3 0.000379929f $X=0.1335 $Y=0.135
cc_79 N_4_22 N_CLK_3 0.000490851f $X=0.018 $Y=0.163
cc_80 N_4_24 N_CLK_3 0.000661339f $X=0.036 $Y=0.234
cc_81 N_4_19 N_CLK_1 0.000964211f $X=0.0165 $Y=0.153
cc_82 N_4_23 N_CLK_7 0.000981669f $X=0.036 $Y=0.036
cc_83 N_4_24 N_CLK_8 0.0010457f $X=0.036 $Y=0.234
cc_84 N_4_25 N_CLK_4 0.00107739f $X=0.151 $Y=0.116
cc_85 N_4_21 N_CLK_4 0.00111615f $X=0.018 $Y=0.125
cc_86 N_4_19 N_CLK_5 0.00162596f $X=0.0165 $Y=0.153
cc_87 N_4_28 N_CLK_5 0.00169829f $X=0.0215 $Y=0.153
cc_88 N_4_23 N_CLK_4 0.00269035f $X=0.036 $Y=0.036
cc_89 N_4_1 N_CLK_1 0.00275674f $X=0.1335 $Y=0.135
cc_90 N_4_19 N_CLK_6 0.00319132f $X=0.0165 $Y=0.153
cc_91 N_4_25 N_CLK_5 0.00325707f $X=0.151 $Y=0.116
cc_92 N_4_13 N_CLK_3 0.0355594f $X=0.135 $Y=0.0245
x_PM_DFFHQNx3_ASAP7_75t_R%6 vss N_M17_g N_M1_d N_M15_d N_M4_g N_M7_g N_M22_g
+ N_6_7 N_6_6 N_6_23 N_6_21 N_6_20 N_6_18 N_6_19 N_6_3 N_6_4 N_6_22 N_6_25
+ N_6_1 N_6_8 N_6_2 N_6_24 N_6_26 N_6_15 N_6_17 N_6_14 N_6_16
+ PM_DFFHQNx3_ASAP7_75t_R%6
cc_93 N_6_7 N_CLK_7 0.000349039f $X=0.162 $Y=0.216
cc_94 N_6_6 N_CLK_7 0.000349152f $X=0.162 $Y=0.054
cc_95 N_6_23 N_CLK_7 0.000663087f $X=0.189 $Y=0.1735
cc_96 N_6_21 N_CLK_7 0.00181431f $X=0.189 $Y=0.234
cc_97 N_6_20 N_CLK_7 0.00195343f $X=0.189 $Y=0.036
cc_98 N_6_20 N_4_13 5.47525e-20 $X=0.189 $Y=0.036
cc_99 N_6_18 N_4_13 0.0111085f $X=0.1475 $Y=0.054
cc_100 N_6_19 N_4_8 5.53013e-20 $X=0.1475 $Y=0.216
cc_101 N_6_21 N_4_24 0.000123689f $X=0.189 $Y=0.234
cc_102 N_6_20 N_4_21 0.000124325f $X=0.189 $Y=0.036
cc_103 N_6_3 N_4_15 0.000190373f $X=0.621 $Y=0.178
cc_104 N_6_6 N_4_13 0.000945008f $X=0.162 $Y=0.054
cc_105 N_6_7 N_4_13 0.000945519f $X=0.162 $Y=0.216
cc_106 N_6_4 N_4_15 0.000244847f $X=0.729 $Y=0.178
cc_107 N_6_21 N_4_25 0.000318618f $X=0.189 $Y=0.234
cc_108 N_6_22 N_4_28 0.000327986f $X=0.3375 $Y=0.135
cc_109 N_6_25 N_4_28 0.000897778f $X=0.513 $Y=0.168
cc_110 N_6_1 N_4_2 0.00192117f $X=0.351 $Y=0.135
cc_111 N_6_20 N_4_25 0.000414282f $X=0.189 $Y=0.036
cc_112 N_6_22 N_4_2 0.000440665f $X=0.3375 $Y=0.135
cc_113 N_6_8 N_4_3 0.0024285f $X=0.501 $Y=0.178
cc_114 N_6_2 N_4_14 0.000469482f $X=0.459 $Y=0.178
cc_115 N_6_24 N_4_28 0.00114908f $X=0.324 $Y=0.1555
cc_116 N_6_8 N_4_27 0.000537611f $X=0.501 $Y=0.178
cc_117 N_6_23 N_4_25 0.00726499f $X=0.189 $Y=0.1735
cc_118 N_6_23 N_4_28 0.000580985f $X=0.189 $Y=0.1735
cc_119 N_6_26 N_4_26 0.000645288f $X=0.1775 $Y=0.189
cc_120 N_6_23 N_4_1 0.000678953f $X=0.189 $Y=0.1735
cc_121 N_6_19 N_4_1 0.000955819f $X=0.1475 $Y=0.216
cc_122 N_6_22 N_4_26 0.00258487f $X=0.3375 $Y=0.135
cc_123 N_6_15 N_4_14 0.00330863f $X=0.459 $Y=0.178
cc_124 N_6_8 N_4_15 0.00374533f $X=0.501 $Y=0.178
cc_125 N_6_17 N_4_15 0.00553244f $X=0.729 $Y=0.178
cc_126 N_6_14 N_4_14 0.00677851f $X=0.351 $Y=0.073
cc_127 N_6_16 N_4_15 0.0171879f $X=0.621 $Y=0.178
cc_128 N_6_26 N_4_28 0.0287051f $X=0.1775 $Y=0.189
cc_129 N_6_19 N_4_13 0.0387447f $X=0.1475 $Y=0.216
cc_130 N_6_7 N_D_3 0.000120711f $X=0.162 $Y=0.216
cc_131 N_6_24 N_D_3 0.00015154f $X=0.324 $Y=0.1555
cc_132 N_6_23 N_D_3 0.000178992f $X=0.189 $Y=0.1735
cc_133 N_6_1 N_D_3 0.000348418f $X=0.351 $Y=0.135
cc_134 N_6_22 N_D_3 0.000633271f $X=0.3375 $Y=0.135
cc_135 N_6_20 N_D_3 0.000864734f $X=0.189 $Y=0.036
cc_136 N_6_24 N_D_9 0.000997692f $X=0.324 $Y=0.1555
cc_137 N_6_26 N_D_9 0.00108387f $X=0.1775 $Y=0.189
cc_138 N_6_21 N_D_6 0.00133071f $X=0.189 $Y=0.234
cc_139 N_6_1 N_D_1 0.00166989f $X=0.351 $Y=0.135
cc_140 N_6_23 N_D_7 0.00178458f $X=0.189 $Y=0.1735
cc_141 N_6_22 N_D_9 0.00189954f $X=0.3375 $Y=0.135
cc_142 N_6_23 N_D_8 0.00260289f $X=0.189 $Y=0.1735
cc_143 N_6_23 N_D_5 0.00369036f $X=0.189 $Y=0.1735
cc_144 N_6_14 N_D_3 0.00501281f $X=0.351 $Y=0.073
x_PM_DFFHQNx3_ASAP7_75t_R%7 vss N_M5_g N_M19_g N_M6_d N_M7_s N_M20_d N_M21_s
+ N_7_13 N_7_17 N_7_19 N_7_14 N_7_16 N_7_3 N_7_4 N_7_1 N_7_12 N_7_11 N_7_10
+ N_7_18 PM_DFFHQNx3_ASAP7_75t_R%7
cc_145 N_7_13 N_4_26 7.14962e-20 $X=0.65 $Y=0.2295
cc_146 N_7_13 N_4_14 0.000114926f $X=0.65 $Y=0.2295
cc_147 N_7_13 N_4_27 0.000367668f $X=0.65 $Y=0.2295
cc_148 N_7_13 N_4_3 0.000222687f $X=0.65 $Y=0.2295
cc_149 N_7_17 N_4_28 0.000237652f $X=0.594 $Y=0.234
cc_150 N_7_19 N_4_27 0.00449397f $X=0.621 $Y=0.1
cc_151 N_7_19 N_4_3 0.000355934f $X=0.621 $Y=0.1
cc_152 N_7_14 N_4_27 0.000760578f $X=0.594 $Y=0.09
cc_153 N_7_16 N_4_28 0.00269358f $X=0.5 $Y=0.09
cc_154 N_7_13 N_4_15 0.0155286f $X=0.65 $Y=0.2295
cc_155 N_7_3 N_6_25 0.000203454f $X=0.594 $Y=0.0405
cc_156 N_7_3 N_6_2 0.00010497f $X=0.594 $Y=0.0405
cc_157 N_7_3 N_6_8 0.000355643f $X=0.594 $Y=0.0405
cc_158 N_7_3 N_6_26 0.000212546f $X=0.594 $Y=0.0405
cc_159 N_7_4 N_6_8 0.00650714f $X=0.594 $Y=0.2295
cc_160 N_7_1 N_6_15 0.000731365f $X=0.513 $Y=0.09
cc_161 N_7_12 N_6_16 0.00762796f $X=0.5795 $Y=0.2295
cc_162 N_7_13 N_6_16 0.00767505f $X=0.65 $Y=0.2295
cc_163 N_7_17 N_6_25 0.000372747f $X=0.594 $Y=0.234
cc_164 N_7_17 N_6_8 0.000376396f $X=0.594 $Y=0.234
cc_165 N_7_4 N_6_3 0.000871281f $X=0.594 $Y=0.2295
cc_166 N_7_19 N_6_8 0.00154874f $X=0.621 $Y=0.1
cc_167 N_7_4 N_6_16 0.00228899f $X=0.594 $Y=0.2295
cc_168 N_7_11 N_6_16 0.00629941f $X=0.5795 $Y=0.0405
cc_169 N_7_10 N_6_15 0.013685f $X=0.513 $Y=0.0245
cc_170 N_7_3 N_6_16 0.0290702f $X=0.594 $Y=0.0405
x_PM_DFFHQNx3_ASAP7_75t_R%9 vss N_M9_g N_M23_g N_M10_d N_M24_d N_9_9 N_9_14
+ N_9_18 N_9_3 N_9_4 N_9_1 N_9_17 N_9_12 N_9_15 N_9_16 N_9_10 N_9_11
+ PM_DFFHQNx3_ASAP7_75t_R%9
cc_171 N_9_9 N_6_8 0.000207124f $X=0.783 $Y=0.0245
cc_172 N_9_9 N_6_4 0.000410434f $X=0.783 $Y=0.0245
cc_173 N_9_9 N_6_17 0.0128576f $X=0.783 $Y=0.0245
x_PM_DFFHQNx3_ASAP7_75t_R%QN vss QN N_M11_d N_M12_d N_M13_d N_M25_d N_M26_d
+ N_M27_d N_QN_15 N_QN_1 N_QN_2 N_QN_14 N_QN_16 N_QN_13
+ PM_DFFHQNx3_ASAP7_75t_R%QN
cc_174 N_QN_15 N_10_29 0.00123593f $X=1.0115 $Y=0.2025
cc_175 N_QN_15 N_10_14 0.00390482f $X=1.0115 $Y=0.2025
cc_176 N_QN_15 N_10_2 0.00822682f $X=1.0115 $Y=0.2025
cc_177 N_QN_15 N_10_30 0.000663856f $X=1.0115 $Y=0.2025
cc_178 N_QN_15 N_10_13 0.0574177f $X=1.0115 $Y=0.2025
cc_179 N_QN_1 N_10_12 0.00177598f $X=1.026 $Y=0.0675
cc_180 N_QN_2 N_10_13 0.00192265f $X=1.026 $Y=0.2025
cc_181 N_QN_14 N_10_14 0.0145573f $X=1.1195 $Y=0.0675
cc_182 N_QN_16 N_10_14 0.0521122f $X=1.1195 $Y=0.2025
cc_183 N_QN_13 N_10_13 0.0103931f $X=1.0115 $Y=0.0675
cc_184 N_QN_13 N_10_12 0.018482f $X=1.0115 $Y=0.0675
cc_185 N_QN_15 N_10_12 0.0478245f $X=1.0115 $Y=0.2025
x_PM_DFFHQNx3_ASAP7_75t_R%14 vss N_M8_d N_M9_s N_14_4 N_14_1 N_14_5
+ PM_DFFHQNx3_ASAP7_75t_R%14
cc_186 N_14_4 N_4_15 0.0147807f $X=0.6875 $Y=0.0405
cc_187 N_14_1 N_6_17 0.000699246f $X=0.702 $Y=0.0405
cc_188 N_14_4 N_6_17 0.00671903f $X=0.6875 $Y=0.0405
cc_189 N_14_5 N_6_17 0.0256975f $X=0.758 $Y=0.0405
cc_190 N_14_1 N_9_9 0.000885133f $X=0.702 $Y=0.0405
cc_191 N_14_5 N_9_9 0.0150071f $X=0.758 $Y=0.0405
cc_192 N_14_1 N_10_15 0.000289697f $X=0.702 $Y=0.0405
cc_193 N_14_1 N_10_22 0.000422819f $X=0.702 $Y=0.0405
cc_194 N_14_1 N_10_23 0.000530683f $X=0.702 $Y=0.0405
cc_195 N_14_4 N_10_5 0.000557868f $X=0.6875 $Y=0.0405
cc_196 N_14_1 N_10_18 0.00238505f $X=0.702 $Y=0.0405
x_PM_DFFHQNx3_ASAP7_75t_R%10 vss N_M10_g N_M24_g N_M21_d N_M22_s N_M11_g
+ N_M25_g N_M12_g N_M26_g N_M13_g N_M27_g N_M7_d N_M8_s N_10_30 N_10_6 N_10_16
+ N_10_25 N_10_15 N_10_17 N_10_23 N_10_19 N_10_5 N_10_24 N_10_22 N_10_2 N_10_20
+ N_10_28 N_10_21 N_10_29 N_10_11 N_10_27 N_10_1 N_10_18 N_10_26 N_10_14
+ N_10_13 N_10_12 PM_DFFHQNx3_ASAP7_75t_R%10
cc_197 N_10_30 N_4_28 0.000131526f $X=0.8795 $Y=0.153
cc_198 N_10_6 N_4_15 0.000132721f $X=0.702 $Y=0.2295
cc_199 N_10_16 N_4_15 0.00643982f $X=0.6875 $Y=0.2295
cc_200 N_10_25 N_4_27 0.000148649f $X=0.81 $Y=0.162
cc_201 N_10_15 N_4_15 0.00654774f $X=0.6335 $Y=0.0405
cc_202 N_10_17 N_4_27 0.000389888f $X=0.729 $Y=0.233
cc_203 N_10_23 N_4_27 0.00408889f $X=0.729 $Y=0.136
cc_204 N_10_23 N_4_3 0.000505057f $X=0.729 $Y=0.136
cc_205 N_10_19 N_4_27 0.000506419f $X=0.729 $Y=0.16
cc_206 N_10_5 N_4_3 0.000506715f $X=0.648 $Y=0.0405
cc_207 N_10_24 N_4_27 0.000541489f $X=0.729 $Y=0.1975
cc_208 N_10_22 N_4_27 0.000545106f $X=0.704 $Y=0.036
cc_209 N_10_22 N_4_28 0.000950471f $X=0.704 $Y=0.036
cc_210 N_10_5 N_4_15 0.0187676f $X=0.648 $Y=0.0405
cc_211 N_10_19 N_6_8 0.000159558f $X=0.729 $Y=0.16
cc_212 N_10_17 N_6_8 0.000195579f $X=0.729 $Y=0.233
cc_213 N_10_15 N_6_16 0.00658889f $X=0.6335 $Y=0.0405
cc_214 N_10_6 N_6_8 0.000228311f $X=0.702 $Y=0.2295
cc_215 N_10_25 N_6_4 0.000390895f $X=0.81 $Y=0.162
cc_216 N_10_23 N_6_8 0.000483158f $X=0.729 $Y=0.136
cc_217 N_10_24 N_6_8 0.000571176f $X=0.729 $Y=0.1975
cc_218 N_10_6 N_6_17 0.000929593f $X=0.702 $Y=0.2295
cc_219 N_10_16 N_6_4 0.0013197f $X=0.6875 $Y=0.2295
cc_220 N_10_16 N_6_8 0.00219996f $X=0.6875 $Y=0.2295
cc_221 N_10_5 N_6_16 0.00947449f $X=0.648 $Y=0.0405
cc_222 N_10_16 N_6_17 0.0167995f $X=0.6875 $Y=0.2295
cc_223 N_10_22 N_7_3 0.000100103f $X=0.704 $Y=0.036
cc_224 N_10_17 N_7_3 0.000185186f $X=0.729 $Y=0.233
cc_225 N_10_16 N_7_3 0.00043371f $X=0.6875 $Y=0.2295
cc_226 N_10_15 N_7_11 0.000474321f $X=0.6335 $Y=0.0405
cc_227 N_10_17 N_7_4 0.000286731f $X=0.729 $Y=0.233
cc_228 N_10_6 N_7_4 0.000748088f $X=0.702 $Y=0.2295
cc_229 N_10_22 N_7_18 0.000477501f $X=0.704 $Y=0.036
cc_230 N_10_16 N_7_4 0.0005675f $X=0.6875 $Y=0.2295
cc_231 N_10_17 N_7_19 0.000678356f $X=0.729 $Y=0.233
cc_232 N_10_22 N_7_14 0.00149158f $X=0.704 $Y=0.036
cc_233 N_10_5 N_7_3 0.00338595f $X=0.648 $Y=0.0405
cc_234 N_10_24 N_9_9 0.000141342f $X=0.729 $Y=0.1975
cc_235 N_10_2 N_9_9 0.00019076f $X=0.9895 $Y=0.136
cc_236 N_10_20 N_9_9 0.000212839f $X=0.837 $Y=0.162
cc_237 N_10_28 N_9_9 0.000229159f $X=0.891 $Y=0.1305
cc_238 N_10_21 N_9_14 0.000238549f $X=0.891 $Y=0.1575
cc_239 N_10_29 N_9_18 0.00140256f $X=0.999 $Y=0.1245
cc_240 N_10_11 N_9_3 0.000359581f $X=0.837 $Y=0.0245
cc_241 N_10_2 N_9_18 0.00036598f $X=0.9895 $Y=0.136
cc_242 N_10_27 N_9_4 0.000373446f $X=0.848 $Y=0.162
cc_243 N_10_21 N_9_18 0.00128332f $X=0.891 $Y=0.1575
cc_244 N_10_11 N_9_4 0.000540838f $X=0.837 $Y=0.0245
cc_245 N_10_1 N_9_1 0.000606623f $X=0.837 $Y=0.135
cc_246 N_10_27 N_9_17 0.000685718f $X=0.848 $Y=0.162
cc_247 N_10_18 N_9_12 0.000791702f $X=0.729 $Y=0.036
cc_248 N_10_26 N_9_15 0.000832677f $X=0.837 $Y=0.118
cc_249 N_10_23 N_9_1 0.000978201f $X=0.729 $Y=0.136
cc_250 N_10_28 N_9_16 0.00112322f $X=0.891 $Y=0.1305
cc_251 N_10_1 N_9_9 0.00116674f $X=0.837 $Y=0.135
cc_252 N_10_21 N_9_17 0.00120432f $X=0.891 $Y=0.1575
cc_253 N_10_11 N_9_1 0.00121761f $X=0.837 $Y=0.0245
cc_254 N_10_25 N_9_15 0.00147538f $X=0.81 $Y=0.162
cc_255 N_10_30 N_9_18 0.00178734f $X=0.8795 $Y=0.153
cc_256 N_10_11 N_9_10 0.00654706f $X=0.837 $Y=0.0245
cc_257 N_10_11 N_9_11 0.00658394f $X=0.837 $Y=0.0245
cc_258 N_10_23 N_9_15 0.00455782f $X=0.729 $Y=0.136
cc_259 N_10_28 N_9_18 0.00614734f $X=0.891 $Y=0.1305
cc_260 N_10_11 N_9_9 0.030588f $X=0.837 $Y=0.0245
x_PM_DFFHQNx3_ASAP7_75t_R%CLK vss CLK N_M0_g N_M14_g N_CLK_3 N_CLK_1 N_CLK_7
+ N_CLK_8 N_CLK_4 N_CLK_5 N_CLK_6 PM_DFFHQNx3_ASAP7_75t_R%CLK
x_PM_DFFHQNx3_ASAP7_75t_R%13 vss N_M18_d N_M19_s N_13_4 N_13_1 N_13_5
+ PM_DFFHQNx3_ASAP7_75t_R%13
cc_261 N_13_4 N_4_14 0.014032f $X=0.4175 $Y=0.2295
cc_262 N_13_1 N_6_2 0.000798372f $X=0.432 $Y=0.2295
cc_263 N_13_5 N_6_8 0.00102067f $X=0.488 $Y=0.2295
cc_264 N_13_1 N_6_15 0.00185625f $X=0.432 $Y=0.2295
cc_265 N_13_5 N_6_15 0.00654352f $X=0.488 $Y=0.2295
cc_266 N_13_4 N_6_15 0.0227808f $X=0.4175 $Y=0.2295
cc_267 N_13_5 N_7_10 0.0184884f $X=0.488 $Y=0.2295
cc_268 N_13_1 N_8_17 0.000405392f $X=0.432 $Y=0.2295
cc_269 N_13_4 N_8_3 0.000500163f $X=0.4175 $Y=0.2295
cc_270 N_13_1 N_8_16 0.00281213f $X=0.432 $Y=0.2295

* End of included file DFFHQNx3_ASAP7_75t_R.pex.sp.pxi
.ends

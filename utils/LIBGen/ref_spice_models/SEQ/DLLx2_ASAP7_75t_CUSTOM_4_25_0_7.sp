.subckt PM_DLLx2_ASAP7_75t_R%CLK vss 18 9 15 3 1 6 4 5 7 8
c1 1 vss 0.00380526f $X=0.081 $Y=0.135
c2 3 vss 0.0687739f $X=0.081 $Y=0.0245
c3 4 vss 0.00210073f $X=0.081 $Y=0.099
c4 5 vss 0.00176192f $X=0.081 $Y=0.171
c5 6 vss 0.00101383f $X=0.081 $Y=0.135
c6 7 vss 0.00438655f $X=0.108 $Y=0.063
c7 8 vss 0.00442439f $X=0.108 $Y=0.198
r1 8 24 2.40741 $w=2.45e-08 $l=2.7e-08 $layer=M1 $thickness=3.6e-08 $X=0.108
+ $Y=0.198 $X2=0.108 $Y2=0.171
r2 7 22 4.50612 $w=2.06667e-08 $l=3.6e-08 $layer=M1 $thickness=3.6e-08 $X=0.108
+ $Y=0.063 $X2=0.108 $Y2=0.099
r3 23 24 0.502848 $w=3.43333e-08 $l=1.35e-08 $layer=M1 $thickness=3.6e-08
+ $X=0.0945 $Y=0.171 $X2=0.108 $Y2=0.171
r4 5 20 1.35805 $w=2.83333e-08 $l=2.25e-08 $layer=M1 $thickness=3.6e-08
+ $X=0.081 $Y=0.171 $X2=0.081 $Y2=0.1485
r5 5 23 0.502848 $w=3.43333e-08 $l=1.35e-08 $layer=M1 $thickness=3.6e-08
+ $X=0.081 $Y=0.171 $X2=0.0945 $Y2=0.171
r6 21 22 0.502848 $w=3.43333e-08 $l=1.35e-08 $layer=M1 $thickness=3.6e-08
+ $X=0.0945 $Y=0.099 $X2=0.108 $Y2=0.099
r7 4 17 0.483592 $w=3.42308e-08 $l=1.87e-08 $layer=M1 $thickness=3.6e-08
+ $X=0.081 $Y=0.099 $X2=0.081 $Y2=0.1177
r8 4 21 0.502848 $w=3.43333e-08 $l=1.35e-08 $layer=M1 $thickness=3.6e-08
+ $X=0.081 $Y=0.099 $X2=0.0945 $Y2=0.099
r9 18 19 0.874462 $w=1.3e-08 $l=3.7e-09 $layer=M1 $thickness=3.6e-08 $X=0.082
+ $Y=0.119 $X2=0.081 $Y2=0.1227
r10 18 17 0.291487 $w=1.3e-08 $l=1.3e-09 $layer=M1 $thickness=3.6e-08 $X=0.082
+ $Y=0.119 $X2=0.081 $Y2=0.1177
r11 6 19 2.85657 $w=1.3e-08 $l=1.23e-08 $layer=M1 $thickness=3.6e-08 $X=0.081
+ $Y=0.135 $X2=0.081 $Y2=0.1227
r12 6 20 3.14806 $w=1.3e-08 $l=1.35e-08 $layer=M1 $thickness=3.6e-08 $X=0.081
+ $Y=0.135 $X2=0.081 $Y2=0.1485
r13 1 12 10.4265 $w=1.765e-08 $layer=LIG $thickness=5.2e-08 $X=0.081 $Y=0.135
+ $X2=0.081 $Y2=0.135
r14 1 6 19.3796 $a=3.24e-16 $layer=V0LIG $X=0.081 $Y=0.135 $X2=0.081 $Y2=0.135
r15 15 14 14.6259 $w=2.1e-08 $l=4.3e-08 $layer=Gate_1 $thickness=5.6e-08
+ $X=0.081 $Y=0.216 $X2=0.081 $Y2=0.173
r16 13 14 7.31297 $w=2.1e-08 $l=2.15e-08 $layer=Gate_1 $thickness=5.6e-08
+ $X=0.081 $Y=0.1515 $X2=0.081 $Y2=0.173
r17 12 13 5.79936 $w=2.03333e-08 $l=1.65e-08 $layer=Gate_1 $thickness=5.6e-08
+ $X=0.081 $Y=0.135 $X2=0.081 $Y2=0.1515
r18 11 12 5.79936 $w=2.03333e-08 $l=1.65e-08 $layer=Gate_1 $thickness=5.6e-08
+ $X=0.081 $Y=0.1185 $X2=0.081 $Y2=0.135
r19 10 11 7.31297 $w=2.1e-08 $l=2.15e-08 $layer=Gate_1 $thickness=5.6e-08
+ $X=0.081 $Y=0.097 $X2=0.081 $Y2=0.1185
r20 9 10 14.6259 $w=2.1e-08 $l=4.3e-08 $layer=Gate_1 $thickness=5.6e-08
+ $X=0.081 $Y=0.054 $X2=0.081 $Y2=0.097
r21 9 3 10.0341 $w=2.1e-08 $l=2.95e-08 $layer=Gate_1 $thickness=5.6e-08
+ $X=0.081 $Y=0.054 $X2=0.081 $Y2=0.0245
.ends

.subckt PM_DLLx2_ASAP7_75t_R%13 vss 2 3 1
c1 1 vss 0.000752697f $X=0.324 $Y=0.2025
r1 2 1 0.209877 $w=8.1e-08 $l=1.7e-08 $layer=P_src_drn $thickness=1e-09
+ $X=0.3066 $Y=0.2025 $X2=0.324 $Y2=0.2025
r2 3 1 0.209877 $w=8.1e-08 $l=1.7e-08 $layer=P_src_drn $thickness=1e-09
+ $X=0.3413 $Y=0.2025 $X2=0.324 $Y2=0.2025
.ends

.subckt PM_DLLx2_ASAP7_75t_R%12 vss 2 3 1
c1 1 vss 0.000538914f $X=0.486 $Y=0.0405
r1 2 1 0.62963 $w=2.7e-08 $l=1.7e-08 $layer=N_src_drn $thickness=1e-09
+ $X=0.4686 $Y=0.0405 $X2=0.486 $Y2=0.0405
r2 3 1 0.62963 $w=2.7e-08 $l=1.7e-08 $layer=N_src_drn $thickness=1e-09
+ $X=0.5033 $Y=0.0405 $X2=0.486 $Y2=0.0405
.ends

.subckt PM_DLLx2_ASAP7_75t_R%4 vss 31 37 65 68 77 79 6 5 16 14 13 21 25 1 23 24
+ 27 22 18 20 11 26 19 12 2
c1 1 vss 0.00339532f $X=0.134 $Y=0.135
c2 2 vss 0.000278855f $X=0.405 $Y=0.144
c3 5 vss 0.00786944f $X=0.054 $Y=0.054
c4 6 vss 0.00790243f $X=0.054 $Y=0.216
c5 11 vss 0.0685463f $X=0.135 $Y=0.0245
c6 12 vss 0.00712065f $X=0.405 $Y=0.135
c7 13 vss 0.0309152f $X=0.056 $Y=0.054
c8 14 vss 0.0309256f $X=0.056 $Y=0.216
c9 15 vss 0.0035794f $X=0.018 $Y=0.036
c10 16 vss 0.00213116f $X=0.0165 $Y=0.153
c11 17 vss 0.00355698f $X=0.018 $Y=0.234
c12 18 vss 0.0013719f $X=0.189 $Y=0.198
c13 19 vss 0.000614895f $X=0.189 $Y=0.135
c14 20 vss 0.00638264f $X=0.018 $Y=0.1305
c15 21 vss 0.00412439f $X=0.018 $Y=0.1755
c16 22 vss 0.00460706f $X=0.036 $Y=0.036
c17 23 vss 0.00436401f $X=0.036 $Y=0.234
c18 24 vss 0.000624832f $X=0.1405 $Y=0.135
c19 25 vss 0.000791299f $X=0.189 $Y=0.1485
c20 26 vss 0.00122067f $X=0.405 $Y=0.116
c21 27 vss 0.0155611f $X=0.0215 $Y=0.153
r1 79 78 0.0462963 $w=5.4e-08 $l=2.5e-09 $layer=P_src_drn $thickness=1e-09
+ $X=0.0713 $Y=0.216 $X2=0.0685 $Y2=0.216
r2 14 78 0.231482 $w=5.4e-08 $l=1.25e-08 $layer=P_src_drn $thickness=1e-09
+ $X=0.056 $Y=0.216 $X2=0.0685 $Y2=0.216
r3 77 76 0.0462963 $w=5.4e-08 $l=2.5e-09 $layer=N_src_drn $thickness=1e-09
+ $X=0.0713 $Y=0.054 $X2=0.0685 $Y2=0.054
r4 13 76 0.231482 $w=5.4e-08 $l=1.25e-08 $layer=N_src_drn $thickness=1e-09
+ $X=0.056 $Y=0.054 $X2=0.0685 $Y2=0.054
r5 6 74 19.3796 $a=3.24e-16 $layer=V0LISD $X=0.054 $Y=0.216 $X2=0.055 $Y2=0.234
r6 5 71 19.3796 $a=3.24e-16 $layer=V0LISD $X=0.054 $Y=0.054 $X2=0.055 $Y2=0.036
r7 73 74 2.09871 $w=1.3e-08 $l=9e-09 $layer=M1 $thickness=3.6e-08 $X=0.046
+ $Y=0.234 $X2=0.055 $Y2=0.234
r8 23 73 2.3319 $w=1.3e-08 $l=1e-08 $layer=M1 $thickness=3.6e-08 $X=0.036
+ $Y=0.234 $X2=0.046 $Y2=0.234
r9 70 71 2.09871 $w=1.3e-08 $l=9e-09 $layer=M1 $thickness=3.6e-08 $X=0.046
+ $Y=0.036 $X2=0.055 $Y2=0.036
r10 22 70 2.3319 $w=1.3e-08 $l=1e-08 $layer=M1 $thickness=3.6e-08 $X=0.036
+ $Y=0.036 $X2=0.046 $Y2=0.036
r11 68 67 16.4967 $w=2.1e-08 $l=4.85e-08 $layer=Gate_1 $thickness=5.6e-08
+ $X=0.405 $Y=0.2295 $X2=0.405 $Y2=0.181
r12 65 66 16.4967 $w=2.1e-08 $l=4.85e-08 $layer=Gate_1 $thickness=5.6e-08
+ $X=0.405 $Y=0.0675 $X2=0.405 $Y2=0.116
r13 12 66 6.6497 $w=2.04211e-08 $l=1.9e-08 $layer=Gate_1 $thickness=5.6e-08
+ $X=0.405 $Y=0.135 $X2=0.405 $Y2=0.116
r14 12 67 15.8334 $w=2.07609e-08 $l=4.6e-08 $layer=Gate_1 $thickness=5.6e-08
+ $X=0.405 $Y=0.135 $X2=0.405 $Y2=0.181
r15 17 62 4.64701 $w=1.62667e-08 $l=2.7e-08 $layer=M1 $thickness=3.6e-08
+ $X=0.018 $Y=0.234 $X2=0.018 $Y2=0.207
r16 17 23 2.5483 $w=1.55e-08 $l=1.8e-08 $layer=M1 $thickness=3.6e-08 $X=0.018
+ $Y=0.234 $X2=0.036 $Y2=0.234
r17 15 61 4.64701 $w=1.62667e-08 $l=2.7e-08 $layer=M1 $thickness=3.6e-08
+ $X=0.018 $Y=0.036 $X2=0.018 $Y2=0.063
r18 15 22 2.5483 $w=1.55e-08 $l=1.8e-08 $layer=M1 $thickness=3.6e-08 $X=0.018
+ $Y=0.036 $X2=0.036 $Y2=0.036
r19 2 63 6.49795 $w=1.53e-08 $l=1.1e-08 $layer=LIG $thickness=4.8e-08 $X=0.405
+ $Y=0.144 $X2=0.405 $Y2=0.133
r20 2 12 5.11004 $w=1.92769e-08 $l=9e-09 $layer=Gate_1 $thickness=5.47692e-08
+ $X=0.405 $Y=0.144 $X2=0.405 $Y2=0.135
r21 21 62 7.34548 $w=1.3e-08 $l=3.15e-08 $layer=M1 $thickness=3.6e-08 $X=0.018
+ $Y=0.1755 $X2=0.018 $Y2=0.207
r22 60 61 8.39483 $w=1.3e-08 $l=3.6e-08 $layer=M1 $thickness=3.6e-08 $X=0.018
+ $Y=0.099 $X2=0.018 $Y2=0.063
r23 20 60 7.34548 $w=1.3e-08 $l=3.15e-08 $layer=M1 $thickness=3.6e-08 $X=0.018
+ $Y=0.1305 $X2=0.018 $Y2=0.099
r24 58 63 19.3796 $a=3.24e-16 $layer=V0LIG $X=0.405 $Y=0.144 $X2=0.405 $Y2=0.133
r25 26 58 6.52931 $w=1.3e-08 $l=2.8e-08 $layer=M1 $thickness=3.6e-08 $X=0.405
+ $Y=0.116 $X2=0.405 $Y2=0.144
r26 55 56 1.90199 $w=1.38333e-08 $l=9e-09 $layer=M1 $thickness=3.6e-08
+ $X=0.0255 $Y=0.153 $X2=0.0345 $Y2=0.153
r27 16 55 0.9184 $w=1.8e-08 $l=9e-09 $layer=M1 $thickness=3.6e-08 $X=0.0165
+ $Y=0.153 $X2=0.0255 $Y2=0.153
r28 16 20 3.9134 $w=1.47857e-08 $l=2.25499e-08 $layer=M1 $thickness=3.6e-08
+ $X=0.0165 $Y=0.153 $X2=0.018 $Y2=0.1305
r29 16 21 3.9134 $w=1.47857e-08 $l=2.25499e-08 $layer=M1 $thickness=3.6e-08
+ $X=0.0165 $Y=0.153 $X2=0.018 $Y2=0.1755
r30 18 47 4.06646 $w=1.5e-08 $l=2.25e-08 $layer=M1 $thickness=3.6e-08 $X=0.189
+ $Y=0.198 $X2=0.189 $Y2=0.1755
r31 53 58 19.5347 $a=3.24e-16 $layer=V1 $X=0.405 $Y=0.153 $X2=0.405 $Y2=0.144
r32 52 53 21.5701 $w=1.3e-08 $l=9.25e-08 $layer=M2 $thickness=3.6e-08 $X=0.3125
+ $Y=0.153 $X2=0.405 $Y2=0.153
r33 51 52 23.0858 $w=1.3e-08 $l=9.9e-08 $layer=M2 $thickness=3.6e-08 $X=0.2135
+ $Y=0.153 $X2=0.3125 $Y2=0.153
r34 50 51 5.71315 $w=1.3e-08 $l=2.45e-08 $layer=M2 $thickness=3.6e-08 $X=0.189
+ $Y=0.153 $X2=0.2135 $Y2=0.153
r35 49 50 18.1888 $w=1.3e-08 $l=7.8e-08 $layer=M2 $thickness=3.6e-08 $X=0.111
+ $Y=0.153 $X2=0.189 $Y2=0.153
r36 48 49 18.1888 $w=1.3e-08 $l=7.8e-08 $layer=M2 $thickness=3.6e-08 $X=0.033
+ $Y=0.153 $X2=0.111 $Y2=0.153
r37 48 56 19.5347 $a=3.24e-16 $layer=V1 $X=0.033 $Y=0.153 $X2=0.0345 $Y2=0.153
r38 27 48 2.68168 $w=1.3e-08 $l=1.15e-08 $layer=M2 $thickness=3.6e-08 $X=0.0215
+ $Y=0.153 $X2=0.033 $Y2=0.153
r39 46 47 4.19742 $w=1.3e-08 $l=1.8e-08 $layer=M1 $thickness=3.6e-08 $X=0.189
+ $Y=0.1575 $X2=0.189 $Y2=0.1755
r40 25 46 2.09871 $w=1.3e-08 $l=9e-09 $layer=M1 $thickness=3.6e-08 $X=0.189
+ $Y=0.1485 $X2=0.189 $Y2=0.1575
r41 25 50 19.5347 $a=3.24e-16 $layer=V1 $X=0.189 $Y=0.1485 $X2=0.189 $Y2=0.153
r42 19 45 2.6649 $w=1.54324e-08 $l=1.85e-08 $layer=M1 $thickness=3.6e-08
+ $X=0.189 $Y=0.135 $X2=0.1705 $Y2=0.135
r43 19 25 1.49895 $w=1.95333e-08 $l=1.35e-08 $layer=M1 $thickness=3.6e-08
+ $X=0.189 $Y=0.135 $X2=0.189 $Y2=0.1485
r44 44 45 3.73104 $w=1.3e-08 $l=1.6e-08 $layer=M1 $thickness=3.6e-08 $X=0.1545
+ $Y=0.135 $X2=0.1705 $Y2=0.135
r45 43 44 2.09871 $w=1.3e-08 $l=9e-09 $layer=M1 $thickness=3.6e-08 $X=0.1455
+ $Y=0.135 $X2=0.1545 $Y2=0.135
r46 24 43 1.16595 $w=1.3e-08 $l=5e-09 $layer=M1 $thickness=3.6e-08 $X=0.1405
+ $Y=0.135 $X2=0.1455 $Y2=0.135
r47 41 44 19.3796 $a=3.24e-16 $layer=V0LIG $X=0.153 $Y=0.135 $X2=0.1545
+ $Y2=0.135
r48 39 41 4.98695 $w=1.60444e-08 $l=9e-09 $layer=LIG $thickness=4.8e-08
+ $X=0.144 $Y=0.135 $X2=0.153 $Y2=0.135
r49 1 39 2.6116 $w=2.2e-08 $l=1e-08 $layer=LIG $thickness=4.8e-08 $X=0.134
+ $Y=0.135 $X2=0.144 $Y2=0.135
r50 1 34 6.27904 $w=2.09e-08 $l=1e-09 $layer=Gate_1 $thickness=5.24e-08
+ $X=0.134 $Y=0.135 $X2=0.135 $Y2=0.135
r51 37 36 14.6259 $w=2.1e-08 $l=4.3e-08 $layer=Gate_1 $thickness=5.6e-08
+ $X=0.135 $Y=0.216 $X2=0.135 $Y2=0.173
r52 35 36 7.31297 $w=2.1e-08 $l=2.15e-08 $layer=Gate_1 $thickness=5.6e-08
+ $X=0.135 $Y=0.1515 $X2=0.135 $Y2=0.173
r53 34 35 5.79936 $w=2.03333e-08 $l=1.65e-08 $layer=Gate_1 $thickness=5.6e-08
+ $X=0.135 $Y=0.135 $X2=0.135 $Y2=0.1515
r54 34 39 4.18976 $w=2.01667e-08 $l=9e-09 $layer=Gate_1 $thickness=5.53333e-08
+ $X=0.135 $Y=0.135 $X2=0.144 $Y2=0.135
r55 33 34 5.79936 $w=2.03333e-08 $l=1.65e-08 $layer=Gate_1 $thickness=5.6e-08
+ $X=0.135 $Y=0.1185 $X2=0.135 $Y2=0.135
r56 32 33 7.31297 $w=2.1e-08 $l=2.15e-08 $layer=Gate_1 $thickness=5.6e-08
+ $X=0.135 $Y=0.097 $X2=0.135 $Y2=0.1185
r57 31 32 14.6259 $w=2.1e-08 $l=4.3e-08 $layer=Gate_1 $thickness=5.6e-08
+ $X=0.135 $Y=0.054 $X2=0.135 $Y2=0.097
r58 31 11 10.0341 $w=2.1e-08 $l=2.95e-08 $layer=Gate_1 $thickness=5.6e-08
+ $X=0.135 $Y=0.054 $X2=0.135 $Y2=0.0245
r59 6 14 1e-05 $l=2e-09 $X=0.054 $Y=0.216 $X2=0.056 $Y2=0.216
r60 5 13 1e-05 $l=2e-09 $X=0.054 $Y=0.054 $X2=0.056 $Y2=0.054
.ends

.subckt PM_DLLx2_ASAP7_75t_R%10 vss 7 9 5 4 1
c1 1 vss 0.00823313f $X=0.351 $Y=0.0675
c2 4 vss 0.00285554f $X=0.3095 $Y=0.0675
c3 5 vss 0.00175276f $X=0.38 $Y=0.0675
r1 9 8 0.0308642 $w=8.1e-08 $l=2.5e-09 $layer=N_src_drn $thickness=1e-09
+ $X=0.3953 $Y=0.0675 $X2=0.3925 $Y2=0.0675
r2 5 8 0.154321 $w=8.1e-08 $l=1.25e-08 $layer=N_src_drn $thickness=1e-09
+ $X=0.38 $Y=0.0675 $X2=0.3925 $Y2=0.0675
r3 4 1 0.154321 $w=8.1e-08 $l=1.25e-08 $layer=N_src_drn $thickness=1e-09
+ $X=0.3095 $Y=0.0675 $X2=0.351 $Y2=0.0675
r4 7 4 0.0308642 $w=8.1e-08 $l=2.5e-09 $layer=N_src_drn $thickness=1e-09
+ $X=0.3066 $Y=0.0675 $X2=0.3095 $Y2=0.0675
r5 1 5 1e-05 $l=2.9e-08 $X=0.351 $Y=0.0675 $X2=0.38 $Y2=0.0675
.ends

.subckt PM_DLLx2_ASAP7_75t_R%11 vss 7 12 4 1 5
c1 1 vss 0.00627732f $X=0.432 $Y=0.2295
c2 4 vss 0.0017677f $X=0.4175 $Y=0.2295
c3 5 vss 0.00216037f $X=0.488 $Y=0.2295
r1 12 11 0.0925926 $w=2.7e-08 $l=2.5e-09 $layer=P_src_drn $thickness=1e-09
+ $X=0.5033 $Y=0.2295 $X2=0.5005 $Y2=0.2295
r2 5 11 0.462963 $w=2.7e-08 $l=1.25e-08 $layer=P_src_drn $thickness=1e-09
+ $X=0.488 $Y=0.2295 $X2=0.5005 $Y2=0.2295
r3 9 5 9.64198 $w=2.32e-08 $l=2.05e-08 $layer=LISD $thickness=2.7e-08 $X=0.4655
+ $Y=0.2295 $X2=0.488 $Y2=0.2295
r4 8 9 7.05511 $w=2.32e-08 $l=1.5e-08 $layer=LISD $thickness=2.7e-08 $X=0.4505
+ $Y=0.2295 $X2=0.4655 $Y2=0.2295
r5 1 8 8.7013 $w=2.32e-08 $l=1.85e-08 $layer=LISD $thickness=2.7e-08 $X=0.432
+ $Y=0.2295 $X2=0.4505 $Y2=0.2295
r6 4 1 0.462963 $w=2.7e-08 $l=1.25e-08 $layer=P_src_drn $thickness=1e-09
+ $X=0.4175 $Y=0.2295 $X2=0.432 $Y2=0.2295
r7 7 4 0.0925926 $w=2.7e-08 $l=2.5e-09 $layer=P_src_drn $thickness=1e-09
+ $X=0.4146 $Y=0.2295 $X2=0.4175 $Y2=0.2295
.ends

.subckt PM_DLLx2_ASAP7_75t_R%6 vss 29 70 74 76 19 4 5 18 16 14 20 21 2 23 1 15
+ 12 13 17 6 22
c1 1 vss 0.000418878f $X=0.351 $Y=0.135
c2 2 vss 0.000150437f $X=0.459 $Y=0.179
c3 4 vss 0.0076012f $X=0.162 $Y=0.054
c4 5 vss 0.00749228f $X=0.162 $Y=0.216
c5 6 vss 0.00948009f $X=0.501 $Y=0.179
c6 12 vss 0.00807779f $X=0.351 $Y=0.073
c7 13 vss 0.00674277f $X=0.459 $Y=0.179
c8 14 vss 0.0323438f $X=0.1475 $Y=0.054
c9 15 vss 0.0325105f $X=0.1475 $Y=0.216
c10 16 vss 0.00308768f $X=0.243 $Y=0.036
c11 17 vss 0.00285129f $X=0.243 $Y=0.234
c12 18 vss 0.00969835f $X=0.216 $Y=0.036
c13 19 vss 0.00878027f $X=0.216 $Y=0.234
c14 20 vss 0.00778698f $X=0.243 $Y=0.153
c15 21 vss 0.00174493f $X=0.351 $Y=0.116
c16 22 vss 0.00144831f $X=0.513 $Y=0.168
c17 23 vss 0.0133494f $X=0.2315 $Y=0.189
r1 15 5 0.231482 $w=5.4e-08 $l=1.25e-08 $layer=P_src_drn $thickness=1e-09
+ $X=0.1475 $Y=0.216 $X2=0.162 $Y2=0.216
r2 76 15 0.0462963 $w=5.4e-08 $l=2.5e-09 $layer=P_src_drn $thickness=1e-09
+ $X=0.1446 $Y=0.216 $X2=0.1475 $Y2=0.216
r3 14 4 0.231482 $w=5.4e-08 $l=1.25e-08 $layer=N_src_drn $thickness=1e-09
+ $X=0.1475 $Y=0.054 $X2=0.162 $Y2=0.054
r4 74 14 0.0462963 $w=5.4e-08 $l=2.5e-09 $layer=N_src_drn $thickness=1e-09
+ $X=0.1446 $Y=0.054 $X2=0.1475 $Y2=0.054
r5 70 71 23.4695 $w=2.1e-08 $l=6.9e-08 $layer=Gate_1 $thickness=5.6e-08
+ $X=0.459 $Y=0.0405 $X2=0.459 $Y2=0.1095
r6 13 71 23.8777 $w=2.07986e-08 $l=6.95e-08 $layer=Gate_1 $thickness=5.6e-08
+ $X=0.459 $Y=0.179 $X2=0.459 $Y2=0.1095
r7 5 65 19.3796 $a=3.24e-16 $layer=V0LISD $X=0.162 $Y=0.216 $X2=0.162 $Y2=0.234
r8 4 62 19.3796 $a=3.24e-16 $layer=V0LISD $X=0.162 $Y=0.054 $X2=0.162 $Y2=0.036
r9 2 56 5.67512 $w=2.4e-08 $l=5e-09 $layer=LISD $thickness=4.02632e-08 $X=0.459
+ $Y=0.179 $X2=0.464 $Y2=0.179
r10 2 13 7.56983 $w=2.18462e-08 $layer=Gate_1 $thickness=5.23077e-08 $X=0.459
+ $Y=0.179 $X2=0.459 $Y2=0.179
r11 65 66 5.24677 $w=1.3e-08 $l=2.25e-08 $layer=M1 $thickness=3.6e-08 $X=0.162
+ $Y=0.234 $X2=0.1845 $Y2=0.234
r12 19 66 7.34548 $w=1.3e-08 $l=3.15e-08 $layer=M1 $thickness=3.6e-08 $X=0.216
+ $Y=0.234 $X2=0.1845 $Y2=0.234
r13 62 63 5.24677 $w=1.3e-08 $l=2.25e-08 $layer=M1 $thickness=3.6e-08 $X=0.162
+ $Y=0.036 $X2=0.1845 $Y2=0.036
r14 18 63 7.34548 $w=1.3e-08 $l=3.15e-08 $layer=M1 $thickness=3.6e-08 $X=0.216
+ $Y=0.036 $X2=0.1845 $Y2=0.036
r15 55 56 11.0623 $w=2.14976e-08 $l=2.05e-08 $layer=LISD $thickness=2.7e-08
+ $X=0.4845 $Y=0.179 $X2=0.464 $Y2=0.179
r16 6 53 7.07284 $w=2.02e-08 $l=1.2e-08 $layer=LISD $thickness=2.7e-08 $X=0.501
+ $Y=0.179 $X2=0.513 $Y2=0.179
r17 6 55 9.72516 $w=2.02e-08 $l=1.65e-08 $layer=LISD $thickness=2.7e-08
+ $X=0.501 $Y=0.179 $X2=0.4845 $Y2=0.179
r18 17 50 2.5483 $w=1.79e-08 $l=1.8e-08 $layer=M1 $thickness=3.6e-08 $X=0.243
+ $Y=0.234 $X2=0.243 $Y2=0.216
r19 17 19 4.64701 $w=1.46667e-08 $l=2.7e-08 $layer=M1 $thickness=3.6e-08
+ $X=0.243 $Y=0.234 $X2=0.216 $Y2=0.234
r20 16 47 4.64701 $w=1.62667e-08 $l=2.7e-08 $layer=M1 $thickness=3.6e-08
+ $X=0.243 $Y=0.036 $X2=0.243 $Y2=0.063
r21 16 18 4.64701 $w=1.46667e-08 $l=2.7e-08 $layer=M1 $thickness=3.6e-08
+ $X=0.243 $Y=0.036 $X2=0.216 $Y2=0.036
r22 51 53 19.3796 $a=3.24e-16 $layer=V0LISD $X=0.513 $Y=0.1845 $X2=0.513
+ $Y2=0.179
r23 22 51 3.84763 $w=1.3e-08 $l=1.65e-08 $layer=M1 $thickness=3.6e-08 $X=0.513
+ $Y=0.168 $X2=0.513 $Y2=0.1845
r24 49 50 3.14806 $w=1.3e-08 $l=1.35e-08 $layer=M1 $thickness=3.6e-08 $X=0.243
+ $Y=0.2025 $X2=0.243 $Y2=0.216
r25 48 49 2.09871 $w=1.3e-08 $l=9e-09 $layer=M1 $thickness=3.6e-08 $X=0.243
+ $Y=0.1935 $X2=0.243 $Y2=0.2025
r26 46 47 8.39483 $w=1.3e-08 $l=3.6e-08 $layer=M1 $thickness=3.6e-08 $X=0.243
+ $Y=0.099 $X2=0.243 $Y2=0.063
r27 45 46 5.24677 $w=1.3e-08 $l=2.25e-08 $layer=M1 $thickness=3.6e-08 $X=0.243
+ $Y=0.1215 $X2=0.243 $Y2=0.099
r28 44 48 2.09871 $w=1.3e-08 $l=9e-09 $layer=M1 $thickness=3.6e-08 $X=0.243
+ $Y=0.1845 $X2=0.243 $Y2=0.1935
r29 20 44 7.34548 $w=1.3e-08 $l=3.15e-08 $layer=M1 $thickness=3.6e-08 $X=0.243
+ $Y=0.153 $X2=0.243 $Y2=0.1845
r30 20 45 7.34548 $w=1.3e-08 $l=3.15e-08 $layer=M1 $thickness=3.6e-08 $X=0.243
+ $Y=0.153 $X2=0.243 $Y2=0.1215
r31 42 51 19.5347 $a=3.24e-16 $layer=V1 $X=0.513 $Y=0.189 $X2=0.513 $Y2=0.1845
r32 41 42 8.39483 $w=1.3e-08 $l=3.6e-08 $layer=M2 $thickness=3.6e-08 $X=0.477
+ $Y=0.189 $X2=0.513 $Y2=0.189
r33 40 41 10.4935 $w=1.3e-08 $l=4.5e-08 $layer=M2 $thickness=3.6e-08 $X=0.432
+ $Y=0.189 $X2=0.477 $Y2=0.189
r34 39 40 10.4935 $w=1.3e-08 $l=4.5e-08 $layer=M2 $thickness=3.6e-08 $X=0.387
+ $Y=0.189 $X2=0.432 $Y2=0.189
r35 38 39 8.39483 $w=1.3e-08 $l=3.6e-08 $layer=M2 $thickness=3.6e-08 $X=0.351
+ $Y=0.189 $X2=0.387 $Y2=0.189
r36 37 38 12.5922 $w=1.3e-08 $l=5.4e-08 $layer=M2 $thickness=3.6e-08 $X=0.297
+ $Y=0.189 $X2=0.351 $Y2=0.189
r37 36 37 12.5922 $w=1.3e-08 $l=5.4e-08 $layer=M2 $thickness=3.6e-08 $X=0.243
+ $Y=0.189 $X2=0.297 $Y2=0.189
r38 36 44 19.5347 $a=3.24e-16 $layer=V1 $X=0.243 $Y=0.189 $X2=0.243 $Y2=0.1845
r39 23 36 2.68168 $w=1.3e-08 $l=1.15e-08 $layer=M2 $thickness=3.6e-08 $X=0.2315
+ $Y=0.189 $X2=0.243 $Y2=0.189
r40 33 38 19.5347 $a=3.24e-16 $layer=V1 $X=0.351 $Y=0.189 $X2=0.351 $Y2=0.189
r41 32 33 6.29612 $w=1.3e-08 $l=2.7e-08 $layer=M1 $thickness=3.6e-08 $X=0.351
+ $Y=0.162 $X2=0.351 $Y2=0.189
r42 31 32 6.29612 $w=1.3e-08 $l=2.7e-08 $layer=M1 $thickness=3.6e-08 $X=0.351
+ $Y=0.135 $X2=0.351 $Y2=0.162
r43 21 31 4.4306 $w=1.3e-08 $l=1.9e-08 $layer=M1 $thickness=3.6e-08 $X=0.351
+ $Y=0.116 $X2=0.351 $Y2=0.135
r44 1 27 10.4265 $w=1.765e-08 $layer=LIG $thickness=5.2e-08 $X=0.351 $Y=0.135
+ $X2=0.351 $Y2=0.135
r45 1 31 19.3796 $a=3.24e-16 $layer=V0LIG $X=0.351 $Y=0.135 $X2=0.351 $Y2=0.135
r46 29 28 16.4967 $w=2.1e-08 $l=4.85e-08 $layer=Gate_1 $thickness=5.6e-08
+ $X=0.351 $Y=0.2025 $X2=0.351 $Y2=0.154
r47 27 28 6.6497 $w=2.04211e-08 $l=1.9e-08 $layer=Gate_1 $thickness=5.6e-08
+ $X=0.351 $Y=0.135 $X2=0.351 $Y2=0.154
r48 12 27 21.2756 $w=2.08226e-08 $l=6.2e-08 $layer=Gate_1 $thickness=5.6e-08
+ $X=0.351 $Y=0.073 $X2=0.351 $Y2=0.135
.ends

.subckt PM_DLLx2_ASAP7_75t_R%7 vss 18 22 39 44 9 11 1 13 4 17 3 16 12 10 15 14
c1 1 vss 0.00270329f $X=0.513 $Y=0.082
c2 3 vss 0.0059141f $X=0.594 $Y=0.0405
c3 4 vss 0.00596526f $X=0.594 $Y=0.2295
c4 9 vss 0.0407546f $X=0.513 $Y=0.0245
c5 10 vss 0.019095f $X=0.5795 $Y=0.0405
c6 11 vss 0.0188201f $X=0.5795 $Y=0.2295
c7 12 vss 0.002918f $X=0.513 $Y=0.036
c8 13 vss 0.00618325f $X=0.621 $Y=0.234
c9 14 vss 0.00286305f $X=0.621 $Y=0.036
c10 15 vss 0.00152199f $X=0.513 $Y=0.059
c11 16 vss 0.00833124f $X=0.551 $Y=0.036
c12 17 vss 0.00455741f $X=0.621 $Y=0.0675
r1 11 4 0.462963 $w=2.7e-08 $l=1.25e-08 $layer=P_src_drn $thickness=1e-09
+ $X=0.5795 $Y=0.2295 $X2=0.594 $Y2=0.2295
r2 44 11 0.0925926 $w=2.7e-08 $l=2.5e-09 $layer=P_src_drn $thickness=1e-09
+ $X=0.5766 $Y=0.2295 $X2=0.5795 $Y2=0.2295
r3 4 41 19.3796 $a=3.24e-16 $layer=V0LISD $X=0.594 $Y=0.2295 $X2=0.594 $Y2=0.234
r4 41 42 3.14806 $w=1.3e-08 $l=1.35e-08 $layer=M1 $thickness=3.6e-08 $X=0.594
+ $Y=0.234 $X2=0.6075 $Y2=0.234
r5 13 37 3.48349 $w=1.525e-08 $l=2e-08 $layer=M1 $thickness=3.6e-08 $X=0.621
+ $Y=0.234 $X2=0.621 $Y2=0.214
r6 13 42 1.96775 $w=1.63333e-08 $l=1.35e-08 $layer=M1 $thickness=3.6e-08
+ $X=0.621 $Y=0.234 $X2=0.6075 $Y2=0.234
r7 10 3 0.462963 $w=2.7e-08 $l=1.25e-08 $layer=N_src_drn $thickness=1e-09
+ $X=0.5795 $Y=0.0405 $X2=0.594 $Y2=0.0405
r8 39 10 0.0925926 $w=2.7e-08 $l=2.5e-09 $layer=N_src_drn $thickness=1e-09
+ $X=0.5766 $Y=0.0405 $X2=0.5795 $Y2=0.0405
r9 36 37 6.7625 $w=1.3e-08 $l=2.9e-08 $layer=M1 $thickness=3.6e-08 $X=0.621
+ $Y=0.185 $X2=0.621 $Y2=0.214
r10 35 36 4.43061 $w=1.3e-08 $l=1.9e-08 $layer=M1 $thickness=3.6e-08 $X=0.621
+ $Y=0.166 $X2=0.621 $Y2=0.185
r11 34 35 3.14806 $w=1.3e-08 $l=1.35e-08 $layer=M1 $thickness=3.6e-08 $X=0.621
+ $Y=0.1525 $X2=0.621 $Y2=0.166
r12 33 34 5.01358 $w=1.3e-08 $l=2.15e-08 $layer=M1 $thickness=3.6e-08 $X=0.621
+ $Y=0.131 $X2=0.621 $Y2=0.1525
r13 32 33 5.01358 $w=1.3e-08 $l=2.15e-08 $layer=M1 $thickness=3.6e-08 $X=0.621
+ $Y=0.1095 $X2=0.621 $Y2=0.131
r14 31 32 3.73104 $w=1.3e-08 $l=1.6e-08 $layer=M1 $thickness=3.6e-08 $X=0.621
+ $Y=0.0935 $X2=0.621 $Y2=0.1095
r15 17 31 6.06293 $w=1.3e-08 $l=2.6e-08 $layer=M1 $thickness=3.6e-08 $X=0.621
+ $Y=0.0675 $X2=0.621 $Y2=0.0935
r16 3 29 19.3796 $a=3.24e-16 $layer=V0LISD $X=0.594 $Y=0.0405 $X2=0.594
+ $Y2=0.036
r17 14 30 1.49895 $w=1.63333e-08 $l=1.35e-08 $layer=M1 $thickness=3.6e-08
+ $X=0.621 $Y=0.036 $X2=0.6075 $Y2=0.036
r18 14 17 5.69636 $w=1.58e-08 $l=3.15e-08 $layer=M1 $thickness=3.6e-08 $X=0.621
+ $Y=0.036 $X2=0.621 $Y2=0.0675
r19 29 30 3.14806 $w=1.3e-08 $l=1.35e-08 $layer=M1 $thickness=3.6e-08 $X=0.594
+ $Y=0.036 $X2=0.6075 $Y2=0.036
r20 28 29 2.68168 $w=1.3e-08 $l=1.15e-08 $layer=M1 $thickness=3.6e-08 $X=0.5825
+ $Y=0.036 $X2=0.594 $Y2=0.036
r21 16 28 7.34548 $w=1.3e-08 $l=3.15e-08 $layer=M1 $thickness=3.6e-08 $X=0.551
+ $Y=0.036 $X2=0.5825 $Y2=0.036
r22 12 15 3.71425 $w=1.68348e-08 $l=2.3e-08 $layer=M1 $thickness=3.6e-08
+ $X=0.513 $Y=0.036 $X2=0.513 $Y2=0.059
r23 12 16 7.2121 $w=1.41842e-08 $l=3.8e-08 $layer=M1 $thickness=3.6e-08
+ $X=0.513 $Y=0.036 $X2=0.551 $Y2=0.036
r24 15 26 5.36336 $w=1.3e-08 $l=2.3e-08 $layer=M1 $thickness=3.6e-08 $X=0.513
+ $Y=0.059 $X2=0.513 $Y2=0.082
r25 1 20 6.54019 $w=2.09524e-08 $layer=Gate_1 $thickness=5.21905e-08 $X=0.513
+ $Y=0.082 $X2=0.513 $Y2=0.082
r26 1 26 19.3796 $a=3.24e-16 $layer=V0LIG $X=0.513 $Y=0.082 $X2=0.513 $Y2=0.082
r27 22 21 25.5104 $w=2.1e-08 $l=7.5e-08 $layer=Gate_1 $thickness=5.6e-08
+ $X=0.513 $Y=0.2295 $X2=0.513 $Y2=0.1545
r28 20 21 24.8471 $w=2.08483e-08 $l=7.25e-08 $layer=Gate_1 $thickness=5.6e-08
+ $X=0.513 $Y=0.082 $X2=0.513 $Y2=0.1545
r29 19 20 6.81977 $w=2.04359e-08 $l=1.95e-08 $layer=Gate_1 $thickness=5.6e-08
+ $X=0.513 $Y=0.0625 $X2=0.513 $Y2=0.082
r30 18 19 7.48304 $w=2.1e-08 $l=2.2e-08 $layer=Gate_1 $thickness=5.6e-08
+ $X=0.513 $Y=0.0405 $X2=0.513 $Y2=0.0625
r31 18 9 5.44221 $w=2.1e-08 $l=1.6e-08 $layer=Gate_1 $thickness=5.6e-08
+ $X=0.513 $Y=0.0405 $X2=0.513 $Y2=0.0245
.ends

.subckt PM_DLLx2_ASAP7_75t_R%Q vss 33 23 36 47 49 2 16 4 3 1 19 20 14 15 21 13
c1 1 vss 0.00843257f $X=0.702 $Y=0.0405
c2 2 vss 0.00858974f $X=0.702 $Y=0.2295
c3 3 vss 0.00820401f $X=0.81 $Y=0.0675
c4 4 vss 0.00824614f $X=0.81 $Y=0.2025
c5 13 vss 0.0377883f $X=0.704 $Y=0.0675
c6 14 vss 0.0379382f $X=0.7955 $Y=0.0675
c7 15 vss 0.0387534f $X=0.704 $Y=0.2025
c8 16 vss 0.0379312f $X=0.7955 $Y=0.2025
c9 17 vss 0.00270662f $X=0.838 $Y=0.036
c10 18 vss 0.00265704f $X=0.838 $Y=0.234
c11 19 vss 0.0126703f $X=0.6905 $Y=0.036
c12 20 vss 0.0129185f $X=0.7965 $Y=0.234
c13 21 vss 0.00419735f $X=0.838 $Y=0.0675
r1 49 48 0.0308642 $w=8.1e-08 $l=2.5e-09 $layer=P_src_drn $thickness=1e-09
+ $X=0.7193 $Y=0.2025 $X2=0.7165 $Y2=0.2025
r2 15 48 0.154321 $w=8.1e-08 $l=1.25e-08 $layer=P_src_drn $thickness=1e-09
+ $X=0.704 $Y=0.2025 $X2=0.7165 $Y2=0.2025
r3 16 4 0.154321 $w=8.1e-08 $l=1.25e-08 $layer=P_src_drn $thickness=1e-09
+ $X=0.7955 $Y=0.2025 $X2=0.81 $Y2=0.2025
r4 47 16 0.0308642 $w=8.1e-08 $l=2.5e-09 $layer=P_src_drn $thickness=1e-09
+ $X=0.7926 $Y=0.2025 $X2=0.7955 $Y2=0.2025
r5 2 41 19.3796 $a=3.24e-16 $layer=V0LISD $X=0.702 $Y=0.2295 $X2=0.702 $Y2=0.234
r6 4 37 19.3796 $a=3.24e-16 $layer=V0LISD $X=0.81 $Y=0.2025 $X2=0.81 $Y2=0.234
r7 41 42 9.44419 $w=1.3e-08 $l=4.05e-08 $layer=M1 $thickness=3.6e-08 $X=0.702
+ $Y=0.234 $X2=0.7425 $Y2=0.234
r8 39 42 9.44419 $w=1.3e-08 $l=4.05e-08 $layer=M1 $thickness=3.6e-08 $X=0.783
+ $Y=0.234 $X2=0.7425 $Y2=0.234
r9 37 38 3.26466 $w=1.3e-08 $l=1.4e-08 $layer=M1 $thickness=3.6e-08 $X=0.81
+ $Y=0.234 $X2=0.824 $Y2=0.234
r10 20 37 3.14806 $w=1.3e-08 $l=1.35e-08 $layer=M1 $thickness=3.6e-08 $X=0.7965
+ $Y=0.234 $X2=0.81 $Y2=0.234
r11 20 39 3.14806 $w=1.3e-08 $l=1.35e-08 $layer=M1 $thickness=3.6e-08 $X=0.7965
+ $Y=0.234 $X2=0.783 $Y2=0.234
r12 18 34 0.624487 $w=2.20462e-08 $l=9.8e-09 $layer=M1 $thickness=3.6e-08
+ $X=0.838 $Y=0.234 $X2=0.838 $Y2=0.2242
r13 18 38 1.61554 $w=1.62143e-08 $l=1.4e-08 $layer=M1 $thickness=3.6e-08
+ $X=0.838 $Y=0.234 $X2=0.824 $Y2=0.234
r14 14 3 0.154321 $w=8.1e-08 $l=1.25e-08 $layer=N_src_drn $thickness=1e-09
+ $X=0.7955 $Y=0.0675 $X2=0.81 $Y2=0.0675
r15 36 14 0.0308642 $w=8.1e-08 $l=2.5e-09 $layer=N_src_drn $thickness=1e-09
+ $X=0.7926 $Y=0.0675 $X2=0.7955 $Y2=0.0675
r16 33 34 0.291487 $w=1.3e-08 $l=1.2e-09 $layer=M1 $thickness=3.6e-08 $X=0.84
+ $Y=0.223 $X2=0.838 $Y2=0.2242
r17 33 32 6.58761 $w=1.3e-08 $l=2.83e-08 $layer=M1 $thickness=3.6e-08 $X=0.84
+ $Y=0.223 $X2=0.838 $Y2=0.1947
r18 31 32 15.4488 $w=1.3e-08 $l=6.62e-08 $layer=M1 $thickness=3.6e-08 $X=0.838
+ $Y=0.1285 $X2=0.838 $Y2=0.1947
r19 21 31 14.2246 $w=1.3e-08 $l=6.1e-08 $layer=M1 $thickness=3.6e-08 $X=0.838
+ $Y=0.0675 $X2=0.838 $Y2=0.1285
r20 3 29 19.3796 $a=3.24e-16 $layer=V0LISD $X=0.81 $Y=0.0675 $X2=0.81 $Y2=0.036
r21 17 30 1.61554 $w=1.62143e-08 $l=1.4e-08 $layer=M1 $thickness=3.6e-08
+ $X=0.838 $Y=0.036 $X2=0.824 $Y2=0.036
r22 17 21 5.69636 $w=1.58e-08 $l=3.15e-08 $layer=M1 $thickness=3.6e-08 $X=0.838
+ $Y=0.036 $X2=0.838 $Y2=0.0675
r23 29 30 3.26466 $w=1.3e-08 $l=1.4e-08 $layer=M1 $thickness=3.6e-08 $X=0.81
+ $Y=0.036 $X2=0.824 $Y2=0.036
r24 28 29 3.14806 $w=1.3e-08 $l=1.35e-08 $layer=M1 $thickness=3.6e-08 $X=0.7965
+ $Y=0.036 $X2=0.81 $Y2=0.036
r25 27 28 3.14806 $w=1.3e-08 $l=1.35e-08 $layer=M1 $thickness=3.6e-08 $X=0.783
+ $Y=0.036 $X2=0.7965 $Y2=0.036
r26 26 27 9.44419 $w=1.3e-08 $l=4.05e-08 $layer=M1 $thickness=3.6e-08 $X=0.7425
+ $Y=0.036 $X2=0.783 $Y2=0.036
r27 25 26 9.44419 $w=1.3e-08 $l=4.05e-08 $layer=M1 $thickness=3.6e-08 $X=0.702
+ $Y=0.036 $X2=0.7425 $Y2=0.036
r28 19 25 2.68168 $w=1.3e-08 $l=1.15e-08 $layer=M1 $thickness=3.6e-08 $X=0.6905
+ $Y=0.036 $X2=0.702 $Y2=0.036
r29 1 13 23.8708 $w=2.02e-08 $l=4.05e-08 $layer=LISD $thickness=2.7e-08
+ $X=0.702 $Y=0.0405 $X2=0.704 $Y2=0.0675
r30 1 25 19.3796 $a=3.24e-16 $layer=V0LISD $X=0.702 $Y=0.0405 $X2=0.702
+ $Y2=0.036
r31 23 22 0.0308642 $w=8.1e-08 $l=2.5e-09 $layer=N_src_drn $thickness=1e-09
+ $X=0.7193 $Y=0.0675 $X2=0.7165 $Y2=0.0675
r32 13 22 0.154321 $w=8.1e-08 $l=1.25e-08 $layer=N_src_drn $thickness=1e-09
+ $X=0.704 $Y=0.0675 $X2=0.7165 $Y2=0.0675
r33 2 15 1e-05 $l=2.7074e-08 $X=0.702 $Y=0.2295 $X2=0.704 $Y2=0.2025
.ends

.subckt PM_DLLx2_ASAP7_75t_R%8 vss 30 36 72 75 79 83 87 91 94 97 25 5 22 17 19
+ 27 23 21 24 6 14 16 15 20 1 11 2 18 26 12 13
c1 1 vss 0.00100757f $X=0.567 $Y=0.131
c2 2 vss 0.010022f $X=0.7735 $Y=0.136
c3 5 vss 0.00473091f $X=0.378 $Y=0.2295
c4 6 vss 0.00472865f $X=0.432 $Y=0.0405
c5 11 vss 0.0506122f $X=0.567 $Y=0.0245
c6 12 vss 0.0827575f $X=0.729 $Y=0.136
c7 13 vss 0.082446f $X=0.783 $Y=0.136
c8 14 vss 0.00289804f $X=0.4175 $Y=0.0405
c9 15 vss 0.00144544f $X=0.4175 $Y=0.081
c10 16 vss 0.00303252f $X=0.3635 $Y=0.2295
c11 17 vss 0.00149535f $X=0.3635 $Y=0.189
c12 18 vss 0.00269158f $X=0.459 $Y=0.036
c13 19 vss 3.60759e-20 $X=0.459 $Y=0.131
c14 20 vss 0.00273335f $X=0.459 $Y=0.234
c15 21 vss 0.00722044f $X=0.432 $Y=0.234
c16 22 vss 0.00381604f $X=0.432 $Y=0.036
c17 23 vss 0.00115623f $X=0.459 $Y=0.114
c18 24 vss 0.000717465f $X=0.459 $Y=0.142
c19 25 vss 0.00105039f $X=0.5395 $Y=0.131
c20 26 vss 0.00263627f $X=0.783 $Y=0.1085
c21 27 vss 0.0104576f $X=0.459 $Y=0.153
r1 17 5 0.231482 $w=5.4e-08 $l=1.25e-08 $layer=P_src_drn $thickness=1e-09
+ $X=0.3635 $Y=0.189 $X2=0.378 $Y2=0.2295
r2 97 96 0.0925926 $w=2.7e-08 $l=2.5e-09 $layer=P_src_drn $thickness=1e-09
+ $X=0.3953 $Y=0.2295 $X2=0.3925 $Y2=0.2295
r3 95 96 0.166667 $w=2.7e-08 $l=4.5e-09 $layer=P_src_drn $thickness=1e-09
+ $X=0.388 $Y=0.2295 $X2=0.3925 $Y2=0.2295
r4 5 95 0.444445 $w=2.7e-08 $l=1.2e-08 $layer=P_src_drn $thickness=1e-09
+ $X=0.378 $Y=0.2295 $X2=0.388 $Y2=0.2295
r5 16 5 0.462963 $w=2.7e-08 $l=1.25e-08 $layer=P_src_drn $thickness=1e-09
+ $X=0.3635 $Y=0.2295 $X2=0.378 $Y2=0.2295
r6 94 16 0.0925926 $w=2.7e-08 $l=2.5e-09 $layer=P_src_drn $thickness=1e-09
+ $X=0.3606 $Y=0.2025 $X2=0.3635 $Y2=0.2295
r7 91 90 14.6259 $w=2.1e-08 $l=4.3e-08 $layer=Gate_1 $thickness=5.6e-08
+ $X=0.729 $Y=0.2025 $X2=0.729 $Y2=0.1595
r8 89 90 2.55104 $w=2.1e-08 $l=7.5e-09 $layer=Gate_1 $thickness=5.6e-08
+ $X=0.729 $Y=0.152 $X2=0.729 $Y2=0.1595
r9 87 88 14.6259 $w=2.1e-08 $l=4.3e-08 $layer=Gate_1 $thickness=5.6e-08
+ $X=0.729 $Y=0.0675 $X2=0.729 $Y2=0.1105
r10 85 88 2.89117 $w=2.1e-08 $l=8.5e-09 $layer=Gate_1 $thickness=5.6e-08
+ $X=0.729 $Y=0.119 $X2=0.729 $Y2=0.1105
r11 12 65 6.54019 $w=2.09524e-08 $layer=Gate_1 $thickness=5.21905e-08 $X=0.729
+ $Y=0.136 $X2=0.729 $Y2=0.136
r12 12 85 5.96942 $w=2.03529e-08 $l=1.7e-08 $layer=Gate_1 $thickness=5.6e-08
+ $X=0.729 $Y=0.136 $X2=0.729 $Y2=0.119
r13 12 89 5.62929 $w=2.03125e-08 $l=1.6e-08 $layer=Gate_1 $thickness=5.6e-08
+ $X=0.729 $Y=0.136 $X2=0.729 $Y2=0.152
r14 83 82 14.6259 $w=2.1e-08 $l=4.3e-08 $layer=Gate_1 $thickness=5.6e-08
+ $X=0.783 $Y=0.2025 $X2=0.783 $Y2=0.1595
r15 81 82 2.55104 $w=2.1e-08 $l=7.5e-09 $layer=Gate_1 $thickness=5.6e-08
+ $X=0.783 $Y=0.152 $X2=0.783 $Y2=0.1595
r16 79 80 14.6259 $w=2.1e-08 $l=4.3e-08 $layer=Gate_1 $thickness=5.6e-08
+ $X=0.783 $Y=0.0675 $X2=0.783 $Y2=0.1105
r17 77 80 2.89117 $w=2.1e-08 $l=8.5e-09 $layer=Gate_1 $thickness=5.6e-08
+ $X=0.783 $Y=0.119 $X2=0.783 $Y2=0.1105
r18 13 62 6.27904 $w=2.09e-08 $layer=Gate_1 $thickness=5.24e-08 $X=0.783
+ $Y=0.136 $X2=0.783 $Y2=0.136
r19 13 77 5.96942 $w=2.03529e-08 $l=1.7e-08 $layer=Gate_1 $thickness=5.6e-08
+ $X=0.783 $Y=0.136 $X2=0.783 $Y2=0.119
r20 13 81 5.62929 $w=2.03125e-08 $l=1.6e-08 $layer=Gate_1 $thickness=5.6e-08
+ $X=0.783 $Y=0.136 $X2=0.783 $Y2=0.152
r21 15 61 0.231482 $w=5.4e-08 $l=1.25e-08 $layer=N_src_drn $thickness=1e-09
+ $X=0.4175 $Y=0.081 $X2=0.432 $Y2=0.081
r22 75 74 0.0925926 $w=2.7e-08 $l=2.5e-09 $layer=N_src_drn $thickness=1e-09
+ $X=0.4493 $Y=0.0405 $X2=0.4465 $Y2=0.0405
r23 73 74 0.166667 $w=2.7e-08 $l=4.5e-09 $layer=N_src_drn $thickness=1e-09
+ $X=0.442 $Y=0.0405 $X2=0.4465 $Y2=0.0405
r24 61 73 0.444445 $w=2.7e-08 $l=1.2e-08 $layer=N_src_drn $thickness=1e-09
+ $X=0.432 $Y=0.081 $X2=0.442 $Y2=0.0405
r25 14 61 0.462963 $w=2.7e-08 $l=1.25e-08 $layer=N_src_drn $thickness=1e-09
+ $X=0.4175 $Y=0.0405 $X2=0.432 $Y2=0.081
r26 72 14 0.0925926 $w=2.7e-08 $l=2.5e-09 $layer=N_src_drn $thickness=1e-09
+ $X=0.4146 $Y=0.0675 $X2=0.4175 $Y2=0.0405
r27 5 59 19.3796 $a=3.24e-16 $layer=V0LISD $X=0.378 $Y=0.2295 $X2=0.378
+ $Y2=0.234
r28 64 65 12.6539 $w=1.77815e-08 $l=2.7e-08 $layer=LIG $thickness=4.8e-08
+ $X=0.756 $Y=0.136 $X2=0.729 $Y2=0.136
r29 2 62 2.48102 $w=2.2e-08 $l=9.5e-09 $layer=LIG $thickness=4.8e-08 $X=0.7735
+ $Y=0.136 $X2=0.783 $Y2=0.136
r30 2 64 10.1729 $w=1.54914e-08 $l=1.75e-08 $layer=LIG $thickness=4.8e-08
+ $X=0.7735 $Y=0.136 $X2=0.756 $Y2=0.136
r31 6 22 19.3796 $a=3.24e-16 $layer=V0LISD $X=0.432 $Y=0.0405 $X2=0.432
+ $Y2=0.036
r32 6 61 23.8708 $w=2.02e-08 $l=4.05e-08 $layer=LISD $thickness=2.7e-08
+ $X=0.432 $Y=0.0405 $X2=0.432 $Y2=0.081
r33 59 60 3.14806 $w=1.3e-08 $l=1.35e-08 $layer=M1 $thickness=3.6e-08 $X=0.378
+ $Y=0.234 $X2=0.3915 $Y2=0.234
r34 57 60 3.14806 $w=1.3e-08 $l=1.35e-08 $layer=M1 $thickness=3.6e-08 $X=0.405
+ $Y=0.234 $X2=0.3915 $Y2=0.234
r35 21 57 6.29612 $w=1.3e-08 $l=2.7e-08 $layer=M1 $thickness=3.6e-08 $X=0.432
+ $Y=0.234 $X2=0.405 $Y2=0.234
r36 55 62 19.3796 $a=3.24e-16 $layer=V0LIG $X=0.783 $Y=0.1445 $X2=0.783
+ $Y2=0.136
r37 26 55 8.39483 $w=1.3e-08 $l=3.6e-08 $layer=M1 $thickness=3.6e-08 $X=0.783
+ $Y=0.1085 $X2=0.783 $Y2=0.1445
r38 20 50 3.01468 $w=1.741e-08 $l=2e-08 $layer=M1 $thickness=3.6e-08 $X=0.459
+ $Y=0.234 $X2=0.459 $Y2=0.214
r39 20 21 4.64701 $w=1.46667e-08 $l=2.7e-08 $layer=M1 $thickness=3.6e-08
+ $X=0.459 $Y=0.234 $X2=0.432 $Y2=0.234
r40 53 55 19.5347 $a=3.24e-16 $layer=V1 $X=0.783 $Y=0.153 $X2=0.783 $Y2=0.1445
r41 52 53 30.8976 $w=1.3e-08 $l=1.325e-07 $layer=M2 $thickness=3.6e-08
+ $X=0.6505 $Y=0.153 $X2=0.783 $Y2=0.153
r42 51 52 35.678 $w=1.3e-08 $l=1.53e-07 $layer=M2 $thickness=3.6e-08 $X=0.4975
+ $Y=0.153 $X2=0.6505 $Y2=0.153
r43 27 51 8.97781 $w=1.3e-08 $l=3.85e-08 $layer=M2 $thickness=3.6e-08 $X=0.459
+ $Y=0.153 $X2=0.4975 $Y2=0.153
r44 27 46 19.5347 $a=3.24e-16 $layer=V1 $X=0.459 $Y=0.153 $X2=0.459 $Y2=0.153
r45 18 45 6.51253 $w=1.552e-08 $l=3.5e-08 $layer=M1 $thickness=3.6e-08 $X=0.459
+ $Y=0.036 $X2=0.459 $Y2=0.071
r46 18 22 4.64701 $w=1.46667e-08 $l=2.7e-08 $layer=M1 $thickness=3.6e-08
+ $X=0.459 $Y=0.036 $X2=0.432 $Y2=0.036
r47 49 50 2.91487 $w=1.3e-08 $l=1.25e-08 $layer=M1 $thickness=3.6e-08 $X=0.459
+ $Y=0.2015 $X2=0.459 $Y2=0.214
r48 48 49 4.43061 $w=1.3e-08 $l=1.9e-08 $layer=M1 $thickness=3.6e-08 $X=0.459
+ $Y=0.1825 $X2=0.459 $Y2=0.2015
r49 47 48 4.43061 $w=1.3e-08 $l=1.9e-08 $layer=M1 $thickness=3.6e-08 $X=0.459
+ $Y=0.1635 $X2=0.459 $Y2=0.1825
r50 46 47 2.44849 $w=1.3e-08 $l=1.05e-08 $layer=M1 $thickness=3.6e-08 $X=0.459
+ $Y=0.153 $X2=0.459 $Y2=0.1635
r51 24 46 2.56509 $w=1.3e-08 $l=1.1e-08 $layer=M1 $thickness=3.6e-08 $X=0.459
+ $Y=0.142 $X2=0.459 $Y2=0.153
r52 44 45 7.11229 $w=1.3e-08 $l=3.05e-08 $layer=M1 $thickness=3.6e-08 $X=0.459
+ $Y=0.1015 $X2=0.459 $Y2=0.071
r53 23 44 2.91487 $w=1.3e-08 $l=1.25e-08 $layer=M1 $thickness=3.6e-08 $X=0.459
+ $Y=0.114 $X2=0.459 $Y2=0.1015
r54 19 43 5.11582 $w=1.46667e-08 $l=2.7e-08 $layer=M1 $thickness=3.6e-08
+ $X=0.459 $Y=0.131 $X2=0.486 $Y2=0.131
r55 19 23 2.78392 $w=1.56471e-08 $l=1.7e-08 $layer=M1 $thickness=3.6e-08
+ $X=0.459 $Y=0.131 $X2=0.459 $Y2=0.114
r56 19 24 1.38478 $w=1.70909e-08 $l=1.1e-08 $layer=M1 $thickness=3.6e-08
+ $X=0.459 $Y=0.131 $X2=0.459 $Y2=0.142
r57 42 43 6.29612 $w=1.3e-08 $l=2.7e-08 $layer=M1 $thickness=3.6e-08 $X=0.513
+ $Y=0.131 $X2=0.486 $Y2=0.131
r58 25 40 6.17953 $w=1.3e-08 $l=2.65e-08 $layer=M1 $thickness=3.6e-08 $X=0.5395
+ $Y=0.131 $X2=0.566 $Y2=0.131
r59 25 42 6.17953 $w=1.3e-08 $l=2.65e-08 $layer=M1 $thickness=3.6e-08 $X=0.5395
+ $Y=0.131 $X2=0.513 $Y2=0.131
r60 1 33 6.54019 $w=2.09524e-08 $layer=Gate_1 $thickness=5.21905e-08 $X=0.567
+ $Y=0.131 $X2=0.567 $Y2=0.131
r61 1 40 19.3796 $a=3.24e-16 $layer=V0LIG $X=0.567 $Y=0.131 $X2=0.566 $Y2=0.131
r62 36 35 14.6259 $w=2.1e-08 $l=4.3e-08 $layer=Gate_1 $thickness=5.6e-08
+ $X=0.567 $Y=0.2295 $X2=0.567 $Y2=0.1865
r63 34 35 12.5851 $w=2.1e-08 $l=3.7e-08 $layer=Gate_1 $thickness=5.6e-08
+ $X=0.567 $Y=0.1495 $X2=0.567 $Y2=0.1865
r64 33 34 6.47963 $w=2.04054e-08 $l=1.85e-08 $layer=Gate_1 $thickness=5.6e-08
+ $X=0.567 $Y=0.131 $X2=0.567 $Y2=0.1495
r65 32 33 5.11908 $w=2.02414e-08 $l=1.45e-08 $layer=Gate_1 $thickness=5.6e-08
+ $X=0.567 $Y=0.1165 $X2=0.567 $Y2=0.131
r66 31 32 11.2246 $w=2.1e-08 $l=3.3e-08 $layer=Gate_1 $thickness=5.6e-08
+ $X=0.567 $Y=0.0835 $X2=0.567 $Y2=0.1165
r67 30 31 14.6259 $w=2.1e-08 $l=4.3e-08 $layer=Gate_1 $thickness=5.6e-08
+ $X=0.567 $Y=0.0405 $X2=0.567 $Y2=0.0835
r68 30 11 5.44221 $w=2.1e-08 $l=1.6e-08 $layer=Gate_1 $thickness=5.6e-08
+ $X=0.567 $Y=0.0405 $X2=0.567 $Y2=0.0245
.ends

.subckt PM_DLLx2_ASAP7_75t_R%D vss 16 7 13 6 4 5 1 3
c1 1 vss 0.0050218f $X=0.297 $Y=0.135
c2 3 vss 0.0919771f $X=0.297 $Y=0.0245
c3 4 vss 0.0054202f $X=0.297 $Y=0.036
c4 5 vss 0.0051994f $X=0.297 $Y=0.234
c5 6 vss 0.00568759f $X=0.297 $Y=0.0755
r1 5 20 3.48349 $w=1.525e-08 $l=2e-08 $layer=M1 $thickness=3.6e-08 $X=0.297
+ $Y=0.234 $X2=0.297 $Y2=0.214
r2 4 6 8.03069 $w=1.41392e-08 $l=3.95e-08 $layer=M1 $thickness=3.6e-08 $X=0.297
+ $Y=0.036 $X2=0.297 $Y2=0.0755
r3 19 20 9.44419 $w=1.3e-08 $l=4.05e-08 $layer=M1 $thickness=3.6e-08 $X=0.297
+ $Y=0.1735 $X2=0.297 $Y2=0.214
r4 18 19 8.97781 $w=1.3e-08 $l=3.85e-08 $layer=M1 $thickness=3.6e-08 $X=0.297
+ $Y=0.135 $X2=0.297 $Y2=0.1735
r5 17 18 3.14806 $w=1.3e-08 $l=1.35e-08 $layer=M1 $thickness=3.6e-08 $X=0.297
+ $Y=0.1215 $X2=0.297 $Y2=0.135
r6 16 17 1.16595 $w=1.3e-08 $l=5e-09 $layer=M1 $thickness=3.6e-08 $X=0.297
+ $Y=0.1165 $X2=0.297 $Y2=0.1215
r7 16 15 1.28254 $w=1.3e-08 $l=5.5e-09 $layer=M1 $thickness=3.6e-08 $X=0.297
+ $Y=0.1165 $X2=0.297 $Y2=0.111
r8 6 15 8.27824 $w=1.3e-08 $l=3.55e-08 $layer=M1 $thickness=3.6e-08 $X=0.297
+ $Y=0.0755 $X2=0.297 $Y2=0.111
r9 1 10 10.4265 $w=1.765e-08 $layer=LIG $thickness=5.2e-08 $X=0.297 $Y=0.135
+ $X2=0.297 $Y2=0.135
r10 1 18 19.3796 $a=3.24e-16 $layer=V0LIG $X=0.297 $Y=0.135 $X2=0.297 $Y2=0.135
r11 13 12 14.6259 $w=2.1e-08 $l=4.3e-08 $layer=Gate_1 $thickness=5.6e-08
+ $X=0.297 $Y=0.2025 $X2=0.297 $Y2=0.1595
r12 11 12 2.7211 $w=2.1e-08 $l=8e-09 $layer=Gate_1 $thickness=5.6e-08 $X=0.297
+ $Y=0.1515 $X2=0.297 $Y2=0.1595
r13 10 11 5.79936 $w=2.03333e-08 $l=1.65e-08 $layer=Gate_1 $thickness=5.6e-08
+ $X=0.297 $Y=0.135 $X2=0.297 $Y2=0.1515
r14 9 10 5.79936 $w=2.03333e-08 $l=1.65e-08 $layer=Gate_1 $thickness=5.6e-08
+ $X=0.297 $Y=0.1185 $X2=0.297 $Y2=0.135
r15 8 9 2.7211 $w=2.1e-08 $l=8e-09 $layer=Gate_1 $thickness=5.6e-08 $X=0.297
+ $Y=0.1105 $X2=0.297 $Y2=0.1185
r16 7 8 14.6259 $w=2.1e-08 $l=4.3e-08 $layer=Gate_1 $thickness=5.6e-08 $X=0.297
+ $Y=0.0675 $X2=0.297 $Y2=0.1105
r17 7 3 14.6259 $w=2.1e-08 $l=4.3e-08 $layer=Gate_1 $thickness=5.6e-08 $X=0.297
+ $Y=0.0675 $X2=0.297 $Y2=0.0245
.ends

* End of included file DLLx2_ASAP7_75t_R.pex.sp.pex

*
.subckt DLLx2_ASAP7_75t_CUSTOM_4_25_0_7 VSS VDD CLK D Q
*
* VSS VSS
* VDD VDD
* CLK CLK
* D D
* Q Q
*
*

M0 VSS N_M0_g N_M0_s VSS nmos_rvt L=2e-08 W=5.4e-08 nfin=2 $X=0.071 $Y=0.027
M1 N_M1_d N_M1_g VSS VSS nmos_rvt L=2e-08 W=5.4e-08 nfin=2 $X=0.125 $Y=0.027
M2 N_M2_d N_M2_g VSS VSS nmos_rvt L=2e-08 W=8.1e-08 nfin=3 $X=0.287 $Y=0.027
M3 N_M3_d N_M3_g N_M3_s VSS nmos_rvt L=2e-08 W=8.1e-08 nfin=3 $X=0.395 $Y=0.027
M4 N_M4_d N_M4_g N_M4_s VSS nmos_rvt L=2e-08 W=2.7e-08 nfin=1 $X=0.449 $Y=0.027
M5 VSS N_M5_g N_M5_s VSS nmos_rvt L=2e-08 W=2.7e-08 nfin=1 $X=0.503 $Y=0.027
M6 N_M6_d N_M6_g VSS VSS nmos_rvt L=2e-08 W=2.7e-08 nfin=1 $X=0.557 $Y=0.027
M7 VSS N_M7_g N_M7_s VSS nmos_rvt L=2e-08 W=8.1e-08 nfin=3 $X=0.719 $Y=0.027
M8 VSS N_M8_g N_M8_s VSS nmos_rvt L=2e-08 W=8.1e-08 nfin=3 $X=0.773 $Y=0.027
M9 VDD N_M9_g N_M9_s VDD pmos_rvt L=2e-08 W=5.4e-08 nfin=2 $X=0.071 $Y=0.189
M10 N_M10_d N_M10_g VDD VDD pmos_rvt L=2e-08 W=5.4e-08 nfin=2 $X=0.125 $Y=0.189
M11 N_M11_d N_M11_g VDD VDD pmos_rvt L=2e-08 W=8.1e-08 nfin=3 $X=0.287 $Y=0.162
M12 N_M12_d N_M12_g N_M12_s VDD pmos_rvt L=2e-08 W=8.1e-08 nfin=3 $X=0.341
+ $Y=0.162
M13 N_M13_d N_M13_g N_M13_s VDD pmos_rvt L=2e-08 W=2.7e-08 nfin=1 $X=0.395
+ $Y=0.216
M14 VDD N_M14_g N_M14_s VDD pmos_rvt L=2e-08 W=2.7e-08 nfin=1 $X=0.503 $Y=0.216
M15 N_M15_d N_M15_g VDD VDD pmos_rvt L=2e-08 W=2.7e-08 nfin=1 $X=0.557 $Y=0.216
M16 VDD N_M16_g N_M16_s VDD pmos_rvt L=2e-08 W=8.1e-08 nfin=3 $X=0.719 $Y=0.162
M17 VDD N_M17_g N_M17_s VDD pmos_rvt L=2e-08 W=8.1e-08 nfin=3 $X=0.773 $Y=0.162

* .include "DLLx2_ASAP7_75t_R.pex.sp.pxi"

* Start of included file DLLx2_ASAP7_75t_R.pex.sp.pxi
x_PM_DLLx2_ASAP7_75t_R%CLK vss CLK N_M0_g N_M9_g N_CLK_3 N_CLK_1 N_CLK_6
+ N_CLK_4 N_CLK_5 N_CLK_7 N_CLK_8 PM_DLLx2_ASAP7_75t_R%CLK
x_PM_DLLx2_ASAP7_75t_R%13 vss N_M11_d N_M12_s N_13_1 PM_DLLx2_ASAP7_75t_R%13
cc_1 N_13_1 N_D_3 0.0167014f $X=0.324 $Y=0.2025
cc_2 N_13_1 N_6_12 0.0169056f $X=0.324 $Y=0.2025
x_PM_DLLx2_ASAP7_75t_R%12 vss N_M4_d N_M5_s N_12_1 PM_DLLx2_ASAP7_75t_R%12
cc_3 N_12_1 N_6_13 0.00756621f $X=0.486 $Y=0.0405
cc_4 N_12_1 N_7_9 0.00765948f $X=0.486 $Y=0.0405
x_PM_DLLx2_ASAP7_75t_R%4 vss N_M1_g N_M10_g N_M3_g N_M13_g N_M0_s N_M9_s N_4_6
+ N_4_5 N_4_16 N_4_14 N_4_13 N_4_21 N_4_25 N_4_1 N_4_23 N_4_24 N_4_27 N_4_22
+ N_4_18 N_4_20 N_4_11 N_4_26 N_4_19 N_4_12 N_4_2 PM_DLLx2_ASAP7_75t_R%4
cc_5 N_4_6 N_CLK_3 0.0010252f $X=0.054 $Y=0.216
cc_6 N_4_5 N_CLK_3 0.0010409f $X=0.054 $Y=0.054
cc_7 N_4_16 N_CLK_3 0.000282533f $X=0.0165 $Y=0.153
cc_8 N_4_14 N_CLK_3 0.0110328f $X=0.056 $Y=0.216
cc_9 N_4_13 N_CLK_3 0.0110391f $X=0.056 $Y=0.054
cc_10 N_4_21 N_CLK_3 0.000437872f $X=0.018 $Y=0.1755
cc_11 N_4_25 N_CLK_3 0.000533805f $X=0.189 $Y=0.1485
cc_12 N_4_1 N_CLK_3 0.000554411f $X=0.134 $Y=0.135
cc_13 N_4_23 N_CLK_3 0.000630339f $X=0.036 $Y=0.234
cc_14 N_4_16 N_CLK_1 0.000829348f $X=0.0165 $Y=0.153
cc_15 N_4_16 N_CLK_6 0.00126908f $X=0.0165 $Y=0.153
cc_16 N_4_24 N_CLK_4 0.00159838f $X=0.1405 $Y=0.135
cc_17 N_4_27 N_CLK_5 0.00184733f $X=0.0215 $Y=0.153
cc_18 N_4_22 N_CLK_7 0.00186748f $X=0.036 $Y=0.036
cc_19 N_4_18 N_CLK_8 0.002238f $X=0.189 $Y=0.198
cc_20 N_4_20 N_CLK_4 0.00256104f $X=0.018 $Y=0.1305
cc_21 N_4_24 N_CLK_5 0.00262667f $X=0.1405 $Y=0.135
cc_22 N_4_1 N_CLK_1 0.00285772f $X=0.134 $Y=0.135
cc_23 N_4_16 N_CLK_5 0.00325815f $X=0.0165 $Y=0.153
cc_24 N_4_11 N_CLK_3 0.0360261f $X=0.135 $Y=0.0245
x_PM_DLLx2_ASAP7_75t_R%10 vss N_M2_d N_M3_s N_10_5 N_10_4 N_10_1
+ PM_DLLx2_ASAP7_75t_R%10
cc_25 N_10_5 N_4_2 0.00062405f $X=0.38 $Y=0.0675
cc_26 N_10_5 N_4_12 0.034334f $X=0.38 $Y=0.0675
cc_27 N_10_4 N_D_6 0.000684667f $X=0.3095 $Y=0.0675
cc_28 N_10_4 N_D_3 0.0354969f $X=0.3095 $Y=0.0675
cc_29 N_10_4 N_6_1 0.00184522f $X=0.3095 $Y=0.0675
cc_30 N_10_4 N_6_12 0.0727097f $X=0.3095 $Y=0.0675
cc_31 N_10_1 N_8_6 0.00123634f $X=0.351 $Y=0.0675
cc_32 N_10_1 N_8_15 0.000581949f $X=0.351 $Y=0.0675
cc_33 N_10_1 N_8_14 0.00252826f $X=0.351 $Y=0.0675
x_PM_DLLx2_ASAP7_75t_R%11 vss N_M13_d N_M14_s N_11_4 N_11_1 N_11_5
+ PM_DLLx2_ASAP7_75t_R%11
cc_34 N_11_4 N_4_12 0.0150965f $X=0.4175 $Y=0.2295
cc_35 N_11_1 N_6_2 0.00100705f $X=0.432 $Y=0.2295
cc_36 N_11_5 N_6_6 0.00107791f $X=0.488 $Y=0.2295
cc_37 N_11_1 N_6_13 0.00201936f $X=0.432 $Y=0.2295
cc_38 N_11_5 N_6_13 0.0069685f $X=0.488 $Y=0.2295
cc_39 N_11_4 N_6_13 0.0242755f $X=0.4175 $Y=0.2295
cc_40 N_11_5 N_7_9 0.0145096f $X=0.488 $Y=0.2295
cc_41 N_11_1 N_8_17 0.000292665f $X=0.432 $Y=0.2295
cc_42 N_11_1 N_8_21 0.000368997f $X=0.432 $Y=0.2295
cc_43 N_11_1 N_8_24 0.000385886f $X=0.432 $Y=0.2295
cc_44 N_11_4 N_8_5 0.000497356f $X=0.4175 $Y=0.2295
cc_45 N_11_1 N_8_20 0.00203547f $X=0.432 $Y=0.2295
x_PM_DLLx2_ASAP7_75t_R%6 vss N_M12_g N_M4_g N_M1_d N_M10_d N_6_19 N_6_4 N_6_5
+ N_6_18 N_6_16 N_6_14 N_6_20 N_6_21 N_6_2 N_6_23 N_6_1 N_6_15 N_6_12 N_6_13
+ N_6_17 N_6_6 N_6_22 PM_DLLx2_ASAP7_75t_R%6
cc_46 N_6_19 N_CLK_7 0.00123511f $X=0.216 $Y=0.234
cc_47 N_6_4 N_CLK_7 0.000442777f $X=0.162 $Y=0.054
cc_48 N_6_5 N_CLK_7 0.000214592f $X=0.162 $Y=0.216
cc_49 N_6_18 N_CLK_7 0.0021706f $X=0.216 $Y=0.036
cc_50 N_6_18 N_4_11 0.000230604f $X=0.216 $Y=0.036
cc_51 N_6_4 N_4_11 0.000921416f $X=0.162 $Y=0.054
cc_52 N_6_19 N_4_23 0.00012276f $X=0.216 $Y=0.234
cc_53 N_6_16 N_4_19 0.000136389f $X=0.243 $Y=0.036
cc_54 N_6_14 N_4_11 0.011029f $X=0.1475 $Y=0.054
cc_55 N_6_20 N_4_25 0.00145075f $X=0.243 $Y=0.153
cc_56 N_6_5 N_4_1 0.000430771f $X=0.162 $Y=0.216
cc_57 N_6_20 N_4_24 0.000442854f $X=0.243 $Y=0.153
cc_58 N_6_21 N_4_27 0.000509824f $X=0.351 $Y=0.116
cc_59 N_6_2 N_4_12 0.000547782f $X=0.459 $Y=0.179
cc_60 N_6_5 N_4_18 0.000564686f $X=0.162 $Y=0.216
cc_61 N_6_18 N_4_19 0.000596322f $X=0.216 $Y=0.036
cc_62 N_6_23 N_4_26 0.000657843f $X=0.2315 $Y=0.189
cc_63 N_6_20 N_4_27 0.00067201f $X=0.243 $Y=0.153
cc_64 N_6_1 N_4_2 0.00237846f $X=0.351 $Y=0.135
cc_65 N_6_15 N_4_1 0.000932299f $X=0.1475 $Y=0.216
cc_66 N_6_5 N_4_11 0.00111626f $X=0.162 $Y=0.216
cc_67 N_6_12 N_4_12 0.00160545f $X=0.351 $Y=0.073
cc_68 N_6_20 N_4_19 0.0037112f $X=0.243 $Y=0.153
cc_69 N_6_21 N_4_26 0.0043763f $X=0.351 $Y=0.116
cc_70 N_6_19 N_4_18 0.00511351f $X=0.216 $Y=0.234
cc_71 N_6_13 N_4_12 0.00851792f $X=0.459 $Y=0.179
cc_72 N_6_23 N_4_27 0.0171253f $X=0.2315 $Y=0.189
cc_73 N_6_15 N_4_11 0.0390853f $X=0.1475 $Y=0.216
cc_74 N_6_23 N_D_6 0.000880599f $X=0.2315 $Y=0.189
cc_75 N_6_16 N_D_4 0.0010363f $X=0.243 $Y=0.036
cc_76 N_6_17 N_D_5 0.00109665f $X=0.243 $Y=0.234
cc_77 N_6_1 N_D_1 0.00258063f $X=0.351 $Y=0.135
cc_78 N_6_20 N_D_6 0.00310016f $X=0.243 $Y=0.153
cc_79 N_6_12 N_D_3 0.00494026f $X=0.351 $Y=0.073
cc_80 N_6_21 N_D_6 0.00838673f $X=0.351 $Y=0.116
x_PM_DLLx2_ASAP7_75t_R%7 vss N_M5_g N_M14_g N_M6_d N_M15_d N_7_9 N_7_11 N_7_1
+ N_7_13 N_7_4 N_7_17 N_7_3 N_7_16 N_7_12 N_7_10 N_7_15 N_7_14
+ PM_DLLx2_ASAP7_75t_R%7
cc_81 N_7_9 N_6_2 0.000171714f $X=0.513 $Y=0.0245
cc_82 N_7_9 N_6_23 0.000206082f $X=0.513 $Y=0.0245
cc_83 N_7_9 N_6_6 0.0051136f $X=0.513 $Y=0.0245
cc_84 N_7_9 N_6_22 0.000315459f $X=0.513 $Y=0.0245
cc_85 N_7_11 N_6_6 0.000374458f $X=0.5795 $Y=0.2295
cc_86 N_7_1 N_6_13 0.000446633f $X=0.513 $Y=0.082
cc_87 N_7_13 N_6_6 0.000518277f $X=0.621 $Y=0.234
cc_88 N_7_4 N_6_6 0.000781246f $X=0.594 $Y=0.2295
cc_89 N_7_17 N_6_6 0.00143022f $X=0.621 $Y=0.0675
cc_90 N_7_9 N_6_13 0.0138145f $X=0.513 $Y=0.0245
x_PM_DLLx2_ASAP7_75t_R%Q vss Q N_M7_s N_M8_s N_M17_s N_M16_s N_Q_2 N_Q_16 N_Q_4
+ N_Q_3 N_Q_1 N_Q_19 N_Q_20 N_Q_14 N_Q_15 N_Q_21 N_Q_13 PM_DLLx2_ASAP7_75t_R%Q
cc_91 N_Q_2 N_7_14 0.000620151f $X=0.702 $Y=0.2295
cc_92 N_Q_2 N_7_17 0.00351409f $X=0.702 $Y=0.2295
cc_93 N_Q_16 N_8_26 0.000660738f $X=0.7955 $Y=0.2025
cc_94 N_Q_16 N_8_12 0.0010997f $X=0.7955 $Y=0.2025
cc_95 N_Q_16 N_8_2 0.00513306f $X=0.7955 $Y=0.2025
cc_96 N_Q_4 N_8_13 0.00111033f $X=0.81 $Y=0.2025
cc_97 N_Q_3 N_8_13 0.00114316f $X=0.81 $Y=0.0675
cc_98 N_Q_1 N_8_12 0.00117673f $X=0.702 $Y=0.0405
cc_99 N_Q_2 N_8_12 0.00118833f $X=0.702 $Y=0.2295
cc_100 N_Q_19 N_8_26 0.00124231f $X=0.6905 $Y=0.036
cc_101 N_Q_20 N_8_26 0.00130141f $X=0.7965 $Y=0.234
cc_102 N_Q_20 N_8_27 0.00204363f $X=0.7965 $Y=0.234
cc_103 N_Q_14 N_8_13 0.0148954f $X=0.7955 $Y=0.0675
cc_104 N_Q_15 N_8_12 0.0149645f $X=0.704 $Y=0.2025
cc_105 N_Q_21 N_8_26 0.00609317f $X=0.838 $Y=0.0675
cc_106 N_Q_13 N_8_12 0.0531504f $X=0.704 $Y=0.0675
cc_107 N_Q_16 N_8_13 0.0544237f $X=0.7955 $Y=0.2025
x_PM_DLLx2_ASAP7_75t_R%8 vss N_M6_g N_M15_g N_M3_d N_M4_s N_M8_g N_M17_g N_M7_g
+ N_M16_g N_M12_d N_M13_s N_8_25 N_8_5 N_8_22 N_8_17 N_8_19 N_8_27 N_8_23
+ N_8_21 N_8_24 N_8_6 N_8_14 N_8_16 N_8_15 N_8_20 N_8_1 N_8_11 N_8_2 N_8_18
+ N_8_26 N_8_12 N_8_13 PM_DLLx2_ASAP7_75t_R%8
cc_108 N_8_25 N_4_12 0.000154755f $X=0.5395 $Y=0.131
cc_109 N_8_5 N_4_26 0.000166699f $X=0.378 $Y=0.2295
cc_110 N_8_22 N_4_26 0.000278852f $X=0.432 $Y=0.036
cc_111 N_8_17 N_4_12 0.00556731f $X=0.3635 $Y=0.189
cc_112 N_8_19 N_4_26 0.000461951f $X=0.459 $Y=0.131
cc_113 N_8_27 N_4_27 0.000659097f $X=0.459 $Y=0.153
cc_114 N_8_23 N_4_26 0.000733838f $X=0.459 $Y=0.114
cc_115 N_8_5 N_4_2 0.000759675f $X=0.378 $Y=0.2295
cc_116 N_8_21 N_4_27 0.000822717f $X=0.432 $Y=0.234
cc_117 N_8_24 N_4_26 0.00527203f $X=0.459 $Y=0.142
cc_118 N_8_21 N_4_26 0.000939972f $X=0.432 $Y=0.234
cc_119 N_8_6 N_4_12 0.00103362f $X=0.432 $Y=0.0405
cc_120 N_8_5 N_4_12 0.00123216f $X=0.378 $Y=0.2295
cc_121 N_8_14 N_4_2 0.00165255f $X=0.4175 $Y=0.0405
cc_122 N_8_14 N_4_12 0.009616f $X=0.4175 $Y=0.0405
cc_123 N_8_16 N_4_12 0.0108384f $X=0.3635 $Y=0.2295
cc_124 N_8_15 N_4_12 0.0454817f $X=0.4175 $Y=0.081
cc_125 N_8_5 N_D_5 0.000821884f $X=0.378 $Y=0.2295
cc_126 N_8_21 N_D_5 0.00128191f $X=0.432 $Y=0.234
cc_127 N_8_14 N_6_22 0.000153597f $X=0.4175 $Y=0.0405
cc_128 N_8_21 N_6_21 0.00144671f $X=0.432 $Y=0.234
cc_129 N_8_17 N_6_12 0.02446f $X=0.3635 $Y=0.189
cc_130 N_8_5 N_6_21 0.00151444f $X=0.378 $Y=0.2295
cc_131 N_8_5 N_6_1 0.000280336f $X=0.378 $Y=0.2295
cc_132 N_8_23 N_6_22 0.000320907f $X=0.459 $Y=0.114
cc_133 N_8_20 N_6_22 0.00042481f $X=0.459 $Y=0.234
cc_134 N_8_15 N_6_13 0.00558805f $X=0.4175 $Y=0.081
cc_135 N_8_1 N_6_6 0.00171457f $X=0.567 $Y=0.131
cc_136 N_8_24 N_6_23 0.000589203f $X=0.459 $Y=0.142
cc_137 N_8_25 N_6_6 0.000641913f $X=0.5395 $Y=0.131
cc_138 N_8_6 N_6_13 0.000645309f $X=0.432 $Y=0.0405
cc_139 N_8_16 N_6_1 0.000754747f $X=0.3635 $Y=0.2295
cc_140 N_8_27 N_6_22 0.000919733f $X=0.459 $Y=0.153
cc_141 N_8_24 N_6_2 0.00101556f $X=0.459 $Y=0.142
cc_142 N_8_5 N_6_12 0.00162985f $X=0.378 $Y=0.2295
cc_143 N_8_24 N_6_22 0.002461f $X=0.459 $Y=0.142
cc_144 N_8_25 N_6_22 0.00359765f $X=0.5395 $Y=0.131
cc_145 N_8_27 N_6_23 0.00400783f $X=0.459 $Y=0.153
cc_146 N_8_21 N_6_23 0.00502249f $X=0.432 $Y=0.234
cc_147 N_8_11 N_6_6 0.006258f $X=0.567 $Y=0.0245
cc_148 N_8_16 N_6_12 0.00991118f $X=0.3635 $Y=0.2295
cc_149 N_8_14 N_6_13 0.0319567f $X=0.4175 $Y=0.0405
cc_150 N_8_2 N_7_9 0.000119686f $X=0.7735 $Y=0.136
cc_151 N_8_25 N_7_9 0.000140826f $X=0.5395 $Y=0.131
cc_152 N_8_6 N_7_1 0.000394068f $X=0.432 $Y=0.0405
cc_153 N_8_27 N_7_13 0.000418824f $X=0.459 $Y=0.153
cc_154 N_8_11 N_7_3 0.00042045f $X=0.567 $Y=0.0245
cc_155 N_8_25 N_7_16 0.000636418f $X=0.5395 $Y=0.131
cc_156 N_8_1 N_7_17 0.000735648f $X=0.567 $Y=0.131
cc_157 N_8_18 N_7_12 0.000861116f $X=0.459 $Y=0.036
cc_158 N_8_1 N_7_9 0.000935323f $X=0.567 $Y=0.131
cc_159 N_8_25 N_7_1 0.000938115f $X=0.5395 $Y=0.131
cc_160 N_8_11 N_7_1 0.000988172f $X=0.567 $Y=0.0245
cc_161 N_8_11 N_7_11 0.00639279f $X=0.567 $Y=0.0245
cc_162 N_8_11 N_7_10 0.0065666f $X=0.567 $Y=0.0245
cc_163 N_8_27 N_7_17 0.00261997f $X=0.459 $Y=0.153
cc_164 N_8_25 N_7_15 0.00273434f $X=0.5395 $Y=0.131
cc_165 N_8_23 N_7_15 0.00344007f $X=0.459 $Y=0.114
cc_166 N_8_25 N_7_17 0.00358939f $X=0.5395 $Y=0.131
cc_167 N_8_11 N_7_9 0.0306982f $X=0.567 $Y=0.0245
x_PM_DLLx2_ASAP7_75t_R%D vss D N_M2_g N_M11_g N_D_6 N_D_4 N_D_5 N_D_1 N_D_3
+ PM_DLLx2_ASAP7_75t_R%D
cc_168 N_D_6 N_4_26 0.000182948f $X=0.297 $Y=0.0755
cc_169 N_D_6 N_4_27 0.00293754f $X=0.297 $Y=0.0755

* End of included file DLLx2_ASAP7_75t_R.pex.sp.pxi
.ends

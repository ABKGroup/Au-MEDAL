.subckt PM_OAI211xp5_ASAP7_75t_R%B vss 13 5 9 4 3
c1 1 vss 0.00566373f $X=0.189 $Y=0.135
c2 3 vss 0.0947311f $X=0.189 $Y=0.0245
c3 4 vss 0.0033696f $X=0.189 $Y=0.116
r1 13 12 0.524677 $w=1.3e-08 $l=2.3e-09 $layer=M1 $thickness=3.6e-08 $X=0.188
+ $Y=0.148 $X2=0.189 $Y2=0.1457
r2 11 12 2.50679 $w=1.3e-08 $l=1.07e-08 $layer=M1 $thickness=3.6e-08 $X=0.189
+ $Y=0.135 $X2=0.189 $Y2=0.1457
r3 4 11 4.4306 $w=1.3e-08 $l=1.9e-08 $layer=M1 $thickness=3.6e-08 $X=0.189
+ $Y=0.116 $X2=0.189 $Y2=0.135
r4 1 7 10.4265 $w=1.765e-08 $layer=LIG $thickness=5.2e-08 $X=0.189 $Y=0.135
+ $X2=0.189 $Y2=0.135
r5 1 11 19.3796 $a=3.24e-16 $layer=V0LIG $X=0.189 $Y=0.135 $X2=0.189 $Y2=0.135
r6 9 8 16.4967 $w=2.1e-08 $l=4.85e-08 $layer=Gate_1 $thickness=5.6e-08 $X=0.189
+ $Y=0.216 $X2=0.189 $Y2=0.1675
r7 7 8 11.2416 $w=2.06615e-08 $l=3.25e-08 $layer=Gate_1 $thickness=5.6e-08
+ $X=0.189 $Y=0.135 $X2=0.189 $Y2=0.1675
r8 6 7 6.6497 $w=2.04211e-08 $l=1.9e-08 $layer=Gate_1 $thickness=5.6e-08
+ $X=0.189 $Y=0.116 $X2=0.189 $Y2=0.135
r9 5 6 16.4967 $w=2.1e-08 $l=4.85e-08 $layer=Gate_1 $thickness=5.6e-08 $X=0.189
+ $Y=0.0675 $X2=0.189 $Y2=0.116
r10 5 3 14.6259 $w=2.1e-08 $l=4.3e-08 $layer=Gate_1 $thickness=5.6e-08 $X=0.189
+ $Y=0.0675 $X2=0.189 $Y2=0.0245
.ends

.subckt PM_OAI211xp5_ASAP7_75t_R%C vss 13 5 11 4 3
c1 1 vss 0.00414166f $X=0.243 $Y=0.135
c2 3 vss 0.0993228f $X=0.243 $Y=0.0245
c3 4 vss 0.00548343f $X=0.243 $Y=0.1142
r1 14 15 2.39019 $w=1.3e-08 $l=1.03e-08 $layer=M1 $thickness=3.6e-08 $X=0.243
+ $Y=0.1247 $X2=0.243 $Y2=0.135
r2 13 14 0.408082 $w=1.3e-08 $l=1.7e-09 $layer=M1 $thickness=3.6e-08 $X=0.241
+ $Y=0.123 $X2=0.243 $Y2=0.1247
r3 13 4 2.04041 $w=1.3e-08 $l=8.8e-09 $layer=M1 $thickness=3.6e-08 $X=0.241
+ $Y=0.123 $X2=0.243 $Y2=0.1142
r4 1 8 10.4265 $w=1.765e-08 $layer=LIG $thickness=5.2e-08 $X=0.243 $Y=0.135
+ $X2=0.243 $Y2=0.135
r5 1 15 19.3796 $a=3.24e-16 $layer=V0LIG $X=0.243 $Y=0.135 $X2=0.243 $Y2=0.135
r6 11 10 14.6259 $w=2.1e-08 $l=4.3e-08 $layer=Gate_1 $thickness=5.6e-08
+ $X=0.243 $Y=0.216 $X2=0.243 $Y2=0.173
r7 9 10 7.31297 $w=2.1e-08 $l=2.15e-08 $layer=Gate_1 $thickness=5.6e-08
+ $X=0.243 $Y=0.1515 $X2=0.243 $Y2=0.173
r8 8 9 5.79936 $w=2.03333e-08 $l=1.65e-08 $layer=Gate_1 $thickness=5.6e-08
+ $X=0.243 $Y=0.135 $X2=0.243 $Y2=0.1515
r9 7 8 5.79936 $w=2.03333e-08 $l=1.65e-08 $layer=Gate_1 $thickness=5.6e-08
+ $X=0.243 $Y=0.1185 $X2=0.243 $Y2=0.135
r10 6 7 2.7211 $w=2.1e-08 $l=8e-09 $layer=Gate_1 $thickness=5.6e-08 $X=0.243
+ $Y=0.1105 $X2=0.243 $Y2=0.1185
r11 5 6 14.6259 $w=2.1e-08 $l=4.3e-08 $layer=Gate_1 $thickness=5.6e-08 $X=0.243
+ $Y=0.0675 $X2=0.243 $Y2=0.1105
r12 5 3 14.6259 $w=2.1e-08 $l=4.3e-08 $layer=Gate_1 $thickness=5.6e-08 $X=0.243
+ $Y=0.0675 $X2=0.243 $Y2=0.0245
.ends

.subckt PM_OAI211xp5_ASAP7_75t_R%Y vss 31 20 21 48 49 51 2 15 10 1 16 11 3 12 17
c1 1 vss 0.00636168f $X=0.054 $Y=0.216
c2 2 vss 0.00980012f $X=0.108 $Y=0.0675
c3 3 vss 0.00719137f $X=0.216 $Y=0.216
c4 10 vss 0.00455565f $X=0.0935 $Y=0.0675
c5 11 vss 0.0272315f $X=0.056 $Y=0.216
c6 12 vss 0.00359529f $X=0.2015 $Y=0.216
c7 13 vss 0.00192517f $X=0.297 $Y=0.072
c8 14 vss 0.00299933f $X=0.297 $Y=0.234
c9 15 vss 0.0218723f $X=0.27 $Y=0.234
c10 16 vss 0.0137956f $X=0.108 $Y=0.072
c11 17 vss 0.00576235f $X=0.297 $Y=0.0935
r1 51 50 0.0462963 $w=5.4e-08 $l=2.5e-09 $layer=P_src_drn $thickness=1e-09
+ $X=0.0713 $Y=0.216 $X2=0.0685 $Y2=0.216
r2 11 50 0.231482 $w=5.4e-08 $l=1.25e-08 $layer=P_src_drn $thickness=1e-09
+ $X=0.056 $Y=0.216 $X2=0.0685 $Y2=0.216
r3 49 47 0.0462963 $w=5.4e-08 $l=2.5e-09 $layer=P_src_drn $thickness=1e-09
+ $X=0.2333 $Y=0.216 $X2=0.2305 $Y2=0.216
r4 3 47 0.268519 $w=5.4e-08 $l=1.45e-08 $layer=P_src_drn $thickness=1e-09
+ $X=0.216 $Y=0.216 $X2=0.2305 $Y2=0.216
r5 12 3 0.268519 $w=5.4e-08 $l=1.45e-08 $layer=P_src_drn $thickness=1e-09
+ $X=0.2015 $Y=0.216 $X2=0.216 $Y2=0.216
r6 48 12 0.0462963 $w=5.4e-08 $l=2.5e-09 $layer=P_src_drn $thickness=1e-09
+ $X=0.1986 $Y=0.216 $X2=0.2015 $Y2=0.216
r7 1 44 19.3796 $a=3.24e-16 $layer=V0LISD $X=0.054 $Y=0.216 $X2=0.054 $Y2=0.234
r8 3 36 19.3796 $a=3.24e-16 $layer=V0LISD $X=0.216 $Y=0.216 $X2=0.216 $Y2=0.234
r9 44 45 5.24677 $w=1.3e-08 $l=2.25e-08 $layer=M1 $thickness=3.6e-08 $X=0.054
+ $Y=0.234 $X2=0.0765 $Y2=0.234
r10 42 45 4.19742 $w=1.3e-08 $l=1.8e-08 $layer=M1 $thickness=3.6e-08 $X=0.0945
+ $Y=0.234 $X2=0.0765 $Y2=0.234
r11 41 42 4.19742 $w=1.3e-08 $l=1.8e-08 $layer=M1 $thickness=3.6e-08 $X=0.1125
+ $Y=0.234 $X2=0.0945 $Y2=0.234
r12 40 41 5.24677 $w=1.3e-08 $l=2.25e-08 $layer=M1 $thickness=3.6e-08 $X=0.135
+ $Y=0.234 $X2=0.1125 $Y2=0.234
r13 39 40 6.29612 $w=1.3e-08 $l=2.7e-08 $layer=M1 $thickness=3.6e-08 $X=0.162
+ $Y=0.234 $X2=0.135 $Y2=0.234
r14 38 39 6.29612 $w=1.3e-08 $l=2.7e-08 $layer=M1 $thickness=3.6e-08 $X=0.189
+ $Y=0.234 $X2=0.162 $Y2=0.234
r15 36 37 3.14806 $w=1.3e-08 $l=1.35e-08 $layer=M1 $thickness=3.6e-08 $X=0.216
+ $Y=0.234 $X2=0.2295 $Y2=0.234
r16 35 36 3.14806 $w=1.3e-08 $l=1.35e-08 $layer=M1 $thickness=3.6e-08 $X=0.2025
+ $Y=0.234 $X2=0.216 $Y2=0.234
r17 35 38 3.14806 $w=1.3e-08 $l=1.35e-08 $layer=M1 $thickness=3.6e-08 $X=0.2025
+ $Y=0.234 $X2=0.189 $Y2=0.234
r18 34 37 3.14806 $w=1.3e-08 $l=1.35e-08 $layer=M1 $thickness=3.6e-08 $X=0.243
+ $Y=0.234 $X2=0.2295 $Y2=0.234
r19 15 34 6.29612 $w=1.3e-08 $l=2.7e-08 $layer=M1 $thickness=3.6e-08 $X=0.27
+ $Y=0.234 $X2=0.243 $Y2=0.234
r20 14 33 3.36447 $w=1.71023e-08 $l=2.15e-08 $layer=M1 $thickness=3.6e-08
+ $X=0.297 $Y=0.234 $X2=0.297 $Y2=0.2125
r21 14 15 4.64701 $w=1.46667e-08 $l=2.7e-08 $layer=M1 $thickness=3.6e-08
+ $X=0.297 $Y=0.234 $X2=0.27 $Y2=0.234
r22 32 33 6.12123 $w=1.3e-08 $l=2.63e-08 $layer=M1 $thickness=3.6e-08 $X=0.297
+ $Y=0.1862 $X2=0.297 $Y2=0.2125
r23 31 32 3.32295 $w=1.3e-08 $l=1.42e-08 $layer=M1 $thickness=3.6e-08 $X=0.299
+ $Y=0.172 $X2=0.297 $Y2=0.1862
r24 31 30 7.75356 $w=1.3e-08 $l=3.33e-08 $layer=M1 $thickness=3.6e-08 $X=0.299
+ $Y=0.172 $X2=0.297 $Y2=0.1387
r25 17 30 10.5518 $w=1.3e-08 $l=4.52e-08 $layer=M1 $thickness=3.6e-08 $X=0.297
+ $Y=0.0935 $X2=0.297 $Y2=0.1387
r26 13 29 4.64701 $w=1.46667e-08 $l=2.7e-08 $layer=M1 $thickness=3.6e-08
+ $X=0.297 $Y=0.072 $X2=0.27 $Y2=0.072
r27 13 17 3.36447 $w=1.71023e-08 $l=2.15e-08 $layer=M1 $thickness=3.6e-08
+ $X=0.297 $Y=0.072 $X2=0.297 $Y2=0.0935
r28 28 29 6.29612 $w=1.3e-08 $l=2.7e-08 $layer=M1 $thickness=3.6e-08 $X=0.243
+ $Y=0.072 $X2=0.27 $Y2=0.072
r29 27 28 6.29612 $w=1.3e-08 $l=2.7e-08 $layer=M1 $thickness=3.6e-08 $X=0.216
+ $Y=0.072 $X2=0.243 $Y2=0.072
r30 26 27 6.29612 $w=1.3e-08 $l=2.7e-08 $layer=M1 $thickness=3.6e-08 $X=0.189
+ $Y=0.072 $X2=0.216 $Y2=0.072
r31 25 26 2.56509 $w=1.3e-08 $l=1.1e-08 $layer=M1 $thickness=3.6e-08 $X=0.178
+ $Y=0.072 $X2=0.189 $Y2=0.072
r32 24 25 4.19742 $w=1.3e-08 $l=1.8e-08 $layer=M1 $thickness=3.6e-08 $X=0.16
+ $Y=0.072 $X2=0.178 $Y2=0.072
r33 23 24 5.82974 $w=1.3e-08 $l=2.5e-08 $layer=M1 $thickness=3.6e-08 $X=0.135
+ $Y=0.072 $X2=0.16 $Y2=0.072
r34 22 23 3.14806 $w=1.3e-08 $l=1.35e-08 $layer=M1 $thickness=3.6e-08 $X=0.1215
+ $Y=0.072 $X2=0.135 $Y2=0.072
r35 16 22 3.14806 $w=1.3e-08 $l=1.35e-08 $layer=M1 $thickness=3.6e-08 $X=0.108
+ $Y=0.072 $X2=0.1215 $Y2=0.072
r36 2 16 19.3796 $a=3.24e-16 $layer=V0LISD $X=0.108 $Y=0.0675 $X2=0.108
+ $Y2=0.072
r37 21 19 0.0308642 $w=8.1e-08 $l=2.5e-09 $layer=N_src_drn $thickness=1e-09
+ $X=0.1253 $Y=0.0675 $X2=0.1225 $Y2=0.0675
r38 2 19 0.179012 $w=8.1e-08 $l=1.45e-08 $layer=N_src_drn $thickness=1e-09
+ $X=0.108 $Y=0.0675 $X2=0.1225 $Y2=0.0675
r39 10 2 0.179012 $w=8.1e-08 $l=1.45e-08 $layer=N_src_drn $thickness=1e-09
+ $X=0.0935 $Y=0.0675 $X2=0.108 $Y2=0.0675
r40 20 10 0.0308642 $w=8.1e-08 $l=2.5e-09 $layer=N_src_drn $thickness=1e-09
+ $X=0.0906 $Y=0.0675 $X2=0.0935 $Y2=0.0675
r41 1 11 1e-05 $l=2e-09 $X=0.054 $Y=0.216 $X2=0.056 $Y2=0.216
.ends

.subckt PM_OAI211xp5_ASAP7_75t_R%A1 vss 13 5 9 4 3 1
c1 1 vss 0.00604212f $X=0.135 $Y=0.135
c2 3 vss 0.0890051f $X=0.135 $Y=0.0245
c3 4 vss 0.0038302f $X=0.135 $Y=0.135
r1 13 12 5.07188 $w=1.3e-08 $l=2.18e-08 $layer=M1 $thickness=3.6e-08 $X=0.134
+ $Y=0.187 $X2=0.135 $Y2=0.1652
r2 4 12 7.05399 $w=1.3e-08 $l=3.02e-08 $layer=M1 $thickness=3.6e-08 $X=0.135
+ $Y=0.135 $X2=0.135 $Y2=0.1652
r3 1 7 10.4265 $w=1.765e-08 $layer=LIG $thickness=5.2e-08 $X=0.135 $Y=0.135
+ $X2=0.135 $Y2=0.135
r4 1 4 19.3796 $a=3.24e-16 $layer=V0LIG $X=0.135 $Y=0.135 $X2=0.135 $Y2=0.135
r5 9 8 16.4967 $w=2.1e-08 $l=4.85e-08 $layer=Gate_1 $thickness=5.6e-08 $X=0.135
+ $Y=0.216 $X2=0.135 $Y2=0.1675
r6 7 8 11.2416 $w=2.06615e-08 $l=3.25e-08 $layer=Gate_1 $thickness=5.6e-08
+ $X=0.135 $Y=0.135 $X2=0.135 $Y2=0.1675
r7 6 7 6.6497 $w=2.04211e-08 $l=1.9e-08 $layer=Gate_1 $thickness=5.6e-08
+ $X=0.135 $Y=0.116 $X2=0.135 $Y2=0.135
r8 5 6 16.4967 $w=2.1e-08 $l=4.85e-08 $layer=Gate_1 $thickness=5.6e-08 $X=0.135
+ $Y=0.0675 $X2=0.135 $Y2=0.116
r9 5 3 14.6259 $w=2.1e-08 $l=4.3e-08 $layer=Gate_1 $thickness=5.6e-08 $X=0.135
+ $Y=0.0675 $X2=0.135 $Y2=0.0245
.ends

.subckt PM_OAI211xp5_ASAP7_75t_R%A2 vss 19 8 14 7 3 1 6
c1 1 vss 0.00336818f $X=0.081 $Y=0.135
c2 3 vss 0.0676052f $X=0.081 $Y=0.0245
c3 4 vss 0.00157729f $X=0.027 $Y=0.135
c4 5 vss 0.00866093f $X=0.027 $Y=0.116
c5 6 vss 0.00598038f $X=0.027 $Y=0.172
c6 7 vss 0.00284096f $X=0.056 $Y=0.135
r1 19 20 2.73998 $w=1.3e-08 $l=1.17e-08 $layer=M1 $thickness=3.6e-08 $X=0.023
+ $Y=0.083 $X2=0.027 $Y2=0.0947
r2 5 20 4.95528 $w=1.3e-08 $l=2.13e-08 $layer=M1 $thickness=3.6e-08 $X=0.027
+ $Y=0.116 $X2=0.027 $Y2=0.0947
r3 4 17 1.38478 $w=1.70909e-08 $l=1.1e-08 $layer=M1 $thickness=3.6e-08 $X=0.027
+ $Y=0.135 $X2=0.038 $Y2=0.135
r4 4 5 3.2503 $w=1.53684e-08 $l=1.9e-08 $layer=M1 $thickness=3.6e-08 $X=0.027
+ $Y=0.135 $X2=0.027 $Y2=0.116
r5 4 6 7.44771 $w=1.42162e-08 $l=3.7e-08 $layer=M1 $thickness=3.6e-08 $X=0.027
+ $Y=0.135 $X2=0.027 $Y2=0.172
r6 7 16 5.82974 $w=1.3e-08 $l=2.5e-08 $layer=M1 $thickness=3.6e-08 $X=0.056
+ $Y=0.135 $X2=0.081 $Y2=0.135
r7 7 17 4.19742 $w=1.3e-08 $l=1.8e-08 $layer=M1 $thickness=3.6e-08 $X=0.056
+ $Y=0.135 $X2=0.038 $Y2=0.135
r8 1 11 10.4265 $w=1.765e-08 $layer=LIG $thickness=5.2e-08 $X=0.081 $Y=0.135
+ $X2=0.081 $Y2=0.135
r9 1 16 19.3796 $a=3.24e-16 $layer=V0LIG $X=0.081 $Y=0.135 $X2=0.081 $Y2=0.135
r10 14 13 14.6259 $w=2.1e-08 $l=4.3e-08 $layer=Gate_1 $thickness=5.6e-08
+ $X=0.081 $Y=0.216 $X2=0.081 $Y2=0.173
r11 12 13 7.31297 $w=2.1e-08 $l=2.15e-08 $layer=Gate_1 $thickness=5.6e-08
+ $X=0.081 $Y=0.1515 $X2=0.081 $Y2=0.173
r12 11 12 5.79936 $w=2.03333e-08 $l=1.65e-08 $layer=Gate_1 $thickness=5.6e-08
+ $X=0.081 $Y=0.135 $X2=0.081 $Y2=0.1515
r13 10 11 5.79936 $w=2.03333e-08 $l=1.65e-08 $layer=Gate_1 $thickness=5.6e-08
+ $X=0.081 $Y=0.1185 $X2=0.081 $Y2=0.135
r14 9 10 2.7211 $w=2.1e-08 $l=8e-09 $layer=Gate_1 $thickness=5.6e-08 $X=0.081
+ $Y=0.1105 $X2=0.081 $Y2=0.1185
r15 8 9 14.6259 $w=2.1e-08 $l=4.3e-08 $layer=Gate_1 $thickness=5.6e-08 $X=0.081
+ $Y=0.0675 $X2=0.081 $Y2=0.1105
r16 8 3 14.6259 $w=2.1e-08 $l=4.3e-08 $layer=Gate_1 $thickness=5.6e-08 $X=0.081
+ $Y=0.0675 $X2=0.081 $Y2=0.0245
.ends

* End of included file OAI211xp5_ASAP7_75t_R.pex.sp.pex

*
.subckt OAI211xp5_ASAP7_75t_CUSTOM_4_25_0_7 VSS VDD A2 A1 B C Y
*
* VSS VSS
* VDD VDD
* A2 A2
* A1 A1
* B B
* C C
* Y Y
*
*

M0 N_M0_d N_M0_g noxref_7 VSS nmos_rvt L=2e-08 W=8.1e-08 nfin=3 $X=0.071
+ $Y=0.027
M1 noxref_7 N_M1_g N_M1_s VSS nmos_rvt L=2e-08 W=8.1e-08 nfin=3 $X=0.125
+ $Y=0.027
M2 noxref_9 N_M2_g noxref_7 VSS nmos_rvt L=2e-08 W=8.1e-08 nfin=3 $X=0.179
+ $Y=0.027
M3 VSS N_M3_g noxref_9 VSS nmos_rvt L=2e-08 W=8.1e-08 nfin=3 $X=0.233 $Y=0.027
M4 noxref_10 N_M4_g N_M4_s VDD pmos_rvt L=2e-08 W=5.4e-08 nfin=2 $X=0.071
+ $Y=0.189
M5 VDD N_M5_g noxref_10 VDD pmos_rvt L=2e-08 W=5.4e-08 nfin=2 $X=0.125 $Y=0.189
M6 N_M6_d N_M6_g VDD VDD pmos_rvt L=2e-08 W=5.4e-08 nfin=2 $X=0.179 $Y=0.189
M7 VDD N_M7_g N_M7_s VDD pmos_rvt L=2e-08 W=5.4e-08 nfin=2 $X=0.233 $Y=0.189

* .include "OAI211xp5_ASAP7_75t_R.pex.sp.pxi"

* Start of included file OAI211xp5_ASAP7_75t_R.pex.sp.pxi
x_PM_OAI211xp5_ASAP7_75t_R%B vss B N_M2_g N_M6_g N_B_4 N_B_3
+ PM_OAI211xp5_ASAP7_75t_R%B
cc_1 N_B_4 N_A1_4 0.00331719f $X=0.189 $Y=0.116
cc_2 N_B_3 N_A1_3 0.00714584f $X=0.189 $Y=0.0245
x_PM_OAI211xp5_ASAP7_75t_R%C vss C N_M3_g N_M7_g N_C_4 N_C_3
+ PM_OAI211xp5_ASAP7_75t_R%C
cc_3 N_C_4 N_B_4 0.0033087f $X=0.243 $Y=0.1142
cc_4 N_C_3 N_B_3 0.0091415f $X=0.243 $Y=0.0245
x_PM_OAI211xp5_ASAP7_75t_R%Y vss Y N_M0_d N_M1_s N_M6_d N_M7_s N_M4_s N_Y_2
+ N_Y_15 N_Y_10 N_Y_1 N_Y_16 N_Y_11 N_Y_3 N_Y_12 N_Y_17
+ PM_OAI211xp5_ASAP7_75t_R%Y
cc_5 N_Y_2 N_A2_3 0.000804566f $X=0.108 $Y=0.0675
cc_6 N_Y_15 N_A2_7 0.000977091f $X=0.27 $Y=0.234
cc_7 N_Y_10 N_A2_1 0.00109737f $X=0.0935 $Y=0.0675
cc_8 N_Y_1 N_A2_3 0.00111543f $X=0.054 $Y=0.216
cc_9 N_Y_16 N_A2_7 0.00111613f $X=0.108 $Y=0.072
cc_10 N_Y_15 N_A2_6 0.00130325f $X=0.27 $Y=0.234
cc_11 N_Y_11 N_A2_3 0.010763f $X=0.056 $Y=0.216
cc_12 N_Y_10 N_A2_3 0.0508547f $X=0.0935 $Y=0.0675
cc_13 N_Y_10 N_A1_1 0.000863978f $X=0.0935 $Y=0.0675
cc_14 N_Y_16 N_A1_4 0.0010961f $X=0.108 $Y=0.072
cc_15 N_Y_15 N_A1_4 0.00136584f $X=0.27 $Y=0.234
cc_16 N_Y_2 N_A1_4 0.00286123f $X=0.108 $Y=0.0675
cc_17 N_Y_10 N_A1_3 0.0364623f $X=0.0935 $Y=0.0675
cc_18 N_Y_15 N_B_4 0.00108437f $X=0.27 $Y=0.234
cc_19 N_Y_16 N_B_4 0.00136411f $X=0.108 $Y=0.072
cc_20 N_Y_3 N_B_4 0.00276036f $X=0.216 $Y=0.216
cc_21 N_Y_12 N_B_3 0.0261142f $X=0.2015 $Y=0.216
cc_22 N_Y_15 N_C_3 0.000991068f $X=0.27 $Y=0.234
cc_23 N_Y_16 N_C_4 0.00132783f $X=0.108 $Y=0.072
cc_24 N_Y_17 N_C_4 0.00634883f $X=0.297 $Y=0.0935
cc_25 N_Y_12 N_C_3 0.026589f $X=0.2015 $Y=0.216
x_PM_OAI211xp5_ASAP7_75t_R%A1 vss A1 N_M1_g N_M5_g N_A1_4 N_A1_3 N_A1_1
+ PM_OAI211xp5_ASAP7_75t_R%A1
cc_26 N_A1_4 N_A2_7 0.00192825f $X=0.135 $Y=0.135
cc_27 N_A1_3 N_A2_3 0.00892528f $X=0.135 $Y=0.0245
x_PM_OAI211xp5_ASAP7_75t_R%A2 vss A2 N_M0_g N_M4_g N_A2_7 N_A2_3 N_A2_1 N_A2_6
+ PM_OAI211xp5_ASAP7_75t_R%A2

* End of included file OAI211xp5_ASAP7_75t_R.pex.sp.pxi
.ends

.subckt PM_OA332x2_ASAP7_75t_R%A3 vss 14 5 9 3 4
c1 1 vss 0.00581652f $X=0.189 $Y=0.135
c2 3 vss 0.139755f $X=0.189 $Y=0.0245
c3 4 vss 0.00674075f $X=0.189 $Y=0.0945
r1 14 13 1.34084 $w=1.3e-08 $l=5.8e-09 $layer=M1 $thickness=3.6e-08 $X=0.189
+ $Y=0.155 $X2=0.189 $Y2=0.1492
r2 12 13 3.32295 $w=1.3e-08 $l=1.42e-08 $layer=M1 $thickness=3.6e-08 $X=0.189
+ $Y=0.135 $X2=0.189 $Y2=0.1492
r3 11 12 2.91487 $w=1.3e-08 $l=1.25e-08 $layer=M1 $thickness=3.6e-08 $X=0.189
+ $Y=0.1225 $X2=0.189 $Y2=0.135
r4 4 11 6.52931 $w=1.3e-08 $l=2.8e-08 $layer=M1 $thickness=3.6e-08 $X=0.189
+ $Y=0.0945 $X2=0.189 $Y2=0.1225
r5 1 7 10.4265 $w=1.765e-08 $layer=LIG $thickness=5.2e-08 $X=0.189 $Y=0.135
+ $X2=0.189 $Y2=0.135
r6 1 12 19.3796 $a=3.24e-16 $layer=V0LIG $X=0.189 $Y=0.135 $X2=0.189 $Y2=0.135
r7 9 8 16.4967 $w=2.1e-08 $l=4.85e-08 $layer=Gate_1 $thickness=5.6e-08 $X=0.189
+ $Y=0.2025 $X2=0.189 $Y2=0.154
r8 7 8 6.6497 $w=2.04211e-08 $l=1.9e-08 $layer=Gate_1 $thickness=5.6e-08
+ $X=0.189 $Y=0.135 $X2=0.189 $Y2=0.154
r9 6 7 6.6497 $w=2.04211e-08 $l=1.9e-08 $layer=Gate_1 $thickness=5.6e-08
+ $X=0.189 $Y=0.116 $X2=0.189 $Y2=0.135
r10 5 6 16.4967 $w=2.1e-08 $l=4.85e-08 $layer=Gate_1 $thickness=5.6e-08
+ $X=0.189 $Y=0.0675 $X2=0.189 $Y2=0.116
r11 5 3 14.6259 $w=2.1e-08 $l=4.3e-08 $layer=Gate_1 $thickness=5.6e-08 $X=0.189
+ $Y=0.0675 $X2=0.189 $Y2=0.0245
.ends

.subckt PM_OA332x2_ASAP7_75t_R%B1 vss 13 5 9 4 3
c1 1 vss 0.00723495f $X=0.351 $Y=0.135
c2 3 vss 0.10166f $X=0.351 $Y=0.0245
c3 4 vss 0.00542884f $X=0.351 $Y=0.116
r1 13 12 1.22425 $w=1.3e-08 $l=5.3e-09 $layer=M1 $thickness=3.6e-08 $X=0.351
+ $Y=0.154 $X2=0.351 $Y2=0.1487
r2 11 12 3.20636 $w=1.3e-08 $l=1.37e-08 $layer=M1 $thickness=3.6e-08 $X=0.351
+ $Y=0.135 $X2=0.351 $Y2=0.1487
r3 4 11 4.4306 $w=1.3e-08 $l=1.9e-08 $layer=M1 $thickness=3.6e-08 $X=0.351
+ $Y=0.116 $X2=0.351 $Y2=0.135
r4 1 7 10.4265 $w=1.765e-08 $layer=LIG $thickness=5.2e-08 $X=0.351 $Y=0.135
+ $X2=0.351 $Y2=0.135
r5 1 11 19.3796 $a=3.24e-16 $layer=V0LIG $X=0.351 $Y=0.135 $X2=0.351 $Y2=0.135
r6 9 8 16.4967 $w=2.1e-08 $l=4.85e-08 $layer=Gate_1 $thickness=5.6e-08 $X=0.351
+ $Y=0.2025 $X2=0.351 $Y2=0.154
r7 7 8 6.6497 $w=2.04211e-08 $l=1.9e-08 $layer=Gate_1 $thickness=5.6e-08
+ $X=0.351 $Y=0.135 $X2=0.351 $Y2=0.154
r8 6 7 6.6497 $w=2.04211e-08 $l=1.9e-08 $layer=Gate_1 $thickness=5.6e-08
+ $X=0.351 $Y=0.116 $X2=0.351 $Y2=0.135
r9 5 6 16.4967 $w=2.1e-08 $l=4.85e-08 $layer=Gate_1 $thickness=5.6e-08 $X=0.351
+ $Y=0.0675 $X2=0.351 $Y2=0.116
r10 5 3 14.6259 $w=2.1e-08 $l=4.3e-08 $layer=Gate_1 $thickness=5.6e-08 $X=0.351
+ $Y=0.0675 $X2=0.351 $Y2=0.0245
.ends

.subckt PM_OA332x2_ASAP7_75t_R%B2 vss 13 5 9 4 3
c1 1 vss 0.00485704f $X=0.405 $Y=0.135
c2 3 vss 0.12119f $X=0.405 $Y=0.0245
c3 4 vss 0.00515123f $X=0.405 $Y=0.116
r1 13 12 1.34084 $w=1.3e-08 $l=5.8e-09 $layer=M1 $thickness=3.6e-08 $X=0.404
+ $Y=0.155 $X2=0.405 $Y2=0.1492
r2 11 12 3.32295 $w=1.3e-08 $l=1.42e-08 $layer=M1 $thickness=3.6e-08 $X=0.405
+ $Y=0.135 $X2=0.405 $Y2=0.1492
r3 4 11 4.4306 $w=1.3e-08 $l=1.9e-08 $layer=M1 $thickness=3.6e-08 $X=0.405
+ $Y=0.116 $X2=0.405 $Y2=0.135
r4 1 7 10.4265 $w=1.765e-08 $layer=LIG $thickness=5.2e-08 $X=0.405 $Y=0.135
+ $X2=0.405 $Y2=0.135
r5 1 11 19.3796 $a=3.24e-16 $layer=V0LIG $X=0.405 $Y=0.135 $X2=0.405 $Y2=0.135
r6 9 8 16.4967 $w=2.1e-08 $l=4.85e-08 $layer=Gate_1 $thickness=5.6e-08 $X=0.405
+ $Y=0.2025 $X2=0.405 $Y2=0.154
r7 7 8 6.6497 $w=2.04211e-08 $l=1.9e-08 $layer=Gate_1 $thickness=5.6e-08
+ $X=0.405 $Y=0.135 $X2=0.405 $Y2=0.154
r8 6 7 6.6497 $w=2.04211e-08 $l=1.9e-08 $layer=Gate_1 $thickness=5.6e-08
+ $X=0.405 $Y=0.116 $X2=0.405 $Y2=0.135
r9 5 6 16.4967 $w=2.1e-08 $l=4.85e-08 $layer=Gate_1 $thickness=5.6e-08 $X=0.405
+ $Y=0.0675 $X2=0.405 $Y2=0.116
r10 5 3 14.6259 $w=2.1e-08 $l=4.3e-08 $layer=Gate_1 $thickness=5.6e-08 $X=0.405
+ $Y=0.0675 $X2=0.405 $Y2=0.0245
.ends

.subckt PM_OA332x2_ASAP7_75t_R%B3 vss 13 5 9 4 3
c1 1 vss 0.0058134f $X=0.459 $Y=0.135
c2 3 vss 0.140123f $X=0.459 $Y=0.0245
c3 4 vss 0.00543215f $X=0.459 $Y=0.116
r1 13 12 1.34084 $w=1.3e-08 $l=5.8e-09 $layer=M1 $thickness=3.6e-08 $X=0.457
+ $Y=0.155 $X2=0.459 $Y2=0.1492
r2 11 12 3.32295 $w=1.3e-08 $l=1.42e-08 $layer=M1 $thickness=3.6e-08 $X=0.459
+ $Y=0.135 $X2=0.459 $Y2=0.1492
r3 4 11 4.4306 $w=1.3e-08 $l=1.9e-08 $layer=M1 $thickness=3.6e-08 $X=0.459
+ $Y=0.116 $X2=0.459 $Y2=0.135
r4 1 7 10.4265 $w=1.765e-08 $layer=LIG $thickness=5.2e-08 $X=0.459 $Y=0.135
+ $X2=0.459 $Y2=0.135
r5 1 11 19.3796 $a=3.24e-16 $layer=V0LIG $X=0.459 $Y=0.135 $X2=0.459 $Y2=0.135
r6 9 8 16.4967 $w=2.1e-08 $l=4.85e-08 $layer=Gate_1 $thickness=5.6e-08 $X=0.459
+ $Y=0.2025 $X2=0.459 $Y2=0.154
r7 7 8 6.6497 $w=2.04211e-08 $l=1.9e-08 $layer=Gate_1 $thickness=5.6e-08
+ $X=0.459 $Y=0.135 $X2=0.459 $Y2=0.154
r8 6 7 6.6497 $w=2.04211e-08 $l=1.9e-08 $layer=Gate_1 $thickness=5.6e-08
+ $X=0.459 $Y=0.116 $X2=0.459 $Y2=0.135
r9 5 6 16.4967 $w=2.1e-08 $l=4.85e-08 $layer=Gate_1 $thickness=5.6e-08 $X=0.459
+ $Y=0.0675 $X2=0.459 $Y2=0.116
r10 5 3 14.6259 $w=2.1e-08 $l=4.3e-08 $layer=Gate_1 $thickness=5.6e-08 $X=0.459
+ $Y=0.0675 $X2=0.459 $Y2=0.0245
.ends

.subckt PM_OA332x2_ASAP7_75t_R%C2 vss 13 5 9 3 4
c1 1 vss 0.00657683f $X=0.513 $Y=0.135
c2 3 vss 0.102289f $X=0.513 $Y=0.0245
c3 4 vss 0.0043278f $X=0.513 $Y=0.116
r1 13 12 1.45744 $w=1.3e-08 $l=6.3e-09 $layer=M1 $thickness=3.6e-08 $X=0.514
+ $Y=0.156 $X2=0.513 $Y2=0.1497
r2 11 12 3.43955 $w=1.3e-08 $l=1.47e-08 $layer=M1 $thickness=3.6e-08 $X=0.513
+ $Y=0.135 $X2=0.513 $Y2=0.1497
r3 4 11 4.4306 $w=1.3e-08 $l=1.9e-08 $layer=M1 $thickness=3.6e-08 $X=0.513
+ $Y=0.116 $X2=0.513 $Y2=0.135
r4 1 7 10.4265 $w=1.765e-08 $layer=LIG $thickness=5.2e-08 $X=0.513 $Y=0.135
+ $X2=0.513 $Y2=0.135
r5 1 11 19.3796 $a=3.24e-16 $layer=V0LIG $X=0.513 $Y=0.135 $X2=0.513 $Y2=0.135
r6 9 8 16.4967 $w=2.1e-08 $l=4.85e-08 $layer=Gate_1 $thickness=5.6e-08 $X=0.513
+ $Y=0.2025 $X2=0.513 $Y2=0.154
r7 7 8 6.6497 $w=2.04211e-08 $l=1.9e-08 $layer=Gate_1 $thickness=5.6e-08
+ $X=0.513 $Y=0.135 $X2=0.513 $Y2=0.154
r8 6 7 6.6497 $w=2.04211e-08 $l=1.9e-08 $layer=Gate_1 $thickness=5.6e-08
+ $X=0.513 $Y=0.116 $X2=0.513 $Y2=0.135
r9 5 6 16.4967 $w=2.1e-08 $l=4.85e-08 $layer=Gate_1 $thickness=5.6e-08 $X=0.513
+ $Y=0.0675 $X2=0.513 $Y2=0.116
r10 5 3 14.6259 $w=2.1e-08 $l=4.3e-08 $layer=Gate_1 $thickness=5.6e-08 $X=0.513
+ $Y=0.0675 $X2=0.513 $Y2=0.0245
.ends

.subckt PM_OA332x2_ASAP7_75t_R%C1 vss 15 5 11 3 4 1
c1 1 vss 0.00289289f $X=0.567 $Y=0.135
c2 3 vss 0.0707303f $X=0.567 $Y=0.0245
c3 4 vss 0.00494247f $X=0.567 $Y=0.116
r1 15 14 1.34084 $w=1.3e-08 $l=5.8e-09 $layer=M1 $thickness=3.6e-08 $X=0.567
+ $Y=0.155 $X2=0.567 $Y2=0.1492
r2 13 14 3.32295 $w=1.3e-08 $l=1.42e-08 $layer=M1 $thickness=3.6e-08 $X=0.567
+ $Y=0.135 $X2=0.567 $Y2=0.1492
r3 4 13 4.4306 $w=1.3e-08 $l=1.9e-08 $layer=M1 $thickness=3.6e-08 $X=0.567
+ $Y=0.116 $X2=0.567 $Y2=0.135
r4 1 8 10.4265 $w=1.765e-08 $layer=LIG $thickness=5.2e-08 $X=0.567 $Y=0.135
+ $X2=0.567 $Y2=0.135
r5 1 13 19.3796 $a=3.24e-16 $layer=V0LIG $X=0.567 $Y=0.135 $X2=0.567 $Y2=0.135
r6 11 10 14.6259 $w=2.1e-08 $l=4.3e-08 $layer=Gate_1 $thickness=5.6e-08
+ $X=0.567 $Y=0.2025 $X2=0.567 $Y2=0.1595
r7 9 10 2.7211 $w=2.1e-08 $l=8e-09 $layer=Gate_1 $thickness=5.6e-08 $X=0.567
+ $Y=0.1515 $X2=0.567 $Y2=0.1595
r8 8 9 5.79936 $w=2.03333e-08 $l=1.65e-08 $layer=Gate_1 $thickness=5.6e-08
+ $X=0.567 $Y=0.135 $X2=0.567 $Y2=0.1515
r9 7 8 5.79936 $w=2.03333e-08 $l=1.65e-08 $layer=Gate_1 $thickness=5.6e-08
+ $X=0.567 $Y=0.1185 $X2=0.567 $Y2=0.135
r10 6 7 2.7211 $w=2.1e-08 $l=8e-09 $layer=Gate_1 $thickness=5.6e-08 $X=0.567
+ $Y=0.1105 $X2=0.567 $Y2=0.1185
r11 5 6 14.6259 $w=2.1e-08 $l=4.3e-08 $layer=Gate_1 $thickness=5.6e-08 $X=0.567
+ $Y=0.0675 $X2=0.567 $Y2=0.1105
r12 5 3 14.6259 $w=2.1e-08 $l=4.3e-08 $layer=Gate_1 $thickness=5.6e-08 $X=0.567
+ $Y=0.0675 $X2=0.567 $Y2=0.0245
.ends

.subckt PM_OA332x2_ASAP7_75t_R%Y vss 22 16 17 31 32 7 13 8
c1 1 vss 0.0100489f $X=0.108 $Y=0.0675
c2 2 vss 0.00867597f $X=0.108 $Y=0.2025
c3 7 vss 0.00441119f $X=0.0935 $Y=0.0675
c4 8 vss 0.00438014f $X=0.0935 $Y=0.2025
c5 9 vss 0.00291767f $X=0.027 $Y=0.036
c6 10 vss 0.00291299f $X=0.027 $Y=0.234
c7 11 vss 0.00882302f $X=0.027 $Y=0.0575
c8 12 vss 0.00886095f $X=0.0675 $Y=0.036
c9 13 vss 0.0094206f $X=0.0675 $Y=0.234
r1 32 30 0.0308642 $w=8.1e-08 $l=2.5e-09 $layer=P_src_drn $thickness=1e-09
+ $X=0.1253 $Y=0.2025 $X2=0.1225 $Y2=0.2025
r2 2 30 0.179012 $w=8.1e-08 $l=1.45e-08 $layer=P_src_drn $thickness=1e-09
+ $X=0.108 $Y=0.2025 $X2=0.1225 $Y2=0.2025
r3 8 2 0.179012 $w=8.1e-08 $l=1.45e-08 $layer=P_src_drn $thickness=1e-09
+ $X=0.0935 $Y=0.2025 $X2=0.108 $Y2=0.2025
r4 31 8 0.0308642 $w=8.1e-08 $l=2.5e-09 $layer=P_src_drn $thickness=1e-09
+ $X=0.0906 $Y=0.2025 $X2=0.0935 $Y2=0.2025
r5 2 25 19.3796 $a=3.24e-16 $layer=V0LISD $X=0.108 $Y=0.2025 $X2=0.108 $Y2=0.234
r6 13 25 9.44419 $w=1.3e-08 $l=4.05e-08 $layer=M1 $thickness=3.6e-08 $X=0.0675
+ $Y=0.234 $X2=0.108 $Y2=0.234
r7 10 24 2.5483 $w=1.79e-08 $l=1.8e-08 $layer=M1 $thickness=3.6e-08 $X=0.027
+ $Y=0.234 $X2=0.027 $Y2=0.216
r8 10 13 7.79507 $w=1.41111e-08 $l=4.05e-08 $layer=M1 $thickness=3.6e-08
+ $X=0.027 $Y=0.234 $X2=0.0675 $Y2=0.234
r9 23 24 9.91056 $w=1.3e-08 $l=4.25e-08 $layer=M1 $thickness=3.6e-08 $X=0.027
+ $Y=0.1735 $X2=0.027 $Y2=0.216
r10 22 23 7.92845 $w=1.3e-08 $l=3.4e-08 $layer=M1 $thickness=3.6e-08 $X=0.0195
+ $Y=0.1395 $X2=0.027 $Y2=0.1735
r11 22 21 2.44849 $w=1.3e-08 $l=1.05e-08 $layer=M1 $thickness=3.6e-08 $X=0.0195
+ $Y=0.1395 $X2=0.027 $Y2=0.129
r12 20 21 8.04505 $w=1.3e-08 $l=3.45e-08 $layer=M1 $thickness=3.6e-08 $X=0.027
+ $Y=0.0945 $X2=0.027 $Y2=0.129
r13 11 20 8.62802 $w=1.3e-08 $l=3.7e-08 $layer=M1 $thickness=3.6e-08 $X=0.027
+ $Y=0.0575 $X2=0.027 $Y2=0.0945
r14 9 12 7.79507 $w=1.41111e-08 $l=4.05e-08 $layer=M1 $thickness=3.6e-08
+ $X=0.027 $Y=0.036 $X2=0.0675 $Y2=0.036
r15 9 11 3.36447 $w=1.71023e-08 $l=2.15e-08 $layer=M1 $thickness=3.6e-08
+ $X=0.027 $Y=0.036 $X2=0.027 $Y2=0.0575
r16 12 18 9.44419 $w=1.3e-08 $l=4.05e-08 $layer=M1 $thickness=3.6e-08 $X=0.0675
+ $Y=0.036 $X2=0.108 $Y2=0.036
r17 1 18 19.3796 $a=3.24e-16 $layer=V0LISD $X=0.108 $Y=0.0675 $X2=0.108
+ $Y2=0.036
r18 17 15 0.0308642 $w=8.1e-08 $l=2.5e-09 $layer=N_src_drn $thickness=1e-09
+ $X=0.1253 $Y=0.0675 $X2=0.1225 $Y2=0.0675
r19 1 15 0.179012 $w=8.1e-08 $l=1.45e-08 $layer=N_src_drn $thickness=1e-09
+ $X=0.108 $Y=0.0675 $X2=0.1225 $Y2=0.0675
r20 7 1 0.179012 $w=8.1e-08 $l=1.45e-08 $layer=N_src_drn $thickness=1e-09
+ $X=0.0935 $Y=0.0675 $X2=0.108 $Y2=0.0675
r21 16 7 0.0308642 $w=8.1e-08 $l=2.5e-09 $layer=N_src_drn $thickness=1e-09
+ $X=0.0906 $Y=0.0675 $X2=0.0935 $Y2=0.0675
.ends

.subckt PM_OA332x2_ASAP7_75t_R%3 vss 28 34 43 46 75 76 80 88 89 23 18 1 22 13
+ 15 3 25 4 26 14 16 5 27 19 24 17 12
c1 1 vss 0.00742543f $X=0.081 $Y=0.135
c2 3 vss 0.0050554f $X=0.324 $Y=0.2025
c3 4 vss 0.0100012f $X=0.54 $Y=0.0675
c4 5 vss 0.00704161f $X=0.594 $Y=0.2025
c5 12 vss 0.0838119f $X=0.081 $Y=0.0245
c6 13 vss 0.0809011f $X=0.135 $Y=0.135
c7 14 vss 0.0065156f $X=0.5255 $Y=0.0675
c8 15 vss 0.00514539f $X=0.3095 $Y=0.2025
c9 16 vss 0.039991f $X=0.5795 $Y=0.2025
c10 17 vss 0.000895849f $X=0.135 $Y=0.198
c11 18 vss 0.000694975f $X=0.189 $Y=0.1945
c12 19 vss 0.00302611f $X=0.189 $Y=0.234
c13 20 vss 0.00299294f $X=0.621 $Y=0.072
c14 21 vss 0.00321016f $X=0.621 $Y=0.234
c15 22 vss 0.00242453f $X=0.135 $Y=0.1225
c16 23 vss 0.00162714f $X=0.162 $Y=0.198
c17 24 vss 0.000613391f $X=0.189 $Y=0.216
c18 25 vss 0.0385908f $X=0.199 $Y=0.234
c19 26 vss 0.0090556f $X=0.611 $Y=0.072
c20 27 vss 0.00779334f $X=0.621 $Y=0.2125
r1 89 87 0.0308642 $w=8.1e-08 $l=2.5e-09 $layer=N_src_drn $thickness=1e-09
+ $X=0.5573 $Y=0.0675 $X2=0.5545 $Y2=0.0675
r2 4 87 0.179012 $w=8.1e-08 $l=1.45e-08 $layer=N_src_drn $thickness=1e-09
+ $X=0.54 $Y=0.0675 $X2=0.5545 $Y2=0.0675
r3 14 4 0.179012 $w=8.1e-08 $l=1.45e-08 $layer=N_src_drn $thickness=1e-09
+ $X=0.5255 $Y=0.0675 $X2=0.54 $Y2=0.0675
r4 88 14 0.0308642 $w=8.1e-08 $l=2.5e-09 $layer=N_src_drn $thickness=1e-09
+ $X=0.5226 $Y=0.0675 $X2=0.5255 $Y2=0.0675
r5 4 84 19.3796 $a=3.24e-16 $layer=V0LISD $X=0.54 $Y=0.0675 $X2=0.54 $Y2=0.072
r6 84 85 3.14806 $w=1.3e-08 $l=1.35e-08 $layer=M1 $thickness=3.6e-08 $X=0.54
+ $Y=0.072 $X2=0.5535 $Y2=0.072
r7 82 85 3.14806 $w=1.3e-08 $l=1.35e-08 $layer=M1 $thickness=3.6e-08 $X=0.567
+ $Y=0.072 $X2=0.5535 $Y2=0.072
r8 81 82 6.06293 $w=1.3e-08 $l=2.6e-08 $layer=M1 $thickness=3.6e-08 $X=0.593
+ $Y=0.072 $X2=0.567 $Y2=0.072
r9 26 81 4.19742 $w=1.3e-08 $l=1.8e-08 $layer=M1 $thickness=3.6e-08 $X=0.611
+ $Y=0.072 $X2=0.593 $Y2=0.072
r10 20 78 3.36447 $w=1.71023e-08 $l=2.15e-08 $layer=M1 $thickness=3.6e-08
+ $X=0.621 $Y=0.072 $X2=0.621 $Y2=0.0935
r11 20 26 0.682785 $w=1.75e-08 $l=1e-08 $layer=M1 $thickness=3.6e-08 $X=0.621
+ $Y=0.072 $X2=0.611 $Y2=0.072
r12 16 5 0.154321 $w=8.1e-08 $l=1.25e-08 $layer=P_src_drn $thickness=1e-09
+ $X=0.5795 $Y=0.2025 $X2=0.594 $Y2=0.2025
r13 80 16 0.0308642 $w=8.1e-08 $l=2.5e-09 $layer=P_src_drn $thickness=1e-09
+ $X=0.5766 $Y=0.2025 $X2=0.5795 $Y2=0.2025
r14 77 78 13.8748 $w=1.3e-08 $l=5.95e-08 $layer=M1 $thickness=3.6e-08 $X=0.621
+ $Y=0.153 $X2=0.621 $Y2=0.0935
r15 27 77 13.8748 $w=1.3e-08 $l=5.95e-08 $layer=M1 $thickness=3.6e-08 $X=0.621
+ $Y=0.2125 $X2=0.621 $Y2=0.153
r16 76 74 0.0308642 $w=8.1e-08 $l=2.5e-09 $layer=P_src_drn $thickness=1e-09
+ $X=0.3413 $Y=0.2025 $X2=0.3385 $Y2=0.2025
r17 3 74 0.179012 $w=8.1e-08 $l=1.45e-08 $layer=P_src_drn $thickness=1e-09
+ $X=0.324 $Y=0.2025 $X2=0.3385 $Y2=0.2025
r18 15 3 0.179012 $w=8.1e-08 $l=1.45e-08 $layer=P_src_drn $thickness=1e-09
+ $X=0.3095 $Y=0.2025 $X2=0.324 $Y2=0.2025
r19 75 15 0.0308642 $w=8.1e-08 $l=2.5e-09 $layer=P_src_drn $thickness=1e-09
+ $X=0.3066 $Y=0.2025 $X2=0.3095 $Y2=0.2025
r20 5 71 19.3796 $a=3.24e-16 $layer=V0LISD $X=0.594 $Y=0.2025 $X2=0.594
+ $Y2=0.234
r21 21 72 1.49895 $w=1.63333e-08 $l=1.35e-08 $layer=M1 $thickness=3.6e-08
+ $X=0.621 $Y=0.234 $X2=0.6075 $Y2=0.234
r22 21 27 3.36447 $w=1.71023e-08 $l=2.15e-08 $layer=M1 $thickness=3.6e-08
+ $X=0.621 $Y=0.234 $X2=0.621 $Y2=0.2125
r23 3 57 19.3796 $a=3.24e-16 $layer=V0LISD $X=0.324 $Y=0.2025 $X2=0.324
+ $Y2=0.234
r24 71 72 3.14806 $w=1.3e-08 $l=1.35e-08 $layer=M1 $thickness=3.6e-08 $X=0.594
+ $Y=0.234 $X2=0.6075 $Y2=0.234
r25 70 71 3.14806 $w=1.3e-08 $l=1.35e-08 $layer=M1 $thickness=3.6e-08 $X=0.5805
+ $Y=0.234 $X2=0.594 $Y2=0.234
r26 69 70 3.14806 $w=1.3e-08 $l=1.35e-08 $layer=M1 $thickness=3.6e-08 $X=0.567
+ $Y=0.234 $X2=0.5805 $Y2=0.234
r27 68 69 5.94634 $w=1.3e-08 $l=2.55e-08 $layer=M1 $thickness=3.6e-08 $X=0.5415
+ $Y=0.234 $X2=0.567 $Y2=0.234
r28 67 68 4.19742 $w=1.3e-08 $l=1.8e-08 $layer=M1 $thickness=3.6e-08 $X=0.5235
+ $Y=0.234 $X2=0.5415 $Y2=0.234
r29 66 67 2.44849 $w=1.3e-08 $l=1.05e-08 $layer=M1 $thickness=3.6e-08 $X=0.513
+ $Y=0.234 $X2=0.5235 $Y2=0.234
r30 65 66 6.29612 $w=1.3e-08 $l=2.7e-08 $layer=M1 $thickness=3.6e-08 $X=0.486
+ $Y=0.234 $X2=0.513 $Y2=0.234
r31 64 65 6.29612 $w=1.3e-08 $l=2.7e-08 $layer=M1 $thickness=3.6e-08 $X=0.459
+ $Y=0.234 $X2=0.486 $Y2=0.234
r32 63 64 2.44849 $w=1.3e-08 $l=1.05e-08 $layer=M1 $thickness=3.6e-08 $X=0.4485
+ $Y=0.234 $X2=0.459 $Y2=0.234
r33 62 63 4.19742 $w=1.3e-08 $l=1.8e-08 $layer=M1 $thickness=3.6e-08 $X=0.4305
+ $Y=0.234 $X2=0.4485 $Y2=0.234
r34 61 62 5.94634 $w=1.3e-08 $l=2.55e-08 $layer=M1 $thickness=3.6e-08 $X=0.405
+ $Y=0.234 $X2=0.4305 $Y2=0.234
r35 60 61 6.29612 $w=1.3e-08 $l=2.7e-08 $layer=M1 $thickness=3.6e-08 $X=0.378
+ $Y=0.234 $X2=0.405 $Y2=0.234
r36 59 60 6.29612 $w=1.3e-08 $l=2.7e-08 $layer=M1 $thickness=3.6e-08 $X=0.351
+ $Y=0.234 $X2=0.378 $Y2=0.234
r37 58 59 3.14806 $w=1.3e-08 $l=1.35e-08 $layer=M1 $thickness=3.6e-08 $X=0.3375
+ $Y=0.234 $X2=0.351 $Y2=0.234
r38 57 58 3.14806 $w=1.3e-08 $l=1.35e-08 $layer=M1 $thickness=3.6e-08 $X=0.324
+ $Y=0.234 $X2=0.3375 $Y2=0.234
r39 56 57 3.14806 $w=1.3e-08 $l=1.35e-08 $layer=M1 $thickness=3.6e-08 $X=0.3105
+ $Y=0.234 $X2=0.324 $Y2=0.234
r40 55 56 3.14806 $w=1.3e-08 $l=1.35e-08 $layer=M1 $thickness=3.6e-08 $X=0.297
+ $Y=0.234 $X2=0.3105 $Y2=0.234
r41 54 55 6.29612 $w=1.3e-08 $l=2.7e-08 $layer=M1 $thickness=3.6e-08 $X=0.27
+ $Y=0.234 $X2=0.297 $Y2=0.234
r42 53 54 6.29612 $w=1.3e-08 $l=2.7e-08 $layer=M1 $thickness=3.6e-08 $X=0.243
+ $Y=0.234 $X2=0.27 $Y2=0.234
r43 52 53 6.06293 $w=1.3e-08 $l=2.6e-08 $layer=M1 $thickness=3.6e-08 $X=0.217
+ $Y=0.234 $X2=0.243 $Y2=0.234
r44 25 52 4.19742 $w=1.3e-08 $l=1.8e-08 $layer=M1 $thickness=3.6e-08 $X=0.199
+ $Y=0.234 $X2=0.217 $Y2=0.234
r45 19 24 2.5483 $w=1.79e-08 $l=1.8e-08 $layer=M1 $thickness=3.6e-08 $X=0.189
+ $Y=0.234 $X2=0.189 $Y2=0.216
r46 19 25 0.682785 $w=1.75e-08 $l=1e-08 $layer=M1 $thickness=3.6e-08 $X=0.189
+ $Y=0.234 $X2=0.199 $Y2=0.234
r47 24 51 2.45586 $w=1.44e-08 $l=1.25e-08 $layer=M1 $thickness=3.6e-08 $X=0.189
+ $Y=0.216 $X2=0.189 $Y2=0.2035
r48 18 51 0.9184 $w=1.8e-08 $l=9e-09 $layer=M1 $thickness=3.6e-08 $X=0.189
+ $Y=0.1945 $X2=0.189 $Y2=0.2035
r49 23 51 4.55457 $w=1.3814e-08 $l=2.75545e-08 $layer=M1 $thickness=3.6e-08
+ $X=0.162 $Y=0.198 $X2=0.189 $Y2=0.2035
r50 17 50 3.36447 $w=1.71023e-08 $l=2.15e-08 $layer=M1 $thickness=3.6e-08
+ $X=0.135 $Y=0.198 $X2=0.135 $Y2=0.1765
r51 17 23 4.64701 $w=1.46667e-08 $l=2.7e-08 $layer=M1 $thickness=3.6e-08
+ $X=0.135 $Y=0.198 $X2=0.162 $Y2=0.198
r52 49 50 5.24677 $w=1.3e-08 $l=2.25e-08 $layer=M1 $thickness=3.6e-08 $X=0.135
+ $Y=0.154 $X2=0.135 $Y2=0.1765
r53 48 49 4.43061 $w=1.3e-08 $l=1.9e-08 $layer=M1 $thickness=3.6e-08 $X=0.135
+ $Y=0.135 $X2=0.135 $Y2=0.154
r54 22 48 2.91487 $w=1.3e-08 $l=1.25e-08 $layer=M1 $thickness=3.6e-08 $X=0.135
+ $Y=0.1225 $X2=0.135 $Y2=0.135
r55 46 45 16.4967 $w=2.1e-08 $l=4.85e-08 $layer=Gate_1 $thickness=5.6e-08
+ $X=0.135 $Y=0.2025 $X2=0.135 $Y2=0.154
r56 43 44 16.4967 $w=2.1e-08 $l=4.85e-08 $layer=Gate_1 $thickness=5.6e-08
+ $X=0.135 $Y=0.0675 $X2=0.135 $Y2=0.116
r57 13 39 6.27904 $w=2.09e-08 $layer=Gate_1 $thickness=5.24e-08 $X=0.135
+ $Y=0.135 $X2=0.135 $Y2=0.135
r58 13 44 6.6497 $w=2.04211e-08 $l=1.9e-08 $layer=Gate_1 $thickness=5.6e-08
+ $X=0.135 $Y=0.135 $X2=0.135 $Y2=0.116
r59 13 45 6.6497 $w=2.04211e-08 $l=1.9e-08 $layer=Gate_1 $thickness=5.6e-08
+ $X=0.135 $Y=0.135 $X2=0.135 $Y2=0.154
r60 39 48 19.3796 $a=3.24e-16 $layer=V0LIG $X=0.135 $Y=0.135 $X2=0.135 $Y2=0.135
r61 38 39 2.48102 $w=2.2e-08 $l=9.5e-09 $layer=LIG $thickness=4.8e-08 $X=0.1255
+ $Y=0.135 $X2=0.135 $Y2=0.135
r62 37 38 10.1729 $w=1.54914e-08 $l=1.75e-08 $layer=LIG $thickness=4.8e-08
+ $X=0.108 $Y=0.135 $X2=0.1255 $Y2=0.135
r63 1 31 6.54019 $w=2.09524e-08 $layer=Gate_1 $thickness=5.21905e-08 $X=0.081
+ $Y=0.135 $X2=0.081 $Y2=0.135
r64 1 37 12.6539 $w=1.77815e-08 $l=2.7e-08 $layer=LIG $thickness=4.8e-08
+ $X=0.081 $Y=0.135 $X2=0.108 $Y2=0.135
r65 34 33 14.6259 $w=2.1e-08 $l=4.3e-08 $layer=Gate_1 $thickness=5.6e-08
+ $X=0.081 $Y=0.2025 $X2=0.081 $Y2=0.1595
r66 32 33 2.7211 $w=2.1e-08 $l=8e-09 $layer=Gate_1 $thickness=5.6e-08 $X=0.081
+ $Y=0.1515 $X2=0.081 $Y2=0.1595
r67 31 32 5.79936 $w=2.03333e-08 $l=1.65e-08 $layer=Gate_1 $thickness=5.6e-08
+ $X=0.081 $Y=0.135 $X2=0.081 $Y2=0.1515
r68 30 31 5.79936 $w=2.03333e-08 $l=1.65e-08 $layer=Gate_1 $thickness=5.6e-08
+ $X=0.081 $Y=0.1185 $X2=0.081 $Y2=0.135
r69 29 30 2.7211 $w=2.1e-08 $l=8e-09 $layer=Gate_1 $thickness=5.6e-08 $X=0.081
+ $Y=0.1105 $X2=0.081 $Y2=0.1185
r70 28 29 14.6259 $w=2.1e-08 $l=4.3e-08 $layer=Gate_1 $thickness=5.6e-08
+ $X=0.081 $Y=0.0675 $X2=0.081 $Y2=0.1105
r71 28 12 14.6259 $w=2.1e-08 $l=4.3e-08 $layer=Gate_1 $thickness=5.6e-08
+ $X=0.081 $Y=0.0675 $X2=0.081 $Y2=0.0245
.ends

.subckt PM_OA332x2_ASAP7_75t_R%A1 vss 13 5 9 3 4
c1 1 vss 0.0047457f $X=0.297 $Y=0.135
c2 3 vss 0.102427f $X=0.297 $Y=0.0245
c3 4 vss 0.00650662f $X=0.297 $Y=0.116
r1 13 12 1.34084 $w=1.3e-08 $l=5.8e-09 $layer=M1 $thickness=3.6e-08 $X=0.297
+ $Y=0.155 $X2=0.297 $Y2=0.1492
r2 11 12 3.32295 $w=1.3e-08 $l=1.42e-08 $layer=M1 $thickness=3.6e-08 $X=0.297
+ $Y=0.135 $X2=0.297 $Y2=0.1492
r3 4 11 4.4306 $w=1.3e-08 $l=1.9e-08 $layer=M1 $thickness=3.6e-08 $X=0.297
+ $Y=0.116 $X2=0.297 $Y2=0.135
r4 1 7 10.4265 $w=1.765e-08 $layer=LIG $thickness=5.2e-08 $X=0.297 $Y=0.135
+ $X2=0.297 $Y2=0.135
r5 1 11 19.3796 $a=3.24e-16 $layer=V0LIG $X=0.297 $Y=0.135 $X2=0.297 $Y2=0.135
r6 9 8 16.4967 $w=2.1e-08 $l=4.85e-08 $layer=Gate_1 $thickness=5.6e-08 $X=0.297
+ $Y=0.2025 $X2=0.297 $Y2=0.154
r7 7 8 6.6497 $w=2.04211e-08 $l=1.9e-08 $layer=Gate_1 $thickness=5.6e-08
+ $X=0.297 $Y=0.135 $X2=0.297 $Y2=0.154
r8 6 7 6.6497 $w=2.04211e-08 $l=1.9e-08 $layer=Gate_1 $thickness=5.6e-08
+ $X=0.297 $Y=0.116 $X2=0.297 $Y2=0.135
r9 5 6 16.4967 $w=2.1e-08 $l=4.85e-08 $layer=Gate_1 $thickness=5.6e-08 $X=0.297
+ $Y=0.0675 $X2=0.297 $Y2=0.116
r10 5 3 14.6259 $w=2.1e-08 $l=4.3e-08 $layer=Gate_1 $thickness=5.6e-08 $X=0.297
+ $Y=0.0675 $X2=0.297 $Y2=0.0245
.ends

.subckt PM_OA332x2_ASAP7_75t_R%A2 vss 13 5 9 4 3
c1 1 vss 0.00445907f $X=0.243 $Y=0.135
c2 3 vss 0.121348f $X=0.243 $Y=0.0245
c3 4 vss 0.00755461f $X=0.243 $Y=0.116
r1 13 12 1.34084 $w=1.3e-08 $l=5.8e-09 $layer=M1 $thickness=3.6e-08 $X=0.243
+ $Y=0.155 $X2=0.243 $Y2=0.1492
r2 11 12 3.32295 $w=1.3e-08 $l=1.42e-08 $layer=M1 $thickness=3.6e-08 $X=0.243
+ $Y=0.135 $X2=0.243 $Y2=0.1492
r3 4 11 4.43061 $w=1.3e-08 $l=1.9e-08 $layer=M1 $thickness=3.6e-08 $X=0.243
+ $Y=0.116 $X2=0.243 $Y2=0.135
r4 1 7 10.4265 $w=1.765e-08 $layer=LIG $thickness=5.2e-08 $X=0.243 $Y=0.135
+ $X2=0.243 $Y2=0.135
r5 1 11 19.3796 $a=3.24e-16 $layer=V0LIG $X=0.243 $Y=0.135 $X2=0.243 $Y2=0.135
r6 9 8 16.4967 $w=2.1e-08 $l=4.85e-08 $layer=Gate_1 $thickness=5.6e-08 $X=0.243
+ $Y=0.2025 $X2=0.243 $Y2=0.154
r7 7 8 6.6497 $w=2.04211e-08 $l=1.9e-08 $layer=Gate_1 $thickness=5.6e-08
+ $X=0.243 $Y=0.135 $X2=0.243 $Y2=0.154
r8 6 7 6.6497 $w=2.04211e-08 $l=1.9e-08 $layer=Gate_1 $thickness=5.6e-08
+ $X=0.243 $Y=0.116 $X2=0.243 $Y2=0.135
r9 5 6 16.4967 $w=2.1e-08 $l=4.85e-08 $layer=Gate_1 $thickness=5.6e-08 $X=0.243
+ $Y=0.0675 $X2=0.243 $Y2=0.116
r10 5 3 14.6259 $w=2.1e-08 $l=4.3e-08 $layer=Gate_1 $thickness=5.6e-08 $X=0.243
+ $Y=0.0675 $X2=0.243 $Y2=0.0245
.ends

* End of included file OA332x2_ASAP7_75t_R.pex.sp.pex

*
.subckt OA332x2_ASAP7_75t_CUSTOM_4_25_0_7 VSS VDD A3 A2 A1 B1 B2 B3 C2 C1 Y
*
* VSS VSS
* VDD VDD
* A3 A3
* A2 A2
* A1 A1
* B1 B1
* B2 B2
* B3 B3
* C2 C2
* C1 C1
* Y Y
*
*

M0 N_M0_d N_M0_g VSS VSS nmos_rvt L=2e-08 W=8.1e-08 nfin=3 $X=0.071 $Y=0.027
M1 N_M1_d N_M1_g VSS VSS nmos_rvt L=2e-08 W=8.1e-08 nfin=3 $X=0.125 $Y=0.027
M2 noxref_13 N_M2_g VSS VSS nmos_rvt L=2e-08 W=8.1e-08 nfin=3 $X=0.179 $Y=0.027
M3 VSS N_M3_g noxref_13 VSS nmos_rvt L=2e-08 W=8.1e-08 nfin=3 $X=0.233 $Y=0.027
M4 noxref_13 N_M4_g VSS VSS nmos_rvt L=2e-08 W=8.1e-08 nfin=3 $X=0.287 $Y=0.027
M5 noxref_14 N_M5_g noxref_13 VSS nmos_rvt L=2e-08 W=8.1e-08 nfin=3 $X=0.341
+ $Y=0.027
M6 noxref_13 N_M6_g noxref_14 VSS nmos_rvt L=2e-08 W=8.1e-08 nfin=3 $X=0.395
+ $Y=0.027
M7 noxref_14 N_M7_g noxref_13 VSS nmos_rvt L=2e-08 W=8.1e-08 nfin=3 $X=0.449
+ $Y=0.027
M8 N_M8_d N_M8_g noxref_14 VSS nmos_rvt L=2e-08 W=8.1e-08 nfin=3 $X=0.503
+ $Y=0.027
M9 noxref_14 N_M9_g N_M9_s VSS nmos_rvt L=2e-08 W=8.1e-08 nfin=3 $X=0.557
+ $Y=0.027
M10 N_M10_d N_M10_g VDD VDD pmos_rvt L=2e-08 W=8.1e-08 nfin=3 $X=0.071 $Y=0.162
M11 N_M11_d N_M11_g VDD VDD pmos_rvt L=2e-08 W=8.1e-08 nfin=3 $X=0.125 $Y=0.162
M12 noxref_15 N_M12_g VDD VDD pmos_rvt L=2e-08 W=8.1e-08 nfin=3 $X=0.179
+ $Y=0.162
M13 noxref_16 N_M13_g noxref_15 VDD pmos_rvt L=2e-08 W=8.1e-08 nfin=3 $X=0.233
+ $Y=0.162
M14 N_M14_d N_M14_g noxref_16 VDD pmos_rvt L=2e-08 W=8.1e-08 nfin=3 $X=0.287
+ $Y=0.162
M15 noxref_17 N_M15_g N_M15_s VDD pmos_rvt L=2e-08 W=8.1e-08 nfin=3 $X=0.341
+ $Y=0.162
M16 noxref_18 N_M16_g noxref_17 VDD pmos_rvt L=2e-08 W=8.1e-08 nfin=3 $X=0.395
+ $Y=0.162
M17 VDD N_M17_g noxref_18 VDD pmos_rvt L=2e-08 W=8.1e-08 nfin=3 $X=0.449
+ $Y=0.162
M18 noxref_19 N_M18_g VDD VDD pmos_rvt L=2e-08 W=8.1e-08 nfin=3 $X=0.503
+ $Y=0.162
M19 N_M19_d N_M19_g noxref_19 VDD pmos_rvt L=2e-08 W=8.1e-08 nfin=3 $X=0.557
+ $Y=0.162

* .include "OA332x2_ASAP7_75t_R.pex.sp.pxi"

* Start of included file OA332x2_ASAP7_75t_R.pex.sp.pxi
x_PM_OA332x2_ASAP7_75t_R%A3 vss A3 N_M2_g N_M12_g N_A3_3 N_A3_4
+ PM_OA332x2_ASAP7_75t_R%A3
cc_1 N_A3_3 N_3_23 0.000396956f $X=0.189 $Y=0.0245
cc_2 N_A3_3 N_3_18 0.000550929f $X=0.189 $Y=0.0245
cc_3 N_A3_3 N_3_1 0.00230004f $X=0.189 $Y=0.0245
cc_4 N_A3_4 N_3_22 0.00323637f $X=0.189 $Y=0.0945
cc_5 N_A3_3 N_3_13 0.00362185f $X=0.189 $Y=0.0245
x_PM_OA332x2_ASAP7_75t_R%B1 vss B1 N_M5_g N_M15_g N_B1_4 N_B1_3
+ PM_OA332x2_ASAP7_75t_R%B1
cc_6 N_B1_4 N_3_25 0.00125751f $X=0.351 $Y=0.116
cc_7 N_B1_3 N_3_3 0.00151237f $X=0.351 $Y=0.0245
cc_8 N_B1_4 N_3_3 0.00179628f $X=0.351 $Y=0.116
cc_9 N_B1_3 N_3_15 0.036107f $X=0.351 $Y=0.0245
cc_10 N_B1_3 N_A1_3 0.00317569f $X=0.351 $Y=0.0245
cc_11 N_B1_4 N_A1_4 0.00497697f $X=0.351 $Y=0.116
x_PM_OA332x2_ASAP7_75t_R%B2 vss B2 N_M6_g N_M16_g N_B2_4 N_B2_3
+ PM_OA332x2_ASAP7_75t_R%B2
cc_12 N_B2_4 N_3_3 0.000336205f $X=0.405 $Y=0.116
cc_13 N_B2_4 N_3_25 0.00317191f $X=0.405 $Y=0.116
cc_14 N_B2_4 N_B1_4 0.00331561f $X=0.405 $Y=0.116
cc_15 N_B2_3 N_B1_3 0.00697136f $X=0.405 $Y=0.0245
x_PM_OA332x2_ASAP7_75t_R%B3 vss B3 N_M7_g N_M17_g N_B3_4 N_B3_3
+ PM_OA332x2_ASAP7_75t_R%B3
cc_16 N_B3_4 N_3_25 0.0030097f $X=0.459 $Y=0.116
cc_17 N_B3_4 N_B2_4 0.00333492f $X=0.459 $Y=0.116
cc_18 N_B3_3 N_B2_3 0.00692765f $X=0.459 $Y=0.0245
x_PM_OA332x2_ASAP7_75t_R%C2 vss C2 N_M8_g N_M18_g N_C2_3 N_C2_4
+ PM_OA332x2_ASAP7_75t_R%C2
cc_19 N_C2_3 N_3_4 0.00149201f $X=0.513 $Y=0.0245
cc_20 N_C2_3 N_3_26 0.000544566f $X=0.513 $Y=0.0245
cc_21 N_C2_4 N_3_25 0.0013014f $X=0.513 $Y=0.116
cc_22 N_C2_4 N_3_4 0.00219077f $X=0.513 $Y=0.116
cc_23 N_C2_3 N_3_14 0.0357002f $X=0.513 $Y=0.0245
cc_24 N_C2_3 N_B3_3 0.00317792f $X=0.513 $Y=0.0245
cc_25 N_C2_4 N_B3_4 0.0053086f $X=0.513 $Y=0.116
x_PM_OA332x2_ASAP7_75t_R%C1 vss C1 N_M9_g N_M19_g N_C1_3 N_C1_4 N_C1_1
+ PM_OA332x2_ASAP7_75t_R%C1
cc_26 N_C1_3 N_3_4 0.0010638f $X=0.567 $Y=0.0245
cc_27 N_C1_3 N_3_16 0.0155504f $X=0.567 $Y=0.0245
cc_28 N_C1_3 N_3_5 0.00244238f $X=0.567 $Y=0.0245
cc_29 N_C1_3 N_3_26 0.000993697f $X=0.567 $Y=0.0245
cc_30 N_C1_4 N_3_25 0.00115438f $X=0.567 $Y=0.116
cc_31 N_C1_1 N_3_16 0.00173064f $X=0.567 $Y=0.135
cc_32 N_C1_4 N_3_27 0.00657701f $X=0.567 $Y=0.116
cc_33 N_C1_3 N_3_14 0.0540887f $X=0.567 $Y=0.0245
cc_34 N_C1_4 N_C2_4 0.00328605f $X=0.567 $Y=0.116
cc_35 N_C1_3 N_C2_3 0.0069465f $X=0.567 $Y=0.0245
x_PM_OA332x2_ASAP7_75t_R%Y vss Y N_M0_d N_M1_d N_M10_d N_M11_d N_Y_7 N_Y_13
+ N_Y_8 PM_OA332x2_ASAP7_75t_R%Y
cc_36 N_Y_7 N_3_19 0.000176499f $X=0.0935 $Y=0.0675
cc_37 N_Y_7 N_3_24 0.000229067f $X=0.0935 $Y=0.0675
cc_38 N_Y_7 N_3_22 0.00156497f $X=0.0935 $Y=0.0675
cc_39 N_Y_7 N_3_17 0.000279588f $X=0.0935 $Y=0.0675
cc_40 N_Y_7 N_3_23 0.000472923f $X=0.0935 $Y=0.0675
cc_41 N_Y_7 N_3_1 0.00135992f $X=0.0935 $Y=0.0675
cc_42 N_Y_7 N_3_13 0.05763f $X=0.0935 $Y=0.0675
cc_43 N_Y_13 N_3_17 0.0027204f $X=0.0675 $Y=0.234
cc_44 N_Y_8 N_3_1 0.00494763f $X=0.0935 $Y=0.2025
cc_45 N_Y_8 N_3_12 0.0289081f $X=0.0935 $Y=0.2025
cc_46 N_Y_7 N_3_12 0.0504874f $X=0.0935 $Y=0.0675
x_PM_OA332x2_ASAP7_75t_R%3 vss N_M0_g N_M10_g N_M1_g N_M11_g N_M14_d N_M15_s
+ N_M19_d N_M8_d N_M9_s N_3_23 N_3_18 N_3_1 N_3_22 N_3_13 N_3_15 N_3_3 N_3_25
+ N_3_4 N_3_26 N_3_14 N_3_16 N_3_5 N_3_27 N_3_19 N_3_24 N_3_17 N_3_12
+ PM_OA332x2_ASAP7_75t_R%3
x_PM_OA332x2_ASAP7_75t_R%A1 vss A1 N_M4_g N_M14_g N_A1_3 N_A1_4
+ PM_OA332x2_ASAP7_75t_R%A1
cc_47 N_A1_3 N_3_3 0.00178843f $X=0.297 $Y=0.0245
cc_48 N_A1_4 N_3_25 0.0012498f $X=0.297 $Y=0.116
cc_49 N_A1_4 N_3_3 0.00183949f $X=0.297 $Y=0.116
cc_50 N_A1_3 N_3_15 0.0360839f $X=0.297 $Y=0.0245
cc_51 N_A1_4 N_A2_4 0.00372135f $X=0.297 $Y=0.116
cc_52 N_A1_3 N_A2_3 0.0069307f $X=0.297 $Y=0.0245
x_PM_OA332x2_ASAP7_75t_R%A2 vss A2 N_M3_g N_M13_g N_A2_4 N_A2_3
+ PM_OA332x2_ASAP7_75t_R%A2
cc_53 N_A2_4 N_3_15 0.000196797f $X=0.243 $Y=0.116
cc_54 N_A2_4 N_3_3 0.00033594f $X=0.243 $Y=0.116
cc_55 N_A2_4 N_3_25 0.00135815f $X=0.243 $Y=0.116
cc_56 N_A2_4 N_3_18 0.00293567f $X=0.243 $Y=0.116
cc_57 N_A2_4 N_A3_4 0.00370893f $X=0.243 $Y=0.116
cc_58 N_A2_3 N_A3_3 0.00698541f $X=0.243 $Y=0.0245

* End of included file OA332x2_ASAP7_75t_R.pex.sp.pxi
.ends

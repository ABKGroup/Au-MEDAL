.subckt PM_OAI21xp33_ASAP7_75t_R%B vss 13 5 11 3 4
c1 1 vss 0.0055235f $X=0.189 $Y=0.135
c2 3 vss 0.0975928f $X=0.189 $Y=0.0245
c3 4 vss 0.00310588f $X=0.189 $Y=0.1102
r1 14 15 3.32295 $w=1.3e-08 $l=1.43e-08 $layer=M1 $thickness=3.6e-08 $X=0.189
+ $Y=0.1207 $X2=0.189 $Y2=0.135
r2 13 14 1.34084 $w=1.3e-08 $l=5.7e-09 $layer=M1 $thickness=3.6e-08 $X=0.193
+ $Y=0.115 $X2=0.189 $Y2=0.1207
r3 13 4 1.10765 $w=1.3e-08 $l=4.8e-09 $layer=M1 $thickness=3.6e-08 $X=0.193
+ $Y=0.115 $X2=0.189 $Y2=0.1102
r4 1 8 10.4265 $w=1.765e-08 $layer=LIG $thickness=5.2e-08 $X=0.189 $Y=0.135
+ $X2=0.189 $Y2=0.135
r5 1 15 19.3796 $a=3.24e-16 $layer=V0LIG $X=0.189 $Y=0.135 $X2=0.189 $Y2=0.135
r6 11 10 14.6259 $w=2.1e-08 $l=4.3e-08 $layer=Gate_1 $thickness=5.6e-08
+ $X=0.189 $Y=0.216 $X2=0.189 $Y2=0.173
r7 9 10 7.31297 $w=2.1e-08 $l=2.15e-08 $layer=Gate_1 $thickness=5.6e-08
+ $X=0.189 $Y=0.1515 $X2=0.189 $Y2=0.173
r8 8 9 5.79936 $w=2.03333e-08 $l=1.65e-08 $layer=Gate_1 $thickness=5.6e-08
+ $X=0.189 $Y=0.135 $X2=0.189 $Y2=0.1515
r9 7 8 5.79936 $w=2.03333e-08 $l=1.65e-08 $layer=Gate_1 $thickness=5.6e-08
+ $X=0.189 $Y=0.1185 $X2=0.189 $Y2=0.135
r10 6 7 7.31297 $w=2.1e-08 $l=2.15e-08 $layer=Gate_1 $thickness=5.6e-08
+ $X=0.189 $Y=0.097 $X2=0.189 $Y2=0.1185
r11 5 6 14.6259 $w=2.1e-08 $l=4.3e-08 $layer=Gate_1 $thickness=5.6e-08 $X=0.189
+ $Y=0.054 $X2=0.189 $Y2=0.097
r12 5 3 10.0341 $w=2.1e-08 $l=2.95e-08 $layer=Gate_1 $thickness=5.6e-08
+ $X=0.189 $Y=0.054 $X2=0.189 $Y2=0.0245
.ends

.subckt PM_OAI21xp33_ASAP7_75t_R%Y vss 26 16 17 36 37 11 7 12 2 8 13
c1 1 vss 0.00830194f $X=0.108 $Y=0.054
c2 2 vss 0.00657714f $X=0.162 $Y=0.216
c3 7 vss 0.00374027f $X=0.0935 $Y=0.054
c4 8 vss 0.00306583f $X=0.1475 $Y=0.216
c5 9 vss 0.00200566f $X=0.243 $Y=0.072
c6 10 vss 0.00296365f $X=0.243 $Y=0.234
c7 11 vss 0.0110779f $X=0.108 $Y=0.072
c8 12 vss 0.00835787f $X=0.216 $Y=0.234
c9 13 vss 0.00556212f $X=0.243 $Y=0.0935
r1 37 35 0.0462963 $w=5.4e-08 $l=2.5e-09 $layer=P_src_drn $thickness=1e-09
+ $X=0.1793 $Y=0.216 $X2=0.1765 $Y2=0.216
r2 2 35 0.268519 $w=5.4e-08 $l=1.45e-08 $layer=P_src_drn $thickness=1e-09
+ $X=0.162 $Y=0.216 $X2=0.1765 $Y2=0.216
r3 8 2 0.268519 $w=5.4e-08 $l=1.45e-08 $layer=P_src_drn $thickness=1e-09
+ $X=0.1475 $Y=0.216 $X2=0.162 $Y2=0.216
r4 36 8 0.0462963 $w=5.4e-08 $l=2.5e-09 $layer=P_src_drn $thickness=1e-09
+ $X=0.1446 $Y=0.216 $X2=0.1475 $Y2=0.216
r5 2 32 19.3796 $a=3.24e-16 $layer=V0LISD $X=0.162 $Y=0.216 $X2=0.162 $Y2=0.234
r6 32 33 3.14806 $w=1.3e-08 $l=1.35e-08 $layer=M1 $thickness=3.6e-08 $X=0.162
+ $Y=0.234 $X2=0.1755 $Y2=0.234
r7 30 33 3.14806 $w=1.3e-08 $l=1.35e-08 $layer=M1 $thickness=3.6e-08 $X=0.189
+ $Y=0.234 $X2=0.1755 $Y2=0.234
r8 12 30 6.29612 $w=1.3e-08 $l=2.7e-08 $layer=M1 $thickness=3.6e-08 $X=0.216
+ $Y=0.234 $X2=0.189 $Y2=0.234
r9 10 29 3.01468 $w=1.741e-08 $l=2e-08 $layer=M1 $thickness=3.6e-08 $X=0.243
+ $Y=0.234 $X2=0.243 $Y2=0.214
r10 10 12 4.64701 $w=1.46667e-08 $l=2.7e-08 $layer=M1 $thickness=3.6e-08
+ $X=0.243 $Y=0.234 $X2=0.216 $Y2=0.234
r11 28 29 2.91487 $w=1.3e-08 $l=1.25e-08 $layer=M1 $thickness=3.6e-08 $X=0.243
+ $Y=0.2015 $X2=0.243 $Y2=0.214
r12 27 28 7.87015 $w=1.3e-08 $l=3.38e-08 $layer=M1 $thickness=3.6e-08 $X=0.243
+ $Y=0.1677 $X2=0.243 $Y2=0.2015
r13 26 27 7.63696 $w=1.3e-08 $l=3.27e-08 $layer=M1 $thickness=3.6e-08 $X=0.241
+ $Y=0.135 $X2=0.243 $Y2=0.1677
r14 26 25 3.43955 $w=1.3e-08 $l=1.48e-08 $layer=M1 $thickness=3.6e-08 $X=0.241
+ $Y=0.135 $X2=0.243 $Y2=0.1202
r15 13 25 6.23783 $w=1.3e-08 $l=2.67e-08 $layer=M1 $thickness=3.6e-08 $X=0.243
+ $Y=0.0935 $X2=0.243 $Y2=0.1202
r16 9 24 4.64701 $w=1.46667e-08 $l=2.7e-08 $layer=M1 $thickness=3.6e-08
+ $X=0.243 $Y=0.072 $X2=0.216 $Y2=0.072
r17 9 13 3.36447 $w=1.71023e-08 $l=2.15e-08 $layer=M1 $thickness=3.6e-08
+ $X=0.243 $Y=0.072 $X2=0.243 $Y2=0.0935
r18 23 24 6.29612 $w=1.3e-08 $l=2.7e-08 $layer=M1 $thickness=3.6e-08 $X=0.189
+ $Y=0.072 $X2=0.216 $Y2=0.072
r19 22 23 2.56509 $w=1.3e-08 $l=1.1e-08 $layer=M1 $thickness=3.6e-08 $X=0.178
+ $Y=0.072 $X2=0.189 $Y2=0.072
r20 21 22 3.73104 $w=1.3e-08 $l=1.6e-08 $layer=M1 $thickness=3.6e-08 $X=0.162
+ $Y=0.072 $X2=0.178 $Y2=0.072
r21 20 21 3.73104 $w=1.3e-08 $l=1.6e-08 $layer=M1 $thickness=3.6e-08 $X=0.146
+ $Y=0.072 $X2=0.162 $Y2=0.072
r22 19 20 2.56509 $w=1.3e-08 $l=1.1e-08 $layer=M1 $thickness=3.6e-08 $X=0.135
+ $Y=0.072 $X2=0.146 $Y2=0.072
r23 18 19 3.14806 $w=1.3e-08 $l=1.35e-08 $layer=M1 $thickness=3.6e-08 $X=0.1215
+ $Y=0.072 $X2=0.135 $Y2=0.072
r24 11 18 3.14806 $w=1.3e-08 $l=1.35e-08 $layer=M1 $thickness=3.6e-08 $X=0.108
+ $Y=0.072 $X2=0.1215 $Y2=0.072
r25 1 11 19.3796 $a=3.24e-16 $layer=V0LISD $X=0.108 $Y=0.054 $X2=0.108 $Y2=0.072
r26 17 15 0.0462963 $w=5.4e-08 $l=2.5e-09 $layer=N_src_drn $thickness=1e-09
+ $X=0.1253 $Y=0.054 $X2=0.1225 $Y2=0.054
r27 1 15 0.268519 $w=5.4e-08 $l=1.45e-08 $layer=N_src_drn $thickness=1e-09
+ $X=0.108 $Y=0.054 $X2=0.1225 $Y2=0.054
r28 7 1 0.268519 $w=5.4e-08 $l=1.45e-08 $layer=N_src_drn $thickness=1e-09
+ $X=0.0935 $Y=0.054 $X2=0.108 $Y2=0.054
r29 16 7 0.0462963 $w=5.4e-08 $l=2.5e-09 $layer=N_src_drn $thickness=1e-09
+ $X=0.0906 $Y=0.054 $X2=0.0935 $Y2=0.054
.ends

.subckt PM_OAI21xp33_ASAP7_75t_R%A1 vss 19 5 11 1 3
c1 1 vss 0.0113589f $X=0.081 $Y=0.135
c2 3 vss 0.0831229f $X=0.081 $Y=0.0245
c3 4 vss 0.0178616f $X=0.027 $Y=0.0935
r1 20 21 3.20636 $w=1.3e-08 $l=1.38e-08 $layer=M1 $thickness=3.6e-08 $X=0.027
+ $Y=0.1212 $X2=0.027 $Y2=0.135
r2 19 20 1.45744 $w=1.3e-08 $l=6.2e-09 $layer=M1 $thickness=3.6e-08 $X=0.025
+ $Y=0.115 $X2=0.027 $Y2=0.1212
r3 19 18 1.10765 $w=1.3e-08 $l=4.8e-09 $layer=M1 $thickness=3.6e-08 $X=0.025
+ $Y=0.115 $X2=0.027 $Y2=0.1102
r4 4 18 3.90593 $w=1.3e-08 $l=1.67e-08 $layer=M1 $thickness=3.6e-08 $X=0.027
+ $Y=0.0935 $X2=0.027 $Y2=0.1102
r5 14 15 61.7733 $w=9.3e-09 $l=2.65e-08 $layer=LIG $thickness=4.8e-08 $X=0.027
+ $Y=0.135 $X2=0.0535 $Y2=0.135
r6 14 21 28.9687 $a=2.88e-16 $layer=V0LIG $X=0.027 $Y=0.135 $X2=0.027 $Y2=0.135
r7 1 8 7.58422 $w=1.77778e-08 $layer=LIG $thickness=5.15556e-08 $X=0.081
+ $Y=0.135 $X2=0.081 $Y2=0.135
r8 1 15 45.5208 $w=1.17364e-08 $l=2.75e-08 $layer=LIG $thickness=4.8e-08
+ $X=0.081 $Y=0.135 $X2=0.0535 $Y2=0.135
r9 11 10 14.6259 $w=2.1e-08 $l=4.3e-08 $layer=Gate_1 $thickness=5.6e-08
+ $X=0.081 $Y=0.216 $X2=0.081 $Y2=0.173
r10 9 10 7.82318 $w=2.1e-08 $l=2.3e-08 $layer=Gate_1 $thickness=5.6e-08
+ $X=0.081 $Y=0.15 $X2=0.081 $Y2=0.173
r11 8 9 5.23813 $w=2.04667e-08 $l=1.5e-08 $layer=Gate_1 $thickness=5.6e-08
+ $X=0.081 $Y=0.135 $X2=0.081 $Y2=0.15
r12 7 8 5.23813 $w=2.04667e-08 $l=1.5e-08 $layer=Gate_1 $thickness=5.6e-08
+ $X=0.081 $Y=0.12 $X2=0.081 $Y2=0.135
r13 6 7 7.82318 $w=2.1e-08 $l=2.3e-08 $layer=Gate_1 $thickness=5.6e-08 $X=0.081
+ $Y=0.097 $X2=0.081 $Y2=0.12
r14 5 6 14.6259 $w=2.1e-08 $l=4.3e-08 $layer=Gate_1 $thickness=5.6e-08 $X=0.081
+ $Y=0.054 $X2=0.081 $Y2=0.097
r15 5 3 10.0341 $w=2.1e-08 $l=2.95e-08 $layer=Gate_1 $thickness=5.6e-08
+ $X=0.081 $Y=0.054 $X2=0.081 $Y2=0.0245
.ends

.subckt PM_OAI21xp33_ASAP7_75t_R%A2 vss 13 5 9 1 3 4
c1 1 vss 0.00198068f $X=0.135 $Y=0.135
c2 3 vss 0.0503653f $X=0.135 $Y=0.0245
c3 4 vss 0.0071216f $X=0.135 $Y=0.1132
r1 14 15 2.62338 $w=1.3e-08 $l=1.13e-08 $layer=M1 $thickness=3.6e-08 $X=0.135
+ $Y=0.1237 $X2=0.135 $Y2=0.135
r2 13 14 0.641272 $w=1.3e-08 $l=2.7e-09 $layer=M1 $thickness=3.6e-08 $X=0.134
+ $Y=0.121 $X2=0.135 $Y2=0.1237
r3 13 4 1.80722 $w=1.3e-08 $l=7.8e-09 $layer=M1 $thickness=3.6e-08 $X=0.134
+ $Y=0.121 $X2=0.135 $Y2=0.1132
r4 1 7 8.65438 $w=1.80211e-08 $layer=LIG $thickness=5.26316e-08 $X=0.135
+ $Y=0.135 $X2=0.135 $Y2=0.135
r5 1 15 19.3796 $a=3.24e-16 $layer=V0LIG $X=0.135 $Y=0.135 $X2=0.135 $Y2=0.135
r6 9 8 16.4967 $w=2.1e-08 $l=4.85e-08 $layer=Gate_1 $thickness=5.6e-08 $X=0.135
+ $Y=0.216 $X2=0.135 $Y2=0.1675
r7 7 8 11.2416 $w=2.06615e-08 $l=3.25e-08 $layer=Gate_1 $thickness=5.6e-08
+ $X=0.135 $Y=0.135 $X2=0.135 $Y2=0.1675
r8 6 7 11.2416 $w=2.06615e-08 $l=3.25e-08 $layer=Gate_1 $thickness=5.6e-08
+ $X=0.135 $Y=0.1025 $X2=0.135 $Y2=0.135
r9 5 6 16.4967 $w=2.1e-08 $l=4.85e-08 $layer=Gate_1 $thickness=5.6e-08 $X=0.135
+ $Y=0.054 $X2=0.135 $Y2=0.1025
r10 5 3 10.0341 $w=2.1e-08 $l=2.95e-08 $layer=Gate_1 $thickness=5.6e-08
+ $X=0.135 $Y=0.054 $X2=0.135 $Y2=0.0245
.ends

* End of included file OAI21xp33_ASAP7_75t_R.pex.sp.pex

*
.subckt OAI21xp33_ASAP7_75t_CUSTOM_4_25_0_7 A1 VSS VDD A2 B Y
*
* A1 A1
* VSS VSS
* VDD VDD
* A2 A2
* B B
* Y Y
*
*

M0 N_M0_d N_M0_g noxref_6 VSS nmos_rvt L=2e-08 W=5.4e-08 nfin=2 $X=0.071
+ $Y=0.027
M1 noxref_6 N_M1_g N_M1_s VSS nmos_rvt L=2e-08 W=5.4e-08 nfin=2 $X=0.125
+ $Y=0.027
M2 VSS N_M2_g noxref_6 VSS nmos_rvt L=2e-08 W=5.4e-08 nfin=2 $X=0.179 $Y=0.027
M3 noxref_8 N_M3_g VDD VDD pmos_rvt L=2e-08 W=5.4e-08 nfin=2 $X=0.071 $Y=0.189
M4 N_M4_d N_M4_g noxref_8 VDD pmos_rvt L=2e-08 W=5.4e-08 nfin=2 $X=0.125
+ $Y=0.189
M5 VDD N_M5_g N_M5_s VDD pmos_rvt L=2e-08 W=5.4e-08 nfin=2 $X=0.179 $Y=0.189

* .include "OAI21xp33_ASAP7_75t_R.pex.sp.pxi"

* Start of included file OAI21xp33_ASAP7_75t_R.pex.sp.pxi
x_PM_OAI21xp33_ASAP7_75t_R%B vss B N_M2_g N_M5_g N_B_3 N_B_4
+ PM_OAI21xp33_ASAP7_75t_R%B
cc_1 N_B_3 N_A2_1 0.00151409f $X=0.189 $Y=0.0245
cc_2 N_B_4 N_A2_4 0.00342195f $X=0.189 $Y=0.1102
cc_3 N_B_3 N_A2_3 0.00812883f $X=0.189 $Y=0.0245
x_PM_OAI21xp33_ASAP7_75t_R%Y vss Y N_M0_d N_M1_s N_M4_d N_M5_s N_Y_11 N_Y_7
+ N_Y_12 N_Y_2 N_Y_8 N_Y_13 PM_OAI21xp33_ASAP7_75t_R%Y
cc_4 N_Y_11 N_A1_3 0.000574325f $X=0.108 $Y=0.072
cc_5 N_Y_7 N_A1_3 0.0269567f $X=0.0935 $Y=0.054
cc_6 N_Y_7 N_A2_1 0.00057949f $X=0.0935 $Y=0.054
cc_7 N_Y_12 N_A2_4 0.000611049f $X=0.216 $Y=0.234
cc_8 N_Y_2 N_A2_3 0.000971827f $X=0.162 $Y=0.216
cc_9 N_Y_11 N_A2_4 0.00126012f $X=0.108 $Y=0.072
cc_10 N_Y_2 N_A2_4 0.00243651f $X=0.162 $Y=0.216
cc_11 N_Y_8 N_A2_3 0.0106463f $X=0.1475 $Y=0.216
cc_12 N_Y_7 N_A2_3 0.0408717f $X=0.0935 $Y=0.054
cc_13 N_Y_12 N_B_3 0.000934783f $X=0.216 $Y=0.234
cc_14 N_Y_11 N_B_4 0.0012305f $X=0.108 $Y=0.072
cc_15 N_Y_13 N_B_4 0.006434f $X=0.243 $Y=0.0935
cc_16 N_Y_8 N_B_3 0.0269216f $X=0.1475 $Y=0.216
x_PM_OAI21xp33_ASAP7_75t_R%A1 vss A1 N_M0_g N_M3_g N_A1_1 N_A1_3
+ PM_OAI21xp33_ASAP7_75t_R%A1
x_PM_OAI21xp33_ASAP7_75t_R%A2 vss A2 N_M1_g N_M4_g N_A2_1 N_A2_3 N_A2_4
+ PM_OAI21xp33_ASAP7_75t_R%A2
cc_17 N_A2_1 N_A1_1 0.00207619f $X=0.135 $Y=0.135
cc_18 N_A2_3 N_A1_3 0.010406f $X=0.135 $Y=0.0245

* End of included file OAI21xp33_ASAP7_75t_R.pex.sp.pxi
.ends

.subckt PM_OA33x2_ASAP7_75t_R%A1 vss 12 5 9 4 3
c1 1 vss 0.00659499f $X=0.189 $Y=0.135
c2 3 vss 0.139769f $X=0.189 $Y=0.0245
c3 4 vss 0.00691f $X=0.189 $Y=0.135
r1 12 13 2.85657 $w=1.3e-08 $l=1.22e-08 $layer=M1 $thickness=3.6e-08 $X=0.189
+ $Y=0.102 $X2=0.189 $Y2=0.1142
r2 4 13 4.83869 $w=1.3e-08 $l=2.08e-08 $layer=M1 $thickness=3.6e-08 $X=0.189
+ $Y=0.135 $X2=0.189 $Y2=0.1142
r3 1 7 10.4265 $w=1.765e-08 $layer=LIG $thickness=5.2e-08 $X=0.189 $Y=0.135
+ $X2=0.189 $Y2=0.135
r4 1 4 19.3796 $a=3.24e-16 $layer=V0LIG $X=0.189 $Y=0.135 $X2=0.189 $Y2=0.135
r5 9 8 16.4967 $w=2.1e-08 $l=4.85e-08 $layer=Gate_1 $thickness=5.6e-08 $X=0.189
+ $Y=0.2025 $X2=0.189 $Y2=0.154
r6 7 8 6.6497 $w=2.04211e-08 $l=1.9e-08 $layer=Gate_1 $thickness=5.6e-08
+ $X=0.189 $Y=0.135 $X2=0.189 $Y2=0.154
r7 6 7 6.6497 $w=2.04211e-08 $l=1.9e-08 $layer=Gate_1 $thickness=5.6e-08
+ $X=0.189 $Y=0.116 $X2=0.189 $Y2=0.135
r8 5 6 16.4967 $w=2.1e-08 $l=4.85e-08 $layer=Gate_1 $thickness=5.6e-08 $X=0.189
+ $Y=0.0675 $X2=0.189 $Y2=0.116
r9 5 3 14.6259 $w=2.1e-08 $l=4.3e-08 $layer=Gate_1 $thickness=5.6e-08 $X=0.189
+ $Y=0.0675 $X2=0.189 $Y2=0.0245
.ends

.subckt PM_OA33x2_ASAP7_75t_R%B3 vss 13 5 9 3 4 1
c1 1 vss 0.00721173f $X=0.351 $Y=0.135
c2 3 vss 0.0646078f $X=0.351 $Y=0.0245
c3 4 vss 0.00421923f $X=0.351 $Y=0.116
r1 13 12 0.524677 $w=1.3e-08 $l=2.3e-09 $layer=M1 $thickness=3.6e-08 $X=0.353
+ $Y=0.148 $X2=0.351 $Y2=0.1457
r2 11 12 2.50679 $w=1.3e-08 $l=1.07e-08 $layer=M1 $thickness=3.6e-08 $X=0.351
+ $Y=0.135 $X2=0.351 $Y2=0.1457
r3 4 11 4.4306 $w=1.3e-08 $l=1.9e-08 $layer=M1 $thickness=3.6e-08 $X=0.351
+ $Y=0.116 $X2=0.351 $Y2=0.135
r4 1 7 10.4265 $w=1.765e-08 $layer=LIG $thickness=5.2e-08 $X=0.351 $Y=0.135
+ $X2=0.351 $Y2=0.135
r5 1 11 19.3796 $a=3.24e-16 $layer=V0LIG $X=0.351 $Y=0.135 $X2=0.351 $Y2=0.135
r6 9 8 16.4967 $w=2.1e-08 $l=4.85e-08 $layer=Gate_1 $thickness=5.6e-08 $X=0.351
+ $Y=0.2025 $X2=0.351 $Y2=0.154
r7 7 8 6.6497 $w=2.04211e-08 $l=1.9e-08 $layer=Gate_1 $thickness=5.6e-08
+ $X=0.351 $Y=0.135 $X2=0.351 $Y2=0.154
r8 6 7 6.6497 $w=2.04211e-08 $l=1.9e-08 $layer=Gate_1 $thickness=5.6e-08
+ $X=0.351 $Y=0.116 $X2=0.351 $Y2=0.135
r9 5 6 16.4967 $w=2.1e-08 $l=4.85e-08 $layer=Gate_1 $thickness=5.6e-08 $X=0.351
+ $Y=0.0675 $X2=0.351 $Y2=0.116
r10 5 3 14.6259 $w=2.1e-08 $l=4.3e-08 $layer=Gate_1 $thickness=5.6e-08 $X=0.351
+ $Y=0.0675 $X2=0.351 $Y2=0.0245
.ends

.subckt PM_OA33x2_ASAP7_75t_R%B1 vss 15 5 11 3 4
c1 1 vss 0.00454552f $X=0.459 $Y=0.135
c2 3 vss 0.107019f $X=0.459 $Y=0.0245
c3 4 vss 0.00440706f $X=0.459 $Y=0.116
r1 15 14 1.22425 $w=1.3e-08 $l=5.3e-09 $layer=M1 $thickness=3.6e-08 $X=0.461
+ $Y=0.154 $X2=0.459 $Y2=0.1487
r2 13 14 3.20636 $w=1.3e-08 $l=1.37e-08 $layer=M1 $thickness=3.6e-08 $X=0.459
+ $Y=0.135 $X2=0.459 $Y2=0.1487
r3 4 13 4.4306 $w=1.3e-08 $l=1.9e-08 $layer=M1 $thickness=3.6e-08 $X=0.459
+ $Y=0.116 $X2=0.459 $Y2=0.135
r4 1 8 10.4265 $w=1.765e-08 $layer=LIG $thickness=5.2e-08 $X=0.459 $Y=0.135
+ $X2=0.459 $Y2=0.135
r5 1 13 19.3796 $a=3.24e-16 $layer=V0LIG $X=0.459 $Y=0.135 $X2=0.459 $Y2=0.135
r6 11 10 14.6259 $w=2.1e-08 $l=4.3e-08 $layer=Gate_1 $thickness=5.6e-08
+ $X=0.459 $Y=0.2025 $X2=0.459 $Y2=0.1595
r7 9 10 2.7211 $w=2.1e-08 $l=8e-09 $layer=Gate_1 $thickness=5.6e-08 $X=0.459
+ $Y=0.1515 $X2=0.459 $Y2=0.1595
r8 8 9 5.79936 $w=2.03333e-08 $l=1.65e-08 $layer=Gate_1 $thickness=5.6e-08
+ $X=0.459 $Y=0.135 $X2=0.459 $Y2=0.1515
r9 7 8 5.79936 $w=2.03333e-08 $l=1.65e-08 $layer=Gate_1 $thickness=5.6e-08
+ $X=0.459 $Y=0.1185 $X2=0.459 $Y2=0.135
r10 6 7 2.7211 $w=2.1e-08 $l=8e-09 $layer=Gate_1 $thickness=5.6e-08 $X=0.459
+ $Y=0.1105 $X2=0.459 $Y2=0.1185
r11 5 6 14.6259 $w=2.1e-08 $l=4.3e-08 $layer=Gate_1 $thickness=5.6e-08 $X=0.459
+ $Y=0.0675 $X2=0.459 $Y2=0.1105
r12 5 3 14.6259 $w=2.1e-08 $l=4.3e-08 $layer=Gate_1 $thickness=5.6e-08 $X=0.459
+ $Y=0.0675 $X2=0.459 $Y2=0.0245
.ends

.subckt PM_OA33x2_ASAP7_75t_R%B2 vss 13 5 9 3 1 4
c1 1 vss 0.00298599f $X=0.405 $Y=0.135
c2 3 vss 0.0834142f $X=0.405 $Y=0.0245
c3 4 vss 0.00542802f $X=0.405 $Y=0.116
r1 13 12 3.08976 $w=1.3e-08 $l=1.33e-08 $layer=M1 $thickness=3.6e-08 $X=0.407
+ $Y=0.17 $X2=0.405 $Y2=0.1567
r2 11 12 5.07188 $w=1.3e-08 $l=2.17e-08 $layer=M1 $thickness=3.6e-08 $X=0.405
+ $Y=0.135 $X2=0.405 $Y2=0.1567
r3 4 11 4.4306 $w=1.3e-08 $l=1.9e-08 $layer=M1 $thickness=3.6e-08 $X=0.405
+ $Y=0.116 $X2=0.405 $Y2=0.135
r4 1 7 10.4265 $w=1.765e-08 $layer=LIG $thickness=5.2e-08 $X=0.405 $Y=0.135
+ $X2=0.405 $Y2=0.135
r5 1 11 19.3796 $a=3.24e-16 $layer=V0LIG $X=0.405 $Y=0.135 $X2=0.405 $Y2=0.135
r6 9 8 16.4967 $w=2.1e-08 $l=4.85e-08 $layer=Gate_1 $thickness=5.6e-08 $X=0.405
+ $Y=0.2025 $X2=0.405 $Y2=0.154
r7 7 8 6.6497 $w=2.04211e-08 $l=1.9e-08 $layer=Gate_1 $thickness=5.6e-08
+ $X=0.405 $Y=0.135 $X2=0.405 $Y2=0.154
r8 6 7 6.6497 $w=2.04211e-08 $l=1.9e-08 $layer=Gate_1 $thickness=5.6e-08
+ $X=0.405 $Y=0.116 $X2=0.405 $Y2=0.135
r9 5 6 16.4967 $w=2.1e-08 $l=4.85e-08 $layer=Gate_1 $thickness=5.6e-08 $X=0.405
+ $Y=0.0675 $X2=0.405 $Y2=0.116
r10 5 3 14.6259 $w=2.1e-08 $l=4.3e-08 $layer=Gate_1 $thickness=5.6e-08 $X=0.405
+ $Y=0.0675 $X2=0.405 $Y2=0.0245
.ends

.subckt PM_OA33x2_ASAP7_75t_R%3 vss 25 31 40 43 68 69 82 85 86 22 1 21 13 17 3
+ 16 23 4 14 5 24 15 18 12
c1 1 vss 0.00737565f $X=0.081 $Y=0.135
c2 3 vss 0.00506994f $X=0.324 $Y=0.2025
c3 4 vss 0.00979008f $X=0.378 $Y=0.0675
c4 5 vss 0.00848409f $X=0.486 $Y=0.0675
c5 12 vss 0.0834732f $X=0.081 $Y=0.0245
c6 13 vss 0.0808427f $X=0.135 $Y=0.135
c7 14 vss 0.00633168f $X=0.3635 $Y=0.0675
c8 15 vss 0.0402644f $X=0.4715 $Y=0.0675
c9 16 vss 0.00482581f $X=0.3095 $Y=0.2025
c10 17 vss 0.00125107f $X=0.124 $Y=0.135
c11 18 vss 0.00282019f $X=0.153 $Y=0.234
c12 19 vss 0.00211088f $X=0.513 $Y=0.072
c13 20 vss 0.00344978f $X=0.513 $Y=0.234
c14 21 vss 0.00254472f $X=0.153 $Y=0.1665
c15 22 vss 0.032071f $X=0.171 $Y=0.234
c16 23 vss 0.0113854f $X=0.4725 $Y=0.072
c17 24 vss 0.0081469f $X=0.513 $Y=0.2125
r1 86 84 0.0308642 $w=8.1e-08 $l=2.5e-09 $layer=N_src_drn $thickness=1e-09
+ $X=0.3953 $Y=0.0675 $X2=0.3925 $Y2=0.0675
r2 4 84 0.179012 $w=8.1e-08 $l=1.45e-08 $layer=N_src_drn $thickness=1e-09
+ $X=0.378 $Y=0.0675 $X2=0.3925 $Y2=0.0675
r3 14 4 0.179012 $w=8.1e-08 $l=1.45e-08 $layer=N_src_drn $thickness=1e-09
+ $X=0.3635 $Y=0.0675 $X2=0.378 $Y2=0.0675
r4 85 14 0.0308642 $w=8.1e-08 $l=2.5e-09 $layer=N_src_drn $thickness=1e-09
+ $X=0.3606 $Y=0.0675 $X2=0.3635 $Y2=0.0675
r5 15 5 0.154321 $w=8.1e-08 $l=1.25e-08 $layer=N_src_drn $thickness=1e-09
+ $X=0.4715 $Y=0.0675 $X2=0.486 $Y2=0.0675
r6 82 15 0.0308642 $w=8.1e-08 $l=2.5e-09 $layer=N_src_drn $thickness=1e-09
+ $X=0.4686 $Y=0.0675 $X2=0.4715 $Y2=0.0675
r7 4 79 19.3796 $a=3.24e-16 $layer=V0LISD $X=0.378 $Y=0.0675 $X2=0.378 $Y2=0.072
r8 5 72 19.3796 $a=3.24e-16 $layer=V0LISD $X=0.486 $Y=0.0675 $X2=0.486 $Y2=0.072
r9 79 80 3.14806 $w=1.3e-08 $l=1.35e-08 $layer=M1 $thickness=3.6e-08 $X=0.378
+ $Y=0.072 $X2=0.3915 $Y2=0.072
r10 77 80 3.14806 $w=1.3e-08 $l=1.35e-08 $layer=M1 $thickness=3.6e-08 $X=0.405
+ $Y=0.072 $X2=0.3915 $Y2=0.072
r11 76 77 5.82974 $w=1.3e-08 $l=2.5e-08 $layer=M1 $thickness=3.6e-08 $X=0.43
+ $Y=0.072 $X2=0.405 $Y2=0.072
r12 75 76 4.19742 $w=1.3e-08 $l=1.8e-08 $layer=M1 $thickness=3.6e-08 $X=0.448
+ $Y=0.072 $X2=0.43 $Y2=0.072
r13 74 75 2.56509 $w=1.3e-08 $l=1.1e-08 $layer=M1 $thickness=3.6e-08 $X=0.459
+ $Y=0.072 $X2=0.448 $Y2=0.072
r14 72 73 3.14806 $w=1.3e-08 $l=1.35e-08 $layer=M1 $thickness=3.6e-08 $X=0.486
+ $Y=0.072 $X2=0.4995 $Y2=0.072
r15 23 72 3.14806 $w=1.3e-08 $l=1.35e-08 $layer=M1 $thickness=3.6e-08 $X=0.4725
+ $Y=0.072 $X2=0.486 $Y2=0.072
r16 23 74 3.14806 $w=1.3e-08 $l=1.35e-08 $layer=M1 $thickness=3.6e-08 $X=0.4725
+ $Y=0.072 $X2=0.459 $Y2=0.072
r17 19 71 3.36447 $w=1.71023e-08 $l=2.15e-08 $layer=M1 $thickness=3.6e-08
+ $X=0.513 $Y=0.072 $X2=0.513 $Y2=0.0935
r18 19 73 1.49895 $w=1.63333e-08 $l=1.35e-08 $layer=M1 $thickness=3.6e-08
+ $X=0.513 $Y=0.072 $X2=0.4995 $Y2=0.072
r19 70 71 13.8748 $w=1.3e-08 $l=5.95e-08 $layer=M1 $thickness=3.6e-08 $X=0.513
+ $Y=0.153 $X2=0.513 $Y2=0.0935
r20 24 70 13.8748 $w=1.3e-08 $l=5.95e-08 $layer=M1 $thickness=3.6e-08 $X=0.513
+ $Y=0.2125 $X2=0.513 $Y2=0.153
r21 69 67 0.0308642 $w=8.1e-08 $l=2.5e-09 $layer=P_src_drn $thickness=1e-09
+ $X=0.3413 $Y=0.2025 $X2=0.3385 $Y2=0.2025
r22 3 67 0.179012 $w=8.1e-08 $l=1.45e-08 $layer=P_src_drn $thickness=1e-09
+ $X=0.324 $Y=0.2025 $X2=0.3385 $Y2=0.2025
r23 16 3 0.179012 $w=8.1e-08 $l=1.45e-08 $layer=P_src_drn $thickness=1e-09
+ $X=0.3095 $Y=0.2025 $X2=0.324 $Y2=0.2025
r24 68 16 0.0308642 $w=8.1e-08 $l=2.5e-09 $layer=P_src_drn $thickness=1e-09
+ $X=0.3066 $Y=0.2025 $X2=0.3095 $Y2=0.2025
r25 20 65 4.64701 $w=1.46667e-08 $l=2.7e-08 $layer=M1 $thickness=3.6e-08
+ $X=0.513 $Y=0.234 $X2=0.486 $Y2=0.234
r26 20 24 3.36447 $w=1.71023e-08 $l=2.15e-08 $layer=M1 $thickness=3.6e-08
+ $X=0.513 $Y=0.234 $X2=0.513 $Y2=0.2125
r27 3 57 19.3796 $a=3.24e-16 $layer=V0LISD $X=0.324 $Y=0.2025 $X2=0.324
+ $Y2=0.234
r28 64 65 6.29612 $w=1.3e-08 $l=2.7e-08 $layer=M1 $thickness=3.6e-08 $X=0.459
+ $Y=0.234 $X2=0.486 $Y2=0.234
r29 63 64 6.29612 $w=1.3e-08 $l=2.7e-08 $layer=M1 $thickness=3.6e-08 $X=0.432
+ $Y=0.234 $X2=0.459 $Y2=0.234
r30 62 63 6.29612 $w=1.3e-08 $l=2.7e-08 $layer=M1 $thickness=3.6e-08 $X=0.405
+ $Y=0.234 $X2=0.432 $Y2=0.234
r31 61 62 5.82974 $w=1.3e-08 $l=2.5e-08 $layer=M1 $thickness=3.6e-08 $X=0.38
+ $Y=0.234 $X2=0.405 $Y2=0.234
r32 60 61 4.19742 $w=1.3e-08 $l=1.8e-08 $layer=M1 $thickness=3.6e-08 $X=0.362
+ $Y=0.234 $X2=0.38 $Y2=0.234
r33 59 60 2.56509 $w=1.3e-08 $l=1.1e-08 $layer=M1 $thickness=3.6e-08 $X=0.351
+ $Y=0.234 $X2=0.362 $Y2=0.234
r34 58 59 3.14806 $w=1.3e-08 $l=1.35e-08 $layer=M1 $thickness=3.6e-08 $X=0.3375
+ $Y=0.234 $X2=0.351 $Y2=0.234
r35 57 58 3.14806 $w=1.3e-08 $l=1.35e-08 $layer=M1 $thickness=3.6e-08 $X=0.324
+ $Y=0.234 $X2=0.3375 $Y2=0.234
r36 56 57 3.14806 $w=1.3e-08 $l=1.35e-08 $layer=M1 $thickness=3.6e-08 $X=0.3105
+ $Y=0.234 $X2=0.324 $Y2=0.234
r37 55 56 3.14806 $w=1.3e-08 $l=1.35e-08 $layer=M1 $thickness=3.6e-08 $X=0.297
+ $Y=0.234 $X2=0.3105 $Y2=0.234
r38 54 55 6.29612 $w=1.3e-08 $l=2.7e-08 $layer=M1 $thickness=3.6e-08 $X=0.27
+ $Y=0.234 $X2=0.297 $Y2=0.234
r39 53 54 6.29612 $w=1.3e-08 $l=2.7e-08 $layer=M1 $thickness=3.6e-08 $X=0.243
+ $Y=0.234 $X2=0.27 $Y2=0.234
r40 52 53 5.82974 $w=1.3e-08 $l=2.5e-08 $layer=M1 $thickness=3.6e-08 $X=0.218
+ $Y=0.234 $X2=0.243 $Y2=0.234
r41 51 52 4.19742 $w=1.3e-08 $l=1.8e-08 $layer=M1 $thickness=3.6e-08 $X=0.2
+ $Y=0.234 $X2=0.218 $Y2=0.234
r42 50 51 2.56509 $w=1.3e-08 $l=1.1e-08 $layer=M1 $thickness=3.6e-08 $X=0.189
+ $Y=0.234 $X2=0.2 $Y2=0.234
r43 22 50 4.19742 $w=1.3e-08 $l=1.8e-08 $layer=M1 $thickness=3.6e-08 $X=0.171
+ $Y=0.234 $X2=0.189 $Y2=0.234
r44 18 49 3.36447 $w=1.71023e-08 $l=2.15e-08 $layer=M1 $thickness=3.6e-08
+ $X=0.153 $Y=0.234 $X2=0.153 $Y2=0.2125
r45 18 22 2.5483 $w=1.55e-08 $l=1.8e-08 $layer=M1 $thickness=3.6e-08 $X=0.153
+ $Y=0.234 $X2=0.171 $Y2=0.234
r46 48 49 4.19742 $w=1.3e-08 $l=1.8e-08 $layer=M1 $thickness=3.6e-08 $X=0.153
+ $Y=0.1945 $X2=0.153 $Y2=0.2125
r47 21 47 6.16517 $w=1.44286e-08 $l=3.15e-08 $layer=M1 $thickness=3.6e-08
+ $X=0.153 $Y=0.1665 $X2=0.153 $Y2=0.135
r48 21 48 6.52931 $w=1.3e-08 $l=2.8e-08 $layer=M1 $thickness=3.6e-08 $X=0.153
+ $Y=0.1665 $X2=0.153 $Y2=0.1945
r49 45 47 3.01711 $w=1.55e-08 $l=1.8e-08 $layer=M1 $thickness=3.6e-08 $X=0.135
+ $Y=0.135 $X2=0.153 $Y2=0.135
r50 17 45 2.56509 $w=1.3e-08 $l=1.1e-08 $layer=M1 $thickness=3.6e-08 $X=0.124
+ $Y=0.135 $X2=0.135 $Y2=0.135
r51 43 42 16.4967 $w=2.1e-08 $l=4.85e-08 $layer=Gate_1 $thickness=5.6e-08
+ $X=0.135 $Y=0.2025 $X2=0.135 $Y2=0.154
r52 40 41 16.4967 $w=2.1e-08 $l=4.85e-08 $layer=Gate_1 $thickness=5.6e-08
+ $X=0.135 $Y=0.0675 $X2=0.135 $Y2=0.116
r53 13 36 6.27904 $w=2.09e-08 $layer=Gate_1 $thickness=5.24e-08 $X=0.135
+ $Y=0.135 $X2=0.135 $Y2=0.135
r54 13 41 6.6497 $w=2.04211e-08 $l=1.9e-08 $layer=Gate_1 $thickness=5.6e-08
+ $X=0.135 $Y=0.135 $X2=0.135 $Y2=0.116
r55 13 42 6.6497 $w=2.04211e-08 $l=1.9e-08 $layer=Gate_1 $thickness=5.6e-08
+ $X=0.135 $Y=0.135 $X2=0.135 $Y2=0.154
r56 36 45 19.3796 $a=3.24e-16 $layer=V0LIG $X=0.135 $Y=0.135 $X2=0.135 $Y2=0.135
r57 35 36 2.48102 $w=2.2e-08 $l=9.5e-09 $layer=LIG $thickness=4.8e-08 $X=0.1255
+ $Y=0.135 $X2=0.135 $Y2=0.135
r58 34 35 10.1729 $w=1.54914e-08 $l=1.75e-08 $layer=LIG $thickness=4.8e-08
+ $X=0.108 $Y=0.135 $X2=0.1255 $Y2=0.135
r59 1 28 6.54019 $w=2.09524e-08 $layer=Gate_1 $thickness=5.21905e-08 $X=0.081
+ $Y=0.135 $X2=0.081 $Y2=0.135
r60 1 34 12.6539 $w=1.77815e-08 $l=2.7e-08 $layer=LIG $thickness=4.8e-08
+ $X=0.081 $Y=0.135 $X2=0.108 $Y2=0.135
r61 31 30 14.6259 $w=2.1e-08 $l=4.3e-08 $layer=Gate_1 $thickness=5.6e-08
+ $X=0.081 $Y=0.2025 $X2=0.081 $Y2=0.1595
r62 29 30 2.7211 $w=2.1e-08 $l=8e-09 $layer=Gate_1 $thickness=5.6e-08 $X=0.081
+ $Y=0.1515 $X2=0.081 $Y2=0.1595
r63 28 29 5.79936 $w=2.03333e-08 $l=1.65e-08 $layer=Gate_1 $thickness=5.6e-08
+ $X=0.081 $Y=0.135 $X2=0.081 $Y2=0.1515
r64 27 28 5.79936 $w=2.03333e-08 $l=1.65e-08 $layer=Gate_1 $thickness=5.6e-08
+ $X=0.081 $Y=0.1185 $X2=0.081 $Y2=0.135
r65 26 27 2.7211 $w=2.1e-08 $l=8e-09 $layer=Gate_1 $thickness=5.6e-08 $X=0.081
+ $Y=0.1105 $X2=0.081 $Y2=0.1185
r66 25 26 14.6259 $w=2.1e-08 $l=4.3e-08 $layer=Gate_1 $thickness=5.6e-08
+ $X=0.081 $Y=0.0675 $X2=0.081 $Y2=0.1105
r67 25 12 14.6259 $w=2.1e-08 $l=4.3e-08 $layer=Gate_1 $thickness=5.6e-08
+ $X=0.081 $Y=0.0675 $X2=0.081 $Y2=0.0245
.ends

.subckt PM_OA33x2_ASAP7_75t_R%Y vss 27 20 21 36 37 8 2 11 7
c1 1 vss 0.00970538f $X=0.108 $Y=0.0675
c2 2 vss 0.00746401f $X=0.108 $Y=0.2025
c3 7 vss 0.00442017f $X=0.0935 $Y=0.0675
c4 8 vss 0.00439844f $X=0.0935 $Y=0.2025
c5 9 vss 0.00290742f $X=0.027 $Y=0.036
c6 10 vss 0.00290812f $X=0.027 $Y=0.234
c7 11 vss 0.00105043f $X=0.108 $Y=0.198
c8 12 vss 0.00251457f $X=0.108 $Y=0.234
c9 13 vss 0.00835865f $X=0.027 $Y=0.0575
c10 14 vss 0.00920166f $X=0.0805 $Y=0.036
c11 15 vss 0.0058038f $X=0.049 $Y=0.234
c12 16 vss 0.00131267f $X=0.0805 $Y=0.198
c13 17 vss 0.000332484f $X=0.108 $Y=0.216
r1 37 35 0.0308642 $w=8.1e-08 $l=2.5e-09 $layer=P_src_drn $thickness=1e-09
+ $X=0.1253 $Y=0.2025 $X2=0.1225 $Y2=0.2025
r2 2 35 0.179012 $w=8.1e-08 $l=1.45e-08 $layer=P_src_drn $thickness=1e-09
+ $X=0.108 $Y=0.2025 $X2=0.1225 $Y2=0.2025
r3 8 2 0.179012 $w=8.1e-08 $l=1.45e-08 $layer=P_src_drn $thickness=1e-09
+ $X=0.0935 $Y=0.2025 $X2=0.108 $Y2=0.2025
r4 36 8 0.0308642 $w=8.1e-08 $l=2.5e-09 $layer=P_src_drn $thickness=1e-09
+ $X=0.0906 $Y=0.2025 $X2=0.0935 $Y2=0.2025
r5 2 17 19.3796 $a=3.24e-16 $layer=V0LISD $X=0.108 $Y=0.2025 $X2=0.108 $Y2=0.216
r6 11 17 2.5483 $w=1.79e-08 $l=1.8e-08 $layer=M1 $thickness=3.6e-08 $X=0.108
+ $Y=0.198 $X2=0.108 $Y2=0.216
r7 11 16 4.76361 $w=1.46364e-08 $l=2.75e-08 $layer=M1 $thickness=3.6e-08
+ $X=0.108 $Y=0.198 $X2=0.0805 $Y2=0.198
r8 12 33 4.76361 $w=1.46364e-08 $l=2.75e-08 $layer=M1 $thickness=3.6e-08
+ $X=0.108 $Y=0.234 $X2=0.0805 $Y2=0.234
r9 12 17 2.5483 $w=1.79e-08 $l=1.8e-08 $layer=M1 $thickness=3.6e-08 $X=0.108
+ $Y=0.234 $X2=0.108 $Y2=0.216
r10 15 33 7.34548 $w=1.3e-08 $l=3.15e-08 $layer=M1 $thickness=3.6e-08 $X=0.049
+ $Y=0.234 $X2=0.0805 $Y2=0.234
r11 10 32 2.5483 $w=1.79e-08 $l=1.8e-08 $layer=M1 $thickness=3.6e-08 $X=0.027
+ $Y=0.234 $X2=0.027 $Y2=0.216
r12 10 15 3.48106 $w=1.50455e-08 $l=2.2e-08 $layer=M1 $thickness=3.6e-08
+ $X=0.027 $Y=0.234 $X2=0.049 $Y2=0.234
r13 31 32 4.19742 $w=1.3e-08 $l=1.8e-08 $layer=M1 $thickness=3.6e-08 $X=0.027
+ $Y=0.198 $X2=0.027 $Y2=0.216
r14 30 31 7.34548 $w=1.3e-08 $l=3.15e-08 $layer=M1 $thickness=3.6e-08 $X=0.027
+ $Y=0.1665 $X2=0.027 $Y2=0.198
r15 29 30 7.34548 $w=1.3e-08 $l=3.15e-08 $layer=M1 $thickness=3.6e-08 $X=0.027
+ $Y=0.135 $X2=0.027 $Y2=0.1665
r16 28 29 4.83869 $w=1.3e-08 $l=2.08e-08 $layer=M1 $thickness=3.6e-08 $X=0.027
+ $Y=0.1142 $X2=0.027 $Y2=0.135
r17 27 28 2.85657 $w=1.3e-08 $l=1.22e-08 $layer=M1 $thickness=3.6e-08 $X=0.029
+ $Y=0.102 $X2=0.027 $Y2=0.1142
r18 27 26 3.78933 $w=1.3e-08 $l=1.63e-08 $layer=M1 $thickness=3.6e-08 $X=0.029
+ $Y=0.102 $X2=0.027 $Y2=0.0857
r19 13 26 6.58761 $w=1.3e-08 $l=2.82e-08 $layer=M1 $thickness=3.6e-08 $X=0.027
+ $Y=0.0575 $X2=0.027 $Y2=0.0857
r20 9 23 3.48106 $w=1.50455e-08 $l=2.2e-08 $layer=M1 $thickness=3.6e-08
+ $X=0.027 $Y=0.036 $X2=0.049 $Y2=0.036
r21 9 13 3.36447 $w=1.71023e-08 $l=2.15e-08 $layer=M1 $thickness=3.6e-08
+ $X=0.027 $Y=0.036 $X2=0.027 $Y2=0.0575
r22 14 22 6.41272 $w=1.3e-08 $l=2.75e-08 $layer=M1 $thickness=3.6e-08 $X=0.0805
+ $Y=0.036 $X2=0.108 $Y2=0.036
r23 14 23 7.34548 $w=1.3e-08 $l=3.15e-08 $layer=M1 $thickness=3.6e-08 $X=0.0805
+ $Y=0.036 $X2=0.049 $Y2=0.036
r24 1 22 19.3796 $a=3.24e-16 $layer=V0LISD $X=0.108 $Y=0.0675 $X2=0.108
+ $Y2=0.036
r25 21 19 0.0308642 $w=8.1e-08 $l=2.5e-09 $layer=N_src_drn $thickness=1e-09
+ $X=0.1253 $Y=0.0675 $X2=0.1225 $Y2=0.0675
r26 1 19 0.179012 $w=8.1e-08 $l=1.45e-08 $layer=N_src_drn $thickness=1e-09
+ $X=0.108 $Y=0.0675 $X2=0.1225 $Y2=0.0675
r27 7 1 0.179012 $w=8.1e-08 $l=1.45e-08 $layer=N_src_drn $thickness=1e-09
+ $X=0.0935 $Y=0.0675 $X2=0.108 $Y2=0.0675
r28 20 7 0.0308642 $w=8.1e-08 $l=2.5e-09 $layer=N_src_drn $thickness=1e-09
+ $X=0.0906 $Y=0.0675 $X2=0.0935 $Y2=0.0675
.ends

.subckt PM_OA33x2_ASAP7_75t_R%A2 vss 13 5 9 4 3
c1 1 vss 0.00438576f $X=0.243 $Y=0.135
c2 3 vss 0.121175f $X=0.243 $Y=0.0245
c3 4 vss 0.00676089f $X=0.243 $Y=0.098
r1 13 12 3.55614 $w=1.3e-08 $l=1.53e-08 $layer=M1 $thickness=3.6e-08 $X=0.243
+ $Y=0.174 $X2=0.243 $Y2=0.1587
r2 11 12 5.53826 $w=1.3e-08 $l=2.37e-08 $layer=M1 $thickness=3.6e-08 $X=0.243
+ $Y=0.135 $X2=0.243 $Y2=0.1587
r3 4 11 8.62802 $w=1.3e-08 $l=3.7e-08 $layer=M1 $thickness=3.6e-08 $X=0.243
+ $Y=0.098 $X2=0.243 $Y2=0.135
r4 1 7 10.4265 $w=1.765e-08 $layer=LIG $thickness=5.2e-08 $X=0.243 $Y=0.135
+ $X2=0.243 $Y2=0.135
r5 1 11 19.3796 $a=3.24e-16 $layer=V0LIG $X=0.243 $Y=0.135 $X2=0.243 $Y2=0.135
r6 9 8 16.4967 $w=2.1e-08 $l=4.85e-08 $layer=Gate_1 $thickness=5.6e-08 $X=0.243
+ $Y=0.2025 $X2=0.243 $Y2=0.154
r7 7 8 6.6497 $w=2.04211e-08 $l=1.9e-08 $layer=Gate_1 $thickness=5.6e-08
+ $X=0.243 $Y=0.135 $X2=0.243 $Y2=0.154
r8 6 7 6.6497 $w=2.04211e-08 $l=1.9e-08 $layer=Gate_1 $thickness=5.6e-08
+ $X=0.243 $Y=0.116 $X2=0.243 $Y2=0.135
r9 5 6 16.4967 $w=2.1e-08 $l=4.85e-08 $layer=Gate_1 $thickness=5.6e-08 $X=0.243
+ $Y=0.0675 $X2=0.243 $Y2=0.116
r10 5 3 14.6259 $w=2.1e-08 $l=4.3e-08 $layer=Gate_1 $thickness=5.6e-08 $X=0.243
+ $Y=0.0675 $X2=0.243 $Y2=0.0245
.ends

.subckt PM_OA33x2_ASAP7_75t_R%A3 vss 11 5 9 3 4
c1 1 vss 0.00439232f $X=0.297 $Y=0.135
c2 3 vss 0.102375f $X=0.297 $Y=0.0245
c3 4 vss 0.00949868f $X=0.297 $Y=0.0912
r1 14 15 4.4306 $w=1.3e-08 $l=1.9e-08 $layer=M1 $thickness=3.6e-08 $X=0.297
+ $Y=0.116 $X2=0.297 $Y2=0.135
r2 12 14 2.73998 $w=1.3e-08 $l=1.18e-08 $layer=M1 $thickness=3.6e-08 $X=0.297
+ $Y=0.1042 $X2=0.297 $Y2=0.116
r3 11 12 0.524677 $w=1.3e-08 $l=2.2e-09 $layer=M1 $thickness=3.6e-08 $X=0.298
+ $Y=0.102 $X2=0.297 $Y2=0.1042
r4 11 4 2.50679 $w=1.3e-08 $l=1.08e-08 $layer=M1 $thickness=3.6e-08 $X=0.298
+ $Y=0.102 $X2=0.297 $Y2=0.0912
r5 1 7 10.4265 $w=1.765e-08 $layer=LIG $thickness=5.2e-08 $X=0.297 $Y=0.135
+ $X2=0.297 $Y2=0.135
r6 1 15 19.3796 $a=3.24e-16 $layer=V0LIG $X=0.297 $Y=0.135 $X2=0.297 $Y2=0.135
r7 9 8 16.4967 $w=2.1e-08 $l=4.85e-08 $layer=Gate_1 $thickness=5.6e-08 $X=0.297
+ $Y=0.2025 $X2=0.297 $Y2=0.154
r8 7 8 6.6497 $w=2.04211e-08 $l=1.9e-08 $layer=Gate_1 $thickness=5.6e-08
+ $X=0.297 $Y=0.135 $X2=0.297 $Y2=0.154
r9 6 7 6.6497 $w=2.04211e-08 $l=1.9e-08 $layer=Gate_1 $thickness=5.6e-08
+ $X=0.297 $Y=0.116 $X2=0.297 $Y2=0.135
r10 5 6 16.4967 $w=2.1e-08 $l=4.85e-08 $layer=Gate_1 $thickness=5.6e-08
+ $X=0.297 $Y=0.0675 $X2=0.297 $Y2=0.116
r11 5 3 14.6259 $w=2.1e-08 $l=4.3e-08 $layer=Gate_1 $thickness=5.6e-08 $X=0.297
+ $Y=0.0675 $X2=0.297 $Y2=0.0245
.ends

* End of included file OA33x2_ASAP7_75t_R.pex.sp.pex

*
.subckt OA33x2_ASAP7_75t_CUSTOM_4_25_0_7 VSS VDD A1 A2 A3 B3 B2 B1 Y
*
* VSS VSS
* VDD VDD
* A1 A1
* A2 A2
* A3 A3
* B3 B3
* B2 B2
* B1 B1
* Y Y
*
*

M0 N_M0_d N_M0_g VSS VSS nmos_rvt L=2e-08 W=8.1e-08 nfin=3 $X=0.071 $Y=0.027
M1 N_M1_d N_M1_g VSS VSS nmos_rvt L=2e-08 W=8.1e-08 nfin=3 $X=0.125 $Y=0.027
M2 noxref_11 N_M2_g VSS VSS nmos_rvt L=2e-08 W=8.1e-08 nfin=3 $X=0.179 $Y=0.027
M3 VSS N_M3_g noxref_11 VSS nmos_rvt L=2e-08 W=8.1e-08 nfin=3 $X=0.233 $Y=0.027
M4 noxref_11 N_M4_g VSS VSS nmos_rvt L=2e-08 W=8.1e-08 nfin=3 $X=0.287 $Y=0.027
M5 N_M5_d N_M5_g noxref_11 VSS nmos_rvt L=2e-08 W=8.1e-08 nfin=3 $X=0.341
+ $Y=0.027
M6 noxref_11 N_M6_g N_M6_s VSS nmos_rvt L=2e-08 W=8.1e-08 nfin=3 $X=0.395
+ $Y=0.027
M7 N_M7_d N_M7_g noxref_11 VSS nmos_rvt L=2e-08 W=8.1e-08 nfin=3 $X=0.449
+ $Y=0.027
M8 N_M8_d N_M8_g VDD VDD pmos_rvt L=2e-08 W=8.1e-08 nfin=3 $X=0.071 $Y=0.162
M9 N_M9_d N_M9_g VDD VDD pmos_rvt L=2e-08 W=8.1e-08 nfin=3 $X=0.125 $Y=0.162
M10 noxref_12 N_M10_g VDD VDD pmos_rvt L=2e-08 W=8.1e-08 nfin=3 $X=0.179
+ $Y=0.162
M11 noxref_13 N_M11_g noxref_12 VDD pmos_rvt L=2e-08 W=8.1e-08 nfin=3 $X=0.233
+ $Y=0.162
M12 N_M12_d N_M12_g noxref_13 VDD pmos_rvt L=2e-08 W=8.1e-08 nfin=3 $X=0.287
+ $Y=0.162
M13 noxref_14 N_M13_g N_M13_s VDD pmos_rvt L=2e-08 W=8.1e-08 nfin=3 $X=0.341
+ $Y=0.162
M14 noxref_15 N_M14_g noxref_14 VDD pmos_rvt L=2e-08 W=8.1e-08 nfin=3 $X=0.395
+ $Y=0.162
M15 VDD N_M15_g noxref_15 VDD pmos_rvt L=2e-08 W=8.1e-08 nfin=3 $X=0.449
+ $Y=0.162

* .include "OA33x2_ASAP7_75t_R.pex.sp.pxi"

* Start of included file OA33x2_ASAP7_75t_R.pex.sp.pxi
x_PM_OA33x2_ASAP7_75t_R%A1 vss A1 N_M2_g N_M10_g N_A1_4 N_A1_3
+ PM_OA33x2_ASAP7_75t_R%A1
cc_1 N_A1_4 N_3_22 0.00100419f $X=0.189 $Y=0.135
cc_2 N_A1_4 N_3_1 0.00144463f $X=0.189 $Y=0.135
cc_3 N_A1_4 N_3_21 0.00216836f $X=0.189 $Y=0.135
cc_4 N_A1_3 N_3_13 0.00340163f $X=0.189 $Y=0.0245
cc_5 N_A1_4 N_3_17 0.00627801f $X=0.189 $Y=0.135
x_PM_OA33x2_ASAP7_75t_R%B3 vss B3 N_M5_g N_M13_g N_B3_3 N_B3_4 N_B3_1
+ PM_OA33x2_ASAP7_75t_R%B3
cc_6 N_B3_3 N_3_16 0.0153383f $X=0.351 $Y=0.0245
cc_7 N_B3_3 N_3_3 0.0019827f $X=0.351 $Y=0.0245
cc_8 N_B3_3 N_3_23 0.000530726f $X=0.351 $Y=0.0245
cc_9 N_B3_3 N_3_4 0.000804495f $X=0.351 $Y=0.0245
cc_10 N_B3_4 N_3_22 0.00124661f $X=0.351 $Y=0.116
cc_11 N_B3_1 N_3_16 0.00146265f $X=0.351 $Y=0.135
cc_12 N_B3_4 N_3_3 0.00255504f $X=0.351 $Y=0.116
cc_13 N_B3_3 N_3_14 0.0543795f $X=0.351 $Y=0.0245
cc_14 N_B3_3 N_A3_3 0.00315865f $X=0.351 $Y=0.0245
cc_15 N_B3_4 N_A3_4 0.00535569f $X=0.351 $Y=0.116
x_PM_OA33x2_ASAP7_75t_R%B1 vss B1 N_M7_g N_M15_g N_B1_3 N_B1_4
+ PM_OA33x2_ASAP7_75t_R%B1
cc_16 N_B1_3 N_3_5 0.00163515f $X=0.459 $Y=0.0245
cc_17 N_B1_4 N_3_23 0.00103176f $X=0.459 $Y=0.116
cc_18 N_B1_4 N_3_22 0.00121056f $X=0.459 $Y=0.116
cc_19 N_B1_4 N_3_24 0.00613486f $X=0.459 $Y=0.116
cc_20 N_B1_3 N_3_15 0.0358654f $X=0.459 $Y=0.0245
cc_21 N_B1_4 N_B2_4 0.00336196f $X=0.459 $Y=0.116
cc_22 N_B1_3 N_B2_3 0.0070881f $X=0.459 $Y=0.0245
x_PM_OA33x2_ASAP7_75t_R%B2 vss B2 N_M6_g N_M14_g N_B2_3 N_B2_1 N_B2_4
+ PM_OA33x2_ASAP7_75t_R%B2
cc_23 N_B2_3 N_3_3 0.00035444f $X=0.405 $Y=0.0245
cc_24 N_B2_3 N_3_4 0.00130884f $X=0.405 $Y=0.0245
cc_25 N_B2_1 N_3_14 0.000809917f $X=0.405 $Y=0.135
cc_26 N_B2_4 N_3_23 0.00105749f $X=0.405 $Y=0.116
cc_27 N_B2_4 N_3_22 0.00146502f $X=0.405 $Y=0.116
cc_28 N_B2_4 N_3_4 0.00272462f $X=0.405 $Y=0.116
cc_29 N_B2_3 N_3_14 0.0349412f $X=0.405 $Y=0.0245
cc_30 N_B2_4 N_B3_4 0.00332835f $X=0.405 $Y=0.116
cc_31 N_B2_3 N_B3_3 0.00695687f $X=0.405 $Y=0.0245
x_PM_OA33x2_ASAP7_75t_R%3 vss N_M0_g N_M8_g N_M1_g N_M9_g N_M12_d N_M13_s
+ N_M7_d N_M5_d N_M6_s N_3_22 N_3_1 N_3_21 N_3_13 N_3_17 N_3_3 N_3_16 N_3_23
+ N_3_4 N_3_14 N_3_5 N_3_24 N_3_15 N_3_18 N_3_12 PM_OA33x2_ASAP7_75t_R%3
x_PM_OA33x2_ASAP7_75t_R%Y vss Y N_M0_d N_M1_d N_M8_d N_M9_d N_Y_8 N_Y_2 N_Y_11
+ N_Y_7 PM_OA33x2_ASAP7_75t_R%Y
cc_32 N_Y_8 N_3_21 0.00127714f $X=0.0935 $Y=0.2025
cc_33 N_Y_8 N_3_1 0.00637221f $X=0.0935 $Y=0.2025
cc_34 N_Y_8 N_3_17 0.000944462f $X=0.0935 $Y=0.2025
cc_35 N_Y_8 N_3_18 0.0010914f $X=0.0935 $Y=0.2025
cc_36 N_Y_8 N_3_13 0.00166186f $X=0.0935 $Y=0.2025
cc_37 N_Y_2 N_3_12 0.00194229f $X=0.108 $Y=0.2025
cc_38 N_Y_11 N_3_21 0.0025222f $X=0.108 $Y=0.198
cc_39 N_Y_7 N_3_13 0.065859f $X=0.0935 $Y=0.0675
cc_40 N_Y_8 N_3_12 0.0684056f $X=0.0935 $Y=0.2025
x_PM_OA33x2_ASAP7_75t_R%A2 vss A2 N_M3_g N_M11_g N_A2_4 N_A2_3
+ PM_OA33x2_ASAP7_75t_R%A2
cc_41 N_A2_4 N_3_3 0.000364355f $X=0.243 $Y=0.098
cc_42 N_A2_4 N_3_22 0.00144263f $X=0.243 $Y=0.098
cc_43 N_A2_4 N_3_17 0.00223549f $X=0.243 $Y=0.098
cc_44 N_A2_4 N_A1_4 0.00459542f $X=0.243 $Y=0.098
cc_45 N_A2_3 N_A1_3 0.00704927f $X=0.243 $Y=0.0245
x_PM_OA33x2_ASAP7_75t_R%A3 vss A3 N_M4_g N_M12_g N_A3_3 N_A3_4
+ PM_OA33x2_ASAP7_75t_R%A3
cc_46 N_A3_3 N_3_3 0.00172825f $X=0.297 $Y=0.0245
cc_47 N_A3_4 N_3_22 0.0012722f $X=0.297 $Y=0.0912
cc_48 N_A3_4 N_3_3 0.00212387f $X=0.297 $Y=0.0912
cc_49 N_A3_3 N_3_16 0.0362215f $X=0.297 $Y=0.0245
cc_50 N_A3_4 N_A2_4 0.00462484f $X=0.297 $Y=0.0912
cc_51 N_A3_3 N_A2_3 0.00695879f $X=0.297 $Y=0.0245

* End of included file OA33x2_ASAP7_75t_R.pex.sp.pxi
.ends

.subckt PM_OA331x1_ASAP7_75t_R%A3 vss 16 5 9 3 4
c1 1 vss 0.00665338f $X=0.135 $Y=0.135
c2 3 vss 0.139599f $X=0.135 $Y=0.0245
c3 4 vss 0.00695205f $X=0.135 $Y=0.1105
r1 16 15 1.34084 $w=1.3e-08 $l=5.8e-09 $layer=M1 $thickness=3.6e-08 $X=0.135
+ $Y=0.155 $X2=0.135 $Y2=0.1492
r2 14 15 3.32295 $w=1.3e-08 $l=1.42e-08 $layer=M1 $thickness=3.6e-08 $X=0.135
+ $Y=0.135 $X2=0.135 $Y2=0.1492
r3 13 14 3.38125 $w=1.3e-08 $l=1.45e-08 $layer=M1 $thickness=3.6e-08 $X=0.135
+ $Y=0.1205 $X2=0.135 $Y2=0.135
r4 4 13 2.3319 $w=1.3e-08 $l=1e-08 $layer=M1 $thickness=3.6e-08 $X=0.135
+ $Y=0.1105 $X2=0.135 $Y2=0.1205
r5 1 7 10.4265 $w=1.765e-08 $layer=LIG $thickness=5.2e-08 $X=0.135 $Y=0.135
+ $X2=0.135 $Y2=0.135
r6 1 14 19.3796 $a=3.24e-16 $layer=V0LIG $X=0.135 $Y=0.135 $X2=0.135 $Y2=0.135
r7 9 8 16.4967 $w=2.1e-08 $l=4.85e-08 $layer=Gate_1 $thickness=5.6e-08 $X=0.135
+ $Y=0.2025 $X2=0.135 $Y2=0.154
r8 7 8 6.6497 $w=2.04211e-08 $l=1.9e-08 $layer=Gate_1 $thickness=5.6e-08
+ $X=0.135 $Y=0.135 $X2=0.135 $Y2=0.154
r9 6 7 6.6497 $w=2.04211e-08 $l=1.9e-08 $layer=Gate_1 $thickness=5.6e-08
+ $X=0.135 $Y=0.116 $X2=0.135 $Y2=0.135
r10 5 6 16.4967 $w=2.1e-08 $l=4.85e-08 $layer=Gate_1 $thickness=5.6e-08
+ $X=0.135 $Y=0.0675 $X2=0.135 $Y2=0.116
r11 5 3 14.6259 $w=2.1e-08 $l=4.3e-08 $layer=Gate_1 $thickness=5.6e-08 $X=0.135
+ $Y=0.0675 $X2=0.135 $Y2=0.0245
.ends

.subckt PM_OA331x1_ASAP7_75t_R%A1 vss 13 5 9 4 3
c1 1 vss 0.00471918f $X=0.243 $Y=0.135
c2 3 vss 0.102285f $X=0.243 $Y=0.0245
c3 4 vss 0.00705316f $X=0.243 $Y=0.116
r1 13 12 1.34084 $w=1.3e-08 $l=5.8e-09 $layer=M1 $thickness=3.6e-08 $X=0.243
+ $Y=0.155 $X2=0.243 $Y2=0.1492
r2 11 12 3.32295 $w=1.3e-08 $l=1.42e-08 $layer=M1 $thickness=3.6e-08 $X=0.243
+ $Y=0.135 $X2=0.243 $Y2=0.1492
r3 4 11 4.4306 $w=1.3e-08 $l=1.9e-08 $layer=M1 $thickness=3.6e-08 $X=0.243
+ $Y=0.116 $X2=0.243 $Y2=0.135
r4 1 7 10.4265 $w=1.765e-08 $layer=LIG $thickness=5.2e-08 $X=0.243 $Y=0.135
+ $X2=0.243 $Y2=0.135
r5 1 11 19.3796 $a=3.24e-16 $layer=V0LIG $X=0.243 $Y=0.135 $X2=0.243 $Y2=0.135
r6 9 8 16.4967 $w=2.1e-08 $l=4.85e-08 $layer=Gate_1 $thickness=5.6e-08 $X=0.243
+ $Y=0.2025 $X2=0.243 $Y2=0.154
r7 7 8 6.6497 $w=2.04211e-08 $l=1.9e-08 $layer=Gate_1 $thickness=5.6e-08
+ $X=0.243 $Y=0.135 $X2=0.243 $Y2=0.154
r8 6 7 6.6497 $w=2.04211e-08 $l=1.9e-08 $layer=Gate_1 $thickness=5.6e-08
+ $X=0.243 $Y=0.116 $X2=0.243 $Y2=0.135
r9 5 6 16.4967 $w=2.1e-08 $l=4.85e-08 $layer=Gate_1 $thickness=5.6e-08 $X=0.243
+ $Y=0.0675 $X2=0.243 $Y2=0.116
r10 5 3 14.6259 $w=2.1e-08 $l=4.3e-08 $layer=Gate_1 $thickness=5.6e-08 $X=0.243
+ $Y=0.0675 $X2=0.243 $Y2=0.0245
.ends

.subckt PM_OA331x1_ASAP7_75t_R%B2 vss 13 5 9 4 3
c1 1 vss 0.00485782f $X=0.351 $Y=0.135
c2 3 vss 0.121134f $X=0.351 $Y=0.0245
c3 4 vss 0.00496756f $X=0.351 $Y=0.116
r1 13 12 1.34084 $w=1.3e-08 $l=5.8e-09 $layer=M1 $thickness=3.6e-08 $X=0.35
+ $Y=0.155 $X2=0.351 $Y2=0.1492
r2 11 12 3.32295 $w=1.3e-08 $l=1.42e-08 $layer=M1 $thickness=3.6e-08 $X=0.351
+ $Y=0.135 $X2=0.351 $Y2=0.1492
r3 4 11 4.4306 $w=1.3e-08 $l=1.9e-08 $layer=M1 $thickness=3.6e-08 $X=0.351
+ $Y=0.116 $X2=0.351 $Y2=0.135
r4 1 7 10.4265 $w=1.765e-08 $layer=LIG $thickness=5.2e-08 $X=0.351 $Y=0.135
+ $X2=0.351 $Y2=0.135
r5 1 11 19.3796 $a=3.24e-16 $layer=V0LIG $X=0.351 $Y=0.135 $X2=0.351 $Y2=0.135
r6 9 8 16.4967 $w=2.1e-08 $l=4.85e-08 $layer=Gate_1 $thickness=5.6e-08 $X=0.351
+ $Y=0.2025 $X2=0.351 $Y2=0.154
r7 7 8 6.6497 $w=2.04211e-08 $l=1.9e-08 $layer=Gate_1 $thickness=5.6e-08
+ $X=0.351 $Y=0.135 $X2=0.351 $Y2=0.154
r8 6 7 6.6497 $w=2.04211e-08 $l=1.9e-08 $layer=Gate_1 $thickness=5.6e-08
+ $X=0.351 $Y=0.116 $X2=0.351 $Y2=0.135
r9 5 6 16.4967 $w=2.1e-08 $l=4.85e-08 $layer=Gate_1 $thickness=5.6e-08 $X=0.351
+ $Y=0.0675 $X2=0.351 $Y2=0.116
r10 5 3 14.6259 $w=2.1e-08 $l=4.3e-08 $layer=Gate_1 $thickness=5.6e-08 $X=0.351
+ $Y=0.0675 $X2=0.351 $Y2=0.0245
.ends

.subckt PM_OA331x1_ASAP7_75t_R%B3 vss 13 5 9 4 3
c1 1 vss 0.00573429f $X=0.405 $Y=0.135
c2 3 vss 0.140056f $X=0.405 $Y=0.0245
c3 4 vss 0.00525788f $X=0.405 $Y=0.116
r1 13 12 1.34084 $w=1.3e-08 $l=5.8e-09 $layer=M1 $thickness=3.6e-08 $X=0.403
+ $Y=0.155 $X2=0.405 $Y2=0.1492
r2 11 12 3.32295 $w=1.3e-08 $l=1.42e-08 $layer=M1 $thickness=3.6e-08 $X=0.405
+ $Y=0.135 $X2=0.405 $Y2=0.1492
r3 4 11 4.4306 $w=1.3e-08 $l=1.9e-08 $layer=M1 $thickness=3.6e-08 $X=0.405
+ $Y=0.116 $X2=0.405 $Y2=0.135
r4 1 7 10.4265 $w=1.765e-08 $layer=LIG $thickness=5.2e-08 $X=0.405 $Y=0.135
+ $X2=0.405 $Y2=0.135
r5 1 11 19.3796 $a=3.24e-16 $layer=V0LIG $X=0.405 $Y=0.135 $X2=0.405 $Y2=0.135
r6 9 8 16.4967 $w=2.1e-08 $l=4.85e-08 $layer=Gate_1 $thickness=5.6e-08 $X=0.405
+ $Y=0.2025 $X2=0.405 $Y2=0.154
r7 7 8 6.6497 $w=2.04211e-08 $l=1.9e-08 $layer=Gate_1 $thickness=5.6e-08
+ $X=0.405 $Y=0.135 $X2=0.405 $Y2=0.154
r8 6 7 6.6497 $w=2.04211e-08 $l=1.9e-08 $layer=Gate_1 $thickness=5.6e-08
+ $X=0.405 $Y=0.116 $X2=0.405 $Y2=0.135
r9 5 6 16.4967 $w=2.1e-08 $l=4.85e-08 $layer=Gate_1 $thickness=5.6e-08 $X=0.405
+ $Y=0.0675 $X2=0.405 $Y2=0.116
r10 5 3 14.6259 $w=2.1e-08 $l=4.3e-08 $layer=Gate_1 $thickness=5.6e-08 $X=0.405
+ $Y=0.0675 $X2=0.405 $Y2=0.0245
.ends

.subckt PM_OA331x1_ASAP7_75t_R%C1 vss 15 5 11 3 1 4
c1 1 vss 0.00387244f $X=0.459 $Y=0.135
c2 3 vss 0.0889574f $X=0.459 $Y=0.0245
c3 4 vss 0.00583489f $X=0.459 $Y=0.116
r1 15 14 1.34084 $w=1.3e-08 $l=5.8e-09 $layer=M1 $thickness=3.6e-08 $X=0.461
+ $Y=0.155 $X2=0.459 $Y2=0.1492
r2 13 14 3.32295 $w=1.3e-08 $l=1.42e-08 $layer=M1 $thickness=3.6e-08 $X=0.459
+ $Y=0.135 $X2=0.459 $Y2=0.1492
r3 4 13 4.4306 $w=1.3e-08 $l=1.9e-08 $layer=M1 $thickness=3.6e-08 $X=0.459
+ $Y=0.116 $X2=0.459 $Y2=0.135
r4 1 8 10.4265 $w=1.765e-08 $layer=LIG $thickness=5.2e-08 $X=0.459 $Y=0.135
+ $X2=0.459 $Y2=0.135
r5 1 13 19.3796 $a=3.24e-16 $layer=V0LIG $X=0.459 $Y=0.135 $X2=0.459 $Y2=0.135
r6 11 10 14.6259 $w=2.1e-08 $l=4.3e-08 $layer=Gate_1 $thickness=5.6e-08
+ $X=0.459 $Y=0.2025 $X2=0.459 $Y2=0.1595
r7 9 10 2.7211 $w=2.1e-08 $l=8e-09 $layer=Gate_1 $thickness=5.6e-08 $X=0.459
+ $Y=0.1515 $X2=0.459 $Y2=0.1595
r8 8 9 5.79936 $w=2.03333e-08 $l=1.65e-08 $layer=Gate_1 $thickness=5.6e-08
+ $X=0.459 $Y=0.135 $X2=0.459 $Y2=0.1515
r9 7 8 5.79936 $w=2.03333e-08 $l=1.65e-08 $layer=Gate_1 $thickness=5.6e-08
+ $X=0.459 $Y=0.1185 $X2=0.459 $Y2=0.135
r10 6 7 2.7211 $w=2.1e-08 $l=8e-09 $layer=Gate_1 $thickness=5.6e-08 $X=0.459
+ $Y=0.1105 $X2=0.459 $Y2=0.1185
r11 5 6 14.6259 $w=2.1e-08 $l=4.3e-08 $layer=Gate_1 $thickness=5.6e-08 $X=0.459
+ $Y=0.0675 $X2=0.459 $Y2=0.1105
r12 5 3 14.6259 $w=2.1e-08 $l=4.3e-08 $layer=Gate_1 $thickness=5.6e-08 $X=0.459
+ $Y=0.0675 $X2=0.459 $Y2=0.0245
.ends

.subckt PM_OA331x1_ASAP7_75t_R%3 vss 24 30 63 64 68 73 16 1 20 12 3 22 14 13 18
+ 5 4 15 23 21 17
c1 1 vss 0.00370406f $X=0.081 $Y=0.135
c2 3 vss 0.00507216f $X=0.27 $Y=0.2025
c3 4 vss 0.00857956f $X=0.486 $Y=0.0675
c4 5 vss 0.00834646f $X=0.486 $Y=0.2025
c5 12 vss 0.0818014f $X=0.081 $Y=0.0245
c6 13 vss 0.0392662f $X=0.4715 $Y=0.0675
c7 14 vss 0.00404128f $X=0.2555 $Y=0.2025
c8 15 vss 0.0392554f $X=0.4715 $Y=0.2025
c9 16 vss 0.00146355f $X=0.081 $Y=0.195
c10 17 vss 0.00286986f $X=0.108 $Y=0.234
c11 18 vss 0.00425711f $X=0.513 $Y=0.072
c12 19 vss 0.00296381f $X=0.513 $Y=0.234
c13 20 vss 0.00180388f $X=0.081 $Y=0.1205
c14 21 vss 0.000822026f $X=0.108 $Y=0.2145
c15 22 vss 0.034506f $X=0.1215 $Y=0.234
c16 23 vss 0.00542672f $X=0.513 $Y=0.2125
r1 13 4 0.154321 $w=8.1e-08 $l=1.25e-08 $layer=N_src_drn $thickness=1e-09
+ $X=0.4715 $Y=0.0675 $X2=0.486 $Y2=0.0675
r2 73 13 0.0308642 $w=8.1e-08 $l=2.5e-09 $layer=N_src_drn $thickness=1e-09
+ $X=0.4686 $Y=0.0675 $X2=0.4715 $Y2=0.0675
r3 4 70 19.3796 $a=3.24e-16 $layer=V0LISD $X=0.486 $Y=0.0675 $X2=0.486 $Y2=0.072
r4 70 71 3.14806 $w=1.3e-08 $l=1.35e-08 $layer=M1 $thickness=3.6e-08 $X=0.486
+ $Y=0.072 $X2=0.4995 $Y2=0.072
r5 18 66 3.83327 $w=1.5093e-08 $l=2.15e-08 $layer=M1 $thickness=3.6e-08
+ $X=0.513 $Y=0.072 $X2=0.513 $Y2=0.0935
r6 18 71 1.96775 $w=1.63333e-08 $l=1.35e-08 $layer=M1 $thickness=3.6e-08
+ $X=0.513 $Y=0.072 $X2=0.4995 $Y2=0.072
r7 15 5 0.154321 $w=8.1e-08 $l=1.25e-08 $layer=P_src_drn $thickness=1e-09
+ $X=0.4715 $Y=0.2025 $X2=0.486 $Y2=0.2025
r8 68 15 0.0308642 $w=8.1e-08 $l=2.5e-09 $layer=P_src_drn $thickness=1e-09
+ $X=0.4686 $Y=0.2025 $X2=0.4715 $Y2=0.2025
r9 65 66 13.8748 $w=1.3e-08 $l=5.95e-08 $layer=M1 $thickness=3.6e-08 $X=0.513
+ $Y=0.153 $X2=0.513 $Y2=0.0935
r10 23 65 13.8748 $w=1.3e-08 $l=5.95e-08 $layer=M1 $thickness=3.6e-08 $X=0.513
+ $Y=0.2125 $X2=0.513 $Y2=0.153
r11 64 62 0.0308642 $w=8.1e-08 $l=2.5e-09 $layer=P_src_drn $thickness=1e-09
+ $X=0.2873 $Y=0.2025 $X2=0.2845 $Y2=0.2025
r12 3 62 0.179012 $w=8.1e-08 $l=1.45e-08 $layer=P_src_drn $thickness=1e-09
+ $X=0.27 $Y=0.2025 $X2=0.2845 $Y2=0.2025
r13 14 3 0.179012 $w=8.1e-08 $l=1.45e-08 $layer=P_src_drn $thickness=1e-09
+ $X=0.2555 $Y=0.2025 $X2=0.27 $Y2=0.2025
r14 63 14 0.0308642 $w=8.1e-08 $l=2.5e-09 $layer=P_src_drn $thickness=1e-09
+ $X=0.2526 $Y=0.2025 $X2=0.2555 $Y2=0.2025
r15 5 59 19.3796 $a=3.24e-16 $layer=V0LISD $X=0.486 $Y=0.2025 $X2=0.486
+ $Y2=0.234
r16 19 60 1.49895 $w=1.63333e-08 $l=1.35e-08 $layer=M1 $thickness=3.6e-08
+ $X=0.513 $Y=0.234 $X2=0.4995 $Y2=0.234
r17 19 23 3.36447 $w=1.71023e-08 $l=2.15e-08 $layer=M1 $thickness=3.6e-08
+ $X=0.513 $Y=0.234 $X2=0.513 $Y2=0.2125
r18 3 46 19.3796 $a=3.24e-16 $layer=V0LISD $X=0.27 $Y=0.2025 $X2=0.27 $Y2=0.234
r19 59 60 3.14806 $w=1.3e-08 $l=1.35e-08 $layer=M1 $thickness=3.6e-08 $X=0.486
+ $Y=0.234 $X2=0.4995 $Y2=0.234
r20 58 59 2.79828 $w=1.3e-08 $l=1.2e-08 $layer=M1 $thickness=3.6e-08 $X=0.474
+ $Y=0.234 $X2=0.486 $Y2=0.234
r21 57 58 1.04935 $w=1.3e-08 $l=4.5e-09 $layer=M1 $thickness=3.6e-08 $X=0.4695
+ $Y=0.234 $X2=0.474 $Y2=0.234
r22 56 57 2.44849 $w=1.3e-08 $l=1.05e-08 $layer=M1 $thickness=3.6e-08 $X=0.459
+ $Y=0.234 $X2=0.4695 $Y2=0.234
r23 55 56 2.44849 $w=1.3e-08 $l=1.05e-08 $layer=M1 $thickness=3.6e-08 $X=0.4485
+ $Y=0.234 $X2=0.459 $Y2=0.234
r24 54 55 4.19742 $w=1.3e-08 $l=1.8e-08 $layer=M1 $thickness=3.6e-08 $X=0.4305
+ $Y=0.234 $X2=0.4485 $Y2=0.234
r25 53 54 5.94634 $w=1.3e-08 $l=2.55e-08 $layer=M1 $thickness=3.6e-08 $X=0.405
+ $Y=0.234 $X2=0.4305 $Y2=0.234
r26 52 53 2.44849 $w=1.3e-08 $l=1.05e-08 $layer=M1 $thickness=3.6e-08 $X=0.3945
+ $Y=0.234 $X2=0.405 $Y2=0.234
r27 51 52 4.19742 $w=1.3e-08 $l=1.8e-08 $layer=M1 $thickness=3.6e-08 $X=0.3765
+ $Y=0.234 $X2=0.3945 $Y2=0.234
r28 50 51 5.94634 $w=1.3e-08 $l=2.55e-08 $layer=M1 $thickness=3.6e-08 $X=0.351
+ $Y=0.234 $X2=0.3765 $Y2=0.234
r29 49 50 6.29612 $w=1.3e-08 $l=2.7e-08 $layer=M1 $thickness=3.6e-08 $X=0.324
+ $Y=0.234 $X2=0.351 $Y2=0.234
r30 48 49 6.29612 $w=1.3e-08 $l=2.7e-08 $layer=M1 $thickness=3.6e-08 $X=0.297
+ $Y=0.234 $X2=0.324 $Y2=0.234
r31 47 48 3.14806 $w=1.3e-08 $l=1.35e-08 $layer=M1 $thickness=3.6e-08 $X=0.2835
+ $Y=0.234 $X2=0.297 $Y2=0.234
r32 46 47 3.14806 $w=1.3e-08 $l=1.35e-08 $layer=M1 $thickness=3.6e-08 $X=0.27
+ $Y=0.234 $X2=0.2835 $Y2=0.234
r33 45 46 3.14806 $w=1.3e-08 $l=1.35e-08 $layer=M1 $thickness=3.6e-08 $X=0.2565
+ $Y=0.234 $X2=0.27 $Y2=0.234
r34 44 45 3.14806 $w=1.3e-08 $l=1.35e-08 $layer=M1 $thickness=3.6e-08 $X=0.243
+ $Y=0.234 $X2=0.2565 $Y2=0.234
r35 43 44 6.29612 $w=1.3e-08 $l=2.7e-08 $layer=M1 $thickness=3.6e-08 $X=0.216
+ $Y=0.234 $X2=0.243 $Y2=0.234
r36 42 43 6.29612 $w=1.3e-08 $l=2.7e-08 $layer=M1 $thickness=3.6e-08 $X=0.189
+ $Y=0.234 $X2=0.216 $Y2=0.234
r37 41 42 5.82974 $w=1.3e-08 $l=2.5e-08 $layer=M1 $thickness=3.6e-08 $X=0.164
+ $Y=0.234 $X2=0.189 $Y2=0.234
r38 40 41 4.19742 $w=1.3e-08 $l=1.8e-08 $layer=M1 $thickness=3.6e-08 $X=0.146
+ $Y=0.234 $X2=0.164 $Y2=0.234
r39 39 40 2.56509 $w=1.3e-08 $l=1.1e-08 $layer=M1 $thickness=3.6e-08 $X=0.135
+ $Y=0.234 $X2=0.146 $Y2=0.234
r40 22 39 3.14806 $w=1.3e-08 $l=1.35e-08 $layer=M1 $thickness=3.6e-08 $X=0.1215
+ $Y=0.234 $X2=0.135 $Y2=0.234
r41 17 21 2.89809 $w=1.75231e-08 $l=1.95e-08 $layer=M1 $thickness=3.6e-08
+ $X=0.108 $Y=0.234 $X2=0.108 $Y2=0.2145
r42 17 22 1.49895 $w=1.63333e-08 $l=1.35e-08 $layer=M1 $thickness=3.6e-08
+ $X=0.108 $Y=0.234 $X2=0.1215 $Y2=0.234
r43 21 38 3.36689 $w=1.53077e-08 $l=1.95e-08 $layer=M1 $thickness=3.6e-08
+ $X=0.108 $Y=0.2145 $X2=0.108 $Y2=0.195
r44 37 38 1.96775 $w=1.63333e-08 $l=1.35e-08 $layer=M1 $thickness=3.6e-08
+ $X=0.0945 $Y=0.195 $X2=0.108 $Y2=0.195
r45 16 36 3.2503 $w=1.53684e-08 $l=1.9e-08 $layer=M1 $thickness=3.6e-08
+ $X=0.081 $Y=0.195 $X2=0.081 $Y2=0.176
r46 16 37 1.96775 $w=1.63333e-08 $l=1.35e-08 $layer=M1 $thickness=3.6e-08
+ $X=0.081 $Y=0.195 $X2=0.0945 $Y2=0.195
r47 35 36 4.89699 $w=1.3e-08 $l=2.1e-08 $layer=M1 $thickness=3.6e-08 $X=0.081
+ $Y=0.155 $X2=0.081 $Y2=0.176
r48 34 35 4.6638 $w=1.3e-08 $l=2e-08 $layer=M1 $thickness=3.6e-08 $X=0.081
+ $Y=0.135 $X2=0.081 $Y2=0.155
r49 20 34 3.38125 $w=1.3e-08 $l=1.45e-08 $layer=M1 $thickness=3.6e-08 $X=0.081
+ $Y=0.1205 $X2=0.081 $Y2=0.135
r50 1 27 6.54019 $w=2.09524e-08 $layer=Gate_1 $thickness=5.21905e-08 $X=0.081
+ $Y=0.135 $X2=0.081 $Y2=0.135
r51 1 34 19.3796 $a=3.24e-16 $layer=V0LIG $X=0.081 $Y=0.135 $X2=0.081 $Y2=0.135
r52 30 29 14.6259 $w=2.1e-08 $l=4.3e-08 $layer=Gate_1 $thickness=5.6e-08
+ $X=0.081 $Y=0.2025 $X2=0.081 $Y2=0.1595
r53 28 29 2.7211 $w=2.1e-08 $l=8e-09 $layer=Gate_1 $thickness=5.6e-08 $X=0.081
+ $Y=0.1515 $X2=0.081 $Y2=0.1595
r54 27 28 5.79936 $w=2.03333e-08 $l=1.65e-08 $layer=Gate_1 $thickness=5.6e-08
+ $X=0.081 $Y=0.135 $X2=0.081 $Y2=0.1515
r55 26 27 5.79936 $w=2.03333e-08 $l=1.65e-08 $layer=Gate_1 $thickness=5.6e-08
+ $X=0.081 $Y=0.1185 $X2=0.081 $Y2=0.135
r56 25 26 2.7211 $w=2.1e-08 $l=8e-09 $layer=Gate_1 $thickness=5.6e-08 $X=0.081
+ $Y=0.1105 $X2=0.081 $Y2=0.1185
r57 24 25 14.6259 $w=2.1e-08 $l=4.3e-08 $layer=Gate_1 $thickness=5.6e-08
+ $X=0.081 $Y=0.0675 $X2=0.081 $Y2=0.1105
r58 24 12 14.6259 $w=2.1e-08 $l=4.3e-08 $layer=Gate_1 $thickness=5.6e-08
+ $X=0.081 $Y=0.0675 $X2=0.081 $Y2=0.0245
.ends

.subckt PM_OA331x1_ASAP7_75t_R%Y vss 19 13 27 8 11 7
c1 7 vss 0.0482189f $X=0.056 $Y=0.0675
c2 8 vss 0.0469843f $X=0.056 $Y=0.2025
c3 9 vss 0.00648756f $X=0.0405 $Y=0.036
c4 10 vss 0.00565264f $X=0.027 $Y=0.234
c5 11 vss 0.0059519f $X=0.027 $Y=0.0575
r1 27 26 0.0308642 $w=8.1e-08 $l=2.5e-09 $layer=P_src_drn $thickness=1e-09
+ $X=0.0713 $Y=0.2025 $X2=0.0685 $Y2=0.2025
r2 8 26 0.154321 $w=8.1e-08 $l=1.25e-08 $layer=P_src_drn $thickness=1e-09
+ $X=0.056 $Y=0.2025 $X2=0.0685 $Y2=0.2025
r3 8 24 19.3796 $a=3.24e-16 $layer=V0LISD $X=0.056 $Y=0.2025 $X2=0.054 $Y2=0.234
r4 23 24 3.14806 $w=1.3e-08 $l=1.35e-08 $layer=M1 $thickness=3.6e-08 $X=0.0405
+ $Y=0.234 $X2=0.054 $Y2=0.234
r5 10 22 3.36689 $w=1.53077e-08 $l=1.95e-08 $layer=M1 $thickness=3.6e-08
+ $X=0.027 $Y=0.234 $X2=0.027 $Y2=0.2145
r6 10 23 1.96775 $w=1.63333e-08 $l=1.35e-08 $layer=M1 $thickness=3.6e-08
+ $X=0.027 $Y=0.234 $X2=0.0405 $Y2=0.234
r7 21 22 4.5472 $w=1.3e-08 $l=1.95e-08 $layer=M1 $thickness=3.6e-08 $X=0.027
+ $Y=0.195 $X2=0.027 $Y2=0.2145
r8 20 21 7.05399 $w=1.3e-08 $l=3.03e-08 $layer=M1 $thickness=3.6e-08 $X=0.027
+ $Y=0.1647 $X2=0.027 $Y2=0.195
r9 19 20 5.07188 $w=1.3e-08 $l=2.17e-08 $layer=M1 $thickness=3.6e-08 $X=0.03
+ $Y=0.143 $X2=0.027 $Y2=0.1647
r10 19 18 3.32295 $w=1.3e-08 $l=1.43e-08 $layer=M1 $thickness=3.6e-08 $X=0.03
+ $Y=0.143 $X2=0.027 $Y2=0.1287
r11 17 18 8.45313 $w=1.3e-08 $l=3.62e-08 $layer=M1 $thickness=3.6e-08 $X=0.027
+ $Y=0.0925 $X2=0.027 $Y2=0.1287
r12 11 16 3.83327 $w=1.5093e-08 $l=2.15e-08 $layer=M1 $thickness=3.6e-08
+ $X=0.027 $Y=0.0575 $X2=0.027 $Y2=0.036
r13 11 17 8.16164 $w=1.3e-08 $l=3.5e-08 $layer=M1 $thickness=3.6e-08 $X=0.027
+ $Y=0.0575 $X2=0.027 $Y2=0.0925
r14 9 14 3.14806 $w=1.3e-08 $l=1.35e-08 $layer=M1 $thickness=3.6e-08 $X=0.0405
+ $Y=0.036 $X2=0.054 $Y2=0.036
r15 9 16 1.96775 $w=1.63333e-08 $l=1.35e-08 $layer=M1 $thickness=3.6e-08
+ $X=0.0405 $Y=0.036 $X2=0.027 $Y2=0.036
r16 7 14 19.3796 $a=3.24e-16 $layer=V0LISD $X=0.056 $Y=0.0675 $X2=0.054
+ $Y2=0.036
r17 13 12 0.0308642 $w=8.1e-08 $l=2.5e-09 $layer=N_src_drn $thickness=1e-09
+ $X=0.0713 $Y=0.0675 $X2=0.0685 $Y2=0.0675
r18 7 12 0.154321 $w=8.1e-08 $l=1.25e-08 $layer=N_src_drn $thickness=1e-09
+ $X=0.056 $Y=0.0675 $X2=0.0685 $Y2=0.0675
.ends

.subckt PM_OA331x1_ASAP7_75t_R%A2 vss 13 5 9 4 3
c1 1 vss 0.00464703f $X=0.189 $Y=0.135
c2 3 vss 0.121275f $X=0.189 $Y=0.0245
c3 4 vss 0.00421095f $X=0.189 $Y=0.116
r1 13 12 1.34084 $w=1.3e-08 $l=5.8e-09 $layer=M1 $thickness=3.6e-08 $X=0.189
+ $Y=0.155 $X2=0.189 $Y2=0.1492
r2 11 12 3.32295 $w=1.3e-08 $l=1.42e-08 $layer=M1 $thickness=3.6e-08 $X=0.189
+ $Y=0.135 $X2=0.189 $Y2=0.1492
r3 4 11 4.43061 $w=1.3e-08 $l=1.9e-08 $layer=M1 $thickness=3.6e-08 $X=0.189
+ $Y=0.116 $X2=0.189 $Y2=0.135
r4 1 7 10.4265 $w=1.765e-08 $layer=LIG $thickness=5.2e-08 $X=0.189 $Y=0.135
+ $X2=0.189 $Y2=0.135
r5 1 11 19.3796 $a=3.24e-16 $layer=V0LIG $X=0.189 $Y=0.135 $X2=0.189 $Y2=0.135
r6 9 8 16.4967 $w=2.1e-08 $l=4.85e-08 $layer=Gate_1 $thickness=5.6e-08 $X=0.189
+ $Y=0.2025 $X2=0.189 $Y2=0.154
r7 7 8 6.6497 $w=2.04211e-08 $l=1.9e-08 $layer=Gate_1 $thickness=5.6e-08
+ $X=0.189 $Y=0.135 $X2=0.189 $Y2=0.154
r8 6 7 6.6497 $w=2.04211e-08 $l=1.9e-08 $layer=Gate_1 $thickness=5.6e-08
+ $X=0.189 $Y=0.116 $X2=0.189 $Y2=0.135
r9 5 6 16.4967 $w=2.1e-08 $l=4.85e-08 $layer=Gate_1 $thickness=5.6e-08 $X=0.189
+ $Y=0.0675 $X2=0.189 $Y2=0.116
r10 5 3 14.6259 $w=2.1e-08 $l=4.3e-08 $layer=Gate_1 $thickness=5.6e-08 $X=0.189
+ $Y=0.0675 $X2=0.189 $Y2=0.0245
.ends

.subckt PM_OA331x1_ASAP7_75t_R%B1 vss 13 5 9 4 3
c1 1 vss 0.00473832f $X=0.297 $Y=0.135
c2 3 vss 0.102488f $X=0.297 $Y=0.0245
c3 4 vss 0.00726439f $X=0.297 $Y=0.116
r1 13 12 1.22425 $w=1.3e-08 $l=5.3e-09 $layer=M1 $thickness=3.6e-08 $X=0.297
+ $Y=0.154 $X2=0.297 $Y2=0.1487
r2 11 12 3.20636 $w=1.3e-08 $l=1.37e-08 $layer=M1 $thickness=3.6e-08 $X=0.297
+ $Y=0.135 $X2=0.297 $Y2=0.1487
r3 4 11 4.4306 $w=1.3e-08 $l=1.9e-08 $layer=M1 $thickness=3.6e-08 $X=0.297
+ $Y=0.116 $X2=0.297 $Y2=0.135
r4 1 7 10.4265 $w=1.765e-08 $layer=LIG $thickness=5.2e-08 $X=0.297 $Y=0.135
+ $X2=0.297 $Y2=0.135
r5 1 11 19.3796 $a=3.24e-16 $layer=V0LIG $X=0.297 $Y=0.135 $X2=0.297 $Y2=0.135
r6 9 8 16.4967 $w=2.1e-08 $l=4.85e-08 $layer=Gate_1 $thickness=5.6e-08 $X=0.297
+ $Y=0.2025 $X2=0.297 $Y2=0.154
r7 7 8 6.6497 $w=2.04211e-08 $l=1.9e-08 $layer=Gate_1 $thickness=5.6e-08
+ $X=0.297 $Y=0.135 $X2=0.297 $Y2=0.154
r8 6 7 6.6497 $w=2.04211e-08 $l=1.9e-08 $layer=Gate_1 $thickness=5.6e-08
+ $X=0.297 $Y=0.116 $X2=0.297 $Y2=0.135
r9 5 6 16.4967 $w=2.1e-08 $l=4.85e-08 $layer=Gate_1 $thickness=5.6e-08 $X=0.297
+ $Y=0.0675 $X2=0.297 $Y2=0.116
r10 5 3 14.6259 $w=2.1e-08 $l=4.3e-08 $layer=Gate_1 $thickness=5.6e-08 $X=0.297
+ $Y=0.0675 $X2=0.297 $Y2=0.0245
.ends

* End of included file OA331x1_ASAP7_75t_R.pex.sp.pex

*
.subckt OA331x1_ASAP7_75t_CUSTOM_4_25_0_7 VSS VDD A3 A2 A1 B1 B2 B3 C1 Y
*
* VSS VSS
* VDD VDD
* A3 A3
* A2 A2
* A1 A1
* B1 B1
* B2 B2
* B3 B3
* C1 C1
* Y Y
*
*

M0 VSS N_M0_g N_M0_s VSS nmos_rvt L=2e-08 W=8.1e-08 nfin=3 $X=0.071 $Y=0.027
M1 noxref_12 N_M1_g VSS VSS nmos_rvt L=2e-08 W=8.1e-08 nfin=3 $X=0.125 $Y=0.027
M2 VSS N_M2_g noxref_12 VSS nmos_rvt L=2e-08 W=8.1e-08 nfin=3 $X=0.179 $Y=0.027
M3 noxref_12 N_M3_g VSS VSS nmos_rvt L=2e-08 W=8.1e-08 nfin=3 $X=0.233 $Y=0.027
M4 noxref_13 N_M4_g noxref_12 VSS nmos_rvt L=2e-08 W=8.1e-08 nfin=3 $X=0.287
+ $Y=0.027
M5 noxref_12 N_M5_g noxref_13 VSS nmos_rvt L=2e-08 W=8.1e-08 nfin=3 $X=0.341
+ $Y=0.027
M6 noxref_13 N_M6_g noxref_12 VSS nmos_rvt L=2e-08 W=8.1e-08 nfin=3 $X=0.395
+ $Y=0.027
M7 N_M7_d N_M7_g noxref_13 VSS nmos_rvt L=2e-08 W=8.1e-08 nfin=3 $X=0.449
+ $Y=0.027
M8 VDD N_M8_g N_M8_s VDD pmos_rvt L=2e-08 W=8.1e-08 nfin=3 $X=0.071 $Y=0.162
M9 noxref_14 N_M9_g VDD VDD pmos_rvt L=2e-08 W=8.1e-08 nfin=3 $X=0.125 $Y=0.162
M10 noxref_15 N_M10_g noxref_14 VDD pmos_rvt L=2e-08 W=8.1e-08 nfin=3 $X=0.179
+ $Y=0.162
M11 N_M11_d N_M11_g noxref_15 VDD pmos_rvt L=2e-08 W=8.1e-08 nfin=3 $X=0.233
+ $Y=0.162
M12 noxref_16 N_M12_g N_M12_s VDD pmos_rvt L=2e-08 W=8.1e-08 nfin=3 $X=0.287
+ $Y=0.162
M13 noxref_17 N_M13_g noxref_16 VDD pmos_rvt L=2e-08 W=8.1e-08 nfin=3 $X=0.341
+ $Y=0.162
M14 VDD N_M14_g noxref_17 VDD pmos_rvt L=2e-08 W=8.1e-08 nfin=3 $X=0.395
+ $Y=0.162
M15 N_M15_d N_M15_g VDD VDD pmos_rvt L=2e-08 W=8.1e-08 nfin=3 $X=0.449 $Y=0.162

* .include "OA331x1_ASAP7_75t_R.pex.sp.pxi"

* Start of included file OA331x1_ASAP7_75t_R.pex.sp.pxi
x_PM_OA331x1_ASAP7_75t_R%A3 vss A3 N_M1_g N_M9_g N_A3_3 N_A3_4
+ PM_OA331x1_ASAP7_75t_R%A3
cc_1 N_A3_3 N_3_16 0.000652176f $X=0.135 $Y=0.0245
cc_2 N_A3_3 N_3_1 0.00189443f $X=0.135 $Y=0.0245
cc_3 N_A3_4 N_3_20 0.00310747f $X=0.135 $Y=0.1105
cc_4 N_A3_3 N_3_12 0.00385727f $X=0.135 $Y=0.0245
x_PM_OA331x1_ASAP7_75t_R%A1 vss A1 N_M3_g N_M11_g N_A1_4 N_A1_3
+ PM_OA331x1_ASAP7_75t_R%A1
cc_5 N_A1_4 N_3_22 0.00125269f $X=0.243 $Y=0.116
cc_6 N_A1_3 N_3_3 0.00143769f $X=0.243 $Y=0.0245
cc_7 N_A1_4 N_3_3 0.00185039f $X=0.243 $Y=0.116
cc_8 N_A1_3 N_3_14 0.0361003f $X=0.243 $Y=0.0245
cc_9 N_A1_4 N_A2_4 0.00344401f $X=0.243 $Y=0.116
cc_10 N_A1_3 N_A2_3 0.00705714f $X=0.243 $Y=0.0245
x_PM_OA331x1_ASAP7_75t_R%B2 vss B2 N_M5_g N_M13_g N_B2_4 N_B2_3
+ PM_OA331x1_ASAP7_75t_R%B2
cc_11 N_B2_4 N_3_22 0.00364239f $X=0.351 $Y=0.116
cc_12 N_B2_4 N_B1_4 0.00333171f $X=0.351 $Y=0.116
cc_13 N_B2_3 N_B1_3 0.00695364f $X=0.351 $Y=0.0245
x_PM_OA331x1_ASAP7_75t_R%B3 vss B3 N_M6_g N_M14_g N_B3_4 N_B3_3
+ PM_OA331x1_ASAP7_75t_R%B3
cc_14 N_B3_4 N_3_22 0.00324201f $X=0.405 $Y=0.116
cc_15 N_B3_4 N_B2_4 0.00332022f $X=0.405 $Y=0.116
cc_16 N_B3_3 N_B2_3 0.00704823f $X=0.405 $Y=0.0245
x_PM_OA331x1_ASAP7_75t_R%C1 vss C1 N_M7_g N_M15_g N_C1_3 N_C1_1 N_C1_4
+ PM_OA331x1_ASAP7_75t_R%C1
cc_17 N_C1_3 N_3_13 0.0152438f $X=0.459 $Y=0.0245
cc_18 N_C1_3 N_3_18 0.000495379f $X=0.459 $Y=0.0245
cc_19 N_C1_3 N_3_5 0.00202136f $X=0.459 $Y=0.0245
cc_20 N_C1_3 N_3_4 0.00092022f $X=0.459 $Y=0.0245
cc_21 N_C1_3 N_3_22 0.0010226f $X=0.459 $Y=0.0245
cc_22 N_C1_1 N_3_15 0.001671f $X=0.459 $Y=0.135
cc_23 N_C1_4 N_3_23 0.00596158f $X=0.459 $Y=0.116
cc_24 N_C1_3 N_3_15 0.053976f $X=0.459 $Y=0.0245
cc_25 N_C1_3 N_B3_3 0.00325445f $X=0.459 $Y=0.0245
cc_26 N_C1_4 N_B3_4 0.0051675f $X=0.459 $Y=0.116
x_PM_OA331x1_ASAP7_75t_R%3 vss N_M0_g N_M8_g N_M11_d N_M12_s N_M15_d N_M7_d
+ N_3_16 N_3_1 N_3_20 N_3_12 N_3_3 N_3_22 N_3_14 N_3_13 N_3_18 N_3_5 N_3_4
+ N_3_15 N_3_23 N_3_21 N_3_17 PM_OA331x1_ASAP7_75t_R%3
x_PM_OA331x1_ASAP7_75t_R%Y vss Y N_M0_s N_M8_s N_Y_8 N_Y_11 N_Y_7
+ PM_OA331x1_ASAP7_75t_R%Y
cc_27 N_Y_8 N_3_21 0.000363914f $X=0.056 $Y=0.2025
cc_28 N_Y_8 N_3_17 0.000406041f $X=0.056 $Y=0.2025
cc_29 N_Y_8 N_3_1 0.00254891f $X=0.056 $Y=0.2025
cc_30 N_Y_8 N_3_16 0.00222858f $X=0.056 $Y=0.2025
cc_31 N_Y_11 N_3_20 0.0044365f $X=0.027 $Y=0.0575
cc_32 N_Y_7 N_3_12 0.0148613f $X=0.056 $Y=0.0675
cc_33 N_Y_8 N_3_12 0.0566899f $X=0.056 $Y=0.2025
x_PM_OA331x1_ASAP7_75t_R%A2 vss A2 N_M2_g N_M10_g N_A2_4 N_A2_3
+ PM_OA331x1_ASAP7_75t_R%A2
cc_34 N_A2_4 N_3_3 0.00036409f $X=0.189 $Y=0.116
cc_35 N_A2_4 N_3_22 0.00399462f $X=0.189 $Y=0.116
cc_36 N_A2_4 N_A3_4 0.00310606f $X=0.189 $Y=0.116
cc_37 N_A2_3 N_A3_3 0.00697547f $X=0.189 $Y=0.0245
x_PM_OA331x1_ASAP7_75t_R%B1 vss B1 N_M4_g N_M12_g N_B1_4 N_B1_3
+ PM_OA331x1_ASAP7_75t_R%B1
cc_38 N_B1_4 N_3_22 0.00124299f $X=0.297 $Y=0.116
cc_39 N_B1_3 N_3_3 0.00148946f $X=0.297 $Y=0.0245
cc_40 N_B1_4 N_3_3 0.00183964f $X=0.297 $Y=0.116
cc_41 N_B1_3 N_3_14 0.0360522f $X=0.297 $Y=0.0245
cc_42 N_B1_3 N_A1_3 0.00317569f $X=0.297 $Y=0.0245
cc_43 N_B1_4 N_A1_4 0.00498471f $X=0.297 $Y=0.116

* End of included file OA331x1_ASAP7_75t_R.pex.sp.pxi
.ends

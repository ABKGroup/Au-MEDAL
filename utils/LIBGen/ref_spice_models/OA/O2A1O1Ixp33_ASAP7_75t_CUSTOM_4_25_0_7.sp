.subckt PM_O2A1O1Ixp33_ASAP7_75t_R%B vss 11 5 9 4 3
c1 1 vss 0.00861897f $X=0.189 $Y=0.135
c2 3 vss 0.123412f $X=0.189 $Y=0.0245
c3 4 vss 0.00774289f $X=0.189 $Y=0.116
r1 11 4 4.4306 $w=1.3e-08 $l=1.9e-08 $layer=M1 $thickness=3.6e-08 $X=0.191
+ $Y=0.136 $X2=0.189 $Y2=0.116
r2 1 7 10.4265 $w=1.765e-08 $layer=LIG $thickness=5.2e-08 $X=0.189 $Y=0.135
+ $X2=0.189 $Y2=0.135
r3 11 1 19.3796 $a=3.24e-16 $layer=V0LIG $X=0.191 $Y=0.136 $X2=0.189 $Y2=0.135
r4 9 8 16.4967 $w=2.1e-08 $l=4.85e-08 $layer=Gate_1 $thickness=5.6e-08 $X=0.189
+ $Y=0.2025 $X2=0.189 $Y2=0.154
r5 7 8 6.6497 $w=2.04211e-08 $l=1.9e-08 $layer=Gate_1 $thickness=5.6e-08
+ $X=0.189 $Y=0.135 $X2=0.189 $Y2=0.154
r6 6 7 6.6497 $w=2.04211e-08 $l=1.9e-08 $layer=Gate_1 $thickness=5.6e-08
+ $X=0.189 $Y=0.116 $X2=0.189 $Y2=0.135
r7 5 6 16.4967 $w=2.1e-08 $l=4.85e-08 $layer=Gate_1 $thickness=5.6e-08 $X=0.189
+ $Y=0.0675 $X2=0.189 $Y2=0.116
r8 5 3 14.6259 $w=2.1e-08 $l=4.3e-08 $layer=Gate_1 $thickness=5.6e-08 $X=0.189
+ $Y=0.0675 $X2=0.189 $Y2=0.0245
.ends

.subckt PM_O2A1O1Ixp33_ASAP7_75t_R%A1 vss 11 5 9 4 3
c1 1 vss 0.00287003f $X=0.135 $Y=0.135
c2 3 vss 0.0681559f $X=0.135 $Y=0.0245
c3 4 vss 0.0100903f $X=0.135 $Y=0.116
r1 11 4 4.4306 $w=1.3e-08 $l=1.9e-08 $layer=M1 $thickness=3.6e-08 $X=0.136
+ $Y=0.138 $X2=0.135 $Y2=0.116
r2 1 7 10.4265 $w=1.765e-08 $layer=LIG $thickness=5.2e-08 $X=0.135 $Y=0.135
+ $X2=0.135 $Y2=0.135
r3 11 1 19.3796 $a=3.24e-16 $layer=V0LIG $X=0.136 $Y=0.138 $X2=0.135 $Y2=0.135
r4 9 8 16.4967 $w=2.1e-08 $l=4.85e-08 $layer=Gate_1 $thickness=5.6e-08 $X=0.135
+ $Y=0.2025 $X2=0.135 $Y2=0.154
r5 7 8 6.6497 $w=2.04211e-08 $l=1.9e-08 $layer=Gate_1 $thickness=5.6e-08
+ $X=0.135 $Y=0.135 $X2=0.135 $Y2=0.154
r6 6 7 6.6497 $w=2.04211e-08 $l=1.9e-08 $layer=Gate_1 $thickness=5.6e-08
+ $X=0.135 $Y=0.116 $X2=0.135 $Y2=0.135
r7 5 6 16.4967 $w=2.1e-08 $l=4.85e-08 $layer=Gate_1 $thickness=5.6e-08 $X=0.135
+ $Y=0.0675 $X2=0.135 $Y2=0.116
r8 5 3 14.6259 $w=2.1e-08 $l=4.3e-08 $layer=Gate_1 $thickness=5.6e-08 $X=0.135
+ $Y=0.0675 $X2=0.135 $Y2=0.0245
.ends

.subckt PM_O2A1O1Ixp33_ASAP7_75t_R%7 vss 11 23 24 1 9 7 2 8
c1 1 vss 0.00576935f $X=0.054 $Y=0.0675
c2 2 vss 0.00505142f $X=0.162 $Y=0.0675
c3 7 vss 0.0357009f $X=0.056 $Y=0.0675
c4 8 vss 0.00319184f $X=0.1475 $Y=0.0675
c5 9 vss 0.00314706f $X=0.0425 $Y=0.072
r1 24 22 0.0308642 $w=8.1e-08 $l=2.5e-09 $layer=N_src_drn $thickness=1e-09
+ $X=0.1793 $Y=0.0675 $X2=0.1765 $Y2=0.0675
r2 2 22 0.179012 $w=8.1e-08 $l=1.45e-08 $layer=N_src_drn $thickness=1e-09
+ $X=0.162 $Y=0.0675 $X2=0.1765 $Y2=0.0675
r3 8 2 0.179012 $w=8.1e-08 $l=1.45e-08 $layer=N_src_drn $thickness=1e-09
+ $X=0.1475 $Y=0.0675 $X2=0.162 $Y2=0.0675
r4 23 8 0.0308642 $w=8.1e-08 $l=2.5e-09 $layer=N_src_drn $thickness=1e-09
+ $X=0.1446 $Y=0.0675 $X2=0.1475 $Y2=0.0675
r5 2 19 19.3796 $a=3.24e-16 $layer=V0LISD $X=0.162 $Y=0.0675 $X2=0.162 $Y2=0.072
r6 18 19 3.14806 $w=1.3e-08 $l=1.35e-08 $layer=M1 $thickness=3.6e-08 $X=0.1485
+ $Y=0.072 $X2=0.162 $Y2=0.072
r7 17 18 3.14806 $w=1.3e-08 $l=1.35e-08 $layer=M1 $thickness=3.6e-08 $X=0.135
+ $Y=0.072 $X2=0.1485 $Y2=0.072
r8 16 17 5.82974 $w=1.3e-08 $l=2.5e-08 $layer=M1 $thickness=3.6e-08 $X=0.11
+ $Y=0.072 $X2=0.135 $Y2=0.072
r9 15 16 4.19742 $w=1.3e-08 $l=1.8e-08 $layer=M1 $thickness=3.6e-08 $X=0.092
+ $Y=0.072 $X2=0.11 $Y2=0.072
r10 14 15 2.56509 $w=1.3e-08 $l=1.1e-08 $layer=M1 $thickness=3.6e-08 $X=0.081
+ $Y=0.072 $X2=0.092 $Y2=0.072
r11 13 14 3.14806 $w=1.3e-08 $l=1.35e-08 $layer=M1 $thickness=3.6e-08 $X=0.0675
+ $Y=0.072 $X2=0.081 $Y2=0.072
r12 12 13 3.14806 $w=1.3e-08 $l=1.35e-08 $layer=M1 $thickness=3.6e-08 $X=0.054
+ $Y=0.072 $X2=0.0675 $Y2=0.072
r13 9 12 2.68168 $w=1.3e-08 $l=1.15e-08 $layer=M1 $thickness=3.6e-08 $X=0.0425
+ $Y=0.072 $X2=0.054 $Y2=0.072
r14 1 12 19.3796 $a=3.24e-16 $layer=V0LISD $X=0.054 $Y=0.0675 $X2=0.054
+ $Y2=0.072
r15 11 10 0.0308642 $w=8.1e-08 $l=2.5e-09 $layer=N_src_drn $thickness=1e-09
+ $X=0.0713 $Y=0.0675 $X2=0.0685 $Y2=0.0675
r16 7 10 0.154321 $w=8.1e-08 $l=1.25e-08 $layer=N_src_drn $thickness=1e-09
+ $X=0.056 $Y=0.0675 $X2=0.0685 $Y2=0.0675
r17 1 7 1e-05 $l=2e-09 $X=0.054 $Y=0.0675 $X2=0.056 $Y2=0.0675
.ends

.subckt PM_O2A1O1Ixp33_ASAP7_75t_R%Y vss 33 19 20 37 41 10 15 12 3 11 16 1
c1 1 vss 0.00431753f $X=0.108 $Y=0.0675
c2 2 vss 0.0073246f $X=0.27 $Y=0.054
c3 3 vss 0.00940064f $X=0.27 $Y=0.2025
c4 10 vss 0.00208336f $X=0.0935 $Y=0.0675
c5 11 vss 0.0280409f $X=0.2555 $Y=0.054
c6 12 vss 0.0377711f $X=0.2555 $Y=0.2025
c7 13 vss 0.00552878f $X=0.297 $Y=0.234
c8 14 vss 0.00265289f $X=0.297 $Y=0.036
c9 15 vss 0.0167397f $X=0.0965 $Y=0.036
c10 16 vss 0.00461369f $X=0.297 $Y=0.054
r1 12 3 0.154321 $w=8.1e-08 $l=1.25e-08 $layer=P_src_drn $thickness=1e-09
+ $X=0.2555 $Y=0.2025 $X2=0.27 $Y2=0.2025
r2 41 12 0.0308642 $w=8.1e-08 $l=2.5e-09 $layer=P_src_drn $thickness=1e-09
+ $X=0.2526 $Y=0.2025 $X2=0.2555 $Y2=0.2025
r3 3 38 19.3796 $a=3.24e-16 $layer=V0LISD $X=0.27 $Y=0.2025 $X2=0.27 $Y2=0.234
r4 38 39 3.14806 $w=1.3e-08 $l=1.35e-08 $layer=M1 $thickness=3.6e-08 $X=0.27
+ $Y=0.234 $X2=0.2835 $Y2=0.234
r5 13 35 3.1337 $w=1.54324e-08 $l=1.85e-08 $layer=M1 $thickness=3.6e-08
+ $X=0.297 $Y=0.234 $X2=0.297 $Y2=0.2155
r6 13 39 1.96775 $w=1.63333e-08 $l=1.35e-08 $layer=M1 $thickness=3.6e-08
+ $X=0.297 $Y=0.234 $X2=0.2835 $Y2=0.234
r7 11 2 0.231482 $w=5.4e-08 $l=1.25e-08 $layer=N_src_drn $thickness=1e-09
+ $X=0.2555 $Y=0.054 $X2=0.27 $Y2=0.054
r8 37 11 0.0462963 $w=5.4e-08 $l=2.5e-09 $layer=N_src_drn $thickness=1e-09
+ $X=0.2526 $Y=0.054 $X2=0.2555 $Y2=0.054
r9 34 35 10.3186 $w=1.3e-08 $l=4.43e-08 $layer=M1 $thickness=3.6e-08 $X=0.297
+ $Y=0.1712 $X2=0.297 $Y2=0.2155
r10 33 34 8.21994 $w=1.3e-08 $l=3.52e-08 $layer=M1 $thickness=3.6e-08 $X=0.298
+ $Y=0.136 $X2=0.297 $Y2=0.1712
r11 33 32 7.75356 $w=1.3e-08 $l=3.33e-08 $layer=M1 $thickness=3.6e-08 $X=0.298
+ $Y=0.136 $X2=0.297 $Y2=0.1027
r12 31 32 8.45313 $w=1.3e-08 $l=3.62e-08 $layer=M1 $thickness=3.6e-08 $X=0.297
+ $Y=0.0665 $X2=0.297 $Y2=0.1027
r13 16 31 2.91487 $w=1.3e-08 $l=1.25e-08 $layer=M1 $thickness=3.6e-08 $X=0.297
+ $Y=0.054 $X2=0.297 $Y2=0.0665
r14 2 29 19.3796 $a=3.24e-16 $layer=V0LISD $X=0.27 $Y=0.054 $X2=0.27 $Y2=0.036
r15 14 30 1.49895 $w=1.63333e-08 $l=1.35e-08 $layer=M1 $thickness=3.6e-08
+ $X=0.297 $Y=0.036 $X2=0.2835 $Y2=0.036
r16 14 16 2.5483 $w=1.79e-08 $l=1.8e-08 $layer=M1 $thickness=3.6e-08 $X=0.297
+ $Y=0.036 $X2=0.297 $Y2=0.054
r17 29 30 3.14806 $w=1.3e-08 $l=1.35e-08 $layer=M1 $thickness=3.6e-08 $X=0.27
+ $Y=0.036 $X2=0.2835 $Y2=0.036
r18 28 29 3.14806 $w=1.3e-08 $l=1.35e-08 $layer=M1 $thickness=3.6e-08 $X=0.2565
+ $Y=0.036 $X2=0.27 $Y2=0.036
r19 27 28 3.14806 $w=1.3e-08 $l=1.35e-08 $layer=M1 $thickness=3.6e-08 $X=0.243
+ $Y=0.036 $X2=0.2565 $Y2=0.036
r20 26 27 3.14806 $w=1.3e-08 $l=1.35e-08 $layer=M1 $thickness=3.6e-08 $X=0.2295
+ $Y=0.036 $X2=0.243 $Y2=0.036
r21 25 26 4.19742 $w=1.3e-08 $l=1.8e-08 $layer=M1 $thickness=3.6e-08 $X=0.2115
+ $Y=0.036 $X2=0.2295 $Y2=0.036
r22 24 25 5.24677 $w=1.3e-08 $l=2.25e-08 $layer=M1 $thickness=3.6e-08 $X=0.189
+ $Y=0.036 $X2=0.2115 $Y2=0.036
r23 23 24 2.56509 $w=1.3e-08 $l=1.1e-08 $layer=M1 $thickness=3.6e-08 $X=0.178
+ $Y=0.036 $X2=0.189 $Y2=0.036
r24 22 23 7.34548 $w=1.3e-08 $l=3.15e-08 $layer=M1 $thickness=3.6e-08 $X=0.1465
+ $Y=0.036 $X2=0.178 $Y2=0.036
r25 21 22 8.97781 $w=1.3e-08 $l=3.85e-08 $layer=M1 $thickness=3.6e-08 $X=0.108
+ $Y=0.036 $X2=0.1465 $Y2=0.036
r26 15 21 2.68168 $w=1.3e-08 $l=1.15e-08 $layer=M1 $thickness=3.6e-08 $X=0.0965
+ $Y=0.036 $X2=0.108 $Y2=0.036
r27 1 21 19.3796 $a=3.24e-16 $layer=V0LISD $X=0.108 $Y=0.0675 $X2=0.108
+ $Y2=0.036
r28 20 18 0.0308642 $w=8.1e-08 $l=2.5e-09 $layer=N_src_drn $thickness=1e-09
+ $X=0.1253 $Y=0.0675 $X2=0.1225 $Y2=0.0675
r29 1 18 0.179012 $w=8.1e-08 $l=1.45e-08 $layer=N_src_drn $thickness=1e-09
+ $X=0.108 $Y=0.0675 $X2=0.1225 $Y2=0.0675
r30 10 1 0.179012 $w=8.1e-08 $l=1.45e-08 $layer=N_src_drn $thickness=1e-09
+ $X=0.0935 $Y=0.0675 $X2=0.108 $Y2=0.0675
r31 19 10 0.0308642 $w=8.1e-08 $l=2.5e-09 $layer=N_src_drn $thickness=1e-09
+ $X=0.0906 $Y=0.0675 $X2=0.0935 $Y2=0.0675
.ends

.subckt PM_O2A1O1Ixp33_ASAP7_75t_R%A2 vss 13 5 11 4 3
c1 1 vss 0.00366974f $X=0.081 $Y=0.135
c2 3 vss 0.0716964f $X=0.081 $Y=0.0245
c3 4 vss 0.0105661f $X=0.081 $Y=0.116
r1 13 4 4.4306 $w=1.3e-08 $l=1.9e-08 $layer=M1 $thickness=3.6e-08 $X=0.082
+ $Y=0.138 $X2=0.081 $Y2=0.116
r2 1 8 10.4265 $w=1.765e-08 $layer=LIG $thickness=5.2e-08 $X=0.081 $Y=0.135
+ $X2=0.081 $Y2=0.135
r3 13 1 19.3796 $a=3.24e-16 $layer=V0LIG $X=0.082 $Y=0.138 $X2=0.081 $Y2=0.135
r4 11 10 14.6259 $w=2.1e-08 $l=4.3e-08 $layer=Gate_1 $thickness=5.6e-08
+ $X=0.081 $Y=0.2025 $X2=0.081 $Y2=0.1595
r5 9 10 2.7211 $w=2.1e-08 $l=8e-09 $layer=Gate_1 $thickness=5.6e-08 $X=0.081
+ $Y=0.1515 $X2=0.081 $Y2=0.1595
r6 8 9 5.79936 $w=2.03333e-08 $l=1.65e-08 $layer=Gate_1 $thickness=5.6e-08
+ $X=0.081 $Y=0.135 $X2=0.081 $Y2=0.1515
r7 7 8 5.79936 $w=2.03333e-08 $l=1.65e-08 $layer=Gate_1 $thickness=5.6e-08
+ $X=0.081 $Y=0.1185 $X2=0.081 $Y2=0.135
r8 6 7 2.7211 $w=2.1e-08 $l=8e-09 $layer=Gate_1 $thickness=5.6e-08 $X=0.081
+ $Y=0.1105 $X2=0.081 $Y2=0.1185
r9 5 6 14.6259 $w=2.1e-08 $l=4.3e-08 $layer=Gate_1 $thickness=5.6e-08 $X=0.081
+ $Y=0.0675 $X2=0.081 $Y2=0.1105
r10 5 3 14.6259 $w=2.1e-08 $l=4.3e-08 $layer=Gate_1 $thickness=5.6e-08 $X=0.081
+ $Y=0.0675 $X2=0.081 $Y2=0.0245
.ends

.subckt PM_O2A1O1Ixp33_ASAP7_75t_R%C vss 15 5 11 3 4 1
c1 1 vss 0.00437169f $X=0.243 $Y=0.135
c2 3 vss 0.0941416f $X=0.243 $Y=0.0245
c3 4 vss 0.00971204f $X=0.243 $Y=0.0935
r1 15 14 4.4306 $w=1.3e-08 $l=1.9e-08 $layer=M1 $thickness=3.6e-08 $X=0.242
+ $Y=0.136 $X2=0.243 $Y2=0.116
r2 4 14 5.24677 $w=1.3e-08 $l=2.25e-08 $layer=M1 $thickness=3.6e-08 $X=0.243
+ $Y=0.0935 $X2=0.243 $Y2=0.116
r3 1 8 10.4265 $w=1.765e-08 $layer=LIG $thickness=5.2e-08 $X=0.243 $Y=0.135
+ $X2=0.243 $Y2=0.135
r4 15 1 19.3796 $a=3.24e-16 $layer=V0LIG $X=0.242 $Y=0.136 $X2=0.243 $Y2=0.135
r5 11 10 14.6259 $w=2.1e-08 $l=4.3e-08 $layer=Gate_1 $thickness=5.6e-08
+ $X=0.243 $Y=0.2025 $X2=0.243 $Y2=0.1595
r6 9 10 2.7211 $w=2.1e-08 $l=8e-09 $layer=Gate_1 $thickness=5.6e-08 $X=0.243
+ $Y=0.1515 $X2=0.243 $Y2=0.1595
r7 8 9 5.79936 $w=2.03333e-08 $l=1.65e-08 $layer=Gate_1 $thickness=5.6e-08
+ $X=0.243 $Y=0.135 $X2=0.243 $Y2=0.1515
r8 7 8 5.79936 $w=2.03333e-08 $l=1.65e-08 $layer=Gate_1 $thickness=5.6e-08
+ $X=0.243 $Y=0.1185 $X2=0.243 $Y2=0.135
r9 6 7 7.31297 $w=2.1e-08 $l=2.15e-08 $layer=Gate_1 $thickness=5.6e-08 $X=0.243
+ $Y=0.097 $X2=0.243 $Y2=0.1185
r10 5 6 14.6259 $w=2.1e-08 $l=4.3e-08 $layer=Gate_1 $thickness=5.6e-08 $X=0.243
+ $Y=0.054 $X2=0.243 $Y2=0.097
r11 5 3 10.0341 $w=2.1e-08 $l=2.95e-08 $layer=Gate_1 $thickness=5.6e-08
+ $X=0.243 $Y=0.054 $X2=0.243 $Y2=0.0245
.ends

* End of included file O2A1O1Ixp33_ASAP7_75t_R.pex.sp.pex

*
.subckt O2A1O1Ixp33_ASAP7_75t_CUSTOM_4_25_0_7 VSS VDD A2 A1 B C Y
*
* VSS VSS
* VDD VDD
* A2 A2
* A1 A1
* B B
* C C
* Y Y
*
*

M0 N_M0_d N_M0_g N_M0_s VSS nmos_rvt L=2e-08 W=8.1e-08 nfin=3 $X=0.071 $Y=0.027
M1 N_M1_d N_M1_g N_M1_s VSS nmos_rvt L=2e-08 W=8.1e-08 nfin=3 $X=0.125 $Y=0.027
M2 VSS N_M2_g N_M2_s VSS nmos_rvt L=2e-08 W=8.1e-08 nfin=3 $X=0.179 $Y=0.027
M3 N_M3_d N_M3_g VSS VSS nmos_rvt L=2e-08 W=5.4e-08 nfin=2 $X=0.233 $Y=0.027
M4 noxref_10 N_M4_g noxref_8 VDD pmos_rvt L=2e-08 W=8.1e-08 nfin=3 $X=0.071
+ $Y=0.162
M5 VDD N_M5_g noxref_10 VDD pmos_rvt L=2e-08 W=8.1e-08 nfin=3 $X=0.125 $Y=0.162
M6 noxref_8 N_M6_g VDD VDD pmos_rvt L=2e-08 W=8.1e-08 nfin=3 $X=0.179 $Y=0.162
M7 N_M7_d N_M7_g noxref_8 VDD pmos_rvt L=2e-08 W=8.1e-08 nfin=3 $X=0.233
+ $Y=0.162

* .include "O2A1O1Ixp33_ASAP7_75t_R.pex.sp.pxi"

* Start of included file O2A1O1Ixp33_ASAP7_75t_R.pex.sp.pxi
x_PM_O2A1O1Ixp33_ASAP7_75t_R%B vss B N_M2_g N_M6_g N_B_4 N_B_3
+ PM_O2A1O1Ixp33_ASAP7_75t_R%B
cc_1 N_B_4 N_A1_4 0.00318307f $X=0.189 $Y=0.116
cc_2 N_B_3 N_A1_3 0.00495039f $X=0.189 $Y=0.0245
x_PM_O2A1O1Ixp33_ASAP7_75t_R%A1 vss A1 N_M1_g N_M5_g N_A1_4 N_A1_3
+ PM_O2A1O1Ixp33_ASAP7_75t_R%A1
cc_3 N_A1_4 N_A2_4 0.00333611f $X=0.135 $Y=0.116
cc_4 N_A1_3 N_A2_3 0.00695461f $X=0.135 $Y=0.0245
x_PM_O2A1O1Ixp33_ASAP7_75t_R%7 vss N_M0_s N_M1_d N_M2_s N_7_1 N_7_9 N_7_7 N_7_2
+ N_7_8 PM_O2A1O1Ixp33_ASAP7_75t_R%7
cc_5 N_7_1 N_A2_3 0.000977949f $X=0.054 $Y=0.0675
cc_6 N_7_9 N_A2_4 0.00121894f $X=0.0425 $Y=0.072
cc_7 N_7_1 N_A2_4 0.00146172f $X=0.054 $Y=0.0675
cc_8 N_7_7 N_A2_3 0.034907f $X=0.056 $Y=0.0675
cc_9 N_7_2 N_A1_3 0.000747726f $X=0.162 $Y=0.0675
cc_10 N_7_9 N_A1_4 0.00106495f $X=0.0425 $Y=0.072
cc_11 N_7_2 N_A1_4 0.00119954f $X=0.162 $Y=0.0675
cc_12 N_7_8 N_A1_3 0.0345696f $X=0.1475 $Y=0.0675
cc_13 N_7_2 N_B_3 0.0014856f $X=0.162 $Y=0.0675
cc_14 N_7_8 N_B_3 0.0352014f $X=0.1475 $Y=0.0675
x_PM_O2A1O1Ixp33_ASAP7_75t_R%Y vss Y N_M0_d N_M1_s N_M3_d N_M7_d N_Y_10 N_Y_15
+ N_Y_12 N_Y_3 N_Y_11 N_Y_16 N_Y_1 PM_O2A1O1Ixp33_ASAP7_75t_R%Y
cc_15 N_Y_10 N_A2_3 0.0358715f $X=0.0935 $Y=0.0675
cc_16 N_Y_10 N_A1_3 0.0362428f $X=0.0935 $Y=0.0675
cc_17 N_Y_15 N_C_3 0.00107457f $X=0.0965 $Y=0.036
cc_18 N_Y_12 N_C_1 0.00121757f $X=0.2555 $Y=0.2025
cc_19 N_Y_3 N_C_3 0.00127f $X=0.27 $Y=0.2025
cc_20 N_Y_11 N_C_3 0.0106036f $X=0.2555 $Y=0.054
cc_21 N_Y_16 N_C_4 0.007718f $X=0.297 $Y=0.054
cc_22 N_Y_12 N_C_3 0.051676f $X=0.2555 $Y=0.2025
cc_23 N_Y_15 N_7_2 0.000656023f $X=0.0965 $Y=0.036
cc_24 N_Y_1 N_7_1 0.00115729f $X=0.108 $Y=0.0675
cc_25 N_Y_10 N_7_7 0.00119864f $X=0.0935 $Y=0.0675
cc_26 N_Y_1 N_7_2 0.00448267f $X=0.108 $Y=0.0675
cc_27 N_Y_15 N_7_9 0.0105529f $X=0.0965 $Y=0.036
x_PM_O2A1O1Ixp33_ASAP7_75t_R%A2 vss A2 N_M0_g N_M4_g N_A2_4 N_A2_3
+ PM_O2A1O1Ixp33_ASAP7_75t_R%A2
x_PM_O2A1O1Ixp33_ASAP7_75t_R%C vss C N_M3_g N_M7_g N_C_3 N_C_4 N_C_1
+ PM_O2A1O1Ixp33_ASAP7_75t_R%C
cc_28 N_C_3 N_B_3 0.00313225f $X=0.243 $Y=0.0245
cc_29 N_C_4 N_B_4 0.00538069f $X=0.243 $Y=0.0935

* End of included file O2A1O1Ixp33_ASAP7_75t_R.pex.sp.pxi
.ends

.subckt PM_OA331x2_ASAP7_75t_R%A2 vss 13 5 9 4 3
c1 1 vss 0.00464976f $X=0.243 $Y=0.135
c2 3 vss 0.121325f $X=0.243 $Y=0.0245
c3 4 vss 0.00407864f $X=0.243 $Y=0.116
r1 13 12 1.34084 $w=1.3e-08 $l=5.8e-09 $layer=M1 $thickness=3.6e-08 $X=0.243
+ $Y=0.155 $X2=0.243 $Y2=0.1492
r2 11 12 3.32295 $w=1.3e-08 $l=1.42e-08 $layer=M1 $thickness=3.6e-08 $X=0.243
+ $Y=0.135 $X2=0.243 $Y2=0.1492
r3 4 11 4.43061 $w=1.3e-08 $l=1.9e-08 $layer=M1 $thickness=3.6e-08 $X=0.243
+ $Y=0.116 $X2=0.243 $Y2=0.135
r4 1 7 10.4265 $w=1.765e-08 $layer=LIG $thickness=5.2e-08 $X=0.243 $Y=0.135
+ $X2=0.243 $Y2=0.135
r5 1 11 19.3796 $a=3.24e-16 $layer=V0LIG $X=0.243 $Y=0.135 $X2=0.243 $Y2=0.135
r6 9 8 16.4967 $w=2.1e-08 $l=4.85e-08 $layer=Gate_1 $thickness=5.6e-08 $X=0.243
+ $Y=0.2025 $X2=0.243 $Y2=0.154
r7 7 8 6.6497 $w=2.04211e-08 $l=1.9e-08 $layer=Gate_1 $thickness=5.6e-08
+ $X=0.243 $Y=0.135 $X2=0.243 $Y2=0.154
r8 6 7 6.6497 $w=2.04211e-08 $l=1.9e-08 $layer=Gate_1 $thickness=5.6e-08
+ $X=0.243 $Y=0.116 $X2=0.243 $Y2=0.135
r9 5 6 16.4967 $w=2.1e-08 $l=4.85e-08 $layer=Gate_1 $thickness=5.6e-08 $X=0.243
+ $Y=0.0675 $X2=0.243 $Y2=0.116
r10 5 3 14.6259 $w=2.1e-08 $l=4.3e-08 $layer=Gate_1 $thickness=5.6e-08 $X=0.243
+ $Y=0.0675 $X2=0.243 $Y2=0.0245
.ends

.subckt PM_OA331x2_ASAP7_75t_R%B1 vss 13 5 9 4 3
c1 1 vss 0.00444222f $X=0.351 $Y=0.135
c2 3 vss 0.102483f $X=0.351 $Y=0.0245
c3 4 vss 0.0072522f $X=0.351 $Y=0.116
r1 13 12 1.22425 $w=1.3e-08 $l=5.3e-09 $layer=M1 $thickness=3.6e-08 $X=0.351
+ $Y=0.154 $X2=0.351 $Y2=0.1487
r2 11 12 3.20636 $w=1.3e-08 $l=1.37e-08 $layer=M1 $thickness=3.6e-08 $X=0.351
+ $Y=0.135 $X2=0.351 $Y2=0.1487
r3 4 11 4.4306 $w=1.3e-08 $l=1.9e-08 $layer=M1 $thickness=3.6e-08 $X=0.351
+ $Y=0.116 $X2=0.351 $Y2=0.135
r4 1 7 10.4265 $w=1.765e-08 $layer=LIG $thickness=5.2e-08 $X=0.351 $Y=0.135
+ $X2=0.351 $Y2=0.135
r5 1 11 19.3796 $a=3.24e-16 $layer=V0LIG $X=0.351 $Y=0.135 $X2=0.351 $Y2=0.135
r6 9 8 16.4967 $w=2.1e-08 $l=4.85e-08 $layer=Gate_1 $thickness=5.6e-08 $X=0.351
+ $Y=0.2025 $X2=0.351 $Y2=0.154
r7 7 8 6.6497 $w=2.04211e-08 $l=1.9e-08 $layer=Gate_1 $thickness=5.6e-08
+ $X=0.351 $Y=0.135 $X2=0.351 $Y2=0.154
r8 6 7 6.6497 $w=2.04211e-08 $l=1.9e-08 $layer=Gate_1 $thickness=5.6e-08
+ $X=0.351 $Y=0.116 $X2=0.351 $Y2=0.135
r9 5 6 16.4967 $w=2.1e-08 $l=4.85e-08 $layer=Gate_1 $thickness=5.6e-08 $X=0.351
+ $Y=0.0675 $X2=0.351 $Y2=0.116
r10 5 3 14.6259 $w=2.1e-08 $l=4.3e-08 $layer=Gate_1 $thickness=5.6e-08 $X=0.351
+ $Y=0.0675 $X2=0.351 $Y2=0.0245
.ends

.subckt PM_OA331x2_ASAP7_75t_R%B2 vss 13 5 9 4 3
c1 1 vss 0.00486274f $X=0.405 $Y=0.135
c2 3 vss 0.121117f $X=0.405 $Y=0.0245
c3 4 vss 0.00506092f $X=0.405 $Y=0.116
r1 13 12 1.34084 $w=1.3e-08 $l=5.8e-09 $layer=M1 $thickness=3.6e-08 $X=0.404
+ $Y=0.155 $X2=0.405 $Y2=0.1492
r2 11 12 3.32295 $w=1.3e-08 $l=1.42e-08 $layer=M1 $thickness=3.6e-08 $X=0.405
+ $Y=0.135 $X2=0.405 $Y2=0.1492
r3 4 11 4.4306 $w=1.3e-08 $l=1.9e-08 $layer=M1 $thickness=3.6e-08 $X=0.405
+ $Y=0.116 $X2=0.405 $Y2=0.135
r4 1 7 10.4265 $w=1.765e-08 $layer=LIG $thickness=5.2e-08 $X=0.405 $Y=0.135
+ $X2=0.405 $Y2=0.135
r5 1 11 19.3796 $a=3.24e-16 $layer=V0LIG $X=0.405 $Y=0.135 $X2=0.405 $Y2=0.135
r6 9 8 16.4967 $w=2.1e-08 $l=4.85e-08 $layer=Gate_1 $thickness=5.6e-08 $X=0.405
+ $Y=0.2025 $X2=0.405 $Y2=0.154
r7 7 8 6.6497 $w=2.04211e-08 $l=1.9e-08 $layer=Gate_1 $thickness=5.6e-08
+ $X=0.405 $Y=0.135 $X2=0.405 $Y2=0.154
r8 6 7 6.6497 $w=2.04211e-08 $l=1.9e-08 $layer=Gate_1 $thickness=5.6e-08
+ $X=0.405 $Y=0.116 $X2=0.405 $Y2=0.135
r9 5 6 16.4967 $w=2.1e-08 $l=4.85e-08 $layer=Gate_1 $thickness=5.6e-08 $X=0.405
+ $Y=0.0675 $X2=0.405 $Y2=0.116
r10 5 3 14.6259 $w=2.1e-08 $l=4.3e-08 $layer=Gate_1 $thickness=5.6e-08 $X=0.405
+ $Y=0.0675 $X2=0.405 $Y2=0.0245
.ends

.subckt PM_OA331x2_ASAP7_75t_R%B3 vss 13 5 9 4 3
c1 1 vss 0.00585214f $X=0.459 $Y=0.135
c2 3 vss 0.140058f $X=0.459 $Y=0.0245
c3 4 vss 0.0052703f $X=0.459 $Y=0.116
r1 13 12 1.34084 $w=1.3e-08 $l=5.8e-09 $layer=M1 $thickness=3.6e-08 $X=0.457
+ $Y=0.155 $X2=0.459 $Y2=0.1492
r2 11 12 3.32295 $w=1.3e-08 $l=1.42e-08 $layer=M1 $thickness=3.6e-08 $X=0.459
+ $Y=0.135 $X2=0.459 $Y2=0.1492
r3 4 11 4.4306 $w=1.3e-08 $l=1.9e-08 $layer=M1 $thickness=3.6e-08 $X=0.459
+ $Y=0.116 $X2=0.459 $Y2=0.135
r4 1 7 10.4265 $w=1.765e-08 $layer=LIG $thickness=5.2e-08 $X=0.459 $Y=0.135
+ $X2=0.459 $Y2=0.135
r5 1 11 19.3796 $a=3.24e-16 $layer=V0LIG $X=0.459 $Y=0.135 $X2=0.459 $Y2=0.135
r6 9 8 16.4967 $w=2.1e-08 $l=4.85e-08 $layer=Gate_1 $thickness=5.6e-08 $X=0.459
+ $Y=0.2025 $X2=0.459 $Y2=0.154
r7 7 8 6.6497 $w=2.04211e-08 $l=1.9e-08 $layer=Gate_1 $thickness=5.6e-08
+ $X=0.459 $Y=0.135 $X2=0.459 $Y2=0.154
r8 6 7 6.6497 $w=2.04211e-08 $l=1.9e-08 $layer=Gate_1 $thickness=5.6e-08
+ $X=0.459 $Y=0.116 $X2=0.459 $Y2=0.135
r9 5 6 16.4967 $w=2.1e-08 $l=4.85e-08 $layer=Gate_1 $thickness=5.6e-08 $X=0.459
+ $Y=0.0675 $X2=0.459 $Y2=0.116
r10 5 3 14.6259 $w=2.1e-08 $l=4.3e-08 $layer=Gate_1 $thickness=5.6e-08 $X=0.459
+ $Y=0.0675 $X2=0.459 $Y2=0.0245
.ends

.subckt PM_OA331x2_ASAP7_75t_R%C1 vss 15 5 11 3 1 4
c1 1 vss 0.00387047f $X=0.513 $Y=0.135
c2 3 vss 0.0888731f $X=0.513 $Y=0.0245
c3 4 vss 0.00570239f $X=0.513 $Y=0.116
r1 15 14 1.34084 $w=1.3e-08 $l=5.8e-09 $layer=M1 $thickness=3.6e-08 $X=0.515
+ $Y=0.155 $X2=0.513 $Y2=0.1492
r2 13 14 3.32295 $w=1.3e-08 $l=1.42e-08 $layer=M1 $thickness=3.6e-08 $X=0.513
+ $Y=0.135 $X2=0.513 $Y2=0.1492
r3 4 13 4.4306 $w=1.3e-08 $l=1.9e-08 $layer=M1 $thickness=3.6e-08 $X=0.513
+ $Y=0.116 $X2=0.513 $Y2=0.135
r4 1 8 10.4265 $w=1.765e-08 $layer=LIG $thickness=5.2e-08 $X=0.513 $Y=0.135
+ $X2=0.513 $Y2=0.135
r5 1 13 19.3796 $a=3.24e-16 $layer=V0LIG $X=0.513 $Y=0.135 $X2=0.513 $Y2=0.135
r6 11 10 14.6259 $w=2.1e-08 $l=4.3e-08 $layer=Gate_1 $thickness=5.6e-08
+ $X=0.513 $Y=0.2025 $X2=0.513 $Y2=0.1595
r7 9 10 2.7211 $w=2.1e-08 $l=8e-09 $layer=Gate_1 $thickness=5.6e-08 $X=0.513
+ $Y=0.1515 $X2=0.513 $Y2=0.1595
r8 8 9 5.79936 $w=2.03333e-08 $l=1.65e-08 $layer=Gate_1 $thickness=5.6e-08
+ $X=0.513 $Y=0.135 $X2=0.513 $Y2=0.1515
r9 7 8 5.79936 $w=2.03333e-08 $l=1.65e-08 $layer=Gate_1 $thickness=5.6e-08
+ $X=0.513 $Y=0.1185 $X2=0.513 $Y2=0.135
r10 6 7 2.7211 $w=2.1e-08 $l=8e-09 $layer=Gate_1 $thickness=5.6e-08 $X=0.513
+ $Y=0.1105 $X2=0.513 $Y2=0.1185
r11 5 6 14.6259 $w=2.1e-08 $l=4.3e-08 $layer=Gate_1 $thickness=5.6e-08 $X=0.513
+ $Y=0.0675 $X2=0.513 $Y2=0.1105
r12 5 3 14.6259 $w=2.1e-08 $l=4.3e-08 $layer=Gate_1 $thickness=5.6e-08 $X=0.513
+ $Y=0.0675 $X2=0.513 $Y2=0.0245
.ends

.subckt PM_OA331x2_ASAP7_75t_R%3 vss 25 31 40 43 74 75 79 84 17 1 21 13 15 3 23
+ 14 19 5 4 16 24 22 18 12
c1 1 vss 0.0076505f $X=0.081 $Y=0.135
c2 3 vss 0.00506671f $X=0.324 $Y=0.2025
c3 4 vss 0.00885757f $X=0.54 $Y=0.0675
c4 5 vss 0.00858916f $X=0.54 $Y=0.2025
c5 12 vss 0.0844018f $X=0.081 $Y=0.0245
c6 13 vss 0.0810228f $X=0.135 $Y=0.135
c7 14 vss 0.0407923f $X=0.5255 $Y=0.0675
c8 15 vss 0.0057855f $X=0.3095 $Y=0.2025
c9 16 vss 0.0407276f $X=0.5255 $Y=0.2025
c10 17 vss 0.00145012f $X=0.135 $Y=0.195
c11 18 vss 0.00289219f $X=0.162 $Y=0.234
c12 19 vss 0.00502621f $X=0.567 $Y=0.072
c13 20 vss 0.00329271f $X=0.567 $Y=0.234
c14 21 vss 0.00250422f $X=0.135 $Y=0.1205
c15 22 vss 0.000829267f $X=0.162 $Y=0.2145
c16 23 vss 0.0366481f $X=0.1755 $Y=0.234
c17 24 vss 0.00762637f $X=0.567 $Y=0.2125
r1 14 4 0.154321 $w=8.1e-08 $l=1.25e-08 $layer=N_src_drn $thickness=1e-09
+ $X=0.5255 $Y=0.0675 $X2=0.54 $Y2=0.0675
r2 84 14 0.0308642 $w=8.1e-08 $l=2.5e-09 $layer=N_src_drn $thickness=1e-09
+ $X=0.5226 $Y=0.0675 $X2=0.5255 $Y2=0.0675
r3 4 81 19.3796 $a=3.24e-16 $layer=V0LISD $X=0.54 $Y=0.0675 $X2=0.54 $Y2=0.072
r4 81 82 3.14806 $w=1.3e-08 $l=1.35e-08 $layer=M1 $thickness=3.6e-08 $X=0.54
+ $Y=0.072 $X2=0.5535 $Y2=0.072
r5 19 77 3.83327 $w=1.5093e-08 $l=2.15e-08 $layer=M1 $thickness=3.6e-08
+ $X=0.567 $Y=0.072 $X2=0.567 $Y2=0.0935
r6 19 82 1.96775 $w=1.63333e-08 $l=1.35e-08 $layer=M1 $thickness=3.6e-08
+ $X=0.567 $Y=0.072 $X2=0.5535 $Y2=0.072
r7 16 5 0.154321 $w=8.1e-08 $l=1.25e-08 $layer=P_src_drn $thickness=1e-09
+ $X=0.5255 $Y=0.2025 $X2=0.54 $Y2=0.2025
r8 79 16 0.0308642 $w=8.1e-08 $l=2.5e-09 $layer=P_src_drn $thickness=1e-09
+ $X=0.5226 $Y=0.2025 $X2=0.5255 $Y2=0.2025
r9 76 77 13.8748 $w=1.3e-08 $l=5.95e-08 $layer=M1 $thickness=3.6e-08 $X=0.567
+ $Y=0.153 $X2=0.567 $Y2=0.0935
r10 24 76 13.8748 $w=1.3e-08 $l=5.95e-08 $layer=M1 $thickness=3.6e-08 $X=0.567
+ $Y=0.2125 $X2=0.567 $Y2=0.153
r11 75 73 0.0308642 $w=8.1e-08 $l=2.5e-09 $layer=P_src_drn $thickness=1e-09
+ $X=0.3413 $Y=0.2025 $X2=0.3385 $Y2=0.2025
r12 3 73 0.179012 $w=8.1e-08 $l=1.45e-08 $layer=P_src_drn $thickness=1e-09
+ $X=0.324 $Y=0.2025 $X2=0.3385 $Y2=0.2025
r13 15 3 0.179012 $w=8.1e-08 $l=1.45e-08 $layer=P_src_drn $thickness=1e-09
+ $X=0.3095 $Y=0.2025 $X2=0.324 $Y2=0.2025
r14 74 15 0.0308642 $w=8.1e-08 $l=2.5e-09 $layer=P_src_drn $thickness=1e-09
+ $X=0.3066 $Y=0.2025 $X2=0.3095 $Y2=0.2025
r15 5 70 19.3796 $a=3.24e-16 $layer=V0LISD $X=0.54 $Y=0.2025 $X2=0.54 $Y2=0.234
r16 20 71 1.49895 $w=1.63333e-08 $l=1.35e-08 $layer=M1 $thickness=3.6e-08
+ $X=0.567 $Y=0.234 $X2=0.5535 $Y2=0.234
r17 20 24 3.36447 $w=1.71023e-08 $l=2.15e-08 $layer=M1 $thickness=3.6e-08
+ $X=0.567 $Y=0.234 $X2=0.567 $Y2=0.2125
r18 3 57 19.3796 $a=3.24e-16 $layer=V0LISD $X=0.324 $Y=0.2025 $X2=0.324
+ $Y2=0.234
r19 70 71 3.14806 $w=1.3e-08 $l=1.35e-08 $layer=M1 $thickness=3.6e-08 $X=0.54
+ $Y=0.234 $X2=0.5535 $Y2=0.234
r20 69 70 2.79828 $w=1.3e-08 $l=1.2e-08 $layer=M1 $thickness=3.6e-08 $X=0.528
+ $Y=0.234 $X2=0.54 $Y2=0.234
r21 68 69 1.04935 $w=1.3e-08 $l=4.5e-09 $layer=M1 $thickness=3.6e-08 $X=0.5235
+ $Y=0.234 $X2=0.528 $Y2=0.234
r22 67 68 2.44849 $w=1.3e-08 $l=1.05e-08 $layer=M1 $thickness=3.6e-08 $X=0.513
+ $Y=0.234 $X2=0.5235 $Y2=0.234
r23 66 67 2.44849 $w=1.3e-08 $l=1.05e-08 $layer=M1 $thickness=3.6e-08 $X=0.5025
+ $Y=0.234 $X2=0.513 $Y2=0.234
r24 65 66 4.19742 $w=1.3e-08 $l=1.8e-08 $layer=M1 $thickness=3.6e-08 $X=0.4845
+ $Y=0.234 $X2=0.5025 $Y2=0.234
r25 64 65 5.94634 $w=1.3e-08 $l=2.55e-08 $layer=M1 $thickness=3.6e-08 $X=0.459
+ $Y=0.234 $X2=0.4845 $Y2=0.234
r26 63 64 2.44849 $w=1.3e-08 $l=1.05e-08 $layer=M1 $thickness=3.6e-08 $X=0.4485
+ $Y=0.234 $X2=0.459 $Y2=0.234
r27 62 63 4.19742 $w=1.3e-08 $l=1.8e-08 $layer=M1 $thickness=3.6e-08 $X=0.4305
+ $Y=0.234 $X2=0.4485 $Y2=0.234
r28 61 62 5.94634 $w=1.3e-08 $l=2.55e-08 $layer=M1 $thickness=3.6e-08 $X=0.405
+ $Y=0.234 $X2=0.4305 $Y2=0.234
r29 60 61 6.29612 $w=1.3e-08 $l=2.7e-08 $layer=M1 $thickness=3.6e-08 $X=0.378
+ $Y=0.234 $X2=0.405 $Y2=0.234
r30 59 60 6.29612 $w=1.3e-08 $l=2.7e-08 $layer=M1 $thickness=3.6e-08 $X=0.351
+ $Y=0.234 $X2=0.378 $Y2=0.234
r31 58 59 3.14806 $w=1.3e-08 $l=1.35e-08 $layer=M1 $thickness=3.6e-08 $X=0.3375
+ $Y=0.234 $X2=0.351 $Y2=0.234
r32 57 58 3.14806 $w=1.3e-08 $l=1.35e-08 $layer=M1 $thickness=3.6e-08 $X=0.324
+ $Y=0.234 $X2=0.3375 $Y2=0.234
r33 56 57 3.14806 $w=1.3e-08 $l=1.35e-08 $layer=M1 $thickness=3.6e-08 $X=0.3105
+ $Y=0.234 $X2=0.324 $Y2=0.234
r34 55 56 3.14806 $w=1.3e-08 $l=1.35e-08 $layer=M1 $thickness=3.6e-08 $X=0.297
+ $Y=0.234 $X2=0.3105 $Y2=0.234
r35 54 55 6.29612 $w=1.3e-08 $l=2.7e-08 $layer=M1 $thickness=3.6e-08 $X=0.27
+ $Y=0.234 $X2=0.297 $Y2=0.234
r36 53 54 6.29612 $w=1.3e-08 $l=2.7e-08 $layer=M1 $thickness=3.6e-08 $X=0.243
+ $Y=0.234 $X2=0.27 $Y2=0.234
r37 52 53 5.82974 $w=1.3e-08 $l=2.5e-08 $layer=M1 $thickness=3.6e-08 $X=0.218
+ $Y=0.234 $X2=0.243 $Y2=0.234
r38 51 52 4.19742 $w=1.3e-08 $l=1.8e-08 $layer=M1 $thickness=3.6e-08 $X=0.2
+ $Y=0.234 $X2=0.218 $Y2=0.234
r39 50 51 2.56509 $w=1.3e-08 $l=1.1e-08 $layer=M1 $thickness=3.6e-08 $X=0.189
+ $Y=0.234 $X2=0.2 $Y2=0.234
r40 23 50 3.14806 $w=1.3e-08 $l=1.35e-08 $layer=M1 $thickness=3.6e-08 $X=0.1755
+ $Y=0.234 $X2=0.189 $Y2=0.234
r41 18 22 2.89809 $w=1.75231e-08 $l=1.95e-08 $layer=M1 $thickness=3.6e-08
+ $X=0.162 $Y=0.234 $X2=0.162 $Y2=0.2145
r42 18 23 1.49895 $w=1.63333e-08 $l=1.35e-08 $layer=M1 $thickness=3.6e-08
+ $X=0.162 $Y=0.234 $X2=0.1755 $Y2=0.234
r43 22 49 3.36689 $w=1.53077e-08 $l=1.95e-08 $layer=M1 $thickness=3.6e-08
+ $X=0.162 $Y=0.2145 $X2=0.162 $Y2=0.195
r44 48 49 1.96775 $w=1.63333e-08 $l=1.35e-08 $layer=M1 $thickness=3.6e-08
+ $X=0.1485 $Y=0.195 $X2=0.162 $Y2=0.195
r45 17 47 3.2503 $w=1.53684e-08 $l=1.9e-08 $layer=M1 $thickness=3.6e-08
+ $X=0.135 $Y=0.195 $X2=0.135 $Y2=0.176
r46 17 48 1.96775 $w=1.63333e-08 $l=1.35e-08 $layer=M1 $thickness=3.6e-08
+ $X=0.135 $Y=0.195 $X2=0.1485 $Y2=0.195
r47 46 47 4.89699 $w=1.3e-08 $l=2.1e-08 $layer=M1 $thickness=3.6e-08 $X=0.135
+ $Y=0.155 $X2=0.135 $Y2=0.176
r48 45 46 4.6638 $w=1.3e-08 $l=2e-08 $layer=M1 $thickness=3.6e-08 $X=0.135
+ $Y=0.135 $X2=0.135 $Y2=0.155
r49 21 45 3.38125 $w=1.3e-08 $l=1.45e-08 $layer=M1 $thickness=3.6e-08 $X=0.135
+ $Y=0.1205 $X2=0.135 $Y2=0.135
r50 43 42 16.4967 $w=2.1e-08 $l=4.85e-08 $layer=Gate_1 $thickness=5.6e-08
+ $X=0.135 $Y=0.2025 $X2=0.135 $Y2=0.154
r51 40 41 16.4967 $w=2.1e-08 $l=4.85e-08 $layer=Gate_1 $thickness=5.6e-08
+ $X=0.135 $Y=0.0675 $X2=0.135 $Y2=0.116
r52 13 36 6.27904 $w=2.09e-08 $layer=Gate_1 $thickness=5.24e-08 $X=0.135
+ $Y=0.135 $X2=0.135 $Y2=0.135
r53 13 41 6.6497 $w=2.04211e-08 $l=1.9e-08 $layer=Gate_1 $thickness=5.6e-08
+ $X=0.135 $Y=0.135 $X2=0.135 $Y2=0.116
r54 13 42 6.6497 $w=2.04211e-08 $l=1.9e-08 $layer=Gate_1 $thickness=5.6e-08
+ $X=0.135 $Y=0.135 $X2=0.135 $Y2=0.154
r55 36 45 19.3796 $a=3.24e-16 $layer=V0LIG $X=0.135 $Y=0.135 $X2=0.135 $Y2=0.135
r56 35 36 2.48102 $w=2.2e-08 $l=9.5e-09 $layer=LIG $thickness=4.8e-08 $X=0.1255
+ $Y=0.135 $X2=0.135 $Y2=0.135
r57 34 35 10.1729 $w=1.54914e-08 $l=1.75e-08 $layer=LIG $thickness=4.8e-08
+ $X=0.108 $Y=0.135 $X2=0.1255 $Y2=0.135
r58 1 28 6.54019 $w=2.09524e-08 $layer=Gate_1 $thickness=5.21905e-08 $X=0.081
+ $Y=0.135 $X2=0.081 $Y2=0.135
r59 1 34 12.6539 $w=1.77815e-08 $l=2.7e-08 $layer=LIG $thickness=4.8e-08
+ $X=0.081 $Y=0.135 $X2=0.108 $Y2=0.135
r60 31 30 14.6259 $w=2.1e-08 $l=4.3e-08 $layer=Gate_1 $thickness=5.6e-08
+ $X=0.081 $Y=0.2025 $X2=0.081 $Y2=0.1595
r61 29 30 2.7211 $w=2.1e-08 $l=8e-09 $layer=Gate_1 $thickness=5.6e-08 $X=0.081
+ $Y=0.1515 $X2=0.081 $Y2=0.1595
r62 28 29 5.79936 $w=2.03333e-08 $l=1.65e-08 $layer=Gate_1 $thickness=5.6e-08
+ $X=0.081 $Y=0.135 $X2=0.081 $Y2=0.1515
r63 27 28 5.79936 $w=2.03333e-08 $l=1.65e-08 $layer=Gate_1 $thickness=5.6e-08
+ $X=0.081 $Y=0.1185 $X2=0.081 $Y2=0.135
r64 26 27 2.7211 $w=2.1e-08 $l=8e-09 $layer=Gate_1 $thickness=5.6e-08 $X=0.081
+ $Y=0.1105 $X2=0.081 $Y2=0.1185
r65 25 26 14.6259 $w=2.1e-08 $l=4.3e-08 $layer=Gate_1 $thickness=5.6e-08
+ $X=0.081 $Y=0.0675 $X2=0.081 $Y2=0.1105
r66 25 12 14.6259 $w=2.1e-08 $l=4.3e-08 $layer=Gate_1 $thickness=5.6e-08
+ $X=0.081 $Y=0.0675 $X2=0.081 $Y2=0.0245
.ends

.subckt PM_OA331x2_ASAP7_75t_R%Y vss 22 16 17 30 31 7 2 13 8
c1 1 vss 0.00979954f $X=0.108 $Y=0.0675
c2 2 vss 0.00868729f $X=0.108 $Y=0.2025
c3 7 vss 0.00435491f $X=0.0935 $Y=0.0675
c4 8 vss 0.00434117f $X=0.0935 $Y=0.2025
c5 9 vss 0.00318515f $X=0.054 $Y=0.036
c6 10 vss 0.0031853f $X=0.054 $Y=0.234
c7 11 vss 0.00882636f $X=0.054 $Y=0.0575
c8 12 vss 0.00627864f $X=0.081 $Y=0.036
c9 13 vss 0.00539907f $X=0.081 $Y=0.234
r1 30 29 0.0308642 $w=8.1e-08 $l=2.5e-09 $layer=P_src_drn $thickness=1e-09
+ $X=0.1253 $Y=0.2025 $X2=0.1225 $Y2=0.2025
r2 2 29 0.179012 $w=8.1e-08 $l=1.45e-08 $layer=P_src_drn $thickness=1e-09
+ $X=0.108 $Y=0.2025 $X2=0.1225 $Y2=0.2025
r3 8 2 0.179012 $w=8.1e-08 $l=1.45e-08 $layer=P_src_drn $thickness=1e-09
+ $X=0.0935 $Y=0.2025 $X2=0.108 $Y2=0.2025
r4 31 8 0.0308642 $w=8.1e-08 $l=2.5e-09 $layer=P_src_drn $thickness=1e-09
+ $X=0.0906 $Y=0.2025 $X2=0.0935 $Y2=0.2025
r5 2 26 19.3796 $a=3.24e-16 $layer=V0LISD $X=0.108 $Y=0.2025 $X2=0.108 $Y2=0.234
r6 13 26 6.29612 $w=1.3e-08 $l=2.7e-08 $layer=M1 $thickness=3.6e-08 $X=0.081
+ $Y=0.234 $X2=0.108 $Y2=0.234
r7 10 25 2.89809 $w=1.75231e-08 $l=1.95e-08 $layer=M1 $thickness=3.6e-08
+ $X=0.054 $Y=0.234 $X2=0.054 $Y2=0.2145
r8 10 13 4.64701 $w=1.46667e-08 $l=2.7e-08 $layer=M1 $thickness=3.6e-08
+ $X=0.054 $Y=0.234 $X2=0.081 $Y2=0.234
r9 24 25 4.5472 $w=1.3e-08 $l=1.95e-08 $layer=M1 $thickness=3.6e-08 $X=0.054
+ $Y=0.195 $X2=0.054 $Y2=0.2145
r10 23 24 7.05399 $w=1.3e-08 $l=3.03e-08 $layer=M1 $thickness=3.6e-08 $X=0.054
+ $Y=0.1647 $X2=0.054 $Y2=0.195
r11 22 23 5.07188 $w=1.3e-08 $l=2.17e-08 $layer=M1 $thickness=3.6e-08 $X=0.057
+ $Y=0.143 $X2=0.054 $Y2=0.1647
r12 22 21 3.32295 $w=1.3e-08 $l=1.43e-08 $layer=M1 $thickness=3.6e-08 $X=0.057
+ $Y=0.143 $X2=0.054 $Y2=0.1287
r13 20 21 8.45313 $w=1.3e-08 $l=3.62e-08 $layer=M1 $thickness=3.6e-08 $X=0.054
+ $Y=0.0925 $X2=0.054 $Y2=0.1287
r14 11 20 8.16164 $w=1.3e-08 $l=3.5e-08 $layer=M1 $thickness=3.6e-08 $X=0.054
+ $Y=0.0575 $X2=0.054 $Y2=0.0925
r15 9 12 4.64701 $w=1.46667e-08 $l=2.7e-08 $layer=M1 $thickness=3.6e-08
+ $X=0.054 $Y=0.036 $X2=0.081 $Y2=0.036
r16 9 11 3.36447 $w=1.71023e-08 $l=2.15e-08 $layer=M1 $thickness=3.6e-08
+ $X=0.054 $Y=0.036 $X2=0.054 $Y2=0.0575
r17 12 18 6.29612 $w=1.3e-08 $l=2.7e-08 $layer=M1 $thickness=3.6e-08 $X=0.081
+ $Y=0.036 $X2=0.108 $Y2=0.036
r18 1 18 19.3796 $a=3.24e-16 $layer=V0LISD $X=0.108 $Y=0.0675 $X2=0.108
+ $Y2=0.036
r19 17 15 0.0308642 $w=8.1e-08 $l=2.5e-09 $layer=N_src_drn $thickness=1e-09
+ $X=0.1253 $Y=0.0675 $X2=0.1225 $Y2=0.0675
r20 1 15 0.179012 $w=8.1e-08 $l=1.45e-08 $layer=N_src_drn $thickness=1e-09
+ $X=0.108 $Y=0.0675 $X2=0.1225 $Y2=0.0675
r21 7 1 0.179012 $w=8.1e-08 $l=1.45e-08 $layer=N_src_drn $thickness=1e-09
+ $X=0.0935 $Y=0.0675 $X2=0.108 $Y2=0.0675
r22 16 7 0.0308642 $w=8.1e-08 $l=2.5e-09 $layer=N_src_drn $thickness=1e-09
+ $X=0.0906 $Y=0.0675 $X2=0.0935 $Y2=0.0675
.ends

.subckt PM_OA331x2_ASAP7_75t_R%A3 vss 16 5 9 3 4
c1 1 vss 0.00588569f $X=0.189 $Y=0.135
c2 3 vss 0.139757f $X=0.189 $Y=0.0245
c3 4 vss 0.00724992f $X=0.189 $Y=0.1105
r1 16 15 1.34084 $w=1.3e-08 $l=5.8e-09 $layer=M1 $thickness=3.6e-08 $X=0.189
+ $Y=0.155 $X2=0.189 $Y2=0.1492
r2 14 15 3.32295 $w=1.3e-08 $l=1.42e-08 $layer=M1 $thickness=3.6e-08 $X=0.189
+ $Y=0.135 $X2=0.189 $Y2=0.1492
r3 13 14 3.38125 $w=1.3e-08 $l=1.45e-08 $layer=M1 $thickness=3.6e-08 $X=0.189
+ $Y=0.1205 $X2=0.189 $Y2=0.135
r4 4 13 2.3319 $w=1.3e-08 $l=1e-08 $layer=M1 $thickness=3.6e-08 $X=0.189
+ $Y=0.1105 $X2=0.189 $Y2=0.1205
r5 1 7 10.4265 $w=1.765e-08 $layer=LIG $thickness=5.2e-08 $X=0.189 $Y=0.135
+ $X2=0.189 $Y2=0.135
r6 1 14 19.3796 $a=3.24e-16 $layer=V0LIG $X=0.189 $Y=0.135 $X2=0.189 $Y2=0.135
r7 9 8 16.4967 $w=2.1e-08 $l=4.85e-08 $layer=Gate_1 $thickness=5.6e-08 $X=0.189
+ $Y=0.2025 $X2=0.189 $Y2=0.154
r8 7 8 6.6497 $w=2.04211e-08 $l=1.9e-08 $layer=Gate_1 $thickness=5.6e-08
+ $X=0.189 $Y=0.135 $X2=0.189 $Y2=0.154
r9 6 7 6.6497 $w=2.04211e-08 $l=1.9e-08 $layer=Gate_1 $thickness=5.6e-08
+ $X=0.189 $Y=0.116 $X2=0.189 $Y2=0.135
r10 5 6 16.4967 $w=2.1e-08 $l=4.85e-08 $layer=Gate_1 $thickness=5.6e-08
+ $X=0.189 $Y=0.0675 $X2=0.189 $Y2=0.116
r11 5 3 14.6259 $w=2.1e-08 $l=4.3e-08 $layer=Gate_1 $thickness=5.6e-08 $X=0.189
+ $Y=0.0675 $X2=0.189 $Y2=0.0245
.ends

.subckt PM_OA331x2_ASAP7_75t_R%A1 vss 13 5 9 4 3
c1 1 vss 0.0044377f $X=0.297 $Y=0.135
c2 3 vss 0.102392f $X=0.297 $Y=0.0245
c3 4 vss 0.00717634f $X=0.297 $Y=0.116
r1 13 12 1.34084 $w=1.3e-08 $l=5.8e-09 $layer=M1 $thickness=3.6e-08 $X=0.297
+ $Y=0.155 $X2=0.297 $Y2=0.1492
r2 11 12 3.32295 $w=1.3e-08 $l=1.42e-08 $layer=M1 $thickness=3.6e-08 $X=0.297
+ $Y=0.135 $X2=0.297 $Y2=0.1492
r3 4 11 4.4306 $w=1.3e-08 $l=1.9e-08 $layer=M1 $thickness=3.6e-08 $X=0.297
+ $Y=0.116 $X2=0.297 $Y2=0.135
r4 1 7 10.4265 $w=1.765e-08 $layer=LIG $thickness=5.2e-08 $X=0.297 $Y=0.135
+ $X2=0.297 $Y2=0.135
r5 1 11 19.3796 $a=3.24e-16 $layer=V0LIG $X=0.297 $Y=0.135 $X2=0.297 $Y2=0.135
r6 9 8 16.4967 $w=2.1e-08 $l=4.85e-08 $layer=Gate_1 $thickness=5.6e-08 $X=0.297
+ $Y=0.2025 $X2=0.297 $Y2=0.154
r7 7 8 6.6497 $w=2.04211e-08 $l=1.9e-08 $layer=Gate_1 $thickness=5.6e-08
+ $X=0.297 $Y=0.135 $X2=0.297 $Y2=0.154
r8 6 7 6.6497 $w=2.04211e-08 $l=1.9e-08 $layer=Gate_1 $thickness=5.6e-08
+ $X=0.297 $Y=0.116 $X2=0.297 $Y2=0.135
r9 5 6 16.4967 $w=2.1e-08 $l=4.85e-08 $layer=Gate_1 $thickness=5.6e-08 $X=0.297
+ $Y=0.0675 $X2=0.297 $Y2=0.116
r10 5 3 14.6259 $w=2.1e-08 $l=4.3e-08 $layer=Gate_1 $thickness=5.6e-08 $X=0.297
+ $Y=0.0675 $X2=0.297 $Y2=0.0245
.ends

* End of included file OA331x2_ASAP7_75t_R.pex.sp.pex

*
.subckt OA331x2_ASAP7_75t_CUSTOM_4_25_0_7 VSS VDD A3 A2 A1 B1 B2 B3 C1 Y
*
* VSS VSS
* VDD VDD
* A3 A3
* A2 A2
* A1 A1
* B1 B1
* B2 B2
* B3 B3
* C1 C1
* Y Y
*
*

M0 N_M0_d N_M0_g VSS VSS nmos_rvt L=2e-08 W=8.1e-08 nfin=3 $X=0.071 $Y=0.027
M1 N_M1_d N_M1_g VSS VSS nmos_rvt L=2e-08 W=8.1e-08 nfin=3 $X=0.125 $Y=0.027
M2 noxref_12 N_M2_g VSS VSS nmos_rvt L=2e-08 W=8.1e-08 nfin=3 $X=0.179 $Y=0.027
M3 VSS N_M3_g noxref_12 VSS nmos_rvt L=2e-08 W=8.1e-08 nfin=3 $X=0.233 $Y=0.027
M4 noxref_12 N_M4_g VSS VSS nmos_rvt L=2e-08 W=8.1e-08 nfin=3 $X=0.287 $Y=0.027
M5 noxref_13 N_M5_g noxref_12 VSS nmos_rvt L=2e-08 W=8.1e-08 nfin=3 $X=0.341
+ $Y=0.027
M6 noxref_12 N_M6_g noxref_13 VSS nmos_rvt L=2e-08 W=8.1e-08 nfin=3 $X=0.395
+ $Y=0.027
M7 noxref_13 N_M7_g noxref_12 VSS nmos_rvt L=2e-08 W=8.1e-08 nfin=3 $X=0.449
+ $Y=0.027
M8 N_M8_d N_M8_g noxref_13 VSS nmos_rvt L=2e-08 W=8.1e-08 nfin=3 $X=0.503
+ $Y=0.027
M9 N_M9_d N_M9_g VDD VDD pmos_rvt L=2e-08 W=8.1e-08 nfin=3 $X=0.071 $Y=0.162
M10 N_M10_d N_M10_g VDD VDD pmos_rvt L=2e-08 W=8.1e-08 nfin=3 $X=0.125 $Y=0.162
M11 noxref_14 N_M11_g VDD VDD pmos_rvt L=2e-08 W=8.1e-08 nfin=3 $X=0.179
+ $Y=0.162
M12 noxref_15 N_M12_g noxref_14 VDD pmos_rvt L=2e-08 W=8.1e-08 nfin=3 $X=0.233
+ $Y=0.162
M13 N_M13_d N_M13_g noxref_15 VDD pmos_rvt L=2e-08 W=8.1e-08 nfin=3 $X=0.287
+ $Y=0.162
M14 noxref_16 N_M14_g N_M14_s VDD pmos_rvt L=2e-08 W=8.1e-08 nfin=3 $X=0.341
+ $Y=0.162
M15 noxref_17 N_M15_g noxref_16 VDD pmos_rvt L=2e-08 W=8.1e-08 nfin=3 $X=0.395
+ $Y=0.162
M16 VDD N_M16_g noxref_17 VDD pmos_rvt L=2e-08 W=8.1e-08 nfin=3 $X=0.449
+ $Y=0.162
M17 N_M17_d N_M17_g VDD VDD pmos_rvt L=2e-08 W=8.1e-08 nfin=3 $X=0.503 $Y=0.162

* .include "OA331x2_ASAP7_75t_R.pex.sp.pxi"

* Start of included file OA331x2_ASAP7_75t_R.pex.sp.pxi
x_PM_OA331x2_ASAP7_75t_R%A2 vss A2 N_M3_g N_M12_g N_A2_4 N_A2_3
+ PM_OA331x2_ASAP7_75t_R%A2
cc_1 N_A2_4 N_3_15 0.000188935f $X=0.243 $Y=0.116
cc_2 N_A2_4 N_3_3 0.000335905f $X=0.243 $Y=0.116
cc_3 N_A2_4 N_3_23 0.00384626f $X=0.243 $Y=0.116
cc_4 N_A2_4 N_A3_4 0.00313402f $X=0.243 $Y=0.116
cc_5 N_A2_3 N_A3_3 0.00697343f $X=0.243 $Y=0.0245
x_PM_OA331x2_ASAP7_75t_R%B1 vss B1 N_M5_g N_M14_g N_B1_4 N_B1_3
+ PM_OA331x2_ASAP7_75t_R%B1
cc_6 N_B1_4 N_3_23 0.00124307f $X=0.351 $Y=0.116
cc_7 N_B1_3 N_3_3 0.00151222f $X=0.351 $Y=0.0245
cc_8 N_B1_4 N_3_3 0.00181309f $X=0.351 $Y=0.116
cc_9 N_B1_3 N_3_15 0.0359987f $X=0.351 $Y=0.0245
cc_10 N_B1_3 N_A1_3 0.00317569f $X=0.351 $Y=0.0245
cc_11 N_B1_4 N_A1_4 0.00495125f $X=0.351 $Y=0.116
x_PM_OA331x2_ASAP7_75t_R%B2 vss B2 N_M6_g N_M15_g N_B2_4 N_B2_3
+ PM_OA331x2_ASAP7_75t_R%B2
cc_12 N_B2_4 N_3_3 0.000336394f $X=0.405 $Y=0.116
cc_13 N_B2_4 N_3_23 0.00327274f $X=0.405 $Y=0.116
cc_14 N_B2_4 N_B1_4 0.00332878f $X=0.405 $Y=0.116
cc_15 N_B2_3 N_B1_3 0.00704466f $X=0.405 $Y=0.0245
x_PM_OA331x2_ASAP7_75t_R%B3 vss B3 N_M7_g N_M16_g N_B3_4 N_B3_3
+ PM_OA331x2_ASAP7_75t_R%B3
cc_16 N_B3_4 N_3_23 0.00318162f $X=0.459 $Y=0.116
cc_17 N_B3_4 N_B2_4 0.00334571f $X=0.459 $Y=0.116
cc_18 N_B3_3 N_B2_3 0.00696013f $X=0.459 $Y=0.0245
x_PM_OA331x2_ASAP7_75t_R%C1 vss C1 N_M8_g N_M17_g N_C1_3 N_C1_1 N_C1_4
+ PM_OA331x2_ASAP7_75t_R%C1
cc_19 N_C1_3 N_3_14 0.0152523f $X=0.513 $Y=0.0245
cc_20 N_C1_3 N_3_19 0.000495394f $X=0.513 $Y=0.0245
cc_21 N_C1_3 N_3_5 0.00202147f $X=0.513 $Y=0.0245
cc_22 N_C1_3 N_3_4 0.000920482f $X=0.513 $Y=0.0245
cc_23 N_C1_3 N_3_23 0.00102416f $X=0.513 $Y=0.0245
cc_24 N_C1_1 N_3_16 0.00167095f $X=0.513 $Y=0.135
cc_25 N_C1_4 N_3_24 0.00594886f $X=0.513 $Y=0.116
cc_26 N_C1_3 N_3_16 0.0539505f $X=0.513 $Y=0.0245
cc_27 N_C1_3 N_B3_3 0.00325606f $X=0.513 $Y=0.0245
cc_28 N_C1_4 N_B3_4 0.0053253f $X=0.513 $Y=0.116
x_PM_OA331x2_ASAP7_75t_R%3 vss N_M0_g N_M9_g N_M1_g N_M10_g N_M13_d N_M14_s
+ N_M17_d N_M8_d N_3_17 N_3_1 N_3_21 N_3_13 N_3_15 N_3_3 N_3_23 N_3_14 N_3_19
+ N_3_5 N_3_4 N_3_16 N_3_24 N_3_22 N_3_18 N_3_12 PM_OA331x2_ASAP7_75t_R%3
x_PM_OA331x2_ASAP7_75t_R%Y vss Y N_M0_d N_M1_d N_M10_d N_M9_d N_Y_7 N_Y_2
+ N_Y_13 N_Y_8 PM_OA331x2_ASAP7_75t_R%Y
cc_29 N_Y_7 N_3_22 0.000352965f $X=0.0935 $Y=0.0675
cc_30 N_Y_7 N_3_17 0.000376146f $X=0.0935 $Y=0.0675
cc_31 N_Y_7 N_3_18 0.000390766f $X=0.0935 $Y=0.0675
cc_32 N_Y_7 N_3_1 0.00209101f $X=0.0935 $Y=0.0675
cc_33 N_Y_7 N_3_13 0.038842f $X=0.0935 $Y=0.0675
cc_34 N_Y_7 N_3_21 0.00156847f $X=0.0935 $Y=0.0675
cc_35 N_Y_2 N_3_13 0.00210713f $X=0.108 $Y=0.2025
cc_36 N_Y_13 N_3_17 0.00213334f $X=0.081 $Y=0.234
cc_37 N_Y_8 N_3_1 0.00489722f $X=0.0935 $Y=0.2025
cc_38 N_Y_8 N_3_12 0.0286542f $X=0.0935 $Y=0.2025
cc_39 N_Y_7 N_3_12 0.0664814f $X=0.0935 $Y=0.0675
x_PM_OA331x2_ASAP7_75t_R%A3 vss A3 N_M2_g N_M11_g N_A3_3 N_A3_4
+ PM_OA331x2_ASAP7_75t_R%A3
cc_40 N_A3_3 N_3_17 0.000664934f $X=0.189 $Y=0.0245
cc_41 N_A3_3 N_3_1 0.00231819f $X=0.189 $Y=0.0245
cc_42 N_A3_4 N_3_21 0.00315956f $X=0.189 $Y=0.1105
cc_43 N_A3_3 N_3_13 0.0039274f $X=0.189 $Y=0.0245
x_PM_OA331x2_ASAP7_75t_R%A1 vss A1 N_M4_g N_M13_g N_A1_4 N_A1_3
+ PM_OA331x2_ASAP7_75t_R%A1
cc_44 N_A1_4 N_3_23 0.00125235f $X=0.297 $Y=0.116
cc_45 N_A1_3 N_3_3 0.00151237f $X=0.297 $Y=0.0245
cc_46 N_A1_4 N_3_3 0.00185139f $X=0.297 $Y=0.116
cc_47 N_A1_3 N_3_15 0.036075f $X=0.297 $Y=0.0245
cc_48 N_A1_4 N_A2_4 0.00344711f $X=0.297 $Y=0.116
cc_49 N_A1_3 N_A2_3 0.00696669f $X=0.297 $Y=0.0245

* End of included file OA331x2_ASAP7_75t_R.pex.sp.pxi
.ends

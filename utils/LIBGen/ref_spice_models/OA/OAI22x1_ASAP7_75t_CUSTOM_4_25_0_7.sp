.subckt PM_OAI22x1_ASAP7_75t_R%B1 vss 23 8 12 27 30 3 1 6 4
c1 1 vss 0.0149678f $X=0.1795 $Y=0.135
c2 3 vss 0.138106f $X=0.135 $Y=0.135
c3 4 vss 0.139417f $X=0.189 $Y=0.0245
c4 5 vss 0.00709388f $X=0.189 $Y=0.072
c5 6 vss 0.00194009f $X=0.189 $Y=0.162
c6 7 vss 0.00352577f $X=0.189 $Y=0.121
r1 5 25 3.01711 $w=1.55e-08 $l=1.8e-08 $layer=M1 $thickness=3.6e-08 $X=0.189
+ $Y=0.072 $X2=0.189 $Y2=0.09
r2 6 21 1.96775 $w=1.63333e-08 $l=1.35e-08 $layer=M1 $thickness=3.6e-08
+ $X=0.189 $Y=0.162 $X2=0.189 $Y2=0.1485
r3 30 29 16.4967 $w=2.1e-08 $l=4.85e-08 $layer=Gate_1 $thickness=5.6e-08
+ $X=0.135 $Y=0.2025 $X2=0.135 $Y2=0.154
r4 27 28 16.4967 $w=2.1e-08 $l=4.85e-08 $layer=Gate_1 $thickness=5.6e-08
+ $X=0.135 $Y=0.0675 $X2=0.135 $Y2=0.116
r5 3 17 6.54019 $w=2.09524e-08 $layer=Gate_1 $thickness=5.21905e-08 $X=0.135
+ $Y=0.135 $X2=0.135 $Y2=0.135
r6 3 28 6.6497 $w=2.04211e-08 $l=1.9e-08 $layer=Gate_1 $thickness=5.6e-08
+ $X=0.135 $Y=0.135 $X2=0.135 $Y2=0.116
r7 3 29 6.6497 $w=2.04211e-08 $l=1.9e-08 $layer=Gate_1 $thickness=5.6e-08
+ $X=0.135 $Y=0.135 $X2=0.135 $Y2=0.154
r8 23 24 0.991057 $w=1.3e-08 $l=4.2e-09 $layer=M1 $thickness=3.6e-08 $X=0.183
+ $Y=0.108 $X2=0.189 $Y2=0.1122
r9 23 22 1.10765 $w=1.3e-08 $l=4.8e-09 $layer=M1 $thickness=3.6e-08 $X=0.183
+ $Y=0.108 $X2=0.189 $Y2=0.1032
r10 22 25 3.08976 $w=1.3e-08 $l=1.32e-08 $layer=M1 $thickness=3.6e-08 $X=0.189
+ $Y=0.1032 $X2=0.189 $Y2=0.09
r11 20 21 3.14806 $w=1.3e-08 $l=1.35e-08 $layer=M1 $thickness=3.6e-08 $X=0.189
+ $Y=0.135 $X2=0.189 $Y2=0.1485
r12 7 20 3.26466 $w=1.3e-08 $l=1.4e-08 $layer=M1 $thickness=3.6e-08 $X=0.189
+ $Y=0.121 $X2=0.189 $Y2=0.135
r13 7 24 2.04041 $w=1.3e-08 $l=8.8e-09 $layer=M1 $thickness=3.6e-08 $X=0.189
+ $Y=0.121 $X2=0.189 $Y2=0.1122
r14 16 17 12.6539 $w=1.77815e-08 $l=2.7e-08 $layer=LIG $thickness=4.8e-08
+ $X=0.162 $Y=0.135 $X2=0.135 $Y2=0.135
r15 14 15 2.48102 $w=2.2e-08 $l=9.5e-09 $layer=LIG $thickness=4.8e-08 $X=0.189
+ $Y=0.135 $X2=0.1985 $Y2=0.135
r16 14 20 19.3796 $a=3.24e-16 $layer=V0LIG $X=0.189 $Y=0.135 $X2=0.189 $Y2=0.135
r17 1 14 2.48102 $w=2.2e-08 $l=9.5e-09 $layer=LIG $thickness=4.8e-08 $X=0.1795
+ $Y=0.135 $X2=0.189 $Y2=0.135
r18 1 16 10.1729 $w=1.54914e-08 $l=1.75e-08 $layer=LIG $thickness=4.8e-08
+ $X=0.1795 $Y=0.135 $X2=0.162 $Y2=0.135
r19 12 11 16.4967 $w=2.1e-08 $l=4.85e-08 $layer=Gate_1 $thickness=5.6e-08
+ $X=0.189 $Y=0.2025 $X2=0.189 $Y2=0.154
r20 10 11 6.6497 $w=2.04211e-08 $l=1.9e-08 $layer=Gate_1 $thickness=5.6e-08
+ $X=0.189 $Y=0.135 $X2=0.189 $Y2=0.154
r21 10 15 4.05918 $w=2.0087e-08 $l=9.5e-09 $layer=Gate_1 $thickness=5.56522e-08
+ $X=0.189 $Y=0.135 $X2=0.1985 $Y2=0.135
r22 10 14 6.27904 $w=2.09e-08 $layer=Gate_1 $thickness=5.24e-08 $X=0.189
+ $Y=0.135 $X2=0.189 $Y2=0.135
r23 9 10 6.6497 $w=2.04211e-08 $l=1.9e-08 $layer=Gate_1 $thickness=5.6e-08
+ $X=0.189 $Y=0.116 $X2=0.189 $Y2=0.135
r24 8 9 16.4967 $w=2.1e-08 $l=4.85e-08 $layer=Gate_1 $thickness=5.6e-08
+ $X=0.189 $Y=0.0675 $X2=0.189 $Y2=0.116
r25 8 4 14.6259 $w=2.1e-08 $l=4.3e-08 $layer=Gate_1 $thickness=5.6e-08 $X=0.189
+ $Y=0.0675 $X2=0.189 $Y2=0.0245
.ends

.subckt PM_OAI22x1_ASAP7_75t_R%B2 vss 23 13 19 40 43 7 2 12 1 11 6 5 10 8 9
c1 1 vss 0.00504556f $X=0.081 $Y=0.135
c2 2 vss 0.00425499f $X=0.243 $Y=0.135
c3 5 vss 0.107234f $X=0.081 $Y=0.0245
c4 6 vss 0.101098f $X=0.243 $Y=0.135
c5 7 vss 0.00738428f $X=0.081 $Y=0.072
c6 8 vss 0.00106254f $X=0.081 $Y=0.198
c7 9 vss 0.000566759f $X=0.243 $Y=0.198
c8 10 vss 0.00755661f $X=0.081 $Y=0.0992
c9 11 vss 0.00536464f $X=0.0995 $Y=0.198
c10 12 vss 0.00320232f $X=0.243 $Y=0.18
r1 43 42 16.4967 $w=2.1e-08 $l=4.85e-08 $layer=Gate_1 $thickness=5.6e-08
+ $X=0.243 $Y=0.2025 $X2=0.243 $Y2=0.154
r2 40 41 16.4967 $w=2.1e-08 $l=4.85e-08 $layer=Gate_1 $thickness=5.6e-08
+ $X=0.243 $Y=0.0675 $X2=0.243 $Y2=0.116
r3 6 41 6.6497 $w=2.04211e-08 $l=1.9e-08 $layer=Gate_1 $thickness=5.6e-08
+ $X=0.243 $Y=0.135 $X2=0.243 $Y2=0.116
r4 6 42 6.6497 $w=2.04211e-08 $l=1.9e-08 $layer=Gate_1 $thickness=5.6e-08
+ $X=0.243 $Y=0.135 $X2=0.243 $Y2=0.154
r5 2 35 19.3796 $a=3.24e-16 $layer=V0LIG $X=0.243 $Y=0.135 $X2=0.243 $Y2=0.135
r6 2 6 10.4265 $w=1.765e-08 $layer=LIG $thickness=5.2e-08 $X=0.243 $Y=0.135
+ $X2=0.243 $Y2=0.135
r7 35 36 3.14806 $w=1.3e-08 $l=1.35e-08 $layer=M1 $thickness=3.6e-08 $X=0.243
+ $Y=0.135 $X2=0.243 $Y2=0.1485
r8 33 36 3.14806 $w=1.3e-08 $l=1.35e-08 $layer=M1 $thickness=3.6e-08 $X=0.243
+ $Y=0.162 $X2=0.243 $Y2=0.1485
r9 12 33 4.19742 $w=1.3e-08 $l=1.8e-08 $layer=M1 $thickness=3.6e-08 $X=0.243
+ $Y=0.18 $X2=0.243 $Y2=0.162
r10 9 32 4.64701 $w=1.46667e-08 $l=2.7e-08 $layer=M1 $thickness=3.6e-08
+ $X=0.243 $Y=0.198 $X2=0.216 $Y2=0.198
r11 9 12 2.5483 $w=1.79e-08 $l=1.8e-08 $layer=M1 $thickness=3.6e-08 $X=0.243
+ $Y=0.198 $X2=0.243 $Y2=0.18
r12 31 32 8.51143 $w=1.3e-08 $l=3.65e-08 $layer=M1 $thickness=3.6e-08 $X=0.1795
+ $Y=0.198 $X2=0.216 $Y2=0.198
r13 30 31 10.3769 $w=1.3e-08 $l=4.45e-08 $layer=M1 $thickness=3.6e-08 $X=0.135
+ $Y=0.198 $X2=0.1795 $Y2=0.198
r14 11 30 8.27824 $w=1.3e-08 $l=3.55e-08 $layer=M1 $thickness=3.6e-08 $X=0.0995
+ $Y=0.198 $X2=0.135 $Y2=0.198
r15 8 28 2.5483 $w=1.79e-08 $l=1.8e-08 $layer=M1 $thickness=3.6e-08 $X=0.081
+ $Y=0.198 $X2=0.081 $Y2=0.18
r16 8 11 2.6649 $w=1.54324e-08 $l=1.85e-08 $layer=M1 $thickness=3.6e-08
+ $X=0.081 $Y=0.198 $X2=0.0995 $Y2=0.198
r17 7 10 5.17411 $w=1.46514e-08 $l=2.72e-08 $layer=M1 $thickness=3.6e-08
+ $X=0.081 $Y=0.072 $X2=0.081 $Y2=0.0992
r18 27 28 4.19742 $w=1.3e-08 $l=1.8e-08 $layer=M1 $thickness=3.6e-08 $X=0.081
+ $Y=0.162 $X2=0.081 $Y2=0.18
r19 26 27 3.14806 $w=1.3e-08 $l=1.35e-08 $layer=M1 $thickness=3.6e-08 $X=0.081
+ $Y=0.1485 $X2=0.081 $Y2=0.162
r20 25 26 3.14806 $w=1.3e-08 $l=1.35e-08 $layer=M1 $thickness=3.6e-08 $X=0.081
+ $Y=0.135 $X2=0.081 $Y2=0.1485
r21 24 25 2.97317 $w=1.3e-08 $l=1.28e-08 $layer=M1 $thickness=3.6e-08 $X=0.081
+ $Y=0.1222 $X2=0.081 $Y2=0.135
r22 23 24 0.991057 $w=1.3e-08 $l=4.2e-09 $layer=M1 $thickness=3.6e-08 $X=0.081
+ $Y=0.118 $X2=0.081 $Y2=0.1222
r23 23 10 4.37231 $w=1.3e-08 $l=1.88e-08 $layer=M1 $thickness=3.6e-08 $X=0.081
+ $Y=0.118 $X2=0.081 $Y2=0.0992
r24 1 16 6.54019 $w=2.09524e-08 $layer=Gate_1 $thickness=5.21905e-08 $X=0.081
+ $Y=0.135 $X2=0.081 $Y2=0.135
r25 1 25 19.3796 $a=3.24e-16 $layer=V0LIG $X=0.081 $Y=0.135 $X2=0.081 $Y2=0.135
r26 19 18 14.6259 $w=2.1e-08 $l=4.3e-08 $layer=Gate_1 $thickness=5.6e-08
+ $X=0.081 $Y=0.2025 $X2=0.081 $Y2=0.1595
r27 17 18 2.7211 $w=2.1e-08 $l=8e-09 $layer=Gate_1 $thickness=5.6e-08 $X=0.081
+ $Y=0.1515 $X2=0.081 $Y2=0.1595
r28 16 17 5.79936 $w=2.03333e-08 $l=1.65e-08 $layer=Gate_1 $thickness=5.6e-08
+ $X=0.081 $Y=0.135 $X2=0.081 $Y2=0.1515
r29 15 16 5.79936 $w=2.03333e-08 $l=1.65e-08 $layer=Gate_1 $thickness=5.6e-08
+ $X=0.081 $Y=0.1185 $X2=0.081 $Y2=0.135
r30 14 15 2.7211 $w=2.1e-08 $l=8e-09 $layer=Gate_1 $thickness=5.6e-08 $X=0.081
+ $Y=0.1105 $X2=0.081 $Y2=0.1185
r31 13 14 14.6259 $w=2.1e-08 $l=4.3e-08 $layer=Gate_1 $thickness=5.6e-08
+ $X=0.081 $Y=0.0675 $X2=0.081 $Y2=0.1105
r32 13 5 14.6259 $w=2.1e-08 $l=4.3e-08 $layer=Gate_1 $thickness=5.6e-08
+ $X=0.081 $Y=0.0675 $X2=0.081 $Y2=0.0245
.ends

.subckt PM_OAI22x1_ASAP7_75t_R%Y vss 45 28 29 41 42 60 63 64 66 2 19 18 1 23 17
+ 16 4 3 5 25 24 20
c1 1 vss 0.0072702f $X=0.054 $Y=0.2025
c2 2 vss 0.00534081f $X=0.27 $Y=0.2025
c3 3 vss 0.00964931f $X=0.324 $Y=0.0675
c4 4 vss 0.00919826f $X=0.432 $Y=0.0675
c5 5 vss 0.0064653f $X=0.486 $Y=0.2025
c6 16 vss 0.00455877f $X=0.3095 $Y=0.0675
c7 17 vss 0.00454063f $X=0.4175 $Y=0.0675
c8 18 vss 0.0365219f $X=0.056 $Y=0.2025
c9 19 vss 0.00251755f $X=0.2555 $Y=0.2025
c10 20 vss 0.0371668f $X=0.4715 $Y=0.2025
c11 21 vss 0.00233424f $X=0.513 $Y=0.072
c12 22 vss 0.0026228f $X=0.513 $Y=0.234
c13 23 vss 0.0385333f $X=0.4725 $Y=0.234
c14 24 vss 0.0162836f $X=0.312 $Y=0.072
c15 25 vss 0.00459532f $X=0.513 $Y=0.09
r1 66 65 0.0308642 $w=8.1e-08 $l=2.5e-09 $layer=P_src_drn $thickness=1e-09
+ $X=0.0713 $Y=0.2025 $X2=0.0685 $Y2=0.2025
r2 18 65 0.154321 $w=8.1e-08 $l=1.25e-08 $layer=P_src_drn $thickness=1e-09
+ $X=0.056 $Y=0.2025 $X2=0.0685 $Y2=0.2025
r3 64 62 0.0308642 $w=8.1e-08 $l=2.5e-09 $layer=P_src_drn $thickness=1e-09
+ $X=0.2873 $Y=0.2025 $X2=0.2845 $Y2=0.2025
r4 2 62 0.179012 $w=8.1e-08 $l=1.45e-08 $layer=P_src_drn $thickness=1e-09
+ $X=0.27 $Y=0.2025 $X2=0.2845 $Y2=0.2025
r5 19 2 0.179012 $w=8.1e-08 $l=1.45e-08 $layer=P_src_drn $thickness=1e-09
+ $X=0.2555 $Y=0.2025 $X2=0.27 $Y2=0.2025
r6 63 19 0.0308642 $w=8.1e-08 $l=2.5e-09 $layer=P_src_drn $thickness=1e-09
+ $X=0.2526 $Y=0.2025 $X2=0.2555 $Y2=0.2025
r7 20 5 0.154321 $w=8.1e-08 $l=1.25e-08 $layer=P_src_drn $thickness=1e-09
+ $X=0.4715 $Y=0.2025 $X2=0.486 $Y2=0.2025
r8 60 20 0.0308642 $w=8.1e-08 $l=2.5e-09 $layer=P_src_drn $thickness=1e-09
+ $X=0.4686 $Y=0.2025 $X2=0.4715 $Y2=0.2025
r9 1 56 19.3796 $a=3.24e-16 $layer=V0LISD $X=0.054 $Y=0.2025 $X2=0.054 $Y2=0.234
r10 2 52 19.3796 $a=3.24e-16 $layer=V0LISD $X=0.27 $Y=0.2025 $X2=0.27 $Y2=0.234
r11 5 48 19.3796 $a=3.24e-16 $layer=V0LISD $X=0.486 $Y=0.2025 $X2=0.486
+ $Y2=0.234
r12 56 57 3.14806 $w=1.3e-08 $l=1.35e-08 $layer=M1 $thickness=3.6e-08 $X=0.054
+ $Y=0.234 $X2=0.0675 $Y2=0.234
r13 54 57 22.0364 $w=1.3e-08 $l=9.45e-08 $layer=M1 $thickness=3.6e-08 $X=0.162
+ $Y=0.234 $X2=0.0675 $Y2=0.234
r14 52 53 3.14806 $w=1.3e-08 $l=1.35e-08 $layer=M1 $thickness=3.6e-08 $X=0.27
+ $Y=0.234 $X2=0.2835 $Y2=0.234
r15 51 52 3.14806 $w=1.3e-08 $l=1.35e-08 $layer=M1 $thickness=3.6e-08 $X=0.2565
+ $Y=0.234 $X2=0.27 $Y2=0.234
r16 51 54 22.0364 $w=1.3e-08 $l=9.45e-08 $layer=M1 $thickness=3.6e-08 $X=0.2565
+ $Y=0.234 $X2=0.162 $Y2=0.234
r17 50 53 22.0364 $w=1.3e-08 $l=9.45e-08 $layer=M1 $thickness=3.6e-08 $X=0.378
+ $Y=0.234 $X2=0.2835 $Y2=0.234
r18 48 49 3.14806 $w=1.3e-08 $l=1.35e-08 $layer=M1 $thickness=3.6e-08 $X=0.486
+ $Y=0.234 $X2=0.4995 $Y2=0.234
r19 23 48 3.14806 $w=1.3e-08 $l=1.35e-08 $layer=M1 $thickness=3.6e-08 $X=0.4725
+ $Y=0.234 $X2=0.486 $Y2=0.234
r20 23 50 22.0364 $w=1.3e-08 $l=9.45e-08 $layer=M1 $thickness=3.6e-08 $X=0.4725
+ $Y=0.234 $X2=0.378 $Y2=0.234
r21 22 47 2.5483 $w=1.79e-08 $l=1.8e-08 $layer=M1 $thickness=3.6e-08 $X=0.513
+ $Y=0.234 $X2=0.513 $Y2=0.216
r22 22 49 1.49895 $w=1.63333e-08 $l=1.35e-08 $layer=M1 $thickness=3.6e-08
+ $X=0.513 $Y=0.234 $X2=0.4995 $Y2=0.234
r23 46 47 7.98675 $w=1.3e-08 $l=3.43e-08 $layer=M1 $thickness=3.6e-08 $X=0.513
+ $Y=0.1817 $X2=0.513 $Y2=0.216
r24 45 46 6.00464 $w=1.3e-08 $l=2.57e-08 $layer=M1 $thickness=3.6e-08 $X=0.513
+ $Y=0.156 $X2=0.513 $Y2=0.1817
r25 45 44 4.6055 $w=1.3e-08 $l=1.98e-08 $layer=M1 $thickness=3.6e-08 $X=0.513
+ $Y=0.156 $X2=0.513 $Y2=0.1362
r26 43 44 6.58761 $w=1.3e-08 $l=2.82e-08 $layer=M1 $thickness=3.6e-08 $X=0.513
+ $Y=0.108 $X2=0.513 $Y2=0.1362
r27 25 43 4.19742 $w=1.3e-08 $l=1.8e-08 $layer=M1 $thickness=3.6e-08 $X=0.513
+ $Y=0.09 $X2=0.513 $Y2=0.108
r28 42 40 0.0308642 $w=8.1e-08 $l=2.5e-09 $layer=N_src_drn $thickness=1e-09
+ $X=0.4493 $Y=0.0675 $X2=0.4465 $Y2=0.0675
r29 4 40 0.179012 $w=8.1e-08 $l=1.45e-08 $layer=N_src_drn $thickness=1e-09
+ $X=0.432 $Y=0.0675 $X2=0.4465 $Y2=0.0675
r30 17 4 0.179012 $w=8.1e-08 $l=1.45e-08 $layer=N_src_drn $thickness=1e-09
+ $X=0.4175 $Y=0.0675 $X2=0.432 $Y2=0.0675
r31 41 17 0.0308642 $w=8.1e-08 $l=2.5e-09 $layer=N_src_drn $thickness=1e-09
+ $X=0.4146 $Y=0.0675 $X2=0.4175 $Y2=0.0675
r32 21 38 0.915974 $w=1.70909e-08 $l=1.1e-08 $layer=M1 $thickness=3.6e-08
+ $X=0.513 $Y=0.072 $X2=0.502 $Y2=0.072
r33 21 25 2.5483 $w=1.79e-08 $l=1.8e-08 $layer=M1 $thickness=3.6e-08 $X=0.513
+ $Y=0.072 $X2=0.513 $Y2=0.09
r34 4 35 19.3796 $a=3.24e-16 $layer=V0LISD $X=0.432 $Y=0.0675 $X2=0.436
+ $Y2=0.072
r35 37 38 4.19742 $w=1.3e-08 $l=1.8e-08 $layer=M1 $thickness=3.6e-08 $X=0.484
+ $Y=0.072 $X2=0.502 $Y2=0.072
r36 36 37 6.8791 $w=1.3e-08 $l=2.95e-08 $layer=M1 $thickness=3.6e-08 $X=0.4545
+ $Y=0.072 $X2=0.484 $Y2=0.072
r37 35 36 4.31401 $w=1.3e-08 $l=1.85e-08 $layer=M1 $thickness=3.6e-08 $X=0.436
+ $Y=0.072 $X2=0.4545 $Y2=0.072
r38 34 35 2.09871 $w=1.3e-08 $l=9e-09 $layer=M1 $thickness=3.6e-08 $X=0.427
+ $Y=0.072 $X2=0.436 $Y2=0.072
r39 33 34 6.06293 $w=1.3e-08 $l=2.6e-08 $layer=M1 $thickness=3.6e-08 $X=0.401
+ $Y=0.072 $X2=0.427 $Y2=0.072
r40 32 33 9.44418 $w=1.3e-08 $l=4.05e-08 $layer=M1 $thickness=3.6e-08 $X=0.3605
+ $Y=0.072 $X2=0.401 $Y2=0.072
r41 31 32 5.36336 $w=1.3e-08 $l=2.3e-08 $layer=M1 $thickness=3.6e-08 $X=0.3375
+ $Y=0.072 $X2=0.3605 $Y2=0.072
r42 30 31 3.14806 $w=1.3e-08 $l=1.35e-08 $layer=M1 $thickness=3.6e-08 $X=0.324
+ $Y=0.072 $X2=0.3375 $Y2=0.072
r43 24 30 2.79828 $w=1.3e-08 $l=1.2e-08 $layer=M1 $thickness=3.6e-08 $X=0.312
+ $Y=0.072 $X2=0.324 $Y2=0.072
r44 3 30 19.3796 $a=3.24e-16 $layer=V0LISD $X=0.324 $Y=0.0675 $X2=0.324
+ $Y2=0.072
r45 29 27 0.0308642 $w=8.1e-08 $l=2.5e-09 $layer=N_src_drn $thickness=1e-09
+ $X=0.3413 $Y=0.0675 $X2=0.3385 $Y2=0.0675
r46 3 27 0.179012 $w=8.1e-08 $l=1.45e-08 $layer=N_src_drn $thickness=1e-09
+ $X=0.324 $Y=0.0675 $X2=0.3385 $Y2=0.0675
r47 16 3 0.179012 $w=8.1e-08 $l=1.45e-08 $layer=N_src_drn $thickness=1e-09
+ $X=0.3095 $Y=0.0675 $X2=0.324 $Y2=0.0675
r48 28 16 0.0308642 $w=8.1e-08 $l=2.5e-09 $layer=N_src_drn $thickness=1e-09
+ $X=0.3066 $Y=0.0675 $X2=0.3095 $Y2=0.0675
r49 1 18 1e-05 $l=2e-09 $X=0.054 $Y=0.2025 $X2=0.056 $Y2=0.2025
.ends

.subckt PM_OAI22x1_ASAP7_75t_R%A1 vss 28 8 12 22 25 4 6 1 3 5
c1 1 vss 0.013678f $X=0.3415 $Y=0.135
c2 3 vss 0.102108f $X=0.351 $Y=0.0245
c3 4 vss 0.101181f $X=0.405 $Y=0.135
c4 5 vss 0.00306836f $X=0.351 $Y=0.108
c5 6 vss 0.00284861f $X=0.3502 $Y=0.162
c6 7 vss 0.00212551f $X=0.351 $Y=0.1175
r1 28 29 0.0765333 $w=1.8e-08 $l=7e-10 $layer=M1 $thickness=3.6e-08 $X=0.359
+ $Y=0.162 $X2=0.3597 $Y2=0.162
r2 28 6 0.892889 $w=1.8e-08 $l=8.8e-09 $layer=M1 $thickness=3.6e-08 $X=0.359
+ $Y=0.162 $X2=0.3502 $Y2=0.162
r3 6 20 4.92269 $w=1.46019e-08 $l=2.65121e-08 $layer=M1 $thickness=3.6e-08
+ $X=0.3502 $Y=0.162 $X2=0.351 $Y2=0.1355
r4 5 7 1.03499 $w=1.77368e-08 $l=9.5e-09 $layer=M1 $thickness=3.6e-08 $X=0.351
+ $Y=0.108 $X2=0.351 $Y2=0.1175
r5 25 24 16.4967 $w=2.1e-08 $l=4.85e-08 $layer=Gate_1 $thickness=5.6e-08
+ $X=0.405 $Y=0.2025 $X2=0.405 $Y2=0.154
r6 22 23 16.4967 $w=2.1e-08 $l=4.85e-08 $layer=Gate_1 $thickness=5.6e-08
+ $X=0.405 $Y=0.0675 $X2=0.405 $Y2=0.116
r7 4 18 6.54019 $w=2.09524e-08 $layer=Gate_1 $thickness=5.21905e-08 $X=0.405
+ $Y=0.135 $X2=0.405 $Y2=0.135
r8 4 23 6.6497 $w=2.04211e-08 $l=1.9e-08 $layer=Gate_1 $thickness=5.6e-08
+ $X=0.405 $Y=0.135 $X2=0.405 $Y2=0.116
r9 4 24 6.6497 $w=2.04211e-08 $l=1.9e-08 $layer=Gate_1 $thickness=5.6e-08
+ $X=0.405 $Y=0.135 $X2=0.405 $Y2=0.154
r10 20 29 4.10633 $w=1.30704e-08 $l=2.78916e-08 $layer=M1 $thickness=3.6e-08
+ $X=0.351 $Y=0.1355 $X2=0.3597 $Y2=0.162
r11 7 20 4.19742 $w=1.3e-08 $l=1.8e-08 $layer=M1 $thickness=3.6e-08 $X=0.351
+ $Y=0.1175 $X2=0.351 $Y2=0.1355
r12 17 18 12.6539 $w=1.77815e-08 $l=2.7e-08 $layer=LIG $thickness=4.8e-08
+ $X=0.378 $Y=0.135 $X2=0.405 $Y2=0.135
r13 15 17 10.1729 $w=1.54914e-08 $l=1.75e-08 $layer=LIG $thickness=4.8e-08
+ $X=0.3605 $Y=0.135 $X2=0.378 $Y2=0.135
r14 14 15 2.48102 $w=2.2e-08 $l=9.5e-09 $layer=LIG $thickness=4.8e-08 $X=0.351
+ $Y=0.135 $X2=0.3605 $Y2=0.135
r15 14 20 19.3796 $a=3.24e-16 $layer=V0LIG $X=0.351 $Y=0.135 $X2=0.351
+ $Y2=0.1355
r16 1 14 2.48102 $w=2.2e-08 $l=9.5e-09 $layer=LIG $thickness=4.8e-08 $X=0.3415
+ $Y=0.135 $X2=0.351 $Y2=0.135
r17 12 11 16.4967 $w=2.1e-08 $l=4.85e-08 $layer=Gate_1 $thickness=5.6e-08
+ $X=0.351 $Y=0.2025 $X2=0.351 $Y2=0.154
r18 10 11 6.6497 $w=2.04211e-08 $l=1.9e-08 $layer=Gate_1 $thickness=5.6e-08
+ $X=0.351 $Y=0.135 $X2=0.351 $Y2=0.154
r19 10 15 4.05918 $w=2.0087e-08 $l=9.5e-09 $layer=Gate_1 $thickness=5.56522e-08
+ $X=0.351 $Y=0.135 $X2=0.3605 $Y2=0.135
r20 10 14 6.27904 $w=2.09e-08 $layer=Gate_1 $thickness=5.24e-08 $X=0.351
+ $Y=0.135 $X2=0.351 $Y2=0.135
r21 9 10 6.6497 $w=2.04211e-08 $l=1.9e-08 $layer=Gate_1 $thickness=5.6e-08
+ $X=0.351 $Y=0.116 $X2=0.351 $Y2=0.135
r22 8 9 16.4967 $w=2.1e-08 $l=4.85e-08 $layer=Gate_1 $thickness=5.6e-08
+ $X=0.351 $Y=0.0675 $X2=0.351 $Y2=0.116
r23 8 3 14.6259 $w=2.1e-08 $l=4.3e-08 $layer=Gate_1 $thickness=5.6e-08 $X=0.351
+ $Y=0.0675 $X2=0.351 $Y2=0.0245
.ends

.subckt PM_OAI22x1_ASAP7_75t_R%A2 vss 25 13 17 37 40 1 10 5 11 6 2 9 12 8 7
c1 1 vss 0.00575954f $X=0.297 $Y=0.135
c2 2 vss 0.006334f $X=0.459 $Y=0.135
c3 5 vss 0.0642856f $X=0.297 $Y=0.0245
c4 6 vss 0.0672977f $X=0.459 $Y=0.135
c5 7 vss 0.00225446f $X=0.297 $Y=0.1922
c6 8 vss 0.00282454f $X=0.459 $Y=0.108
c7 9 vss 0.00225081f $X=0.459 $Y=0.198
c8 10 vss 0.00339492f $X=0.297 $Y=0.122
c9 11 vss 0.00518678f $X=0.3075 $Y=0.198
c10 12 vss 0.00251796f $X=0.459 $Y=0.18
r1 40 39 16.4967 $w=2.1e-08 $l=4.85e-08 $layer=Gate_1 $thickness=5.6e-08
+ $X=0.459 $Y=0.2025 $X2=0.459 $Y2=0.154
r2 37 38 16.4967 $w=2.1e-08 $l=4.85e-08 $layer=Gate_1 $thickness=5.6e-08
+ $X=0.459 $Y=0.0675 $X2=0.459 $Y2=0.116
r3 6 38 6.6497 $w=2.04211e-08 $l=1.9e-08 $layer=Gate_1 $thickness=5.6e-08
+ $X=0.459 $Y=0.135 $X2=0.459 $Y2=0.116
r4 6 39 6.6497 $w=2.04211e-08 $l=1.9e-08 $layer=Gate_1 $thickness=5.6e-08
+ $X=0.459 $Y=0.135 $X2=0.459 $Y2=0.154
r5 2 33 19.3796 $a=3.24e-16 $layer=V0LIG $X=0.459 $Y=0.135 $X2=0.459 $Y2=0.135
r6 2 6 10.4265 $w=1.765e-08 $layer=LIG $thickness=5.2e-08 $X=0.459 $Y=0.135
+ $X2=0.459 $Y2=0.135
r7 8 32 1.96775 $w=1.63333e-08 $l=1.35e-08 $layer=M1 $thickness=3.6e-08
+ $X=0.459 $Y=0.108 $X2=0.459 $Y2=0.1215
r8 33 34 3.14806 $w=1.3e-08 $l=1.35e-08 $layer=M1 $thickness=3.6e-08 $X=0.459
+ $Y=0.135 $X2=0.459 $Y2=0.1485
r9 32 33 3.14806 $w=1.3e-08 $l=1.35e-08 $layer=M1 $thickness=3.6e-08 $X=0.459
+ $Y=0.1215 $X2=0.459 $Y2=0.135
r10 31 34 3.14806 $w=1.3e-08 $l=1.35e-08 $layer=M1 $thickness=3.6e-08 $X=0.459
+ $Y=0.162 $X2=0.459 $Y2=0.1485
r11 12 31 4.19742 $w=1.3e-08 $l=1.8e-08 $layer=M1 $thickness=3.6e-08 $X=0.459
+ $Y=0.18 $X2=0.459 $Y2=0.162
r12 9 30 2.6649 $w=1.54324e-08 $l=1.85e-08 $layer=M1 $thickness=3.6e-08
+ $X=0.459 $Y=0.198 $X2=0.4405 $Y2=0.198
r13 9 12 2.5483 $w=1.79e-08 $l=1.8e-08 $layer=M1 $thickness=3.6e-08 $X=0.459
+ $Y=0.198 $X2=0.459 $Y2=0.18
r14 29 30 8.27824 $w=1.3e-08 $l=3.55e-08 $layer=M1 $thickness=3.6e-08 $X=0.405
+ $Y=0.198 $X2=0.4405 $Y2=0.198
r15 28 29 10.3769 $w=1.3e-08 $l=4.45e-08 $layer=M1 $thickness=3.6e-08 $X=0.3605
+ $Y=0.198 $X2=0.405 $Y2=0.198
r16 27 28 8.16164 $w=1.3e-08 $l=3.5e-08 $layer=M1 $thickness=3.6e-08 $X=0.3255
+ $Y=0.198 $X2=0.3605 $Y2=0.198
r17 25 11 0.400807 $w=2.71429e-09 $l=1.06888e-08 $layer=M1 $thickness=3.6e-08
+ $X=0.296 $Y=0.196 $X2=0.3075 $Y2=0.198
r18 11 27 4.19742 $w=1.3e-08 $l=1.8e-08 $layer=M1 $thickness=3.6e-08 $X=0.3075
+ $Y=0.198 $X2=0.3255 $Y2=0.198
r19 25 7 0.382667 $w=1.8e-08 $l=3.8e-09 $layer=M1 $thickness=3.6e-08 $X=0.296
+ $Y=0.196 $X2=0.297 $Y2=0.1922
r20 7 24 2.43035 $w=1.43265e-08 $l=1.22e-08 $layer=M1 $thickness=3.6e-08
+ $X=0.297 $Y=0.1922 $X2=0.297 $Y2=0.18
r21 23 24 4.19742 $w=1.3e-08 $l=1.8e-08 $layer=M1 $thickness=3.6e-08 $X=0.297
+ $Y=0.162 $X2=0.297 $Y2=0.18
r22 22 23 3.14806 $w=1.3e-08 $l=1.35e-08 $layer=M1 $thickness=3.6e-08 $X=0.297
+ $Y=0.1485 $X2=0.297 $Y2=0.162
r23 21 22 3.14806 $w=1.3e-08 $l=1.35e-08 $layer=M1 $thickness=3.6e-08 $X=0.297
+ $Y=0.135 $X2=0.297 $Y2=0.1485
r24 10 21 3.03147 $w=1.3e-08 $l=1.3e-08 $layer=M1 $thickness=3.6e-08 $X=0.297
+ $Y=0.122 $X2=0.297 $Y2=0.135
r25 1 15 6.54019 $w=2.09524e-08 $layer=Gate_1 $thickness=5.21905e-08 $X=0.297
+ $Y=0.135 $X2=0.297 $Y2=0.135
r26 1 21 19.3796 $a=3.24e-16 $layer=V0LIG $X=0.297 $Y=0.135 $X2=0.297 $Y2=0.135
r27 17 16 16.4967 $w=2.1e-08 $l=4.85e-08 $layer=Gate_1 $thickness=5.6e-08
+ $X=0.297 $Y=0.2025 $X2=0.297 $Y2=0.154
r28 15 16 6.6497 $w=2.04211e-08 $l=1.9e-08 $layer=Gate_1 $thickness=5.6e-08
+ $X=0.297 $Y=0.135 $X2=0.297 $Y2=0.154
r29 14 15 6.6497 $w=2.04211e-08 $l=1.9e-08 $layer=Gate_1 $thickness=5.6e-08
+ $X=0.297 $Y=0.116 $X2=0.297 $Y2=0.135
r30 13 14 16.4967 $w=2.1e-08 $l=4.85e-08 $layer=Gate_1 $thickness=5.6e-08
+ $X=0.297 $Y=0.0675 $X2=0.297 $Y2=0.116
r31 13 5 14.6259 $w=2.1e-08 $l=4.3e-08 $layer=Gate_1 $thickness=5.6e-08
+ $X=0.297 $Y=0.0675 $X2=0.297 $Y2=0.0245
.ends

* End of included file OAI22x1_ASAP7_75t_R.pex.sp.pex

*
.subckt OAI22x1_ASAP7_75t_CUSTOM_4_25_0_7 VSS VDD B2 B1 A2 A1 Y
*
* VSS VSS
* VDD VDD
* B2 B2
* B1 B1
* A2 A2
* A1 A1
* Y Y
*
*

M0 VSS N_M0_g noxref_7 VSS nmos_rvt L=2e-08 W=8.1e-08 nfin=3 $X=0.071 $Y=0.027
M1 noxref_7 N_M1_g VSS VSS nmos_rvt L=2e-08 W=8.1e-08 nfin=3 $X=0.125 $Y=0.027
M2 noxref_7 N_M2_g VSS VSS nmos_rvt L=2e-08 W=8.1e-08 nfin=3 $X=0.179 $Y=0.027
M3 VSS N_M3_g noxref_7 VSS nmos_rvt L=2e-08 W=8.1e-08 nfin=3 $X=0.233 $Y=0.027
M4 N_M4_d N_M4_g noxref_7 VSS nmos_rvt L=2e-08 W=8.1e-08 nfin=3 $X=0.287
+ $Y=0.027
M5 noxref_7 N_M5_g N_M5_s VSS nmos_rvt L=2e-08 W=8.1e-08 nfin=3 $X=0.341
+ $Y=0.027
M6 noxref_7 N_M6_g N_M6_s VSS nmos_rvt L=2e-08 W=8.1e-08 nfin=3 $X=0.395
+ $Y=0.027
M7 N_M7_d N_M7_g noxref_7 VSS nmos_rvt L=2e-08 W=8.1e-08 nfin=3 $X=0.449
+ $Y=0.027
M8 N_M8_d N_M8_g noxref_9 VDD pmos_rvt L=2e-08 W=8.1e-08 nfin=3 $X=0.071
+ $Y=0.162
M9 noxref_9 N_M9_g VDD VDD pmos_rvt L=2e-08 W=8.1e-08 nfin=3 $X=0.125 $Y=0.162
M10 noxref_10 N_M10_g VDD VDD pmos_rvt L=2e-08 W=8.1e-08 nfin=3 $X=0.179
+ $Y=0.162
M11 N_M11_d N_M11_g noxref_10 VDD pmos_rvt L=2e-08 W=8.1e-08 nfin=3 $X=0.233
+ $Y=0.162
M12 N_M12_d N_M12_g noxref_11 VDD pmos_rvt L=2e-08 W=8.1e-08 nfin=3 $X=0.287
+ $Y=0.162
M13 noxref_11 N_M13_g VDD VDD pmos_rvt L=2e-08 W=8.1e-08 nfin=3 $X=0.341
+ $Y=0.162
M14 noxref_12 N_M14_g VDD VDD pmos_rvt L=2e-08 W=8.1e-08 nfin=3 $X=0.395
+ $Y=0.162
M15 N_M15_d N_M15_g noxref_12 VDD pmos_rvt L=2e-08 W=8.1e-08 nfin=3 $X=0.449
+ $Y=0.162

* .include "OAI22x1_ASAP7_75t_R.pex.sp.pxi"

* Start of included file OAI22x1_ASAP7_75t_R.pex.sp.pxi
x_PM_OAI22x1_ASAP7_75t_R%B1 vss B1 N_M2_g N_M10_g N_M1_g N_M9_g N_B1_3 N_B1_1
+ N_B1_6 N_B1_4 PM_OAI22x1_ASAP7_75t_R%B1
cc_1 N_B1_3 N_B2_7 0.000794822f $X=0.135 $Y=0.135
cc_2 N_B1_3 N_B2_2 0.000933297f $X=0.135 $Y=0.135
cc_3 N_B1_3 N_B2_12 0.00265849f $X=0.135 $Y=0.135
cc_4 N_B1_1 N_B2_1 0.00291366f $X=0.1795 $Y=0.135
cc_5 N_B1_6 N_B2_11 0.00510491f $X=0.189 $Y=0.162
cc_6 N_B1_4 N_B2_6 0.00513526f $X=0.189 $Y=0.0245
cc_7 N_B1_3 N_B2_5 0.00694715f $X=0.135 $Y=0.135
x_PM_OAI22x1_ASAP7_75t_R%B2 vss B2 N_M0_g N_M8_g N_M3_g N_M11_g N_B2_7 N_B2_2
+ N_B2_12 N_B2_1 N_B2_11 N_B2_6 N_B2_5 N_B2_10 N_B2_8 N_B2_9
+ PM_OAI22x1_ASAP7_75t_R%B2
x_PM_OAI22x1_ASAP7_75t_R%Y vss Y N_M4_d N_M5_s N_M6_s N_M7_d N_M15_d N_M11_d
+ N_M12_d N_M8_d N_Y_2 N_Y_19 N_Y_18 N_Y_1 N_Y_23 N_Y_17 N_Y_16 N_Y_4 N_Y_3
+ N_Y_5 N_Y_25 N_Y_24 N_Y_20 PM_OAI22x1_ASAP7_75t_R%Y
cc_8 N_Y_2 N_B2_12 0.000758986f $X=0.27 $Y=0.2025
cc_9 N_Y_19 N_B2_2 0.000759737f $X=0.2555 $Y=0.2025
cc_10 N_Y_18 N_B2_1 0.000870278f $X=0.056 $Y=0.2025
cc_11 N_Y_1 N_B2_10 0.000888386f $X=0.054 $Y=0.2025
cc_12 N_Y_23 N_B2_8 0.00138448f $X=0.4725 $Y=0.234
cc_13 N_Y_2 N_B2_6 0.00153367f $X=0.27 $Y=0.2025
cc_14 N_Y_1 N_B2_5 0.001852f $X=0.054 $Y=0.2025
cc_15 N_Y_23 N_B2_11 0.00502458f $X=0.4725 $Y=0.234
cc_16 N_Y_23 N_B2_9 0.00807627f $X=0.4725 $Y=0.234
cc_17 N_Y_18 N_B2_5 0.0339442f $X=0.056 $Y=0.2025
cc_18 N_Y_19 N_B2_6 0.0358072f $X=0.2555 $Y=0.2025
cc_19 N_Y_17 N_A2_6 0.0147305f $X=0.4175 $Y=0.0675
cc_20 N_Y_16 N_A2_5 0.0149321f $X=0.3095 $Y=0.0675
cc_21 N_Y_2 N_A2_1 0.000505786f $X=0.27 $Y=0.2025
cc_22 N_Y_4 N_A2_2 0.000749002f $X=0.432 $Y=0.0675
cc_23 N_Y_3 N_A2_5 0.000804127f $X=0.324 $Y=0.0675
cc_24 N_Y_2 N_A2_10 0.000957966f $X=0.27 $Y=0.2025
cc_25 N_Y_4 N_A2_6 0.000987464f $X=0.432 $Y=0.0675
cc_26 N_Y_16 N_A2_1 0.00144949f $X=0.3095 $Y=0.0675
cc_27 N_Y_2 N_A2_5 0.00154157f $X=0.27 $Y=0.2025
cc_28 N_Y_5 N_A2_6 0.00160951f $X=0.486 $Y=0.2025
cc_29 N_Y_23 N_A2_9 0.0016457f $X=0.4725 $Y=0.234
cc_30 N_Y_17 N_A2_2 0.00167884f $X=0.4175 $Y=0.0675
cc_31 N_Y_25 N_A2_12 0.00412434f $X=0.513 $Y=0.09
cc_32 N_Y_24 N_A2_8 0.00509651f $X=0.312 $Y=0.072
cc_33 N_Y_23 N_A2_11 0.00517627f $X=0.4725 $Y=0.234
cc_34 N_Y_23 N_A2_7 0.00780485f $X=0.4725 $Y=0.234
cc_35 N_Y_20 N_A2_6 0.0524932f $X=0.4715 $Y=0.2025
cc_36 N_Y_19 N_A2_5 0.0543049f $X=0.2555 $Y=0.2025
cc_37 N_Y_23 N_A1_3 0.0005777f $X=0.4725 $Y=0.234
cc_38 N_Y_4 N_A1_3 0.000713916f $X=0.432 $Y=0.0675
cc_39 N_Y_3 N_A1_3 0.000814875f $X=0.324 $Y=0.0675
cc_40 N_Y_17 N_A1_1 0.00162562f $X=0.4175 $Y=0.0675
cc_41 N_Y_24 N_A1_5 0.00447817f $X=0.312 $Y=0.072
cc_42 N_Y_17 N_A1_4 0.0331383f $X=0.4175 $Y=0.0675
cc_43 N_Y_16 N_A1_3 0.0358831f $X=0.3095 $Y=0.0675
x_PM_OAI22x1_ASAP7_75t_R%A1 vss A1 N_M5_g N_M13_g N_M6_g N_M14_g N_A1_4 N_A1_6
+ N_A1_1 N_A1_3 N_A1_5 PM_OAI22x1_ASAP7_75t_R%A1
cc_44 N_A1_4 N_A2_10 0.00148726f $X=0.405 $Y=0.135
cc_45 N_A1_4 N_A2_1 0.000873399f $X=0.405 $Y=0.135
cc_46 N_A1_6 N_A2_10 0.00106599f $X=0.3502 $Y=0.162
cc_47 N_A1_1 N_A2_1 0.00296256f $X=0.3415 $Y=0.135
cc_48 N_A1_6 N_A2_11 0.00487253f $X=0.3502 $Y=0.162
cc_49 N_A1_3 N_A2_5 0.00512379f $X=0.351 $Y=0.0245
cc_50 N_A1_4 N_A2_6 0.00692332f $X=0.405 $Y=0.135
x_PM_OAI22x1_ASAP7_75t_R%A2 vss A2 N_M4_g N_M12_g N_M7_g N_M15_g N_A2_1 N_A2_10
+ N_A2_5 N_A2_11 N_A2_6 N_A2_2 N_A2_9 N_A2_12 N_A2_8 N_A2_7
+ PM_OAI22x1_ASAP7_75t_R%A2
cc_51 N_A2_1 N_B2_2 0.00112546f $X=0.297 $Y=0.135
cc_52 N_A2_10 N_B2_12 0.00264606f $X=0.297 $Y=0.122
cc_53 N_A2_5 N_B2_6 0.00503952f $X=0.297 $Y=0.0245

* End of included file OAI22x1_ASAP7_75t_R.pex.sp.pxi
.ends

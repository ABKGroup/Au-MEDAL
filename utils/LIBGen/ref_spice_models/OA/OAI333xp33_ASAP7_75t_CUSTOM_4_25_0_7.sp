.subckt PM_OAI333xp33_ASAP7_75t_R%C3 vss 15 5 11 3
c1 1 vss 0.00747013f $X=0.081 $Y=0.135
c2 3 vss 0.141868f $X=0.081 $Y=0.0245
c3 4 vss 0.0126145f $X=0.081 $Y=0.116
r1 15 14 1.45744 $w=1.3e-08 $l=6.3e-09 $layer=M1 $thickness=3.6e-08 $X=0.073
+ $Y=0.156 $X2=0.081 $Y2=0.1497
r2 13 14 3.43955 $w=1.3e-08 $l=1.47e-08 $layer=M1 $thickness=3.6e-08 $X=0.081
+ $Y=0.135 $X2=0.081 $Y2=0.1497
r3 4 13 4.43061 $w=1.3e-08 $l=1.9e-08 $layer=M1 $thickness=3.6e-08 $X=0.081
+ $Y=0.116 $X2=0.081 $Y2=0.135
r4 1 8 10.4265 $w=1.765e-08 $layer=LIG $thickness=5.2e-08 $X=0.081 $Y=0.135
+ $X2=0.081 $Y2=0.135
r5 1 13 19.3796 $a=3.24e-16 $layer=V0LIG $X=0.081 $Y=0.135 $X2=0.081 $Y2=0.135
r6 11 10 14.6259 $w=2.1e-08 $l=4.3e-08 $layer=Gate_1 $thickness=5.6e-08
+ $X=0.081 $Y=0.2025 $X2=0.081 $Y2=0.1595
r7 9 10 2.7211 $w=2.1e-08 $l=8e-09 $layer=Gate_1 $thickness=5.6e-08 $X=0.081
+ $Y=0.1515 $X2=0.081 $Y2=0.1595
r8 8 9 5.79936 $w=2.03333e-08 $l=1.65e-08 $layer=Gate_1 $thickness=5.6e-08
+ $X=0.081 $Y=0.135 $X2=0.081 $Y2=0.1515
r9 7 8 5.79936 $w=2.03333e-08 $l=1.65e-08 $layer=Gate_1 $thickness=5.6e-08
+ $X=0.081 $Y=0.1185 $X2=0.081 $Y2=0.135
r10 6 7 2.7211 $w=2.1e-08 $l=8e-09 $layer=Gate_1 $thickness=5.6e-08 $X=0.081
+ $Y=0.1105 $X2=0.081 $Y2=0.1185
r11 5 6 14.6259 $w=2.1e-08 $l=4.3e-08 $layer=Gate_1 $thickness=5.6e-08 $X=0.081
+ $Y=0.0675 $X2=0.081 $Y2=0.1105
r12 5 3 14.6259 $w=2.1e-08 $l=4.3e-08 $layer=Gate_1 $thickness=5.6e-08 $X=0.081
+ $Y=0.0675 $X2=0.081 $Y2=0.0245
.ends

.subckt PM_OAI333xp33_ASAP7_75t_R%C2 vss 13 5 9 4 3
c1 1 vss 0.00489545f $X=0.135 $Y=0.135
c2 3 vss 0.121542f $X=0.135 $Y=0.0245
c3 4 vss 0.00940076f $X=0.135 $Y=0.116
r1 13 12 1.22425 $w=1.3e-08 $l=5.3e-09 $layer=M1 $thickness=3.6e-08 $X=0.129
+ $Y=0.154 $X2=0.135 $Y2=0.1487
r2 11 12 3.20636 $w=1.3e-08 $l=1.37e-08 $layer=M1 $thickness=3.6e-08 $X=0.135
+ $Y=0.135 $X2=0.135 $Y2=0.1487
r3 4 11 4.4306 $w=1.3e-08 $l=1.9e-08 $layer=M1 $thickness=3.6e-08 $X=0.135
+ $Y=0.116 $X2=0.135 $Y2=0.135
r4 1 7 10.4265 $w=1.765e-08 $layer=LIG $thickness=5.2e-08 $X=0.135 $Y=0.135
+ $X2=0.135 $Y2=0.135
r5 1 11 19.3796 $a=3.24e-16 $layer=V0LIG $X=0.135 $Y=0.135 $X2=0.135 $Y2=0.135
r6 9 8 16.4967 $w=2.1e-08 $l=4.85e-08 $layer=Gate_1 $thickness=5.6e-08 $X=0.135
+ $Y=0.2025 $X2=0.135 $Y2=0.154
r7 7 8 6.6497 $w=2.04211e-08 $l=1.9e-08 $layer=Gate_1 $thickness=5.6e-08
+ $X=0.135 $Y=0.135 $X2=0.135 $Y2=0.154
r8 6 7 6.6497 $w=2.04211e-08 $l=1.9e-08 $layer=Gate_1 $thickness=5.6e-08
+ $X=0.135 $Y=0.116 $X2=0.135 $Y2=0.135
r9 5 6 16.4967 $w=2.1e-08 $l=4.85e-08 $layer=Gate_1 $thickness=5.6e-08 $X=0.135
+ $Y=0.0675 $X2=0.135 $Y2=0.116
r10 5 3 14.6259 $w=2.1e-08 $l=4.3e-08 $layer=Gate_1 $thickness=5.6e-08 $X=0.135
+ $Y=0.0675 $X2=0.135 $Y2=0.0245
.ends

.subckt PM_OAI333xp33_ASAP7_75t_R%B2 vss 13 5 9 4 3
c1 1 vss 0.00472631f $X=0.297 $Y=0.135
c2 3 vss 0.121255f $X=0.297 $Y=0.0245
c3 4 vss 0.00511388f $X=0.297 $Y=0.116
r1 13 12 1.34084 $w=1.3e-08 $l=5.8e-09 $layer=M1 $thickness=3.6e-08 $X=0.296
+ $Y=0.155 $X2=0.297 $Y2=0.1492
r2 11 12 3.32295 $w=1.3e-08 $l=1.42e-08 $layer=M1 $thickness=3.6e-08 $X=0.297
+ $Y=0.135 $X2=0.297 $Y2=0.1492
r3 4 11 4.4306 $w=1.3e-08 $l=1.9e-08 $layer=M1 $thickness=3.6e-08 $X=0.297
+ $Y=0.116 $X2=0.297 $Y2=0.135
r4 1 7 10.4265 $w=1.765e-08 $layer=LIG $thickness=5.2e-08 $X=0.297 $Y=0.135
+ $X2=0.297 $Y2=0.135
r5 1 11 19.3796 $a=3.24e-16 $layer=V0LIG $X=0.297 $Y=0.135 $X2=0.297 $Y2=0.135
r6 9 8 16.4967 $w=2.1e-08 $l=4.85e-08 $layer=Gate_1 $thickness=5.6e-08 $X=0.297
+ $Y=0.2025 $X2=0.297 $Y2=0.154
r7 7 8 6.6497 $w=2.04211e-08 $l=1.9e-08 $layer=Gate_1 $thickness=5.6e-08
+ $X=0.297 $Y=0.135 $X2=0.297 $Y2=0.154
r8 6 7 6.6497 $w=2.04211e-08 $l=1.9e-08 $layer=Gate_1 $thickness=5.6e-08
+ $X=0.297 $Y=0.116 $X2=0.297 $Y2=0.135
r9 5 6 16.4967 $w=2.1e-08 $l=4.85e-08 $layer=Gate_1 $thickness=5.6e-08 $X=0.297
+ $Y=0.0675 $X2=0.297 $Y2=0.116
r10 5 3 14.6259 $w=2.1e-08 $l=4.3e-08 $layer=Gate_1 $thickness=5.6e-08 $X=0.297
+ $Y=0.0675 $X2=0.297 $Y2=0.0245
.ends

.subckt PM_OAI333xp33_ASAP7_75t_R%B3 vss 13 5 9 4 3
c1 1 vss 0.00708195f $X=0.351 $Y=0.135
c2 3 vss 0.139655f $X=0.351 $Y=0.0245
c3 4 vss 0.00480522f $X=0.351 $Y=0.116
r1 13 12 1.34084 $w=1.3e-08 $l=5.8e-09 $layer=M1 $thickness=3.6e-08 $X=0.346
+ $Y=0.155 $X2=0.351 $Y2=0.1492
r2 11 12 3.32295 $w=1.3e-08 $l=1.42e-08 $layer=M1 $thickness=3.6e-08 $X=0.351
+ $Y=0.135 $X2=0.351 $Y2=0.1492
r3 4 11 4.4306 $w=1.3e-08 $l=1.9e-08 $layer=M1 $thickness=3.6e-08 $X=0.351
+ $Y=0.116 $X2=0.351 $Y2=0.135
r4 1 7 10.4265 $w=1.765e-08 $layer=LIG $thickness=5.2e-08 $X=0.351 $Y=0.135
+ $X2=0.351 $Y2=0.135
r5 1 11 19.3796 $a=3.24e-16 $layer=V0LIG $X=0.351 $Y=0.135 $X2=0.351 $Y2=0.135
r6 9 8 16.4967 $w=2.1e-08 $l=4.85e-08 $layer=Gate_1 $thickness=5.6e-08 $X=0.351
+ $Y=0.2025 $X2=0.351 $Y2=0.154
r7 7 8 6.6497 $w=2.04211e-08 $l=1.9e-08 $layer=Gate_1 $thickness=5.6e-08
+ $X=0.351 $Y=0.135 $X2=0.351 $Y2=0.154
r8 6 7 6.6497 $w=2.04211e-08 $l=1.9e-08 $layer=Gate_1 $thickness=5.6e-08
+ $X=0.351 $Y=0.116 $X2=0.351 $Y2=0.135
r9 5 6 16.4967 $w=2.1e-08 $l=4.85e-08 $layer=Gate_1 $thickness=5.6e-08 $X=0.351
+ $Y=0.0675 $X2=0.351 $Y2=0.116
r10 5 3 14.6259 $w=2.1e-08 $l=4.3e-08 $layer=Gate_1 $thickness=5.6e-08 $X=0.351
+ $Y=0.0675 $X2=0.351 $Y2=0.0245
.ends

.subckt PM_OAI333xp33_ASAP7_75t_R%A3 vss 13 5 9 3 4
c1 1 vss 0.00735765f $X=0.405 $Y=0.135
c2 3 vss 0.102641f $X=0.405 $Y=0.0245
c3 4 vss 0.00438555f $X=0.405 $Y=0.116
r1 13 12 1.34084 $w=1.3e-08 $l=5.8e-09 $layer=M1 $thickness=3.6e-08 $X=0.408
+ $Y=0.155 $X2=0.405 $Y2=0.1492
r2 11 12 3.32295 $w=1.3e-08 $l=1.42e-08 $layer=M1 $thickness=3.6e-08 $X=0.405
+ $Y=0.135 $X2=0.405 $Y2=0.1492
r3 4 11 4.4306 $w=1.3e-08 $l=1.9e-08 $layer=M1 $thickness=3.6e-08 $X=0.405
+ $Y=0.116 $X2=0.405 $Y2=0.135
r4 1 7 10.4265 $w=1.765e-08 $layer=LIG $thickness=5.2e-08 $X=0.405 $Y=0.135
+ $X2=0.405 $Y2=0.135
r5 1 11 19.3796 $a=3.24e-16 $layer=V0LIG $X=0.405 $Y=0.135 $X2=0.405 $Y2=0.135
r6 9 8 16.4967 $w=2.1e-08 $l=4.85e-08 $layer=Gate_1 $thickness=5.6e-08 $X=0.405
+ $Y=0.2025 $X2=0.405 $Y2=0.154
r7 7 8 6.6497 $w=2.04211e-08 $l=1.9e-08 $layer=Gate_1 $thickness=5.6e-08
+ $X=0.405 $Y=0.135 $X2=0.405 $Y2=0.154
r8 6 7 6.6497 $w=2.04211e-08 $l=1.9e-08 $layer=Gate_1 $thickness=5.6e-08
+ $X=0.405 $Y=0.116 $X2=0.405 $Y2=0.135
r9 5 6 16.4967 $w=2.1e-08 $l=4.85e-08 $layer=Gate_1 $thickness=5.6e-08 $X=0.405
+ $Y=0.0675 $X2=0.405 $Y2=0.116
r10 5 3 14.6259 $w=2.1e-08 $l=4.3e-08 $layer=Gate_1 $thickness=5.6e-08 $X=0.405
+ $Y=0.0675 $X2=0.405 $Y2=0.0245
.ends

.subckt PM_OAI333xp33_ASAP7_75t_R%A1 vss 15 5 11 4 3 1
c1 1 vss 0.00253489f $X=0.513 $Y=0.135
c2 3 vss 0.0718801f $X=0.513 $Y=0.0245
c3 4 vss 0.00494259f $X=0.513 $Y=0.116
r1 15 14 1.34084 $w=1.3e-08 $l=5.8e-09 $layer=M1 $thickness=3.6e-08 $X=0.521
+ $Y=0.155 $X2=0.513 $Y2=0.1492
r2 13 14 3.32295 $w=1.3e-08 $l=1.42e-08 $layer=M1 $thickness=3.6e-08 $X=0.513
+ $Y=0.135 $X2=0.513 $Y2=0.1492
r3 4 13 4.4306 $w=1.3e-08 $l=1.9e-08 $layer=M1 $thickness=3.6e-08 $X=0.513
+ $Y=0.116 $X2=0.513 $Y2=0.135
r4 1 8 10.4265 $w=1.765e-08 $layer=LIG $thickness=5.2e-08 $X=0.513 $Y=0.135
+ $X2=0.513 $Y2=0.135
r5 1 13 19.3796 $a=3.24e-16 $layer=V0LIG $X=0.513 $Y=0.135 $X2=0.513 $Y2=0.135
r6 11 10 14.6259 $w=2.1e-08 $l=4.3e-08 $layer=Gate_1 $thickness=5.6e-08
+ $X=0.513 $Y=0.2025 $X2=0.513 $Y2=0.1595
r7 9 10 2.7211 $w=2.1e-08 $l=8e-09 $layer=Gate_1 $thickness=5.6e-08 $X=0.513
+ $Y=0.1515 $X2=0.513 $Y2=0.1595
r8 8 9 5.79936 $w=2.03333e-08 $l=1.65e-08 $layer=Gate_1 $thickness=5.6e-08
+ $X=0.513 $Y=0.135 $X2=0.513 $Y2=0.1515
r9 7 8 5.79936 $w=2.03333e-08 $l=1.65e-08 $layer=Gate_1 $thickness=5.6e-08
+ $X=0.513 $Y=0.1185 $X2=0.513 $Y2=0.135
r10 6 7 2.7211 $w=2.1e-08 $l=8e-09 $layer=Gate_1 $thickness=5.6e-08 $X=0.513
+ $Y=0.1105 $X2=0.513 $Y2=0.1185
r11 5 6 14.6259 $w=2.1e-08 $l=4.3e-08 $layer=Gate_1 $thickness=5.6e-08 $X=0.513
+ $Y=0.0675 $X2=0.513 $Y2=0.1105
r12 5 3 14.6259 $w=2.1e-08 $l=4.3e-08 $layer=Gate_1 $thickness=5.6e-08 $X=0.513
+ $Y=0.0675 $X2=0.513 $Y2=0.0245
.ends

.subckt PM_OAI333xp33_ASAP7_75t_R%A2 vss 13 5 9 4 3 1
c1 1 vss 0.00304913f $X=0.459 $Y=0.135
c2 3 vss 0.0835412f $X=0.459 $Y=0.0245
c3 4 vss 0.00585812f $X=0.459 $Y=0.116
r1 13 12 1.34084 $w=1.3e-08 $l=5.8e-09 $layer=M1 $thickness=3.6e-08 $X=0.457
+ $Y=0.155 $X2=0.459 $Y2=0.1492
r2 11 12 3.32295 $w=1.3e-08 $l=1.42e-08 $layer=M1 $thickness=3.6e-08 $X=0.459
+ $Y=0.135 $X2=0.459 $Y2=0.1492
r3 4 11 4.4306 $w=1.3e-08 $l=1.9e-08 $layer=M1 $thickness=3.6e-08 $X=0.459
+ $Y=0.116 $X2=0.459 $Y2=0.135
r4 1 7 10.4265 $w=1.765e-08 $layer=LIG $thickness=5.2e-08 $X=0.459 $Y=0.135
+ $X2=0.459 $Y2=0.135
r5 1 11 19.3796 $a=3.24e-16 $layer=V0LIG $X=0.459 $Y=0.135 $X2=0.459 $Y2=0.135
r6 9 8 16.4967 $w=2.1e-08 $l=4.85e-08 $layer=Gate_1 $thickness=5.6e-08 $X=0.459
+ $Y=0.2025 $X2=0.459 $Y2=0.154
r7 7 8 6.6497 $w=2.04211e-08 $l=1.9e-08 $layer=Gate_1 $thickness=5.6e-08
+ $X=0.459 $Y=0.135 $X2=0.459 $Y2=0.154
r8 6 7 6.6497 $w=2.04211e-08 $l=1.9e-08 $layer=Gate_1 $thickness=5.6e-08
+ $X=0.459 $Y=0.116 $X2=0.459 $Y2=0.135
r9 5 6 16.4967 $w=2.1e-08 $l=4.85e-08 $layer=Gate_1 $thickness=5.6e-08 $X=0.459
+ $Y=0.0675 $X2=0.459 $Y2=0.116
r10 5 3 14.6259 $w=2.1e-08 $l=4.3e-08 $layer=Gate_1 $thickness=5.6e-08 $X=0.459
+ $Y=0.0675 $X2=0.459 $Y2=0.0245
.ends

.subckt PM_OAI333xp33_ASAP7_75t_R%Y vss 37 24 25 41 60 63 64 19 1 15 20 2 13 3
+ 4 14 21 16
c1 1 vss 0.00584369f $X=0.216 $Y=0.2025
c2 2 vss 0.0096365f $X=0.432 $Y=0.0675
c3 3 vss 0.00780163f $X=0.54 $Y=0.0675
c4 4 vss 0.00618953f $X=0.54 $Y=0.2025
c5 13 vss 0.00451572f $X=0.4175 $Y=0.0675
c6 14 vss 0.0370584f $X=0.5255 $Y=0.0675
c7 15 vss 0.00261296f $X=0.2015 $Y=0.2025
c8 16 vss 0.036305f $X=0.5255 $Y=0.2025
c9 17 vss 0.0015002f $X=0.567 $Y=0.072
c10 18 vss 0.00264812f $X=0.567 $Y=0.234
c11 19 vss 0.0319726f $X=0.5265 $Y=0.234
c12 20 vss 0.0113705f $X=0.4185 $Y=0.072
c13 21 vss 0.00329393f $X=0.567 $Y=0.0935
r1 64 62 0.0308642 $w=8.1e-08 $l=2.5e-09 $layer=P_src_drn $thickness=1e-09
+ $X=0.2333 $Y=0.2025 $X2=0.2305 $Y2=0.2025
r2 1 62 0.179012 $w=8.1e-08 $l=1.45e-08 $layer=P_src_drn $thickness=1e-09
+ $X=0.216 $Y=0.2025 $X2=0.2305 $Y2=0.2025
r3 15 1 0.179012 $w=8.1e-08 $l=1.45e-08 $layer=P_src_drn $thickness=1e-09
+ $X=0.2015 $Y=0.2025 $X2=0.216 $Y2=0.2025
r4 63 15 0.0308642 $w=8.1e-08 $l=2.5e-09 $layer=P_src_drn $thickness=1e-09
+ $X=0.1986 $Y=0.2025 $X2=0.2015 $Y2=0.2025
r5 16 4 0.154321 $w=8.1e-08 $l=1.25e-08 $layer=P_src_drn $thickness=1e-09
+ $X=0.5255 $Y=0.2025 $X2=0.54 $Y2=0.2025
r6 60 16 0.0308642 $w=8.1e-08 $l=2.5e-09 $layer=P_src_drn $thickness=1e-09
+ $X=0.5226 $Y=0.2025 $X2=0.5255 $Y2=0.2025
r7 1 57 19.3796 $a=3.24e-16 $layer=V0LISD $X=0.216 $Y=0.2025 $X2=0.216 $Y2=0.234
r8 4 42 19.3796 $a=3.24e-16 $layer=V0LISD $X=0.54 $Y=0.2025 $X2=0.54 $Y2=0.234
r9 57 58 3.14806 $w=1.3e-08 $l=1.35e-08 $layer=M1 $thickness=3.6e-08 $X=0.216
+ $Y=0.234 $X2=0.2295 $Y2=0.234
r10 55 58 3.14806 $w=1.3e-08 $l=1.35e-08 $layer=M1 $thickness=3.6e-08 $X=0.243
+ $Y=0.234 $X2=0.2295 $Y2=0.234
r11 54 55 6.29612 $w=1.3e-08 $l=2.7e-08 $layer=M1 $thickness=3.6e-08 $X=0.27
+ $Y=0.234 $X2=0.243 $Y2=0.234
r12 53 54 6.29612 $w=1.3e-08 $l=2.7e-08 $layer=M1 $thickness=3.6e-08 $X=0.297
+ $Y=0.234 $X2=0.27 $Y2=0.234
r13 52 53 6.06293 $w=1.3e-08 $l=2.6e-08 $layer=M1 $thickness=3.6e-08 $X=0.323
+ $Y=0.234 $X2=0.297 $Y2=0.234
r14 51 52 4.19742 $w=1.3e-08 $l=1.8e-08 $layer=M1 $thickness=3.6e-08 $X=0.341
+ $Y=0.234 $X2=0.323 $Y2=0.234
r15 50 51 2.3319 $w=1.3e-08 $l=1e-08 $layer=M1 $thickness=3.6e-08 $X=0.351
+ $Y=0.234 $X2=0.341 $Y2=0.234
r16 49 50 6.29612 $w=1.3e-08 $l=2.7e-08 $layer=M1 $thickness=3.6e-08 $X=0.378
+ $Y=0.234 $X2=0.351 $Y2=0.234
r17 48 49 6.29612 $w=1.3e-08 $l=2.7e-08 $layer=M1 $thickness=3.6e-08 $X=0.405
+ $Y=0.234 $X2=0.378 $Y2=0.234
r18 47 48 6.29612 $w=1.3e-08 $l=2.7e-08 $layer=M1 $thickness=3.6e-08 $X=0.432
+ $Y=0.234 $X2=0.405 $Y2=0.234
r19 46 47 6.29612 $w=1.3e-08 $l=2.7e-08 $layer=M1 $thickness=3.6e-08 $X=0.459
+ $Y=0.234 $X2=0.432 $Y2=0.234
r20 45 46 6.29612 $w=1.3e-08 $l=2.7e-08 $layer=M1 $thickness=3.6e-08 $X=0.486
+ $Y=0.234 $X2=0.459 $Y2=0.234
r21 44 45 6.29612 $w=1.3e-08 $l=2.7e-08 $layer=M1 $thickness=3.6e-08 $X=0.513
+ $Y=0.234 $X2=0.486 $Y2=0.234
r22 42 43 3.14806 $w=1.3e-08 $l=1.35e-08 $layer=M1 $thickness=3.6e-08 $X=0.54
+ $Y=0.234 $X2=0.5535 $Y2=0.234
r23 19 42 3.14806 $w=1.3e-08 $l=1.35e-08 $layer=M1 $thickness=3.6e-08 $X=0.5265
+ $Y=0.234 $X2=0.54 $Y2=0.234
r24 19 44 3.14806 $w=1.3e-08 $l=1.35e-08 $layer=M1 $thickness=3.6e-08 $X=0.5265
+ $Y=0.234 $X2=0.513 $Y2=0.234
r25 18 39 3.36447 $w=1.71023e-08 $l=2.15e-08 $layer=M1 $thickness=3.6e-08
+ $X=0.567 $Y=0.234 $X2=0.567 $Y2=0.2125
r26 18 43 1.49895 $w=1.63333e-08 $l=1.35e-08 $layer=M1 $thickness=3.6e-08
+ $X=0.567 $Y=0.234 $X2=0.5535 $Y2=0.234
r27 14 3 0.154321 $w=8.1e-08 $l=1.25e-08 $layer=N_src_drn $thickness=1e-09
+ $X=0.5255 $Y=0.0675 $X2=0.54 $Y2=0.0675
r28 41 14 0.0308642 $w=8.1e-08 $l=2.5e-09 $layer=N_src_drn $thickness=1e-09
+ $X=0.5226 $Y=0.0675 $X2=0.5255 $Y2=0.0675
r29 38 39 9.50248 $w=1.3e-08 $l=4.08e-08 $layer=M1 $thickness=3.6e-08 $X=0.567
+ $Y=0.1717 $X2=0.567 $Y2=0.2125
r30 37 38 6.70421 $w=1.3e-08 $l=2.87e-08 $layer=M1 $thickness=3.6e-08 $X=0.572
+ $Y=0.143 $X2=0.567 $Y2=0.1717
r31 37 36 4.37231 $w=1.3e-08 $l=1.88e-08 $layer=M1 $thickness=3.6e-08 $X=0.572
+ $Y=0.143 $X2=0.567 $Y2=0.1242
r32 21 36 7.17059 $w=1.3e-08 $l=3.07e-08 $layer=M1 $thickness=3.6e-08 $X=0.567
+ $Y=0.0935 $X2=0.567 $Y2=0.1242
r33 3 34 19.3796 $a=3.24e-16 $layer=V0LISD $X=0.54 $Y=0.0675 $X2=0.54 $Y2=0.072
r34 17 35 1.49895 $w=1.63333e-08 $l=1.35e-08 $layer=M1 $thickness=3.6e-08
+ $X=0.567 $Y=0.072 $X2=0.5535 $Y2=0.072
r35 17 21 3.36447 $w=1.71023e-08 $l=2.15e-08 $layer=M1 $thickness=3.6e-08
+ $X=0.567 $Y=0.072 $X2=0.567 $Y2=0.0935
r36 34 35 3.14806 $w=1.3e-08 $l=1.35e-08 $layer=M1 $thickness=3.6e-08 $X=0.54
+ $Y=0.072 $X2=0.5535 $Y2=0.072
r37 33 34 3.14806 $w=1.3e-08 $l=1.35e-08 $layer=M1 $thickness=3.6e-08 $X=0.5265
+ $Y=0.072 $X2=0.54 $Y2=0.072
r38 32 33 1.86552 $w=1.3e-08 $l=8e-09 $layer=M1 $thickness=3.6e-08 $X=0.5185
+ $Y=0.072 $X2=0.5265 $Y2=0.072
r39 31 32 2.09871 $w=1.3e-08 $l=9e-09 $layer=M1 $thickness=3.6e-08 $X=0.5095
+ $Y=0.072 $X2=0.5185 $Y2=0.072
r40 30 31 5.47996 $w=1.3e-08 $l=2.35e-08 $layer=M1 $thickness=3.6e-08 $X=0.486
+ $Y=0.072 $X2=0.5095 $Y2=0.072
r41 29 30 6.29612 $w=1.3e-08 $l=2.7e-08 $layer=M1 $thickness=3.6e-08 $X=0.459
+ $Y=0.072 $X2=0.486 $Y2=0.072
r42 27 29 3.14806 $w=1.3e-08 $l=1.35e-08 $layer=M1 $thickness=3.6e-08 $X=0.4455
+ $Y=0.072 $X2=0.459 $Y2=0.072
r43 26 27 3.14806 $w=1.3e-08 $l=1.35e-08 $layer=M1 $thickness=3.6e-08 $X=0.432
+ $Y=0.072 $X2=0.4455 $Y2=0.072
r44 20 26 3.14806 $w=1.3e-08 $l=1.35e-08 $layer=M1 $thickness=3.6e-08 $X=0.4185
+ $Y=0.072 $X2=0.432 $Y2=0.072
r45 2 26 19.3796 $a=3.24e-16 $layer=V0LISD $X=0.432 $Y=0.0675 $X2=0.432
+ $Y2=0.072
r46 25 23 0.0308642 $w=8.1e-08 $l=2.5e-09 $layer=N_src_drn $thickness=1e-09
+ $X=0.4493 $Y=0.0675 $X2=0.4465 $Y2=0.0675
r47 2 23 0.179012 $w=8.1e-08 $l=1.45e-08 $layer=N_src_drn $thickness=1e-09
+ $X=0.432 $Y=0.0675 $X2=0.4465 $Y2=0.0675
r48 13 2 0.179012 $w=8.1e-08 $l=1.45e-08 $layer=N_src_drn $thickness=1e-09
+ $X=0.4175 $Y=0.0675 $X2=0.432 $Y2=0.0675
r49 24 13 0.0308642 $w=8.1e-08 $l=2.5e-09 $layer=N_src_drn $thickness=1e-09
+ $X=0.4146 $Y=0.0675 $X2=0.4175 $Y2=0.0675
.ends

.subckt PM_OAI333xp33_ASAP7_75t_R%B1 vss 13 5 9 3 4
c1 1 vss 0.00486542f $X=0.243 $Y=0.135
c2 3 vss 0.102915f $X=0.243 $Y=0.0245
c3 4 vss 0.0075431f $X=0.243 $Y=0.116
r1 13 12 1.22425 $w=1.3e-08 $l=5.3e-09 $layer=M1 $thickness=3.6e-08 $X=0.243
+ $Y=0.154 $X2=0.243 $Y2=0.1487
r2 11 12 3.20636 $w=1.3e-08 $l=1.37e-08 $layer=M1 $thickness=3.6e-08 $X=0.243
+ $Y=0.135 $X2=0.243 $Y2=0.1487
r3 4 11 4.4306 $w=1.3e-08 $l=1.9e-08 $layer=M1 $thickness=3.6e-08 $X=0.243
+ $Y=0.116 $X2=0.243 $Y2=0.135
r4 1 7 10.4265 $w=1.765e-08 $layer=LIG $thickness=5.2e-08 $X=0.243 $Y=0.135
+ $X2=0.243 $Y2=0.135
r5 1 11 19.3796 $a=3.24e-16 $layer=V0LIG $X=0.243 $Y=0.135 $X2=0.243 $Y2=0.135
r6 9 8 16.4967 $w=2.1e-08 $l=4.85e-08 $layer=Gate_1 $thickness=5.6e-08 $X=0.243
+ $Y=0.2025 $X2=0.243 $Y2=0.154
r7 7 8 6.6497 $w=2.04211e-08 $l=1.9e-08 $layer=Gate_1 $thickness=5.6e-08
+ $X=0.243 $Y=0.135 $X2=0.243 $Y2=0.154
r8 6 7 6.6497 $w=2.04211e-08 $l=1.9e-08 $layer=Gate_1 $thickness=5.6e-08
+ $X=0.243 $Y=0.116 $X2=0.243 $Y2=0.135
r9 5 6 16.4967 $w=2.1e-08 $l=4.85e-08 $layer=Gate_1 $thickness=5.6e-08 $X=0.243
+ $Y=0.0675 $X2=0.243 $Y2=0.116
r10 5 3 14.6259 $w=2.1e-08 $l=4.3e-08 $layer=Gate_1 $thickness=5.6e-08 $X=0.243
+ $Y=0.0675 $X2=0.243 $Y2=0.0245
.ends

.subckt PM_OAI333xp33_ASAP7_75t_R%C1 vss 13 5 9 4 3
c1 1 vss 0.00481314f $X=0.189 $Y=0.135
c2 3 vss 0.103006f $X=0.189 $Y=0.0245
c3 4 vss 0.00757898f $X=0.189 $Y=0.116
r1 13 12 1.34084 $w=1.3e-08 $l=5.8e-09 $layer=M1 $thickness=3.6e-08 $X=0.187
+ $Y=0.155 $X2=0.189 $Y2=0.1492
r2 11 12 3.32295 $w=1.3e-08 $l=1.42e-08 $layer=M1 $thickness=3.6e-08 $X=0.189
+ $Y=0.135 $X2=0.189 $Y2=0.1492
r3 4 11 4.4306 $w=1.3e-08 $l=1.9e-08 $layer=M1 $thickness=3.6e-08 $X=0.189
+ $Y=0.116 $X2=0.189 $Y2=0.135
r4 1 7 10.4265 $w=1.765e-08 $layer=LIG $thickness=5.2e-08 $X=0.189 $Y=0.135
+ $X2=0.189 $Y2=0.135
r5 1 11 19.3796 $a=3.24e-16 $layer=V0LIG $X=0.189 $Y=0.135 $X2=0.189 $Y2=0.135
r6 9 8 16.4967 $w=2.1e-08 $l=4.85e-08 $layer=Gate_1 $thickness=5.6e-08 $X=0.189
+ $Y=0.2025 $X2=0.189 $Y2=0.154
r7 7 8 6.6497 $w=2.04211e-08 $l=1.9e-08 $layer=Gate_1 $thickness=5.6e-08
+ $X=0.189 $Y=0.135 $X2=0.189 $Y2=0.154
r8 6 7 6.6497 $w=2.04211e-08 $l=1.9e-08 $layer=Gate_1 $thickness=5.6e-08
+ $X=0.189 $Y=0.116 $X2=0.189 $Y2=0.135
r9 5 6 16.4967 $w=2.1e-08 $l=4.85e-08 $layer=Gate_1 $thickness=5.6e-08 $X=0.189
+ $Y=0.0675 $X2=0.189 $Y2=0.116
r10 5 3 14.6259 $w=2.1e-08 $l=4.3e-08 $layer=Gate_1 $thickness=5.6e-08 $X=0.189
+ $Y=0.0675 $X2=0.189 $Y2=0.0245
.ends

* End of included file OAI333xp33_ASAP7_75t_R.pex.sp.pex

*
.subckt OAI333xp33_ASAP7_75t_CUSTOM_4_25_0_7 VSS VDD C3 C2 C1 B1 B2 B3 A3 A2 A1 Y
*
* VSS VSS
* VDD VDD
* C3 C3
* C2 C2
* C1 C1
* B1 B1
* B2 B2
* B3 B3
* A3 A3
* A2 A2
* A1 A1
* Y Y
*
*

M0 noxref_12 N_M0_g VSS VSS nmos_rvt L=2e-08 W=8.1e-08 nfin=3 $X=0.071 $Y=0.027
M1 VSS N_M1_g noxref_12 VSS nmos_rvt L=2e-08 W=8.1e-08 nfin=3 $X=0.125 $Y=0.027
M2 noxref_12 N_M2_g VSS VSS nmos_rvt L=2e-08 W=8.1e-08 nfin=3 $X=0.179 $Y=0.027
M3 noxref_13 N_M3_g noxref_12 VSS nmos_rvt L=2e-08 W=8.1e-08 nfin=3 $X=0.233
+ $Y=0.027
M4 noxref_12 N_M4_g noxref_13 VSS nmos_rvt L=2e-08 W=8.1e-08 nfin=3 $X=0.287
+ $Y=0.027
M5 noxref_13 N_M5_g noxref_12 VSS nmos_rvt L=2e-08 W=8.1e-08 nfin=3 $X=0.341
+ $Y=0.027
M6 N_M6_d N_M6_g noxref_13 VSS nmos_rvt L=2e-08 W=8.1e-08 nfin=3 $X=0.395
+ $Y=0.027
M7 noxref_13 N_M7_g N_M7_s VSS nmos_rvt L=2e-08 W=8.1e-08 nfin=3 $X=0.449
+ $Y=0.027
M8 N_M8_d N_M8_g noxref_13 VSS nmos_rvt L=2e-08 W=8.1e-08 nfin=3 $X=0.503
+ $Y=0.027
M9 noxref_15 N_M9_g VDD VDD pmos_rvt L=2e-08 W=8.1e-08 nfin=3 $X=0.071 $Y=0.162
M10 noxref_16 N_M10_g noxref_15 VDD pmos_rvt L=2e-08 W=8.1e-08 nfin=3 $X=0.125
+ $Y=0.162
M11 N_M11_d N_M11_g noxref_16 VDD pmos_rvt L=2e-08 W=8.1e-08 nfin=3 $X=0.179
+ $Y=0.162
M12 noxref_17 N_M12_g N_M12_s VDD pmos_rvt L=2e-08 W=8.1e-08 nfin=3 $X=0.233
+ $Y=0.162
M13 noxref_18 N_M13_g noxref_17 VDD pmos_rvt L=2e-08 W=8.1e-08 nfin=3 $X=0.287
+ $Y=0.162
M14 VDD N_M14_g noxref_18 VDD pmos_rvt L=2e-08 W=8.1e-08 nfin=3 $X=0.341
+ $Y=0.162
M15 noxref_19 N_M15_g VDD VDD pmos_rvt L=2e-08 W=8.1e-08 nfin=3 $X=0.395
+ $Y=0.162
M16 noxref_20 N_M16_g noxref_19 VDD pmos_rvt L=2e-08 W=8.1e-08 nfin=3 $X=0.449
+ $Y=0.162
M17 N_M17_d N_M17_g noxref_20 VDD pmos_rvt L=2e-08 W=8.1e-08 nfin=3 $X=0.503
+ $Y=0.162

* .include "OAI333xp33_ASAP7_75t_R.pex.sp.pxi"

* Start of included file OAI333xp33_ASAP7_75t_R.pex.sp.pxi
x_PM_OAI333xp33_ASAP7_75t_R%C3 vss C3 N_M0_g N_M9_g N_C3_3
+ PM_OAI333xp33_ASAP7_75t_R%C3
x_PM_OAI333xp33_ASAP7_75t_R%C2 vss C2 N_M1_g N_M10_g N_C2_4 N_C2_3
+ PM_OAI333xp33_ASAP7_75t_R%C2
cc_1 N_C2_4 N_C3_3 0.00492794f $X=0.135 $Y=0.116
cc_2 N_C2_3 N_C3_3 0.00722055f $X=0.135 $Y=0.0245
x_PM_OAI333xp33_ASAP7_75t_R%B2 vss B2 N_M4_g N_M13_g N_B2_4 N_B2_3
+ PM_OAI333xp33_ASAP7_75t_R%B2
cc_3 N_B2_4 N_B1_4 0.00332284f $X=0.297 $Y=0.116
cc_4 N_B2_3 N_B1_3 0.00699183f $X=0.297 $Y=0.0245
x_PM_OAI333xp33_ASAP7_75t_R%B3 vss B3 N_M5_g N_M14_g N_B3_4 N_B3_3
+ PM_OAI333xp33_ASAP7_75t_R%B3
cc_5 N_B3_4 N_B2_4 0.00341108f $X=0.351 $Y=0.116
cc_6 N_B3_3 N_B2_3 0.00692899f $X=0.351 $Y=0.0245
x_PM_OAI333xp33_ASAP7_75t_R%A3 vss A3 N_M6_g N_M15_g N_A3_3 N_A3_4
+ PM_OAI333xp33_ASAP7_75t_R%A3
cc_7 N_A3_3 N_B3_3 0.00315791f $X=0.405 $Y=0.0245
cc_8 N_A3_4 N_B3_4 0.0051018f $X=0.405 $Y=0.116
x_PM_OAI333xp33_ASAP7_75t_R%A1 vss A1 N_M8_g N_M17_g N_A1_4 N_A1_3 N_A1_1
+ PM_OAI333xp33_ASAP7_75t_R%A1
cc_9 N_A1_4 N_A2_4 0.00335192f $X=0.513 $Y=0.116
cc_10 N_A1_3 N_A2_3 0.0070904f $X=0.513 $Y=0.0245
x_PM_OAI333xp33_ASAP7_75t_R%A2 vss A2 N_M7_g N_M16_g N_A2_4 N_A2_3 N_A2_1
+ PM_OAI333xp33_ASAP7_75t_R%A2
cc_11 N_A2_4 N_A3_4 0.00340663f $X=0.459 $Y=0.116
cc_12 N_A2_3 N_A3_3 0.00693989f $X=0.459 $Y=0.0245
x_PM_OAI333xp33_ASAP7_75t_R%Y vss Y N_M6_d N_M7_s N_M8_d N_M17_d N_M11_d
+ N_M12_s N_Y_19 N_Y_1 N_Y_15 N_Y_20 N_Y_2 N_Y_13 N_Y_3 N_Y_4 N_Y_14 N_Y_21
+ N_Y_16 PM_OAI333xp33_ASAP7_75t_R%Y
cc_13 N_Y_19 N_C1_3 0.000568807f $X=0.5265 $Y=0.234
cc_14 N_Y_1 N_C1_4 0.00111521f $X=0.216 $Y=0.2025
cc_15 N_Y_1 N_C1_3 0.00147497f $X=0.216 $Y=0.2025
cc_16 N_Y_15 N_C1_3 0.035418f $X=0.2015 $Y=0.2025
cc_17 N_Y_19 N_B1_3 0.00114573f $X=0.5265 $Y=0.234
cc_18 N_Y_1 N_B1_3 0.00141163f $X=0.216 $Y=0.2025
cc_19 N_Y_1 N_B1_4 0.00172073f $X=0.216 $Y=0.2025
cc_20 N_Y_15 N_B1_3 0.035394f $X=0.2015 $Y=0.2025
cc_21 N_Y_19 N_B2_4 0.00350256f $X=0.5265 $Y=0.234
cc_22 N_Y_19 N_B3_4 0.00278315f $X=0.5265 $Y=0.234
cc_23 N_Y_20 N_A3_3 0.000593134f $X=0.4185 $Y=0.072
cc_24 N_Y_2 N_A3_3 0.00078589f $X=0.432 $Y=0.0675
cc_25 N_Y_19 N_A3_4 0.00128401f $X=0.5265 $Y=0.234
cc_26 N_Y_2 N_A3_4 0.00204505f $X=0.432 $Y=0.0675
cc_27 N_Y_13 N_A3_3 0.0351777f $X=0.4175 $Y=0.0675
cc_28 N_Y_2 N_A2_3 0.00129234f $X=0.432 $Y=0.0675
cc_29 N_Y_13 N_A2_1 0.000797097f $X=0.4175 $Y=0.0675
cc_30 N_Y_20 N_A2_4 0.00107253f $X=0.4185 $Y=0.072
cc_31 N_Y_19 N_A2_4 0.00141489f $X=0.5265 $Y=0.234
cc_32 N_Y_2 N_A2_4 0.00276672f $X=0.432 $Y=0.0675
cc_33 N_Y_13 N_A2_3 0.0347197f $X=0.4175 $Y=0.0675
cc_34 N_Y_3 N_A1_3 0.00181404f $X=0.54 $Y=0.0675
cc_35 N_Y_20 N_A1_3 0.00103036f $X=0.4185 $Y=0.072
cc_36 N_Y_19 N_A1_4 0.0011093f $X=0.5265 $Y=0.234
cc_37 N_Y_4 N_A1_3 0.0015306f $X=0.54 $Y=0.2025
cc_38 N_Y_14 N_A1_1 0.00179699f $X=0.5255 $Y=0.0675
cc_39 N_Y_14 N_A1_3 0.0145717f $X=0.5255 $Y=0.0675
cc_40 N_Y_21 N_A1_4 0.00653324f $X=0.567 $Y=0.0935
cc_41 N_Y_16 N_A1_3 0.0541521f $X=0.5255 $Y=0.2025
x_PM_OAI333xp33_ASAP7_75t_R%B1 vss B1 N_M3_g N_M12_g N_B1_3 N_B1_4
+ PM_OAI333xp33_ASAP7_75t_R%B1
cc_42 N_B1_3 N_C1_3 0.00315796f $X=0.243 $Y=0.0245
cc_43 N_B1_4 N_C1_4 0.00500231f $X=0.243 $Y=0.116
x_PM_OAI333xp33_ASAP7_75t_R%C1 vss C1 N_M2_g N_M11_g N_C1_4 N_C1_3
+ PM_OAI333xp33_ASAP7_75t_R%C1
cc_44 N_C1_4 N_C2_4 0.00395041f $X=0.189 $Y=0.116
cc_45 N_C1_3 N_C2_3 0.00698711f $X=0.189 $Y=0.0245

* End of included file OAI333xp33_ASAP7_75t_R.pex.sp.pxi
.ends

.subckt PM_OAI31xp67_ASAP7_75t_R%A3 vss 26 9 15 30 33 4
c1 1 vss 0.017716f $X=0.0715 $Y=0.135
c2 3 vss 0.159513f $X=0.081 $Y=0.0245
c3 4 vss 0.160234f $X=0.135 $Y=0.135
c4 5 vss 0.00124925f $X=0.027 $Y=0.135
c5 6 vss 0.00663558f $X=0.027 $Y=0.098
c6 7 vss 0.0102618f $X=0.027 $Y=0.172
c7 8 vss 0.00325223f $X=0.056 $Y=0.135
r1 5 25 1.20989 $w=1.73902e-08 $l=1.02e-08 $layer=M1 $thickness=3.6e-08
+ $X=0.027 $Y=0.135 $X2=0.0372 $Y2=0.135
r2 5 6 7.44771 $w=1.42162e-08 $l=3.7e-08 $layer=M1 $thickness=3.6e-08 $X=0.027
+ $Y=0.135 $X2=0.027 $Y2=0.098
r3 5 7 7.44771 $w=1.42162e-08 $l=3.7e-08 $layer=M1 $thickness=3.6e-08 $X=0.027
+ $Y=0.135 $X2=0.027 $Y2=0.172
r4 33 32 16.4967 $w=2.1e-08 $l=4.85e-08 $layer=Gate_1 $thickness=5.6e-08
+ $X=0.135 $Y=0.2025 $X2=0.135 $Y2=0.154
r5 30 31 16.4967 $w=2.1e-08 $l=4.85e-08 $layer=Gate_1 $thickness=5.6e-08
+ $X=0.135 $Y=0.0675 $X2=0.135 $Y2=0.116
r6 4 21 6.54019 $w=2.09524e-08 $layer=Gate_1 $thickness=5.21905e-08 $X=0.135
+ $Y=0.135 $X2=0.135 $Y2=0.135
r7 4 31 6.6497 $w=2.04211e-08 $l=1.9e-08 $layer=Gate_1 $thickness=5.6e-08
+ $X=0.135 $Y=0.135 $X2=0.135 $Y2=0.116
r8 4 32 6.6497 $w=2.04211e-08 $l=1.9e-08 $layer=Gate_1 $thickness=5.6e-08
+ $X=0.135 $Y=0.135 $X2=0.135 $Y2=0.154
r9 26 27 0.174892 $w=1.3e-08 $l=7e-10 $layer=M1 $thickness=3.6e-08 $X=0.039
+ $Y=0.134 $X2=0.0397 $Y2=0.135
r10 26 25 0.408082 $w=1.3e-08 $l=1.8e-09 $layer=M1 $thickness=3.6e-08 $X=0.039
+ $Y=0.134 $X2=0.0372 $Y2=0.135
r11 8 23 5.82974 $w=1.3e-08 $l=2.5e-08 $layer=M1 $thickness=3.6e-08 $X=0.056
+ $Y=0.135 $X2=0.081 $Y2=0.135
r12 8 27 3.78933 $w=1.3e-08 $l=1.63e-08 $layer=M1 $thickness=3.6e-08 $X=0.056
+ $Y=0.135 $X2=0.0397 $Y2=0.135
r13 20 21 12.6539 $w=1.77815e-08 $l=2.7e-08 $layer=LIG $thickness=4.8e-08
+ $X=0.108 $Y=0.135 $X2=0.135 $Y2=0.135
r14 18 20 10.1729 $w=1.54914e-08 $l=1.75e-08 $layer=LIG $thickness=4.8e-08
+ $X=0.0905 $Y=0.135 $X2=0.108 $Y2=0.135
r15 17 18 2.48102 $w=2.2e-08 $l=9.5e-09 $layer=LIG $thickness=4.8e-08 $X=0.081
+ $Y=0.135 $X2=0.0905 $Y2=0.135
r16 17 23 19.3796 $a=3.24e-16 $layer=V0LIG $X=0.081 $Y=0.135 $X2=0.081 $Y2=0.135
r17 1 17 2.48102 $w=2.2e-08 $l=9.5e-09 $layer=LIG $thickness=4.8e-08 $X=0.0715
+ $Y=0.135 $X2=0.081 $Y2=0.135
r18 15 14 14.6259 $w=2.1e-08 $l=4.3e-08 $layer=Gate_1 $thickness=5.6e-08
+ $X=0.081 $Y=0.2025 $X2=0.081 $Y2=0.1595
r19 13 14 2.7211 $w=2.1e-08 $l=8e-09 $layer=Gate_1 $thickness=5.6e-08 $X=0.081
+ $Y=0.1515 $X2=0.081 $Y2=0.1595
r20 12 13 5.79936 $w=2.03333e-08 $l=1.65e-08 $layer=Gate_1 $thickness=5.6e-08
+ $X=0.081 $Y=0.135 $X2=0.081 $Y2=0.1515
r21 12 18 4.05918 $w=2.0087e-08 $l=9.5e-09 $layer=Gate_1 $thickness=5.56522e-08
+ $X=0.081 $Y=0.135 $X2=0.0905 $Y2=0.135
r22 12 17 6.27904 $w=2.09e-08 $layer=Gate_1 $thickness=5.24e-08 $X=0.081
+ $Y=0.135 $X2=0.081 $Y2=0.135
r23 11 12 5.79936 $w=2.03333e-08 $l=1.65e-08 $layer=Gate_1 $thickness=5.6e-08
+ $X=0.081 $Y=0.1185 $X2=0.081 $Y2=0.135
r24 10 11 2.7211 $w=2.1e-08 $l=8e-09 $layer=Gate_1 $thickness=5.6e-08 $X=0.081
+ $Y=0.1105 $X2=0.081 $Y2=0.1185
r25 9 10 14.6259 $w=2.1e-08 $l=4.3e-08 $layer=Gate_1 $thickness=5.6e-08
+ $X=0.081 $Y=0.0675 $X2=0.081 $Y2=0.1105
r26 9 3 14.6259 $w=2.1e-08 $l=4.3e-08 $layer=Gate_1 $thickness=5.6e-08 $X=0.081
+ $Y=0.0675 $X2=0.081 $Y2=0.0245
.ends

.subckt PM_OAI31xp67_ASAP7_75t_R%A1 vss 31 8 12 22 26 3 4 7 6 1
c1 1 vss 0.0138132f $X=0.513 $Y=0.135
c2 3 vss 0.118159f $X=0.513 $Y=0.0245
c3 4 vss 0.125585f $X=0.567 $Y=0.135
c4 5 vss 0.00243731f $X=0.675 $Y=0.135
c5 6 vss 0.0079176f $X=0.5555 $Y=0.135
c6 7 vss 0.0061584f $X=0.675 $Y=0.1665
r1 5 33 0.79938 $w=1.72857e-08 $l=1.05e-08 $layer=M1 $thickness=3.6e-08
+ $X=0.675 $Y=0.135 $X2=0.6645 $Y2=0.135
r2 5 7 5.69636 $w=1.58e-08 $l=3.15e-08 $layer=M1 $thickness=3.6e-08 $X=0.675
+ $Y=0.135 $X2=0.675 $Y2=0.1665
r3 32 33 3.32295 $w=1.3e-08 $l=1.43e-08 $layer=M1 $thickness=3.6e-08 $X=0.6502
+ $Y=0.135 $X2=0.6645 $Y2=0.135
r4 31 32 3.08976 $w=1.3e-08 $l=1.32e-08 $layer=M1 $thickness=3.6e-08 $X=0.637
+ $Y=0.134 $X2=0.6502 $Y2=0.135
r5 31 30 3.43955 $w=1.3e-08 $l=1.48e-08 $layer=M1 $thickness=3.6e-08 $X=0.637
+ $Y=0.134 $X2=0.6222 $Y2=0.135
r6 29 30 7.05399 $w=1.3e-08 $l=3.02e-08 $layer=M1 $thickness=3.6e-08 $X=0.592
+ $Y=0.135 $X2=0.6222 $Y2=0.135
r7 28 29 5.82974 $w=1.3e-08 $l=2.5e-08 $layer=M1 $thickness=3.6e-08 $X=0.567
+ $Y=0.135 $X2=0.592 $Y2=0.135
r8 6 28 2.68168 $w=1.3e-08 $l=1.15e-08 $layer=M1 $thickness=3.6e-08 $X=0.5555
+ $Y=0.135 $X2=0.567 $Y2=0.135
r9 26 25 14.6259 $w=2.1e-08 $l=4.3e-08 $layer=Gate_1 $thickness=5.6e-08
+ $X=0.567 $Y=0.2025 $X2=0.567 $Y2=0.1595
r10 24 25 2.7211 $w=2.1e-08 $l=8e-09 $layer=Gate_1 $thickness=5.6e-08 $X=0.567
+ $Y=0.1515 $X2=0.567 $Y2=0.1595
r11 22 23 14.6259 $w=2.1e-08 $l=4.3e-08 $layer=Gate_1 $thickness=5.6e-08
+ $X=0.567 $Y=0.0675 $X2=0.567 $Y2=0.1105
r12 20 23 2.7211 $w=2.1e-08 $l=8e-09 $layer=Gate_1 $thickness=5.6e-08 $X=0.567
+ $Y=0.1185 $X2=0.567 $Y2=0.1105
r13 4 17 6.27904 $w=2.09e-08 $layer=Gate_1 $thickness=5.24e-08 $X=0.567
+ $Y=0.135 $X2=0.567 $Y2=0.135
r14 4 20 5.79936 $w=2.03333e-08 $l=1.65e-08 $layer=Gate_1 $thickness=5.6e-08
+ $X=0.567 $Y=0.135 $X2=0.567 $Y2=0.1185
r15 4 24 5.79936 $w=2.03333e-08 $l=1.65e-08 $layer=Gate_1 $thickness=5.6e-08
+ $X=0.567 $Y=0.135 $X2=0.567 $Y2=0.1515
r16 17 28 19.3796 $a=3.24e-16 $layer=V0LIG $X=0.567 $Y=0.135 $X2=0.567 $Y2=0.135
r17 16 17 2.48102 $w=2.2e-08 $l=9.5e-09 $layer=LIG $thickness=4.8e-08 $X=0.5575
+ $Y=0.135 $X2=0.567 $Y2=0.135
r18 15 16 10.1729 $w=1.54914e-08 $l=1.75e-08 $layer=LIG $thickness=4.8e-08
+ $X=0.54 $Y=0.135 $X2=0.5575 $Y2=0.135
r19 1 10 6.54019 $w=2.09524e-08 $layer=Gate_1 $thickness=5.21905e-08 $X=0.513
+ $Y=0.135 $X2=0.513 $Y2=0.135
r20 1 15 12.6539 $w=1.77815e-08 $l=2.7e-08 $layer=LIG $thickness=4.8e-08
+ $X=0.513 $Y=0.135 $X2=0.54 $Y2=0.135
r21 12 11 16.4967 $w=2.1e-08 $l=4.85e-08 $layer=Gate_1 $thickness=5.6e-08
+ $X=0.513 $Y=0.2025 $X2=0.513 $Y2=0.154
r22 10 11 6.6497 $w=2.04211e-08 $l=1.9e-08 $layer=Gate_1 $thickness=5.6e-08
+ $X=0.513 $Y=0.135 $X2=0.513 $Y2=0.154
r23 9 10 6.6497 $w=2.04211e-08 $l=1.9e-08 $layer=Gate_1 $thickness=5.6e-08
+ $X=0.513 $Y=0.116 $X2=0.513 $Y2=0.135
r24 8 9 16.4967 $w=2.1e-08 $l=4.85e-08 $layer=Gate_1 $thickness=5.6e-08
+ $X=0.513 $Y=0.0675 $X2=0.513 $Y2=0.116
r25 8 3 14.6259 $w=2.1e-08 $l=4.3e-08 $layer=Gate_1 $thickness=5.6e-08 $X=0.513
+ $Y=0.0675 $X2=0.513 $Y2=0.0245
.ends

.subckt PM_OAI31xp67_ASAP7_75t_R%Y vss 35 23 24 53 56 57 16 17 1 14 13 2 18 19
+ 20 3 4 15
c1 1 vss 0.00951808f $X=0.216 $Y=0.0675
c2 2 vss 0.0075779f $X=0.216 $Y=0.216
c3 3 vss 0.0114869f $X=0.54 $Y=0.2025
c4 4 vss 0.028861f $X=0.648 $Y=0.072
c5 13 vss 0.00434647f $X=0.2015 $Y=0.0675
c6 14 vss 0.00296041f $X=0.2015 $Y=0.216
c7 15 vss 0.00434219f $X=0.5255 $Y=0.2025
c8 16 vss 0.00540484f $X=0.2025 $Y=0.072
c9 17 vss 0.00577585f $X=0.243 $Y=0.198
c10 18 vss 0.00256677f $X=0.243 $Y=0.1035
c11 19 vss 0.0382013f $X=0.27 $Y=0.072
c12 20 vss 0.0194896f $X=0.6235 $Y=0.234
r1 57 55 0.0308642 $w=8.1e-08 $l=2.5e-09 $layer=P_src_drn $thickness=1e-09
+ $X=0.5573 $Y=0.2025 $X2=0.5545 $Y2=0.2025
r2 3 55 0.179012 $w=8.1e-08 $l=1.45e-08 $layer=P_src_drn $thickness=1e-09
+ $X=0.54 $Y=0.2025 $X2=0.5545 $Y2=0.2025
r3 15 3 0.179012 $w=8.1e-08 $l=1.45e-08 $layer=P_src_drn $thickness=1e-09
+ $X=0.5255 $Y=0.2025 $X2=0.54 $Y2=0.2025
r4 56 15 0.0308642 $w=8.1e-08 $l=2.5e-09 $layer=P_src_drn $thickness=1e-09
+ $X=0.5226 $Y=0.2025 $X2=0.5255 $Y2=0.2025
r5 3 50 19.3796 $a=3.24e-16 $layer=V0LISD $X=0.54 $Y=0.2025 $X2=0.54 $Y2=0.234
r6 14 2 0.231482 $w=5.4e-08 $l=1.25e-08 $layer=P_src_drn $thickness=1e-09
+ $X=0.2015 $Y=0.216 $X2=0.216 $Y2=0.216
r7 53 14 0.0462963 $w=5.4e-08 $l=2.5e-09 $layer=P_src_drn $thickness=1e-09
+ $X=0.1986 $Y=0.216 $X2=0.2015 $Y2=0.216
r8 50 51 8.97781 $w=1.3e-08 $l=3.85e-08 $layer=M1 $thickness=3.6e-08 $X=0.54
+ $Y=0.234 $X2=0.5785 $Y2=0.234
r9 20 47 5.71315 $w=1.3e-08 $l=2.45e-08 $layer=M1 $thickness=3.6e-08 $X=0.6235
+ $Y=0.234 $X2=0.648 $Y2=0.234
r10 20 51 10.4935 $w=1.3e-08 $l=4.5e-08 $layer=M1 $thickness=3.6e-08 $X=0.6235
+ $Y=0.234 $X2=0.5785 $Y2=0.234
r11 2 40 19.3796 $a=3.24e-16 $layer=V0LISD $X=0.216 $Y=0.216 $X2=0.216 $Y2=0.198
r12 46 47 19.3796 $a=3.24e-16 $layer=V0LISD $X=0.648 $Y=0.234 $X2=0.648
+ $Y2=0.234
r13 45 46 23.8708 $w=2.02e-08 $l=4.05e-08 $layer=LISD $thickness=2.7e-08
+ $X=0.648 $Y=0.1935 $X2=0.648 $Y2=0.234
r14 44 45 34.4801 $w=2.02e-08 $l=5.85e-08 $layer=LISD $thickness=2.7e-08
+ $X=0.648 $Y=0.135 $X2=0.648 $Y2=0.1935
r15 43 44 23.8708 $w=2.02e-08 $l=4.05e-08 $layer=LISD $thickness=2.7e-08
+ $X=0.648 $Y=0.0945 $X2=0.648 $Y2=0.135
r16 4 43 13.2616 $w=2.02e-08 $l=2.25e-08 $layer=LISD $thickness=2.7e-08
+ $X=0.648 $Y=0.072 $X2=0.648 $Y2=0.0945
r17 4 37 19.3796 $a=3.24e-16 $layer=V0LISD $X=0.648 $Y=0.072 $X2=0.648 $Y2=0.072
r18 40 41 3.14806 $w=1.3e-08 $l=1.35e-08 $layer=M1 $thickness=3.6e-08 $X=0.216
+ $Y=0.198 $X2=0.2295 $Y2=0.198
r19 17 30 6.16517 $w=1.44286e-08 $l=3.15e-08 $layer=M1 $thickness=3.6e-08
+ $X=0.243 $Y=0.198 $X2=0.243 $Y2=0.1665
r20 17 41 1.96775 $w=1.63333e-08 $l=1.35e-08 $layer=M1 $thickness=3.6e-08
+ $X=0.243 $Y=0.198 $X2=0.2295 $Y2=0.198
r21 36 37 4.37231 $w=1.3e-08 $l=1.88e-08 $layer=M1 $thickness=3.6e-08 $X=0.6292
+ $Y=0.072 $X2=0.648 $Y2=0.072
r22 35 36 2.39019 $w=1.3e-08 $l=1.02e-08 $layer=M1 $thickness=3.6e-08 $X=0.619
+ $Y=0.079 $X2=0.6292 $Y2=0.072
r23 35 34 7.63696 $w=1.3e-08 $l=3.28e-08 $layer=M1 $thickness=3.6e-08 $X=0.619
+ $Y=0.079 $X2=0.5862 $Y2=0.072
r24 33 34 7.63696 $w=1.3e-08 $l=3.27e-08 $layer=M1 $thickness=3.6e-08 $X=0.5535
+ $Y=0.072 $X2=0.5862 $Y2=0.072
r25 32 33 15.7403 $w=1.3e-08 $l=6.75e-08 $layer=M1 $thickness=3.6e-08 $X=0.486
+ $Y=0.072 $X2=0.5535 $Y2=0.072
r26 31 32 30.8976 $w=1.3e-08 $l=1.325e-07 $layer=M1 $thickness=3.6e-08
+ $X=0.3535 $Y=0.072 $X2=0.486 $Y2=0.072
r27 19 28 5.11582 $w=1.46667e-08 $l=2.7e-08 $layer=M1 $thickness=3.6e-08
+ $X=0.27 $Y=0.072 $X2=0.243 $Y2=0.072
r28 19 31 19.4713 $w=1.3e-08 $l=8.35e-08 $layer=M1 $thickness=3.6e-08 $X=0.27
+ $Y=0.072 $X2=0.3535 $Y2=0.072
r29 29 30 7.34548 $w=1.3e-08 $l=3.15e-08 $layer=M1 $thickness=3.6e-08 $X=0.243
+ $Y=0.135 $X2=0.243 $Y2=0.1665
r30 18 28 6.16517 $w=1.44286e-08 $l=3.15e-08 $layer=M1 $thickness=3.6e-08
+ $X=0.243 $Y=0.1035 $X2=0.243 $Y2=0.072
r31 18 29 7.34548 $w=1.3e-08 $l=3.15e-08 $layer=M1 $thickness=3.6e-08 $X=0.243
+ $Y=0.1035 $X2=0.243 $Y2=0.135
r32 27 28 1.96775 $w=1.63333e-08 $l=1.35e-08 $layer=M1 $thickness=3.6e-08
+ $X=0.2295 $Y=0.072 $X2=0.243 $Y2=0.072
r33 26 27 3.14806 $w=1.3e-08 $l=1.35e-08 $layer=M1 $thickness=3.6e-08 $X=0.216
+ $Y=0.072 $X2=0.2295 $Y2=0.072
r34 25 26 2.56509 $w=1.3e-08 $l=1.1e-08 $layer=M1 $thickness=3.6e-08 $X=0.205
+ $Y=0.072 $X2=0.216 $Y2=0.072
r35 16 25 0.582974 $w=1.3e-08 $l=2.5e-09 $layer=M1 $thickness=3.6e-08 $X=0.2025
+ $Y=0.072 $X2=0.205 $Y2=0.072
r36 1 26 19.3796 $a=3.24e-16 $layer=V0LISD $X=0.216 $Y=0.0675 $X2=0.216
+ $Y2=0.072
r37 24 22 0.0308642 $w=8.1e-08 $l=2.5e-09 $layer=N_src_drn $thickness=1e-09
+ $X=0.2333 $Y=0.0675 $X2=0.2305 $Y2=0.0675
r38 1 22 0.179012 $w=8.1e-08 $l=1.45e-08 $layer=N_src_drn $thickness=1e-09
+ $X=0.216 $Y=0.0675 $X2=0.2305 $Y2=0.0675
r39 13 1 0.179012 $w=8.1e-08 $l=1.45e-08 $layer=N_src_drn $thickness=1e-09
+ $X=0.2015 $Y=0.0675 $X2=0.216 $Y2=0.0675
r40 23 13 0.0308642 $w=8.1e-08 $l=2.5e-09 $layer=N_src_drn $thickness=1e-09
+ $X=0.1986 $Y=0.0675 $X2=0.2015 $Y2=0.0675
.ends

.subckt PM_OAI31xp67_ASAP7_75t_R%A2 vss 25 8 14 28 31 4 7 5
c1 1 vss 0.0180247f $X=0.3955 $Y=0.135
c2 3 vss 0.159576f $X=0.405 $Y=0.0245
c3 4 vss 0.156238f $X=0.459 $Y=0.135
c4 5 vss 0.00147397f $X=0.297 $Y=0.135
c5 6 vss 0.00540687f $X=0.297 $Y=0.1665
c6 7 vss 0.0078397f $X=0.38 $Y=0.135
r1 5 24 3.30617 $w=1.51176e-08 $l=2.12e-08 $layer=M1 $thickness=3.6e-08
+ $X=0.297 $Y=0.135 $X2=0.3182 $Y2=0.135
r2 5 6 5.69636 $w=1.58e-08 $l=3.15e-08 $layer=M1 $thickness=3.6e-08 $X=0.297
+ $Y=0.135 $X2=0.297 $Y2=0.1665
r3 31 30 16.4967 $w=2.1e-08 $l=4.85e-08 $layer=Gate_1 $thickness=5.6e-08
+ $X=0.459 $Y=0.2025 $X2=0.459 $Y2=0.154
r4 28 29 16.4967 $w=2.1e-08 $l=4.85e-08 $layer=Gate_1 $thickness=5.6e-08
+ $X=0.459 $Y=0.0675 $X2=0.459 $Y2=0.116
r5 4 20 6.54019 $w=2.09524e-08 $layer=Gate_1 $thickness=5.21905e-08 $X=0.459
+ $Y=0.135 $X2=0.459 $Y2=0.135
r6 4 29 6.6497 $w=2.04211e-08 $l=1.9e-08 $layer=Gate_1 $thickness=5.6e-08
+ $X=0.459 $Y=0.135 $X2=0.459 $Y2=0.116
r7 4 30 6.6497 $w=2.04211e-08 $l=1.9e-08 $layer=Gate_1 $thickness=5.6e-08
+ $X=0.459 $Y=0.135 $X2=0.459 $Y2=0.154
r8 25 26 3.90593 $w=1.3e-08 $l=1.67e-08 $layer=M1 $thickness=3.6e-08 $X=0.331
+ $Y=0.137 $X2=0.3477 $Y2=0.135
r9 25 24 2.97317 $w=1.3e-08 $l=1.28e-08 $layer=M1 $thickness=3.6e-08 $X=0.331
+ $Y=0.137 $X2=0.3182 $Y2=0.135
r10 7 22 5.82974 $w=1.3e-08 $l=2.5e-08 $layer=M1 $thickness=3.6e-08 $X=0.38
+ $Y=0.135 $X2=0.405 $Y2=0.135
r11 7 26 7.52037 $w=1.3e-08 $l=3.23e-08 $layer=M1 $thickness=3.6e-08 $X=0.38
+ $Y=0.135 $X2=0.3477 $Y2=0.135
r12 19 20 12.6539 $w=1.77815e-08 $l=2.7e-08 $layer=LIG $thickness=4.8e-08
+ $X=0.432 $Y=0.135 $X2=0.459 $Y2=0.135
r13 17 19 10.1729 $w=1.54914e-08 $l=1.75e-08 $layer=LIG $thickness=4.8e-08
+ $X=0.4145 $Y=0.135 $X2=0.432 $Y2=0.135
r14 16 17 2.48102 $w=2.2e-08 $l=9.5e-09 $layer=LIG $thickness=4.8e-08 $X=0.405
+ $Y=0.135 $X2=0.4145 $Y2=0.135
r15 16 22 19.3796 $a=3.24e-16 $layer=V0LIG $X=0.405 $Y=0.135 $X2=0.405 $Y2=0.135
r16 1 16 2.48102 $w=2.2e-08 $l=9.5e-09 $layer=LIG $thickness=4.8e-08 $X=0.3955
+ $Y=0.135 $X2=0.405 $Y2=0.135
r17 14 13 14.6259 $w=2.1e-08 $l=4.3e-08 $layer=Gate_1 $thickness=5.6e-08
+ $X=0.405 $Y=0.2025 $X2=0.405 $Y2=0.1595
r18 12 13 2.7211 $w=2.1e-08 $l=8e-09 $layer=Gate_1 $thickness=5.6e-08 $X=0.405
+ $Y=0.1515 $X2=0.405 $Y2=0.1595
r19 11 12 5.79936 $w=2.03333e-08 $l=1.65e-08 $layer=Gate_1 $thickness=5.6e-08
+ $X=0.405 $Y=0.135 $X2=0.405 $Y2=0.1515
r20 11 17 4.05918 $w=2.0087e-08 $l=9.5e-09 $layer=Gate_1 $thickness=5.56522e-08
+ $X=0.405 $Y=0.135 $X2=0.4145 $Y2=0.135
r21 11 16 6.27904 $w=2.09e-08 $layer=Gate_1 $thickness=5.24e-08 $X=0.405
+ $Y=0.135 $X2=0.405 $Y2=0.135
r22 10 11 5.79936 $w=2.03333e-08 $l=1.65e-08 $layer=Gate_1 $thickness=5.6e-08
+ $X=0.405 $Y=0.1185 $X2=0.405 $Y2=0.135
r23 9 10 2.7211 $w=2.1e-08 $l=8e-09 $layer=Gate_1 $thickness=5.6e-08 $X=0.405
+ $Y=0.1105 $X2=0.405 $Y2=0.1185
r24 8 9 14.6259 $w=2.1e-08 $l=4.3e-08 $layer=Gate_1 $thickness=5.6e-08 $X=0.405
+ $Y=0.0675 $X2=0.405 $Y2=0.1105
r25 8 3 14.6259 $w=2.1e-08 $l=4.3e-08 $layer=Gate_1 $thickness=5.6e-08 $X=0.405
+ $Y=0.0675 $X2=0.405 $Y2=0.0245
.ends

.subckt PM_OAI31xp67_ASAP7_75t_R%B vss 21 9 13 28 5 3 4 8 1
c1 1 vss 0.00943273f $X=0.1795 $Y=0.135
c2 3 vss 0.0842218f $X=0.189 $Y=0.0245
c3 4 vss 0.0629183f $X=0.243 $Y=0.135
c4 5 vss 0.000761425f $X=0.135 $Y=0.135
c5 6 vss 0.00747422f $X=0.135 $Y=0.1035
c6 7 vss 0.00758778f $X=0.135 $Y=0.1665
c7 8 vss 0.00426041f $X=0.1527 $Y=0.135
r1 5 8 2.95881 $w=1.55352e-08 $l=1.77e-08 $layer=M1 $thickness=3.6e-08 $X=0.135
+ $Y=0.135 $X2=0.1527 $Y2=0.135
r2 5 6 6.16517 $w=1.44286e-08 $l=3.15e-08 $layer=M1 $thickness=3.6e-08 $X=0.135
+ $Y=0.135 $X2=0.135 $Y2=0.1035
r3 5 7 6.16517 $w=1.44286e-08 $l=3.15e-08 $layer=M1 $thickness=3.6e-08 $X=0.135
+ $Y=0.135 $X2=0.135 $Y2=0.1665
r4 28 29 14.6259 $w=2.1e-08 $l=4.3e-08 $layer=Gate_1 $thickness=5.6e-08
+ $X=0.243 $Y=0.0675 $X2=0.243 $Y2=0.1105
r5 26 29 2.7211 $w=2.1e-08 $l=8e-09 $layer=Gate_1 $thickness=5.6e-08 $X=0.243
+ $Y=0.1185 $X2=0.243 $Y2=0.1105
r6 4 19 6.54019 $w=2.09524e-08 $layer=Gate_1 $thickness=5.21905e-08 $X=0.243
+ $Y=0.135 $X2=0.243 $Y2=0.135
r7 4 26 5.79936 $w=2.03333e-08 $l=1.65e-08 $layer=Gate_1 $thickness=5.6e-08
+ $X=0.243 $Y=0.135 $X2=0.243 $Y2=0.1185
r8 22 23 4.13912 $w=1.3e-08 $l=1.78e-08 $layer=M1 $thickness=3.6e-08 $X=0.1712
+ $Y=0.135 $X2=0.189 $Y2=0.135
r9 21 22 2.15701 $w=1.3e-08 $l=9.2e-09 $layer=M1 $thickness=3.6e-08 $X=0.162
+ $Y=0.131 $X2=0.1712 $Y2=0.135
r10 21 8 2.15701 $w=1.3e-08 $l=9.3e-09 $layer=M1 $thickness=3.6e-08 $X=0.162
+ $Y=0.131 $X2=0.1527 $Y2=0.135
r11 18 19 12.6539 $w=1.77815e-08 $l=2.7e-08 $layer=LIG $thickness=4.8e-08
+ $X=0.216 $Y=0.135 $X2=0.243 $Y2=0.135
r12 16 18 10.1729 $w=1.54914e-08 $l=1.75e-08 $layer=LIG $thickness=4.8e-08
+ $X=0.1985 $Y=0.135 $X2=0.216 $Y2=0.135
r13 15 16 2.48102 $w=2.2e-08 $l=9.5e-09 $layer=LIG $thickness=4.8e-08 $X=0.189
+ $Y=0.135 $X2=0.1985 $Y2=0.135
r14 15 23 19.3796 $a=3.24e-16 $layer=V0LIG $X=0.189 $Y=0.135 $X2=0.189 $Y2=0.135
r15 1 15 2.48102 $w=2.2e-08 $l=9.5e-09 $layer=LIG $thickness=4.8e-08 $X=0.1795
+ $Y=0.135 $X2=0.189 $Y2=0.135
r16 13 12 16.4967 $w=2.1e-08 $l=4.85e-08 $layer=Gate_1 $thickness=5.6e-08
+ $X=0.189 $Y=0.216 $X2=0.189 $Y2=0.1675
r17 11 12 11.2416 $w=2.06615e-08 $l=3.25e-08 $layer=Gate_1 $thickness=5.6e-08
+ $X=0.189 $Y=0.135 $X2=0.189 $Y2=0.1675
r18 11 16 4.05918 $w=2.0087e-08 $l=9.5e-09 $layer=Gate_1 $thickness=5.56522e-08
+ $X=0.189 $Y=0.135 $X2=0.1985 $Y2=0.135
r19 11 15 6.27904 $w=2.09e-08 $layer=Gate_1 $thickness=5.24e-08 $X=0.189
+ $Y=0.135 $X2=0.189 $Y2=0.135
r20 10 11 6.6497 $w=2.04211e-08 $l=1.9e-08 $layer=Gate_1 $thickness=5.6e-08
+ $X=0.189 $Y=0.116 $X2=0.189 $Y2=0.135
r21 9 10 16.4967 $w=2.1e-08 $l=4.85e-08 $layer=Gate_1 $thickness=5.6e-08
+ $X=0.189 $Y=0.0675 $X2=0.189 $Y2=0.116
r22 9 3 14.6259 $w=2.1e-08 $l=4.3e-08 $layer=Gate_1 $thickness=5.6e-08 $X=0.189
+ $Y=0.0675 $X2=0.189 $Y2=0.0245
.ends

* End of included file OAI31xp67_ASAP7_75t_R.pex.sp.pex

*
.subckt OAI31xp67_ASAP7_75t_CUSTOM_4_25_0_7 VSS VDD A3 B A2 A1 Y
*
* VSS VSS
* VDD VDD
* A3 A3
* B B
* A2 A2
* A1 A1
* Y Y
*
*

M0 VSS N_M0_g noxref_7 VSS nmos_rvt L=2e-08 W=8.1e-08 nfin=3 $X=0.071 $Y=0.027
M1 VSS N_M1_g noxref_7 VSS nmos_rvt L=2e-08 W=8.1e-08 nfin=3 $X=0.125 $Y=0.027
M2 N_M2_d N_M2_g noxref_7 VSS nmos_rvt L=2e-08 W=8.1e-08 nfin=3 $X=0.179
+ $Y=0.027
M3 N_M3_d N_M3_g noxref_7 VSS nmos_rvt L=2e-08 W=8.1e-08 nfin=3 $X=0.233
+ $Y=0.027
M4 noxref_7 N_M4_g VSS VSS nmos_rvt L=2e-08 W=8.1e-08 nfin=3 $X=0.395 $Y=0.027
M5 noxref_7 N_M5_g VSS VSS nmos_rvt L=2e-08 W=8.1e-08 nfin=3 $X=0.449 $Y=0.027
M6 noxref_7 N_M6_g VSS VSS nmos_rvt L=2e-08 W=8.1e-08 nfin=3 $X=0.503 $Y=0.027
M7 noxref_7 N_M7_g VSS VSS nmos_rvt L=2e-08 W=8.1e-08 nfin=3 $X=0.557 $Y=0.027
M8 noxref_8 N_M8_g VDD VDD pmos_rvt L=2e-08 W=8.1e-08 nfin=3 $X=0.071 $Y=0.162
M9 noxref_8 N_M9_g VDD VDD pmos_rvt L=2e-08 W=8.1e-08 nfin=3 $X=0.125 $Y=0.162
M10 N_M10_d N_M10_g VDD VDD pmos_rvt L=2e-08 W=5.4e-08 nfin=2 $X=0.179 $Y=0.189
M11 noxref_8 N_M11_g noxref_10 VDD pmos_rvt L=2e-08 W=8.1e-08 nfin=3 $X=0.395
+ $Y=0.162
M12 noxref_8 N_M12_g noxref_10 VDD pmos_rvt L=2e-08 W=8.1e-08 nfin=3 $X=0.449
+ $Y=0.162
M13 N_M13_d N_M13_g noxref_10 VDD pmos_rvt L=2e-08 W=8.1e-08 nfin=3 $X=0.503
+ $Y=0.162
M14 N_M14_d N_M14_g noxref_10 VDD pmos_rvt L=2e-08 W=8.1e-08 nfin=3 $X=0.557
+ $Y=0.162

* .include "OAI31xp67_ASAP7_75t_R.pex.sp.pxi"

* Start of included file OAI31xp67_ASAP7_75t_R.pex.sp.pxi
x_PM_OAI31xp67_ASAP7_75t_R%A3 vss A3 N_M0_g N_M8_g N_M1_g N_M9_g N_A3_4
+ PM_OAI31xp67_ASAP7_75t_R%A3
x_PM_OAI31xp67_ASAP7_75t_R%A1 vss A1 N_M6_g N_M13_g N_M7_g N_M14_g N_A1_3
+ N_A1_4 N_A1_7 N_A1_6 N_A1_1 PM_OAI31xp67_ASAP7_75t_R%A1
cc_1 N_A1_3 N_A2_4 0.00481519f $X=0.513 $Y=0.0245
x_PM_OAI31xp67_ASAP7_75t_R%Y vss Y N_M2_d N_M3_d N_M10_d N_M13_d N_M14_d N_Y_16
+ N_Y_17 N_Y_1 N_Y_14 N_Y_13 N_Y_2 N_Y_18 N_Y_19 N_Y_20 N_Y_3 N_Y_4 N_Y_15
+ PM_OAI31xp67_ASAP7_75t_R%Y
cc_2 N_Y_16 N_B_4 0.000535363f $X=0.2025 $Y=0.072
cc_3 N_Y_17 N_B_4 0.000593803f $X=0.243 $Y=0.198
cc_4 N_Y_1 N_B_4 0.00228989f $X=0.216 $Y=0.0675
cc_5 N_Y_14 N_B_3 0.00854907f $X=0.2015 $Y=0.216
cc_6 N_Y_13 N_B_3 0.0518098f $X=0.2015 $Y=0.0675
cc_7 N_Y_2 N_B_3 0.000914182f $X=0.216 $Y=0.216
cc_8 N_Y_18 N_B_8 0.00324842f $X=0.243 $Y=0.1035
cc_9 N_Y_13 N_B_1 0.00373246f $X=0.2015 $Y=0.0675
cc_10 N_Y_14 N_B_4 0.0145276f $X=0.2015 $Y=0.216
cc_11 N_Y_13 N_B_4 0.0444872f $X=0.2015 $Y=0.0675
cc_12 N_Y_18 N_A2_7 0.00131365f $X=0.243 $Y=0.1035
cc_13 N_Y_18 N_A2_5 0.00233774f $X=0.243 $Y=0.1035
cc_14 N_Y_19 N_A2_7 0.00571746f $X=0.27 $Y=0.072
cc_15 N_Y_20 N_A1_4 0.000756838f $X=0.6235 $Y=0.234
cc_16 N_Y_3 N_A1_4 0.00159826f $X=0.54 $Y=0.2025
cc_17 N_Y_4 N_A1_7 0.00165183f $X=0.648 $Y=0.072
cc_18 N_Y_4 N_A1_6 0.00235262f $X=0.648 $Y=0.072
cc_19 N_Y_19 N_A1_1 0.00235598f $X=0.27 $Y=0.072
cc_20 N_Y_15 N_A1_1 0.00272647f $X=0.5255 $Y=0.2025
cc_21 N_Y_19 N_A1_6 0.00288789f $X=0.27 $Y=0.072
cc_22 N_Y_15 N_A1_3 0.0369804f $X=0.5255 $Y=0.2025
cc_23 N_Y_15 N_A1_4 0.0312504f $X=0.5255 $Y=0.2025
x_PM_OAI31xp67_ASAP7_75t_R%A2 vss A2 N_M4_g N_M11_g N_M5_g N_M12_g N_A2_4
+ N_A2_7 N_A2_5 PM_OAI31xp67_ASAP7_75t_R%A2
x_PM_OAI31xp67_ASAP7_75t_R%B vss B N_M2_g N_M10_g N_M3_g N_B_5 N_B_3 N_B_4
+ N_B_8 N_B_1 PM_OAI31xp67_ASAP7_75t_R%B
cc_24 N_B_5 N_A3_4 0.00271342f $X=0.135 $Y=0.135
cc_25 N_B_3 N_A3_4 0.00634839f $X=0.189 $Y=0.0245

* End of included file OAI31xp67_ASAP7_75t_R.pex.sp.pxi
.ends

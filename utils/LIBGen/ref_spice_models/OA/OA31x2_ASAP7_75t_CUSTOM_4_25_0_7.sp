.subckt PM_OA31x2_ASAP7_75t_R%A2 vss 34 9 15 25 5 7 3 4
c1 1 vss 0.0155554f $X=0.243 $Y=0.135
c2 3 vss 0.124302f $X=0.189 $Y=0.135
c3 4 vss 0.12815f $X=0.243 $Y=0.0245
c4 5 vss 0.00152023f $X=0.135 $Y=0.135
c5 6 vss 0.00655684f $X=0.135 $Y=0.198
c6 7 vss 0.00260552f $X=0.135 $Y=0.154
c7 8 vss 0.0032032f $X=0.1715 $Y=0.135
r1 6 35 1.09329 $w=1.76154e-08 $l=9.8e-09 $layer=M1 $thickness=3.6e-08 $X=0.135
+ $Y=0.198 $X2=0.135 $Y2=0.1882
r2 34 35 0.291487 $w=1.3e-08 $l=1.2e-09 $layer=M1 $thickness=3.6e-08 $X=0.135
+ $Y=0.187 $X2=0.135 $Y2=0.1882
r3 34 33 2.73998 $w=1.3e-08 $l=1.18e-08 $layer=M1 $thickness=3.6e-08 $X=0.135
+ $Y=0.187 $X2=0.135 $Y2=0.1752
r4 7 33 4.95528 $w=1.3e-08 $l=2.12e-08 $layer=M1 $thickness=3.6e-08 $X=0.135
+ $Y=0.154 $X2=0.135 $Y2=0.1752
r5 5 29 3.1337 $w=1.54324e-08 $l=1.85e-08 $layer=M1 $thickness=3.6e-08 $X=0.135
+ $Y=0.135 $X2=0.1535 $Y2=0.135
r6 5 7 3.2503 $w=1.53684e-08 $l=1.9e-08 $layer=M1 $thickness=3.6e-08 $X=0.135
+ $Y=0.135 $X2=0.135 $Y2=0.154
r7 8 27 4.08082 $w=1.3e-08 $l=1.75e-08 $layer=M1 $thickness=3.6e-08 $X=0.1715
+ $Y=0.135 $X2=0.189 $Y2=0.135
r8 8 29 4.19742 $w=1.3e-08 $l=1.8e-08 $layer=M1 $thickness=3.6e-08 $X=0.1715
+ $Y=0.135 $X2=0.1535 $Y2=0.135
r9 25 24 16.4967 $w=2.1e-08 $l=4.85e-08 $layer=Gate_1 $thickness=5.6e-08
+ $X=0.189 $Y=0.2025 $X2=0.189 $Y2=0.154
r10 3 19 6.27904 $w=2.09e-08 $layer=Gate_1 $thickness=5.24e-08 $X=0.189
+ $Y=0.135 $X2=0.189 $Y2=0.135
r11 3 24 6.6497 $w=2.04211e-08 $l=1.9e-08 $layer=Gate_1 $thickness=5.6e-08
+ $X=0.189 $Y=0.135 $X2=0.189 $Y2=0.154
r12 19 20 2.48102 $w=2.2e-08 $l=9.5e-09 $layer=LIG $thickness=4.8e-08 $X=0.189
+ $Y=0.135 $X2=0.1985 $Y2=0.135
r13 19 27 19.3796 $a=3.24e-16 $layer=V0LIG $X=0.189 $Y=0.135 $X2=0.189 $Y2=0.135
r14 17 20 10.1729 $w=1.54914e-08 $l=1.75e-08 $layer=LIG $thickness=4.8e-08
+ $X=0.216 $Y=0.135 $X2=0.1985 $Y2=0.135
r15 1 12 6.54019 $w=2.09524e-08 $layer=Gate_1 $thickness=5.21905e-08 $X=0.243
+ $Y=0.135 $X2=0.243 $Y2=0.135
r16 1 17 12.6539 $w=1.77815e-08 $l=2.7e-08 $layer=LIG $thickness=4.8e-08
+ $X=0.243 $Y=0.135 $X2=0.216 $Y2=0.135
r17 15 14 14.6259 $w=2.1e-08 $l=4.3e-08 $layer=Gate_1 $thickness=5.6e-08
+ $X=0.243 $Y=0.2025 $X2=0.243 $Y2=0.1595
r18 13 14 2.7211 $w=2.1e-08 $l=8e-09 $layer=Gate_1 $thickness=5.6e-08 $X=0.243
+ $Y=0.1515 $X2=0.243 $Y2=0.1595
r19 12 13 5.79936 $w=2.03333e-08 $l=1.65e-08 $layer=Gate_1 $thickness=5.6e-08
+ $X=0.243 $Y=0.135 $X2=0.243 $Y2=0.1515
r20 11 12 5.79936 $w=2.03333e-08 $l=1.65e-08 $layer=Gate_1 $thickness=5.6e-08
+ $X=0.243 $Y=0.1185 $X2=0.243 $Y2=0.135
r21 10 11 2.7211 $w=2.1e-08 $l=8e-09 $layer=Gate_1 $thickness=5.6e-08 $X=0.243
+ $Y=0.1105 $X2=0.243 $Y2=0.1185
r22 9 10 14.6259 $w=2.1e-08 $l=4.3e-08 $layer=Gate_1 $thickness=5.6e-08
+ $X=0.243 $Y=0.0675 $X2=0.243 $Y2=0.1105
r23 9 4 14.6259 $w=2.1e-08 $l=4.3e-08 $layer=Gate_1 $thickness=5.6e-08 $X=0.243
+ $Y=0.0675 $X2=0.243 $Y2=0.0245
.ends

.subckt PM_OA31x2_ASAP7_75t_R%A3 vss 33 13 24 27 4 1 6 3 5 8 7
c1 1 vss 0.0103073f $X=0.3955 $Y=0.135
c2 3 vss 0.0717968f $X=0.405 $Y=0.0675
c3 4 vss 0.0868451f $X=0.459 $Y=0.135
c4 5 vss 0.00695394f $X=0.3462 $Y=0.072
c5 6 vss 0.00509406f $X=0.351 $Y=0.135
c6 7 vss 0.00365402f $X=0.351 $Y=0.116
c7 8 vss 0.00464574f $X=0.3825 $Y=0.135
r1 33 5 0.484711 $w=1.8e-08 $l=4.8e-09 $layer=M1 $thickness=3.6e-08 $X=0.351
+ $Y=0.08 $X2=0.3462 $Y2=0.072
r2 33 32 2.14973 $w=1.32632e-08 $l=1.8e-08 $layer=M1 $thickness=3.6e-08
+ $X=0.351 $Y=0.08 $X2=0.351 $Y2=0.09
r3 31 32 2.91487 $w=1.3e-08 $l=1.25e-08 $layer=M1 $thickness=3.6e-08 $X=0.351
+ $Y=0.1025 $X2=0.351 $Y2=0.09
r4 7 31 3.14806 $w=1.3e-08 $l=1.35e-08 $layer=M1 $thickness=3.6e-08 $X=0.351
+ $Y=0.116 $X2=0.351 $Y2=0.1025
r5 6 22 1.96775 $w=1.63333e-08 $l=1.35e-08 $layer=M1 $thickness=3.6e-08
+ $X=0.351 $Y=0.135 $X2=0.3645 $Y2=0.135
r6 6 7 3.2503 $w=1.53684e-08 $l=1.9e-08 $layer=M1 $thickness=3.6e-08 $X=0.351
+ $Y=0.135 $X2=0.351 $Y2=0.116
r7 27 26 16.4967 $w=2.1e-08 $l=4.85e-08 $layer=Gate_1 $thickness=5.6e-08
+ $X=0.459 $Y=0.2025 $X2=0.459 $Y2=0.154
r8 24 25 16.4967 $w=2.1e-08 $l=4.85e-08 $layer=Gate_1 $thickness=5.6e-08
+ $X=0.459 $Y=0.0675 $X2=0.459 $Y2=0.116
r9 4 19 6.54019 $w=2.09524e-08 $layer=Gate_1 $thickness=5.21905e-08 $X=0.459
+ $Y=0.135 $X2=0.459 $Y2=0.135
r10 4 25 6.6497 $w=2.04211e-08 $l=1.9e-08 $layer=Gate_1 $thickness=5.6e-08
+ $X=0.459 $Y=0.135 $X2=0.459 $Y2=0.116
r11 4 26 6.6497 $w=2.04211e-08 $l=1.9e-08 $layer=Gate_1 $thickness=5.6e-08
+ $X=0.459 $Y=0.135 $X2=0.459 $Y2=0.154
r12 8 21 5.24677 $w=1.3e-08 $l=2.25e-08 $layer=M1 $thickness=3.6e-08 $X=0.3825
+ $Y=0.135 $X2=0.405 $Y2=0.135
r13 8 22 4.19742 $w=1.3e-08 $l=1.8e-08 $layer=M1 $thickness=3.6e-08 $X=0.3825
+ $Y=0.135 $X2=0.3645 $Y2=0.135
r14 18 19 12.6539 $w=1.77815e-08 $l=2.7e-08 $layer=LIG $thickness=4.8e-08
+ $X=0.432 $Y=0.135 $X2=0.459 $Y2=0.135
r15 16 18 10.1729 $w=1.54914e-08 $l=1.75e-08 $layer=LIG $thickness=4.8e-08
+ $X=0.4145 $Y=0.135 $X2=0.432 $Y2=0.135
r16 15 16 2.48102 $w=2.2e-08 $l=9.5e-09 $layer=LIG $thickness=4.8e-08 $X=0.405
+ $Y=0.135 $X2=0.4145 $Y2=0.135
r17 15 21 19.3796 $a=3.24e-16 $layer=V0LIG $X=0.405 $Y=0.135 $X2=0.405 $Y2=0.135
r18 1 15 2.48102 $w=2.2e-08 $l=9.5e-09 $layer=LIG $thickness=4.8e-08 $X=0.3955
+ $Y=0.135 $X2=0.405 $Y2=0.135
r19 13 12 14.6259 $w=2.1e-08 $l=4.3e-08 $layer=Gate_1 $thickness=5.6e-08
+ $X=0.405 $Y=0.2025 $X2=0.405 $Y2=0.1595
r20 11 12 2.7211 $w=2.1e-08 $l=8e-09 $layer=Gate_1 $thickness=5.6e-08 $X=0.405
+ $Y=0.1515 $X2=0.405 $Y2=0.1595
r21 10 11 5.79936 $w=2.03333e-08 $l=1.65e-08 $layer=Gate_1 $thickness=5.6e-08
+ $X=0.405 $Y=0.135 $X2=0.405 $Y2=0.1515
r22 10 16 4.05918 $w=2.0087e-08 $l=9.5e-09 $layer=Gate_1 $thickness=5.56522e-08
+ $X=0.405 $Y=0.135 $X2=0.4145 $Y2=0.135
r23 10 15 6.27904 $w=2.09e-08 $layer=Gate_1 $thickness=5.24e-08 $X=0.405
+ $Y=0.135 $X2=0.405 $Y2=0.135
r24 9 10 5.79936 $w=2.03333e-08 $l=1.65e-08 $layer=Gate_1 $thickness=5.6e-08
+ $X=0.405 $Y=0.1185 $X2=0.405 $Y2=0.135
r25 3 9 17.347 $w=2.1e-08 $l=5.1e-08 $layer=Gate_1 $thickness=5.6e-08 $X=0.405
+ $Y=0.0675 $X2=0.405 $Y2=0.1185
.ends

.subckt PM_OA31x2_ASAP7_75t_R%A1 vss 24 8 14 28 1 7 4 3 5
c1 1 vss 0.0155129f $X=0.0715 $Y=0.135
c2 3 vss 0.123953f $X=0.081 $Y=0.0245
c3 4 vss 0.123563f $X=0.135 $Y=0.135
c4 5 vss 0.00250599f $X=0.081 $Y=0.108
c5 6 vss 0.00714543f $X=0.081 $Y=0.198
c6 7 vss 0.00357454f $X=0.081 $Y=0.1215
r1 6 25 5.17411 $w=1.46514e-08 $l=2.73e-08 $layer=M1 $thickness=3.6e-08
+ $X=0.081 $Y=0.198 $X2=0.081 $Y2=0.1707
r2 5 7 1.96775 $w=1.63333e-08 $l=1.35e-08 $layer=M1 $thickness=3.6e-08 $X=0.081
+ $Y=0.108 $X2=0.081 $Y2=0.1215
r3 28 27 16.4967 $w=2.1e-08 $l=4.85e-08 $layer=Gate_1 $thickness=5.6e-08
+ $X=0.135 $Y=0.2025 $X2=0.135 $Y2=0.154
r4 4 20 6.54019 $w=2.09524e-08 $layer=Gate_1 $thickness=5.21905e-08 $X=0.135
+ $Y=0.135 $X2=0.135 $Y2=0.135
r5 4 27 6.6497 $w=2.04211e-08 $l=1.9e-08 $layer=Gate_1 $thickness=5.6e-08
+ $X=0.135 $Y=0.135 $X2=0.135 $Y2=0.154
r6 24 25 4.37231 $w=1.3e-08 $l=1.87e-08 $layer=M1 $thickness=3.6e-08 $X=0.083
+ $Y=0.152 $X2=0.081 $Y2=0.1707
r7 24 23 0.991057 $w=1.3e-08 $l=4.3e-09 $layer=M1 $thickness=3.6e-08 $X=0.083
+ $Y=0.152 $X2=0.081 $Y2=0.1477
r8 22 23 2.97317 $w=1.3e-08 $l=1.27e-08 $layer=M1 $thickness=3.6e-08 $X=0.081
+ $Y=0.135 $X2=0.081 $Y2=0.1477
r9 7 22 3.14806 $w=1.3e-08 $l=1.35e-08 $layer=M1 $thickness=3.6e-08 $X=0.081
+ $Y=0.1215 $X2=0.081 $Y2=0.135
r10 19 20 12.6539 $w=1.77815e-08 $l=2.7e-08 $layer=LIG $thickness=4.8e-08
+ $X=0.108 $Y=0.135 $X2=0.135 $Y2=0.135
r11 17 19 10.1729 $w=1.54914e-08 $l=1.75e-08 $layer=LIG $thickness=4.8e-08
+ $X=0.0905 $Y=0.135 $X2=0.108 $Y2=0.135
r12 16 17 2.48102 $w=2.2e-08 $l=9.5e-09 $layer=LIG $thickness=4.8e-08 $X=0.081
+ $Y=0.135 $X2=0.0905 $Y2=0.135
r13 16 22 19.3796 $a=3.24e-16 $layer=V0LIG $X=0.081 $Y=0.135 $X2=0.081 $Y2=0.135
r14 1 16 2.48102 $w=2.2e-08 $l=9.5e-09 $layer=LIG $thickness=4.8e-08 $X=0.0715
+ $Y=0.135 $X2=0.081 $Y2=0.135
r15 14 13 14.6259 $w=2.1e-08 $l=4.3e-08 $layer=Gate_1 $thickness=5.6e-08
+ $X=0.081 $Y=0.2025 $X2=0.081 $Y2=0.1595
r16 12 13 2.7211 $w=2.1e-08 $l=8e-09 $layer=Gate_1 $thickness=5.6e-08 $X=0.081
+ $Y=0.1515 $X2=0.081 $Y2=0.1595
r17 11 12 5.79936 $w=2.03333e-08 $l=1.65e-08 $layer=Gate_1 $thickness=5.6e-08
+ $X=0.081 $Y=0.135 $X2=0.081 $Y2=0.1515
r18 11 17 4.05918 $w=2.0087e-08 $l=9.5e-09 $layer=Gate_1 $thickness=5.56522e-08
+ $X=0.081 $Y=0.135 $X2=0.0905 $Y2=0.135
r19 11 16 6.27904 $w=2.09e-08 $layer=Gate_1 $thickness=5.24e-08 $X=0.081
+ $Y=0.135 $X2=0.081 $Y2=0.135
r20 10 11 5.79936 $w=2.03333e-08 $l=1.65e-08 $layer=Gate_1 $thickness=5.6e-08
+ $X=0.081 $Y=0.1185 $X2=0.081 $Y2=0.135
r21 9 10 2.7211 $w=2.1e-08 $l=8e-09 $layer=Gate_1 $thickness=5.6e-08 $X=0.081
+ $Y=0.1105 $X2=0.081 $Y2=0.1185
r22 8 9 14.6259 $w=2.1e-08 $l=4.3e-08 $layer=Gate_1 $thickness=5.6e-08 $X=0.081
+ $Y=0.0675 $X2=0.081 $Y2=0.1105
r23 8 3 14.6259 $w=2.1e-08 $l=4.3e-08 $layer=Gate_1 $thickness=5.6e-08 $X=0.081
+ $Y=0.0675 $X2=0.081 $Y2=0.0245
.ends

.subckt PM_OA31x2_ASAP7_75t_R%7 vss 39 45 56 60 81 83 86 91 95 107 5 33 23 3 24
+ 28 6 9 7 27 8 10 35 34 4 25 26 29 36 37 31 22 1 38 21
c1 1 vss 0.0127062f $X=0.666 $Y=0.135
c2 3 vss 0.00133837f $X=0.27 $Y=0.096
c3 4 vss 0.000902479f $X=0.432 $Y=0.096
c4 5 vss 0.00891856f $X=0.054 $Y=0.0675
c5 6 vss 0.00773109f $X=0.27 $Y=0.0555
c6 7 vss 0.00986939f $X=0.405 $Y=0.096
c7 8 vss 0.00994315f $X=0.378 $Y=0.2025
c8 9 vss 0.00727464f $X=0.432 $Y=0.0555
c9 10 vss 0.00811387f $X=0.486 $Y=0.1755
c10 21 vss 0.0803925f $X=0.675 $Y=0.0245
c11 22 vss 0.0812204f $X=0.729 $Y=0.135
c12 23 vss 0.038331f $X=0.056 $Y=0.0675
c13 24 vss 0.0378578f $X=0.2555 $Y=0.0675
c14 25 vss 0.00372432f $X=0.434 $Y=0.0675
c15 26 vss 0.00396377f $X=0.4715 $Y=0.1975
c16 27 vss 0.0381666f $X=0.38 $Y=0.2025
c17 28 vss 0.00013036f $X=0.4715 $Y=0.1755
c18 29 vss 0.000543636f $X=0.4715 $Y=0.2245
c19 30 vss 0.00213481f $X=0.567 $Y=0.072
c20 31 vss 0.000312538f $X=0.567 $Y=0.135
c21 32 vss 0.00205716f $X=0.567 $Y=0.198
c22 33 vss 0.0221032f $X=0.232 $Y=0.072
c23 34 vss 0.0131806f $X=0.54 $Y=0.198
c24 35 vss 0.0124177f $X=0.54 $Y=0.072
c25 36 vss 0.00179248f $X=0.567 $Y=0.116
c26 37 vss 0.00153083f $X=0.567 $Y=0.1485
c27 38 vss 0.00419125f $X=0.6125 $Y=0.135
r1 107 106 0.0308642 $w=8.1e-08 $l=2.5e-09 $layer=N_src_drn $thickness=1e-09
+ $X=0.0713 $Y=0.0675 $X2=0.0685 $Y2=0.0675
r2 23 106 0.154321 $w=8.1e-08 $l=1.25e-08 $layer=N_src_drn $thickness=1e-09
+ $X=0.056 $Y=0.0675 $X2=0.0685 $Y2=0.0675
r3 5 102 19.3796 $a=3.24e-16 $layer=V0LISD $X=0.054 $Y=0.0675 $X2=0.058
+ $Y2=0.072
r4 102 103 4.31401 $w=1.3e-08 $l=1.85e-08 $layer=M1 $thickness=3.6e-08 $X=0.058
+ $Y=0.072 $X2=0.0765 $Y2=0.072
r5 101 103 3.61444 $w=1.3e-08 $l=1.55e-08 $layer=M1 $thickness=3.6e-08 $X=0.092
+ $Y=0.072 $X2=0.0765 $Y2=0.072
r6 100 101 4.19742 $w=1.3e-08 $l=1.8e-08 $layer=M1 $thickness=3.6e-08 $X=0.11
+ $Y=0.072 $X2=0.092 $Y2=0.072
r7 99 100 5.82974 $w=1.3e-08 $l=2.5e-08 $layer=M1 $thickness=3.6e-08 $X=0.135
+ $Y=0.072 $X2=0.11 $Y2=0.072
r8 98 99 8.97781 $w=1.3e-08 $l=3.85e-08 $layer=M1 $thickness=3.6e-08 $X=0.1735
+ $Y=0.072 $X2=0.135 $Y2=0.072
r9 33 96 8.86121 $w=1.3e-08 $l=3.8e-08 $layer=M1 $thickness=3.6e-08 $X=0.232
+ $Y=0.072 $X2=0.27 $Y2=0.072
r10 33 98 13.6416 $w=1.3e-08 $l=5.85e-08 $layer=M1 $thickness=3.6e-08 $X=0.232
+ $Y=0.072 $X2=0.1735 $Y2=0.072
r11 24 6 0.154321 $w=8.1e-08 $l=1.25e-08 $layer=N_src_drn $thickness=1e-09
+ $X=0.2555 $Y=0.0675 $X2=0.27 $Y2=0.0555
r12 95 24 0.0308642 $w=8.1e-08 $l=2.5e-09 $layer=N_src_drn $thickness=1e-09
+ $X=0.2526 $Y=0.0675 $X2=0.2555 $Y2=0.0675
r13 6 96 19.3796 $a=3.24e-16 $layer=V0LISD $X=0.27 $Y=0.0555 $X2=0.27 $Y2=0.072
r14 3 93 30.0784 $w=2.10444e-08 $l=5.4e-08 $layer=LISD $thickness=2.7e-08
+ $X=0.27 $Y=0.096 $X2=0.324 $Y2=0.096
r15 3 6 22.1214 $w=2.13259e-08 $l=4.05e-08 $layer=LISD $thickness=2.7e-08
+ $X=0.27 $Y=0.096 $X2=0.27 $Y2=0.0555
r16 92 93 31.8278 $w=2.02e-08 $l=5.4e-08 $layer=LISD $thickness=2.7e-08
+ $X=0.378 $Y=0.096 $X2=0.324 $Y2=0.096
r17 7 92 15.9139 $w=2.02e-08 $l=2.7e-08 $layer=LISD $thickness=2.7e-08 $X=0.405
+ $Y=0.096 $X2=0.378 $Y2=0.096
r18 91 90 0.0308642 $w=8.1e-08 $l=2.5e-09 $layer=P_src_drn $thickness=1e-09
+ $X=0.3953 $Y=0.2025 $X2=0.3925 $Y2=0.2025
r19 27 90 0.154321 $w=8.1e-08 $l=1.25e-08 $layer=P_src_drn $thickness=1e-09
+ $X=0.38 $Y=0.2025 $X2=0.3925 $Y2=0.2025
r20 29 79 0.391892 $w=3.7e-08 $l=1.45e-08 $layer=P_src_drn $thickness=1e-09
+ $X=0.4715 $Y=0.2245 $X2=0.486 $Y2=0.216
r21 28 79 0.462963 $w=2.7e-08 $l=1.25e-08 $layer=P_src_drn $thickness=1e-09
+ $X=0.4715 $Y=0.1755 $X2=0.486 $Y2=0.216
r22 86 85 0.147059 $w=1.7e-08 $l=2.5e-09 $layer=P_src_drn $thickness=1e-09
+ $X=0.5033 $Y=0.216 $X2=0.5005 $Y2=0.1975
r23 84 85 0.264706 $w=1.7e-08 $l=4.5e-09 $layer=P_src_drn $thickness=1e-09
+ $X=0.496 $Y=0.1975 $X2=0.5005 $Y2=0.1975
r24 79 84 0.705882 $w=1.7e-08 $l=1.2e-08 $layer=P_src_drn $thickness=1e-09
+ $X=0.486 $Y=0.216 $X2=0.496 $Y2=0.1975
r25 26 79 0.735294 $w=1.7e-08 $l=1.25e-08 $layer=P_src_drn $thickness=1e-09
+ $X=0.4715 $Y=0.1975 $X2=0.486 $Y2=0.216
r26 83 26 0.147059 $w=1.7e-08 $l=2.5e-09 $layer=P_src_drn $thickness=1e-09
+ $X=0.4686 $Y=0.2025 $X2=0.4715 $Y2=0.1975
r27 81 80 0.0308642 $w=8.1e-08 $l=2.5e-09 $layer=N_src_drn $thickness=1e-09
+ $X=0.4493 $Y=0.0675 $X2=0.4465 $Y2=0.0675
r28 25 80 0.154321 $w=8.1e-08 $l=1.25e-08 $layer=N_src_drn $thickness=1e-09
+ $X=0.434 $Y=0.0675 $X2=0.4465 $Y2=0.0675
r29 4 9 22.1214 $w=2.13259e-08 $l=4.05e-08 $layer=LISD $thickness=2.7e-08
+ $X=0.432 $Y=0.096 $X2=0.432 $Y2=0.0555
r30 4 7 14.1645 $w=2.18889e-08 $l=2.7e-08 $layer=LISD $thickness=2.7e-08
+ $X=0.432 $Y=0.096 $X2=0.405 $Y2=0.096
r31 8 77 19.3796 $a=3.24e-16 $layer=V0LISD $X=0.378 $Y=0.2025 $X2=0.378
+ $Y2=0.198
r32 10 79 23.8708 $w=2.02e-08 $l=4.05e-08 $layer=LISD $thickness=2.7e-08
+ $X=0.486 $Y=0.1755 $X2=0.486 $Y2=0.216
r33 9 69 19.3796 $a=3.24e-16 $layer=V0LISD $X=0.432 $Y=0.0555 $X2=0.432
+ $Y2=0.072
r34 77 78 5.24677 $w=1.3e-08 $l=2.25e-08 $layer=M1 $thickness=3.6e-08 $X=0.378
+ $Y=0.198 $X2=0.4005 $Y2=0.198
r35 76 78 3.61444 $w=1.3e-08 $l=1.55e-08 $layer=M1 $thickness=3.6e-08 $X=0.416
+ $Y=0.198 $X2=0.4005 $Y2=0.198
r36 75 76 3.73104 $w=1.3e-08 $l=1.6e-08 $layer=M1 $thickness=3.6e-08 $X=0.432
+ $Y=0.198 $X2=0.416 $Y2=0.198
r37 73 74 4.5472 $w=1.3e-08 $l=1.95e-08 $layer=M1 $thickness=3.6e-08 $X=0.4615
+ $Y=0.198 $X2=0.481 $Y2=0.198
r38 73 75 6.8791 $w=1.3e-08 $l=2.95e-08 $layer=M1 $thickness=3.6e-08 $X=0.4615
+ $Y=0.198 $X2=0.432 $Y2=0.198
r39 71 72 4.31401 $w=1.3e-08 $l=1.85e-08 $layer=M1 $thickness=3.6e-08 $X=0.49
+ $Y=0.198 $X2=0.5085 $Y2=0.198
r40 71 74 2.09871 $w=1.3e-08 $l=9e-09 $layer=M1 $thickness=3.6e-08 $X=0.49
+ $Y=0.198 $X2=0.481 $Y2=0.198
r41 71 79 19.3796 $a=3.24e-16 $layer=V0LISD $X=0.49 $Y=0.198 $X2=0.486 $Y2=0.216
r42 34 72 7.34548 $w=1.3e-08 $l=3.15e-08 $layer=M1 $thickness=3.6e-08 $X=0.54
+ $Y=0.198 $X2=0.5085 $Y2=0.198
r43 69 70 7.22888 $w=1.3e-08 $l=3.1e-08 $layer=M1 $thickness=3.6e-08 $X=0.432
+ $Y=0.072 $X2=0.463 $Y2=0.072
r44 67 70 6.8791 $w=1.3e-08 $l=2.95e-08 $layer=M1 $thickness=3.6e-08 $X=0.4925
+ $Y=0.072 $X2=0.463 $Y2=0.072
r45 66 67 2.2153 $w=1.3e-08 $l=9.5e-09 $layer=M1 $thickness=3.6e-08 $X=0.502
+ $Y=0.072 $X2=0.4925 $Y2=0.072
r46 65 66 2.56509 $w=1.3e-08 $l=1.1e-08 $layer=M1 $thickness=3.6e-08 $X=0.513
+ $Y=0.072 $X2=0.502 $Y2=0.072
r47 35 65 6.29612 $w=1.3e-08 $l=2.7e-08 $layer=M1 $thickness=3.6e-08 $X=0.54
+ $Y=0.072 $X2=0.513 $Y2=0.072
r48 32 64 2.5483 $w=1.79e-08 $l=1.8e-08 $layer=M1 $thickness=3.6e-08 $X=0.567
+ $Y=0.198 $X2=0.567 $Y2=0.18
r49 32 34 4.64701 $w=1.46667e-08 $l=2.7e-08 $layer=M1 $thickness=3.6e-08
+ $X=0.567 $Y=0.198 $X2=0.54 $Y2=0.198
r50 30 62 3.36447 $w=1.71023e-08 $l=2.15e-08 $layer=M1 $thickness=3.6e-08
+ $X=0.567 $Y=0.072 $X2=0.567 $Y2=0.0935
r51 30 35 4.64701 $w=1.46667e-08 $l=2.7e-08 $layer=M1 $thickness=3.6e-08
+ $X=0.567 $Y=0.072 $X2=0.54 $Y2=0.072
r52 63 64 4.19742 $w=1.3e-08 $l=1.8e-08 $layer=M1 $thickness=3.6e-08 $X=0.567
+ $Y=0.162 $X2=0.567 $Y2=0.18
r53 37 63 3.14806 $w=1.3e-08 $l=1.35e-08 $layer=M1 $thickness=3.6e-08 $X=0.567
+ $Y=0.1485 $X2=0.567 $Y2=0.162
r54 36 62 5.24677 $w=1.3e-08 $l=2.25e-08 $layer=M1 $thickness=3.6e-08 $X=0.567
+ $Y=0.116 $X2=0.567 $Y2=0.0935
r55 31 38 9.42983 $w=1.3989e-08 $l=4.55e-08 $layer=M1 $thickness=3.6e-08
+ $X=0.567 $Y=0.135 $X2=0.6125 $Y2=0.135
r56 31 36 3.2503 $w=1.53684e-08 $l=1.9e-08 $layer=M1 $thickness=3.6e-08
+ $X=0.567 $Y=0.135 $X2=0.567 $Y2=0.116
r57 31 37 1.96775 $w=1.63333e-08 $l=1.35e-08 $layer=M1 $thickness=3.6e-08
+ $X=0.567 $Y=0.135 $X2=0.567 $Y2=0.1485
r58 60 59 14.6259 $w=2.1e-08 $l=4.3e-08 $layer=Gate_1 $thickness=5.6e-08
+ $X=0.729 $Y=0.2025 $X2=0.729 $Y2=0.1595
r59 58 59 2.7211 $w=2.1e-08 $l=8e-09 $layer=Gate_1 $thickness=5.6e-08 $X=0.729
+ $Y=0.1515 $X2=0.729 $Y2=0.1595
r60 56 57 14.6259 $w=2.1e-08 $l=4.3e-08 $layer=Gate_1 $thickness=5.6e-08
+ $X=0.729 $Y=0.0675 $X2=0.729 $Y2=0.1105
r61 54 57 2.7211 $w=2.1e-08 $l=8e-09 $layer=Gate_1 $thickness=5.6e-08 $X=0.729
+ $Y=0.1185 $X2=0.729 $Y2=0.1105
r62 22 51 6.54019 $w=2.09524e-08 $layer=Gate_1 $thickness=5.21905e-08 $X=0.729
+ $Y=0.135 $X2=0.729 $Y2=0.135
r63 22 54 5.79936 $w=2.03333e-08 $l=1.65e-08 $layer=Gate_1 $thickness=5.6e-08
+ $X=0.729 $Y=0.135 $X2=0.729 $Y2=0.1185
r64 22 58 5.79936 $w=2.03333e-08 $l=1.65e-08 $layer=Gate_1 $thickness=5.6e-08
+ $X=0.729 $Y=0.135 $X2=0.729 $Y2=0.1515
r65 38 53 10.6101 $w=1.3e-08 $l=4.55e-08 $layer=M1 $thickness=3.6e-08 $X=0.6125
+ $Y=0.135 $X2=0.658 $Y2=0.135
r66 50 51 12.6539 $w=1.77815e-08 $l=2.7e-08 $layer=LIG $thickness=4.8e-08
+ $X=0.702 $Y=0.135 $X2=0.729 $Y2=0.135
r67 49 53 19.3796 $a=3.24e-16 $layer=V0LIG $X=0.657 $Y=0.135 $X2=0.658 $Y2=0.135
r68 47 50 12.3927 $w=1.76192e-08 $l=2.6e-08 $layer=LIG $thickness=4.8e-08
+ $X=0.676 $Y=0.135 $X2=0.702 $Y2=0.135
r69 1 47 2.6116 $w=2.2e-08 $l=1e-08 $layer=LIG $thickness=4.8e-08 $X=0.666
+ $Y=0.135 $X2=0.676 $Y2=0.135
r70 1 49 4.98695 $w=1.60444e-08 $l=9e-09 $layer=LIG $thickness=4.8e-08 $X=0.666
+ $Y=0.135 $X2=0.657 $Y2=0.135
r71 45 44 14.6259 $w=2.1e-08 $l=4.3e-08 $layer=Gate_1 $thickness=5.6e-08
+ $X=0.675 $Y=0.2025 $X2=0.675 $Y2=0.1595
r72 43 44 2.7211 $w=2.1e-08 $l=8e-09 $layer=Gate_1 $thickness=5.6e-08 $X=0.675
+ $Y=0.1515 $X2=0.675 $Y2=0.1595
r73 42 43 5.79936 $w=2.03333e-08 $l=1.65e-08 $layer=Gate_1 $thickness=5.6e-08
+ $X=0.675 $Y=0.135 $X2=0.675 $Y2=0.1515
r74 42 47 6.27904 $w=2.09e-08 $l=1e-09 $layer=Gate_1 $thickness=5.24e-08
+ $X=0.675 $Y=0.135 $X2=0.676 $Y2=0.135
r75 41 42 5.79936 $w=2.03333e-08 $l=1.65e-08 $layer=Gate_1 $thickness=5.6e-08
+ $X=0.675 $Y=0.1185 $X2=0.675 $Y2=0.135
r76 40 41 2.7211 $w=2.1e-08 $l=8e-09 $layer=Gate_1 $thickness=5.6e-08 $X=0.675
+ $Y=0.1105 $X2=0.675 $Y2=0.1185
r77 39 40 14.6259 $w=2.1e-08 $l=4.3e-08 $layer=Gate_1 $thickness=5.6e-08
+ $X=0.675 $Y=0.0675 $X2=0.675 $Y2=0.1105
r78 39 21 14.6259 $w=2.1e-08 $l=4.3e-08 $layer=Gate_1 $thickness=5.6e-08
+ $X=0.675 $Y=0.0675 $X2=0.675 $Y2=0.0245
r79 5 23 1e-05 $l=2e-09 $X=0.054 $Y=0.0675 $X2=0.056 $Y2=0.0675
r80 3 6 1e-05 $l=4.05e-08 $X=0.27 $Y=0.096 $X2=0.27 $Y2=0.0555
r81 4 25 1e-05 $l=2.85701e-08 $X=0.432 $Y=0.096 $X2=0.434 $Y2=0.0675
r82 8 27 1e-05 $l=2e-09 $X=0.378 $Y=0.2025 $X2=0.38 $Y2=0.2025
r83 9 25 1e-05 $l=1.21655e-08 $X=0.432 $Y=0.0555 $X2=0.434 $Y2=0.0675
.ends

.subckt PM_OA31x2_ASAP7_75t_R%B1 vss 5 6 12 3 4
c1 1 vss 0.00539386f $X=0.513 $Y=0.135
c2 3 vss 0.120623f $X=0.513 $Y=0.0245
c3 4 vss 0.00152039f $X=0.513 $Y=0.162
c4 5 vss 0.00252077f $X=0.515 $Y=0.129
r1 4 15 1.96775 $w=1.63333e-08 $l=1.35e-08 $layer=M1 $thickness=3.6e-08
+ $X=0.513 $Y=0.162 $X2=0.513 $Y2=0.1485
r2 5 15 3.14806 $w=1.3e-08 $l=1.35e-08 $layer=M1 $thickness=3.6e-08 $X=0.515
+ $Y=0.129 $X2=0.513 $Y2=0.1485
r3 1 9 10.4265 $w=1.765e-08 $layer=LIG $thickness=5.2e-08 $X=0.513 $Y=0.135
+ $X2=0.513 $Y2=0.135
r4 5 1 19.3796 $a=3.24e-16 $layer=V0LIG $X=0.515 $Y=0.129 $X2=0.513 $Y2=0.135
r5 12 11 14.6259 $w=2.1e-08 $l=4.3e-08 $layer=Gate_1 $thickness=5.6e-08
+ $X=0.513 $Y=0.216 $X2=0.513 $Y2=0.173
r6 10 11 7.31297 $w=2.1e-08 $l=2.15e-08 $layer=Gate_1 $thickness=5.6e-08
+ $X=0.513 $Y=0.1515 $X2=0.513 $Y2=0.173
r7 9 10 5.79936 $w=2.03333e-08 $l=1.65e-08 $layer=Gate_1 $thickness=5.6e-08
+ $X=0.513 $Y=0.135 $X2=0.513 $Y2=0.1515
r8 8 9 5.79936 $w=2.03333e-08 $l=1.65e-08 $layer=Gate_1 $thickness=5.6e-08
+ $X=0.513 $Y=0.1185 $X2=0.513 $Y2=0.135
r9 7 8 2.7211 $w=2.1e-08 $l=8e-09 $layer=Gate_1 $thickness=5.6e-08 $X=0.513
+ $Y=0.1105 $X2=0.513 $Y2=0.1185
r10 6 7 14.6259 $w=2.1e-08 $l=4.3e-08 $layer=Gate_1 $thickness=5.6e-08 $X=0.513
+ $Y=0.0675 $X2=0.513 $Y2=0.1105
r11 6 3 14.6259 $w=2.1e-08 $l=4.3e-08 $layer=Gate_1 $thickness=5.6e-08 $X=0.513
+ $Y=0.0675 $X2=0.513 $Y2=0.0245
.ends

.subckt PM_OA31x2_ASAP7_75t_R%Y vss 20 16 17 28 29 8 7
c1 1 vss 0.00947973f $X=0.702 $Y=0.0675
c2 2 vss 0.00947973f $X=0.702 $Y=0.2025
c3 7 vss 0.00443513f $X=0.6875 $Y=0.0675
c4 8 vss 0.00443436f $X=0.6875 $Y=0.2025
c5 9 vss 0.00291737f $X=0.783 $Y=0.036
c6 10 vss 0.00290963f $X=0.783 $Y=0.234
c7 11 vss 0.00830429f $X=0.702 $Y=0.036
c8 12 vss 0.00827313f $X=0.702 $Y=0.234
c9 13 vss 0.00854906f $X=0.783 $Y=0.054
r1 29 27 0.0308642 $w=8.1e-08 $l=2.5e-09 $layer=P_src_drn $thickness=1e-09
+ $X=0.7193 $Y=0.2025 $X2=0.7165 $Y2=0.2025
r2 2 27 0.179012 $w=8.1e-08 $l=1.45e-08 $layer=P_src_drn $thickness=1e-09
+ $X=0.702 $Y=0.2025 $X2=0.7165 $Y2=0.2025
r3 8 2 0.179012 $w=8.1e-08 $l=1.45e-08 $layer=P_src_drn $thickness=1e-09
+ $X=0.6875 $Y=0.2025 $X2=0.702 $Y2=0.2025
r4 28 8 0.0308642 $w=8.1e-08 $l=2.5e-09 $layer=P_src_drn $thickness=1e-09
+ $X=0.6846 $Y=0.2025 $X2=0.6875 $Y2=0.2025
r5 2 12 19.3796 $a=3.24e-16 $layer=V0LISD $X=0.702 $Y=0.2025 $X2=0.702 $Y2=0.234
r6 12 25 9.44419 $w=1.3e-08 $l=4.05e-08 $layer=M1 $thickness=3.6e-08 $X=0.702
+ $Y=0.234 $X2=0.7425 $Y2=0.234
r7 10 24 2.5483 $w=1.79e-08 $l=1.8e-08 $layer=M1 $thickness=3.6e-08 $X=0.783
+ $Y=0.234 $X2=0.783 $Y2=0.216
r8 10 25 7.79507 $w=1.41111e-08 $l=4.05e-08 $layer=M1 $thickness=3.6e-08
+ $X=0.783 $Y=0.234 $X2=0.7425 $Y2=0.234
r9 23 24 9.44419 $w=1.3e-08 $l=4.05e-08 $layer=M1 $thickness=3.6e-08 $X=0.783
+ $Y=0.1755 $X2=0.783 $Y2=0.216
r10 22 23 9.44419 $w=1.3e-08 $l=4.05e-08 $layer=M1 $thickness=3.6e-08 $X=0.783
+ $Y=0.135 $X2=0.783 $Y2=0.1755
r11 21 22 2.3319 $w=1.3e-08 $l=1e-08 $layer=M1 $thickness=3.6e-08 $X=0.783
+ $Y=0.125 $X2=0.783 $Y2=0.135
r12 20 21 0.349785 $w=1.3e-08 $l=1.5e-09 $layer=M1 $thickness=3.6e-08 $X=0.787
+ $Y=0.1235 $X2=0.783 $Y2=0.125
r13 20 19 7.11229 $w=1.3e-08 $l=3.05e-08 $layer=M1 $thickness=3.6e-08 $X=0.787
+ $Y=0.1235 $X2=0.783 $Y2=0.093
r14 13 19 9.0944 $w=1.3e-08 $l=3.9e-08 $layer=M1 $thickness=3.6e-08 $X=0.783
+ $Y=0.054 $X2=0.783 $Y2=0.093
r15 9 18 7.79507 $w=1.41111e-08 $l=4.05e-08 $layer=M1 $thickness=3.6e-08
+ $X=0.783 $Y=0.036 $X2=0.7425 $Y2=0.036
r16 9 13 2.5483 $w=1.79e-08 $l=1.8e-08 $layer=M1 $thickness=3.6e-08 $X=0.783
+ $Y=0.036 $X2=0.783 $Y2=0.054
r17 11 18 9.44419 $w=1.3e-08 $l=4.05e-08 $layer=M1 $thickness=3.6e-08 $X=0.702
+ $Y=0.036 $X2=0.7425 $Y2=0.036
r18 1 11 19.3796 $a=3.24e-16 $layer=V0LISD $X=0.702 $Y=0.0675 $X2=0.702
+ $Y2=0.036
r19 17 15 0.0308642 $w=8.1e-08 $l=2.5e-09 $layer=N_src_drn $thickness=1e-09
+ $X=0.7193 $Y=0.0675 $X2=0.7165 $Y2=0.0675
r20 1 15 0.179012 $w=8.1e-08 $l=1.45e-08 $layer=N_src_drn $thickness=1e-09
+ $X=0.702 $Y=0.0675 $X2=0.7165 $Y2=0.0675
r21 7 1 0.179012 $w=8.1e-08 $l=1.45e-08 $layer=N_src_drn $thickness=1e-09
+ $X=0.6875 $Y=0.0675 $X2=0.702 $Y2=0.0675
r22 16 7 0.0308642 $w=8.1e-08 $l=2.5e-09 $layer=N_src_drn $thickness=1e-09
+ $X=0.6846 $Y=0.0675 $X2=0.6875 $Y2=0.0675
.ends

* End of included file OA31x2_ASAP7_75t_R.pex.sp.pex

*
.subckt OA31x2_ASAP7_75t_CUSTOM_4_25_0_7 VSS VDD A1 A2 A3 B1 Y
*
* VSS VSS
* VDD VDD
* A1 A1
* A2 A2
* A3 A3
* B1 B1
* Y Y
*
*

M0 noxref_9 N_M0_g N_M0_s VSS nmos_rvt L=2e-08 W=8.1e-08 nfin=3 $X=0.071
+ $Y=0.027
M1 N_M1_d N_M1_g noxref_9 VSS nmos_rvt L=2e-08 W=8.1e-08 nfin=3 $X=0.233
+ $Y=0.027
M2 noxref_9 N_M2_g N_M2_s VSS nmos_rvt L=2e-08 W=8.1e-08 nfin=3 $X=0.449
+ $Y=0.027
M3 VSS N_M3_g noxref_9 VSS nmos_rvt L=2e-08 W=8.1e-08 nfin=3 $X=0.503 $Y=0.027
M4 N_M4_d N_M4_g VSS VSS nmos_rvt L=2e-08 W=8.1e-08 nfin=3 $X=0.665 $Y=0.027
M5 N_M5_d N_M5_g VSS VSS nmos_rvt L=2e-08 W=8.1e-08 nfin=3 $X=0.719 $Y=0.027
M6 VDD N_M6_g noxref_8 VDD pmos_rvt L=2e-08 W=8.1e-08 nfin=3 $X=0.071 $Y=0.162
M7 VDD N_M7_g noxref_8 VDD pmos_rvt L=2e-08 W=8.1e-08 nfin=3 $X=0.125 $Y=0.162
M8 noxref_10 N_M8_g noxref_8 VDD pmos_rvt L=2e-08 W=8.1e-08 nfin=3 $X=0.179
+ $Y=0.162
M9 noxref_10 N_M9_g noxref_8 VDD pmos_rvt L=2e-08 W=8.1e-08 nfin=3 $X=0.233
+ $Y=0.162
M10 noxref_10 N_M10_g N_M10_s VDD pmos_rvt L=2e-08 W=8.1e-08 nfin=3 $X=0.395
+ $Y=0.162
M11 noxref_10 N_M11_g N_M11_s VDD pmos_rvt L=2e-08 W=8.1e-08 nfin=3 $X=0.449
+ $Y=0.162
M12 VDD N_M12_g N_M12_s VDD pmos_rvt L=2e-08 W=5.4e-08 nfin=2 $X=0.503 $Y=0.189
M13 N_M13_d N_M13_g VDD VDD pmos_rvt L=2e-08 W=8.1e-08 nfin=3 $X=0.665 $Y=0.162
M14 N_M14_d N_M14_g VDD VDD pmos_rvt L=2e-08 W=8.1e-08 nfin=3 $X=0.719 $Y=0.162

* .include "OA31x2_ASAP7_75t_R.pex.sp.pxi"

* Start of included file OA31x2_ASAP7_75t_R.pex.sp.pxi
x_PM_OA31x2_ASAP7_75t_R%A2 vss A2 N_M1_g N_M9_g N_M8_g N_A2_5 N_A2_7 N_A2_3
+ N_A2_4 PM_OA31x2_ASAP7_75t_R%A2
cc_1 N_A2_5 N_A1_1 0.00167488f $X=0.135 $Y=0.135
cc_2 N_A2_7 N_A1_7 0.00218838f $X=0.135 $Y=0.154
cc_3 N_A2_3 N_A1_4 0.0147922f $X=0.189 $Y=0.135
x_PM_OA31x2_ASAP7_75t_R%A3 vss A3 N_M10_g N_M2_g N_M11_g N_A3_4 N_A3_1 N_A3_6
+ N_A3_3 N_A3_5 N_A3_8 N_A3_7 PM_OA31x2_ASAP7_75t_R%A3
x_PM_OA31x2_ASAP7_75t_R%A1 vss A1 N_M0_g N_M6_g N_M7_g N_A1_1 N_A1_7 N_A1_4
+ N_A1_3 N_A1_5 PM_OA31x2_ASAP7_75t_R%A1
x_PM_OA31x2_ASAP7_75t_R%7 vss N_M4_g N_M13_g N_M5_g N_M14_g N_M2_s N_M11_s
+ N_M12_s N_M10_s N_M1_d N_M0_s N_7_5 N_7_33 N_7_23 N_7_3 N_7_24 N_7_28 N_7_6
+ N_7_9 N_7_7 N_7_27 N_7_8 N_7_10 N_7_35 N_7_34 N_7_4 N_7_25 N_7_26 N_7_29
+ N_7_36 N_7_37 N_7_31 N_7_22 N_7_1 N_7_38 N_7_21 PM_OA31x2_ASAP7_75t_R%7
cc_4 N_7_5 N_A1_3 0.00189393f $X=0.054 $Y=0.0675
cc_5 N_7_33 N_A1_1 0.00220368f $X=0.232 $Y=0.072
cc_6 N_7_33 N_A1_5 0.00229935f $X=0.232 $Y=0.072
cc_7 N_7_23 N_A1_3 0.0355154f $X=0.056 $Y=0.0675
cc_8 N_7_33 N_A2_4 0.00116258f $X=0.232 $Y=0.072
cc_9 N_7_3 N_A2_4 0.000586282f $X=0.27 $Y=0.096
cc_10 N_7_33 N_A2_5 0.00360841f $X=0.232 $Y=0.072
cc_11 N_7_24 N_A2_4 0.0363543f $X=0.2555 $Y=0.0675
cc_12 N_7_28 N_A3_4 0.00017396f $X=0.4715 $Y=0.1755
cc_13 N_7_6 N_A3_4 0.000182207f $X=0.27 $Y=0.0555
cc_14 N_7_9 N_A3_4 0.0007155f $X=0.432 $Y=0.0555
cc_15 N_7_7 N_A3_4 0.000382036f $X=0.405 $Y=0.096
cc_16 N_7_27 N_A3_4 0.0004356f $X=0.38 $Y=0.2025
cc_17 N_7_8 N_A3_4 0.000531541f $X=0.378 $Y=0.2025
cc_18 N_7_10 N_A3_4 0.000683393f $X=0.486 $Y=0.1755
cc_19 N_7_35 N_A3_1 0.000811683f $X=0.54 $Y=0.072
cc_20 N_7_34 N_A3_6 0.00108131f $X=0.54 $Y=0.198
cc_21 N_7_7 N_A3_1 0.00109248f $X=0.405 $Y=0.096
cc_22 N_7_4 N_A3_1 0.00112246f $X=0.432 $Y=0.096
cc_23 N_7_25 N_A3_4 0.0119459f $X=0.434 $Y=0.0675
cc_24 N_7_8 N_A3_3 0.00126899f $X=0.378 $Y=0.2025
cc_25 N_7_33 N_A3_5 0.00127031f $X=0.232 $Y=0.072
cc_26 N_7_34 N_A3_1 0.00130555f $X=0.54 $Y=0.198
cc_27 N_7_34 N_A3_8 0.00167745f $X=0.54 $Y=0.198
cc_28 N_7_25 N_A3_1 0.00515574f $X=0.434 $Y=0.0675
cc_29 N_7_7 N_A3_7 0.00521737f $X=0.405 $Y=0.096
cc_30 N_7_26 N_A3_4 0.00953492f $X=0.4715 $Y=0.1975
cc_31 N_7_27 N_A3_3 0.0545929f $X=0.38 $Y=0.2025
cc_32 N_7_25 N_A3_3 0.0210182f $X=0.434 $Y=0.0675
cc_33 N_7_29 N_A3_4 0.0602562f $X=0.4715 $Y=0.2245
cc_34 N_7_28 N_B1_3 0.000238745f $X=0.4715 $Y=0.1755
cc_35 N_7_10 N_B1_3 0.00225077f $X=0.486 $Y=0.1755
cc_36 N_7_36 N_B1_3 0.000538534f $X=0.567 $Y=0.116
cc_37 N_7_37 N_B1_3 0.000568781f $X=0.567 $Y=0.1485
cc_38 N_7_35 B1 0.00133648f $X=0.54 $Y=0.072
cc_39 N_7_31 B1 0.00270171f $X=0.567 $Y=0.135
cc_40 N_7_34 N_B1_4 0.00509192f $X=0.54 $Y=0.198
cc_41 N_7_29 N_B1_3 0.00510508f $X=0.4715 $Y=0.2245
cc_42 N_7_26 N_B1_3 0.0317045f $X=0.4715 $Y=0.1975
x_PM_OA31x2_ASAP7_75t_R%B1 vss B1 N_M3_g N_M12_g N_B1_3 N_B1_4
+ PM_OA31x2_ASAP7_75t_R%B1
cc_43 N_B1_3 N_A3_4 0.00493792f $X=0.513 $Y=0.0245
x_PM_OA31x2_ASAP7_75t_R%Y vss Y N_M4_d N_M5_d N_M13_d N_M14_d N_Y_8 N_Y_7
+ PM_OA31x2_ASAP7_75t_R%Y
cc_44 N_Y_8 N_7_36 0.000145079f $X=0.6875 $Y=0.2025
cc_45 N_Y_8 N_7_22 0.0377648f $X=0.6875 $Y=0.2025
cc_46 N_Y_8 N_7_1 0.00137226f $X=0.6875 $Y=0.2025
cc_47 N_Y_8 N_7_38 0.000817484f $X=0.6875 $Y=0.2025
cc_48 N_Y_7 N_7_1 0.00539076f $X=0.6875 $Y=0.0675
cc_49 N_Y_7 N_7_21 0.0102975f $X=0.6875 $Y=0.0675
cc_50 N_Y_7 N_7_22 0.0183842f $X=0.6875 $Y=0.0675
cc_51 N_Y_8 N_7_21 0.0711019f $X=0.6875 $Y=0.2025

* End of included file OA31x2_ASAP7_75t_R.pex.sp.pxi
.ends

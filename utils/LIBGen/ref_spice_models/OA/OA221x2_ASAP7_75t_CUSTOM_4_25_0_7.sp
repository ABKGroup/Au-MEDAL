.subckt PM_OA221x2_ASAP7_75t_R%A1 vss 26 8 12 21 6 1 3 4
c1 1 vss 0.0170647f $X=0.189 $Y=0.135
c2 3 vss 0.1597f $X=0.189 $Y=0.0245
c3 4 vss 0.159614f $X=0.243 $Y=0.135
c4 5 vss 0.00607136f $X=0.243 $Y=0.108
c5 6 vss 0.00267818f $X=0.243 $Y=0.198
c6 7 vss 0.00363316f $X=0.243 $Y=0.135
r1 6 27 5.5239 $w=1.45652e-08 $l=2.88e-08 $layer=M1 $thickness=3.6e-08 $X=0.243
+ $Y=0.198 $X2=0.243 $Y2=0.1692
r2 5 24 1.96775 $w=1.63333e-08 $l=1.35e-08 $layer=M1 $thickness=3.6e-08
+ $X=0.243 $Y=0.108 $X2=0.243 $Y2=0.1215
r3 26 27 4.72209 $w=1.3e-08 $l=2.02e-08 $layer=M1 $thickness=3.6e-08 $X=0.248
+ $Y=0.149 $X2=0.243 $Y2=0.1692
r4 26 25 0.641272 $w=1.3e-08 $l=2.8e-09 $layer=M1 $thickness=3.6e-08 $X=0.248
+ $Y=0.149 $X2=0.243 $Y2=0.1462
r5 7 17 19.3796 $a=3.24e-16 $layer=V0LIG $X=0.243 $Y=0.135 $X2=0.243 $Y2=0.135
r6 7 24 3.14806 $w=1.3e-08 $l=1.35e-08 $layer=M1 $thickness=3.6e-08 $X=0.243
+ $Y=0.135 $X2=0.243 $Y2=0.1215
r7 7 25 2.62338 $w=1.3e-08 $l=1.12e-08 $layer=M1 $thickness=3.6e-08 $X=0.243
+ $Y=0.135 $X2=0.243 $Y2=0.1462
r8 21 22 16.4967 $w=2.1e-08 $l=4.85e-08 $layer=Gate_1 $thickness=5.6e-08
+ $X=0.243 $Y=0.0675 $X2=0.243 $Y2=0.116
r9 4 17 6.27904 $w=2.09e-08 $layer=Gate_1 $thickness=5.24e-08 $X=0.243 $Y=0.135
+ $X2=0.243 $Y2=0.135
r10 4 22 6.6497 $w=2.04211e-08 $l=1.9e-08 $layer=Gate_1 $thickness=5.6e-08
+ $X=0.243 $Y=0.135 $X2=0.243 $Y2=0.116
r11 16 17 2.48102 $w=2.2e-08 $l=9.5e-09 $layer=LIG $thickness=4.8e-08 $X=0.2335
+ $Y=0.135 $X2=0.243 $Y2=0.135
r12 15 16 10.1729 $w=1.54914e-08 $l=1.75e-08 $layer=LIG $thickness=4.8e-08
+ $X=0.216 $Y=0.135 $X2=0.2335 $Y2=0.135
r13 1 10 6.54019 $w=2.09524e-08 $layer=Gate_1 $thickness=5.21905e-08 $X=0.189
+ $Y=0.135 $X2=0.189 $Y2=0.135
r14 1 15 12.6539 $w=1.77815e-08 $l=2.7e-08 $layer=LIG $thickness=4.8e-08
+ $X=0.189 $Y=0.135 $X2=0.216 $Y2=0.135
r15 12 11 16.4967 $w=2.1e-08 $l=4.85e-08 $layer=Gate_1 $thickness=5.6e-08
+ $X=0.189 $Y=0.2025 $X2=0.189 $Y2=0.154
r16 10 11 6.6497 $w=2.04211e-08 $l=1.9e-08 $layer=Gate_1 $thickness=5.6e-08
+ $X=0.189 $Y=0.135 $X2=0.189 $Y2=0.154
r17 9 10 6.6497 $w=2.04211e-08 $l=1.9e-08 $layer=Gate_1 $thickness=5.6e-08
+ $X=0.189 $Y=0.116 $X2=0.189 $Y2=0.135
r18 8 9 16.4967 $w=2.1e-08 $l=4.85e-08 $layer=Gate_1 $thickness=5.6e-08
+ $X=0.189 $Y=0.0675 $X2=0.189 $Y2=0.116
r19 8 3 14.6259 $w=2.1e-08 $l=4.3e-08 $layer=Gate_1 $thickness=5.6e-08 $X=0.189
+ $Y=0.0675 $X2=0.189 $Y2=0.0245
.ends

.subckt PM_OA221x2_ASAP7_75t_R%B1 vss 22 8 12 25 6 1 3 4
c1 1 vss 0.0161504f $X=0.6115 $Y=0.135
c2 3 vss 0.142335f $X=0.621 $Y=0.0245
c3 4 vss 0.161519f $X=0.675 $Y=0.135
c4 5 vss 0.00614553f $X=0.621 $Y=0.108
c5 6 vss 0.00196161f $X=0.621 $Y=0.198
c6 7 vss 0.00310784f $X=0.621 $Y=0.1215
r1 6 23 5.29071 $w=1.46216e-08 $l=2.78e-08 $layer=M1 $thickness=3.6e-08
+ $X=0.621 $Y=0.198 $X2=0.621 $Y2=0.1702
r2 5 7 1.96775 $w=1.63333e-08 $l=1.35e-08 $layer=M1 $thickness=3.6e-08 $X=0.621
+ $Y=0.108 $X2=0.621 $Y2=0.1215
r3 25 26 16.4967 $w=2.1e-08 $l=4.85e-08 $layer=Gate_1 $thickness=5.6e-08
+ $X=0.675 $Y=0.0675 $X2=0.675 $Y2=0.116
r4 4 18 6.54019 $w=2.09524e-08 $layer=Gate_1 $thickness=5.21905e-08 $X=0.675
+ $Y=0.135 $X2=0.675 $Y2=0.135
r5 4 26 6.6497 $w=2.04211e-08 $l=1.9e-08 $layer=Gate_1 $thickness=5.6e-08
+ $X=0.675 $Y=0.135 $X2=0.675 $Y2=0.116
r6 22 23 4.4889 $w=1.3e-08 $l=1.92e-08 $layer=M1 $thickness=3.6e-08 $X=0.622
+ $Y=0.151 $X2=0.621 $Y2=0.1702
r7 22 21 0.874462 $w=1.3e-08 $l=3.8e-09 $layer=M1 $thickness=3.6e-08 $X=0.622
+ $Y=0.151 $X2=0.621 $Y2=0.1472
r8 20 21 2.85657 $w=1.3e-08 $l=1.22e-08 $layer=M1 $thickness=3.6e-08 $X=0.621
+ $Y=0.135 $X2=0.621 $Y2=0.1472
r9 7 20 3.14806 $w=1.3e-08 $l=1.35e-08 $layer=M1 $thickness=3.6e-08 $X=0.621
+ $Y=0.1215 $X2=0.621 $Y2=0.135
r10 17 18 12.6539 $w=1.77815e-08 $l=2.7e-08 $layer=LIG $thickness=4.8e-08
+ $X=0.648 $Y=0.135 $X2=0.675 $Y2=0.135
r11 15 17 10.1729 $w=1.54914e-08 $l=1.75e-08 $layer=LIG $thickness=4.8e-08
+ $X=0.6305 $Y=0.135 $X2=0.648 $Y2=0.135
r12 14 15 2.48102 $w=2.2e-08 $l=9.5e-09 $layer=LIG $thickness=4.8e-08 $X=0.621
+ $Y=0.135 $X2=0.6305 $Y2=0.135
r13 14 20 19.3796 $a=3.24e-16 $layer=V0LIG $X=0.621 $Y=0.135 $X2=0.621 $Y2=0.135
r14 1 14 2.48102 $w=2.2e-08 $l=9.5e-09 $layer=LIG $thickness=4.8e-08 $X=0.6115
+ $Y=0.135 $X2=0.621 $Y2=0.135
r15 12 11 16.4967 $w=2.1e-08 $l=4.85e-08 $layer=Gate_1 $thickness=5.6e-08
+ $X=0.621 $Y=0.2025 $X2=0.621 $Y2=0.154
r16 10 11 6.6497 $w=2.04211e-08 $l=1.9e-08 $layer=Gate_1 $thickness=5.6e-08
+ $X=0.621 $Y=0.135 $X2=0.621 $Y2=0.154
r17 10 15 4.05918 $w=2.0087e-08 $l=9.5e-09 $layer=Gate_1 $thickness=5.56522e-08
+ $X=0.621 $Y=0.135 $X2=0.6305 $Y2=0.135
r18 10 14 6.27904 $w=2.09e-08 $layer=Gate_1 $thickness=5.24e-08 $X=0.621
+ $Y=0.135 $X2=0.621 $Y2=0.135
r19 9 10 6.6497 $w=2.04211e-08 $l=1.9e-08 $layer=Gate_1 $thickness=5.6e-08
+ $X=0.621 $Y=0.116 $X2=0.621 $Y2=0.135
r20 8 9 16.4967 $w=2.1e-08 $l=4.85e-08 $layer=Gate_1 $thickness=5.6e-08
+ $X=0.621 $Y=0.0675 $X2=0.621 $Y2=0.116
r21 8 3 14.6259 $w=2.1e-08 $l=4.3e-08 $layer=Gate_1 $thickness=5.6e-08 $X=0.621
+ $Y=0.0675 $X2=0.621 $Y2=0.0245
.ends

.subckt PM_OA221x2_ASAP7_75t_R%C vss 22 8 12 26 4 1 3 5 6
c1 1 vss 0.011279f $X=0.7195 $Y=0.135
c2 3 vss 0.0845499f $X=0.729 $Y=0.0245
c3 4 vss 0.0577053f $X=0.783 $Y=0.135
c4 5 vss 0.00418694f $X=0.729 $Y=0.108
c5 6 vss 0.00353148f $X=0.729 $Y=0.198
c6 7 vss 0.00421109f $X=0.729 $Y=0.1215
r1 6 23 5.29071 $w=1.46216e-08 $l=2.78e-08 $layer=M1 $thickness=3.6e-08
+ $X=0.729 $Y=0.198 $X2=0.729 $Y2=0.1702
r2 5 7 1.96775 $w=1.63333e-08 $l=1.35e-08 $layer=M1 $thickness=3.6e-08 $X=0.729
+ $Y=0.108 $X2=0.729 $Y2=0.1215
r3 26 27 14.6259 $w=2.1e-08 $l=4.3e-08 $layer=Gate_1 $thickness=5.6e-08
+ $X=0.783 $Y=0.0675 $X2=0.783 $Y2=0.1105
r4 24 27 2.7211 $w=2.1e-08 $l=8e-09 $layer=Gate_1 $thickness=5.6e-08 $X=0.783
+ $Y=0.1185 $X2=0.783 $Y2=0.1105
r5 4 18 6.54019 $w=2.09524e-08 $layer=Gate_1 $thickness=5.21905e-08 $X=0.783
+ $Y=0.135 $X2=0.783 $Y2=0.135
r6 4 24 5.79936 $w=2.03333e-08 $l=1.65e-08 $layer=Gate_1 $thickness=5.6e-08
+ $X=0.783 $Y=0.135 $X2=0.783 $Y2=0.1185
r7 22 23 4.4889 $w=1.3e-08 $l=1.92e-08 $layer=M1 $thickness=3.6e-08 $X=0.733
+ $Y=0.151 $X2=0.729 $Y2=0.1702
r8 22 21 0.874462 $w=1.3e-08 $l=3.8e-09 $layer=M1 $thickness=3.6e-08 $X=0.733
+ $Y=0.151 $X2=0.729 $Y2=0.1472
r9 20 21 2.85657 $w=1.3e-08 $l=1.22e-08 $layer=M1 $thickness=3.6e-08 $X=0.729
+ $Y=0.135 $X2=0.729 $Y2=0.1472
r10 7 20 3.14806 $w=1.3e-08 $l=1.35e-08 $layer=M1 $thickness=3.6e-08 $X=0.729
+ $Y=0.1215 $X2=0.729 $Y2=0.135
r11 17 18 12.6539 $w=1.77815e-08 $l=2.7e-08 $layer=LIG $thickness=4.8e-08
+ $X=0.756 $Y=0.135 $X2=0.783 $Y2=0.135
r12 15 17 10.1729 $w=1.54914e-08 $l=1.75e-08 $layer=LIG $thickness=4.8e-08
+ $X=0.7385 $Y=0.135 $X2=0.756 $Y2=0.135
r13 14 15 2.48102 $w=2.2e-08 $l=9.5e-09 $layer=LIG $thickness=4.8e-08 $X=0.729
+ $Y=0.135 $X2=0.7385 $Y2=0.135
r14 14 20 19.3796 $a=3.24e-16 $layer=V0LIG $X=0.729 $Y=0.135 $X2=0.729 $Y2=0.135
r15 1 14 2.48102 $w=2.2e-08 $l=9.5e-09 $layer=LIG $thickness=4.8e-08 $X=0.7195
+ $Y=0.135 $X2=0.729 $Y2=0.135
r16 12 11 16.4967 $w=2.1e-08 $l=4.85e-08 $layer=Gate_1 $thickness=5.6e-08
+ $X=0.729 $Y=0.216 $X2=0.729 $Y2=0.1675
r17 10 11 11.2416 $w=2.06615e-08 $l=3.25e-08 $layer=Gate_1 $thickness=5.6e-08
+ $X=0.729 $Y=0.135 $X2=0.729 $Y2=0.1675
r18 10 15 4.05918 $w=2.0087e-08 $l=9.5e-09 $layer=Gate_1 $thickness=5.56522e-08
+ $X=0.729 $Y=0.135 $X2=0.7385 $Y2=0.135
r19 10 14 6.27904 $w=2.09e-08 $layer=Gate_1 $thickness=5.24e-08 $X=0.729
+ $Y=0.135 $X2=0.729 $Y2=0.135
r20 9 10 6.6497 $w=2.04211e-08 $l=1.9e-08 $layer=Gate_1 $thickness=5.6e-08
+ $X=0.729 $Y=0.116 $X2=0.729 $Y2=0.135
r21 8 9 16.4967 $w=2.1e-08 $l=4.85e-08 $layer=Gate_1 $thickness=5.6e-08
+ $X=0.729 $Y=0.0675 $X2=0.729 $Y2=0.116
r22 8 3 14.6259 $w=2.1e-08 $l=4.3e-08 $layer=Gate_1 $thickness=5.6e-08 $X=0.729
+ $Y=0.0675 $X2=0.729 $Y2=0.0245
.ends

.subckt PM_OA221x2_ASAP7_75t_R%3 vss 31 37 46 49 73 75 89 92 93 1 23 27 18 28 6
+ 5 3 20 7 4 21 8 9 22 30 29 19 24 17
c1 1 vss 0.00773755f $X=0.081 $Y=0.135
c2 3 vss 0.00113607f $X=0.324 $Y=0.174
c3 4 vss 0.000425237f $X=0.54 $Y=0.174
c4 5 vss 0.00454254f $X=0.324 $Y=0.2145
c5 6 vss 0.0140189f $X=0.513 $Y=0.174
c6 7 vss 0.00499678f $X=0.54 $Y=0.2145
c7 8 vss 0.00982877f $X=0.756 $Y=0.0675
c8 9 vss 0.00672073f $X=0.756 $Y=0.216
c9 17 vss 0.0823718f $X=0.081 $Y=0.0245
c10 18 vss 0.0805336f $X=0.135 $Y=0.135
c11 19 vss 0.00557663f $X=0.7415 $Y=0.0675
c12 20 vss 0.00461734f $X=0.3095 $Y=0.2025
c13 21 vss 0.00387865f $X=0.542 $Y=0.2025
c14 22 vss 0.00413778f $X=0.7415 $Y=0.216
c15 23 vss 0.00213876f $X=0.124 $Y=0.135
c16 24 vss 0.00280977f $X=0.153 $Y=0.234
c17 25 vss 0.00274031f $X=0.837 $Y=0.072
c18 26 vss 0.00318589f $X=0.837 $Y=0.234
c19 27 vss 0.00343438f $X=0.153 $Y=0.1665
c20 28 vss 0.06395f $X=0.182 $Y=0.234
c21 29 vss 0.00892666f $X=0.826 $Y=0.072
c22 30 vss 0.00765395f $X=0.837 $Y=0.216
r1 93 91 0.0308642 $w=8.1e-08 $l=2.5e-09 $layer=N_src_drn $thickness=1e-09
+ $X=0.7733 $Y=0.0675 $X2=0.7705 $Y2=0.0675
r2 8 91 0.179012 $w=8.1e-08 $l=1.45e-08 $layer=N_src_drn $thickness=1e-09
+ $X=0.756 $Y=0.0675 $X2=0.7705 $Y2=0.0675
r3 19 8 0.179012 $w=8.1e-08 $l=1.45e-08 $layer=N_src_drn $thickness=1e-09
+ $X=0.7415 $Y=0.0675 $X2=0.756 $Y2=0.0675
r4 92 19 0.0308642 $w=8.1e-08 $l=2.5e-09 $layer=N_src_drn $thickness=1e-09
+ $X=0.7386 $Y=0.0675 $X2=0.7415 $Y2=0.0675
r5 8 87 19.3796 $a=3.24e-16 $layer=V0LISD $X=0.756 $Y=0.0675 $X2=0.752 $Y2=0.072
r6 20 5 0.154321 $w=8.1e-08 $l=1.25e-08 $layer=P_src_drn $thickness=1e-09
+ $X=0.3095 $Y=0.2025 $X2=0.324 $Y2=0.2145
r7 89 20 0.0308642 $w=8.1e-08 $l=2.5e-09 $layer=P_src_drn $thickness=1e-09
+ $X=0.3066 $Y=0.2025 $X2=0.3095 $Y2=0.2025
r8 84 85 7.81186 $w=1.3e-08 $l=3.35e-08 $layer=M1 $thickness=3.6e-08 $X=0.761
+ $Y=0.072 $X2=0.7945 $Y2=0.072
r9 84 87 2.09871 $w=1.3e-08 $l=9e-09 $layer=M1 $thickness=3.6e-08 $X=0.761
+ $Y=0.072 $X2=0.752 $Y2=0.072
r10 29 85 7.34548 $w=1.3e-08 $l=3.15e-08 $layer=M1 $thickness=3.6e-08 $X=0.826
+ $Y=0.072 $X2=0.7945 $Y2=0.072
r11 3 83 14.1645 $w=2.18889e-08 $l=2.7e-08 $layer=LISD $thickness=2.7e-08
+ $X=0.324 $Y=0.174 $X2=0.351 $Y2=0.174
r12 3 5 22.1214 $w=2.13259e-08 $l=4.05e-08 $layer=LISD $thickness=2.7e-08
+ $X=0.324 $Y=0.174 $X2=0.324 $Y2=0.2145
r13 25 79 2.5483 $w=1.79e-08 $l=1.8e-08 $layer=M1 $thickness=3.6e-08 $X=0.837
+ $Y=0.072 $X2=0.837 $Y2=0.09
r14 25 29 0.915974 $w=1.70909e-08 $l=1.1e-08 $layer=M1 $thickness=3.6e-08
+ $X=0.837 $Y=0.072 $X2=0.826 $Y2=0.072
r15 82 83 15.9139 $w=2.02e-08 $l=2.7e-08 $layer=LISD $thickness=2.7e-08
+ $X=0.378 $Y=0.174 $X2=0.351 $Y2=0.174
r16 81 82 31.8278 $w=2.02e-08 $l=5.4e-08 $layer=LISD $thickness=2.7e-08
+ $X=0.432 $Y=0.174 $X2=0.378 $Y2=0.174
r17 80 81 31.8278 $w=2.02e-08 $l=5.4e-08 $layer=LISD $thickness=2.7e-08
+ $X=0.486 $Y=0.174 $X2=0.432 $Y2=0.174
r18 6 80 15.9139 $w=2.02e-08 $l=2.7e-08 $layer=LISD $thickness=2.7e-08 $X=0.513
+ $Y=0.174 $X2=0.486 $Y2=0.174
r19 78 79 4.19742 $w=1.3e-08 $l=1.8e-08 $layer=M1 $thickness=3.6e-08 $X=0.837
+ $Y=0.108 $X2=0.837 $Y2=0.09
r20 77 78 10.4935 $w=1.3e-08 $l=4.5e-08 $layer=M1 $thickness=3.6e-08 $X=0.837
+ $Y=0.153 $X2=0.837 $Y2=0.108
r21 76 77 10.4935 $w=1.3e-08 $l=4.5e-08 $layer=M1 $thickness=3.6e-08 $X=0.837
+ $Y=0.198 $X2=0.837 $Y2=0.153
r22 30 76 4.19742 $w=1.3e-08 $l=1.8e-08 $layer=M1 $thickness=3.6e-08 $X=0.837
+ $Y=0.216 $X2=0.837 $Y2=0.198
r23 22 9 0.231482 $w=5.4e-08 $l=1.25e-08 $layer=P_src_drn $thickness=1e-09
+ $X=0.7415 $Y=0.216 $X2=0.756 $Y2=0.216
r24 75 22 0.0462963 $w=5.4e-08 $l=2.5e-09 $layer=P_src_drn $thickness=1e-09
+ $X=0.7386 $Y=0.216 $X2=0.7415 $Y2=0.216
r25 73 72 0.0308642 $w=8.1e-08 $l=2.5e-09 $layer=P_src_drn $thickness=1e-09
+ $X=0.5573 $Y=0.2025 $X2=0.5545 $Y2=0.2025
r26 21 72 0.154321 $w=8.1e-08 $l=1.25e-08 $layer=P_src_drn $thickness=1e-09
+ $X=0.542 $Y=0.2025 $X2=0.5545 $Y2=0.2025
r27 4 7 22.1214 $w=2.13259e-08 $l=4.05e-08 $layer=LISD $thickness=2.7e-08
+ $X=0.54 $Y=0.174 $X2=0.54 $Y2=0.2145
r28 4 6 14.1645 $w=2.18889e-08 $l=2.7e-08 $layer=LISD $thickness=2.7e-08
+ $X=0.54 $Y=0.174 $X2=0.513 $Y2=0.174
r29 26 71 7.79507 $w=1.41111e-08 $l=4.05e-08 $layer=M1 $thickness=3.6e-08
+ $X=0.837 $Y=0.234 $X2=0.7965 $Y2=0.234
r30 26 30 2.5483 $w=1.79e-08 $l=1.8e-08 $layer=M1 $thickness=3.6e-08 $X=0.837
+ $Y=0.234 $X2=0.837 $Y2=0.216
r31 9 69 19.3796 $a=3.24e-16 $layer=V0LISD $X=0.756 $Y=0.216 $X2=0.752 $Y2=0.234
r32 7 63 19.3796 $a=3.24e-16 $layer=V0LISD $X=0.54 $Y=0.2145 $X2=0.54 $Y2=0.234
r33 70 71 8.27824 $w=1.3e-08 $l=3.55e-08 $layer=M1 $thickness=3.6e-08 $X=0.761
+ $Y=0.234 $X2=0.7965 $Y2=0.234
r34 69 70 2.09871 $w=1.3e-08 $l=9e-09 $layer=M1 $thickness=3.6e-08 $X=0.752
+ $Y=0.234 $X2=0.761 $Y2=0.234
r35 68 69 4.31401 $w=1.3e-08 $l=1.85e-08 $layer=M1 $thickness=3.6e-08 $X=0.7335
+ $Y=0.234 $X2=0.752 $Y2=0.234
r36 67 68 9.211 $w=1.3e-08 $l=3.95e-08 $layer=M1 $thickness=3.6e-08 $X=0.694
+ $Y=0.234 $X2=0.7335 $Y2=0.234
r37 66 67 10.4935 $w=1.3e-08 $l=4.5e-08 $layer=M1 $thickness=3.6e-08 $X=0.649
+ $Y=0.234 $X2=0.694 $Y2=0.234
r38 65 66 8.74462 $w=1.3e-08 $l=3.75e-08 $layer=M1 $thickness=3.6e-08 $X=0.6115
+ $Y=0.234 $X2=0.649 $Y2=0.234
r39 64 65 9.44419 $w=1.3e-08 $l=4.05e-08 $layer=M1 $thickness=3.6e-08 $X=0.571
+ $Y=0.234 $X2=0.6115 $Y2=0.234
r40 63 64 7.22888 $w=1.3e-08 $l=3.1e-08 $layer=M1 $thickness=3.6e-08 $X=0.54
+ $Y=0.234 $X2=0.571 $Y2=0.234
r41 62 63 3.14806 $w=1.3e-08 $l=1.35e-08 $layer=M1 $thickness=3.6e-08 $X=0.5265
+ $Y=0.234 $X2=0.54 $Y2=0.234
r42 61 62 5.36336 $w=1.3e-08 $l=2.3e-08 $layer=M1 $thickness=3.6e-08 $X=0.5035
+ $Y=0.234 $X2=0.5265 $Y2=0.234
r43 60 61 16.6731 $w=1.3e-08 $l=7.15e-08 $layer=M1 $thickness=3.6e-08 $X=0.432
+ $Y=0.234 $X2=0.5035 $Y2=0.234
r44 59 60 16.6731 $w=1.3e-08 $l=7.15e-08 $layer=M1 $thickness=3.6e-08 $X=0.3605
+ $Y=0.234 $X2=0.432 $Y2=0.234
r45 58 59 14.8076 $w=1.3e-08 $l=6.35e-08 $layer=M1 $thickness=3.6e-08 $X=0.297
+ $Y=0.234 $X2=0.3605 $Y2=0.234
r46 57 58 14.8076 $w=1.3e-08 $l=6.35e-08 $layer=M1 $thickness=3.6e-08 $X=0.2335
+ $Y=0.234 $X2=0.297 $Y2=0.234
r47 56 57 5.82974 $w=1.3e-08 $l=2.5e-08 $layer=M1 $thickness=3.6e-08 $X=0.2085
+ $Y=0.234 $X2=0.2335 $Y2=0.234
r48 28 56 6.17953 $w=1.3e-08 $l=2.65e-08 $layer=M1 $thickness=3.6e-08 $X=0.182
+ $Y=0.234 $X2=0.2085 $Y2=0.234
r49 24 55 2.5483 $w=1.79e-08 $l=1.8e-08 $layer=M1 $thickness=3.6e-08 $X=0.153
+ $Y=0.234 $X2=0.153 $Y2=0.216
r50 24 28 5.11339 $w=1.45517e-08 $l=2.9e-08 $layer=M1 $thickness=3.6e-08
+ $X=0.153 $Y=0.234 $X2=0.182 $Y2=0.234
r51 54 55 4.19742 $w=1.3e-08 $l=1.8e-08 $layer=M1 $thickness=3.6e-08 $X=0.153
+ $Y=0.198 $X2=0.153 $Y2=0.216
r52 27 53 6.16517 $w=1.44286e-08 $l=3.15e-08 $layer=M1 $thickness=3.6e-08
+ $X=0.153 $Y=0.1665 $X2=0.153 $Y2=0.135
r53 27 54 7.34548 $w=1.3e-08 $l=3.15e-08 $layer=M1 $thickness=3.6e-08 $X=0.153
+ $Y=0.1665 $X2=0.153 $Y2=0.198
r54 51 53 3.01711 $w=1.55e-08 $l=1.8e-08 $layer=M1 $thickness=3.6e-08 $X=0.135
+ $Y=0.135 $X2=0.153 $Y2=0.135
r55 23 51 2.56509 $w=1.3e-08 $l=1.1e-08 $layer=M1 $thickness=3.6e-08 $X=0.124
+ $Y=0.135 $X2=0.135 $Y2=0.135
r56 49 48 16.4967 $w=2.1e-08 $l=4.85e-08 $layer=Gate_1 $thickness=5.6e-08
+ $X=0.135 $Y=0.2025 $X2=0.135 $Y2=0.154
r57 46 47 16.4967 $w=2.1e-08 $l=4.85e-08 $layer=Gate_1 $thickness=5.6e-08
+ $X=0.135 $Y=0.0675 $X2=0.135 $Y2=0.116
r58 18 42 6.27904 $w=2.09e-08 $layer=Gate_1 $thickness=5.24e-08 $X=0.135
+ $Y=0.135 $X2=0.135 $Y2=0.135
r59 18 47 6.6497 $w=2.04211e-08 $l=1.9e-08 $layer=Gate_1 $thickness=5.6e-08
+ $X=0.135 $Y=0.135 $X2=0.135 $Y2=0.116
r60 18 48 6.6497 $w=2.04211e-08 $l=1.9e-08 $layer=Gate_1 $thickness=5.6e-08
+ $X=0.135 $Y=0.135 $X2=0.135 $Y2=0.154
r61 42 51 19.3796 $a=3.24e-16 $layer=V0LIG $X=0.135 $Y=0.135 $X2=0.135 $Y2=0.135
r62 41 42 2.48102 $w=2.2e-08 $l=9.5e-09 $layer=LIG $thickness=4.8e-08 $X=0.1255
+ $Y=0.135 $X2=0.135 $Y2=0.135
r63 40 41 10.1729 $w=1.54914e-08 $l=1.75e-08 $layer=LIG $thickness=4.8e-08
+ $X=0.108 $Y=0.135 $X2=0.1255 $Y2=0.135
r64 1 34 6.54019 $w=2.09524e-08 $layer=Gate_1 $thickness=5.21905e-08 $X=0.081
+ $Y=0.135 $X2=0.081 $Y2=0.135
r65 1 40 12.6539 $w=1.77815e-08 $l=2.7e-08 $layer=LIG $thickness=4.8e-08
+ $X=0.081 $Y=0.135 $X2=0.108 $Y2=0.135
r66 37 36 14.6259 $w=2.1e-08 $l=4.3e-08 $layer=Gate_1 $thickness=5.6e-08
+ $X=0.081 $Y=0.2025 $X2=0.081 $Y2=0.1595
r67 35 36 2.7211 $w=2.1e-08 $l=8e-09 $layer=Gate_1 $thickness=5.6e-08 $X=0.081
+ $Y=0.1515 $X2=0.081 $Y2=0.1595
r68 34 35 5.79936 $w=2.03333e-08 $l=1.65e-08 $layer=Gate_1 $thickness=5.6e-08
+ $X=0.081 $Y=0.135 $X2=0.081 $Y2=0.1515
r69 33 34 5.79936 $w=2.03333e-08 $l=1.65e-08 $layer=Gate_1 $thickness=5.6e-08
+ $X=0.081 $Y=0.1185 $X2=0.081 $Y2=0.135
r70 32 33 2.7211 $w=2.1e-08 $l=8e-09 $layer=Gate_1 $thickness=5.6e-08 $X=0.081
+ $Y=0.1105 $X2=0.081 $Y2=0.1185
r71 31 32 14.6259 $w=2.1e-08 $l=4.3e-08 $layer=Gate_1 $thickness=5.6e-08
+ $X=0.081 $Y=0.0675 $X2=0.081 $Y2=0.1105
r72 31 17 14.6259 $w=2.1e-08 $l=4.3e-08 $layer=Gate_1 $thickness=5.6e-08
+ $X=0.081 $Y=0.0675 $X2=0.081 $Y2=0.0245
r73 3 5 1e-05 $l=4.05e-08 $X=0.324 $Y=0.174 $X2=0.324 $Y2=0.2145
r74 4 21 1e-05 $l=2.85701e-08 $X=0.54 $Y=0.174 $X2=0.542 $Y2=0.2025
r75 7 21 1e-05 $l=1.21655e-08 $X=0.54 $Y=0.2145 $X2=0.542 $Y2=0.2025
.ends

.subckt PM_OA221x2_ASAP7_75t_R%Y vss 29 18 19 34 35 7 15 8
c1 1 vss 0.00970333f $X=0.108 $Y=0.0675
c2 2 vss 0.00742855f $X=0.108 $Y=0.2025
c3 7 vss 0.0044112f $X=0.0935 $Y=0.0675
c4 8 vss 0.0044805f $X=0.0935 $Y=0.2025
c5 9 vss 0.00292955f $X=0.027 $Y=0.036
c6 10 vss 0.00294238f $X=0.027 $Y=0.234
c7 11 vss 0.00256648f $X=0.108 $Y=0.234
c8 12 vss 0.0087664f $X=0.027 $Y=0.054
c9 13 vss 0.00931425f $X=0.108 $Y=0.036
c10 14 vss 0.00605428f $X=0.0675 $Y=0.234
c11 15 vss 0.00105831f $X=0.108 $Y=0.207
r1 35 33 0.0308642 $w=8.1e-08 $l=2.5e-09 $layer=P_src_drn $thickness=1e-09
+ $X=0.1253 $Y=0.2025 $X2=0.1225 $Y2=0.2025
r2 2 33 0.179012 $w=8.1e-08 $l=1.45e-08 $layer=P_src_drn $thickness=1e-09
+ $X=0.108 $Y=0.2025 $X2=0.1225 $Y2=0.2025
r3 8 2 0.179012 $w=8.1e-08 $l=1.45e-08 $layer=P_src_drn $thickness=1e-09
+ $X=0.0935 $Y=0.2025 $X2=0.108 $Y2=0.2025
r4 34 8 0.0308642 $w=8.1e-08 $l=2.5e-09 $layer=P_src_drn $thickness=1e-09
+ $X=0.0906 $Y=0.2025 $X2=0.0935 $Y2=0.2025
r5 2 15 19.3796 $a=3.24e-16 $layer=V0LISD $X=0.108 $Y=0.2025 $X2=0.108 $Y2=0.207
r6 11 14 7.79507 $w=1.41111e-08 $l=4.05e-08 $layer=M1 $thickness=3.6e-08
+ $X=0.108 $Y=0.234 $X2=0.0675 $Y2=0.234
r7 11 15 4.64701 $w=1.62667e-08 $l=2.7e-08 $layer=M1 $thickness=3.6e-08
+ $X=0.108 $Y=0.234 $X2=0.108 $Y2=0.207
r8 10 31 4.58871 $w=1.62972e-08 $l=2.68e-08 $layer=M1 $thickness=3.6e-08
+ $X=0.027 $Y=0.234 $X2=0.027 $Y2=0.2072
r9 10 14 7.79507 $w=1.41111e-08 $l=4.05e-08 $layer=M1 $thickness=3.6e-08
+ $X=0.027 $Y=0.234 $X2=0.0675 $Y2=0.234
r10 30 31 4.19742 $w=1.3e-08 $l=1.8e-08 $layer=M1 $thickness=3.6e-08 $X=0.027
+ $Y=0.1892 $X2=0.027 $Y2=0.2072
r11 29 30 0.116595 $w=1.3e-08 $l=5e-10 $layer=M1 $thickness=3.6e-08 $X=0.027
+ $Y=0.189 $X2=0.027 $Y2=0.1892
r12 29 28 5.24677 $w=1.3e-08 $l=2.25e-08 $layer=M1 $thickness=3.6e-08 $X=0.027
+ $Y=0.189 $X2=0.027 $Y2=0.1662
r13 27 28 7.28718 $w=1.3e-08 $l=3.12e-08 $layer=M1 $thickness=3.6e-08 $X=0.027
+ $Y=0.135 $X2=0.027 $Y2=0.1662
r14 26 27 3.14806 $w=1.3e-08 $l=1.35e-08 $layer=M1 $thickness=3.6e-08 $X=0.027
+ $Y=0.1215 $X2=0.027 $Y2=0.135
r15 25 26 3.14806 $w=1.3e-08 $l=1.35e-08 $layer=M1 $thickness=3.6e-08 $X=0.027
+ $Y=0.108 $X2=0.027 $Y2=0.1215
r16 24 25 4.19742 $w=1.3e-08 $l=1.8e-08 $layer=M1 $thickness=3.6e-08 $X=0.027
+ $Y=0.09 $X2=0.027 $Y2=0.108
r17 23 24 4.19742 $w=1.3e-08 $l=1.8e-08 $layer=M1 $thickness=3.6e-08 $X=0.027
+ $Y=0.072 $X2=0.027 $Y2=0.09
r18 12 23 4.19742 $w=1.3e-08 $l=1.8e-08 $layer=M1 $thickness=3.6e-08 $X=0.027
+ $Y=0.054 $X2=0.027 $Y2=0.072
r19 9 20 7.79507 $w=1.41111e-08 $l=4.05e-08 $layer=M1 $thickness=3.6e-08
+ $X=0.027 $Y=0.036 $X2=0.0675 $Y2=0.036
r20 9 12 2.5483 $w=1.79e-08 $l=1.8e-08 $layer=M1 $thickness=3.6e-08 $X=0.027
+ $Y=0.036 $X2=0.027 $Y2=0.054
r21 13 20 9.44419 $w=1.3e-08 $l=4.05e-08 $layer=M1 $thickness=3.6e-08 $X=0.108
+ $Y=0.036 $X2=0.0675 $Y2=0.036
r22 1 13 19.3796 $a=3.24e-16 $layer=V0LISD $X=0.108 $Y=0.0675 $X2=0.108
+ $Y2=0.036
r23 19 17 0.0308642 $w=8.1e-08 $l=2.5e-09 $layer=N_src_drn $thickness=1e-09
+ $X=0.1253 $Y=0.0675 $X2=0.1225 $Y2=0.0675
r24 1 17 0.179012 $w=8.1e-08 $l=1.45e-08 $layer=N_src_drn $thickness=1e-09
+ $X=0.108 $Y=0.0675 $X2=0.1225 $Y2=0.0675
r25 7 1 0.179012 $w=8.1e-08 $l=1.45e-08 $layer=N_src_drn $thickness=1e-09
+ $X=0.0935 $Y=0.0675 $X2=0.108 $Y2=0.0675
r26 18 7 0.0308642 $w=8.1e-08 $l=2.5e-09 $layer=N_src_drn $thickness=1e-09
+ $X=0.0906 $Y=0.0675 $X2=0.0935 $Y2=0.0675
.ends

.subckt PM_OA221x2_ASAP7_75t_R%A2 vss 28 8 12 22 3 7 1 6 4
c1 1 vss 0.0120782f $X=0.297 $Y=0.135
c2 3 vss 0.12406f $X=0.297 $Y=0.0245
c3 4 vss 0.0961607f $X=0.351 $Y=0.135
c4 5 vss 0.00716817f $X=0.351 $Y=0.108
c5 6 vss 0.00210479f $X=0.351 $Y=0.198
c6 7 vss 0.0037106f $X=0.351 $Y=0.1215
r1 6 29 5.29071 $w=1.46216e-08 $l=2.78e-08 $layer=M1 $thickness=3.6e-08
+ $X=0.351 $Y=0.198 $X2=0.351 $Y2=0.1702
r2 5 7 1.96775 $w=1.63333e-08 $l=1.35e-08 $layer=M1 $thickness=3.6e-08 $X=0.351
+ $Y=0.108 $X2=0.351 $Y2=0.1215
r3 28 29 4.4889 $w=1.3e-08 $l=1.92e-08 $layer=M1 $thickness=3.6e-08 $X=0.353
+ $Y=0.151 $X2=0.351 $Y2=0.1702
r4 28 27 0.874462 $w=1.3e-08 $l=3.8e-09 $layer=M1 $thickness=3.6e-08 $X=0.353
+ $Y=0.151 $X2=0.351 $Y2=0.1472
r5 26 27 2.85657 $w=1.3e-08 $l=1.22e-08 $layer=M1 $thickness=3.6e-08 $X=0.351
+ $Y=0.135 $X2=0.351 $Y2=0.1472
r6 7 26 3.14806 $w=1.3e-08 $l=1.35e-08 $layer=M1 $thickness=3.6e-08 $X=0.351
+ $Y=0.1215 $X2=0.351 $Y2=0.135
r7 22 23 14.6259 $w=2.1e-08 $l=4.3e-08 $layer=Gate_1 $thickness=5.6e-08
+ $X=0.351 $Y=0.0675 $X2=0.351 $Y2=0.1105
r8 20 23 2.7211 $w=2.1e-08 $l=8e-09 $layer=Gate_1 $thickness=5.6e-08 $X=0.351
+ $Y=0.1185 $X2=0.351 $Y2=0.1105
r9 4 17 6.27904 $w=2.09e-08 $layer=Gate_1 $thickness=5.24e-08 $X=0.351 $Y=0.135
+ $X2=0.351 $Y2=0.135
r10 4 20 5.79936 $w=2.03333e-08 $l=1.65e-08 $layer=Gate_1 $thickness=5.6e-08
+ $X=0.351 $Y=0.135 $X2=0.351 $Y2=0.1185
r11 17 26 19.3796 $a=3.24e-16 $layer=V0LIG $X=0.351 $Y=0.135 $X2=0.351 $Y2=0.135
r12 16 17 2.48102 $w=2.2e-08 $l=9.5e-09 $layer=LIG $thickness=4.8e-08 $X=0.3415
+ $Y=0.135 $X2=0.351 $Y2=0.135
r13 15 16 10.1729 $w=1.54914e-08 $l=1.75e-08 $layer=LIG $thickness=4.8e-08
+ $X=0.324 $Y=0.135 $X2=0.3415 $Y2=0.135
r14 1 10 6.54019 $w=2.09524e-08 $layer=Gate_1 $thickness=5.21905e-08 $X=0.297
+ $Y=0.135 $X2=0.297 $Y2=0.135
r15 1 15 12.6539 $w=1.77815e-08 $l=2.7e-08 $layer=LIG $thickness=4.8e-08
+ $X=0.297 $Y=0.135 $X2=0.324 $Y2=0.135
r16 12 11 16.4967 $w=2.1e-08 $l=4.85e-08 $layer=Gate_1 $thickness=5.6e-08
+ $X=0.297 $Y=0.2025 $X2=0.297 $Y2=0.154
r17 10 11 6.6497 $w=2.04211e-08 $l=1.9e-08 $layer=Gate_1 $thickness=5.6e-08
+ $X=0.297 $Y=0.135 $X2=0.297 $Y2=0.154
r18 9 10 6.6497 $w=2.04211e-08 $l=1.9e-08 $layer=Gate_1 $thickness=5.6e-08
+ $X=0.297 $Y=0.116 $X2=0.297 $Y2=0.135
r19 8 9 16.4967 $w=2.1e-08 $l=4.85e-08 $layer=Gate_1 $thickness=5.6e-08
+ $X=0.297 $Y=0.0675 $X2=0.297 $Y2=0.116
r20 8 3 14.6259 $w=2.1e-08 $l=4.3e-08 $layer=Gate_1 $thickness=5.6e-08 $X=0.297
+ $Y=0.0675 $X2=0.297 $Y2=0.0245
.ends

.subckt PM_OA221x2_ASAP7_75t_R%B2 vss 28 8 12 22 4 7 1 6 3
c1 1 vss 0.0107493f $X=0.567 $Y=0.135
c2 3 vss 0.0965739f $X=0.513 $Y=0.135
c3 4 vss 0.103351f $X=0.567 $Y=0.0245
c4 5 vss 0.007158f $X=0.513 $Y=0.108
c5 6 vss 0.00189471f $X=0.513 $Y=0.198
c6 7 vss 0.00338276f $X=0.513 $Y=0.1215
r1 6 29 5.29071 $w=1.46216e-08 $l=2.78e-08 $layer=M1 $thickness=3.6e-08
+ $X=0.513 $Y=0.198 $X2=0.513 $Y2=0.1702
r2 5 7 1.96775 $w=1.63333e-08 $l=1.35e-08 $layer=M1 $thickness=3.6e-08 $X=0.513
+ $Y=0.108 $X2=0.513 $Y2=0.1215
r3 28 29 4.4889 $w=1.3e-08 $l=1.92e-08 $layer=M1 $thickness=3.6e-08 $X=0.511
+ $Y=0.151 $X2=0.513 $Y2=0.1702
r4 28 27 0.874462 $w=1.3e-08 $l=3.8e-09 $layer=M1 $thickness=3.6e-08 $X=0.511
+ $Y=0.151 $X2=0.513 $Y2=0.1472
r5 26 27 2.85657 $w=1.3e-08 $l=1.22e-08 $layer=M1 $thickness=3.6e-08 $X=0.513
+ $Y=0.135 $X2=0.513 $Y2=0.1472
r6 7 26 3.14806 $w=1.3e-08 $l=1.35e-08 $layer=M1 $thickness=3.6e-08 $X=0.513
+ $Y=0.1215 $X2=0.513 $Y2=0.135
r7 22 23 14.6259 $w=2.1e-08 $l=4.3e-08 $layer=Gate_1 $thickness=5.6e-08
+ $X=0.513 $Y=0.0675 $X2=0.513 $Y2=0.1105
r8 20 23 2.7211 $w=2.1e-08 $l=8e-09 $layer=Gate_1 $thickness=5.6e-08 $X=0.513
+ $Y=0.1185 $X2=0.513 $Y2=0.1105
r9 3 16 6.27904 $w=2.09e-08 $layer=Gate_1 $thickness=5.24e-08 $X=0.513 $Y=0.135
+ $X2=0.513 $Y2=0.135
r10 3 20 5.79936 $w=2.03333e-08 $l=1.65e-08 $layer=Gate_1 $thickness=5.6e-08
+ $X=0.513 $Y=0.135 $X2=0.513 $Y2=0.1185
r11 16 17 2.48102 $w=2.2e-08 $l=9.5e-09 $layer=LIG $thickness=4.8e-08 $X=0.513
+ $Y=0.135 $X2=0.5225 $Y2=0.135
r12 16 26 19.3796 $a=3.24e-16 $layer=V0LIG $X=0.513 $Y=0.135 $X2=0.513 $Y2=0.135
r13 14 17 10.1729 $w=1.54914e-08 $l=1.75e-08 $layer=LIG $thickness=4.8e-08
+ $X=0.54 $Y=0.135 $X2=0.5225 $Y2=0.135
r14 1 10 6.54019 $w=2.09524e-08 $layer=Gate_1 $thickness=5.21905e-08 $X=0.567
+ $Y=0.135 $X2=0.567 $Y2=0.135
r15 1 14 12.6539 $w=1.77815e-08 $l=2.7e-08 $layer=LIG $thickness=4.8e-08
+ $X=0.567 $Y=0.135 $X2=0.54 $Y2=0.135
r16 12 11 16.4967 $w=2.1e-08 $l=4.85e-08 $layer=Gate_1 $thickness=5.6e-08
+ $X=0.567 $Y=0.2025 $X2=0.567 $Y2=0.154
r17 10 11 6.6497 $w=2.04211e-08 $l=1.9e-08 $layer=Gate_1 $thickness=5.6e-08
+ $X=0.567 $Y=0.135 $X2=0.567 $Y2=0.154
r18 9 10 6.6497 $w=2.04211e-08 $l=1.9e-08 $layer=Gate_1 $thickness=5.6e-08
+ $X=0.567 $Y=0.116 $X2=0.567 $Y2=0.135
r19 8 9 16.4967 $w=2.1e-08 $l=4.85e-08 $layer=Gate_1 $thickness=5.6e-08
+ $X=0.567 $Y=0.0675 $X2=0.567 $Y2=0.116
r20 8 4 14.6259 $w=2.1e-08 $l=4.3e-08 $layer=Gate_1 $thickness=5.6e-08 $X=0.567
+ $Y=0.0675 $X2=0.567 $Y2=0.0245
.ends

* End of included file OA221x2_ASAP7_75t_R.pex.sp.pex

*
.subckt OA221x2_ASAP7_75t_CUSTOM_4_25_0_7 VSS VDD A1 A2 B2 B1 C Y
*
* VSS VSS
* VDD VDD
* A1 A1
* A2 A2
* B2 B2
* B1 B1
* C C
* Y Y
*
*

M0 N_M0_d N_M0_g VSS VSS nmos_rvt L=2e-08 W=8.1e-08 nfin=3 $X=0.071 $Y=0.027
M1 N_M1_d N_M1_g VSS VSS nmos_rvt L=2e-08 W=8.1e-08 nfin=3 $X=0.125 $Y=0.027
M2 noxref_10 N_M2_g VSS VSS nmos_rvt L=2e-08 W=8.1e-08 nfin=3 $X=0.179 $Y=0.027
M3 noxref_10 N_M3_g VSS VSS nmos_rvt L=2e-08 W=8.1e-08 nfin=3 $X=0.233 $Y=0.027
M4 noxref_10 N_M4_g VSS VSS nmos_rvt L=2e-08 W=8.1e-08 nfin=3 $X=0.287 $Y=0.027
M5 noxref_10 N_M5_g VSS VSS nmos_rvt L=2e-08 W=8.1e-08 nfin=3 $X=0.341 $Y=0.027
M6 noxref_10 N_M6_g noxref_11 VSS nmos_rvt L=2e-08 W=8.1e-08 nfin=3 $X=0.503
+ $Y=0.027
M7 noxref_10 N_M7_g noxref_11 VSS nmos_rvt L=2e-08 W=8.1e-08 nfin=3 $X=0.557
+ $Y=0.027
M8 noxref_10 N_M8_g noxref_11 VSS nmos_rvt L=2e-08 W=8.1e-08 nfin=3 $X=0.611
+ $Y=0.027
M9 noxref_10 N_M9_g noxref_11 VSS nmos_rvt L=2e-08 W=8.1e-08 nfin=3 $X=0.665
+ $Y=0.027
M10 N_M10_d N_M10_g noxref_11 VSS nmos_rvt L=2e-08 W=8.1e-08 nfin=3 $X=0.719
+ $Y=0.027
M11 N_M11_d N_M11_g noxref_11 VSS nmos_rvt L=2e-08 W=8.1e-08 nfin=3 $X=0.773
+ $Y=0.027
M12 N_M12_d N_M12_g VDD VDD pmos_rvt L=2e-08 W=8.1e-08 nfin=3 $X=0.071 $Y=0.162
M13 N_M13_d N_M13_g VDD VDD pmos_rvt L=2e-08 W=8.1e-08 nfin=3 $X=0.125 $Y=0.162
M14 noxref_12 N_M14_g VDD VDD pmos_rvt L=2e-08 W=8.1e-08 nfin=3 $X=0.179
+ $Y=0.162
M15 N_M15_d N_M15_g noxref_12 VDD pmos_rvt L=2e-08 W=8.1e-08 nfin=3 $X=0.287
+ $Y=0.162
M16 noxref_13 N_M16_g N_M16_s VDD pmos_rvt L=2e-08 W=8.1e-08 nfin=3 $X=0.557
+ $Y=0.162
M17 VDD N_M17_g noxref_13 VDD pmos_rvt L=2e-08 W=8.1e-08 nfin=3 $X=0.611
+ $Y=0.162
M18 N_M18_d N_M18_g VDD VDD pmos_rvt L=2e-08 W=5.4e-08 nfin=2 $X=0.719 $Y=0.189

* .include "OA221x2_ASAP7_75t_R.pex.sp.pxi"

* Start of included file OA221x2_ASAP7_75t_R.pex.sp.pxi
x_PM_OA221x2_ASAP7_75t_R%A1 vss A1 N_M2_g N_M14_g N_M3_g N_A1_6 N_A1_1 N_A1_3
+ N_A1_4 PM_OA221x2_ASAP7_75t_R%A1
cc_1 N_A1_6 N_3_1 0.000182725f $X=0.243 $Y=0.198
cc_2 N_A1_6 N_3_23 0.000732081f $X=0.243 $Y=0.198
cc_3 N_A1_6 N_3_27 0.000665536f $X=0.243 $Y=0.198
cc_4 N_A1_1 N_3_1 0.00191885f $X=0.189 $Y=0.135
cc_5 N_A1_3 N_3_18 0.00343796f $X=0.189 $Y=0.0245
cc_6 N_A1_6 N_3_28 0.00594836f $X=0.243 $Y=0.198
x_PM_OA221x2_ASAP7_75t_R%B1 vss B1 N_M8_g N_M17_g N_M9_g N_B1_6 N_B1_1 N_B1_3
+ N_B1_4 PM_OA221x2_ASAP7_75t_R%B1
cc_7 N_B1_6 N_3_4 0.000226689f $X=0.621 $Y=0.198
cc_8 N_B1_6 N_3_7 0.000327282f $X=0.621 $Y=0.198
cc_9 N_B1_6 N_3_21 0.00042056f $X=0.621 $Y=0.198
cc_10 N_B1_6 N_3_28 0.0060291f $X=0.621 $Y=0.198
cc_11 N_B1_1 N_B2_4 0.0011901f $X=0.6115 $Y=0.135
cc_12 N_B1_3 N_B2_4 0.00696418f $X=0.621 $Y=0.0245
x_PM_OA221x2_ASAP7_75t_R%C vss C N_M10_g N_M18_g N_M11_g N_C_4 N_C_1 N_C_3
+ N_C_5 N_C_6 PM_OA221x2_ASAP7_75t_R%C
cc_13 N_C_4 N_3_8 0.000867783f $X=0.783 $Y=0.135
cc_14 N_C_4 N_3_9 0.00282073f $X=0.783 $Y=0.135
cc_15 N_C_4 N_3_22 0.0157942f $X=0.783 $Y=0.135
cc_16 N_C_1 N_3_30 0.0011087f $X=0.7195 $Y=0.135
cc_17 N_C_3 N_3_8 0.0018284f $X=0.729 $Y=0.0245
cc_18 N_C_5 N_3_29 0.00329426f $X=0.729 $Y=0.108
cc_19 N_C_1 N_3_19 0.00385014f $X=0.7195 $Y=0.135
cc_20 N_C_6 N_3_28 0.0052555f $X=0.729 $Y=0.198
cc_21 N_C_3 N_3_22 0.00788102f $X=0.729 $Y=0.0245
cc_22 N_C_3 N_3_19 0.0330843f $X=0.729 $Y=0.0245
cc_23 N_C_4 N_3_19 0.0644596f $X=0.783 $Y=0.135
cc_24 N_C_3 N_B1_4 0.00586353f $X=0.729 $Y=0.0245
x_PM_OA221x2_ASAP7_75t_R%3 vss N_M0_g N_M12_g N_M1_g N_M13_g N_M16_s N_M18_d
+ N_M15_d N_M10_d N_M11_d N_3_1 N_3_23 N_3_27 N_3_18 N_3_28 N_3_6 N_3_5 N_3_3
+ N_3_20 N_3_7 N_3_4 N_3_21 N_3_8 N_3_9 N_3_22 N_3_30 N_3_29 N_3_19 N_3_24
+ N_3_17 PM_OA221x2_ASAP7_75t_R%3
x_PM_OA221x2_ASAP7_75t_R%Y vss Y N_M0_d N_M1_d N_M12_d N_M13_d N_Y_7 N_Y_15
+ N_Y_8 PM_OA221x2_ASAP7_75t_R%Y
cc_25 N_Y_7 N_3_27 0.000593657f $X=0.0935 $Y=0.0675
cc_26 N_Y_7 N_3_1 0.0063418f $X=0.0935 $Y=0.0675
cc_27 N_Y_7 N_3_23 0.000965438f $X=0.0935 $Y=0.0675
cc_28 N_Y_7 N_3_24 0.00110612f $X=0.0935 $Y=0.0675
cc_29 N_Y_7 N_3_18 0.0201603f $X=0.0935 $Y=0.0675
cc_30 N_Y_15 N_3_27 0.0027312f $X=0.108 $Y=0.207
cc_31 N_Y_8 N_3_17 0.0290273f $X=0.0935 $Y=0.2025
cc_32 N_Y_8 N_3_18 0.0367282f $X=0.0935 $Y=0.2025
cc_33 N_Y_7 N_3_17 0.0515976f $X=0.0935 $Y=0.0675
x_PM_OA221x2_ASAP7_75t_R%A2 vss A2 N_M4_g N_M15_g N_M5_g N_A2_3 N_A2_7 N_A2_1
+ N_A2_6 N_A2_4 PM_OA221x2_ASAP7_75t_R%A2
cc_34 N_A2_3 N_3_6 0.000510052f $X=0.297 $Y=0.0245
cc_35 N_A2_3 N_3_5 0.000700715f $X=0.297 $Y=0.0245
cc_36 N_A2_3 N_3_3 0.0012154f $X=0.297 $Y=0.0245
cc_37 N_A2_7 N_3_6 0.00130864f $X=0.351 $Y=0.1215
cc_38 N_A2_1 N_3_20 0.00341703f $X=0.297 $Y=0.135
cc_39 N_A2_6 N_3_6 0.00361085f $X=0.351 $Y=0.198
cc_40 N_A2_6 N_3_28 0.00560684f $X=0.351 $Y=0.198
cc_41 N_A2_4 N_3_20 0.0204811f $X=0.351 $Y=0.135
cc_42 N_A2_3 N_3_20 0.0529525f $X=0.297 $Y=0.0245
cc_43 N_A2_3 N_A1_4 0.00582987f $X=0.297 $Y=0.0245
x_PM_OA221x2_ASAP7_75t_R%B2 vss B2 N_M7_g N_M16_g N_M6_g N_B2_4 N_B2_7 N_B2_1
+ N_B2_6 N_B2_3 PM_OA221x2_ASAP7_75t_R%B2
cc_44 N_B2_4 N_3_7 0.00113111f $X=0.567 $Y=0.0245
cc_45 N_B2_4 N_3_6 0.000612646f $X=0.567 $Y=0.0245
cc_46 N_B2_7 N_3_6 0.00125327f $X=0.513 $Y=0.1215
cc_47 N_B2_1 N_3_4 0.00131734f $X=0.567 $Y=0.135
cc_48 N_B2_4 N_3_28 0.00154897f $X=0.567 $Y=0.0245
cc_49 N_B2_1 N_3_21 0.00356435f $X=0.567 $Y=0.135
cc_50 N_B2_6 N_3_6 0.00360379f $X=0.513 $Y=0.198
cc_51 N_B2_6 N_3_28 0.00403603f $X=0.513 $Y=0.198
cc_52 N_B2_3 N_3_21 0.0204729f $X=0.513 $Y=0.135
cc_53 N_B2_4 N_3_21 0.0529613f $X=0.567 $Y=0.0245

* End of included file OA221x2_ASAP7_75t_R.pex.sp.pxi
.ends

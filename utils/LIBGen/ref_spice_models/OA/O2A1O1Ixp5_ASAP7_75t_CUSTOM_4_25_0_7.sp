.subckt PM_O2A1O1Ixp5_ASAP7_75t_R%A2 vss 24 6 10 20 3 1 4 5
c1 1 vss 0.0147832f $X=0.189 $Y=0.135
c2 3 vss 0.0858396f $X=0.135 $Y=0.135
c3 4 vss 0.12293f $X=0.189 $Y=0.0245
c4 5 vss 0.00562222f $X=0.135 $Y=0.116
r1 24 23 0.757867 $w=1.3e-08 $l=3.3e-09 $layer=M1 $thickness=3.6e-08 $X=0.139
+ $Y=0.15 $X2=0.135 $Y2=0.1467
r2 22 23 2.73998 $w=1.3e-08 $l=1.17e-08 $layer=M1 $thickness=3.6e-08 $X=0.135
+ $Y=0.135 $X2=0.135 $Y2=0.1467
r3 5 22 4.43061 $w=1.3e-08 $l=1.9e-08 $layer=M1 $thickness=3.6e-08 $X=0.135
+ $Y=0.116 $X2=0.135 $Y2=0.135
r4 20 19 16.4967 $w=2.1e-08 $l=4.85e-08 $layer=Gate_1 $thickness=5.6e-08
+ $X=0.135 $Y=0.2025 $X2=0.135 $Y2=0.154
r5 3 14 6.27904 $w=2.09e-08 $layer=Gate_1 $thickness=5.24e-08 $X=0.135 $Y=0.135
+ $X2=0.135 $Y2=0.135
r6 3 19 6.6497 $w=2.04211e-08 $l=1.9e-08 $layer=Gate_1 $thickness=5.6e-08
+ $X=0.135 $Y=0.135 $X2=0.135 $Y2=0.154
r7 14 15 2.48102 $w=2.2e-08 $l=9.5e-09 $layer=LIG $thickness=4.8e-08 $X=0.135
+ $Y=0.135 $X2=0.1445 $Y2=0.135
r8 14 22 19.3796 $a=3.24e-16 $layer=V0LIG $X=0.135 $Y=0.135 $X2=0.135 $Y2=0.135
r9 12 15 10.1729 $w=1.54914e-08 $l=1.75e-08 $layer=LIG $thickness=4.8e-08
+ $X=0.162 $Y=0.135 $X2=0.1445 $Y2=0.135
r10 1 8 6.54019 $w=2.09524e-08 $layer=Gate_1 $thickness=5.21905e-08 $X=0.189
+ $Y=0.135 $X2=0.189 $Y2=0.135
r11 1 12 12.6539 $w=1.77815e-08 $l=2.7e-08 $layer=LIG $thickness=4.8e-08
+ $X=0.189 $Y=0.135 $X2=0.162 $Y2=0.135
r12 10 9 16.4967 $w=2.1e-08 $l=4.85e-08 $layer=Gate_1 $thickness=5.6e-08
+ $X=0.189 $Y=0.2025 $X2=0.189 $Y2=0.154
r13 8 9 6.6497 $w=2.04211e-08 $l=1.9e-08 $layer=Gate_1 $thickness=5.6e-08
+ $X=0.189 $Y=0.135 $X2=0.189 $Y2=0.154
r14 7 8 6.6497 $w=2.04211e-08 $l=1.9e-08 $layer=Gate_1 $thickness=5.6e-08
+ $X=0.189 $Y=0.116 $X2=0.189 $Y2=0.135
r15 6 7 16.4967 $w=2.1e-08 $l=4.85e-08 $layer=Gate_1 $thickness=5.6e-08
+ $X=0.189 $Y=0.0675 $X2=0.189 $Y2=0.116
r16 6 4 14.6259 $w=2.1e-08 $l=4.3e-08 $layer=Gate_1 $thickness=5.6e-08 $X=0.189
+ $Y=0.0675 $X2=0.189 $Y2=0.0245
.ends

.subckt PM_O2A1O1Ixp5_ASAP7_75t_R%B vss 11 5 9 4 3
c1 1 vss 0.00968896f $X=0.297 $Y=0.135
c2 3 vss 0.0867438f $X=0.297 $Y=0.0245
c3 4 vss 0.00669471f $X=0.297 $Y=0.098
r1 11 4 8.62802 $w=1.3e-08 $l=3.7e-08 $layer=M1 $thickness=3.6e-08 $X=0.296
+ $Y=0.128 $X2=0.297 $Y2=0.098
r2 1 7 10.4265 $w=1.765e-08 $layer=LIG $thickness=5.2e-08 $X=0.297 $Y=0.135
+ $X2=0.297 $Y2=0.135
r3 11 1 19.3796 $a=3.24e-16 $layer=V0LIG $X=0.296 $Y=0.128 $X2=0.297 $Y2=0.135
r4 9 8 16.4967 $w=2.1e-08 $l=4.85e-08 $layer=Gate_1 $thickness=5.6e-08 $X=0.297
+ $Y=0.2025 $X2=0.297 $Y2=0.154
r5 7 8 6.6497 $w=2.04211e-08 $l=1.9e-08 $layer=Gate_1 $thickness=5.6e-08
+ $X=0.297 $Y=0.135 $X2=0.297 $Y2=0.154
r6 6 7 6.6497 $w=2.04211e-08 $l=1.9e-08 $layer=Gate_1 $thickness=5.6e-08
+ $X=0.297 $Y=0.116 $X2=0.297 $Y2=0.135
r7 5 6 16.4967 $w=2.1e-08 $l=4.85e-08 $layer=Gate_1 $thickness=5.6e-08 $X=0.297
+ $Y=0.0675 $X2=0.297 $Y2=0.116
r8 5 3 14.6259 $w=2.1e-08 $l=4.3e-08 $layer=Gate_1 $thickness=5.6e-08 $X=0.297
+ $Y=0.0675 $X2=0.297 $Y2=0.0245
.ends

.subckt PM_O2A1O1Ixp5_ASAP7_75t_R%Y vss 29 16 19 40 1 7 9 2 14 10
c1 1 vss 0.00657003f $X=0.324 $Y=0.054
c2 2 vss 0.00916992f $X=0.378 $Y=0.2025
c3 7 vss 0.00263336f $X=0.3095 $Y=0.0725
c4 8 vss 0.000111908f $X=0.3095 $Y=0.0455
c5 9 vss 0.000276733f $X=0.3095 $Y=0.0945
c6 10 vss 0.0375977f $X=0.3635 $Y=0.2025
c7 11 vss 0.00659934f $X=0.405 $Y=0.234
c8 12 vss 0.00294496f $X=0.405 $Y=0.0357
c9 13 vss 0.00759816f $X=0.324 $Y=0.036
c10 14 vss 0.00639054f $X=0.405 $Y=0.0452
r1 10 2 0.154321 $w=8.1e-08 $l=1.25e-08 $layer=P_src_drn $thickness=1e-09
+ $X=0.3635 $Y=0.2025 $X2=0.378 $Y2=0.2025
r2 40 10 0.0308642 $w=8.1e-08 $l=2.5e-09 $layer=P_src_drn $thickness=1e-09
+ $X=0.3606 $Y=0.2025 $X2=0.3635 $Y2=0.2025
r3 2 37 19.3796 $a=3.24e-16 $layer=V0LISD $X=0.378 $Y=0.2025 $X2=0.378 $Y2=0.234
r4 37 38 3.14806 $w=1.3e-08 $l=1.35e-08 $layer=M1 $thickness=3.6e-08 $X=0.378
+ $Y=0.234 $X2=0.3915 $Y2=0.234
r5 11 35 3.01711 $w=1.55e-08 $l=1.8e-08 $layer=M1 $thickness=3.6e-08 $X=0.405
+ $Y=0.234 $X2=0.405 $Y2=0.216
r6 11 38 1.96775 $w=1.63333e-08 $l=1.35e-08 $layer=M1 $thickness=3.6e-08
+ $X=0.405 $Y=0.234 $X2=0.3915 $Y2=0.234
r7 34 35 4.19742 $w=1.3e-08 $l=1.8e-08 $layer=M1 $thickness=3.6e-08 $X=0.405
+ $Y=0.198 $X2=0.405 $Y2=0.216
r8 33 34 5.01358 $w=1.3e-08 $l=2.15e-08 $layer=M1 $thickness=3.6e-08 $X=0.405
+ $Y=0.1765 $X2=0.405 $Y2=0.198
r9 32 33 13.8748 $w=1.3e-08 $l=5.95e-08 $layer=M1 $thickness=3.6e-08 $X=0.405
+ $Y=0.117 $X2=0.405 $Y2=0.1765
r10 31 32 11.7761 $w=1.3e-08 $l=5.05e-08 $layer=M1 $thickness=3.6e-08 $X=0.405
+ $Y=0.0665 $X2=0.405 $Y2=0.117
r11 30 31 2.85657 $w=1.3e-08 $l=1.23e-08 $layer=M1 $thickness=3.6e-08 $X=0.405
+ $Y=0.0542 $X2=0.405 $Y2=0.0665
r12 14 30 2.09871 $w=1.3e-08 $l=9e-09 $layer=M1 $thickness=3.6e-08 $X=0.405
+ $Y=0.0452 $X2=0.405 $Y2=0.0542
r13 29 14 0.0838086 $w=1.55e-08 $l=5e-10 $layer=M1 $thickness=3.6e-08 $X=0.405
+ $Y=0.045 $X2=0.405 $Y2=0.0452
r14 29 12 0.9184 $w=1.8e-08 $l=9e-09 $layer=M1 $thickness=3.6e-08 $X=0.405
+ $Y=0.045 $X2=0.405 $Y2=0.0357
r15 29 28 3.75655 $w=8.5e-09 $l=2.64706e-08 $layer=M1 $thickness=3.6e-08
+ $X=0.405 $Y=0.045 $X2=0.38 $Y2=0.036
r16 27 28 4.19742 $w=1.3e-08 $l=1.8e-08 $layer=M1 $thickness=3.6e-08 $X=0.362
+ $Y=0.036 $X2=0.38 $Y2=0.036
r17 26 27 2.56509 $w=1.3e-08 $l=1.1e-08 $layer=M1 $thickness=3.6e-08 $X=0.351
+ $Y=0.036 $X2=0.362 $Y2=0.036
r18 25 26 2.56509 $w=1.3e-08 $l=1.1e-08 $layer=M1 $thickness=3.6e-08 $X=0.34
+ $Y=0.036 $X2=0.351 $Y2=0.036
r19 24 25 1.04935 $w=1.3e-08 $l=4.5e-09 $layer=M1 $thickness=3.6e-08 $X=0.3355
+ $Y=0.036 $X2=0.34 $Y2=0.036
r20 13 24 2.68168 $w=1.3e-08 $l=1.15e-08 $layer=M1 $thickness=3.6e-08 $X=0.324
+ $Y=0.036 $X2=0.3355 $Y2=0.036
r21 1 13 19.3796 $a=3.24e-16 $layer=V0LISD $X=0.324 $Y=0.054 $X2=0.324 $Y2=0.036
r22 9 1 0.462963 $w=2.7e-08 $l=1.25e-08 $layer=N_src_drn $thickness=1e-09
+ $X=0.3095 $Y=0.0945 $X2=0.324 $Y2=0.054
r23 8 1 0.245304 $w=3.7e-08 $l=1.45e-08 $layer=N_src_drn $thickness=1e-09
+ $X=0.3095 $Y=0.0455 $X2=0.324 $Y2=0.054
r24 19 18 0.147059 $w=1.7e-08 $l=2.5e-09 $layer=N_src_drn $thickness=1e-09
+ $X=0.3413 $Y=0.054 $X2=0.3385 $Y2=0.0725
r25 17 18 0.264706 $w=1.7e-08 $l=4.5e-09 $layer=N_src_drn $thickness=1e-09
+ $X=0.334 $Y=0.0725 $X2=0.3385 $Y2=0.0725
r26 1 17 0.705882 $w=1.7e-08 $l=1.2e-08 $layer=N_src_drn $thickness=1e-09
+ $X=0.324 $Y=0.054 $X2=0.334 $Y2=0.0725
r27 7 1 0.735294 $w=1.7e-08 $l=1.25e-08 $layer=N_src_drn $thickness=1e-09
+ $X=0.3095 $Y=0.0725 $X2=0.324 $Y2=0.054
r28 16 7 0.147059 $w=1.7e-08 $l=2.5e-09 $layer=N_src_drn $thickness=1e-09
+ $X=0.3066 $Y=0.0675 $X2=0.3095 $Y2=0.0725
.ends

.subckt PM_O2A1O1Ixp5_ASAP7_75t_R%9 vss 11 18 19 1 8 2 9 7
c1 1 vss 0.00664346f $X=0.162 $Y=0.0675
c2 2 vss 0.00638138f $X=0.27 $Y=0.0675
c3 7 vss 0.00325381f $X=0.164 $Y=0.0675
c4 8 vss 0.00312953f $X=0.2555 $Y=0.0675
c5 9 vss 0.0116561f $X=0.1505 $Y=0.036
r1 19 17 0.0308642 $w=8.1e-08 $l=2.5e-09 $layer=N_src_drn $thickness=1e-09
+ $X=0.2873 $Y=0.0675 $X2=0.2845 $Y2=0.0675
r2 2 17 0.179012 $w=8.1e-08 $l=1.45e-08 $layer=N_src_drn $thickness=1e-09
+ $X=0.27 $Y=0.0675 $X2=0.2845 $Y2=0.0675
r3 8 2 0.179012 $w=8.1e-08 $l=1.45e-08 $layer=N_src_drn $thickness=1e-09
+ $X=0.2555 $Y=0.0675 $X2=0.27 $Y2=0.0675
r4 18 8 0.0308642 $w=8.1e-08 $l=2.5e-09 $layer=N_src_drn $thickness=1e-09
+ $X=0.2526 $Y=0.0675 $X2=0.2555 $Y2=0.0675
r5 2 15 19.3796 $a=3.24e-16 $layer=V0LISD $X=0.27 $Y=0.0675 $X2=0.27 $Y2=0.036
r6 14 15 3.14806 $w=1.3e-08 $l=1.35e-08 $layer=M1 $thickness=3.6e-08 $X=0.2565
+ $Y=0.036 $X2=0.27 $Y2=0.036
r7 13 14 10.4935 $w=1.3e-08 $l=4.5e-08 $layer=M1 $thickness=3.6e-08 $X=0.2115
+ $Y=0.036 $X2=0.2565 $Y2=0.036
r8 12 13 11.5429 $w=1.3e-08 $l=4.95e-08 $layer=M1 $thickness=3.6e-08 $X=0.162
+ $Y=0.036 $X2=0.2115 $Y2=0.036
r9 9 12 2.68168 $w=1.3e-08 $l=1.15e-08 $layer=M1 $thickness=3.6e-08 $X=0.1505
+ $Y=0.036 $X2=0.162 $Y2=0.036
r10 1 12 19.3796 $a=3.24e-16 $layer=V0LISD $X=0.162 $Y=0.0675 $X2=0.162
+ $Y2=0.036
r11 11 10 0.0308642 $w=8.1e-08 $l=2.5e-09 $layer=N_src_drn $thickness=1e-09
+ $X=0.1793 $Y=0.0675 $X2=0.1765 $Y2=0.0675
r12 7 10 0.154321 $w=8.1e-08 $l=1.25e-08 $layer=N_src_drn $thickness=1e-09
+ $X=0.164 $Y=0.0675 $X2=0.1765 $Y2=0.0675
r13 1 7 1e-05 $l=2e-09 $X=0.162 $Y=0.0675 $X2=0.164 $Y2=0.0675
.ends

.subckt PM_O2A1O1Ixp5_ASAP7_75t_R%A1 vss 25 12 16 37 10 2 6 9 5 11 8
c1 1 vss 0.00562234f $X=0.081 $Y=0.135
c2 2 vss 0.00579474f $X=0.243 $Y=0.135
c3 5 vss 0.0972989f $X=0.081 $Y=0.135
c4 6 vss 0.119368f $X=0.243 $Y=0.0245
c5 7 vss 0.00264017f $X=0.081 $Y=0.072
c6 8 vss 0.00101979f $X=0.243 $Y=0.0755
c7 9 vss 0.0116082f $X=0.081 $Y=0.0935
c8 10 vss 0.00642575f $X=0.191 $Y=0.072
c9 11 vss 0.0058642f $X=0.243 $Y=0.116
r1 37 36 14.6259 $w=2.1e-08 $l=4.3e-08 $layer=Gate_1 $thickness=5.6e-08
+ $X=0.081 $Y=0.2025 $X2=0.081 $Y2=0.1595
r2 35 36 2.7211 $w=2.1e-08 $l=8e-09 $layer=Gate_1 $thickness=5.6e-08 $X=0.081
+ $Y=0.1515 $X2=0.081 $Y2=0.1595
r3 5 35 5.79936 $w=2.03333e-08 $l=1.65e-08 $layer=Gate_1 $thickness=5.6e-08
+ $X=0.081 $Y=0.135 $X2=0.081 $Y2=0.1515
r4 1 29 19.3796 $a=3.24e-16 $layer=V0LIG $X=0.081 $Y=0.135 $X2=0.081 $Y2=0.135
r5 1 5 10.4265 $w=1.765e-08 $layer=LIG $thickness=5.2e-08 $X=0.081 $Y=0.135
+ $X2=0.081 $Y2=0.135
r6 28 29 4.43061 $w=1.3e-08 $l=1.9e-08 $layer=M1 $thickness=3.6e-08 $X=0.081
+ $Y=0.116 $X2=0.081 $Y2=0.135
r7 9 28 5.24677 $w=1.3e-08 $l=2.25e-08 $layer=M1 $thickness=3.6e-08 $X=0.081
+ $Y=0.0935 $X2=0.081 $Y2=0.116
r8 7 27 0.915974 $w=1.70909e-08 $l=1.1e-08 $layer=M1 $thickness=3.6e-08
+ $X=0.081 $Y=0.072 $X2=0.092 $Y2=0.072
r9 7 9 3.36447 $w=1.71023e-08 $l=2.15e-08 $layer=M1 $thickness=3.6e-08 $X=0.081
+ $Y=0.072 $X2=0.081 $Y2=0.0935
r10 25 26 2.73998 $w=1.3e-08 $l=1.17e-08 $layer=M1 $thickness=3.6e-08 $X=0.103
+ $Y=0.072 $X2=0.1147 $Y2=0.072
r11 25 24 1.10765 $w=1.3e-08 $l=4.8e-09 $layer=M1 $thickness=3.6e-08 $X=0.103
+ $Y=0.072 $X2=0.0982 $Y2=0.072
r12 24 27 1.45744 $w=1.3e-08 $l=6.2e-09 $layer=M1 $thickness=3.6e-08 $X=0.0982
+ $Y=0.072 $X2=0.092 $Y2=0.072
r13 23 26 4.72209 $w=1.3e-08 $l=2.03e-08 $layer=M1 $thickness=3.6e-08 $X=0.135
+ $Y=0.072 $X2=0.1147 $Y2=0.072
r14 22 23 2.56509 $w=1.3e-08 $l=1.1e-08 $layer=M1 $thickness=3.6e-08 $X=0.146
+ $Y=0.072 $X2=0.135 $Y2=0.072
r15 10 22 10.4935 $w=1.3e-08 $l=4.5e-08 $layer=M1 $thickness=3.6e-08 $X=0.191
+ $Y=0.072 $X2=0.146 $Y2=0.072
r16 8 20 3.47612 $w=1.45278e-08 $l=1.8e-08 $layer=M1 $thickness=3.6e-08
+ $X=0.243 $Y=0.0755 $X2=0.243 $Y2=0.0935
r17 8 10 10.5884 $w=1.3567e-08 $l=5.21177e-08 $layer=M1 $thickness=3.6e-08
+ $X=0.243 $Y=0.0755 $X2=0.191 $Y2=0.072
r18 11 18 4.43061 $w=1.3e-08 $l=1.9e-08 $layer=M1 $thickness=3.6e-08 $X=0.243
+ $Y=0.116 $X2=0.243 $Y2=0.135
r19 11 20 5.24677 $w=1.3e-08 $l=2.25e-08 $layer=M1 $thickness=3.6e-08 $X=0.243
+ $Y=0.116 $X2=0.243 $Y2=0.0935
r20 2 14 10.4265 $w=1.765e-08 $layer=LIG $thickness=5.2e-08 $X=0.243 $Y=0.135
+ $X2=0.243 $Y2=0.135
r21 2 18 19.3796 $a=3.24e-16 $layer=V0LIG $X=0.243 $Y=0.135 $X2=0.243 $Y2=0.135
r22 16 15 16.4967 $w=2.1e-08 $l=4.85e-08 $layer=Gate_1 $thickness=5.6e-08
+ $X=0.243 $Y=0.2025 $X2=0.243 $Y2=0.154
r23 14 15 6.6497 $w=2.04211e-08 $l=1.9e-08 $layer=Gate_1 $thickness=5.6e-08
+ $X=0.243 $Y=0.135 $X2=0.243 $Y2=0.154
r24 13 14 6.6497 $w=2.04211e-08 $l=1.9e-08 $layer=Gate_1 $thickness=5.6e-08
+ $X=0.243 $Y=0.116 $X2=0.243 $Y2=0.135
r25 12 13 16.4967 $w=2.1e-08 $l=4.85e-08 $layer=Gate_1 $thickness=5.6e-08
+ $X=0.243 $Y=0.0675 $X2=0.243 $Y2=0.116
r26 12 6 14.6259 $w=2.1e-08 $l=4.3e-08 $layer=Gate_1 $thickness=5.6e-08
+ $X=0.243 $Y=0.0675 $X2=0.243 $Y2=0.0245
.ends

.subckt PM_O2A1O1Ixp5_ASAP7_75t_R%C vss 13 5 11 3 4 1
c1 1 vss 0.00351104f $X=0.351 $Y=0.135
c2 3 vss 0.0840009f $X=0.351 $Y=0.0245
c3 4 vss 0.00798558f $X=0.351 $Y=0.0927
r1 14 15 3.20636 $w=1.3e-08 $l=1.38e-08 $layer=M1 $thickness=3.6e-08 $X=0.351
+ $Y=0.1212 $X2=0.351 $Y2=0.135
r2 13 14 1.22425 $w=1.3e-08 $l=5.2e-09 $layer=M1 $thickness=3.6e-08 $X=0.349
+ $Y=0.116 $X2=0.351 $Y2=0.1212
r3 13 4 5.42166 $w=1.3e-08 $l=2.33e-08 $layer=M1 $thickness=3.6e-08 $X=0.349
+ $Y=0.116 $X2=0.351 $Y2=0.0927
r4 1 8 10.4265 $w=1.765e-08 $layer=LIG $thickness=5.2e-08 $X=0.351 $Y=0.135
+ $X2=0.351 $Y2=0.135
r5 1 15 19.3796 $a=3.24e-16 $layer=V0LIG $X=0.351 $Y=0.135 $X2=0.351 $Y2=0.135
r6 11 10 14.6259 $w=2.1e-08 $l=4.3e-08 $layer=Gate_1 $thickness=5.6e-08
+ $X=0.351 $Y=0.2025 $X2=0.351 $Y2=0.1595
r7 9 10 2.7211 $w=2.1e-08 $l=8e-09 $layer=Gate_1 $thickness=5.6e-08 $X=0.351
+ $Y=0.1515 $X2=0.351 $Y2=0.1595
r8 8 9 5.79936 $w=2.03333e-08 $l=1.65e-08 $layer=Gate_1 $thickness=5.6e-08
+ $X=0.351 $Y=0.135 $X2=0.351 $Y2=0.1515
r9 7 8 5.79936 $w=2.03333e-08 $l=1.65e-08 $layer=Gate_1 $thickness=5.6e-08
+ $X=0.351 $Y=0.1185 $X2=0.351 $Y2=0.135
r10 6 7 7.31297 $w=2.1e-08 $l=2.15e-08 $layer=Gate_1 $thickness=5.6e-08
+ $X=0.351 $Y=0.097 $X2=0.351 $Y2=0.1185
r11 5 6 14.6259 $w=2.1e-08 $l=4.3e-08 $layer=Gate_1 $thickness=5.6e-08 $X=0.351
+ $Y=0.054 $X2=0.351 $Y2=0.097
r12 5 3 10.0341 $w=2.1e-08 $l=2.95e-08 $layer=Gate_1 $thickness=5.6e-08
+ $X=0.351 $Y=0.054 $X2=0.351 $Y2=0.0245
.ends

* End of included file O2A1O1Ixp5_ASAP7_75t_R.pex.sp.pex

*
.subckt O2A1O1Ixp5_ASAP7_75t_CUSTOM_4_25_0_7 VSS VDD A1 A2 B C Y
*
* VSS VSS
* VDD VDD
* A1 A1
* A2 A2
* B B
* C C
* Y Y
*
*

M0 VSS N_M0_g N_M0_s VSS nmos_rvt L=2e-08 W=8.1e-08 nfin=3 $X=0.179 $Y=0.027
M1 N_M1_d N_M1_g VSS VSS nmos_rvt L=2e-08 W=8.1e-08 nfin=3 $X=0.233 $Y=0.027
M2 N_M2_d N_M2_g N_M2_s VSS nmos_rvt L=2e-08 W=8.1e-08 nfin=3 $X=0.287 $Y=0.027
M3 VSS N_M3_g N_M3_s VSS nmos_rvt L=2e-08 W=5.4e-08 nfin=2 $X=0.341 $Y=0.027
M4 noxref_7 N_M4_g VDD VDD pmos_rvt L=2e-08 W=8.1e-08 nfin=3 $X=0.071 $Y=0.162
M5 noxref_8 N_M5_g noxref_7 VDD pmos_rvt L=2e-08 W=8.1e-08 nfin=3 $X=0.125
+ $Y=0.162
M6 noxref_8 N_M6_g noxref_7 VDD pmos_rvt L=2e-08 W=8.1e-08 nfin=3 $X=0.179
+ $Y=0.162
M7 noxref_7 N_M7_g VDD VDD pmos_rvt L=2e-08 W=8.1e-08 nfin=3 $X=0.233 $Y=0.162
M8 noxref_8 N_M8_g VDD VDD pmos_rvt L=2e-08 W=8.1e-08 nfin=3 $X=0.287 $Y=0.162
M9 N_M9_d N_M9_g noxref_8 VDD pmos_rvt L=2e-08 W=8.1e-08 nfin=3 $X=0.341
+ $Y=0.162

* .include "O2A1O1Ixp5_ASAP7_75t_R.pex.sp.pxi"

* Start of included file O2A1O1Ixp5_ASAP7_75t_R.pex.sp.pxi
x_PM_O2A1O1Ixp5_ASAP7_75t_R%A2 vss A2 N_M0_g N_M6_g N_M5_g N_A2_3 N_A2_1 N_A2_4
+ N_A2_5 PM_O2A1O1Ixp5_ASAP7_75t_R%A2
cc_1 N_A2_3 N_A1_10 0.00148739f $X=0.135 $Y=0.135
cc_2 N_A2_1 N_A1_2 0.00175903f $X=0.189 $Y=0.135
cc_3 N_A2_4 N_A1_6 0.00349194f $X=0.189 $Y=0.0245
cc_4 N_A2_5 N_A1_9 0.00396856f $X=0.135 $Y=0.116
cc_5 N_A2_3 N_A1_5 0.0133967f $X=0.135 $Y=0.135
x_PM_O2A1O1Ixp5_ASAP7_75t_R%B vss B N_M2_g N_M8_g N_B_4 N_B_3
+ PM_O2A1O1Ixp5_ASAP7_75t_R%B
cc_6 N_B_4 N_A1_11 0.00309943f $X=0.297 $Y=0.098
cc_7 N_B_3 N_A1_6 0.00537337f $X=0.297 $Y=0.0245
x_PM_O2A1O1Ixp5_ASAP7_75t_R%Y vss Y N_M2_d N_M3_s N_M9_d N_Y_1 N_Y_7 N_Y_9
+ N_Y_2 N_Y_14 N_Y_10 PM_O2A1O1Ixp5_ASAP7_75t_R%Y
cc_8 N_Y_1 N_B_4 0.0011193f $X=0.324 $Y=0.054
cc_9 N_Y_7 N_B_3 0.00952252f $X=0.3095 $Y=0.0725
cc_10 N_Y_9 N_B_3 0.0270765f $X=0.3095 $Y=0.0945
cc_11 N_Y_2 N_C_3 0.0010109f $X=0.378 $Y=0.2025
cc_12 N_Y_1 N_C_3 0.00113303f $X=0.324 $Y=0.054
cc_13 N_Y_7 N_C_1 0.00169591f $X=0.3095 $Y=0.0725
cc_14 N_Y_9 N_C_3 0.00500377f $X=0.3095 $Y=0.0945
cc_15 N_Y_14 N_C_4 0.0057975f $X=0.405 $Y=0.0452
cc_16 N_Y_7 N_C_3 0.0100617f $X=0.3095 $Y=0.0725
cc_17 N_Y_10 N_C_3 0.057069f $X=0.3635 $Y=0.2025
cc_18 N_Y_1 N_9_2 0.00473985f $X=0.324 $Y=0.054
x_PM_O2A1O1Ixp5_ASAP7_75t_R%9 vss N_M0_s N_M1_d N_M2_s N_9_1 N_9_8 N_9_2 N_9_9
+ N_9_7 PM_O2A1O1Ixp5_ASAP7_75t_R%9
cc_19 N_9_1 N_A1_10 0.00176946f $X=0.162 $Y=0.0675
cc_20 N_9_8 N_A1_2 0.000652474f $X=0.2555 $Y=0.0675
cc_21 N_9_2 N_A1_6 0.00106804f $X=0.27 $Y=0.0675
cc_22 N_9_9 N_A1_8 0.00117702f $X=0.1505 $Y=0.036
cc_23 N_9_9 N_A1_10 0.00808037f $X=0.1505 $Y=0.036
cc_24 N_9_8 N_A1_6 0.0343589f $X=0.2555 $Y=0.0675
cc_25 N_9_1 N_A2_4 0.00194428f $X=0.162 $Y=0.0675
cc_26 N_9_7 N_A2_1 0.0021909f $X=0.164 $Y=0.0675
cc_27 N_9_7 N_A2_3 0.0187646f $X=0.164 $Y=0.0675
cc_28 N_9_7 N_A2_4 0.0508432f $X=0.164 $Y=0.0675
cc_29 N_9_2 N_B_4 0.000886351f $X=0.27 $Y=0.0675
cc_30 N_9_2 N_B_3 0.0010172f $X=0.27 $Y=0.0675
cc_31 N_9_8 N_B_3 0.0344738f $X=0.2555 $Y=0.0675
x_PM_O2A1O1Ixp5_ASAP7_75t_R%A1 vss A1 N_M1_g N_M7_g N_M4_g N_A1_10 N_A1_2
+ N_A1_6 N_A1_9 N_A1_5 N_A1_11 N_A1_8 PM_O2A1O1Ixp5_ASAP7_75t_R%A1
x_PM_O2A1O1Ixp5_ASAP7_75t_R%C vss C N_M3_g N_M9_g N_C_3 N_C_4 N_C_1
+ PM_O2A1O1Ixp5_ASAP7_75t_R%C
cc_32 N_C_3 N_B_3 0.0031441f $X=0.351 $Y=0.0245
cc_33 N_C_4 N_B_4 0.00497114f $X=0.351 $Y=0.0927

* End of included file O2A1O1Ixp5_ASAP7_75t_R.pex.sp.pxi
.ends

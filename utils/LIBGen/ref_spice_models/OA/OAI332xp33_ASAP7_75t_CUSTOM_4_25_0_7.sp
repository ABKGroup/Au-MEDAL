.subckt PM_OAI332xp33_ASAP7_75t_R%A3 vss 15 5 11 3
c1 1 vss 0.00746248f $X=0.081 $Y=0.135
c2 3 vss 0.141696f $X=0.081 $Y=0.0245
c3 4 vss 0.0128951f $X=0.081 $Y=0.116
r1 15 14 1.34084 $w=1.3e-08 $l=5.8e-09 $layer=M1 $thickness=3.6e-08 $X=0.081
+ $Y=0.155 $X2=0.081 $Y2=0.1492
r2 13 14 3.32295 $w=1.3e-08 $l=1.42e-08 $layer=M1 $thickness=3.6e-08 $X=0.081
+ $Y=0.135 $X2=0.081 $Y2=0.1492
r3 4 13 4.43061 $w=1.3e-08 $l=1.9e-08 $layer=M1 $thickness=3.6e-08 $X=0.081
+ $Y=0.116 $X2=0.081 $Y2=0.135
r4 1 8 10.4265 $w=1.765e-08 $layer=LIG $thickness=5.2e-08 $X=0.081 $Y=0.135
+ $X2=0.081 $Y2=0.135
r5 1 13 19.3796 $a=3.24e-16 $layer=V0LIG $X=0.081 $Y=0.135 $X2=0.081 $Y2=0.135
r6 11 10 14.6259 $w=2.1e-08 $l=4.3e-08 $layer=Gate_1 $thickness=5.6e-08
+ $X=0.081 $Y=0.2025 $X2=0.081 $Y2=0.1595
r7 9 10 2.7211 $w=2.1e-08 $l=8e-09 $layer=Gate_1 $thickness=5.6e-08 $X=0.081
+ $Y=0.1515 $X2=0.081 $Y2=0.1595
r8 8 9 5.79936 $w=2.03333e-08 $l=1.65e-08 $layer=Gate_1 $thickness=5.6e-08
+ $X=0.081 $Y=0.135 $X2=0.081 $Y2=0.1515
r9 7 8 5.79936 $w=2.03333e-08 $l=1.65e-08 $layer=Gate_1 $thickness=5.6e-08
+ $X=0.081 $Y=0.1185 $X2=0.081 $Y2=0.135
r10 6 7 2.7211 $w=2.1e-08 $l=8e-09 $layer=Gate_1 $thickness=5.6e-08 $X=0.081
+ $Y=0.1105 $X2=0.081 $Y2=0.1185
r11 5 6 14.6259 $w=2.1e-08 $l=4.3e-08 $layer=Gate_1 $thickness=5.6e-08 $X=0.081
+ $Y=0.0675 $X2=0.081 $Y2=0.1105
r12 5 3 14.6259 $w=2.1e-08 $l=4.3e-08 $layer=Gate_1 $thickness=5.6e-08 $X=0.081
+ $Y=0.0675 $X2=0.081 $Y2=0.0245
.ends

.subckt PM_OAI332xp33_ASAP7_75t_R%A2 vss 13 5 9 4 3
c1 1 vss 0.00487985f $X=0.135 $Y=0.135
c2 3 vss 0.121445f $X=0.135 $Y=0.0245
c3 4 vss 0.00955044f $X=0.135 $Y=0.116
r1 13 12 1.34084 $w=1.3e-08 $l=5.8e-09 $layer=M1 $thickness=3.6e-08 $X=0.135
+ $Y=0.155 $X2=0.135 $Y2=0.1492
r2 11 12 3.32295 $w=1.3e-08 $l=1.42e-08 $layer=M1 $thickness=3.6e-08 $X=0.135
+ $Y=0.135 $X2=0.135 $Y2=0.1492
r3 4 11 4.4306 $w=1.3e-08 $l=1.9e-08 $layer=M1 $thickness=3.6e-08 $X=0.135
+ $Y=0.116 $X2=0.135 $Y2=0.135
r4 1 7 10.4265 $w=1.765e-08 $layer=LIG $thickness=5.2e-08 $X=0.135 $Y=0.135
+ $X2=0.135 $Y2=0.135
r5 1 11 19.3796 $a=3.24e-16 $layer=V0LIG $X=0.135 $Y=0.135 $X2=0.135 $Y2=0.135
r6 9 8 16.4967 $w=2.1e-08 $l=4.85e-08 $layer=Gate_1 $thickness=5.6e-08 $X=0.135
+ $Y=0.2025 $X2=0.135 $Y2=0.154
r7 7 8 6.6497 $w=2.04211e-08 $l=1.9e-08 $layer=Gate_1 $thickness=5.6e-08
+ $X=0.135 $Y=0.135 $X2=0.135 $Y2=0.154
r8 6 7 6.6497 $w=2.04211e-08 $l=1.9e-08 $layer=Gate_1 $thickness=5.6e-08
+ $X=0.135 $Y=0.116 $X2=0.135 $Y2=0.135
r9 5 6 16.4967 $w=2.1e-08 $l=4.85e-08 $layer=Gate_1 $thickness=5.6e-08 $X=0.135
+ $Y=0.0675 $X2=0.135 $Y2=0.116
r10 5 3 14.6259 $w=2.1e-08 $l=4.3e-08 $layer=Gate_1 $thickness=5.6e-08 $X=0.135
+ $Y=0.0675 $X2=0.135 $Y2=0.0245
.ends

.subckt PM_OAI332xp33_ASAP7_75t_R%B2 vss 13 5 9 4 3
c1 1 vss 0.00486139f $X=0.297 $Y=0.135
c2 3 vss 0.121199f $X=0.297 $Y=0.0245
c3 4 vss 0.00514466f $X=0.297 $Y=0.116
r1 13 12 1.34084 $w=1.3e-08 $l=5.8e-09 $layer=M1 $thickness=3.6e-08 $X=0.296
+ $Y=0.155 $X2=0.297 $Y2=0.1492
r2 11 12 3.32295 $w=1.3e-08 $l=1.42e-08 $layer=M1 $thickness=3.6e-08 $X=0.297
+ $Y=0.135 $X2=0.297 $Y2=0.1492
r3 4 11 4.4306 $w=1.3e-08 $l=1.9e-08 $layer=M1 $thickness=3.6e-08 $X=0.297
+ $Y=0.116 $X2=0.297 $Y2=0.135
r4 1 7 10.4265 $w=1.765e-08 $layer=LIG $thickness=5.2e-08 $X=0.297 $Y=0.135
+ $X2=0.297 $Y2=0.135
r5 1 11 19.3796 $a=3.24e-16 $layer=V0LIG $X=0.297 $Y=0.135 $X2=0.297 $Y2=0.135
r6 9 8 16.4967 $w=2.1e-08 $l=4.85e-08 $layer=Gate_1 $thickness=5.6e-08 $X=0.297
+ $Y=0.2025 $X2=0.297 $Y2=0.154
r7 7 8 6.6497 $w=2.04211e-08 $l=1.9e-08 $layer=Gate_1 $thickness=5.6e-08
+ $X=0.297 $Y=0.135 $X2=0.297 $Y2=0.154
r8 6 7 6.6497 $w=2.04211e-08 $l=1.9e-08 $layer=Gate_1 $thickness=5.6e-08
+ $X=0.297 $Y=0.116 $X2=0.297 $Y2=0.135
r9 5 6 16.4967 $w=2.1e-08 $l=4.85e-08 $layer=Gate_1 $thickness=5.6e-08 $X=0.297
+ $Y=0.0675 $X2=0.297 $Y2=0.116
r10 5 3 14.6259 $w=2.1e-08 $l=4.3e-08 $layer=Gate_1 $thickness=5.6e-08 $X=0.297
+ $Y=0.0675 $X2=0.297 $Y2=0.0245
.ends

.subckt PM_OAI332xp33_ASAP7_75t_R%C2 vss 13 5 9 3 4
c1 1 vss 0.00706073f $X=0.405 $Y=0.135
c2 3 vss 0.102513f $X=0.405 $Y=0.0245
c3 4 vss 0.00457748f $X=0.405 $Y=0.116
r1 13 12 1.45744 $w=1.3e-08 $l=6.3e-09 $layer=M1 $thickness=3.6e-08 $X=0.406
+ $Y=0.156 $X2=0.405 $Y2=0.1497
r2 11 12 3.43955 $w=1.3e-08 $l=1.47e-08 $layer=M1 $thickness=3.6e-08 $X=0.405
+ $Y=0.135 $X2=0.405 $Y2=0.1497
r3 4 11 4.4306 $w=1.3e-08 $l=1.9e-08 $layer=M1 $thickness=3.6e-08 $X=0.405
+ $Y=0.116 $X2=0.405 $Y2=0.135
r4 1 7 10.4265 $w=1.765e-08 $layer=LIG $thickness=5.2e-08 $X=0.405 $Y=0.135
+ $X2=0.405 $Y2=0.135
r5 1 11 19.3796 $a=3.24e-16 $layer=V0LIG $X=0.405 $Y=0.135 $X2=0.405 $Y2=0.135
r6 9 8 16.4967 $w=2.1e-08 $l=4.85e-08 $layer=Gate_1 $thickness=5.6e-08 $X=0.405
+ $Y=0.2025 $X2=0.405 $Y2=0.154
r7 7 8 6.6497 $w=2.04211e-08 $l=1.9e-08 $layer=Gate_1 $thickness=5.6e-08
+ $X=0.405 $Y=0.135 $X2=0.405 $Y2=0.154
r8 6 7 6.6497 $w=2.04211e-08 $l=1.9e-08 $layer=Gate_1 $thickness=5.6e-08
+ $X=0.405 $Y=0.116 $X2=0.405 $Y2=0.135
r9 5 6 16.4967 $w=2.1e-08 $l=4.85e-08 $layer=Gate_1 $thickness=5.6e-08 $X=0.405
+ $Y=0.0675 $X2=0.405 $Y2=0.116
r10 5 3 14.6259 $w=2.1e-08 $l=4.3e-08 $layer=Gate_1 $thickness=5.6e-08 $X=0.405
+ $Y=0.0675 $X2=0.405 $Y2=0.0245
.ends

.subckt PM_OAI332xp33_ASAP7_75t_R%C1 vss 15 5 11 4 3 1
c1 1 vss 0.00296445f $X=0.459 $Y=0.135
c2 3 vss 0.0718005f $X=0.459 $Y=0.0245
c3 4 vss 0.00540321f $X=0.459 $Y=0.116
r1 15 14 1.34084 $w=1.3e-08 $l=5.8e-09 $layer=M1 $thickness=3.6e-08 $X=0.459
+ $Y=0.155 $X2=0.459 $Y2=0.1492
r2 13 14 3.32295 $w=1.3e-08 $l=1.42e-08 $layer=M1 $thickness=3.6e-08 $X=0.459
+ $Y=0.135 $X2=0.459 $Y2=0.1492
r3 4 13 4.4306 $w=1.3e-08 $l=1.9e-08 $layer=M1 $thickness=3.6e-08 $X=0.459
+ $Y=0.116 $X2=0.459 $Y2=0.135
r4 1 8 10.4265 $w=1.765e-08 $layer=LIG $thickness=5.2e-08 $X=0.459 $Y=0.135
+ $X2=0.459 $Y2=0.135
r5 1 13 19.3796 $a=3.24e-16 $layer=V0LIG $X=0.459 $Y=0.135 $X2=0.459 $Y2=0.135
r6 11 10 14.6259 $w=2.1e-08 $l=4.3e-08 $layer=Gate_1 $thickness=5.6e-08
+ $X=0.459 $Y=0.2025 $X2=0.459 $Y2=0.1595
r7 9 10 2.7211 $w=2.1e-08 $l=8e-09 $layer=Gate_1 $thickness=5.6e-08 $X=0.459
+ $Y=0.1515 $X2=0.459 $Y2=0.1595
r8 8 9 5.79936 $w=2.03333e-08 $l=1.65e-08 $layer=Gate_1 $thickness=5.6e-08
+ $X=0.459 $Y=0.135 $X2=0.459 $Y2=0.1515
r9 7 8 5.79936 $w=2.03333e-08 $l=1.65e-08 $layer=Gate_1 $thickness=5.6e-08
+ $X=0.459 $Y=0.1185 $X2=0.459 $Y2=0.135
r10 6 7 2.7211 $w=2.1e-08 $l=8e-09 $layer=Gate_1 $thickness=5.6e-08 $X=0.459
+ $Y=0.1105 $X2=0.459 $Y2=0.1185
r11 5 6 14.6259 $w=2.1e-08 $l=4.3e-08 $layer=Gate_1 $thickness=5.6e-08 $X=0.459
+ $Y=0.0675 $X2=0.459 $Y2=0.1105
r12 5 3 14.6259 $w=2.1e-08 $l=4.3e-08 $layer=Gate_1 $thickness=5.6e-08 $X=0.459
+ $Y=0.0675 $X2=0.459 $Y2=0.0245
.ends

.subckt PM_OAI332xp33_ASAP7_75t_R%B1 vss 13 5 9 3 4
c1 1 vss 0.00486578f $X=0.243 $Y=0.135
c2 3 vss 0.102917f $X=0.243 $Y=0.0245
c3 4 vss 0.00754347f $X=0.243 $Y=0.116
r1 13 12 1.22425 $w=1.3e-08 $l=5.3e-09 $layer=M1 $thickness=3.6e-08 $X=0.243
+ $Y=0.154 $X2=0.243 $Y2=0.1487
r2 11 12 3.20636 $w=1.3e-08 $l=1.37e-08 $layer=M1 $thickness=3.6e-08 $X=0.243
+ $Y=0.135 $X2=0.243 $Y2=0.1487
r3 4 11 4.4306 $w=1.3e-08 $l=1.9e-08 $layer=M1 $thickness=3.6e-08 $X=0.243
+ $Y=0.116 $X2=0.243 $Y2=0.135
r4 1 7 10.4265 $w=1.765e-08 $layer=LIG $thickness=5.2e-08 $X=0.243 $Y=0.135
+ $X2=0.243 $Y2=0.135
r5 1 11 19.3796 $a=3.24e-16 $layer=V0LIG $X=0.243 $Y=0.135 $X2=0.243 $Y2=0.135
r6 9 8 16.4967 $w=2.1e-08 $l=4.85e-08 $layer=Gate_1 $thickness=5.6e-08 $X=0.243
+ $Y=0.2025 $X2=0.243 $Y2=0.154
r7 7 8 6.6497 $w=2.04211e-08 $l=1.9e-08 $layer=Gate_1 $thickness=5.6e-08
+ $X=0.243 $Y=0.135 $X2=0.243 $Y2=0.154
r8 6 7 6.6497 $w=2.04211e-08 $l=1.9e-08 $layer=Gate_1 $thickness=5.6e-08
+ $X=0.243 $Y=0.116 $X2=0.243 $Y2=0.135
r9 5 6 16.4967 $w=2.1e-08 $l=4.85e-08 $layer=Gate_1 $thickness=5.6e-08 $X=0.243
+ $Y=0.0675 $X2=0.243 $Y2=0.116
r10 5 3 14.6259 $w=2.1e-08 $l=4.3e-08 $layer=Gate_1 $thickness=5.6e-08 $X=0.243
+ $Y=0.0675 $X2=0.243 $Y2=0.0245
.ends

.subckt PM_OAI332xp33_ASAP7_75t_R%Y vss 28 20 21 48 51 52 1 11 15 16 2 10 3 12
+ 17
c1 1 vss 0.00584103f $X=0.216 $Y=0.2025
c2 2 vss 0.00970566f $X=0.432 $Y=0.0675
c3 3 vss 0.00656361f $X=0.486 $Y=0.2025
c4 10 vss 0.00453826f $X=0.4175 $Y=0.0675
c5 11 vss 0.00261457f $X=0.2015 $Y=0.2025
c6 12 vss 0.0363341f $X=0.4715 $Y=0.2025
c7 13 vss 0.00232794f $X=0.513 $Y=0.072
c8 14 vss 0.00264697f $X=0.513 $Y=0.234
c9 15 vss 0.0273335f $X=0.4725 $Y=0.234
c10 16 vss 0.00813969f $X=0.42 $Y=0.072
c11 17 vss 0.00441361f $X=0.513 $Y=0.0935
r1 52 50 0.0308642 $w=8.1e-08 $l=2.5e-09 $layer=P_src_drn $thickness=1e-09
+ $X=0.2333 $Y=0.2025 $X2=0.2305 $Y2=0.2025
r2 1 50 0.179012 $w=8.1e-08 $l=1.45e-08 $layer=P_src_drn $thickness=1e-09
+ $X=0.216 $Y=0.2025 $X2=0.2305 $Y2=0.2025
r3 11 1 0.179012 $w=8.1e-08 $l=1.45e-08 $layer=P_src_drn $thickness=1e-09
+ $X=0.2015 $Y=0.2025 $X2=0.216 $Y2=0.2025
r4 51 11 0.0308642 $w=8.1e-08 $l=2.5e-09 $layer=P_src_drn $thickness=1e-09
+ $X=0.1986 $Y=0.2025 $X2=0.2015 $Y2=0.2025
r5 12 3 0.154321 $w=8.1e-08 $l=1.25e-08 $layer=P_src_drn $thickness=1e-09
+ $X=0.4715 $Y=0.2025 $X2=0.486 $Y2=0.2025
r6 48 12 0.0308642 $w=8.1e-08 $l=2.5e-09 $layer=P_src_drn $thickness=1e-09
+ $X=0.4686 $Y=0.2025 $X2=0.4715 $Y2=0.2025
r7 1 45 19.3796 $a=3.24e-16 $layer=V0LISD $X=0.216 $Y=0.2025 $X2=0.216 $Y2=0.234
r8 3 31 19.3796 $a=3.24e-16 $layer=V0LISD $X=0.486 $Y=0.2025 $X2=0.486 $Y2=0.234
r9 45 46 3.14806 $w=1.3e-08 $l=1.35e-08 $layer=M1 $thickness=3.6e-08 $X=0.216
+ $Y=0.234 $X2=0.2295 $Y2=0.234
r10 43 46 3.14806 $w=1.3e-08 $l=1.35e-08 $layer=M1 $thickness=3.6e-08 $X=0.243
+ $Y=0.234 $X2=0.2295 $Y2=0.234
r11 42 43 6.29612 $w=1.3e-08 $l=2.7e-08 $layer=M1 $thickness=3.6e-08 $X=0.27
+ $Y=0.234 $X2=0.243 $Y2=0.234
r12 41 42 6.29612 $w=1.3e-08 $l=2.7e-08 $layer=M1 $thickness=3.6e-08 $X=0.297
+ $Y=0.234 $X2=0.27 $Y2=0.234
r13 40 41 5.94634 $w=1.3e-08 $l=2.55e-08 $layer=M1 $thickness=3.6e-08 $X=0.3225
+ $Y=0.234 $X2=0.297 $Y2=0.234
r14 39 40 4.19742 $w=1.3e-08 $l=1.8e-08 $layer=M1 $thickness=3.6e-08 $X=0.3405
+ $Y=0.234 $X2=0.3225 $Y2=0.234
r15 38 39 2.44849 $w=1.3e-08 $l=1.05e-08 $layer=M1 $thickness=3.6e-08 $X=0.351
+ $Y=0.234 $X2=0.3405 $Y2=0.234
r16 37 38 6.29612 $w=1.3e-08 $l=2.7e-08 $layer=M1 $thickness=3.6e-08 $X=0.378
+ $Y=0.234 $X2=0.351 $Y2=0.234
r17 36 37 6.29612 $w=1.3e-08 $l=2.7e-08 $layer=M1 $thickness=3.6e-08 $X=0.405
+ $Y=0.234 $X2=0.378 $Y2=0.234
r18 35 36 2.44849 $w=1.3e-08 $l=1.05e-08 $layer=M1 $thickness=3.6e-08 $X=0.4155
+ $Y=0.234 $X2=0.405 $Y2=0.234
r19 34 35 4.19742 $w=1.3e-08 $l=1.8e-08 $layer=M1 $thickness=3.6e-08 $X=0.4335
+ $Y=0.234 $X2=0.4155 $Y2=0.234
r20 33 34 5.94634 $w=1.3e-08 $l=2.55e-08 $layer=M1 $thickness=3.6e-08 $X=0.459
+ $Y=0.234 $X2=0.4335 $Y2=0.234
r21 31 32 3.14806 $w=1.3e-08 $l=1.35e-08 $layer=M1 $thickness=3.6e-08 $X=0.486
+ $Y=0.234 $X2=0.4995 $Y2=0.234
r22 15 31 3.14806 $w=1.3e-08 $l=1.35e-08 $layer=M1 $thickness=3.6e-08 $X=0.4725
+ $Y=0.234 $X2=0.486 $Y2=0.234
r23 15 33 3.14806 $w=1.3e-08 $l=1.35e-08 $layer=M1 $thickness=3.6e-08 $X=0.4725
+ $Y=0.234 $X2=0.459 $Y2=0.234
r24 14 30 3.36447 $w=1.71023e-08 $l=2.15e-08 $layer=M1 $thickness=3.6e-08
+ $X=0.513 $Y=0.234 $X2=0.513 $Y2=0.2125
r25 14 32 1.49895 $w=1.63333e-08 $l=1.35e-08 $layer=M1 $thickness=3.6e-08
+ $X=0.513 $Y=0.234 $X2=0.4995 $Y2=0.234
r26 29 30 9.50248 $w=1.3e-08 $l=4.08e-08 $layer=M1 $thickness=3.6e-08 $X=0.513
+ $Y=0.1717 $X2=0.513 $Y2=0.2125
r27 28 29 6.70421 $w=1.3e-08 $l=2.87e-08 $layer=M1 $thickness=3.6e-08 $X=0.512
+ $Y=0.143 $X2=0.513 $Y2=0.1717
r28 28 27 4.37231 $w=1.3e-08 $l=1.88e-08 $layer=M1 $thickness=3.6e-08 $X=0.512
+ $Y=0.143 $X2=0.513 $Y2=0.1242
r29 17 27 7.17059 $w=1.3e-08 $l=3.07e-08 $layer=M1 $thickness=3.6e-08 $X=0.513
+ $Y=0.0935 $X2=0.513 $Y2=0.1242
r30 13 26 0.682785 $w=1.75e-08 $l=1e-08 $layer=M1 $thickness=3.6e-08 $X=0.513
+ $Y=0.072 $X2=0.503 $Y2=0.072
r31 13 17 3.36447 $w=1.71023e-08 $l=2.15e-08 $layer=M1 $thickness=3.6e-08
+ $X=0.513 $Y=0.072 $X2=0.513 $Y2=0.0935
r32 25 26 4.19742 $w=1.3e-08 $l=1.8e-08 $layer=M1 $thickness=3.6e-08 $X=0.485
+ $Y=0.072 $X2=0.503 $Y2=0.072
r33 24 25 6.06293 $w=1.3e-08 $l=2.6e-08 $layer=M1 $thickness=3.6e-08 $X=0.459
+ $Y=0.072 $X2=0.485 $Y2=0.072
r34 23 24 3.14806 $w=1.3e-08 $l=1.35e-08 $layer=M1 $thickness=3.6e-08 $X=0.4455
+ $Y=0.072 $X2=0.459 $Y2=0.072
r35 22 23 3.14806 $w=1.3e-08 $l=1.35e-08 $layer=M1 $thickness=3.6e-08 $X=0.432
+ $Y=0.072 $X2=0.4455 $Y2=0.072
r36 16 22 2.79828 $w=1.3e-08 $l=1.2e-08 $layer=M1 $thickness=3.6e-08 $X=0.42
+ $Y=0.072 $X2=0.432 $Y2=0.072
r37 2 22 19.3796 $a=3.24e-16 $layer=V0LISD $X=0.432 $Y=0.0675 $X2=0.432
+ $Y2=0.072
r38 21 19 0.0308642 $w=8.1e-08 $l=2.5e-09 $layer=N_src_drn $thickness=1e-09
+ $X=0.4493 $Y=0.0675 $X2=0.4465 $Y2=0.0675
r39 2 19 0.179012 $w=8.1e-08 $l=1.45e-08 $layer=N_src_drn $thickness=1e-09
+ $X=0.432 $Y=0.0675 $X2=0.4465 $Y2=0.0675
r40 10 2 0.179012 $w=8.1e-08 $l=1.45e-08 $layer=N_src_drn $thickness=1e-09
+ $X=0.4175 $Y=0.0675 $X2=0.432 $Y2=0.0675
r41 20 10 0.0308642 $w=8.1e-08 $l=2.5e-09 $layer=N_src_drn $thickness=1e-09
+ $X=0.4146 $Y=0.0675 $X2=0.4175 $Y2=0.0675
.ends

.subckt PM_OAI332xp33_ASAP7_75t_R%A1 vss 13 5 9 4 3
c1 1 vss 0.00481677f $X=0.189 $Y=0.135
c2 3 vss 0.103026f $X=0.189 $Y=0.0245
c3 4 vss 0.00756166f $X=0.189 $Y=0.116
r1 13 12 1.34084 $w=1.3e-08 $l=5.8e-09 $layer=M1 $thickness=3.6e-08 $X=0.189
+ $Y=0.155 $X2=0.189 $Y2=0.1492
r2 11 12 3.32295 $w=1.3e-08 $l=1.42e-08 $layer=M1 $thickness=3.6e-08 $X=0.189
+ $Y=0.135 $X2=0.189 $Y2=0.1492
r3 4 11 4.4306 $w=1.3e-08 $l=1.9e-08 $layer=M1 $thickness=3.6e-08 $X=0.189
+ $Y=0.116 $X2=0.189 $Y2=0.135
r4 1 7 10.4265 $w=1.765e-08 $layer=LIG $thickness=5.2e-08 $X=0.189 $Y=0.135
+ $X2=0.189 $Y2=0.135
r5 1 11 19.3796 $a=3.24e-16 $layer=V0LIG $X=0.189 $Y=0.135 $X2=0.189 $Y2=0.135
r6 9 8 16.4967 $w=2.1e-08 $l=4.85e-08 $layer=Gate_1 $thickness=5.6e-08 $X=0.189
+ $Y=0.2025 $X2=0.189 $Y2=0.154
r7 7 8 6.6497 $w=2.04211e-08 $l=1.9e-08 $layer=Gate_1 $thickness=5.6e-08
+ $X=0.189 $Y=0.135 $X2=0.189 $Y2=0.154
r8 6 7 6.6497 $w=2.04211e-08 $l=1.9e-08 $layer=Gate_1 $thickness=5.6e-08
+ $X=0.189 $Y=0.116 $X2=0.189 $Y2=0.135
r9 5 6 16.4967 $w=2.1e-08 $l=4.85e-08 $layer=Gate_1 $thickness=5.6e-08 $X=0.189
+ $Y=0.0675 $X2=0.189 $Y2=0.116
r10 5 3 14.6259 $w=2.1e-08 $l=4.3e-08 $layer=Gate_1 $thickness=5.6e-08 $X=0.189
+ $Y=0.0675 $X2=0.189 $Y2=0.0245
.ends

.subckt PM_OAI332xp33_ASAP7_75t_R%B3 vss 13 5 9 4 3
c1 1 vss 0.00702247f $X=0.351 $Y=0.135
c2 3 vss 0.139608f $X=0.351 $Y=0.0245
c3 4 vss 0.00475858f $X=0.351 $Y=0.116
r1 13 12 1.34084 $w=1.3e-08 $l=5.8e-09 $layer=M1 $thickness=3.6e-08 $X=0.349
+ $Y=0.155 $X2=0.351 $Y2=0.1492
r2 11 12 3.32295 $w=1.3e-08 $l=1.42e-08 $layer=M1 $thickness=3.6e-08 $X=0.351
+ $Y=0.135 $X2=0.351 $Y2=0.1492
r3 4 11 4.4306 $w=1.3e-08 $l=1.9e-08 $layer=M1 $thickness=3.6e-08 $X=0.351
+ $Y=0.116 $X2=0.351 $Y2=0.135
r4 1 7 10.4265 $w=1.765e-08 $layer=LIG $thickness=5.2e-08 $X=0.351 $Y=0.135
+ $X2=0.351 $Y2=0.135
r5 1 11 19.3796 $a=3.24e-16 $layer=V0LIG $X=0.351 $Y=0.135 $X2=0.351 $Y2=0.135
r6 9 8 16.4967 $w=2.1e-08 $l=4.85e-08 $layer=Gate_1 $thickness=5.6e-08 $X=0.351
+ $Y=0.2025 $X2=0.351 $Y2=0.154
r7 7 8 6.6497 $w=2.04211e-08 $l=1.9e-08 $layer=Gate_1 $thickness=5.6e-08
+ $X=0.351 $Y=0.135 $X2=0.351 $Y2=0.154
r8 6 7 6.6497 $w=2.04211e-08 $l=1.9e-08 $layer=Gate_1 $thickness=5.6e-08
+ $X=0.351 $Y=0.116 $X2=0.351 $Y2=0.135
r9 5 6 16.4967 $w=2.1e-08 $l=4.85e-08 $layer=Gate_1 $thickness=5.6e-08 $X=0.351
+ $Y=0.0675 $X2=0.351 $Y2=0.116
r10 5 3 14.6259 $w=2.1e-08 $l=4.3e-08 $layer=Gate_1 $thickness=5.6e-08 $X=0.351
+ $Y=0.0675 $X2=0.351 $Y2=0.0245
.ends

* End of included file OAI332xp33_ASAP7_75t_R.pex.sp.pex

*
.subckt OAI332xp33_ASAP7_75t_CUSTOM_4_25_0_7 VSS VDD A3 A2 A1 B1 B2 B3 C2 C1 Y
*
* VSS VSS
* VDD VDD
* A3 A3
* A2 A2
* A1 A1
* B1 B1
* B2 B2
* B3 B3
* C2 C2
* C1 C1
* Y Y
*
*

M0 noxref_11 N_M0_g VSS VSS nmos_rvt L=2e-08 W=8.1e-08 nfin=3 $X=0.071 $Y=0.027
M1 VSS N_M1_g noxref_11 VSS nmos_rvt L=2e-08 W=8.1e-08 nfin=3 $X=0.125 $Y=0.027
M2 noxref_11 N_M2_g VSS VSS nmos_rvt L=2e-08 W=8.1e-08 nfin=3 $X=0.179 $Y=0.027
M3 noxref_12 N_M3_g noxref_11 VSS nmos_rvt L=2e-08 W=8.1e-08 nfin=3 $X=0.233
+ $Y=0.027
M4 noxref_11 N_M4_g noxref_12 VSS nmos_rvt L=2e-08 W=8.1e-08 nfin=3 $X=0.287
+ $Y=0.027
M5 noxref_12 N_M5_g noxref_11 VSS nmos_rvt L=2e-08 W=8.1e-08 nfin=3 $X=0.341
+ $Y=0.027
M6 N_M6_d N_M6_g noxref_12 VSS nmos_rvt L=2e-08 W=8.1e-08 nfin=3 $X=0.395
+ $Y=0.027
M7 noxref_12 N_M7_g N_M7_s VSS nmos_rvt L=2e-08 W=8.1e-08 nfin=3 $X=0.449
+ $Y=0.027
M8 noxref_14 N_M8_g VDD VDD pmos_rvt L=2e-08 W=8.1e-08 nfin=3 $X=0.071 $Y=0.162
M9 noxref_15 N_M9_g noxref_14 VDD pmos_rvt L=2e-08 W=8.1e-08 nfin=3 $X=0.125
+ $Y=0.162
M10 N_M10_d N_M10_g noxref_15 VDD pmos_rvt L=2e-08 W=8.1e-08 nfin=3 $X=0.179
+ $Y=0.162
M11 noxref_16 N_M11_g N_M11_s VDD pmos_rvt L=2e-08 W=8.1e-08 nfin=3 $X=0.233
+ $Y=0.162
M12 noxref_17 N_M12_g noxref_16 VDD pmos_rvt L=2e-08 W=8.1e-08 nfin=3 $X=0.287
+ $Y=0.162
M13 VDD N_M13_g noxref_17 VDD pmos_rvt L=2e-08 W=8.1e-08 nfin=3 $X=0.341
+ $Y=0.162
M14 noxref_18 N_M14_g VDD VDD pmos_rvt L=2e-08 W=8.1e-08 nfin=3 $X=0.395
+ $Y=0.162
M15 N_M15_d N_M15_g noxref_18 VDD pmos_rvt L=2e-08 W=8.1e-08 nfin=3 $X=0.449
+ $Y=0.162

* .include "OAI332xp33_ASAP7_75t_R.pex.sp.pxi"

* Start of included file OAI332xp33_ASAP7_75t_R.pex.sp.pxi
x_PM_OAI332xp33_ASAP7_75t_R%A3 vss A3 N_M0_g N_M8_g N_A3_3
+ PM_OAI332xp33_ASAP7_75t_R%A3
x_PM_OAI332xp33_ASAP7_75t_R%A2 vss A2 N_M1_g N_M9_g N_A2_4 N_A2_3
+ PM_OAI332xp33_ASAP7_75t_R%A2
cc_1 N_A2_4 N_A3_3 0.00489941f $X=0.135 $Y=0.116
cc_2 N_A2_3 N_A3_3 0.0072203f $X=0.135 $Y=0.0245
x_PM_OAI332xp33_ASAP7_75t_R%B2 vss B2 N_M4_g N_M12_g N_B2_4 N_B2_3
+ PM_OAI332xp33_ASAP7_75t_R%B2
cc_3 N_B2_4 N_B1_4 0.00332716f $X=0.297 $Y=0.116
cc_4 N_B2_3 N_B1_3 0.00698254f $X=0.297 $Y=0.0245
x_PM_OAI332xp33_ASAP7_75t_R%C2 vss C2 N_M6_g N_M14_g N_C2_3 N_C2_4
+ PM_OAI332xp33_ASAP7_75t_R%C2
cc_5 N_C2_3 N_B3_3 0.00317014f $X=0.405 $Y=0.0245
cc_6 N_C2_4 N_B3_4 0.00505522f $X=0.405 $Y=0.116
x_PM_OAI332xp33_ASAP7_75t_R%C1 vss C1 N_M7_g N_M15_g N_C1_4 N_C1_3 N_C1_1
+ PM_OAI332xp33_ASAP7_75t_R%C1
cc_7 N_C1_4 N_C2_4 0.00328204f $X=0.459 $Y=0.116
cc_8 N_C1_3 N_C2_3 0.00694804f $X=0.459 $Y=0.0245
x_PM_OAI332xp33_ASAP7_75t_R%B1 vss B1 N_M3_g N_M11_g N_B1_3 N_B1_4
+ PM_OAI332xp33_ASAP7_75t_R%B1
cc_9 N_B1_3 N_A1_3 0.00315796f $X=0.243 $Y=0.0245
cc_10 N_B1_4 N_A1_4 0.00501548f $X=0.243 $Y=0.116
x_PM_OAI332xp33_ASAP7_75t_R%Y vss Y N_M6_d N_M7_s N_M15_d N_M10_d N_M11_s N_Y_1
+ N_Y_11 N_Y_15 N_Y_16 N_Y_2 N_Y_10 N_Y_3 N_Y_12 N_Y_17
+ PM_OAI332xp33_ASAP7_75t_R%Y
cc_11 N_Y_1 N_A1_4 0.00110343f $X=0.216 $Y=0.2025
cc_12 N_Y_1 N_A1_3 0.00147598f $X=0.216 $Y=0.2025
cc_13 N_Y_11 N_A1_3 0.0359344f $X=0.2015 $Y=0.2025
cc_14 N_Y_15 N_B1_3 0.00114421f $X=0.4725 $Y=0.234
cc_15 N_Y_1 N_B1_3 0.0014128f $X=0.216 $Y=0.2025
cc_16 N_Y_1 N_B1_4 0.00171817f $X=0.216 $Y=0.2025
cc_17 N_Y_11 N_B1_3 0.0353823f $X=0.2015 $Y=0.2025
cc_18 N_Y_15 N_B2_4 0.00344379f $X=0.4725 $Y=0.234
cc_19 N_Y_15 N_B3_4 0.00294305f $X=0.4725 $Y=0.234
cc_20 N_Y_16 N_C2_3 0.000534932f $X=0.42 $Y=0.072
cc_21 N_Y_2 N_C2_3 0.000789889f $X=0.432 $Y=0.0675
cc_22 N_Y_15 N_C2_4 0.00124987f $X=0.4725 $Y=0.234
cc_23 N_Y_2 N_C2_4 0.00214438f $X=0.432 $Y=0.0675
cc_24 N_Y_10 N_C2_3 0.0357339f $X=0.4175 $Y=0.0675
cc_25 N_Y_2 N_C1_3 0.00165098f $X=0.432 $Y=0.0675
cc_26 N_Y_16 N_C1_3 0.000975691f $X=0.42 $Y=0.072
cc_27 N_Y_15 N_C1_4 0.00109015f $X=0.4725 $Y=0.234
cc_28 N_Y_3 N_C1_3 0.00153398f $X=0.486 $Y=0.2025
cc_29 N_Y_10 N_C1_1 0.00169921f $X=0.4175 $Y=0.0675
cc_30 N_Y_12 N_C1_3 0.01478f $X=0.4715 $Y=0.2025
cc_31 N_Y_17 N_C1_4 0.00645354f $X=0.513 $Y=0.0935
cc_32 N_Y_10 N_C1_3 0.0537635f $X=0.4175 $Y=0.0675
x_PM_OAI332xp33_ASAP7_75t_R%A1 vss A1 N_M2_g N_M10_g N_A1_4 N_A1_3
+ PM_OAI332xp33_ASAP7_75t_R%A1
cc_33 N_A1_4 N_A2_4 0.00394948f $X=0.189 $Y=0.116
cc_34 N_A1_3 N_A2_3 0.00698711f $X=0.189 $Y=0.0245
x_PM_OAI332xp33_ASAP7_75t_R%B3 vss B3 N_M5_g N_M13_g N_B3_4 N_B3_3
+ PM_OAI332xp33_ASAP7_75t_R%B3
cc_35 N_B3_4 N_B2_4 0.00340241f $X=0.351 $Y=0.116
cc_36 N_B3_3 N_B2_3 0.00692893f $X=0.351 $Y=0.0245

* End of included file OAI332xp33_ASAP7_75t_R.pex.sp.pxi
.ends

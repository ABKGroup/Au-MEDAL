.subckt PM_OA332x1_ASAP7_75t_R%A3 vss 14 5 9 3 4
c1 1 vss 0.00673135f $X=0.135 $Y=0.135
c2 3 vss 0.139642f $X=0.135 $Y=0.0245
c3 4 vss 0.00633133f $X=0.135 $Y=0.0945
r1 14 13 1.34084 $w=1.3e-08 $l=5.8e-09 $layer=M1 $thickness=3.6e-08 $X=0.135
+ $Y=0.155 $X2=0.135 $Y2=0.1492
r2 12 13 3.32295 $w=1.3e-08 $l=1.42e-08 $layer=M1 $thickness=3.6e-08 $X=0.135
+ $Y=0.135 $X2=0.135 $Y2=0.1492
r3 11 12 2.91487 $w=1.3e-08 $l=1.25e-08 $layer=M1 $thickness=3.6e-08 $X=0.135
+ $Y=0.1225 $X2=0.135 $Y2=0.135
r4 4 11 6.52931 $w=1.3e-08 $l=2.8e-08 $layer=M1 $thickness=3.6e-08 $X=0.135
+ $Y=0.0945 $X2=0.135 $Y2=0.1225
r5 1 7 10.4265 $w=1.765e-08 $layer=LIG $thickness=5.2e-08 $X=0.135 $Y=0.135
+ $X2=0.135 $Y2=0.135
r6 1 12 19.3796 $a=3.24e-16 $layer=V0LIG $X=0.135 $Y=0.135 $X2=0.135 $Y2=0.135
r7 9 8 16.4967 $w=2.1e-08 $l=4.85e-08 $layer=Gate_1 $thickness=5.6e-08 $X=0.135
+ $Y=0.2025 $X2=0.135 $Y2=0.154
r8 7 8 6.6497 $w=2.04211e-08 $l=1.9e-08 $layer=Gate_1 $thickness=5.6e-08
+ $X=0.135 $Y=0.135 $X2=0.135 $Y2=0.154
r9 6 7 6.6497 $w=2.04211e-08 $l=1.9e-08 $layer=Gate_1 $thickness=5.6e-08
+ $X=0.135 $Y=0.116 $X2=0.135 $Y2=0.135
r10 5 6 16.4967 $w=2.1e-08 $l=4.85e-08 $layer=Gate_1 $thickness=5.6e-08
+ $X=0.135 $Y=0.0675 $X2=0.135 $Y2=0.116
r11 5 3 14.6259 $w=2.1e-08 $l=4.3e-08 $layer=Gate_1 $thickness=5.6e-08 $X=0.135
+ $Y=0.0675 $X2=0.135 $Y2=0.0245
.ends

.subckt PM_OA332x1_ASAP7_75t_R%B1 vss 13 5 9 4 3
c1 1 vss 0.00475315f $X=0.297 $Y=0.135
c2 3 vss 0.10267f $X=0.297 $Y=0.0245
c3 4 vss 0.0071453f $X=0.297 $Y=0.116
r1 13 12 1.22425 $w=1.3e-08 $l=5.3e-09 $layer=M1 $thickness=3.6e-08 $X=0.297
+ $Y=0.154 $X2=0.297 $Y2=0.1487
r2 11 12 3.20636 $w=1.3e-08 $l=1.37e-08 $layer=M1 $thickness=3.6e-08 $X=0.297
+ $Y=0.135 $X2=0.297 $Y2=0.1487
r3 4 11 4.4306 $w=1.3e-08 $l=1.9e-08 $layer=M1 $thickness=3.6e-08 $X=0.297
+ $Y=0.116 $X2=0.297 $Y2=0.135
r4 1 7 10.4265 $w=1.765e-08 $layer=LIG $thickness=5.2e-08 $X=0.297 $Y=0.135
+ $X2=0.297 $Y2=0.135
r5 1 11 19.3796 $a=3.24e-16 $layer=V0LIG $X=0.297 $Y=0.135 $X2=0.297 $Y2=0.135
r6 9 8 16.4967 $w=2.1e-08 $l=4.85e-08 $layer=Gate_1 $thickness=5.6e-08 $X=0.297
+ $Y=0.2025 $X2=0.297 $Y2=0.154
r7 7 8 6.6497 $w=2.04211e-08 $l=1.9e-08 $layer=Gate_1 $thickness=5.6e-08
+ $X=0.297 $Y=0.135 $X2=0.297 $Y2=0.154
r8 6 7 6.6497 $w=2.04211e-08 $l=1.9e-08 $layer=Gate_1 $thickness=5.6e-08
+ $X=0.297 $Y=0.116 $X2=0.297 $Y2=0.135
r9 5 6 16.4967 $w=2.1e-08 $l=4.85e-08 $layer=Gate_1 $thickness=5.6e-08 $X=0.297
+ $Y=0.0675 $X2=0.297 $Y2=0.116
r10 5 3 14.6259 $w=2.1e-08 $l=4.3e-08 $layer=Gate_1 $thickness=5.6e-08 $X=0.297
+ $Y=0.0675 $X2=0.297 $Y2=0.0245
.ends

.subckt PM_OA332x1_ASAP7_75t_R%B2 vss 13 5 9 4 3
c1 1 vss 0.00484847f $X=0.351 $Y=0.135
c2 3 vss 0.121182f $X=0.351 $Y=0.0245
c3 4 vss 0.00517635f $X=0.351 $Y=0.116
r1 13 12 1.34084 $w=1.3e-08 $l=5.8e-09 $layer=M1 $thickness=3.6e-08 $X=0.35
+ $Y=0.155 $X2=0.351 $Y2=0.1492
r2 11 12 3.32295 $w=1.3e-08 $l=1.42e-08 $layer=M1 $thickness=3.6e-08 $X=0.351
+ $Y=0.135 $X2=0.351 $Y2=0.1492
r3 4 11 4.4306 $w=1.3e-08 $l=1.9e-08 $layer=M1 $thickness=3.6e-08 $X=0.351
+ $Y=0.116 $X2=0.351 $Y2=0.135
r4 1 7 10.4265 $w=1.765e-08 $layer=LIG $thickness=5.2e-08 $X=0.351 $Y=0.135
+ $X2=0.351 $Y2=0.135
r5 1 11 19.3796 $a=3.24e-16 $layer=V0LIG $X=0.351 $Y=0.135 $X2=0.351 $Y2=0.135
r6 9 8 16.4967 $w=2.1e-08 $l=4.85e-08 $layer=Gate_1 $thickness=5.6e-08 $X=0.351
+ $Y=0.2025 $X2=0.351 $Y2=0.154
r7 7 8 6.6497 $w=2.04211e-08 $l=1.9e-08 $layer=Gate_1 $thickness=5.6e-08
+ $X=0.351 $Y=0.135 $X2=0.351 $Y2=0.154
r8 6 7 6.6497 $w=2.04211e-08 $l=1.9e-08 $layer=Gate_1 $thickness=5.6e-08
+ $X=0.351 $Y=0.116 $X2=0.351 $Y2=0.135
r9 5 6 16.4967 $w=2.1e-08 $l=4.85e-08 $layer=Gate_1 $thickness=5.6e-08 $X=0.351
+ $Y=0.0675 $X2=0.351 $Y2=0.116
r10 5 3 14.6259 $w=2.1e-08 $l=4.3e-08 $layer=Gate_1 $thickness=5.6e-08 $X=0.351
+ $Y=0.0675 $X2=0.351 $Y2=0.0245
.ends

.subckt PM_OA332x1_ASAP7_75t_R%B3 vss 13 5 9 4 3
c1 1 vss 0.00602975f $X=0.405 $Y=0.135
c2 3 vss 0.140048f $X=0.405 $Y=0.0245
c3 4 vss 0.00532786f $X=0.405 $Y=0.116
r1 13 12 1.34084 $w=1.3e-08 $l=5.8e-09 $layer=M1 $thickness=3.6e-08 $X=0.403
+ $Y=0.155 $X2=0.405 $Y2=0.1492
r2 11 12 3.32295 $w=1.3e-08 $l=1.42e-08 $layer=M1 $thickness=3.6e-08 $X=0.405
+ $Y=0.135 $X2=0.405 $Y2=0.1492
r3 4 11 4.4306 $w=1.3e-08 $l=1.9e-08 $layer=M1 $thickness=3.6e-08 $X=0.405
+ $Y=0.116 $X2=0.405 $Y2=0.135
r4 1 7 10.4265 $w=1.765e-08 $layer=LIG $thickness=5.2e-08 $X=0.405 $Y=0.135
+ $X2=0.405 $Y2=0.135
r5 1 11 19.3796 $a=3.24e-16 $layer=V0LIG $X=0.405 $Y=0.135 $X2=0.405 $Y2=0.135
r6 9 8 16.4967 $w=2.1e-08 $l=4.85e-08 $layer=Gate_1 $thickness=5.6e-08 $X=0.405
+ $Y=0.2025 $X2=0.405 $Y2=0.154
r7 7 8 6.6497 $w=2.04211e-08 $l=1.9e-08 $layer=Gate_1 $thickness=5.6e-08
+ $X=0.405 $Y=0.135 $X2=0.405 $Y2=0.154
r8 6 7 6.6497 $w=2.04211e-08 $l=1.9e-08 $layer=Gate_1 $thickness=5.6e-08
+ $X=0.405 $Y=0.116 $X2=0.405 $Y2=0.135
r9 5 6 16.4967 $w=2.1e-08 $l=4.85e-08 $layer=Gate_1 $thickness=5.6e-08 $X=0.405
+ $Y=0.0675 $X2=0.405 $Y2=0.116
r10 5 3 14.6259 $w=2.1e-08 $l=4.3e-08 $layer=Gate_1 $thickness=5.6e-08 $X=0.405
+ $Y=0.0675 $X2=0.405 $Y2=0.0245
.ends

.subckt PM_OA332x1_ASAP7_75t_R%C2 vss 13 5 9 3 4
c1 1 vss 0.00666233f $X=0.459 $Y=0.135
c2 3 vss 0.102324f $X=0.459 $Y=0.0245
c3 4 vss 0.00437476f $X=0.459 $Y=0.116
r1 13 12 1.45744 $w=1.3e-08 $l=6.3e-09 $layer=M1 $thickness=3.6e-08 $X=0.46
+ $Y=0.156 $X2=0.459 $Y2=0.1497
r2 11 12 3.43955 $w=1.3e-08 $l=1.47e-08 $layer=M1 $thickness=3.6e-08 $X=0.459
+ $Y=0.135 $X2=0.459 $Y2=0.1497
r3 4 11 4.4306 $w=1.3e-08 $l=1.9e-08 $layer=M1 $thickness=3.6e-08 $X=0.459
+ $Y=0.116 $X2=0.459 $Y2=0.135
r4 1 7 10.4265 $w=1.765e-08 $layer=LIG $thickness=5.2e-08 $X=0.459 $Y=0.135
+ $X2=0.459 $Y2=0.135
r5 1 11 19.3796 $a=3.24e-16 $layer=V0LIG $X=0.459 $Y=0.135 $X2=0.459 $Y2=0.135
r6 9 8 16.4967 $w=2.1e-08 $l=4.85e-08 $layer=Gate_1 $thickness=5.6e-08 $X=0.459
+ $Y=0.2025 $X2=0.459 $Y2=0.154
r7 7 8 6.6497 $w=2.04211e-08 $l=1.9e-08 $layer=Gate_1 $thickness=5.6e-08
+ $X=0.459 $Y=0.135 $X2=0.459 $Y2=0.154
r8 6 7 6.6497 $w=2.04211e-08 $l=1.9e-08 $layer=Gate_1 $thickness=5.6e-08
+ $X=0.459 $Y=0.116 $X2=0.459 $Y2=0.135
r9 5 6 16.4967 $w=2.1e-08 $l=4.85e-08 $layer=Gate_1 $thickness=5.6e-08 $X=0.459
+ $Y=0.0675 $X2=0.459 $Y2=0.116
r10 5 3 14.6259 $w=2.1e-08 $l=4.3e-08 $layer=Gate_1 $thickness=5.6e-08 $X=0.459
+ $Y=0.0675 $X2=0.459 $Y2=0.0245
.ends

.subckt PM_OA332x1_ASAP7_75t_R%C1 vss 15 5 11 3 4 1
c1 1 vss 0.00292494f $X=0.513 $Y=0.135
c2 3 vss 0.070781f $X=0.513 $Y=0.0245
c3 4 vss 0.00474668f $X=0.513 $Y=0.116
r1 15 14 1.34084 $w=1.3e-08 $l=5.8e-09 $layer=M1 $thickness=3.6e-08 $X=0.513
+ $Y=0.155 $X2=0.513 $Y2=0.1492
r2 13 14 3.32295 $w=1.3e-08 $l=1.42e-08 $layer=M1 $thickness=3.6e-08 $X=0.513
+ $Y=0.135 $X2=0.513 $Y2=0.1492
r3 4 13 4.4306 $w=1.3e-08 $l=1.9e-08 $layer=M1 $thickness=3.6e-08 $X=0.513
+ $Y=0.116 $X2=0.513 $Y2=0.135
r4 1 8 10.4265 $w=1.765e-08 $layer=LIG $thickness=5.2e-08 $X=0.513 $Y=0.135
+ $X2=0.513 $Y2=0.135
r5 1 13 19.3796 $a=3.24e-16 $layer=V0LIG $X=0.513 $Y=0.135 $X2=0.513 $Y2=0.135
r6 11 10 14.6259 $w=2.1e-08 $l=4.3e-08 $layer=Gate_1 $thickness=5.6e-08
+ $X=0.513 $Y=0.2025 $X2=0.513 $Y2=0.1595
r7 9 10 2.7211 $w=2.1e-08 $l=8e-09 $layer=Gate_1 $thickness=5.6e-08 $X=0.513
+ $Y=0.1515 $X2=0.513 $Y2=0.1595
r8 8 9 5.79936 $w=2.03333e-08 $l=1.65e-08 $layer=Gate_1 $thickness=5.6e-08
+ $X=0.513 $Y=0.135 $X2=0.513 $Y2=0.1515
r9 7 8 5.79936 $w=2.03333e-08 $l=1.65e-08 $layer=Gate_1 $thickness=5.6e-08
+ $X=0.513 $Y=0.1185 $X2=0.513 $Y2=0.135
r10 6 7 2.7211 $w=2.1e-08 $l=8e-09 $layer=Gate_1 $thickness=5.6e-08 $X=0.513
+ $Y=0.1105 $X2=0.513 $Y2=0.1185
r11 5 6 14.6259 $w=2.1e-08 $l=4.3e-08 $layer=Gate_1 $thickness=5.6e-08 $X=0.513
+ $Y=0.0675 $X2=0.513 $Y2=0.1105
r12 5 3 14.6259 $w=2.1e-08 $l=4.3e-08 $layer=Gate_1 $thickness=5.6e-08 $X=0.513
+ $Y=0.0675 $X2=0.513 $Y2=0.0245
.ends

.subckt PM_OA332x1_ASAP7_75t_R%3 vss 27 33 63 64 68 76 77 17 1 21 12 14 3 24 4
+ 25 13 5 15 26 16 23 18 22
c1 1 vss 0.00371882f $X=0.081 $Y=0.135
c2 3 vss 0.00502924f $X=0.27 $Y=0.2025
c3 4 vss 0.00993444f $X=0.486 $Y=0.0675
c4 5 vss 0.00683279f $X=0.54 $Y=0.2025
c5 12 vss 0.0814936f $X=0.081 $Y=0.0245
c6 13 vss 0.0054572f $X=0.4715 $Y=0.0675
c7 14 vss 0.00361423f $X=0.2555 $Y=0.2025
c8 15 vss 0.0382896f $X=0.5255 $Y=0.2025
c9 16 vss 0.000707997f $X=0.081 $Y=0.198
c10 17 vss 0.000678196f $X=0.135 $Y=0.1945
c11 18 vss 0.00285601f $X=0.135 $Y=0.234
c12 19 vss 0.00264152f $X=0.567 $Y=0.072
c13 20 vss 0.00291343f $X=0.567 $Y=0.234
c14 21 vss 0.00165441f $X=0.081 $Y=0.1225
c15 22 vss 0.00133195f $X=0.092 $Y=0.198
c16 23 vss 0.00064578f $X=0.135 $Y=0.216
c17 24 vss 0.036257f $X=0.145 $Y=0.234
c18 25 vss 0.00847477f $X=0.557 $Y=0.072
c19 26 vss 0.00590612f $X=0.567 $Y=0.2125
r1 77 75 0.0308642 $w=8.1e-08 $l=2.5e-09 $layer=N_src_drn $thickness=1e-09
+ $X=0.5033 $Y=0.0675 $X2=0.5005 $Y2=0.0675
r2 4 75 0.179012 $w=8.1e-08 $l=1.45e-08 $layer=N_src_drn $thickness=1e-09
+ $X=0.486 $Y=0.0675 $X2=0.5005 $Y2=0.0675
r3 13 4 0.179012 $w=8.1e-08 $l=1.45e-08 $layer=N_src_drn $thickness=1e-09
+ $X=0.4715 $Y=0.0675 $X2=0.486 $Y2=0.0675
r4 76 13 0.0308642 $w=8.1e-08 $l=2.5e-09 $layer=N_src_drn $thickness=1e-09
+ $X=0.4686 $Y=0.0675 $X2=0.4715 $Y2=0.0675
r5 4 72 19.3796 $a=3.24e-16 $layer=V0LISD $X=0.486 $Y=0.0675 $X2=0.486 $Y2=0.072
r6 72 73 3.14806 $w=1.3e-08 $l=1.35e-08 $layer=M1 $thickness=3.6e-08 $X=0.486
+ $Y=0.072 $X2=0.4995 $Y2=0.072
r7 70 73 3.14806 $w=1.3e-08 $l=1.35e-08 $layer=M1 $thickness=3.6e-08 $X=0.513
+ $Y=0.072 $X2=0.4995 $Y2=0.072
r8 69 70 6.06293 $w=1.3e-08 $l=2.6e-08 $layer=M1 $thickness=3.6e-08 $X=0.539
+ $Y=0.072 $X2=0.513 $Y2=0.072
r9 25 69 4.19742 $w=1.3e-08 $l=1.8e-08 $layer=M1 $thickness=3.6e-08 $X=0.557
+ $Y=0.072 $X2=0.539 $Y2=0.072
r10 19 66 3.36447 $w=1.71023e-08 $l=2.15e-08 $layer=M1 $thickness=3.6e-08
+ $X=0.567 $Y=0.072 $X2=0.567 $Y2=0.0935
r11 19 25 0.682785 $w=1.75e-08 $l=1e-08 $layer=M1 $thickness=3.6e-08 $X=0.567
+ $Y=0.072 $X2=0.557 $Y2=0.072
r12 15 5 0.154321 $w=8.1e-08 $l=1.25e-08 $layer=P_src_drn $thickness=1e-09
+ $X=0.5255 $Y=0.2025 $X2=0.54 $Y2=0.2025
r13 68 15 0.0308642 $w=8.1e-08 $l=2.5e-09 $layer=P_src_drn $thickness=1e-09
+ $X=0.5226 $Y=0.2025 $X2=0.5255 $Y2=0.2025
r14 65 66 13.8748 $w=1.3e-08 $l=5.95e-08 $layer=M1 $thickness=3.6e-08 $X=0.567
+ $Y=0.153 $X2=0.567 $Y2=0.0935
r15 26 65 13.8748 $w=1.3e-08 $l=5.95e-08 $layer=M1 $thickness=3.6e-08 $X=0.567
+ $Y=0.2125 $X2=0.567 $Y2=0.153
r16 64 62 0.0308642 $w=8.1e-08 $l=2.5e-09 $layer=P_src_drn $thickness=1e-09
+ $X=0.2873 $Y=0.2025 $X2=0.2845 $Y2=0.2025
r17 3 62 0.179012 $w=8.1e-08 $l=1.45e-08 $layer=P_src_drn $thickness=1e-09
+ $X=0.27 $Y=0.2025 $X2=0.2845 $Y2=0.2025
r18 14 3 0.179012 $w=8.1e-08 $l=1.45e-08 $layer=P_src_drn $thickness=1e-09
+ $X=0.2555 $Y=0.2025 $X2=0.27 $Y2=0.2025
r19 63 14 0.0308642 $w=8.1e-08 $l=2.5e-09 $layer=P_src_drn $thickness=1e-09
+ $X=0.2526 $Y=0.2025 $X2=0.2555 $Y2=0.2025
r20 5 59 19.3796 $a=3.24e-16 $layer=V0LISD $X=0.54 $Y=0.2025 $X2=0.54 $Y2=0.234
r21 20 60 1.49895 $w=1.63333e-08 $l=1.35e-08 $layer=M1 $thickness=3.6e-08
+ $X=0.567 $Y=0.234 $X2=0.5535 $Y2=0.234
r22 20 26 3.36447 $w=1.71023e-08 $l=2.15e-08 $layer=M1 $thickness=3.6e-08
+ $X=0.567 $Y=0.234 $X2=0.567 $Y2=0.2125
r23 3 45 19.3796 $a=3.24e-16 $layer=V0LISD $X=0.27 $Y=0.2025 $X2=0.27 $Y2=0.234
r24 59 60 3.14806 $w=1.3e-08 $l=1.35e-08 $layer=M1 $thickness=3.6e-08 $X=0.54
+ $Y=0.234 $X2=0.5535 $Y2=0.234
r25 58 59 3.14806 $w=1.3e-08 $l=1.35e-08 $layer=M1 $thickness=3.6e-08 $X=0.5265
+ $Y=0.234 $X2=0.54 $Y2=0.234
r26 57 58 3.14806 $w=1.3e-08 $l=1.35e-08 $layer=M1 $thickness=3.6e-08 $X=0.513
+ $Y=0.234 $X2=0.5265 $Y2=0.234
r27 56 57 5.94634 $w=1.3e-08 $l=2.55e-08 $layer=M1 $thickness=3.6e-08 $X=0.4875
+ $Y=0.234 $X2=0.513 $Y2=0.234
r28 55 56 4.19742 $w=1.3e-08 $l=1.8e-08 $layer=M1 $thickness=3.6e-08 $X=0.4695
+ $Y=0.234 $X2=0.4875 $Y2=0.234
r29 54 55 2.44849 $w=1.3e-08 $l=1.05e-08 $layer=M1 $thickness=3.6e-08 $X=0.459
+ $Y=0.234 $X2=0.4695 $Y2=0.234
r30 53 54 6.29612 $w=1.3e-08 $l=2.7e-08 $layer=M1 $thickness=3.6e-08 $X=0.432
+ $Y=0.234 $X2=0.459 $Y2=0.234
r31 52 53 6.29612 $w=1.3e-08 $l=2.7e-08 $layer=M1 $thickness=3.6e-08 $X=0.405
+ $Y=0.234 $X2=0.432 $Y2=0.234
r32 51 52 2.44849 $w=1.3e-08 $l=1.05e-08 $layer=M1 $thickness=3.6e-08 $X=0.3945
+ $Y=0.234 $X2=0.405 $Y2=0.234
r33 50 51 4.19742 $w=1.3e-08 $l=1.8e-08 $layer=M1 $thickness=3.6e-08 $X=0.3765
+ $Y=0.234 $X2=0.3945 $Y2=0.234
r34 49 50 5.94634 $w=1.3e-08 $l=2.55e-08 $layer=M1 $thickness=3.6e-08 $X=0.351
+ $Y=0.234 $X2=0.3765 $Y2=0.234
r35 48 49 6.29612 $w=1.3e-08 $l=2.7e-08 $layer=M1 $thickness=3.6e-08 $X=0.324
+ $Y=0.234 $X2=0.351 $Y2=0.234
r36 47 48 6.29612 $w=1.3e-08 $l=2.7e-08 $layer=M1 $thickness=3.6e-08 $X=0.297
+ $Y=0.234 $X2=0.324 $Y2=0.234
r37 46 47 3.14806 $w=1.3e-08 $l=1.35e-08 $layer=M1 $thickness=3.6e-08 $X=0.2835
+ $Y=0.234 $X2=0.297 $Y2=0.234
r38 45 46 3.14806 $w=1.3e-08 $l=1.35e-08 $layer=M1 $thickness=3.6e-08 $X=0.27
+ $Y=0.234 $X2=0.2835 $Y2=0.234
r39 44 45 3.14806 $w=1.3e-08 $l=1.35e-08 $layer=M1 $thickness=3.6e-08 $X=0.2565
+ $Y=0.234 $X2=0.27 $Y2=0.234
r40 43 44 3.14806 $w=1.3e-08 $l=1.35e-08 $layer=M1 $thickness=3.6e-08 $X=0.243
+ $Y=0.234 $X2=0.2565 $Y2=0.234
r41 42 43 6.29612 $w=1.3e-08 $l=2.7e-08 $layer=M1 $thickness=3.6e-08 $X=0.216
+ $Y=0.234 $X2=0.243 $Y2=0.234
r42 41 42 6.29612 $w=1.3e-08 $l=2.7e-08 $layer=M1 $thickness=3.6e-08 $X=0.189
+ $Y=0.234 $X2=0.216 $Y2=0.234
r43 40 41 6.06293 $w=1.3e-08 $l=2.6e-08 $layer=M1 $thickness=3.6e-08 $X=0.163
+ $Y=0.234 $X2=0.189 $Y2=0.234
r44 24 40 4.19742 $w=1.3e-08 $l=1.8e-08 $layer=M1 $thickness=3.6e-08 $X=0.145
+ $Y=0.234 $X2=0.163 $Y2=0.234
r45 18 23 2.5483 $w=1.79e-08 $l=1.8e-08 $layer=M1 $thickness=3.6e-08 $X=0.135
+ $Y=0.234 $X2=0.135 $Y2=0.216
r46 18 24 0.682785 $w=1.75e-08 $l=1e-08 $layer=M1 $thickness=3.6e-08 $X=0.135
+ $Y=0.234 $X2=0.145 $Y2=0.234
r47 23 39 2.45586 $w=1.44e-08 $l=1.25e-08 $layer=M1 $thickness=3.6e-08 $X=0.135
+ $Y=0.216 $X2=0.135 $Y2=0.2035
r48 17 39 0.9184 $w=1.8e-08 $l=9e-09 $layer=M1 $thickness=3.6e-08 $X=0.135
+ $Y=0.1945 $X2=0.135 $Y2=0.2035
r49 38 39 4.08819 $w=1.38974e-08 $l=2.55979e-08 $layer=M1 $thickness=3.6e-08
+ $X=0.11 $Y=0.198 $X2=0.135 $Y2=0.2035
r50 22 38 4.19742 $w=1.3e-08 $l=1.8e-08 $layer=M1 $thickness=3.6e-08 $X=0.092
+ $Y=0.198 $X2=0.11 $Y2=0.198
r51 16 37 3.36447 $w=1.71023e-08 $l=2.15e-08 $layer=M1 $thickness=3.6e-08
+ $X=0.081 $Y=0.198 $X2=0.081 $Y2=0.1765
r52 16 22 0.915974 $w=1.70909e-08 $l=1.1e-08 $layer=M1 $thickness=3.6e-08
+ $X=0.081 $Y=0.198 $X2=0.092 $Y2=0.198
r53 36 37 5.24677 $w=1.3e-08 $l=2.25e-08 $layer=M1 $thickness=3.6e-08 $X=0.081
+ $Y=0.154 $X2=0.081 $Y2=0.1765
r54 35 36 4.43061 $w=1.3e-08 $l=1.9e-08 $layer=M1 $thickness=3.6e-08 $X=0.081
+ $Y=0.135 $X2=0.081 $Y2=0.154
r55 21 35 2.91487 $w=1.3e-08 $l=1.25e-08 $layer=M1 $thickness=3.6e-08 $X=0.081
+ $Y=0.1225 $X2=0.081 $Y2=0.135
r56 1 30 10.4265 $w=1.765e-08 $layer=LIG $thickness=5.2e-08 $X=0.081 $Y=0.135
+ $X2=0.081 $Y2=0.135
r57 1 35 19.3796 $a=3.24e-16 $layer=V0LIG $X=0.081 $Y=0.135 $X2=0.081 $Y2=0.135
r58 33 32 14.6259 $w=2.1e-08 $l=4.3e-08 $layer=Gate_1 $thickness=5.6e-08
+ $X=0.081 $Y=0.2025 $X2=0.081 $Y2=0.1595
r59 31 32 2.7211 $w=2.1e-08 $l=8e-09 $layer=Gate_1 $thickness=5.6e-08 $X=0.081
+ $Y=0.1515 $X2=0.081 $Y2=0.1595
r60 30 31 5.79936 $w=2.03333e-08 $l=1.65e-08 $layer=Gate_1 $thickness=5.6e-08
+ $X=0.081 $Y=0.135 $X2=0.081 $Y2=0.1515
r61 29 30 5.79936 $w=2.03333e-08 $l=1.65e-08 $layer=Gate_1 $thickness=5.6e-08
+ $X=0.081 $Y=0.1185 $X2=0.081 $Y2=0.135
r62 28 29 2.7211 $w=2.1e-08 $l=8e-09 $layer=Gate_1 $thickness=5.6e-08 $X=0.081
+ $Y=0.1105 $X2=0.081 $Y2=0.1185
r63 27 28 14.6259 $w=2.1e-08 $l=4.3e-08 $layer=Gate_1 $thickness=5.6e-08
+ $X=0.081 $Y=0.0675 $X2=0.081 $Y2=0.1105
r64 27 12 14.6259 $w=2.1e-08 $l=4.3e-08 $layer=Gate_1 $thickness=5.6e-08
+ $X=0.081 $Y=0.0675 $X2=0.081 $Y2=0.0245
.ends

.subckt PM_OA332x1_ASAP7_75t_R%Y vss 20 14 28 8 12 11 7
c1 7 vss 0.0481369f $X=0.056 $Y=0.0675
c2 8 vss 0.0468112f $X=0.056 $Y=0.2025
c3 9 vss 0.00646755f $X=0.0405 $Y=0.036
c4 10 vss 0.00281317f $X=0.027 $Y=0.234
c5 11 vss 0.0059638f $X=0.027 $Y=0.0575
c6 12 vss 0.00563844f $X=0.0405 $Y=0.234
r1 28 27 0.0308642 $w=8.1e-08 $l=2.5e-09 $layer=P_src_drn $thickness=1e-09
+ $X=0.0713 $Y=0.2025 $X2=0.0685 $Y2=0.2025
r2 8 27 0.154321 $w=8.1e-08 $l=1.25e-08 $layer=P_src_drn $thickness=1e-09
+ $X=0.056 $Y=0.2025 $X2=0.0685 $Y2=0.2025
r3 8 23 19.3796 $a=3.24e-16 $layer=V0LISD $X=0.056 $Y=0.2025 $X2=0.054 $Y2=0.234
r4 12 23 3.14806 $w=1.3e-08 $l=1.35e-08 $layer=M1 $thickness=3.6e-08 $X=0.0405
+ $Y=0.234 $X2=0.054 $Y2=0.234
r5 10 22 2.5483 $w=1.79e-08 $l=1.8e-08 $layer=M1 $thickness=3.6e-08 $X=0.027
+ $Y=0.234 $X2=0.027 $Y2=0.216
r6 10 12 1.49895 $w=1.63333e-08 $l=1.35e-08 $layer=M1 $thickness=3.6e-08
+ $X=0.027 $Y=0.234 $X2=0.0405 $Y2=0.234
r7 21 22 9.91056 $w=1.3e-08 $l=4.25e-08 $layer=M1 $thickness=3.6e-08 $X=0.027
+ $Y=0.1735 $X2=0.027 $Y2=0.216
r8 20 21 7.92845 $w=1.3e-08 $l=3.4e-08 $layer=M1 $thickness=3.6e-08 $X=0.0255
+ $Y=0.1395 $X2=0.027 $Y2=0.1735
r9 20 19 2.44849 $w=1.3e-08 $l=1.05e-08 $layer=M1 $thickness=3.6e-08 $X=0.0255
+ $Y=0.1395 $X2=0.027 $Y2=0.129
r10 18 19 8.04505 $w=1.3e-08 $l=3.45e-08 $layer=M1 $thickness=3.6e-08 $X=0.027
+ $Y=0.0945 $X2=0.027 $Y2=0.129
r11 11 17 3.83327 $w=1.5093e-08 $l=2.15e-08 $layer=M1 $thickness=3.6e-08
+ $X=0.027 $Y=0.0575 $X2=0.027 $Y2=0.036
r12 11 18 8.62802 $w=1.3e-08 $l=3.7e-08 $layer=M1 $thickness=3.6e-08 $X=0.027
+ $Y=0.0575 $X2=0.027 $Y2=0.0945
r13 9 15 3.14806 $w=1.3e-08 $l=1.35e-08 $layer=M1 $thickness=3.6e-08 $X=0.0405
+ $Y=0.036 $X2=0.054 $Y2=0.036
r14 9 17 1.96775 $w=1.63333e-08 $l=1.35e-08 $layer=M1 $thickness=3.6e-08
+ $X=0.0405 $Y=0.036 $X2=0.027 $Y2=0.036
r15 7 15 19.3796 $a=3.24e-16 $layer=V0LISD $X=0.056 $Y=0.0675 $X2=0.054
+ $Y2=0.036
r16 14 13 0.0308642 $w=8.1e-08 $l=2.5e-09 $layer=N_src_drn $thickness=1e-09
+ $X=0.0713 $Y=0.0675 $X2=0.0685 $Y2=0.0675
r17 7 13 0.154321 $w=8.1e-08 $l=1.25e-08 $layer=N_src_drn $thickness=1e-09
+ $X=0.056 $Y=0.0675 $X2=0.0685 $Y2=0.0675
.ends

.subckt PM_OA332x1_ASAP7_75t_R%A2 vss 13 5 9 4 3
c1 1 vss 0.00446117f $X=0.189 $Y=0.135
c2 3 vss 0.121218f $X=0.189 $Y=0.0245
c3 4 vss 0.00784167f $X=0.189 $Y=0.116
r1 13 12 1.34084 $w=1.3e-08 $l=5.8e-09 $layer=M1 $thickness=3.6e-08 $X=0.189
+ $Y=0.155 $X2=0.189 $Y2=0.1492
r2 11 12 3.32295 $w=1.3e-08 $l=1.42e-08 $layer=M1 $thickness=3.6e-08 $X=0.189
+ $Y=0.135 $X2=0.189 $Y2=0.1492
r3 4 11 4.43061 $w=1.3e-08 $l=1.9e-08 $layer=M1 $thickness=3.6e-08 $X=0.189
+ $Y=0.116 $X2=0.189 $Y2=0.135
r4 1 7 10.4265 $w=1.765e-08 $layer=LIG $thickness=5.2e-08 $X=0.189 $Y=0.135
+ $X2=0.189 $Y2=0.135
r5 1 11 19.3796 $a=3.24e-16 $layer=V0LIG $X=0.189 $Y=0.135 $X2=0.189 $Y2=0.135
r6 9 8 16.4967 $w=2.1e-08 $l=4.85e-08 $layer=Gate_1 $thickness=5.6e-08 $X=0.189
+ $Y=0.2025 $X2=0.189 $Y2=0.154
r7 7 8 6.6497 $w=2.04211e-08 $l=1.9e-08 $layer=Gate_1 $thickness=5.6e-08
+ $X=0.189 $Y=0.135 $X2=0.189 $Y2=0.154
r8 6 7 6.6497 $w=2.04211e-08 $l=1.9e-08 $layer=Gate_1 $thickness=5.6e-08
+ $X=0.189 $Y=0.116 $X2=0.189 $Y2=0.135
r9 5 6 16.4967 $w=2.1e-08 $l=4.85e-08 $layer=Gate_1 $thickness=5.6e-08 $X=0.189
+ $Y=0.0675 $X2=0.189 $Y2=0.116
r10 5 3 14.6259 $w=2.1e-08 $l=4.3e-08 $layer=Gate_1 $thickness=5.6e-08 $X=0.189
+ $Y=0.0675 $X2=0.189 $Y2=0.0245
.ends

.subckt PM_OA332x1_ASAP7_75t_R%A1 vss 13 5 9 3 4
c1 1 vss 0.00469605f $X=0.243 $Y=0.135
c2 3 vss 0.102234f $X=0.243 $Y=0.0245
c3 4 vss 0.00661093f $X=0.243 $Y=0.116
r1 13 12 1.34084 $w=1.3e-08 $l=5.8e-09 $layer=M1 $thickness=3.6e-08 $X=0.243
+ $Y=0.155 $X2=0.243 $Y2=0.1492
r2 11 12 3.32295 $w=1.3e-08 $l=1.42e-08 $layer=M1 $thickness=3.6e-08 $X=0.243
+ $Y=0.135 $X2=0.243 $Y2=0.1492
r3 4 11 4.4306 $w=1.3e-08 $l=1.9e-08 $layer=M1 $thickness=3.6e-08 $X=0.243
+ $Y=0.116 $X2=0.243 $Y2=0.135
r4 1 7 10.4265 $w=1.765e-08 $layer=LIG $thickness=5.2e-08 $X=0.243 $Y=0.135
+ $X2=0.243 $Y2=0.135
r5 1 11 19.3796 $a=3.24e-16 $layer=V0LIG $X=0.243 $Y=0.135 $X2=0.243 $Y2=0.135
r6 9 8 16.4967 $w=2.1e-08 $l=4.85e-08 $layer=Gate_1 $thickness=5.6e-08 $X=0.243
+ $Y=0.2025 $X2=0.243 $Y2=0.154
r7 7 8 6.6497 $w=2.04211e-08 $l=1.9e-08 $layer=Gate_1 $thickness=5.6e-08
+ $X=0.243 $Y=0.135 $X2=0.243 $Y2=0.154
r8 6 7 6.6497 $w=2.04211e-08 $l=1.9e-08 $layer=Gate_1 $thickness=5.6e-08
+ $X=0.243 $Y=0.116 $X2=0.243 $Y2=0.135
r9 5 6 16.4967 $w=2.1e-08 $l=4.85e-08 $layer=Gate_1 $thickness=5.6e-08 $X=0.243
+ $Y=0.0675 $X2=0.243 $Y2=0.116
r10 5 3 14.6259 $w=2.1e-08 $l=4.3e-08 $layer=Gate_1 $thickness=5.6e-08 $X=0.243
+ $Y=0.0675 $X2=0.243 $Y2=0.0245
.ends

* End of included file OA332x1_ASAP7_75t_R.pex.sp.pex

*
.subckt OA332x1_ASAP7_75t_CUSTOM_4_25_0_7 VSS VDD A3 A2 A1 B1 B2 B3 C2 C1 Y
*
* VSS VSS
* VDD VDD
* A3 A3
* A2 A2
* A1 A1
* B1 B1
* B2 B2
* B3 B3
* C2 C2
* C1 C1
* Y Y
*
*

M0 VSS N_M0_g N_M0_s VSS nmos_rvt L=2e-08 W=8.1e-08 nfin=3 $X=0.071 $Y=0.027
M1 noxref_13 N_M1_g VSS VSS nmos_rvt L=2e-08 W=8.1e-08 nfin=3 $X=0.125 $Y=0.027
M2 VSS N_M2_g noxref_13 VSS nmos_rvt L=2e-08 W=8.1e-08 nfin=3 $X=0.179 $Y=0.027
M3 noxref_13 N_M3_g VSS VSS nmos_rvt L=2e-08 W=8.1e-08 nfin=3 $X=0.233 $Y=0.027
M4 noxref_14 N_M4_g noxref_13 VSS nmos_rvt L=2e-08 W=8.1e-08 nfin=3 $X=0.287
+ $Y=0.027
M5 noxref_13 N_M5_g noxref_14 VSS nmos_rvt L=2e-08 W=8.1e-08 nfin=3 $X=0.341
+ $Y=0.027
M6 noxref_14 N_M6_g noxref_13 VSS nmos_rvt L=2e-08 W=8.1e-08 nfin=3 $X=0.395
+ $Y=0.027
M7 N_M7_d N_M7_g noxref_14 VSS nmos_rvt L=2e-08 W=8.1e-08 nfin=3 $X=0.449
+ $Y=0.027
M8 noxref_14 N_M8_g N_M8_s VSS nmos_rvt L=2e-08 W=8.1e-08 nfin=3 $X=0.503
+ $Y=0.027
M9 VDD N_M9_g N_M9_s VDD pmos_rvt L=2e-08 W=8.1e-08 nfin=3 $X=0.071 $Y=0.162
M10 noxref_15 N_M10_g VDD VDD pmos_rvt L=2e-08 W=8.1e-08 nfin=3 $X=0.125
+ $Y=0.162
M11 noxref_16 N_M11_g noxref_15 VDD pmos_rvt L=2e-08 W=8.1e-08 nfin=3 $X=0.179
+ $Y=0.162
M12 N_M12_d N_M12_g noxref_16 VDD pmos_rvt L=2e-08 W=8.1e-08 nfin=3 $X=0.233
+ $Y=0.162
M13 noxref_17 N_M13_g N_M13_s VDD pmos_rvt L=2e-08 W=8.1e-08 nfin=3 $X=0.287
+ $Y=0.162
M14 noxref_18 N_M14_g noxref_17 VDD pmos_rvt L=2e-08 W=8.1e-08 nfin=3 $X=0.341
+ $Y=0.162
M15 VDD N_M15_g noxref_18 VDD pmos_rvt L=2e-08 W=8.1e-08 nfin=3 $X=0.395
+ $Y=0.162
M16 noxref_19 N_M16_g VDD VDD pmos_rvt L=2e-08 W=8.1e-08 nfin=3 $X=0.449
+ $Y=0.162
M17 N_M17_d N_M17_g noxref_19 VDD pmos_rvt L=2e-08 W=8.1e-08 nfin=3 $X=0.503
+ $Y=0.162

* .include "OA332x1_ASAP7_75t_R.pex.sp.pxi"

* Start of included file OA332x1_ASAP7_75t_R.pex.sp.pxi
x_PM_OA332x1_ASAP7_75t_R%A3 vss A3 N_M1_g N_M10_g N_A3_3 N_A3_4
+ PM_OA332x1_ASAP7_75t_R%A3
cc_1 N_A3_3 N_3_17 0.000551716f $X=0.135 $Y=0.0245
cc_2 N_A3_3 N_3_1 0.00194541f $X=0.135 $Y=0.0245
cc_3 N_A3_4 N_3_21 0.0032284f $X=0.135 $Y=0.0945
cc_4 N_A3_3 N_3_12 0.00393234f $X=0.135 $Y=0.0245
x_PM_OA332x1_ASAP7_75t_R%B1 vss B1 N_M4_g N_M13_g N_B1_4 N_B1_3
+ PM_OA332x1_ASAP7_75t_R%B1
cc_5 N_B1_4 N_3_24 0.00125093f $X=0.297 $Y=0.116
cc_6 N_B1_3 N_3_3 0.00151236f $X=0.297 $Y=0.0245
cc_7 N_B1_4 N_3_3 0.00183395f $X=0.297 $Y=0.116
cc_8 N_B1_3 N_3_14 0.0361224f $X=0.297 $Y=0.0245
cc_9 N_B1_3 N_A1_3 0.00317569f $X=0.297 $Y=0.0245
cc_10 N_B1_4 N_A1_4 0.00497908f $X=0.297 $Y=0.116
x_PM_OA332x1_ASAP7_75t_R%B2 vss B2 N_M5_g N_M14_g N_B2_4 N_B2_3
+ PM_OA332x1_ASAP7_75t_R%B2
cc_11 N_B2_4 N_3_24 0.0034643f $X=0.351 $Y=0.116
cc_12 N_B2_4 N_B1_4 0.00334017f $X=0.351 $Y=0.116
cc_13 N_B2_3 N_B1_3 0.006912f $X=0.351 $Y=0.0245
x_PM_OA332x1_ASAP7_75t_R%B3 vss B3 N_M6_g N_M15_g N_B3_4 N_B3_3
+ PM_OA332x1_ASAP7_75t_R%B3
cc_14 N_B3_4 N_3_24 0.00305597f $X=0.405 $Y=0.116
cc_15 N_B3_4 N_B2_4 0.00333171f $X=0.405 $Y=0.116
cc_16 N_B3_3 N_B2_3 0.00699449f $X=0.405 $Y=0.0245
x_PM_OA332x1_ASAP7_75t_R%C2 vss C2 N_M7_g N_M16_g N_C2_3 N_C2_4
+ PM_OA332x1_ASAP7_75t_R%C2
cc_17 N_C2_3 N_3_4 0.00119947f $X=0.459 $Y=0.0245
cc_18 N_C2_3 N_3_25 0.00054336f $X=0.459 $Y=0.0245
cc_19 N_C2_4 N_3_24 0.00129739f $X=0.459 $Y=0.116
cc_20 N_C2_4 N_3_4 0.00219199f $X=0.459 $Y=0.116
cc_21 N_C2_3 N_3_13 0.0360525f $X=0.459 $Y=0.0245
cc_22 N_C2_3 N_B3_3 0.00317358f $X=0.459 $Y=0.0245
cc_23 N_C2_4 N_B3_4 0.00505884f $X=0.459 $Y=0.116
x_PM_OA332x1_ASAP7_75t_R%C1 vss C1 N_M8_g N_M17_g N_C1_3 N_C1_4 N_C1_1
+ PM_OA332x1_ASAP7_75t_R%C1
cc_24 N_C1_3 N_3_13 0.0152611f $X=0.513 $Y=0.0245
cc_25 N_C1_3 N_3_4 0.000799512f $X=0.513 $Y=0.0245
cc_26 N_C1_3 N_3_5 0.00244213f $X=0.513 $Y=0.0245
cc_27 N_C1_3 N_3_25 0.000990462f $X=0.513 $Y=0.0245
cc_28 N_C1_4 N_3_24 0.00114931f $X=0.513 $Y=0.116
cc_29 N_C1_1 N_3_15 0.0017306f $X=0.513 $Y=0.135
cc_30 N_C1_4 N_3_26 0.00665105f $X=0.513 $Y=0.116
cc_31 N_C1_3 N_3_15 0.0547018f $X=0.513 $Y=0.0245
cc_32 N_C1_4 N_C2_4 0.00329591f $X=0.513 $Y=0.116
cc_33 N_C1_3 N_C2_3 0.00694646f $X=0.513 $Y=0.0245
x_PM_OA332x1_ASAP7_75t_R%3 vss N_M0_g N_M9_g N_M12_d N_M13_s N_M17_d N_M7_d
+ N_M8_s N_3_17 N_3_1 N_3_21 N_3_12 N_3_14 N_3_3 N_3_24 N_3_4 N_3_25 N_3_13
+ N_3_5 N_3_15 N_3_26 N_3_16 N_3_23 N_3_18 N_3_22 PM_OA332x1_ASAP7_75t_R%3
x_PM_OA332x1_ASAP7_75t_R%Y vss Y N_M0_s N_M9_s N_Y_8 N_Y_12 N_Y_11 N_Y_7
+ PM_OA332x1_ASAP7_75t_R%Y
cc_34 N_Y_8 N_3_16 0.000215726f $X=0.056 $Y=0.2025
cc_35 N_Y_8 N_3_23 0.000222249f $X=0.056 $Y=0.2025
cc_36 N_Y_8 N_3_18 0.000339654f $X=0.056 $Y=0.2025
cc_37 N_Y_8 N_3_22 0.000648776f $X=0.056 $Y=0.2025
cc_38 N_Y_8 N_3_1 0.00249574f $X=0.056 $Y=0.2025
cc_39 N_Y_12 N_3_16 0.00320186f $X=0.0405 $Y=0.234
cc_40 N_Y_11 N_3_21 0.00439162f $X=0.027 $Y=0.0575
cc_41 N_Y_7 N_3_12 0.0148562f $X=0.056 $Y=0.0675
cc_42 N_Y_8 N_3_12 0.0566051f $X=0.056 $Y=0.2025
x_PM_OA332x1_ASAP7_75t_R%A2 vss A2 N_M2_g N_M11_g N_A2_4 N_A2_3
+ PM_OA332x1_ASAP7_75t_R%A2
cc_43 N_A2_4 N_3_14 0.000195092f $X=0.189 $Y=0.116
cc_44 N_A2_4 N_3_3 0.000336449f $X=0.189 $Y=0.116
cc_45 N_A2_4 N_3_24 0.00135504f $X=0.189 $Y=0.116
cc_46 N_A2_4 N_3_17 0.00291117f $X=0.189 $Y=0.116
cc_47 N_A2_4 N_A3_4 0.00360435f $X=0.189 $Y=0.116
cc_48 N_A2_3 N_A3_3 0.00698642f $X=0.189 $Y=0.0245
x_PM_OA332x1_ASAP7_75t_R%A1 vss A1 N_M3_g N_M12_g N_A1_3 N_A1_4
+ PM_OA332x1_ASAP7_75t_R%A1
cc_49 N_A1_3 N_3_3 0.00178764f $X=0.243 $Y=0.0245
cc_50 N_A1_4 N_3_24 0.00124572f $X=0.243 $Y=0.116
cc_51 N_A1_4 N_3_3 0.00184566f $X=0.243 $Y=0.116
cc_52 N_A1_3 N_3_14 0.0360449f $X=0.243 $Y=0.0245
cc_53 N_A1_4 N_A2_4 0.00372857f $X=0.243 $Y=0.116
cc_54 N_A1_3 N_A2_3 0.0070517f $X=0.243 $Y=0.0245

* End of included file OA332x1_ASAP7_75t_R.pex.sp.pxi
.ends

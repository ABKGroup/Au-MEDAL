.subckt PM_OA333x2_ASAP7_75t_R%C2 vss 13 5 9 4 3
c1 1 vss 0.00462596f $X=0.243 $Y=0.135
c2 3 vss 0.121206f $X=0.243 $Y=0.0245
c3 4 vss 0.0078192f $X=0.243 $Y=0.116
r1 13 12 1.22425 $w=1.3e-08 $l=5.3e-09 $layer=M1 $thickness=3.6e-08 $X=0.237
+ $Y=0.154 $X2=0.243 $Y2=0.1487
r2 11 12 3.20636 $w=1.3e-08 $l=1.37e-08 $layer=M1 $thickness=3.6e-08 $X=0.243
+ $Y=0.135 $X2=0.243 $Y2=0.1487
r3 4 11 4.43061 $w=1.3e-08 $l=1.9e-08 $layer=M1 $thickness=3.6e-08 $X=0.243
+ $Y=0.116 $X2=0.243 $Y2=0.135
r4 1 7 10.4265 $w=1.765e-08 $layer=LIG $thickness=5.2e-08 $X=0.243 $Y=0.135
+ $X2=0.243 $Y2=0.135
r5 1 11 19.3796 $a=3.24e-16 $layer=V0LIG $X=0.243 $Y=0.135 $X2=0.243 $Y2=0.135
r6 9 8 16.4967 $w=2.1e-08 $l=4.85e-08 $layer=Gate_1 $thickness=5.6e-08 $X=0.243
+ $Y=0.2025 $X2=0.243 $Y2=0.154
r7 7 8 6.6497 $w=2.04211e-08 $l=1.9e-08 $layer=Gate_1 $thickness=5.6e-08
+ $X=0.243 $Y=0.135 $X2=0.243 $Y2=0.154
r8 6 7 6.6497 $w=2.04211e-08 $l=1.9e-08 $layer=Gate_1 $thickness=5.6e-08
+ $X=0.243 $Y=0.116 $X2=0.243 $Y2=0.135
r9 5 6 16.4967 $w=2.1e-08 $l=4.85e-08 $layer=Gate_1 $thickness=5.6e-08 $X=0.243
+ $Y=0.0675 $X2=0.243 $Y2=0.116
r10 5 3 14.6259 $w=2.1e-08 $l=4.3e-08 $layer=Gate_1 $thickness=5.6e-08 $X=0.243
+ $Y=0.0675 $X2=0.243 $Y2=0.0245
.ends

.subckt PM_OA333x2_ASAP7_75t_R%B2 vss 13 5 9 4 3
c1 1 vss 0.00470852f $X=0.405 $Y=0.135
c2 3 vss 0.121131f $X=0.405 $Y=0.0245
c3 4 vss 0.00530385f $X=0.405 $Y=0.116
r1 13 12 1.34084 $w=1.3e-08 $l=5.8e-09 $layer=M1 $thickness=3.6e-08 $X=0.404
+ $Y=0.155 $X2=0.405 $Y2=0.1492
r2 11 12 3.32295 $w=1.3e-08 $l=1.42e-08 $layer=M1 $thickness=3.6e-08 $X=0.405
+ $Y=0.135 $X2=0.405 $Y2=0.1492
r3 4 11 4.4306 $w=1.3e-08 $l=1.9e-08 $layer=M1 $thickness=3.6e-08 $X=0.405
+ $Y=0.116 $X2=0.405 $Y2=0.135
r4 1 7 10.4265 $w=1.765e-08 $layer=LIG $thickness=5.2e-08 $X=0.405 $Y=0.135
+ $X2=0.405 $Y2=0.135
r5 1 11 19.3796 $a=3.24e-16 $layer=V0LIG $X=0.405 $Y=0.135 $X2=0.405 $Y2=0.135
r6 9 8 16.4967 $w=2.1e-08 $l=4.85e-08 $layer=Gate_1 $thickness=5.6e-08 $X=0.405
+ $Y=0.2025 $X2=0.405 $Y2=0.154
r7 7 8 6.6497 $w=2.04211e-08 $l=1.9e-08 $layer=Gate_1 $thickness=5.6e-08
+ $X=0.405 $Y=0.135 $X2=0.405 $Y2=0.154
r8 6 7 6.6497 $w=2.04211e-08 $l=1.9e-08 $layer=Gate_1 $thickness=5.6e-08
+ $X=0.405 $Y=0.116 $X2=0.405 $Y2=0.135
r9 5 6 16.4967 $w=2.1e-08 $l=4.85e-08 $layer=Gate_1 $thickness=5.6e-08 $X=0.405
+ $Y=0.0675 $X2=0.405 $Y2=0.116
r10 5 3 14.6259 $w=2.1e-08 $l=4.3e-08 $layer=Gate_1 $thickness=5.6e-08 $X=0.405
+ $Y=0.0675 $X2=0.405 $Y2=0.0245
.ends

.subckt PM_OA333x2_ASAP7_75t_R%B3 vss 13 5 9 4 3
c1 1 vss 0.00577067f $X=0.459 $Y=0.135
c2 3 vss 0.140282f $X=0.459 $Y=0.0245
c3 4 vss 0.00577394f $X=0.459 $Y=0.116
r1 13 12 1.34084 $w=1.3e-08 $l=5.8e-09 $layer=M1 $thickness=3.6e-08 $X=0.454
+ $Y=0.155 $X2=0.459 $Y2=0.1492
r2 11 12 3.32295 $w=1.3e-08 $l=1.42e-08 $layer=M1 $thickness=3.6e-08 $X=0.459
+ $Y=0.135 $X2=0.459 $Y2=0.1492
r3 4 11 4.4306 $w=1.3e-08 $l=1.9e-08 $layer=M1 $thickness=3.6e-08 $X=0.459
+ $Y=0.116 $X2=0.459 $Y2=0.135
r4 1 7 10.4265 $w=1.765e-08 $layer=LIG $thickness=5.2e-08 $X=0.459 $Y=0.135
+ $X2=0.459 $Y2=0.135
r5 1 11 19.3796 $a=3.24e-16 $layer=V0LIG $X=0.459 $Y=0.135 $X2=0.459 $Y2=0.135
r6 9 8 16.4967 $w=2.1e-08 $l=4.85e-08 $layer=Gate_1 $thickness=5.6e-08 $X=0.459
+ $Y=0.2025 $X2=0.459 $Y2=0.154
r7 7 8 6.6497 $w=2.04211e-08 $l=1.9e-08 $layer=Gate_1 $thickness=5.6e-08
+ $X=0.459 $Y=0.135 $X2=0.459 $Y2=0.154
r8 6 7 6.6497 $w=2.04211e-08 $l=1.9e-08 $layer=Gate_1 $thickness=5.6e-08
+ $X=0.459 $Y=0.116 $X2=0.459 $Y2=0.135
r9 5 6 16.4967 $w=2.1e-08 $l=4.85e-08 $layer=Gate_1 $thickness=5.6e-08 $X=0.459
+ $Y=0.0675 $X2=0.459 $Y2=0.116
r10 5 3 14.6259 $w=2.1e-08 $l=4.3e-08 $layer=Gate_1 $thickness=5.6e-08 $X=0.459
+ $Y=0.0675 $X2=0.459 $Y2=0.0245
.ends

.subckt PM_OA333x2_ASAP7_75t_R%C1 vss 13 5 9 3 4
c1 1 vss 0.0046862f $X=0.297 $Y=0.135
c2 3 vss 0.102593f $X=0.297 $Y=0.0245
c3 4 vss 0.00665053f $X=0.297 $Y=0.116
r1 13 12 1.34084 $w=1.3e-08 $l=5.8e-09 $layer=M1 $thickness=3.6e-08 $X=0.295
+ $Y=0.155 $X2=0.297 $Y2=0.1492
r2 11 12 3.32295 $w=1.3e-08 $l=1.42e-08 $layer=M1 $thickness=3.6e-08 $X=0.297
+ $Y=0.135 $X2=0.297 $Y2=0.1492
r3 4 11 4.4306 $w=1.3e-08 $l=1.9e-08 $layer=M1 $thickness=3.6e-08 $X=0.297
+ $Y=0.116 $X2=0.297 $Y2=0.135
r4 1 7 10.4265 $w=1.765e-08 $layer=LIG $thickness=5.2e-08 $X=0.297 $Y=0.135
+ $X2=0.297 $Y2=0.135
r5 1 11 19.3796 $a=3.24e-16 $layer=V0LIG $X=0.297 $Y=0.135 $X2=0.297 $Y2=0.135
r6 9 8 16.4967 $w=2.1e-08 $l=4.85e-08 $layer=Gate_1 $thickness=5.6e-08 $X=0.297
+ $Y=0.2025 $X2=0.297 $Y2=0.154
r7 7 8 6.6497 $w=2.04211e-08 $l=1.9e-08 $layer=Gate_1 $thickness=5.6e-08
+ $X=0.297 $Y=0.135 $X2=0.297 $Y2=0.154
r8 6 7 6.6497 $w=2.04211e-08 $l=1.9e-08 $layer=Gate_1 $thickness=5.6e-08
+ $X=0.297 $Y=0.116 $X2=0.297 $Y2=0.135
r9 5 6 16.4967 $w=2.1e-08 $l=4.85e-08 $layer=Gate_1 $thickness=5.6e-08 $X=0.297
+ $Y=0.0675 $X2=0.297 $Y2=0.116
r10 5 3 14.6259 $w=2.1e-08 $l=4.3e-08 $layer=Gate_1 $thickness=5.6e-08 $X=0.297
+ $Y=0.0675 $X2=0.297 $Y2=0.0245
.ends

.subckt PM_OA333x2_ASAP7_75t_R%A2 vss 13 5 9 3 1 4
c1 1 vss 0.0029592f $X=0.567 $Y=0.135
c2 3 vss 0.0833265f $X=0.567 $Y=0.0245
c3 4 vss 0.00550955f $X=0.567 $Y=0.116
r1 13 12 1.34084 $w=1.3e-08 $l=5.8e-09 $layer=M1 $thickness=3.6e-08 $X=0.565
+ $Y=0.155 $X2=0.567 $Y2=0.1492
r2 11 12 3.32295 $w=1.3e-08 $l=1.42e-08 $layer=M1 $thickness=3.6e-08 $X=0.567
+ $Y=0.135 $X2=0.567 $Y2=0.1492
r3 4 11 4.4306 $w=1.3e-08 $l=1.9e-08 $layer=M1 $thickness=3.6e-08 $X=0.567
+ $Y=0.116 $X2=0.567 $Y2=0.135
r4 1 7 10.4265 $w=1.765e-08 $layer=LIG $thickness=5.2e-08 $X=0.567 $Y=0.135
+ $X2=0.567 $Y2=0.135
r5 1 11 19.3796 $a=3.24e-16 $layer=V0LIG $X=0.567 $Y=0.135 $X2=0.567 $Y2=0.135
r6 9 8 16.4967 $w=2.1e-08 $l=4.85e-08 $layer=Gate_1 $thickness=5.6e-08 $X=0.567
+ $Y=0.2025 $X2=0.567 $Y2=0.154
r7 7 8 6.6497 $w=2.04211e-08 $l=1.9e-08 $layer=Gate_1 $thickness=5.6e-08
+ $X=0.567 $Y=0.135 $X2=0.567 $Y2=0.154
r8 6 7 6.6497 $w=2.04211e-08 $l=1.9e-08 $layer=Gate_1 $thickness=5.6e-08
+ $X=0.567 $Y=0.116 $X2=0.567 $Y2=0.135
r9 5 6 16.4967 $w=2.1e-08 $l=4.85e-08 $layer=Gate_1 $thickness=5.6e-08 $X=0.567
+ $Y=0.0675 $X2=0.567 $Y2=0.116
r10 5 3 14.6259 $w=2.1e-08 $l=4.3e-08 $layer=Gate_1 $thickness=5.6e-08 $X=0.567
+ $Y=0.0675 $X2=0.567 $Y2=0.0245
.ends

.subckt PM_OA333x2_ASAP7_75t_R%A3 vss 11 5 9 3 4
c1 1 vss 0.0042848f $X=0.513 $Y=0.135
c2 3 vss 0.103478f $X=0.513 $Y=0.0245
c3 4 vss 0.00612512f $X=0.513 $Y=0.1122
r1 12 13 2.85657 $w=1.3e-08 $l=1.23e-08 $layer=M1 $thickness=3.6e-08 $X=0.513
+ $Y=0.1227 $X2=0.513 $Y2=0.135
r2 11 12 0.874462 $w=1.3e-08 $l=3.7e-09 $layer=M1 $thickness=3.6e-08 $X=0.516
+ $Y=0.119 $X2=0.513 $Y2=0.1227
r3 11 4 1.57403 $w=1.3e-08 $l=6.8e-09 $layer=M1 $thickness=3.6e-08 $X=0.516
+ $Y=0.119 $X2=0.513 $Y2=0.1122
r4 1 7 10.4265 $w=1.765e-08 $layer=LIG $thickness=5.2e-08 $X=0.513 $Y=0.135
+ $X2=0.513 $Y2=0.135
r5 1 13 19.3796 $a=3.24e-16 $layer=V0LIG $X=0.513 $Y=0.135 $X2=0.513 $Y2=0.135
r6 9 8 16.4967 $w=2.1e-08 $l=4.85e-08 $layer=Gate_1 $thickness=5.6e-08 $X=0.513
+ $Y=0.2025 $X2=0.513 $Y2=0.154
r7 7 8 6.6497 $w=2.04211e-08 $l=1.9e-08 $layer=Gate_1 $thickness=5.6e-08
+ $X=0.513 $Y=0.135 $X2=0.513 $Y2=0.154
r8 6 7 6.6497 $w=2.04211e-08 $l=1.9e-08 $layer=Gate_1 $thickness=5.6e-08
+ $X=0.513 $Y=0.116 $X2=0.513 $Y2=0.135
r9 5 6 16.4967 $w=2.1e-08 $l=4.85e-08 $layer=Gate_1 $thickness=5.6e-08 $X=0.513
+ $Y=0.0675 $X2=0.513 $Y2=0.116
r10 5 3 14.6259 $w=2.1e-08 $l=4.3e-08 $layer=Gate_1 $thickness=5.6e-08 $X=0.513
+ $Y=0.0675 $X2=0.513 $Y2=0.0245
.ends

.subckt PM_OA333x2_ASAP7_75t_R%A1 vss 15 5 11 3 4 1
c1 1 vss 0.00250785f $X=0.621 $Y=0.135
c2 3 vss 0.0708906f $X=0.621 $Y=0.0245
c3 4 vss 0.00447953f $X=0.621 $Y=0.116
r1 15 14 1.34084 $w=1.3e-08 $l=5.8e-09 $layer=M1 $thickness=3.6e-08 $X=0.629
+ $Y=0.155 $X2=0.621 $Y2=0.1492
r2 13 14 3.32295 $w=1.3e-08 $l=1.42e-08 $layer=M1 $thickness=3.6e-08 $X=0.621
+ $Y=0.135 $X2=0.621 $Y2=0.1492
r3 4 13 4.4306 $w=1.3e-08 $l=1.9e-08 $layer=M1 $thickness=3.6e-08 $X=0.621
+ $Y=0.116 $X2=0.621 $Y2=0.135
r4 1 8 10.4265 $w=1.765e-08 $layer=LIG $thickness=5.2e-08 $X=0.621 $Y=0.135
+ $X2=0.621 $Y2=0.135
r5 1 13 19.3796 $a=3.24e-16 $layer=V0LIG $X=0.621 $Y=0.135 $X2=0.621 $Y2=0.135
r6 11 10 14.6259 $w=2.1e-08 $l=4.3e-08 $layer=Gate_1 $thickness=5.6e-08
+ $X=0.621 $Y=0.2025 $X2=0.621 $Y2=0.1595
r7 9 10 2.7211 $w=2.1e-08 $l=8e-09 $layer=Gate_1 $thickness=5.6e-08 $X=0.621
+ $Y=0.1515 $X2=0.621 $Y2=0.1595
r8 8 9 5.79936 $w=2.03333e-08 $l=1.65e-08 $layer=Gate_1 $thickness=5.6e-08
+ $X=0.621 $Y=0.135 $X2=0.621 $Y2=0.1515
r9 7 8 5.79936 $w=2.03333e-08 $l=1.65e-08 $layer=Gate_1 $thickness=5.6e-08
+ $X=0.621 $Y=0.1185 $X2=0.621 $Y2=0.135
r10 6 7 2.7211 $w=2.1e-08 $l=8e-09 $layer=Gate_1 $thickness=5.6e-08 $X=0.621
+ $Y=0.1105 $X2=0.621 $Y2=0.1185
r11 5 6 14.6259 $w=2.1e-08 $l=4.3e-08 $layer=Gate_1 $thickness=5.6e-08 $X=0.621
+ $Y=0.0675 $X2=0.621 $Y2=0.1105
r12 5 3 14.6259 $w=2.1e-08 $l=4.3e-08 $layer=Gate_1 $thickness=5.6e-08 $X=0.621
+ $Y=0.0675 $X2=0.621 $Y2=0.0245
.ends

.subckt PM_OA333x2_ASAP7_75t_R%Y vss 21 14 15 30 31 7 11 8
c1 1 vss 0.00971642f $X=0.108 $Y=0.0675
c2 2 vss 0.00855968f $X=0.108 $Y=0.2025
c3 7 vss 0.00426517f $X=0.0935 $Y=0.0675
c4 8 vss 0.00425788f $X=0.0935 $Y=0.2025
c5 9 vss 0.0064125f $X=0.0945 $Y=0.036
c6 10 vss 0.0056691f $X=0.081 $Y=0.234
c7 11 vss 0.00801565f $X=0.081 $Y=0.0575
r1 31 29 0.0308642 $w=8.1e-08 $l=2.5e-09 $layer=P_src_drn $thickness=1e-09
+ $X=0.1253 $Y=0.2025 $X2=0.1225 $Y2=0.2025
r2 2 29 0.179012 $w=8.1e-08 $l=1.45e-08 $layer=P_src_drn $thickness=1e-09
+ $X=0.108 $Y=0.2025 $X2=0.1225 $Y2=0.2025
r3 8 2 0.179012 $w=8.1e-08 $l=1.45e-08 $layer=P_src_drn $thickness=1e-09
+ $X=0.0935 $Y=0.2025 $X2=0.108 $Y2=0.2025
r4 30 8 0.0308642 $w=8.1e-08 $l=2.5e-09 $layer=P_src_drn $thickness=1e-09
+ $X=0.0906 $Y=0.2025 $X2=0.0935 $Y2=0.2025
r5 2 26 19.3796 $a=3.24e-16 $layer=V0LISD $X=0.108 $Y=0.2025 $X2=0.108 $Y2=0.234
r6 25 26 3.14806 $w=1.3e-08 $l=1.35e-08 $layer=M1 $thickness=3.6e-08 $X=0.0945
+ $Y=0.234 $X2=0.108 $Y2=0.234
r7 10 24 3.36689 $w=1.53077e-08 $l=1.95e-08 $layer=M1 $thickness=3.6e-08
+ $X=0.081 $Y=0.234 $X2=0.081 $Y2=0.2145
r8 10 25 1.96775 $w=1.63333e-08 $l=1.35e-08 $layer=M1 $thickness=3.6e-08
+ $X=0.081 $Y=0.234 $X2=0.0945 $Y2=0.234
r9 23 24 4.5472 $w=1.3e-08 $l=1.95e-08 $layer=M1 $thickness=3.6e-08 $X=0.081
+ $Y=0.195 $X2=0.081 $Y2=0.2145
r10 22 23 7.05399 $w=1.3e-08 $l=3.03e-08 $layer=M1 $thickness=3.6e-08 $X=0.081
+ $Y=0.1647 $X2=0.081 $Y2=0.195
r11 21 22 5.07188 $w=1.3e-08 $l=2.17e-08 $layer=M1 $thickness=3.6e-08 $X=0.084
+ $Y=0.143 $X2=0.081 $Y2=0.1647
r12 21 20 3.32295 $w=1.3e-08 $l=1.43e-08 $layer=M1 $thickness=3.6e-08 $X=0.084
+ $Y=0.143 $X2=0.081 $Y2=0.1287
r13 19 20 8.45313 $w=1.3e-08 $l=3.62e-08 $layer=M1 $thickness=3.6e-08 $X=0.081
+ $Y=0.0925 $X2=0.081 $Y2=0.1287
r14 11 18 3.83327 $w=1.5093e-08 $l=2.15e-08 $layer=M1 $thickness=3.6e-08
+ $X=0.081 $Y=0.0575 $X2=0.081 $Y2=0.036
r15 11 19 8.16164 $w=1.3e-08 $l=3.5e-08 $layer=M1 $thickness=3.6e-08 $X=0.081
+ $Y=0.0575 $X2=0.081 $Y2=0.0925
r16 9 16 3.14806 $w=1.3e-08 $l=1.35e-08 $layer=M1 $thickness=3.6e-08 $X=0.0945
+ $Y=0.036 $X2=0.108 $Y2=0.036
r17 9 18 1.96775 $w=1.63333e-08 $l=1.35e-08 $layer=M1 $thickness=3.6e-08
+ $X=0.0945 $Y=0.036 $X2=0.081 $Y2=0.036
r18 1 16 19.3796 $a=3.24e-16 $layer=V0LISD $X=0.108 $Y=0.0675 $X2=0.108
+ $Y2=0.036
r19 15 13 0.0308642 $w=8.1e-08 $l=2.5e-09 $layer=N_src_drn $thickness=1e-09
+ $X=0.1253 $Y=0.0675 $X2=0.1225 $Y2=0.0675
r20 1 13 0.179012 $w=8.1e-08 $l=1.45e-08 $layer=N_src_drn $thickness=1e-09
+ $X=0.108 $Y=0.0675 $X2=0.1225 $Y2=0.0675
r21 7 1 0.179012 $w=8.1e-08 $l=1.45e-08 $layer=N_src_drn $thickness=1e-09
+ $X=0.0935 $Y=0.0675 $X2=0.108 $Y2=0.0675
r22 14 7 0.0308642 $w=8.1e-08 $l=2.5e-09 $layer=N_src_drn $thickness=1e-09
+ $X=0.0906 $Y=0.0675 $X2=0.0935 $Y2=0.0675
.ends

.subckt PM_OA333x2_ASAP7_75t_R%3 vss 30 36 45 48 82 83 87 99 102 103 21 1 25 16
+ 3 19 27 4 28 17 6 5 18 29 20 26 22 15
c1 1 vss 0.00774338f $X=0.081 $Y=0.135
c2 3 vss 0.00505377f $X=0.324 $Y=0.2025
c3 4 vss 0.00995459f $X=0.54 $Y=0.0675
c4 5 vss 0.00835556f $X=0.648 $Y=0.0675
c5 6 vss 0.0066539f $X=0.648 $Y=0.2025
c6 15 vss 0.0833895f $X=0.081 $Y=0.0245
c7 16 vss 0.0808444f $X=0.135 $Y=0.135
c8 17 vss 0.00633675f $X=0.5255 $Y=0.0675
c9 18 vss 0.039906f $X=0.6335 $Y=0.0675
c10 19 vss 0.00484697f $X=0.3095 $Y=0.2025
c11 20 vss 0.0391324f $X=0.6335 $Y=0.2025
c12 21 vss 0.00144726f $X=0.135 $Y=0.195
c13 22 vss 0.00287957f $X=0.162 $Y=0.234
c14 23 vss 0.00210385f $X=0.675 $Y=0.072
c15 24 vss 0.00314173f $X=0.675 $Y=0.234
c16 25 vss 0.0019395f $X=0.135 $Y=0.1205
c17 26 vss 0.0008219f $X=0.162 $Y=0.2145
c18 27 vss 0.0461346f $X=0.1755 $Y=0.234
c19 28 vss 0.0126023f $X=0.6345 $Y=0.072
c20 29 vss 0.00619585f $X=0.675 $Y=0.2125
r1 103 101 0.0308642 $w=8.1e-08 $l=2.5e-09 $layer=N_src_drn $thickness=1e-09
+ $X=0.5573 $Y=0.0675 $X2=0.5545 $Y2=0.0675
r2 4 101 0.179012 $w=8.1e-08 $l=1.45e-08 $layer=N_src_drn $thickness=1e-09
+ $X=0.54 $Y=0.0675 $X2=0.5545 $Y2=0.0675
r3 17 4 0.179012 $w=8.1e-08 $l=1.45e-08 $layer=N_src_drn $thickness=1e-09
+ $X=0.5255 $Y=0.0675 $X2=0.54 $Y2=0.0675
r4 102 17 0.0308642 $w=8.1e-08 $l=2.5e-09 $layer=N_src_drn $thickness=1e-09
+ $X=0.5226 $Y=0.0675 $X2=0.5255 $Y2=0.0675
r5 18 5 0.154321 $w=8.1e-08 $l=1.25e-08 $layer=N_src_drn $thickness=1e-09
+ $X=0.6335 $Y=0.0675 $X2=0.648 $Y2=0.0675
r6 99 18 0.0308642 $w=8.1e-08 $l=2.5e-09 $layer=N_src_drn $thickness=1e-09
+ $X=0.6306 $Y=0.0675 $X2=0.6335 $Y2=0.0675
r7 4 95 19.3796 $a=3.24e-16 $layer=V0LISD $X=0.54 $Y=0.0675 $X2=0.54 $Y2=0.072
r8 5 88 19.3796 $a=3.24e-16 $layer=V0LISD $X=0.648 $Y=0.0675 $X2=0.648 $Y2=0.072
r9 95 96 3.14806 $w=1.3e-08 $l=1.35e-08 $layer=M1 $thickness=3.6e-08 $X=0.54
+ $Y=0.072 $X2=0.5535 $Y2=0.072
r10 93 96 3.14806 $w=1.3e-08 $l=1.35e-08 $layer=M1 $thickness=3.6e-08 $X=0.567
+ $Y=0.072 $X2=0.5535 $Y2=0.072
r11 92 93 6.29612 $w=1.3e-08 $l=2.7e-08 $layer=M1 $thickness=3.6e-08 $X=0.594
+ $Y=0.072 $X2=0.567 $Y2=0.072
r12 91 92 5.47996 $w=1.3e-08 $l=2.35e-08 $layer=M1 $thickness=3.6e-08 $X=0.6175
+ $Y=0.072 $X2=0.594 $Y2=0.072
r13 90 91 2.09871 $w=1.3e-08 $l=9e-09 $layer=M1 $thickness=3.6e-08 $X=0.6265
+ $Y=0.072 $X2=0.6175 $Y2=0.072
r14 88 89 3.14806 $w=1.3e-08 $l=1.35e-08 $layer=M1 $thickness=3.6e-08 $X=0.648
+ $Y=0.072 $X2=0.6615 $Y2=0.072
r15 28 88 3.14806 $w=1.3e-08 $l=1.35e-08 $layer=M1 $thickness=3.6e-08 $X=0.6345
+ $Y=0.072 $X2=0.648 $Y2=0.072
r16 28 90 1.86552 $w=1.3e-08 $l=8e-09 $layer=M1 $thickness=3.6e-08 $X=0.6345
+ $Y=0.072 $X2=0.6265 $Y2=0.072
r17 23 85 3.36447 $w=1.71023e-08 $l=2.15e-08 $layer=M1 $thickness=3.6e-08
+ $X=0.675 $Y=0.072 $X2=0.675 $Y2=0.0935
r18 23 89 1.49895 $w=1.63333e-08 $l=1.35e-08 $layer=M1 $thickness=3.6e-08
+ $X=0.675 $Y=0.072 $X2=0.6615 $Y2=0.072
r19 20 6 0.154321 $w=8.1e-08 $l=1.25e-08 $layer=P_src_drn $thickness=1e-09
+ $X=0.6335 $Y=0.2025 $X2=0.648 $Y2=0.2025
r20 87 20 0.0308642 $w=8.1e-08 $l=2.5e-09 $layer=P_src_drn $thickness=1e-09
+ $X=0.6306 $Y=0.2025 $X2=0.6335 $Y2=0.2025
r21 84 85 13.8748 $w=1.3e-08 $l=5.95e-08 $layer=M1 $thickness=3.6e-08 $X=0.675
+ $Y=0.153 $X2=0.675 $Y2=0.0935
r22 29 84 13.8748 $w=1.3e-08 $l=5.95e-08 $layer=M1 $thickness=3.6e-08 $X=0.675
+ $Y=0.2125 $X2=0.675 $Y2=0.153
r23 83 81 0.0308642 $w=8.1e-08 $l=2.5e-09 $layer=P_src_drn $thickness=1e-09
+ $X=0.3413 $Y=0.2025 $X2=0.3385 $Y2=0.2025
r24 3 81 0.179012 $w=8.1e-08 $l=1.45e-08 $layer=P_src_drn $thickness=1e-09
+ $X=0.324 $Y=0.2025 $X2=0.3385 $Y2=0.2025
r25 19 3 0.179012 $w=8.1e-08 $l=1.45e-08 $layer=P_src_drn $thickness=1e-09
+ $X=0.3095 $Y=0.2025 $X2=0.324 $Y2=0.2025
r26 82 19 0.0308642 $w=8.1e-08 $l=2.5e-09 $layer=P_src_drn $thickness=1e-09
+ $X=0.3066 $Y=0.2025 $X2=0.3095 $Y2=0.2025
r27 6 78 19.3796 $a=3.24e-16 $layer=V0LISD $X=0.648 $Y=0.2025 $X2=0.648
+ $Y2=0.234
r28 24 79 1.49895 $w=1.63333e-08 $l=1.35e-08 $layer=M1 $thickness=3.6e-08
+ $X=0.675 $Y=0.234 $X2=0.6615 $Y2=0.234
r29 24 29 3.36447 $w=1.71023e-08 $l=2.15e-08 $layer=M1 $thickness=3.6e-08
+ $X=0.675 $Y=0.234 $X2=0.675 $Y2=0.2125
r30 3 63 19.3796 $a=3.24e-16 $layer=V0LISD $X=0.324 $Y=0.2025 $X2=0.324
+ $Y2=0.234
r31 78 79 3.14806 $w=1.3e-08 $l=1.35e-08 $layer=M1 $thickness=3.6e-08 $X=0.648
+ $Y=0.234 $X2=0.6615 $Y2=0.234
r32 77 78 3.14806 $w=1.3e-08 $l=1.35e-08 $layer=M1 $thickness=3.6e-08 $X=0.6345
+ $Y=0.234 $X2=0.648 $Y2=0.234
r33 76 77 3.14806 $w=1.3e-08 $l=1.35e-08 $layer=M1 $thickness=3.6e-08 $X=0.621
+ $Y=0.234 $X2=0.6345 $Y2=0.234
r34 75 76 6.29612 $w=1.3e-08 $l=2.7e-08 $layer=M1 $thickness=3.6e-08 $X=0.594
+ $Y=0.234 $X2=0.621 $Y2=0.234
r35 74 75 6.29612 $w=1.3e-08 $l=2.7e-08 $layer=M1 $thickness=3.6e-08 $X=0.567
+ $Y=0.234 $X2=0.594 $Y2=0.234
r36 73 74 6.29612 $w=1.3e-08 $l=2.7e-08 $layer=M1 $thickness=3.6e-08 $X=0.54
+ $Y=0.234 $X2=0.567 $Y2=0.234
r37 72 73 6.29612 $w=1.3e-08 $l=2.7e-08 $layer=M1 $thickness=3.6e-08 $X=0.513
+ $Y=0.234 $X2=0.54 $Y2=0.234
r38 71 72 6.29612 $w=1.3e-08 $l=2.7e-08 $layer=M1 $thickness=3.6e-08 $X=0.486
+ $Y=0.234 $X2=0.513 $Y2=0.234
r39 70 71 6.29612 $w=1.3e-08 $l=2.7e-08 $layer=M1 $thickness=3.6e-08 $X=0.459
+ $Y=0.234 $X2=0.486 $Y2=0.234
r40 69 70 2.3319 $w=1.3e-08 $l=1e-08 $layer=M1 $thickness=3.6e-08 $X=0.449
+ $Y=0.234 $X2=0.459 $Y2=0.234
r41 68 69 4.19742 $w=1.3e-08 $l=1.8e-08 $layer=M1 $thickness=3.6e-08 $X=0.431
+ $Y=0.234 $X2=0.449 $Y2=0.234
r42 67 68 6.06293 $w=1.3e-08 $l=2.6e-08 $layer=M1 $thickness=3.6e-08 $X=0.405
+ $Y=0.234 $X2=0.431 $Y2=0.234
r43 66 67 6.29612 $w=1.3e-08 $l=2.7e-08 $layer=M1 $thickness=3.6e-08 $X=0.378
+ $Y=0.234 $X2=0.405 $Y2=0.234
r44 65 66 6.29612 $w=1.3e-08 $l=2.7e-08 $layer=M1 $thickness=3.6e-08 $X=0.351
+ $Y=0.234 $X2=0.378 $Y2=0.234
r45 64 65 3.14806 $w=1.3e-08 $l=1.35e-08 $layer=M1 $thickness=3.6e-08 $X=0.3375
+ $Y=0.234 $X2=0.351 $Y2=0.234
r46 63 64 3.14806 $w=1.3e-08 $l=1.35e-08 $layer=M1 $thickness=3.6e-08 $X=0.324
+ $Y=0.234 $X2=0.3375 $Y2=0.234
r47 62 63 3.14806 $w=1.3e-08 $l=1.35e-08 $layer=M1 $thickness=3.6e-08 $X=0.3105
+ $Y=0.234 $X2=0.324 $Y2=0.234
r48 61 62 3.14806 $w=1.3e-08 $l=1.35e-08 $layer=M1 $thickness=3.6e-08 $X=0.297
+ $Y=0.234 $X2=0.3105 $Y2=0.234
r49 60 61 2.3319 $w=1.3e-08 $l=1e-08 $layer=M1 $thickness=3.6e-08 $X=0.287
+ $Y=0.234 $X2=0.297 $Y2=0.234
r50 59 60 4.19742 $w=1.3e-08 $l=1.8e-08 $layer=M1 $thickness=3.6e-08 $X=0.269
+ $Y=0.234 $X2=0.287 $Y2=0.234
r51 58 59 6.06293 $w=1.3e-08 $l=2.6e-08 $layer=M1 $thickness=3.6e-08 $X=0.243
+ $Y=0.234 $X2=0.269 $Y2=0.234
r52 57 58 5.94634 $w=1.3e-08 $l=2.55e-08 $layer=M1 $thickness=3.6e-08 $X=0.2175
+ $Y=0.234 $X2=0.243 $Y2=0.234
r53 56 57 4.19742 $w=1.3e-08 $l=1.8e-08 $layer=M1 $thickness=3.6e-08 $X=0.1995
+ $Y=0.234 $X2=0.2175 $Y2=0.234
r54 55 56 2.44849 $w=1.3e-08 $l=1.05e-08 $layer=M1 $thickness=3.6e-08 $X=0.189
+ $Y=0.234 $X2=0.1995 $Y2=0.234
r55 27 55 3.14806 $w=1.3e-08 $l=1.35e-08 $layer=M1 $thickness=3.6e-08 $X=0.1755
+ $Y=0.234 $X2=0.189 $Y2=0.234
r56 22 26 2.89809 $w=1.75231e-08 $l=1.95e-08 $layer=M1 $thickness=3.6e-08
+ $X=0.162 $Y=0.234 $X2=0.162 $Y2=0.2145
r57 22 27 1.49895 $w=1.63333e-08 $l=1.35e-08 $layer=M1 $thickness=3.6e-08
+ $X=0.162 $Y=0.234 $X2=0.1755 $Y2=0.234
r58 26 54 3.36689 $w=1.53077e-08 $l=1.95e-08 $layer=M1 $thickness=3.6e-08
+ $X=0.162 $Y=0.2145 $X2=0.162 $Y2=0.195
r59 53 54 1.96775 $w=1.63333e-08 $l=1.35e-08 $layer=M1 $thickness=3.6e-08
+ $X=0.1485 $Y=0.195 $X2=0.162 $Y2=0.195
r60 21 52 3.48349 $w=1.525e-08 $l=2e-08 $layer=M1 $thickness=3.6e-08 $X=0.135
+ $Y=0.195 $X2=0.135 $Y2=0.175
r61 21 53 1.96775 $w=1.63333e-08 $l=1.35e-08 $layer=M1 $thickness=3.6e-08
+ $X=0.135 $Y=0.195 $X2=0.1485 $Y2=0.195
r62 51 52 4.89699 $w=1.3e-08 $l=2.1e-08 $layer=M1 $thickness=3.6e-08 $X=0.135
+ $Y=0.154 $X2=0.135 $Y2=0.175
r63 50 51 4.43061 $w=1.3e-08 $l=1.9e-08 $layer=M1 $thickness=3.6e-08 $X=0.135
+ $Y=0.135 $X2=0.135 $Y2=0.154
r64 25 50 3.38125 $w=1.3e-08 $l=1.45e-08 $layer=M1 $thickness=3.6e-08 $X=0.135
+ $Y=0.1205 $X2=0.135 $Y2=0.135
r65 48 47 16.4967 $w=2.1e-08 $l=4.85e-08 $layer=Gate_1 $thickness=5.6e-08
+ $X=0.135 $Y=0.2025 $X2=0.135 $Y2=0.154
r66 45 46 16.4967 $w=2.1e-08 $l=4.85e-08 $layer=Gate_1 $thickness=5.6e-08
+ $X=0.135 $Y=0.0675 $X2=0.135 $Y2=0.116
r67 16 41 6.27904 $w=2.09e-08 $layer=Gate_1 $thickness=5.24e-08 $X=0.135
+ $Y=0.135 $X2=0.135 $Y2=0.135
r68 16 46 6.6497 $w=2.04211e-08 $l=1.9e-08 $layer=Gate_1 $thickness=5.6e-08
+ $X=0.135 $Y=0.135 $X2=0.135 $Y2=0.116
r69 16 47 6.6497 $w=2.04211e-08 $l=1.9e-08 $layer=Gate_1 $thickness=5.6e-08
+ $X=0.135 $Y=0.135 $X2=0.135 $Y2=0.154
r70 41 50 19.3796 $a=3.24e-16 $layer=V0LIG $X=0.135 $Y=0.135 $X2=0.135 $Y2=0.135
r71 40 41 2.48102 $w=2.2e-08 $l=9.5e-09 $layer=LIG $thickness=4.8e-08 $X=0.1255
+ $Y=0.135 $X2=0.135 $Y2=0.135
r72 39 40 10.1729 $w=1.54914e-08 $l=1.75e-08 $layer=LIG $thickness=4.8e-08
+ $X=0.108 $Y=0.135 $X2=0.1255 $Y2=0.135
r73 1 33 6.54019 $w=2.09524e-08 $layer=Gate_1 $thickness=5.21905e-08 $X=0.081
+ $Y=0.135 $X2=0.081 $Y2=0.135
r74 1 39 12.6539 $w=1.77815e-08 $l=2.7e-08 $layer=LIG $thickness=4.8e-08
+ $X=0.081 $Y=0.135 $X2=0.108 $Y2=0.135
r75 36 35 14.6259 $w=2.1e-08 $l=4.3e-08 $layer=Gate_1 $thickness=5.6e-08
+ $X=0.081 $Y=0.2025 $X2=0.081 $Y2=0.1595
r76 34 35 2.7211 $w=2.1e-08 $l=8e-09 $layer=Gate_1 $thickness=5.6e-08 $X=0.081
+ $Y=0.1515 $X2=0.081 $Y2=0.1595
r77 33 34 5.79936 $w=2.03333e-08 $l=1.65e-08 $layer=Gate_1 $thickness=5.6e-08
+ $X=0.081 $Y=0.135 $X2=0.081 $Y2=0.1515
r78 32 33 5.79936 $w=2.03333e-08 $l=1.65e-08 $layer=Gate_1 $thickness=5.6e-08
+ $X=0.081 $Y=0.1185 $X2=0.081 $Y2=0.135
r79 31 32 2.7211 $w=2.1e-08 $l=8e-09 $layer=Gate_1 $thickness=5.6e-08 $X=0.081
+ $Y=0.1105 $X2=0.081 $Y2=0.1185
r80 30 31 14.6259 $w=2.1e-08 $l=4.3e-08 $layer=Gate_1 $thickness=5.6e-08
+ $X=0.081 $Y=0.0675 $X2=0.081 $Y2=0.1105
r81 30 15 14.6259 $w=2.1e-08 $l=4.3e-08 $layer=Gate_1 $thickness=5.6e-08
+ $X=0.081 $Y=0.0675 $X2=0.081 $Y2=0.0245
.ends

.subckt PM_OA333x2_ASAP7_75t_R%C3 vss 14 5 9 3 4
c1 1 vss 0.00662515f $X=0.189 $Y=0.135
c2 3 vss 0.139668f $X=0.189 $Y=0.0245
c3 4 vss 0.00632087f $X=0.189 $Y=0.0925
r1 14 13 1.45744 $w=1.3e-08 $l=6.3e-09 $layer=M1 $thickness=3.6e-08 $X=0.181
+ $Y=0.156 $X2=0.189 $Y2=0.1497
r2 12 13 3.43955 $w=1.3e-08 $l=1.47e-08 $layer=M1 $thickness=3.6e-08 $X=0.189
+ $Y=0.135 $X2=0.189 $Y2=0.1497
r3 11 12 3.38125 $w=1.3e-08 $l=1.45e-08 $layer=M1 $thickness=3.6e-08 $X=0.189
+ $Y=0.1205 $X2=0.189 $Y2=0.135
r4 4 11 6.52931 $w=1.3e-08 $l=2.8e-08 $layer=M1 $thickness=3.6e-08 $X=0.189
+ $Y=0.0925 $X2=0.189 $Y2=0.1205
r5 1 7 10.4265 $w=1.765e-08 $layer=LIG $thickness=5.2e-08 $X=0.189 $Y=0.135
+ $X2=0.189 $Y2=0.135
r6 1 12 19.3796 $a=3.24e-16 $layer=V0LIG $X=0.189 $Y=0.135 $X2=0.189 $Y2=0.135
r7 9 8 16.4967 $w=2.1e-08 $l=4.85e-08 $layer=Gate_1 $thickness=5.6e-08 $X=0.189
+ $Y=0.2025 $X2=0.189 $Y2=0.154
r8 7 8 6.6497 $w=2.04211e-08 $l=1.9e-08 $layer=Gate_1 $thickness=5.6e-08
+ $X=0.189 $Y=0.135 $X2=0.189 $Y2=0.154
r9 6 7 6.6497 $w=2.04211e-08 $l=1.9e-08 $layer=Gate_1 $thickness=5.6e-08
+ $X=0.189 $Y=0.116 $X2=0.189 $Y2=0.135
r10 5 6 16.4967 $w=2.1e-08 $l=4.85e-08 $layer=Gate_1 $thickness=5.6e-08
+ $X=0.189 $Y=0.0675 $X2=0.189 $Y2=0.116
r11 5 3 14.6259 $w=2.1e-08 $l=4.3e-08 $layer=Gate_1 $thickness=5.6e-08 $X=0.189
+ $Y=0.0675 $X2=0.189 $Y2=0.0245
.ends

.subckt PM_OA333x2_ASAP7_75t_R%B1 vss 13 5 9 3 4
c1 1 vss 0.00464542f $X=0.351 $Y=0.135
c2 3 vss 0.102493f $X=0.351 $Y=0.0245
c3 4 vss 0.00712348f $X=0.351 $Y=0.116
r1 13 12 1.22425 $w=1.3e-08 $l=5.3e-09 $layer=M1 $thickness=3.6e-08 $X=0.351
+ $Y=0.154 $X2=0.351 $Y2=0.1487
r2 11 12 3.20636 $w=1.3e-08 $l=1.37e-08 $layer=M1 $thickness=3.6e-08 $X=0.351
+ $Y=0.135 $X2=0.351 $Y2=0.1487
r3 4 11 4.4306 $w=1.3e-08 $l=1.9e-08 $layer=M1 $thickness=3.6e-08 $X=0.351
+ $Y=0.116 $X2=0.351 $Y2=0.135
r4 1 7 10.4265 $w=1.765e-08 $layer=LIG $thickness=5.2e-08 $X=0.351 $Y=0.135
+ $X2=0.351 $Y2=0.135
r5 1 11 19.3796 $a=3.24e-16 $layer=V0LIG $X=0.351 $Y=0.135 $X2=0.351 $Y2=0.135
r6 9 8 16.4967 $w=2.1e-08 $l=4.85e-08 $layer=Gate_1 $thickness=5.6e-08 $X=0.351
+ $Y=0.2025 $X2=0.351 $Y2=0.154
r7 7 8 6.6497 $w=2.04211e-08 $l=1.9e-08 $layer=Gate_1 $thickness=5.6e-08
+ $X=0.351 $Y=0.135 $X2=0.351 $Y2=0.154
r8 6 7 6.6497 $w=2.04211e-08 $l=1.9e-08 $layer=Gate_1 $thickness=5.6e-08
+ $X=0.351 $Y=0.116 $X2=0.351 $Y2=0.135
r9 5 6 16.4967 $w=2.1e-08 $l=4.85e-08 $layer=Gate_1 $thickness=5.6e-08 $X=0.351
+ $Y=0.0675 $X2=0.351 $Y2=0.116
r10 5 3 14.6259 $w=2.1e-08 $l=4.3e-08 $layer=Gate_1 $thickness=5.6e-08 $X=0.351
+ $Y=0.0675 $X2=0.351 $Y2=0.0245
.ends

* End of included file OA333x2_ASAP7_75t_R.pex.sp.pex

*
.subckt OA333x2_ASAP7_75t_CUSTOM_4_25_0_7 VSS VDD C3 C2 C1 B1 B2 B3 A3 A2 A1 Y
*
* VSS VSS
* VDD VDD
* C3 C3
* C2 C2
* C1 C1
* B1 B1
* B2 B2
* B3 B3
* A3 A3
* A2 A2
* A1 A1
* Y Y
*
*

M0 N_M0_d N_M0_g VSS VSS nmos_rvt L=2e-08 W=8.1e-08 nfin=3 $X=0.071 $Y=0.027
M1 N_M1_d N_M1_g VSS VSS nmos_rvt L=2e-08 W=8.1e-08 nfin=3 $X=0.125 $Y=0.027
M2 noxref_14 N_M2_g VSS VSS nmos_rvt L=2e-08 W=8.1e-08 nfin=3 $X=0.179 $Y=0.027
M3 VSS N_M3_g noxref_14 VSS nmos_rvt L=2e-08 W=8.1e-08 nfin=3 $X=0.233 $Y=0.027
M4 noxref_14 N_M4_g VSS VSS nmos_rvt L=2e-08 W=8.1e-08 nfin=3 $X=0.287 $Y=0.027
M5 noxref_15 N_M5_g noxref_14 VSS nmos_rvt L=2e-08 W=8.1e-08 nfin=3 $X=0.341
+ $Y=0.027
M6 noxref_14 N_M6_g noxref_15 VSS nmos_rvt L=2e-08 W=8.1e-08 nfin=3 $X=0.395
+ $Y=0.027
M7 noxref_15 N_M7_g noxref_14 VSS nmos_rvt L=2e-08 W=8.1e-08 nfin=3 $X=0.449
+ $Y=0.027
M8 N_M8_d N_M8_g noxref_15 VSS nmos_rvt L=2e-08 W=8.1e-08 nfin=3 $X=0.503
+ $Y=0.027
M9 noxref_15 N_M9_g N_M9_s VSS nmos_rvt L=2e-08 W=8.1e-08 nfin=3 $X=0.557
+ $Y=0.027
M10 N_M10_d N_M10_g noxref_15 VSS nmos_rvt L=2e-08 W=8.1e-08 nfin=3 $X=0.611
+ $Y=0.027
M11 N_M11_d N_M11_g VDD VDD pmos_rvt L=2e-08 W=8.1e-08 nfin=3 $X=0.071 $Y=0.162
M12 N_M12_d N_M12_g VDD VDD pmos_rvt L=2e-08 W=8.1e-08 nfin=3 $X=0.125 $Y=0.162
M13 noxref_16 N_M13_g VDD VDD pmos_rvt L=2e-08 W=8.1e-08 nfin=3 $X=0.179
+ $Y=0.162
M14 noxref_17 N_M14_g noxref_16 VDD pmos_rvt L=2e-08 W=8.1e-08 nfin=3 $X=0.233
+ $Y=0.162
M15 N_M15_d N_M15_g noxref_17 VDD pmos_rvt L=2e-08 W=8.1e-08 nfin=3 $X=0.287
+ $Y=0.162
M16 noxref_18 N_M16_g N_M16_s VDD pmos_rvt L=2e-08 W=8.1e-08 nfin=3 $X=0.341
+ $Y=0.162
M17 noxref_19 N_M17_g noxref_18 VDD pmos_rvt L=2e-08 W=8.1e-08 nfin=3 $X=0.395
+ $Y=0.162
M18 VDD N_M18_g noxref_19 VDD pmos_rvt L=2e-08 W=8.1e-08 nfin=3 $X=0.449
+ $Y=0.162
M19 noxref_20 N_M19_g VDD VDD pmos_rvt L=2e-08 W=8.1e-08 nfin=3 $X=0.503
+ $Y=0.162
M20 noxref_21 N_M20_g noxref_20 VDD pmos_rvt L=2e-08 W=8.1e-08 nfin=3 $X=0.557
+ $Y=0.162
M21 N_M21_d N_M21_g noxref_21 VDD pmos_rvt L=2e-08 W=8.1e-08 nfin=3 $X=0.611
+ $Y=0.162

* .include "OA333x2_ASAP7_75t_R.pex.sp.pxi"

* Start of included file OA333x2_ASAP7_75t_R.pex.sp.pxi
x_PM_OA333x2_ASAP7_75t_R%C2 vss C2 N_M3_g N_M14_g N_C2_4 N_C2_3
+ PM_OA333x2_ASAP7_75t_R%C2
cc_1 N_C2_4 N_3_3 0.000513617f $X=0.243 $Y=0.116
cc_2 N_C2_4 N_3_19 0.000188898f $X=0.243 $Y=0.116
cc_3 N_C2_4 N_3_27 0.00151704f $X=0.243 $Y=0.116
cc_4 N_C2_4 N_3_21 0.0022106f $X=0.243 $Y=0.116
cc_5 N_C2_4 N_C3_4 0.00384504f $X=0.243 $Y=0.116
cc_6 N_C2_3 N_C3_3 0.00699237f $X=0.243 $Y=0.0245
x_PM_OA333x2_ASAP7_75t_R%B2 vss B2 N_M6_g N_M17_g N_B2_4 N_B2_3
+ PM_OA333x2_ASAP7_75t_R%B2
cc_7 N_B2_4 N_3_3 0.000337331f $X=0.405 $Y=0.116
cc_8 N_B2_4 N_3_27 0.003226f $X=0.405 $Y=0.116
cc_9 N_B2_4 N_B1_4 0.00331982f $X=0.405 $Y=0.116
cc_10 N_B2_3 N_B1_3 0.00699756f $X=0.405 $Y=0.0245
x_PM_OA333x2_ASAP7_75t_R%B3 vss B3 N_M7_g N_M18_g N_B3_4 N_B3_3
+ PM_OA333x2_ASAP7_75t_R%B3
cc_11 N_B3_4 N_3_27 0.00280239f $X=0.459 $Y=0.116
cc_12 N_B3_4 N_B2_4 0.00332887f $X=0.459 $Y=0.116
cc_13 N_B3_3 N_B2_3 0.00694039f $X=0.459 $Y=0.0245
x_PM_OA333x2_ASAP7_75t_R%C1 vss C1 N_M4_g N_M15_g N_C1_3 N_C1_4
+ PM_OA333x2_ASAP7_75t_R%C1
cc_14 N_C1_3 N_3_3 0.0017812f $X=0.297 $Y=0.0245
cc_15 N_C1_4 N_3_27 0.00125377f $X=0.297 $Y=0.116
cc_16 N_C1_4 N_3_3 0.00185051f $X=0.297 $Y=0.116
cc_17 N_C1_3 N_3_19 0.0357901f $X=0.297 $Y=0.0245
cc_18 N_C1_4 N_C2_4 0.00371364f $X=0.297 $Y=0.116
cc_19 N_C1_3 N_C2_3 0.00695491f $X=0.297 $Y=0.0245
x_PM_OA333x2_ASAP7_75t_R%A2 vss A2 N_M9_g N_M20_g N_A2_3 N_A2_1 N_A2_4
+ PM_OA333x2_ASAP7_75t_R%A2
cc_20 N_A2_3 N_3_6 0.000249523f $X=0.567 $Y=0.0245
cc_21 N_A2_3 N_3_4 0.00156896f $X=0.567 $Y=0.0245
cc_22 N_A2_1 N_3_17 0.000811553f $X=0.567 $Y=0.135
cc_23 N_A2_4 N_3_28 0.00109178f $X=0.567 $Y=0.116
cc_24 N_A2_4 N_3_27 0.00142013f $X=0.567 $Y=0.116
cc_25 N_A2_4 N_3_4 0.00273185f $X=0.567 $Y=0.116
cc_26 N_A2_3 N_3_17 0.0348357f $X=0.567 $Y=0.0245
cc_27 N_A2_4 N_A3_4 0.00332039f $X=0.567 $Y=0.116
cc_28 N_A2_3 N_A3_3 0.00695439f $X=0.567 $Y=0.0245
x_PM_OA333x2_ASAP7_75t_R%A3 vss A3 N_M8_g N_M19_g N_A3_3 N_A3_4
+ PM_OA333x2_ASAP7_75t_R%A3
cc_29 N_A3_3 N_3_4 0.00115503f $X=0.513 $Y=0.0245
cc_30 N_A3_3 N_3_28 0.000603526f $X=0.513 $Y=0.0245
cc_31 N_A3_4 N_3_27 0.00130748f $X=0.513 $Y=0.1122
cc_32 N_A3_4 N_3_4 0.00210603f $X=0.513 $Y=0.1122
cc_33 N_A3_3 N_3_17 0.0354431f $X=0.513 $Y=0.0245
cc_34 N_A3_4 N_B3_4 0.00299632f $X=0.513 $Y=0.1122
cc_35 N_A3_3 N_B3_3 0.00523547f $X=0.513 $Y=0.0245
x_PM_OA333x2_ASAP7_75t_R%A1 vss A1 N_M10_g N_M21_g N_A1_3 N_A1_4 N_A1_1
+ PM_OA333x2_ASAP7_75t_R%A1
cc_36 N_A1_3 N_3_5 0.00210442f $X=0.621 $Y=0.0245
cc_37 N_A1_3 N_3_18 0.0152392f $X=0.621 $Y=0.0245
cc_38 N_A1_3 N_3_28 0.0010489f $X=0.621 $Y=0.0245
cc_39 N_A1_4 N_3_27 0.00114081f $X=0.621 $Y=0.116
cc_40 N_A1_3 N_3_6 0.00155845f $X=0.621 $Y=0.0245
cc_41 N_A1_1 N_3_18 0.00182973f $X=0.621 $Y=0.135
cc_42 N_A1_4 N_3_29 0.00661932f $X=0.621 $Y=0.116
cc_43 N_A1_3 N_3_20 0.0544712f $X=0.621 $Y=0.0245
cc_44 N_A1_4 N_A2_4 0.00334247f $X=0.621 $Y=0.116
cc_45 N_A1_3 N_A2_3 0.00708753f $X=0.621 $Y=0.0245
x_PM_OA333x2_ASAP7_75t_R%Y vss Y N_M0_d N_M1_d N_M11_d N_M12_d N_Y_7 N_Y_11
+ N_Y_8 PM_OA333x2_ASAP7_75t_R%Y
cc_46 N_Y_7 N_3_26 0.000332222f $X=0.0935 $Y=0.0675
cc_47 N_Y_7 N_3_21 0.00246017f $X=0.0935 $Y=0.0675
cc_48 N_Y_7 N_3_22 0.000384509f $X=0.0935 $Y=0.0675
cc_49 N_Y_7 N_3_1 0.000596153f $X=0.0935 $Y=0.0675
cc_50 N_Y_7 N_3_15 0.0594762f $X=0.0935 $Y=0.0675
cc_51 N_Y_11 N_3_25 0.0045998f $X=0.081 $Y=0.0575
cc_52 N_Y_8 N_3_1 0.00492678f $X=0.0935 $Y=0.2025
cc_53 N_Y_8 N_3_16 0.0283794f $X=0.0935 $Y=0.2025
cc_54 N_Y_7 N_3_16 0.0464524f $X=0.0935 $Y=0.0675
x_PM_OA333x2_ASAP7_75t_R%3 vss N_M0_g N_M11_g N_M1_g N_M12_g N_M15_d N_M16_s
+ N_M21_d N_M10_d N_M8_d N_M9_s N_3_21 N_3_1 N_3_25 N_3_16 N_3_3 N_3_19 N_3_27
+ N_3_4 N_3_28 N_3_17 N_3_6 N_3_5 N_3_18 N_3_29 N_3_20 N_3_26 N_3_22 N_3_15
+ PM_OA333x2_ASAP7_75t_R%3
x_PM_OA333x2_ASAP7_75t_R%C3 vss C3 N_M2_g N_M13_g N_C3_3 N_C3_4
+ PM_OA333x2_ASAP7_75t_R%C3
cc_55 N_C3_3 N_3_21 0.000611051f $X=0.189 $Y=0.0245
cc_56 N_C3_3 N_3_1 0.00229784f $X=0.189 $Y=0.0245
cc_57 N_C3_4 N_3_25 0.00309033f $X=0.189 $Y=0.0925
cc_58 N_C3_3 N_3_16 0.00358623f $X=0.189 $Y=0.0245
x_PM_OA333x2_ASAP7_75t_R%B1 vss B1 N_M5_g N_M16_g N_B1_3 N_B1_4
+ PM_OA333x2_ASAP7_75t_R%B1
cc_59 N_B1_3 N_3_3 0.00178108f $X=0.351 $Y=0.0245
cc_60 N_B1_4 N_3_27 0.00123241f $X=0.351 $Y=0.116
cc_61 N_B1_4 N_3_3 0.00182626f $X=0.351 $Y=0.116
cc_62 N_B1_3 N_3_19 0.0357639f $X=0.351 $Y=0.0245
cc_63 N_B1_3 N_C1_3 0.00317569f $X=0.351 $Y=0.0245
cc_64 N_B1_4 N_C1_4 0.0049991f $X=0.351 $Y=0.116

* End of included file OA333x2_ASAP7_75t_R.pex.sp.pxi
.ends

.subckt PM_OAI221xp5_ASAP7_75t_R%A2 vss 13 5 11 3
c1 1 vss 0.00654403f $X=0.297 $Y=0.135
c2 3 vss 0.133773f $X=0.297 $Y=0.0245
c3 4 vss 0.0135096f $X=0.297 $Y=0.1142
r1 14 15 2.39019 $w=1.3e-08 $l=1.03e-08 $layer=M1 $thickness=3.6e-08 $X=0.297
+ $Y=0.1247 $X2=0.297 $Y2=0.135
r2 13 14 0.408082 $w=1.3e-08 $l=1.7e-09 $layer=M1 $thickness=3.6e-08 $X=0.295
+ $Y=0.123 $X2=0.297 $Y2=0.1247
r3 13 4 2.04041 $w=1.3e-08 $l=8.8e-09 $layer=M1 $thickness=3.6e-08 $X=0.295
+ $Y=0.123 $X2=0.297 $Y2=0.1142
r4 1 8 10.4265 $w=1.765e-08 $layer=LIG $thickness=5.2e-08 $X=0.297 $Y=0.135
+ $X2=0.297 $Y2=0.135
r5 1 15 19.3796 $a=3.24e-16 $layer=V0LIG $X=0.297 $Y=0.135 $X2=0.297 $Y2=0.135
r6 11 10 14.6259 $w=2.1e-08 $l=4.3e-08 $layer=Gate_1 $thickness=5.6e-08
+ $X=0.297 $Y=0.216 $X2=0.297 $Y2=0.173
r7 9 10 7.31297 $w=2.1e-08 $l=2.15e-08 $layer=Gate_1 $thickness=5.6e-08
+ $X=0.297 $Y=0.1515 $X2=0.297 $Y2=0.173
r8 8 9 5.79936 $w=2.03333e-08 $l=1.65e-08 $layer=Gate_1 $thickness=5.6e-08
+ $X=0.297 $Y=0.135 $X2=0.297 $Y2=0.1515
r9 7 8 5.79936 $w=2.03333e-08 $l=1.65e-08 $layer=Gate_1 $thickness=5.6e-08
+ $X=0.297 $Y=0.1185 $X2=0.297 $Y2=0.135
r10 6 7 2.7211 $w=2.1e-08 $l=8e-09 $layer=Gate_1 $thickness=5.6e-08 $X=0.297
+ $Y=0.1105 $X2=0.297 $Y2=0.1185
r11 5 6 14.6259 $w=2.1e-08 $l=4.3e-08 $layer=Gate_1 $thickness=5.6e-08 $X=0.297
+ $Y=0.0675 $X2=0.297 $Y2=0.1105
r12 5 3 14.6259 $w=2.1e-08 $l=4.3e-08 $layer=Gate_1 $thickness=5.6e-08 $X=0.297
+ $Y=0.0675 $X2=0.297 $Y2=0.0245
.ends

.subckt PM_OAI221xp5_ASAP7_75t_R%C vss 11 5 9 4 3
c1 1 vss 0.00714444f $X=0.189 $Y=0.135
c2 3 vss 0.112686f $X=0.189 $Y=0.0245
c3 4 vss 0.00528845f $X=0.189 $Y=0.1142
r1 12 13 2.39019 $w=1.3e-08 $l=1.03e-08 $layer=M1 $thickness=3.6e-08 $X=0.189
+ $Y=0.1247 $X2=0.189 $Y2=0.135
r2 11 12 0.408082 $w=1.3e-08 $l=1.7e-09 $layer=M1 $thickness=3.6e-08 $X=0.188
+ $Y=0.123 $X2=0.189 $Y2=0.1247
r3 11 4 2.04041 $w=1.3e-08 $l=8.8e-09 $layer=M1 $thickness=3.6e-08 $X=0.188
+ $Y=0.123 $X2=0.189 $Y2=0.1142
r4 1 7 10.4265 $w=1.765e-08 $layer=LIG $thickness=5.2e-08 $X=0.189 $Y=0.135
+ $X2=0.189 $Y2=0.135
r5 1 13 19.3796 $a=3.24e-16 $layer=V0LIG $X=0.189 $Y=0.135 $X2=0.189 $Y2=0.135
r6 9 8 16.4967 $w=2.1e-08 $l=4.85e-08 $layer=Gate_1 $thickness=5.6e-08 $X=0.189
+ $Y=0.216 $X2=0.189 $Y2=0.1675
r7 7 8 11.2416 $w=2.06615e-08 $l=3.25e-08 $layer=Gate_1 $thickness=5.6e-08
+ $X=0.189 $Y=0.135 $X2=0.189 $Y2=0.1675
r8 6 7 6.6497 $w=2.04211e-08 $l=1.9e-08 $layer=Gate_1 $thickness=5.6e-08
+ $X=0.189 $Y=0.116 $X2=0.189 $Y2=0.135
r9 5 6 16.4967 $w=2.1e-08 $l=4.85e-08 $layer=Gate_1 $thickness=5.6e-08 $X=0.189
+ $Y=0.0675 $X2=0.189 $Y2=0.116
r10 5 3 14.6259 $w=2.1e-08 $l=4.3e-08 $layer=Gate_1 $thickness=5.6e-08 $X=0.189
+ $Y=0.0675 $X2=0.189 $Y2=0.0245
.ends

.subckt PM_OAI221xp5_ASAP7_75t_R%B2 vss 11 5 9 4 3 1
c1 1 vss 0.00642501f $X=0.135 $Y=0.135
c2 3 vss 0.0904817f $X=0.135 $Y=0.0245
c3 4 vss 0.00453366f $X=0.135 $Y=0.1072
r1 12 13 4.02252 $w=1.3e-08 $l=1.73e-08 $layer=M1 $thickness=3.6e-08 $X=0.135
+ $Y=0.1177 $X2=0.135 $Y2=0.135
r2 11 12 2.04041 $w=1.3e-08 $l=8.7e-09 $layer=M1 $thickness=3.6e-08 $X=0.134
+ $Y=0.109 $X2=0.135 $Y2=0.1177
r3 11 4 0.408082 $w=1.3e-08 $l=1.8e-09 $layer=M1 $thickness=3.6e-08 $X=0.134
+ $Y=0.109 $X2=0.135 $Y2=0.1072
r4 1 7 10.4265 $w=1.765e-08 $layer=LIG $thickness=5.2e-08 $X=0.135 $Y=0.135
+ $X2=0.135 $Y2=0.135
r5 1 13 19.3796 $a=3.24e-16 $layer=V0LIG $X=0.135 $Y=0.135 $X2=0.135 $Y2=0.135
r6 9 8 16.4967 $w=2.1e-08 $l=4.85e-08 $layer=Gate_1 $thickness=5.6e-08 $X=0.135
+ $Y=0.216 $X2=0.135 $Y2=0.1675
r7 7 8 11.2416 $w=2.06615e-08 $l=3.25e-08 $layer=Gate_1 $thickness=5.6e-08
+ $X=0.135 $Y=0.135 $X2=0.135 $Y2=0.1675
r8 6 7 6.6497 $w=2.04211e-08 $l=1.9e-08 $layer=Gate_1 $thickness=5.6e-08
+ $X=0.135 $Y=0.116 $X2=0.135 $Y2=0.135
r9 5 6 16.4967 $w=2.1e-08 $l=4.85e-08 $layer=Gate_1 $thickness=5.6e-08 $X=0.135
+ $Y=0.0675 $X2=0.135 $Y2=0.116
r10 5 3 14.6259 $w=2.1e-08 $l=4.3e-08 $layer=Gate_1 $thickness=5.6e-08 $X=0.135
+ $Y=0.0675 $X2=0.135 $Y2=0.0245
.ends

.subckt PM_OAI221xp5_ASAP7_75t_R%Y vss 28 20 21 45 48 49 1 16 17 10 11 15 2 3 12
c1 1 vss 0.00598357f $X=0.054 $Y=0.216
c2 2 vss 0.00966426f $X=0.108 $Y=0.0675
c3 3 vss 0.00662378f $X=0.216 $Y=0.216
c4 10 vss 0.00452733f $X=0.0935 $Y=0.0675
c5 11 vss 0.0271109f $X=0.056 $Y=0.216
c6 12 vss 0.00313211f $X=0.2015 $Y=0.216
c7 13 vss 0.00229443f $X=0.027 $Y=0.072
c8 14 vss 0.00264219f $X=0.027 $Y=0.234
c9 15 vss 0.0045395f $X=0.027 $Y=0.0935
c10 16 vss 0.00801467f $X=0.0945 $Y=0.072
c11 17 vss 0.0174859f $X=0.0405 $Y=0.234
r1 49 47 0.0462963 $w=5.4e-08 $l=2.5e-09 $layer=P_src_drn $thickness=1e-09
+ $X=0.2333 $Y=0.216 $X2=0.2305 $Y2=0.216
r2 3 47 0.268519 $w=5.4e-08 $l=1.45e-08 $layer=P_src_drn $thickness=1e-09
+ $X=0.216 $Y=0.216 $X2=0.2305 $Y2=0.216
r3 12 3 0.268519 $w=5.4e-08 $l=1.45e-08 $layer=P_src_drn $thickness=1e-09
+ $X=0.2015 $Y=0.216 $X2=0.216 $Y2=0.216
r4 48 12 0.0462963 $w=5.4e-08 $l=2.5e-09 $layer=P_src_drn $thickness=1e-09
+ $X=0.1986 $Y=0.216 $X2=0.2015 $Y2=0.216
r5 45 44 0.0462963 $w=5.4e-08 $l=2.5e-09 $layer=P_src_drn $thickness=1e-09
+ $X=0.0713 $Y=0.216 $X2=0.0685 $Y2=0.216
r6 11 44 0.231482 $w=5.4e-08 $l=1.25e-08 $layer=P_src_drn $thickness=1e-09
+ $X=0.056 $Y=0.216 $X2=0.0685 $Y2=0.216
r7 3 42 19.3796 $a=3.24e-16 $layer=V0LISD $X=0.216 $Y=0.216 $X2=0.216 $Y2=0.234
r8 1 31 19.3796 $a=3.24e-16 $layer=V0LISD $X=0.054 $Y=0.216 $X2=0.054 $Y2=0.234
r9 41 42 2.79828 $w=1.3e-08 $l=1.2e-08 $layer=M1 $thickness=3.6e-08 $X=0.204
+ $Y=0.234 $X2=0.216 $Y2=0.234
r10 40 41 1.04935 $w=1.3e-08 $l=4.5e-09 $layer=M1 $thickness=3.6e-08 $X=0.1995
+ $Y=0.234 $X2=0.204 $Y2=0.234
r11 39 40 2.44849 $w=1.3e-08 $l=1.05e-08 $layer=M1 $thickness=3.6e-08 $X=0.189
+ $Y=0.234 $X2=0.1995 $Y2=0.234
r12 38 39 2.56509 $w=1.3e-08 $l=1.1e-08 $layer=M1 $thickness=3.6e-08 $X=0.178
+ $Y=0.234 $X2=0.189 $Y2=0.234
r13 37 38 4.19742 $w=1.3e-08 $l=1.8e-08 $layer=M1 $thickness=3.6e-08 $X=0.16
+ $Y=0.234 $X2=0.178 $Y2=0.234
r14 36 37 5.82974 $w=1.3e-08 $l=2.5e-08 $layer=M1 $thickness=3.6e-08 $X=0.135
+ $Y=0.234 $X2=0.16 $Y2=0.234
r15 35 36 2.44849 $w=1.3e-08 $l=1.05e-08 $layer=M1 $thickness=3.6e-08 $X=0.1245
+ $Y=0.234 $X2=0.135 $Y2=0.234
r16 34 35 4.19742 $w=1.3e-08 $l=1.8e-08 $layer=M1 $thickness=3.6e-08 $X=0.1065
+ $Y=0.234 $X2=0.1245 $Y2=0.234
r17 33 34 5.94634 $w=1.3e-08 $l=2.55e-08 $layer=M1 $thickness=3.6e-08 $X=0.081
+ $Y=0.234 $X2=0.1065 $Y2=0.234
r18 32 33 3.14806 $w=1.3e-08 $l=1.35e-08 $layer=M1 $thickness=3.6e-08 $X=0.0675
+ $Y=0.234 $X2=0.081 $Y2=0.234
r19 31 32 3.14806 $w=1.3e-08 $l=1.35e-08 $layer=M1 $thickness=3.6e-08 $X=0.054
+ $Y=0.234 $X2=0.0675 $Y2=0.234
r20 17 31 3.14806 $w=1.3e-08 $l=1.35e-08 $layer=M1 $thickness=3.6e-08 $X=0.0405
+ $Y=0.234 $X2=0.054 $Y2=0.234
r21 14 30 3.36447 $w=1.71023e-08 $l=2.15e-08 $layer=M1 $thickness=3.6e-08
+ $X=0.027 $Y=0.234 $X2=0.027 $Y2=0.2125
r22 14 17 1.49895 $w=1.63333e-08 $l=1.35e-08 $layer=M1 $thickness=3.6e-08
+ $X=0.027 $Y=0.234 $X2=0.0405 $Y2=0.234
r23 29 30 6.12123 $w=1.3e-08 $l=2.63e-08 $layer=M1 $thickness=3.6e-08 $X=0.027
+ $Y=0.1862 $X2=0.027 $Y2=0.2125
r24 28 29 3.32295 $w=1.3e-08 $l=1.42e-08 $layer=M1 $thickness=3.6e-08 $X=0.025
+ $Y=0.172 $X2=0.027 $Y2=0.1862
r25 28 27 7.75356 $w=1.3e-08 $l=3.33e-08 $layer=M1 $thickness=3.6e-08 $X=0.025
+ $Y=0.172 $X2=0.027 $Y2=0.1387
r26 15 27 10.5518 $w=1.3e-08 $l=4.52e-08 $layer=M1 $thickness=3.6e-08 $X=0.027
+ $Y=0.0935 $X2=0.027 $Y2=0.1387
r27 13 26 0.915974 $w=1.70909e-08 $l=1.1e-08 $layer=M1 $thickness=3.6e-08
+ $X=0.027 $Y=0.072 $X2=0.038 $Y2=0.072
r28 13 15 3.36447 $w=1.71023e-08 $l=2.15e-08 $layer=M1 $thickness=3.6e-08
+ $X=0.027 $Y=0.072 $X2=0.027 $Y2=0.0935
r29 25 26 4.19742 $w=1.3e-08 $l=1.8e-08 $layer=M1 $thickness=3.6e-08 $X=0.056
+ $Y=0.072 $X2=0.038 $Y2=0.072
r30 24 25 5.82974 $w=1.3e-08 $l=2.5e-08 $layer=M1 $thickness=3.6e-08 $X=0.081
+ $Y=0.072 $X2=0.056 $Y2=0.072
r31 16 22 3.14806 $w=1.3e-08 $l=1.35e-08 $layer=M1 $thickness=3.6e-08 $X=0.0945
+ $Y=0.072 $X2=0.108 $Y2=0.072
r32 16 24 3.14806 $w=1.3e-08 $l=1.35e-08 $layer=M1 $thickness=3.6e-08 $X=0.0945
+ $Y=0.072 $X2=0.081 $Y2=0.072
r33 2 22 19.3796 $a=3.24e-16 $layer=V0LISD $X=0.108 $Y=0.0675 $X2=0.108
+ $Y2=0.072
r34 21 19 0.0308642 $w=8.1e-08 $l=2.5e-09 $layer=N_src_drn $thickness=1e-09
+ $X=0.1253 $Y=0.0675 $X2=0.1225 $Y2=0.0675
r35 2 19 0.179012 $w=8.1e-08 $l=1.45e-08 $layer=N_src_drn $thickness=1e-09
+ $X=0.108 $Y=0.0675 $X2=0.1225 $Y2=0.0675
r36 10 2 0.179012 $w=8.1e-08 $l=1.45e-08 $layer=N_src_drn $thickness=1e-09
+ $X=0.0935 $Y=0.0675 $X2=0.108 $Y2=0.0675
r37 20 10 0.0308642 $w=8.1e-08 $l=2.5e-09 $layer=N_src_drn $thickness=1e-09
+ $X=0.0906 $Y=0.0675 $X2=0.0935 $Y2=0.0675
r38 1 11 1e-05 $l=2e-09 $X=0.054 $Y=0.216 $X2=0.056 $Y2=0.216
.ends

.subckt PM_OAI221xp5_ASAP7_75t_R%B1 vss 15 5 11 4 3 1
c1 1 vss 0.00345066f $X=0.081 $Y=0.135
c2 3 vss 0.0705497f $X=0.081 $Y=0.0245
c3 4 vss 0.00620557f $X=0.081 $Y=0.116
r1 15 14 0.524677 $w=1.3e-08 $l=2.3e-09 $layer=M1 $thickness=3.6e-08 $X=0.084
+ $Y=0.148 $X2=0.081 $Y2=0.1457
r2 13 14 2.50679 $w=1.3e-08 $l=1.07e-08 $layer=M1 $thickness=3.6e-08 $X=0.081
+ $Y=0.135 $X2=0.081 $Y2=0.1457
r3 4 13 4.4306 $w=1.3e-08 $l=1.9e-08 $layer=M1 $thickness=3.6e-08 $X=0.081
+ $Y=0.116 $X2=0.081 $Y2=0.135
r4 1 8 10.4265 $w=1.765e-08 $layer=LIG $thickness=5.2e-08 $X=0.081 $Y=0.135
+ $X2=0.081 $Y2=0.135
r5 1 13 19.3796 $a=3.24e-16 $layer=V0LIG $X=0.081 $Y=0.135 $X2=0.081 $Y2=0.135
r6 11 10 14.6259 $w=2.1e-08 $l=4.3e-08 $layer=Gate_1 $thickness=5.6e-08
+ $X=0.081 $Y=0.216 $X2=0.081 $Y2=0.173
r7 9 10 7.31297 $w=2.1e-08 $l=2.15e-08 $layer=Gate_1 $thickness=5.6e-08
+ $X=0.081 $Y=0.1515 $X2=0.081 $Y2=0.173
r8 8 9 5.79936 $w=2.03333e-08 $l=1.65e-08 $layer=Gate_1 $thickness=5.6e-08
+ $X=0.081 $Y=0.135 $X2=0.081 $Y2=0.1515
r9 7 8 5.79936 $w=2.03333e-08 $l=1.65e-08 $layer=Gate_1 $thickness=5.6e-08
+ $X=0.081 $Y=0.1185 $X2=0.081 $Y2=0.135
r10 6 7 2.7211 $w=2.1e-08 $l=8e-09 $layer=Gate_1 $thickness=5.6e-08 $X=0.081
+ $Y=0.1105 $X2=0.081 $Y2=0.1185
r11 5 6 14.6259 $w=2.1e-08 $l=4.3e-08 $layer=Gate_1 $thickness=5.6e-08 $X=0.081
+ $Y=0.0675 $X2=0.081 $Y2=0.1105
r12 5 3 14.6259 $w=2.1e-08 $l=4.3e-08 $layer=Gate_1 $thickness=5.6e-08 $X=0.081
+ $Y=0.0675 $X2=0.081 $Y2=0.0245
.ends

.subckt PM_OAI221xp5_ASAP7_75t_R%A1 vss 13 5 9 4 3
c1 1 vss 0.00705323f $X=0.243 $Y=0.135
c2 3 vss 0.100911f $X=0.243 $Y=0.0245
c3 4 vss 0.00590874f $X=0.243 $Y=0.116
r1 13 12 2.97317 $w=1.3e-08 $l=1.28e-08 $layer=M1 $thickness=3.6e-08 $X=0.24
+ $Y=0.169 $X2=0.243 $Y2=0.1562
r2 11 12 4.95528 $w=1.3e-08 $l=2.12e-08 $layer=M1 $thickness=3.6e-08 $X=0.243
+ $Y=0.135 $X2=0.243 $Y2=0.1562
r3 4 11 4.4306 $w=1.3e-08 $l=1.9e-08 $layer=M1 $thickness=3.6e-08 $X=0.243
+ $Y=0.116 $X2=0.243 $Y2=0.135
r4 1 7 10.4265 $w=1.765e-08 $layer=LIG $thickness=5.2e-08 $X=0.243 $Y=0.135
+ $X2=0.243 $Y2=0.135
r5 1 11 19.3796 $a=3.24e-16 $layer=V0LIG $X=0.243 $Y=0.135 $X2=0.243 $Y2=0.135
r6 9 8 16.4967 $w=2.1e-08 $l=4.85e-08 $layer=Gate_1 $thickness=5.6e-08 $X=0.243
+ $Y=0.216 $X2=0.243 $Y2=0.1675
r7 7 8 11.2416 $w=2.06615e-08 $l=3.25e-08 $layer=Gate_1 $thickness=5.6e-08
+ $X=0.243 $Y=0.135 $X2=0.243 $Y2=0.1675
r8 6 7 6.6497 $w=2.04211e-08 $l=1.9e-08 $layer=Gate_1 $thickness=5.6e-08
+ $X=0.243 $Y=0.116 $X2=0.243 $Y2=0.135
r9 5 6 16.4967 $w=2.1e-08 $l=4.85e-08 $layer=Gate_1 $thickness=5.6e-08 $X=0.243
+ $Y=0.0675 $X2=0.243 $Y2=0.116
r10 5 3 14.6259 $w=2.1e-08 $l=4.3e-08 $layer=Gate_1 $thickness=5.6e-08 $X=0.243
+ $Y=0.0675 $X2=0.243 $Y2=0.0245
.ends

* End of included file OAI221xp5_ASAP7_75t_R.pex.sp.pex

*
.subckt OAI221xp5_ASAP7_75t_CUSTOM_4_25_0_7 VSS VDD B1 B2 C A1 A2 Y
*
* VSS VSS
* VDD VDD
* B1 B1
* B2 B2
* C C
* A1 A1
* A2 A2
* Y Y
*
*

M0 N_M0_d N_M0_g noxref_9 VSS nmos_rvt L=2e-08 W=8.1e-08 nfin=3 $X=0.071
+ $Y=0.027
M1 noxref_9 N_M1_g N_M1_s VSS nmos_rvt L=2e-08 W=8.1e-08 nfin=3 $X=0.125
+ $Y=0.027
M2 noxref_10 N_M2_g noxref_9 VSS nmos_rvt L=2e-08 W=8.1e-08 nfin=3 $X=0.179
+ $Y=0.027
M3 VSS N_M3_g noxref_10 VSS nmos_rvt L=2e-08 W=8.1e-08 nfin=3 $X=0.233 $Y=0.027
M4 noxref_10 N_M4_g VSS VSS nmos_rvt L=2e-08 W=8.1e-08 nfin=3 $X=0.287 $Y=0.027
M5 noxref_11 N_M5_g N_M5_s VDD pmos_rvt L=2e-08 W=5.4e-08 nfin=2 $X=0.071
+ $Y=0.189
M6 VDD N_M6_g noxref_11 VDD pmos_rvt L=2e-08 W=5.4e-08 nfin=2 $X=0.125 $Y=0.189
M7 N_M7_d N_M7_g VDD VDD pmos_rvt L=2e-08 W=5.4e-08 nfin=2 $X=0.179 $Y=0.189
M8 noxref_12 N_M8_g N_M8_s VDD pmos_rvt L=2e-08 W=5.4e-08 nfin=2 $X=0.233
+ $Y=0.189
M9 VDD N_M9_g noxref_12 VDD pmos_rvt L=2e-08 W=5.4e-08 nfin=2 $X=0.287 $Y=0.189

* .include "OAI221xp5_ASAP7_75t_R.pex.sp.pxi"

* Start of included file OAI221xp5_ASAP7_75t_R.pex.sp.pxi
x_PM_OAI221xp5_ASAP7_75t_R%A2 vss A2 N_M4_g N_M9_g N_A2_3
+ PM_OAI221xp5_ASAP7_75t_R%A2
cc_1 N_A2_3 N_A1_4 0.00391828f $X=0.297 $Y=0.0245
cc_2 N_A2_3 N_A1_3 0.00878452f $X=0.297 $Y=0.0245
x_PM_OAI221xp5_ASAP7_75t_R%C vss C N_M2_g N_M7_g N_C_4 N_C_3
+ PM_OAI221xp5_ASAP7_75t_R%C
cc_3 N_C_4 N_B2_4 0.00331926f $X=0.189 $Y=0.1142
cc_4 N_C_3 N_B2_3 0.00715806f $X=0.189 $Y=0.0245
x_PM_OAI221xp5_ASAP7_75t_R%B2 vss B2 N_M1_g N_M6_g N_B2_4 N_B2_3 N_B2_1
+ PM_OAI221xp5_ASAP7_75t_R%B2
cc_5 N_B2_4 N_B1_4 0.00334174f $X=0.135 $Y=0.1072
cc_6 N_B2_3 N_B1_3 0.00857566f $X=0.135 $Y=0.0245
x_PM_OAI221xp5_ASAP7_75t_R%Y vss Y N_M0_d N_M1_s N_M5_s N_M7_d N_M8_s N_Y_1
+ N_Y_16 N_Y_17 N_Y_10 N_Y_11 N_Y_15 N_Y_2 N_Y_3 N_Y_12
+ PM_OAI221xp5_ASAP7_75t_R%Y
cc_7 N_Y_1 N_B1_3 0.000891949f $X=0.054 $Y=0.216
cc_8 N_Y_16 N_B1_4 0.000970357f $X=0.0945 $Y=0.072
cc_9 N_Y_17 N_B1_4 0.00106819f $X=0.0405 $Y=0.234
cc_10 N_Y_10 N_B1_1 0.00123479f $X=0.0935 $Y=0.0675
cc_11 N_Y_11 N_B1_3 0.0106282f $X=0.056 $Y=0.216
cc_12 N_Y_15 N_B1_4 0.00643821f $X=0.027 $Y=0.0935
cc_13 N_Y_10 N_B1_3 0.0508363f $X=0.0935 $Y=0.0675
cc_14 N_Y_10 N_B2_1 0.000828611f $X=0.0935 $Y=0.0675
cc_15 N_Y_17 N_B2_4 0.00122979f $X=0.0405 $Y=0.234
cc_16 N_Y_2 N_B2_4 0.00211564f $X=0.108 $Y=0.0675
cc_17 N_Y_10 N_B2_3 0.0368647f $X=0.0935 $Y=0.0675
cc_18 N_Y_3 N_C_4 0.00160845f $X=0.216 $Y=0.216
cc_19 N_Y_12 N_C_3 0.0267639f $X=0.2015 $Y=0.216
cc_20 N_Y_3 N_A1_4 0.00101549f $X=0.216 $Y=0.216
cc_21 N_Y_12 N_A1_3 0.0270011f $X=0.2015 $Y=0.216
x_PM_OAI221xp5_ASAP7_75t_R%B1 vss B1 N_M0_g N_M5_g N_B1_4 N_B1_3 N_B1_1
+ PM_OAI221xp5_ASAP7_75t_R%B1
x_PM_OAI221xp5_ASAP7_75t_R%A1 vss A1 N_M3_g N_M8_g N_A1_4 N_A1_3
+ PM_OAI221xp5_ASAP7_75t_R%A1
cc_22 N_A1_4 N_C_4 0.003284f $X=0.243 $Y=0.116
cc_23 N_A1_3 N_C_3 0.00715808f $X=0.243 $Y=0.0245

* End of included file OAI221xp5_ASAP7_75t_R.pex.sp.pxi
.ends

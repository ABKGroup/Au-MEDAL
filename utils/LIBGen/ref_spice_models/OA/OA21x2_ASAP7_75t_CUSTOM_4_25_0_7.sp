.subckt PM_OA21x2_ASAP7_75t_R%A1 vss 19 5 11 3 1
c1 1 vss 0.0159061f $X=0.081 $Y=0.135
c2 3 vss 0.104456f $X=0.081 $Y=0.0245
c3 4 vss 0.0184429f $X=0.027 $Y=0.0935
r1 20 21 3.20636 $w=1.3e-08 $l=1.38e-08 $layer=M1 $thickness=3.6e-08 $X=0.027
+ $Y=0.1212 $X2=0.027 $Y2=0.135
r2 19 20 1.45744 $w=1.3e-08 $l=6.2e-09 $layer=M1 $thickness=3.6e-08 $X=0.03
+ $Y=0.115 $X2=0.027 $Y2=0.1212
r3 19 18 1.10765 $w=1.3e-08 $l=4.8e-09 $layer=M1 $thickness=3.6e-08 $X=0.03
+ $Y=0.115 $X2=0.027 $Y2=0.1102
r4 4 18 3.90593 $w=1.3e-08 $l=1.67e-08 $layer=M1 $thickness=3.6e-08 $X=0.027
+ $Y=0.0935 $X2=0.027 $Y2=0.1102
r5 14 15 61.7733 $w=9.3e-09 $l=2.65e-08 $layer=LIG $thickness=4.8e-08 $X=0.027
+ $Y=0.135 $X2=0.0535 $Y2=0.135
r6 14 21 28.9687 $a=2.88e-16 $layer=V0LIG $X=0.027 $Y=0.135 $X2=0.027 $Y2=0.135
r7 1 8 7.58422 $w=1.77778e-08 $layer=LIG $thickness=5.15556e-08 $X=0.081
+ $Y=0.135 $X2=0.081 $Y2=0.135
r8 1 15 45.5208 $w=1.17364e-08 $l=2.75e-08 $layer=LIG $thickness=4.8e-08
+ $X=0.081 $Y=0.135 $X2=0.0535 $Y2=0.135
r9 11 10 14.6259 $w=2.1e-08 $l=4.3e-08 $layer=Gate_1 $thickness=5.6e-08
+ $X=0.081 $Y=0.2025 $X2=0.081 $Y2=0.1595
r10 9 10 3.23131 $w=2.1e-08 $l=9.5e-09 $layer=Gate_1 $thickness=5.6e-08
+ $X=0.081 $Y=0.15 $X2=0.081 $Y2=0.1595
r11 8 9 5.23813 $w=2.04667e-08 $l=1.5e-08 $layer=Gate_1 $thickness=5.6e-08
+ $X=0.081 $Y=0.135 $X2=0.081 $Y2=0.15
r12 7 8 5.23813 $w=2.04667e-08 $l=1.5e-08 $layer=Gate_1 $thickness=5.6e-08
+ $X=0.081 $Y=0.12 $X2=0.081 $Y2=0.135
r13 6 7 3.23131 $w=2.1e-08 $l=9.5e-09 $layer=Gate_1 $thickness=5.6e-08 $X=0.081
+ $Y=0.1105 $X2=0.081 $Y2=0.12
r14 5 6 14.6259 $w=2.1e-08 $l=4.3e-08 $layer=Gate_1 $thickness=5.6e-08 $X=0.081
+ $Y=0.0675 $X2=0.081 $Y2=0.1105
r15 5 3 14.6259 $w=2.1e-08 $l=4.3e-08 $layer=Gate_1 $thickness=5.6e-08 $X=0.081
+ $Y=0.0675 $X2=0.081 $Y2=0.0245
.ends

.subckt PM_OA21x2_ASAP7_75t_R%Y vss 22 16 17 30 31 7 1 2 11 12 8 13
c1 1 vss 0.00882011f $X=0.27 $Y=0.0675
c2 2 vss 0.00887949f $X=0.27 $Y=0.2025
c3 7 vss 0.00439096f $X=0.2555 $Y=0.0675
c4 8 vss 0.00437792f $X=0.2555 $Y=0.2025
c5 9 vss 0.00289946f $X=0.351 $Y=0.036
c6 10 vss 0.00289912f $X=0.351 $Y=0.234
c7 11 vss 0.0079837f $X=0.2585 $Y=0.036
c8 12 vss 0.0076527f $X=0.324 $Y=0.234
c9 13 vss 0.00778178f $X=0.351 $Y=0.054
r1 31 29 0.0308642 $w=8.1e-08 $l=2.5e-09 $layer=P_src_drn $thickness=1e-09
+ $X=0.2873 $Y=0.2025 $X2=0.2845 $Y2=0.2025
r2 2 29 0.179012 $w=8.1e-08 $l=1.45e-08 $layer=P_src_drn $thickness=1e-09
+ $X=0.27 $Y=0.2025 $X2=0.2845 $Y2=0.2025
r3 8 2 0.179012 $w=8.1e-08 $l=1.45e-08 $layer=P_src_drn $thickness=1e-09
+ $X=0.2555 $Y=0.2025 $X2=0.27 $Y2=0.2025
r4 30 8 0.0308642 $w=8.1e-08 $l=2.5e-09 $layer=P_src_drn $thickness=1e-09
+ $X=0.2526 $Y=0.2025 $X2=0.2555 $Y2=0.2025
r5 2 26 19.3796 $a=3.24e-16 $layer=V0LISD $X=0.27 $Y=0.2025 $X2=0.27 $Y2=0.234
r6 26 27 5.24677 $w=1.3e-08 $l=2.25e-08 $layer=M1 $thickness=3.6e-08 $X=0.27
+ $Y=0.234 $X2=0.2925 $Y2=0.234
r7 12 27 7.34548 $w=1.3e-08 $l=3.15e-08 $layer=M1 $thickness=3.6e-08 $X=0.324
+ $Y=0.234 $X2=0.2925 $Y2=0.234
r8 10 24 2.5483 $w=1.79e-08 $l=1.8e-08 $layer=M1 $thickness=3.6e-08 $X=0.351
+ $Y=0.234 $X2=0.351 $Y2=0.216
r9 10 12 4.64701 $w=1.46667e-08 $l=2.7e-08 $layer=M1 $thickness=3.6e-08
+ $X=0.351 $Y=0.234 $X2=0.324 $Y2=0.234
r10 23 24 9.73567 $w=1.3e-08 $l=4.18e-08 $layer=M1 $thickness=3.6e-08 $X=0.351
+ $Y=0.1742 $X2=0.351 $Y2=0.216
r11 22 23 7.75356 $w=1.3e-08 $l=3.32e-08 $layer=M1 $thickness=3.6e-08 $X=0.352
+ $Y=0.141 $X2=0.351 $Y2=0.1742
r12 22 21 9.1527 $w=1.3e-08 $l=3.93e-08 $layer=M1 $thickness=3.6e-08 $X=0.352
+ $Y=0.141 $X2=0.351 $Y2=0.1017
r13 13 21 11.1348 $w=1.3e-08 $l=4.77e-08 $layer=M1 $thickness=3.6e-08 $X=0.351
+ $Y=0.054 $X2=0.351 $Y2=0.1017
r14 9 20 4.64701 $w=1.46667e-08 $l=2.7e-08 $layer=M1 $thickness=3.6e-08
+ $X=0.351 $Y=0.036 $X2=0.324 $Y2=0.036
r15 9 13 2.5483 $w=1.79e-08 $l=1.8e-08 $layer=M1 $thickness=3.6e-08 $X=0.351
+ $Y=0.036 $X2=0.351 $Y2=0.054
r16 19 20 7.34548 $w=1.3e-08 $l=3.15e-08 $layer=M1 $thickness=3.6e-08 $X=0.2925
+ $Y=0.036 $X2=0.324 $Y2=0.036
r17 18 19 5.24677 $w=1.3e-08 $l=2.25e-08 $layer=M1 $thickness=3.6e-08 $X=0.27
+ $Y=0.036 $X2=0.2925 $Y2=0.036
r18 11 18 2.68168 $w=1.3e-08 $l=1.15e-08 $layer=M1 $thickness=3.6e-08 $X=0.2585
+ $Y=0.036 $X2=0.27 $Y2=0.036
r19 1 18 19.3796 $a=3.24e-16 $layer=V0LISD $X=0.27 $Y=0.0675 $X2=0.27 $Y2=0.036
r20 17 15 0.0308642 $w=8.1e-08 $l=2.5e-09 $layer=N_src_drn $thickness=1e-09
+ $X=0.2873 $Y=0.0675 $X2=0.2845 $Y2=0.0675
r21 1 15 0.179012 $w=8.1e-08 $l=1.45e-08 $layer=N_src_drn $thickness=1e-09
+ $X=0.27 $Y=0.0675 $X2=0.2845 $Y2=0.0675
r22 7 1 0.179012 $w=8.1e-08 $l=1.45e-08 $layer=N_src_drn $thickness=1e-09
+ $X=0.2555 $Y=0.0675 $X2=0.27 $Y2=0.0675
r23 16 7 0.0308642 $w=8.1e-08 $l=2.5e-09 $layer=N_src_drn $thickness=1e-09
+ $X=0.2526 $Y=0.0675 $X2=0.2555 $Y2=0.0675
.ends

.subckt PM_OA21x2_ASAP7_75t_R%6 vss 22 26 36 40 59 60 66 67 3 11 12 4 18 17 21
+ 1 13 20 9 10 15 16
c1 1 vss 0.00758431f $X=0.243 $Y=0.135
c2 3 vss 0.01033f $X=0.108 $Y=0.0675
c3 4 vss 0.0077048f $X=0.162 $Y=0.2025
c4 9 vss 0.0809202f $X=0.243 $Y=0.0245
c5 10 vss 0.0847761f $X=0.297 $Y=0.135
c6 11 vss 0.00719611f $X=0.0935 $Y=0.0675
c7 12 vss 0.00646805f $X=0.1475 $Y=0.2025
c8 13 vss 0.000603547f $X=0.215 $Y=0.1945
c9 14 vss 0.0028533f $X=0.215 $Y=0.234
c10 15 vss 0.000694117f $X=0.297 $Y=0.072
c11 16 vss 0.000682532f $X=0.297 $Y=0.198
c12 17 vss 0.0145559f $X=0.272 $Y=0.072
c13 18 vss 0.00646047f $X=0.193 $Y=0.234
c14 19 vss 0.000677724f $X=0.215 $Y=0.216
c15 20 vss 0.00178945f $X=0.272 $Y=0.198
c16 21 vss 0.00310362f $X=0.297 $Y=0.1295
r1 67 65 0.0308642 $w=8.1e-08 $l=2.5e-09 $layer=P_src_drn $thickness=1e-09
+ $X=0.1793 $Y=0.2025 $X2=0.1765 $Y2=0.2025
r2 4 65 0.179012 $w=8.1e-08 $l=1.45e-08 $layer=P_src_drn $thickness=1e-09
+ $X=0.162 $Y=0.2025 $X2=0.1765 $Y2=0.2025
r3 12 4 0.179012 $w=8.1e-08 $l=1.45e-08 $layer=P_src_drn $thickness=1e-09
+ $X=0.1475 $Y=0.2025 $X2=0.162 $Y2=0.2025
r4 66 12 0.0308642 $w=8.1e-08 $l=2.5e-09 $layer=P_src_drn $thickness=1e-09
+ $X=0.1446 $Y=0.2025 $X2=0.1475 $Y2=0.2025
r5 4 62 19.3796 $a=3.24e-16 $layer=V0LISD $X=0.162 $Y=0.2025 $X2=0.162 $Y2=0.234
r6 62 63 3.14806 $w=1.3e-08 $l=1.35e-08 $layer=M1 $thickness=3.6e-08 $X=0.162
+ $Y=0.234 $X2=0.1755 $Y2=0.234
r7 18 63 4.08082 $w=1.3e-08 $l=1.75e-08 $layer=M1 $thickness=3.6e-08 $X=0.193
+ $Y=0.234 $X2=0.1755 $Y2=0.234
r8 14 19 2.5483 $w=1.79e-08 $l=1.8e-08 $layer=M1 $thickness=3.6e-08 $X=0.215
+ $Y=0.234 $X2=0.215 $Y2=0.216
r9 14 18 3.48106 $w=1.50455e-08 $l=2.2e-08 $layer=M1 $thickness=3.6e-08
+ $X=0.215 $Y=0.234 $X2=0.193 $Y2=0.234
r10 19 56 2.45586 $w=1.44e-08 $l=1.25e-08 $layer=M1 $thickness=3.6e-08 $X=0.215
+ $Y=0.216 $X2=0.215 $Y2=0.2035
r11 60 58 0.0308642 $w=8.1e-08 $l=2.5e-09 $layer=N_src_drn $thickness=1e-09
+ $X=0.1253 $Y=0.0675 $X2=0.1225 $Y2=0.0675
r12 3 58 0.179012 $w=8.1e-08 $l=1.45e-08 $layer=N_src_drn $thickness=1e-09
+ $X=0.108 $Y=0.0675 $X2=0.1225 $Y2=0.0675
r13 11 3 0.179012 $w=8.1e-08 $l=1.45e-08 $layer=N_src_drn $thickness=1e-09
+ $X=0.0935 $Y=0.0675 $X2=0.108 $Y2=0.0675
r14 59 11 0.0308642 $w=8.1e-08 $l=2.5e-09 $layer=N_src_drn $thickness=1e-09
+ $X=0.0906 $Y=0.0675 $X2=0.0935 $Y2=0.0675
r15 13 56 0.9184 $w=1.8e-08 $l=9e-09 $layer=M1 $thickness=3.6e-08 $X=0.215
+ $Y=0.1945 $X2=0.215 $Y2=0.2035
r16 3 52 19.3796 $a=3.24e-16 $layer=V0LISD $X=0.108 $Y=0.0675 $X2=0.108
+ $Y2=0.072
r17 55 56 2.10608 $w=1.45909e-08 $l=1.73925e-08 $layer=M1 $thickness=3.6e-08
+ $X=0.2315 $Y=0.198 $X2=0.215 $Y2=0.2035
r18 54 55 3.73104 $w=1.3e-08 $l=1.6e-08 $layer=M1 $thickness=3.6e-08 $X=0.2475
+ $Y=0.198 $X2=0.2315 $Y2=0.198
r19 20 54 5.71315 $w=1.3e-08 $l=2.45e-08 $layer=M1 $thickness=3.6e-08 $X=0.272
+ $Y=0.198 $X2=0.2475 $Y2=0.198
r20 52 53 3.14806 $w=1.3e-08 $l=1.35e-08 $layer=M1 $thickness=3.6e-08 $X=0.108
+ $Y=0.072 $X2=0.1215 $Y2=0.072
r21 51 53 3.14806 $w=1.3e-08 $l=1.35e-08 $layer=M1 $thickness=3.6e-08 $X=0.135
+ $Y=0.072 $X2=0.1215 $Y2=0.072
r22 50 51 2.56509 $w=1.3e-08 $l=1.1e-08 $layer=M1 $thickness=3.6e-08 $X=0.146
+ $Y=0.072 $X2=0.135 $Y2=0.072
r23 49 50 3.73104 $w=1.3e-08 $l=1.6e-08 $layer=M1 $thickness=3.6e-08 $X=0.162
+ $Y=0.072 $X2=0.146 $Y2=0.072
r24 48 49 3.73104 $w=1.3e-08 $l=1.6e-08 $layer=M1 $thickness=3.6e-08 $X=0.178
+ $Y=0.072 $X2=0.162 $Y2=0.072
r25 47 48 2.56509 $w=1.3e-08 $l=1.1e-08 $layer=M1 $thickness=3.6e-08 $X=0.189
+ $Y=0.072 $X2=0.178 $Y2=0.072
r26 46 47 6.8791 $w=1.3e-08 $l=2.95e-08 $layer=M1 $thickness=3.6e-08 $X=0.2185
+ $Y=0.072 $X2=0.189 $Y2=0.072
r27 45 46 6.7625 $w=1.3e-08 $l=2.9e-08 $layer=M1 $thickness=3.6e-08 $X=0.2475
+ $Y=0.072 $X2=0.2185 $Y2=0.072
r28 17 45 5.71315 $w=1.3e-08 $l=2.45e-08 $layer=M1 $thickness=3.6e-08 $X=0.272
+ $Y=0.072 $X2=0.2475 $Y2=0.072
r29 16 44 2.5483 $w=1.79e-08 $l=1.8e-08 $layer=M1 $thickness=3.6e-08 $X=0.297
+ $Y=0.198 $X2=0.297 $Y2=0.18
r30 16 20 4.18063 $w=1.48e-08 $l=2.5e-08 $layer=M1 $thickness=3.6e-08 $X=0.297
+ $Y=0.198 $X2=0.272 $Y2=0.198
r31 15 42 3.36447 $w=1.71023e-08 $l=2.15e-08 $layer=M1 $thickness=3.6e-08
+ $X=0.297 $Y=0.072 $X2=0.297 $Y2=0.0935
r32 15 17 4.18063 $w=1.48e-08 $l=2.5e-08 $layer=M1 $thickness=3.6e-08 $X=0.297
+ $Y=0.072 $X2=0.272 $Y2=0.072
r33 43 44 4.19742 $w=1.3e-08 $l=1.8e-08 $layer=M1 $thickness=3.6e-08 $X=0.297
+ $Y=0.162 $X2=0.297 $Y2=0.18
r34 21 31 19.3796 $a=3.24e-16 $layer=V0LIG $X=0.297 $Y=0.1295 $X2=0.297
+ $Y2=0.135
r35 21 42 8.39483 $w=1.3e-08 $l=3.6e-08 $layer=M1 $thickness=3.6e-08 $X=0.297
+ $Y=0.1295 $X2=0.297 $Y2=0.0935
r36 21 43 7.57867 $w=1.3e-08 $l=3.25e-08 $layer=M1 $thickness=3.6e-08 $X=0.297
+ $Y=0.1295 $X2=0.297 $Y2=0.162
r37 40 39 14.6259 $w=2.1e-08 $l=4.3e-08 $layer=Gate_1 $thickness=5.6e-08
+ $X=0.297 $Y=0.2025 $X2=0.297 $Y2=0.1595
r38 38 39 2.7211 $w=2.1e-08 $l=8e-09 $layer=Gate_1 $thickness=5.6e-08 $X=0.297
+ $Y=0.1515 $X2=0.297 $Y2=0.1595
r39 36 37 14.6259 $w=2.1e-08 $l=4.3e-08 $layer=Gate_1 $thickness=5.6e-08
+ $X=0.297 $Y=0.0675 $X2=0.297 $Y2=0.1105
r40 34 37 2.7211 $w=2.1e-08 $l=8e-09 $layer=Gate_1 $thickness=5.6e-08 $X=0.297
+ $Y=0.1185 $X2=0.297 $Y2=0.1105
r41 10 31 6.27904 $w=2.09e-08 $layer=Gate_1 $thickness=5.24e-08 $X=0.297
+ $Y=0.135 $X2=0.297 $Y2=0.135
r42 10 34 5.79936 $w=2.03333e-08 $l=1.65e-08 $layer=Gate_1 $thickness=5.6e-08
+ $X=0.297 $Y=0.135 $X2=0.297 $Y2=0.1185
r43 10 38 5.79936 $w=2.03333e-08 $l=1.65e-08 $layer=Gate_1 $thickness=5.6e-08
+ $X=0.297 $Y=0.135 $X2=0.297 $Y2=0.1515
r44 30 31 2.48102 $w=2.2e-08 $l=9.5e-09 $layer=LIG $thickness=4.8e-08 $X=0.2875
+ $Y=0.135 $X2=0.297 $Y2=0.135
r45 29 30 10.1729 $w=1.54914e-08 $l=1.75e-08 $layer=LIG $thickness=4.8e-08
+ $X=0.27 $Y=0.135 $X2=0.2875 $Y2=0.135
r46 1 24 6.54019 $w=2.09524e-08 $layer=Gate_1 $thickness=5.21905e-08 $X=0.243
+ $Y=0.135 $X2=0.243 $Y2=0.135
r47 1 29 12.6539 $w=1.77815e-08 $l=2.7e-08 $layer=LIG $thickness=4.8e-08
+ $X=0.243 $Y=0.135 $X2=0.27 $Y2=0.135
r48 26 25 16.4967 $w=2.1e-08 $l=4.85e-08 $layer=Gate_1 $thickness=5.6e-08
+ $X=0.243 $Y=0.2025 $X2=0.243 $Y2=0.154
r49 24 25 6.6497 $w=2.04211e-08 $l=1.9e-08 $layer=Gate_1 $thickness=5.6e-08
+ $X=0.243 $Y=0.135 $X2=0.243 $Y2=0.154
r50 23 24 6.6497 $w=2.04211e-08 $l=1.9e-08 $layer=Gate_1 $thickness=5.6e-08
+ $X=0.243 $Y=0.116 $X2=0.243 $Y2=0.135
r51 22 23 16.4967 $w=2.1e-08 $l=4.85e-08 $layer=Gate_1 $thickness=5.6e-08
+ $X=0.243 $Y=0.0675 $X2=0.243 $Y2=0.116
r52 22 9 14.6259 $w=2.1e-08 $l=4.3e-08 $layer=Gate_1 $thickness=5.6e-08
+ $X=0.243 $Y=0.0675 $X2=0.243 $Y2=0.0245
.ends

.subckt PM_OA21x2_ASAP7_75t_R%B vss 15 7 11 3 6 1 5
c1 1 vss 0.00701215f $X=0.189 $Y=0.135
c2 3 vss 0.118996f $X=0.189 $Y=0.0245
c3 4 vss 0.0014022f $X=0.189 $Y=0.162
c4 5 vss 0.0020009f $X=0.189 $Y=0.1102
c5 6 vss 0.00257725f $X=0.202 $Y=0.162
r1 4 18 1.49895 $w=1.95333e-08 $l=1.35e-08 $layer=M1 $thickness=3.6e-08
+ $X=0.189 $Y=0.162 $X2=0.189 $Y2=0.1485
r2 4 6 1.38235 $w=1.64615e-08 $l=1.3e-08 $layer=M1 $thickness=3.6e-08 $X=0.189
+ $Y=0.162 $X2=0.202 $Y2=0.162
r3 17 18 3.14806 $w=1.3e-08 $l=1.35e-08 $layer=M1 $thickness=3.6e-08 $X=0.189
+ $Y=0.135 $X2=0.189 $Y2=0.1485
r4 16 17 3.32295 $w=1.3e-08 $l=1.43e-08 $layer=M1 $thickness=3.6e-08 $X=0.189
+ $Y=0.1207 $X2=0.189 $Y2=0.135
r5 15 16 1.34084 $w=1.3e-08 $l=5.7e-09 $layer=M1 $thickness=3.6e-08 $X=0.193
+ $Y=0.115 $X2=0.189 $Y2=0.1207
r6 15 5 1.10765 $w=1.3e-08 $l=4.8e-09 $layer=M1 $thickness=3.6e-08 $X=0.193
+ $Y=0.115 $X2=0.189 $Y2=0.1102
r7 1 9 6.54019 $w=2.09524e-08 $layer=Gate_1 $thickness=5.21905e-08 $X=0.189
+ $Y=0.135 $X2=0.189 $Y2=0.135
r8 1 17 19.3796 $a=3.24e-16 $layer=V0LIG $X=0.189 $Y=0.135 $X2=0.189 $Y2=0.135
r9 11 10 16.4967 $w=2.1e-08 $l=4.85e-08 $layer=Gate_1 $thickness=5.6e-08
+ $X=0.189 $Y=0.2025 $X2=0.189 $Y2=0.154
r10 9 10 6.6497 $w=2.04211e-08 $l=1.9e-08 $layer=Gate_1 $thickness=5.6e-08
+ $X=0.189 $Y=0.135 $X2=0.189 $Y2=0.154
r11 8 9 6.6497 $w=2.04211e-08 $l=1.9e-08 $layer=Gate_1 $thickness=5.6e-08
+ $X=0.189 $Y=0.116 $X2=0.189 $Y2=0.135
r12 7 8 16.4967 $w=2.1e-08 $l=4.85e-08 $layer=Gate_1 $thickness=5.6e-08
+ $X=0.189 $Y=0.0675 $X2=0.189 $Y2=0.116
r13 7 3 14.6259 $w=2.1e-08 $l=4.3e-08 $layer=Gate_1 $thickness=5.6e-08 $X=0.189
+ $Y=0.0675 $X2=0.189 $Y2=0.0245
.ends

.subckt PM_OA21x2_ASAP7_75t_R%A2 vss 13 5 9 1 3 4
c1 1 vss 0.00722512f $X=0.135 $Y=0.135
c2 3 vss 0.0648539f $X=0.135 $Y=0.0245
c3 4 vss 0.0051383f $X=0.135 $Y=0.1132
r1 14 15 2.62338 $w=1.3e-08 $l=1.13e-08 $layer=M1 $thickness=3.6e-08 $X=0.135
+ $Y=0.1237 $X2=0.135 $Y2=0.135
r2 13 14 0.641272 $w=1.3e-08 $l=2.7e-09 $layer=M1 $thickness=3.6e-08 $X=0.134
+ $Y=0.121 $X2=0.135 $Y2=0.1237
r3 13 4 1.80722 $w=1.3e-08 $l=7.8e-09 $layer=M1 $thickness=3.6e-08 $X=0.134
+ $Y=0.121 $X2=0.135 $Y2=0.1132
r4 1 7 8.65438 $w=1.80211e-08 $layer=LIG $thickness=5.26316e-08 $X=0.135
+ $Y=0.135 $X2=0.135 $Y2=0.135
r5 1 15 19.3796 $a=3.24e-16 $layer=V0LIG $X=0.135 $Y=0.135 $X2=0.135 $Y2=0.135
r6 9 8 16.4967 $w=2.1e-08 $l=4.85e-08 $layer=Gate_1 $thickness=5.6e-08 $X=0.135
+ $Y=0.2025 $X2=0.135 $Y2=0.154
r7 7 8 6.6497 $w=2.04211e-08 $l=1.9e-08 $layer=Gate_1 $thickness=5.6e-08
+ $X=0.135 $Y=0.135 $X2=0.135 $Y2=0.154
r8 6 7 6.6497 $w=2.04211e-08 $l=1.9e-08 $layer=Gate_1 $thickness=5.6e-08
+ $X=0.135 $Y=0.116 $X2=0.135 $Y2=0.135
r9 5 6 16.4967 $w=2.1e-08 $l=4.85e-08 $layer=Gate_1 $thickness=5.6e-08 $X=0.135
+ $Y=0.0675 $X2=0.135 $Y2=0.116
r10 5 3 14.6259 $w=2.1e-08 $l=4.3e-08 $layer=Gate_1 $thickness=5.6e-08 $X=0.135
+ $Y=0.0675 $X2=0.135 $Y2=0.0245
.ends

* End of included file OA21x2_ASAP7_75t_R.pex.sp.pex

*
.subckt OA21x2_ASAP7_75t_CUSTOM_4_25_0_7 A1 VSS VDD A2 B Y
*
* A1 A1
* VSS VSS
* VDD VDD
* A2 A2
* B B
* Y Y
*
*

M0 N_M0_d N_M0_g noxref_7 VSS nmos_rvt L=2e-08 W=8.1e-08 nfin=3 $X=0.071
+ $Y=0.027
M1 noxref_7 N_M1_g N_M1_s VSS nmos_rvt L=2e-08 W=8.1e-08 nfin=3 $X=0.125
+ $Y=0.027
M2 VSS N_M2_g noxref_7 VSS nmos_rvt L=2e-08 W=8.1e-08 nfin=3 $X=0.179 $Y=0.027
M3 N_M3_d N_M3_g VSS VSS nmos_rvt L=2e-08 W=8.1e-08 nfin=3 $X=0.233 $Y=0.027
M4 N_M4_d N_M4_g VSS VSS nmos_rvt L=2e-08 W=8.1e-08 nfin=3 $X=0.287 $Y=0.027
M5 noxref_9 N_M5_g VDD VDD pmos_rvt L=2e-08 W=8.1e-08 nfin=3 $X=0.071 $Y=0.162
M6 N_M6_d N_M6_g noxref_9 VDD pmos_rvt L=2e-08 W=8.1e-08 nfin=3 $X=0.125
+ $Y=0.162
M7 VDD N_M7_g N_M7_s VDD pmos_rvt L=2e-08 W=8.1e-08 nfin=3 $X=0.179 $Y=0.162
M8 N_M8_d N_M8_g VDD VDD pmos_rvt L=2e-08 W=8.1e-08 nfin=3 $X=0.233 $Y=0.162
M9 N_M9_d N_M9_g VDD VDD pmos_rvt L=2e-08 W=8.1e-08 nfin=3 $X=0.287 $Y=0.162

* .include "OA21x2_ASAP7_75t_R.pex.sp.pxi"

* Start of included file OA21x2_ASAP7_75t_R.pex.sp.pxi
x_PM_OA21x2_ASAP7_75t_R%A1 vss A1 N_M0_g N_M5_g N_A1_3 N_A1_1
+ PM_OA21x2_ASAP7_75t_R%A1
x_PM_OA21x2_ASAP7_75t_R%Y vss Y N_M3_d N_M4_d N_M8_d N_M9_d N_Y_7 N_Y_1 N_Y_2
+ N_Y_11 N_Y_12 N_Y_8 N_Y_13 PM_OA21x2_ASAP7_75t_R%Y
cc_1 N_Y_7 N_6_17 0.00282895f $X=0.2555 $Y=0.0675
cc_2 N_Y_7 N_6_1 0.000617396f $X=0.2555 $Y=0.0675
cc_3 N_Y_7 N_6_20 0.0026098f $X=0.2555 $Y=0.0675
cc_4 N_Y_7 N_6_9 0.000844838f $X=0.2555 $Y=0.0675
cc_5 N_Y_1 N_6_10 0.00248319f $X=0.27 $Y=0.0675
cc_6 N_Y_2 N_6_10 0.00249567f $X=0.27 $Y=0.2025
cc_7 N_Y_11 N_6_15 0.00381136f $X=0.2585 $Y=0.036
cc_8 N_Y_12 N_6_16 0.00400639f $X=0.324 $Y=0.234
cc_9 N_Y_8 N_6_1 0.00439546f $X=0.2555 $Y=0.2025
cc_10 N_Y_13 N_6_21 0.00544881f $X=0.351 $Y=0.054
cc_11 N_Y_8 N_6_10 0.0184949f $X=0.2555 $Y=0.2025
cc_12 N_Y_8 N_6_9 0.0470649f $X=0.2555 $Y=0.2025
cc_13 N_Y_7 N_6_10 0.0674941f $X=0.2555 $Y=0.0675
x_PM_OA21x2_ASAP7_75t_R%6 vss N_M3_g N_M8_g N_M4_g N_M9_g N_M0_d N_M1_s N_M6_d
+ N_M7_s N_6_3 N_6_11 N_6_12 N_6_4 N_6_18 N_6_17 N_6_21 N_6_1 N_6_13 N_6_20
+ N_6_9 N_6_10 N_6_15 N_6_16 PM_OA21x2_ASAP7_75t_R%6
cc_14 N_6_3 N_A1_3 0.00139805f $X=0.108 $Y=0.0675
cc_15 N_6_11 N_A1_1 0.000880756f $X=0.0935 $Y=0.0675
cc_16 N_6_11 N_A1_3 0.0352439f $X=0.0935 $Y=0.0675
cc_17 N_6_12 N_A2_3 0.015308f $X=0.1475 $Y=0.2025
cc_18 N_6_4 N_A2_3 0.00202092f $X=0.162 $Y=0.2025
cc_19 N_6_18 N_A2_3 0.000596372f $X=0.193 $Y=0.234
cc_20 N_6_3 N_A2_3 0.000860208f $X=0.108 $Y=0.0675
cc_21 N_6_17 N_A2_4 0.00121748f $X=0.272 $Y=0.072
cc_22 N_6_11 N_A2_1 0.00157009f $X=0.0935 $Y=0.0675
cc_23 N_6_4 N_A2_4 0.0028995f $X=0.162 $Y=0.2025
cc_24 N_6_11 N_A2_3 0.0545369f $X=0.0935 $Y=0.0675
cc_25 N_6_21 N_B_3 0.000455918f $X=0.297 $Y=0.1295
cc_26 N_6_4 N_B_3 0.00158421f $X=0.162 $Y=0.2025
cc_27 N_6_1 N_B_3 0.000663373f $X=0.243 $Y=0.135
cc_28 N_6_13 N_B_3 0.000899642f $X=0.215 $Y=0.1945
cc_29 N_6_20 N_B_6 0.000971343f $X=0.272 $Y=0.198
cc_30 N_6_12 N_B_1 0.00115883f $X=0.1475 $Y=0.2025
cc_31 N_6_9 N_B_3 0.00166074f $X=0.243 $Y=0.0245
cc_32 N_6_17 N_B_5 0.00295778f $X=0.272 $Y=0.072
cc_33 N_6_13 N_B_6 0.00352918f $X=0.215 $Y=0.1945
cc_34 N_6_12 N_B_3 0.0365417f $X=0.1475 $Y=0.2025
x_PM_OA21x2_ASAP7_75t_R%B vss B N_M2_g N_M7_g N_B_3 N_B_6 N_B_1 N_B_5
+ PM_OA21x2_ASAP7_75t_R%B
cc_35 N_B_3 N_A2_4 0.00194701f $X=0.189 $Y=0.0245
cc_36 N_B_3 N_A2_3 0.00583999f $X=0.189 $Y=0.0245
x_PM_OA21x2_ASAP7_75t_R%A2 vss A2 N_M1_g N_M6_g N_A2_1 N_A2_3 N_A2_4
+ PM_OA21x2_ASAP7_75t_R%A2
cc_37 N_A2_1 N_A1_3 0.00132597f $X=0.135 $Y=0.135
cc_38 N_A2_3 N_A1_3 0.00664739f $X=0.135 $Y=0.0245

* End of included file OA21x2_ASAP7_75t_R.pex.sp.pxi
.ends

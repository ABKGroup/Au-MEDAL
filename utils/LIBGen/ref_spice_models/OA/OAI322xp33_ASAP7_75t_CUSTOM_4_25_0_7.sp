.subckt PM_OAI322xp33_ASAP7_75t_R%B2 vss 13 5 11 3
c1 1 vss 0.00656551f $X=0.081 $Y=0.135
c2 3 vss 0.134191f $X=0.081 $Y=0.0245
c3 4 vss 0.0132214f $X=0.081 $Y=0.116
r1 13 4 4.4306 $w=1.3e-08 $l=1.9e-08 $layer=M1 $thickness=3.6e-08 $X=0.075
+ $Y=0.134 $X2=0.081 $Y2=0.116
r2 1 8 10.4265 $w=1.765e-08 $layer=LIG $thickness=5.2e-08 $X=0.081 $Y=0.135
+ $X2=0.081 $Y2=0.135
r3 13 1 19.3796 $a=3.24e-16 $layer=V0LIG $X=0.075 $Y=0.134 $X2=0.081 $Y2=0.135
r4 11 10 14.6259 $w=2.1e-08 $l=4.3e-08 $layer=Gate_1 $thickness=5.6e-08
+ $X=0.081 $Y=0.216 $X2=0.081 $Y2=0.173
r5 9 10 7.31297 $w=2.1e-08 $l=2.15e-08 $layer=Gate_1 $thickness=5.6e-08
+ $X=0.081 $Y=0.1515 $X2=0.081 $Y2=0.173
r6 8 9 5.79936 $w=2.03333e-08 $l=1.65e-08 $layer=Gate_1 $thickness=5.6e-08
+ $X=0.081 $Y=0.135 $X2=0.081 $Y2=0.1515
r7 7 8 5.79936 $w=2.03333e-08 $l=1.65e-08 $layer=Gate_1 $thickness=5.6e-08
+ $X=0.081 $Y=0.1185 $X2=0.081 $Y2=0.135
r8 6 7 2.7211 $w=2.1e-08 $l=8e-09 $layer=Gate_1 $thickness=5.6e-08 $X=0.081
+ $Y=0.1105 $X2=0.081 $Y2=0.1185
r9 5 6 14.6259 $w=2.1e-08 $l=4.3e-08 $layer=Gate_1 $thickness=5.6e-08 $X=0.081
+ $Y=0.0675 $X2=0.081 $Y2=0.1105
r10 5 3 14.6259 $w=2.1e-08 $l=4.3e-08 $layer=Gate_1 $thickness=5.6e-08 $X=0.081
+ $Y=0.0675 $X2=0.081 $Y2=0.0245
.ends

.subckt PM_OAI322xp33_ASAP7_75t_R%B1 vss 11 5 9 4 3
c1 1 vss 0.0120508f $X=0.135 $Y=0.135
c2 3 vss 0.103178f $X=0.135 $Y=0.0245
c3 4 vss 0.00838726f $X=0.135 $Y=0.116
r1 11 4 4.4306 $w=1.3e-08 $l=1.9e-08 $layer=M1 $thickness=3.6e-08 $X=0.131
+ $Y=0.134 $X2=0.135 $Y2=0.116
r2 1 7 10.4265 $w=1.765e-08 $layer=LIG $thickness=5.2e-08 $X=0.135 $Y=0.135
+ $X2=0.135 $Y2=0.135
r3 11 1 19.3796 $a=3.24e-16 $layer=V0LIG $X=0.131 $Y=0.134 $X2=0.135 $Y2=0.135
r4 9 8 16.4967 $w=2.1e-08 $l=4.85e-08 $layer=Gate_1 $thickness=5.6e-08 $X=0.135
+ $Y=0.216 $X2=0.135 $Y2=0.1675
r5 7 8 11.2416 $w=2.06615e-08 $l=3.25e-08 $layer=Gate_1 $thickness=5.6e-08
+ $X=0.135 $Y=0.135 $X2=0.135 $Y2=0.1675
r6 6 7 6.6497 $w=2.04211e-08 $l=1.9e-08 $layer=Gate_1 $thickness=5.6e-08
+ $X=0.135 $Y=0.116 $X2=0.135 $Y2=0.135
r7 5 6 16.4967 $w=2.1e-08 $l=4.85e-08 $layer=Gate_1 $thickness=5.6e-08 $X=0.135
+ $Y=0.0675 $X2=0.135 $Y2=0.116
r8 5 3 14.6259 $w=2.1e-08 $l=4.3e-08 $layer=Gate_1 $thickness=5.6e-08 $X=0.135
+ $Y=0.0675 $X2=0.135 $Y2=0.0245
.ends

.subckt PM_OAI322xp33_ASAP7_75t_R%A3 vss 12 5 9 4 3
c1 1 vss 0.00625711f $X=0.297 $Y=0.135
c2 3 vss 0.143171f $X=0.297 $Y=0.0245
c3 4 vss 0.00774479f $X=0.297 $Y=0.1055
r1 12 11 4.4306 $w=1.3e-08 $l=1.9e-08 $layer=M1 $thickness=3.6e-08 $X=0.296
+ $Y=0.136 $X2=0.297 $Y2=0.116
r2 4 11 2.44849 $w=1.3e-08 $l=1.05e-08 $layer=M1 $thickness=3.6e-08 $X=0.297
+ $Y=0.1055 $X2=0.297 $Y2=0.116
r3 1 7 10.4265 $w=1.765e-08 $layer=LIG $thickness=5.2e-08 $X=0.297 $Y=0.135
+ $X2=0.297 $Y2=0.135
r4 12 1 19.3796 $a=3.24e-16 $layer=V0LIG $X=0.296 $Y=0.136 $X2=0.297 $Y2=0.135
r5 9 8 16.4967 $w=2.1e-08 $l=4.85e-08 $layer=Gate_1 $thickness=5.6e-08 $X=0.297
+ $Y=0.2025 $X2=0.297 $Y2=0.154
r6 7 8 6.6497 $w=2.04211e-08 $l=1.9e-08 $layer=Gate_1 $thickness=5.6e-08
+ $X=0.297 $Y=0.135 $X2=0.297 $Y2=0.154
r7 6 7 6.6497 $w=2.04211e-08 $l=1.9e-08 $layer=Gate_1 $thickness=5.6e-08
+ $X=0.297 $Y=0.116 $X2=0.297 $Y2=0.135
r8 5 6 16.4967 $w=2.1e-08 $l=4.85e-08 $layer=Gate_1 $thickness=5.6e-08 $X=0.297
+ $Y=0.0675 $X2=0.297 $Y2=0.116
r9 5 3 14.6259 $w=2.1e-08 $l=4.3e-08 $layer=Gate_1 $thickness=5.6e-08 $X=0.297
+ $Y=0.0675 $X2=0.297 $Y2=0.0245
.ends

.subckt PM_OAI322xp33_ASAP7_75t_R%C2 vss 12 5 9 3 4
c1 1 vss 0.00862282f $X=0.351 $Y=0.135
c2 3 vss 0.114003f $X=0.351 $Y=0.0245
c3 4 vss 0.00553395f $X=0.351 $Y=0.1055
r1 12 11 4.4306 $w=1.3e-08 $l=1.9e-08 $layer=M1 $thickness=3.6e-08 $X=0.348
+ $Y=0.134 $X2=0.351 $Y2=0.116
r2 4 11 2.44849 $w=1.3e-08 $l=1.05e-08 $layer=M1 $thickness=3.6e-08 $X=0.351
+ $Y=0.1055 $X2=0.351 $Y2=0.116
r3 1 7 10.4265 $w=1.765e-08 $layer=LIG $thickness=5.2e-08 $X=0.351 $Y=0.135
+ $X2=0.351 $Y2=0.135
r4 12 1 19.3796 $a=3.24e-16 $layer=V0LIG $X=0.348 $Y=0.134 $X2=0.351 $Y2=0.135
r5 9 8 16.4967 $w=2.1e-08 $l=4.85e-08 $layer=Gate_1 $thickness=5.6e-08 $X=0.351
+ $Y=0.216 $X2=0.351 $Y2=0.1675
r6 7 8 11.2416 $w=2.06615e-08 $l=3.25e-08 $layer=Gate_1 $thickness=5.6e-08
+ $X=0.351 $Y=0.135 $X2=0.351 $Y2=0.1675
r7 6 7 6.6497 $w=2.04211e-08 $l=1.9e-08 $layer=Gate_1 $thickness=5.6e-08
+ $X=0.351 $Y=0.116 $X2=0.351 $Y2=0.135
r8 5 6 16.4967 $w=2.1e-08 $l=4.85e-08 $layer=Gate_1 $thickness=5.6e-08 $X=0.351
+ $Y=0.0675 $X2=0.351 $Y2=0.116
r9 5 3 14.6259 $w=2.1e-08 $l=4.3e-08 $layer=Gate_1 $thickness=5.6e-08 $X=0.351
+ $Y=0.0675 $X2=0.351 $Y2=0.0245
.ends

.subckt PM_OAI322xp33_ASAP7_75t_R%C1 vss 13 5 11 4 3 1
c1 1 vss 0.0107436f $X=0.405 $Y=0.135
c2 3 vss 0.0687953f $X=0.405 $Y=0.0245
c3 4 vss 0.00550589f $X=0.405 $Y=0.116
r1 13 4 4.4306 $w=1.3e-08 $l=1.9e-08 $layer=M1 $thickness=3.6e-08 $X=0.405
+ $Y=0.134 $X2=0.405 $Y2=0.116
r2 1 8 10.4265 $w=1.765e-08 $layer=LIG $thickness=5.2e-08 $X=0.405 $Y=0.135
+ $X2=0.405 $Y2=0.135
r3 13 1 19.3796 $a=3.24e-16 $layer=V0LIG $X=0.405 $Y=0.134 $X2=0.405 $Y2=0.135
r4 11 10 14.6259 $w=2.1e-08 $l=4.3e-08 $layer=Gate_1 $thickness=5.6e-08
+ $X=0.405 $Y=0.216 $X2=0.405 $Y2=0.173
r5 9 10 7.31297 $w=2.1e-08 $l=2.15e-08 $layer=Gate_1 $thickness=5.6e-08
+ $X=0.405 $Y=0.1515 $X2=0.405 $Y2=0.173
r6 8 9 5.79936 $w=2.03333e-08 $l=1.65e-08 $layer=Gate_1 $thickness=5.6e-08
+ $X=0.405 $Y=0.135 $X2=0.405 $Y2=0.1515
r7 7 8 5.79936 $w=2.03333e-08 $l=1.65e-08 $layer=Gate_1 $thickness=5.6e-08
+ $X=0.405 $Y=0.1185 $X2=0.405 $Y2=0.135
r8 6 7 2.7211 $w=2.1e-08 $l=8e-09 $layer=Gate_1 $thickness=5.6e-08 $X=0.405
+ $Y=0.1105 $X2=0.405 $Y2=0.1185
r9 5 6 14.6259 $w=2.1e-08 $l=4.3e-08 $layer=Gate_1 $thickness=5.6e-08 $X=0.405
+ $Y=0.0675 $X2=0.405 $Y2=0.1105
r10 5 3 14.6259 $w=2.1e-08 $l=4.3e-08 $layer=Gate_1 $thickness=5.6e-08 $X=0.405
+ $Y=0.0675 $X2=0.405 $Y2=0.0245
.ends

.subckt PM_OAI322xp33_ASAP7_75t_R%Y vss 42 22 23 51 53 56 1 13 11 17 18 2 10 3
+ 14 19
c1 1 vss 0.00546311f $X=0.162 $Y=0.216
c2 2 vss 0.00905282f $X=0.378 $Y=0.0675
c3 3 vss 0.00563212f $X=0.432 $Y=0.216
c4 10 vss 0.00423899f $X=0.3635 $Y=0.0675
c5 11 vss 0.00196243f $X=0.1475 $Y=0.1975
c6 12 vss 0.000118017f $X=0.1475 $Y=0.2245
c7 13 vss 0.000260731f $X=0.164 $Y=0.1755
c8 14 vss 0.0251695f $X=0.4175 $Y=0.216
c9 15 vss 0.00221186f $X=0.459 $Y=0.072
c10 16 vss 0.00246465f $X=0.459 $Y=0.234
c11 17 vss 0.0254124f $X=0.4185 $Y=0.234
c12 18 vss 0.00749977f $X=0.3665 $Y=0.072
c13 19 vss 0.00435098f $X=0.459 $Y=0.093
r1 13 1 0.958606 $w=2.2e-08 $l=2.2e-08 $layer=P_src_drn $thickness=1e-09
+ $X=0.164 $Y=0.1755 $X2=0.162 $Y2=0.216
r2 12 1 0.391892 $w=3.7e-08 $l=1.45e-08 $layer=P_src_drn $thickness=1e-09
+ $X=0.1475 $Y=0.2245 $X2=0.162 $Y2=0.216
r3 56 55 0.147059 $w=1.7e-08 $l=2.5e-09 $layer=P_src_drn $thickness=1e-09
+ $X=0.1793 $Y=0.2025 $X2=0.1765 $Y2=0.1975
r4 1 55 0.735294 $w=1.7e-08 $l=1.25e-08 $layer=P_src_drn $thickness=1e-09
+ $X=0.162 $Y=0.216 $X2=0.1765 $Y2=0.1975
r5 52 1 0.705882 $w=1.7e-08 $l=1.2e-08 $layer=P_src_drn $thickness=1e-09
+ $X=0.152 $Y=0.1975 $X2=0.162 $Y2=0.216
r6 11 52 0.264706 $w=1.7e-08 $l=4.5e-09 $layer=P_src_drn $thickness=1e-09
+ $X=0.1475 $Y=0.1975 $X2=0.152 $Y2=0.1975
r7 53 11 0.147059 $w=1.7e-08 $l=2.5e-09 $layer=P_src_drn $thickness=1e-09
+ $X=0.1446 $Y=0.216 $X2=0.1475 $Y2=0.1975
r8 14 3 0.231482 $w=5.4e-08 $l=1.25e-08 $layer=P_src_drn $thickness=1e-09
+ $X=0.4175 $Y=0.216 $X2=0.432 $Y2=0.216
r9 51 14 0.0462963 $w=5.4e-08 $l=2.5e-09 $layer=P_src_drn $thickness=1e-09
+ $X=0.4146 $Y=0.216 $X2=0.4175 $Y2=0.216
r10 1 47 19.3796 $a=3.24e-16 $layer=V0LISD $X=0.162 $Y=0.216 $X2=0.162 $Y2=0.234
r11 3 31 19.3796 $a=3.24e-16 $layer=V0LISD $X=0.432 $Y=0.216 $X2=0.432 $Y2=0.234
r12 47 48 3.14806 $w=1.3e-08 $l=1.35e-08 $layer=M1 $thickness=3.6e-08 $X=0.162
+ $Y=0.234 $X2=0.1755 $Y2=0.234
r13 45 48 3.14806 $w=1.3e-08 $l=1.35e-08 $layer=M1 $thickness=3.6e-08 $X=0.189
+ $Y=0.234 $X2=0.1755 $Y2=0.234
r14 44 45 6.29612 $w=1.3e-08 $l=2.7e-08 $layer=M1 $thickness=3.6e-08 $X=0.216
+ $Y=0.234 $X2=0.189 $Y2=0.234
r15 42 43 0.524677 $w=1.3e-08 $l=2.2e-09 $layer=M1 $thickness=3.6e-08 $X=0.248
+ $Y=0.232 $X2=0.2502 $Y2=0.234
r16 42 41 1.69063 $w=1.3e-08 $l=7.3e-09 $layer=M1 $thickness=3.6e-08 $X=0.248
+ $Y=0.232 $X2=0.2407 $Y2=0.234
r17 41 44 5.77145 $w=1.3e-08 $l=2.47e-08 $layer=M1 $thickness=3.6e-08 $X=0.2407
+ $Y=0.234 $X2=0.216 $Y2=0.234
r18 40 43 4.13912 $w=1.3e-08 $l=1.78e-08 $layer=M1 $thickness=3.6e-08 $X=0.268
+ $Y=0.234 $X2=0.2502 $Y2=0.234
r19 39 40 4.19742 $w=1.3e-08 $l=1.8e-08 $layer=M1 $thickness=3.6e-08 $X=0.286
+ $Y=0.234 $X2=0.268 $Y2=0.234
r20 38 39 2.56509 $w=1.3e-08 $l=1.1e-08 $layer=M1 $thickness=3.6e-08 $X=0.297
+ $Y=0.234 $X2=0.286 $Y2=0.234
r21 37 38 6.29612 $w=1.3e-08 $l=2.7e-08 $layer=M1 $thickness=3.6e-08 $X=0.324
+ $Y=0.234 $X2=0.297 $Y2=0.234
r22 36 37 6.29612 $w=1.3e-08 $l=2.7e-08 $layer=M1 $thickness=3.6e-08 $X=0.351
+ $Y=0.234 $X2=0.324 $Y2=0.234
r23 35 36 2.56509 $w=1.3e-08 $l=1.1e-08 $layer=M1 $thickness=3.6e-08 $X=0.362
+ $Y=0.234 $X2=0.351 $Y2=0.234
r24 34 35 4.19742 $w=1.3e-08 $l=1.8e-08 $layer=M1 $thickness=3.6e-08 $X=0.38
+ $Y=0.234 $X2=0.362 $Y2=0.234
r25 33 34 5.82974 $w=1.3e-08 $l=2.5e-08 $layer=M1 $thickness=3.6e-08 $X=0.405
+ $Y=0.234 $X2=0.38 $Y2=0.234
r26 31 32 3.14806 $w=1.3e-08 $l=1.35e-08 $layer=M1 $thickness=3.6e-08 $X=0.432
+ $Y=0.234 $X2=0.4455 $Y2=0.234
r27 17 31 3.14806 $w=1.3e-08 $l=1.35e-08 $layer=M1 $thickness=3.6e-08 $X=0.4185
+ $Y=0.234 $X2=0.432 $Y2=0.234
r28 17 33 3.14806 $w=1.3e-08 $l=1.35e-08 $layer=M1 $thickness=3.6e-08 $X=0.4185
+ $Y=0.234 $X2=0.405 $Y2=0.234
r29 16 30 3.36447 $w=1.71023e-08 $l=2.15e-08 $layer=M1 $thickness=3.6e-08
+ $X=0.459 $Y=0.234 $X2=0.459 $Y2=0.2125
r30 16 32 1.49895 $w=1.63333e-08 $l=1.35e-08 $layer=M1 $thickness=3.6e-08
+ $X=0.459 $Y=0.234 $X2=0.4455 $Y2=0.234
r31 29 30 13.8748 $w=1.3e-08 $l=5.95e-08 $layer=M1 $thickness=3.6e-08 $X=0.459
+ $Y=0.153 $X2=0.459 $Y2=0.2125
r32 28 29 11.0765 $w=1.3e-08 $l=4.75e-08 $layer=M1 $thickness=3.6e-08 $X=0.459
+ $Y=0.1055 $X2=0.459 $Y2=0.153
r33 19 28 2.91487 $w=1.3e-08 $l=1.25e-08 $layer=M1 $thickness=3.6e-08 $X=0.459
+ $Y=0.093 $X2=0.459 $Y2=0.1055
r34 15 27 4.64701 $w=1.46667e-08 $l=2.7e-08 $layer=M1 $thickness=3.6e-08
+ $X=0.459 $Y=0.072 $X2=0.432 $Y2=0.072
r35 15 19 3.24787 $w=1.72e-08 $l=2.1e-08 $layer=M1 $thickness=3.6e-08 $X=0.459
+ $Y=0.072 $X2=0.459 $Y2=0.093
r36 26 27 6.29612 $w=1.3e-08 $l=2.7e-08 $layer=M1 $thickness=3.6e-08 $X=0.405
+ $Y=0.072 $X2=0.432 $Y2=0.072
r37 25 26 3.14806 $w=1.3e-08 $l=1.35e-08 $layer=M1 $thickness=3.6e-08 $X=0.3915
+ $Y=0.072 $X2=0.405 $Y2=0.072
r38 24 25 3.14806 $w=1.3e-08 $l=1.35e-08 $layer=M1 $thickness=3.6e-08 $X=0.378
+ $Y=0.072 $X2=0.3915 $Y2=0.072
r39 18 24 2.68168 $w=1.3e-08 $l=1.15e-08 $layer=M1 $thickness=3.6e-08 $X=0.3665
+ $Y=0.072 $X2=0.378 $Y2=0.072
r40 2 24 19.3796 $a=3.24e-16 $layer=V0LISD $X=0.378 $Y=0.0675 $X2=0.378
+ $Y2=0.072
r41 23 21 0.0308642 $w=8.1e-08 $l=2.5e-09 $layer=N_src_drn $thickness=1e-09
+ $X=0.3953 $Y=0.0675 $X2=0.3925 $Y2=0.0675
r42 2 21 0.179012 $w=8.1e-08 $l=1.45e-08 $layer=N_src_drn $thickness=1e-09
+ $X=0.378 $Y=0.0675 $X2=0.3925 $Y2=0.0675
r43 10 2 0.179012 $w=8.1e-08 $l=1.45e-08 $layer=N_src_drn $thickness=1e-09
+ $X=0.3635 $Y=0.0675 $X2=0.378 $Y2=0.0675
r44 22 10 0.0308642 $w=8.1e-08 $l=2.5e-09 $layer=N_src_drn $thickness=1e-09
+ $X=0.3606 $Y=0.0675 $X2=0.3635 $Y2=0.0675
r45 1 13 1e-05 $l=4.05494e-08 $X=0.162 $Y=0.216 $X2=0.164 $Y2=0.1755
.ends

.subckt PM_OAI322xp33_ASAP7_75t_R%A1 vss 11 5 9 3 4
c1 1 vss 0.0191218f $X=0.189 $Y=0.135
c2 3 vss 0.0799484f $X=0.189 $Y=0.0245
c3 4 vss 0.0118765f $X=0.189 $Y=0.116
r1 11 4 4.4306 $w=1.3e-08 $l=1.9e-08 $layer=M1 $thickness=3.6e-08 $X=0.187
+ $Y=0.136 $X2=0.189 $Y2=0.116
r2 1 7 10.4265 $w=1.765e-08 $layer=LIG $thickness=5.2e-08 $X=0.189 $Y=0.135
+ $X2=0.189 $Y2=0.135
r3 11 1 19.3796 $a=3.24e-16 $layer=V0LIG $X=0.187 $Y=0.136 $X2=0.189 $Y2=0.135
r4 9 8 16.4967 $w=2.1e-08 $l=4.85e-08 $layer=Gate_1 $thickness=5.6e-08 $X=0.189
+ $Y=0.2025 $X2=0.189 $Y2=0.154
r5 7 8 6.6497 $w=2.04211e-08 $l=1.9e-08 $layer=Gate_1 $thickness=5.6e-08
+ $X=0.189 $Y=0.135 $X2=0.189 $Y2=0.154
r6 6 7 6.6497 $w=2.04211e-08 $l=1.9e-08 $layer=Gate_1 $thickness=5.6e-08
+ $X=0.189 $Y=0.116 $X2=0.189 $Y2=0.135
r7 5 6 16.4967 $w=2.1e-08 $l=4.85e-08 $layer=Gate_1 $thickness=5.6e-08 $X=0.189
+ $Y=0.0675 $X2=0.189 $Y2=0.116
r8 5 3 14.6259 $w=2.1e-08 $l=4.3e-08 $layer=Gate_1 $thickness=5.6e-08 $X=0.189
+ $Y=0.0675 $X2=0.189 $Y2=0.0245
.ends

.subckt PM_OAI322xp33_ASAP7_75t_R%A2 vss 11 5 9 4 3
c1 1 vss 0.00451817f $X=0.243 $Y=0.135
c2 3 vss 0.115205f $X=0.243 $Y=0.0245
c3 4 vss 0.00423007f $X=0.243 $Y=0.116
r1 11 4 4.4306 $w=1.3e-08 $l=1.9e-08 $layer=M1 $thickness=3.6e-08 $X=0.247
+ $Y=0.136 $X2=0.243 $Y2=0.116
r2 1 7 10.4265 $w=1.765e-08 $layer=LIG $thickness=5.2e-08 $X=0.243 $Y=0.135
+ $X2=0.243 $Y2=0.135
r3 11 1 19.3796 $a=3.24e-16 $layer=V0LIG $X=0.247 $Y=0.136 $X2=0.243 $Y2=0.135
r4 9 8 16.4967 $w=2.1e-08 $l=4.85e-08 $layer=Gate_1 $thickness=5.6e-08 $X=0.243
+ $Y=0.2025 $X2=0.243 $Y2=0.154
r5 7 8 6.6497 $w=2.04211e-08 $l=1.9e-08 $layer=Gate_1 $thickness=5.6e-08
+ $X=0.243 $Y=0.135 $X2=0.243 $Y2=0.154
r6 6 7 6.6497 $w=2.04211e-08 $l=1.9e-08 $layer=Gate_1 $thickness=5.6e-08
+ $X=0.243 $Y=0.116 $X2=0.243 $Y2=0.135
r7 5 6 16.4967 $w=2.1e-08 $l=4.85e-08 $layer=Gate_1 $thickness=5.6e-08 $X=0.243
+ $Y=0.0675 $X2=0.243 $Y2=0.116
r8 5 3 14.6259 $w=2.1e-08 $l=4.3e-08 $layer=Gate_1 $thickness=5.6e-08 $X=0.243
+ $Y=0.0675 $X2=0.243 $Y2=0.0245
.ends

* End of included file OAI322xp33_ASAP7_75t_R.pex.sp.pex

*
.subckt OAI322xp33_ASAP7_75t_CUSTOM_4_25_0_7 VSS VDD B2 B1 A1 A2 A3 C2 C1 Y
*
* VSS VSS
* VDD VDD
* B2 B2
* B1 B1
* A1 A1
* A2 A2
* A3 A3
* C2 C2
* C1 C1
* Y Y
*
*

M0 VSS N_M0_g noxref_10 VSS nmos_rvt L=2e-08 W=8.1e-08 nfin=3 $X=0.071 $Y=0.027
M1 noxref_10 N_M1_g VSS VSS nmos_rvt L=2e-08 W=8.1e-08 nfin=3 $X=0.125 $Y=0.027
M2 noxref_11 N_M2_g noxref_10 VSS nmos_rvt L=2e-08 W=8.1e-08 nfin=3 $X=0.179
+ $Y=0.027
M3 noxref_10 N_M3_g noxref_11 VSS nmos_rvt L=2e-08 W=8.1e-08 nfin=3 $X=0.233
+ $Y=0.027
M4 noxref_11 N_M4_g noxref_10 VSS nmos_rvt L=2e-08 W=8.1e-08 nfin=3 $X=0.287
+ $Y=0.027
M5 N_M5_d N_M5_g noxref_11 VSS nmos_rvt L=2e-08 W=8.1e-08 nfin=3 $X=0.341
+ $Y=0.027
M6 noxref_11 N_M6_g N_M6_s VSS nmos_rvt L=2e-08 W=8.1e-08 nfin=3 $X=0.395
+ $Y=0.027
M7 noxref_13 N_M7_g VDD VDD pmos_rvt L=2e-08 W=5.4e-08 nfin=2 $X=0.071 $Y=0.189
M8 N_M8_d N_M8_g noxref_13 VDD pmos_rvt L=2e-08 W=5.4e-08 nfin=2 $X=0.125
+ $Y=0.189
M9 noxref_14 N_M9_g N_M9_s VDD pmos_rvt L=2e-08 W=8.1e-08 nfin=3 $X=0.179
+ $Y=0.162
M10 noxref_15 N_M10_g noxref_14 VDD pmos_rvt L=2e-08 W=8.1e-08 nfin=3 $X=0.233
+ $Y=0.162
M11 VDD N_M11_g noxref_15 VDD pmos_rvt L=2e-08 W=8.1e-08 nfin=3 $X=0.287
+ $Y=0.162
M12 noxref_16 N_M12_g VDD VDD pmos_rvt L=2e-08 W=5.4e-08 nfin=2 $X=0.341
+ $Y=0.189
M13 N_M13_d N_M13_g noxref_16 VDD pmos_rvt L=2e-08 W=5.4e-08 nfin=2 $X=0.395
+ $Y=0.189

* .include "OAI322xp33_ASAP7_75t_R.pex.sp.pxi"

* Start of included file OAI322xp33_ASAP7_75t_R.pex.sp.pxi
x_PM_OAI322xp33_ASAP7_75t_R%B2 vss B2 N_M0_g N_M7_g N_B2_3
+ PM_OAI322xp33_ASAP7_75t_R%B2
x_PM_OAI322xp33_ASAP7_75t_R%B1 vss B1 N_M1_g N_M8_g N_B1_4 N_B1_3
+ PM_OAI322xp33_ASAP7_75t_R%B1
cc_1 N_B1_4 N_B2_3 0.00386443f $X=0.135 $Y=0.116
cc_2 N_B1_3 N_B2_3 0.00865858f $X=0.135 $Y=0.0245
x_PM_OAI322xp33_ASAP7_75t_R%A3 vss A3 N_M4_g N_M11_g N_A3_4 N_A3_3
+ PM_OAI322xp33_ASAP7_75t_R%A3
cc_3 N_A3_4 N_A2_4 0.00322785f $X=0.297 $Y=0.1055
cc_4 N_A3_3 N_A2_3 0.0107732f $X=0.297 $Y=0.0245
x_PM_OAI322xp33_ASAP7_75t_R%C2 vss C2 N_M5_g N_M12_g N_C2_3 N_C2_4
+ PM_OAI322xp33_ASAP7_75t_R%C2
cc_5 N_C2_3 N_A3_3 0.00303304f $X=0.351 $Y=0.0245
cc_6 N_C2_4 N_A3_4 0.00509844f $X=0.351 $Y=0.1055
x_PM_OAI322xp33_ASAP7_75t_R%C1 vss C1 N_M6_g N_M13_g N_C1_4 N_C1_3 N_C1_1
+ PM_OAI322xp33_ASAP7_75t_R%C1
cc_7 N_C1_4 N_C2_4 0.00334394f $X=0.405 $Y=0.116
cc_8 N_C1_3 N_C2_3 0.00848996f $X=0.405 $Y=0.0245
x_PM_OAI322xp33_ASAP7_75t_R%Y vss Y N_M5_d N_M6_s N_M13_d N_M8_d N_M9_s N_Y_1
+ N_Y_13 N_Y_11 N_Y_17 N_Y_18 N_Y_2 N_Y_10 N_Y_3 N_Y_14 N_Y_19
+ PM_OAI322xp33_ASAP7_75t_R%Y
cc_9 N_Y_1 N_B1_4 0.00109829f $X=0.162 $Y=0.216
cc_10 N_Y_1 N_B1_3 0.0012817f $X=0.162 $Y=0.216
cc_11 N_Y_13 N_B1_3 0.00463157f $X=0.164 $Y=0.1755
cc_12 N_Y_11 N_B1_3 0.0355589f $X=0.1475 $Y=0.1975
cc_13 N_Y_17 N_A1_3 0.00106498f $X=0.4185 $Y=0.234
cc_14 N_Y_1 N_A1_3 0.00122691f $X=0.162 $Y=0.216
cc_15 N_Y_1 N_A1_4 0.00159093f $X=0.162 $Y=0.216
cc_16 N_Y_11 N_A1_3 0.00894915f $X=0.1475 $Y=0.1975
cc_17 N_Y_13 N_A1_3 0.0364173f $X=0.164 $Y=0.1755
cc_18 N_Y_17 N_A2_4 0.00320183f $X=0.4185 $Y=0.234
cc_19 N_Y_17 N_A3_4 0.0027848f $X=0.4185 $Y=0.234
cc_20 N_Y_18 N_C2_3 0.00047324f $X=0.3665 $Y=0.072
cc_21 N_Y_2 N_C2_3 0.0007357f $X=0.378 $Y=0.0675
cc_22 N_Y_17 N_C2_4 0.0011641f $X=0.4185 $Y=0.234
cc_23 N_Y_2 N_C2_4 0.00197742f $X=0.378 $Y=0.0675
cc_24 N_Y_10 N_C2_3 0.0339026f $X=0.3635 $Y=0.0675
cc_25 N_Y_2 N_C1_3 0.00144607f $X=0.378 $Y=0.0675
cc_26 N_Y_3 N_C1_3 0.000834606f $X=0.432 $Y=0.216
cc_27 N_Y_18 N_C1_4 0.00087722f $X=0.3665 $Y=0.072
cc_28 N_Y_17 N_C1_4 0.00102548f $X=0.4185 $Y=0.234
cc_29 N_Y_10 N_C1_1 0.00115545f $X=0.3635 $Y=0.0675
cc_30 N_Y_14 N_C1_3 0.00992252f $X=0.4175 $Y=0.216
cc_31 N_Y_19 N_C1_4 0.00599754f $X=0.459 $Y=0.093
cc_32 N_Y_10 N_C1_3 0.0462344f $X=0.3635 $Y=0.0675
x_PM_OAI322xp33_ASAP7_75t_R%A1 vss A1 N_M2_g N_M9_g N_A1_3 N_A1_4
+ PM_OAI322xp33_ASAP7_75t_R%A1
cc_33 N_A1_3 N_B1_3 0.00302274f $X=0.189 $Y=0.0245
cc_34 N_A1_4 N_B1_4 0.00498773f $X=0.189 $Y=0.116
x_PM_OAI322xp33_ASAP7_75t_R%A2 vss A2 N_M3_g N_M10_g N_A2_4 N_A2_3
+ PM_OAI322xp33_ASAP7_75t_R%A2
cc_35 N_A2_4 N_A1_4 0.00318262f $X=0.243 $Y=0.116
cc_36 N_A2_3 N_A1_3 0.0109099f $X=0.243 $Y=0.0245

* End of included file OAI322xp33_ASAP7_75t_R.pex.sp.pxi
.ends

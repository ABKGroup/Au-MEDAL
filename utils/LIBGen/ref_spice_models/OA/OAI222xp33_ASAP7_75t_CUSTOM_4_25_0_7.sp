.subckt PM_OAI222xp33_ASAP7_75t_R%B2 vss 13 5 9 3 4
c1 1 vss 0.00580724f $X=0.189 $Y=0.135
c2 3 vss 0.140145f $X=0.189 $Y=0.0245
c3 4 vss 0.00502822f $X=0.189 $Y=0.116
r1 13 12 3.32295 $w=1.3e-08 $l=1.43e-08 $layer=M1 $thickness=3.6e-08 $X=0.189
+ $Y=0.172 $X2=0.189 $Y2=0.1577
r2 11 12 5.30507 $w=1.3e-08 $l=2.27e-08 $layer=M1 $thickness=3.6e-08 $X=0.189
+ $Y=0.135 $X2=0.189 $Y2=0.1577
r3 4 11 4.4306 $w=1.3e-08 $l=1.9e-08 $layer=M1 $thickness=3.6e-08 $X=0.189
+ $Y=0.116 $X2=0.189 $Y2=0.135
r4 1 7 10.4265 $w=1.765e-08 $layer=LIG $thickness=5.2e-08 $X=0.189 $Y=0.135
+ $X2=0.189 $Y2=0.135
r5 1 11 19.3796 $a=3.24e-16 $layer=V0LIG $X=0.189 $Y=0.135 $X2=0.189 $Y2=0.135
r6 9 8 16.4967 $w=2.1e-08 $l=4.85e-08 $layer=Gate_1 $thickness=5.6e-08 $X=0.189
+ $Y=0.2025 $X2=0.189 $Y2=0.154
r7 7 8 6.6497 $w=2.04211e-08 $l=1.9e-08 $layer=Gate_1 $thickness=5.6e-08
+ $X=0.189 $Y=0.135 $X2=0.189 $Y2=0.154
r8 6 7 6.6497 $w=2.04211e-08 $l=1.9e-08 $layer=Gate_1 $thickness=5.6e-08
+ $X=0.189 $Y=0.116 $X2=0.189 $Y2=0.135
r9 5 6 16.4967 $w=2.1e-08 $l=4.85e-08 $layer=Gate_1 $thickness=5.6e-08 $X=0.189
+ $Y=0.0675 $X2=0.189 $Y2=0.116
r10 5 3 14.6259 $w=2.1e-08 $l=4.3e-08 $layer=Gate_1 $thickness=5.6e-08 $X=0.189
+ $Y=0.0675 $X2=0.189 $Y2=0.0245
.ends

.subckt PM_OAI222xp33_ASAP7_75t_R%C1 vss 13 5 11 4 3
c1 1 vss 0.00502022f $X=0.405 $Y=0.135
c2 3 vss 0.10549f $X=0.405 $Y=0.0245
c3 4 vss 0.0101379f $X=0.405 $Y=0.0872
r1 16 17 4.4306 $w=1.3e-08 $l=1.9e-08 $layer=M1 $thickness=3.6e-08 $X=0.405
+ $Y=0.116 $X2=0.405 $Y2=0.135
r2 14 16 3.67274 $w=1.3e-08 $l=1.58e-08 $layer=M1 $thickness=3.6e-08 $X=0.405
+ $Y=0.1002 $X2=0.405 $Y2=0.116
r3 13 14 1.45744 $w=1.3e-08 $l=6.2e-09 $layer=M1 $thickness=3.6e-08 $X=0.405
+ $Y=0.094 $X2=0.405 $Y2=0.1002
r4 13 4 1.57403 $w=1.3e-08 $l=6.8e-09 $layer=M1 $thickness=3.6e-08 $X=0.405
+ $Y=0.094 $X2=0.405 $Y2=0.0872
r5 1 8 10.4265 $w=1.765e-08 $layer=LIG $thickness=5.2e-08 $X=0.405 $Y=0.135
+ $X2=0.405 $Y2=0.135
r6 1 17 19.3796 $a=3.24e-16 $layer=V0LIG $X=0.405 $Y=0.135 $X2=0.405 $Y2=0.135
r7 11 10 14.6259 $w=2.1e-08 $l=4.3e-08 $layer=Gate_1 $thickness=5.6e-08
+ $X=0.405 $Y=0.2025 $X2=0.405 $Y2=0.1595
r8 9 10 2.7211 $w=2.1e-08 $l=8e-09 $layer=Gate_1 $thickness=5.6e-08 $X=0.405
+ $Y=0.1515 $X2=0.405 $Y2=0.1595
r9 8 9 5.79936 $w=2.03333e-08 $l=1.65e-08 $layer=Gate_1 $thickness=5.6e-08
+ $X=0.405 $Y=0.135 $X2=0.405 $Y2=0.1515
r10 7 8 5.79936 $w=2.03333e-08 $l=1.65e-08 $layer=Gate_1 $thickness=5.6e-08
+ $X=0.405 $Y=0.1185 $X2=0.405 $Y2=0.135
r11 6 7 2.7211 $w=2.1e-08 $l=8e-09 $layer=Gate_1 $thickness=5.6e-08 $X=0.405
+ $Y=0.1105 $X2=0.405 $Y2=0.1185
r12 5 6 14.6259 $w=2.1e-08 $l=4.3e-08 $layer=Gate_1 $thickness=5.6e-08 $X=0.405
+ $Y=0.0675 $X2=0.405 $Y2=0.1105
r13 5 3 14.6259 $w=2.1e-08 $l=4.3e-08 $layer=Gate_1 $thickness=5.6e-08 $X=0.405
+ $Y=0.0675 $X2=0.405 $Y2=0.0245
.ends

.subckt PM_OAI222xp33_ASAP7_75t_R%B1 vss 13 5 11 4 3
c1 1 vss 0.00537131f $X=0.243 $Y=0.135
c2 3 vss 0.105538f $X=0.243 $Y=0.0245
c3 4 vss 0.00740299f $X=0.243 $Y=0.1102
r1 14 15 3.32295 $w=1.3e-08 $l=1.43e-08 $layer=M1 $thickness=3.6e-08 $X=0.243
+ $Y=0.1207 $X2=0.243 $Y2=0.135
r2 13 14 1.34084 $w=1.3e-08 $l=5.7e-09 $layer=M1 $thickness=3.6e-08 $X=0.243
+ $Y=0.115 $X2=0.243 $Y2=0.1207
r3 13 4 1.10765 $w=1.3e-08 $l=4.8e-09 $layer=M1 $thickness=3.6e-08 $X=0.243
+ $Y=0.115 $X2=0.243 $Y2=0.1102
r4 1 8 10.4265 $w=1.765e-08 $layer=LIG $thickness=5.2e-08 $X=0.243 $Y=0.135
+ $X2=0.243 $Y2=0.135
r5 1 15 19.3796 $a=3.24e-16 $layer=V0LIG $X=0.243 $Y=0.135 $X2=0.243 $Y2=0.135
r6 11 10 14.6259 $w=2.1e-08 $l=4.3e-08 $layer=Gate_1 $thickness=5.6e-08
+ $X=0.243 $Y=0.2025 $X2=0.243 $Y2=0.1595
r7 9 10 2.7211 $w=2.1e-08 $l=8e-09 $layer=Gate_1 $thickness=5.6e-08 $X=0.243
+ $Y=0.1515 $X2=0.243 $Y2=0.1595
r8 8 9 5.79936 $w=2.03333e-08 $l=1.65e-08 $layer=Gate_1 $thickness=5.6e-08
+ $X=0.243 $Y=0.135 $X2=0.243 $Y2=0.1515
r9 7 8 5.79936 $w=2.03333e-08 $l=1.65e-08 $layer=Gate_1 $thickness=5.6e-08
+ $X=0.243 $Y=0.1185 $X2=0.243 $Y2=0.135
r10 6 7 2.7211 $w=2.1e-08 $l=8e-09 $layer=Gate_1 $thickness=5.6e-08 $X=0.243
+ $Y=0.1105 $X2=0.243 $Y2=0.1185
r11 5 6 14.6259 $w=2.1e-08 $l=4.3e-08 $layer=Gate_1 $thickness=5.6e-08 $X=0.243
+ $Y=0.0675 $X2=0.243 $Y2=0.1105
r12 5 3 14.6259 $w=2.1e-08 $l=4.3e-08 $layer=Gate_1 $thickness=5.6e-08 $X=0.243
+ $Y=0.0675 $X2=0.243 $Y2=0.0245
.ends

.subckt PM_OAI222xp33_ASAP7_75t_R%C2 vss 15 5 11 4 3
c1 1 vss 0.00635067f $X=0.459 $Y=0.135
c2 3 vss 0.142595f $X=0.459 $Y=0.0245
c3 4 vss 0.00745823f $X=0.459 $Y=0.098
r1 15 14 0.408082 $w=1.3e-08 $l=1.8e-09 $layer=M1 $thickness=3.6e-08 $X=0.459
+ $Y=0.147 $X2=0.459 $Y2=0.1452
r2 13 14 2.3902 $w=1.3e-08 $l=1.02e-08 $layer=M1 $thickness=3.6e-08 $X=0.459
+ $Y=0.135 $X2=0.459 $Y2=0.1452
r3 4 13 8.62802 $w=1.3e-08 $l=3.7e-08 $layer=M1 $thickness=3.6e-08 $X=0.459
+ $Y=0.098 $X2=0.459 $Y2=0.135
r4 1 8 10.4265 $w=1.765e-08 $layer=LIG $thickness=5.2e-08 $X=0.459 $Y=0.135
+ $X2=0.459 $Y2=0.135
r5 1 13 19.3796 $a=3.24e-16 $layer=V0LIG $X=0.459 $Y=0.135 $X2=0.459 $Y2=0.135
r6 11 10 14.6259 $w=2.1e-08 $l=4.3e-08 $layer=Gate_1 $thickness=5.6e-08
+ $X=0.459 $Y=0.2025 $X2=0.459 $Y2=0.1595
r7 9 10 2.7211 $w=2.1e-08 $l=8e-09 $layer=Gate_1 $thickness=5.6e-08 $X=0.459
+ $Y=0.1515 $X2=0.459 $Y2=0.1595
r8 8 9 5.79936 $w=2.03333e-08 $l=1.65e-08 $layer=Gate_1 $thickness=5.6e-08
+ $X=0.459 $Y=0.135 $X2=0.459 $Y2=0.1515
r9 7 8 5.79936 $w=2.03333e-08 $l=1.65e-08 $layer=Gate_1 $thickness=5.6e-08
+ $X=0.459 $Y=0.1185 $X2=0.459 $Y2=0.135
r10 6 7 2.7211 $w=2.1e-08 $l=8e-09 $layer=Gate_1 $thickness=5.6e-08 $X=0.459
+ $Y=0.1105 $X2=0.459 $Y2=0.1185
r11 5 6 14.6259 $w=2.1e-08 $l=4.3e-08 $layer=Gate_1 $thickness=5.6e-08 $X=0.459
+ $Y=0.0675 $X2=0.459 $Y2=0.1105
r12 5 3 14.6259 $w=2.1e-08 $l=4.3e-08 $layer=Gate_1 $thickness=5.6e-08 $X=0.459
+ $Y=0.0675 $X2=0.459 $Y2=0.0245
.ends

.subckt PM_OAI222xp33_ASAP7_75t_R%Y vss 63 26 27 57 59 61 2 21 22 1 13 14 20 3
+ 15 4 16 23
c1 1 vss 0.00673554f $X=0.054 $Y=0.2025
c2 2 vss 0.00993972f $X=0.108 $Y=0.0675
c3 3 vss 0.00676659f $X=0.27 $Y=0.2025
c4 4 vss 0.00676703f $X=0.378 $Y=0.2025
c5 13 vss 0.00491376f $X=0.0935 $Y=0.0675
c6 14 vss 0.0374981f $X=0.056 $Y=0.2025
c7 15 vss 0.0374158f $X=0.2555 $Y=0.2025
c8 16 vss 0.0374145f $X=0.38 $Y=0.2025
c9 17 vss 0.00245552f $X=0.027 $Y=0.072
c10 18 vss 0.00277434f $X=0.027 $Y=0.234
c11 19 vss 0.00310048f $X=0.513 $Y=0.234
c12 20 vss 0.00500144f $X=0.027 $Y=0.0935
c13 21 vss 0.00814525f $X=0.0945 $Y=0.072
c14 22 vss 0.040973f $X=0.0405 $Y=0.234
c15 23 vss 0.0103835f $X=0.513 $Y=0.2125
r1 63 64 6.23783 $w=1.3e-08 $l=2.67e-08 $layer=M1 $thickness=3.6e-08 $X=0.516
+ $Y=0.147 $X2=0.513 $Y2=0.1737
r2 23 64 9.0361 $w=1.3e-08 $l=3.88e-08 $layer=M1 $thickness=3.6e-08 $X=0.513
+ $Y=0.2125 $X2=0.513 $Y2=0.1737
r3 61 60 0.0308642 $w=8.1e-08 $l=2.5e-09 $layer=P_src_drn $thickness=1e-09
+ $X=0.3953 $Y=0.2025 $X2=0.3925 $Y2=0.2025
r4 16 60 0.154321 $w=8.1e-08 $l=1.25e-08 $layer=P_src_drn $thickness=1e-09
+ $X=0.38 $Y=0.2025 $X2=0.3925 $Y2=0.2025
r5 15 3 0.154321 $w=8.1e-08 $l=1.25e-08 $layer=P_src_drn $thickness=1e-09
+ $X=0.2555 $Y=0.2025 $X2=0.27 $Y2=0.2025
r6 59 15 0.0308642 $w=8.1e-08 $l=2.5e-09 $layer=P_src_drn $thickness=1e-09
+ $X=0.2526 $Y=0.2025 $X2=0.2555 $Y2=0.2025
r7 57 56 0.0308642 $w=8.1e-08 $l=2.5e-09 $layer=P_src_drn $thickness=1e-09
+ $X=0.0713 $Y=0.2025 $X2=0.0685 $Y2=0.2025
r8 14 56 0.154321 $w=8.1e-08 $l=1.25e-08 $layer=P_src_drn $thickness=1e-09
+ $X=0.056 $Y=0.2025 $X2=0.0685 $Y2=0.2025
r9 19 55 4.64701 $w=1.46667e-08 $l=2.7e-08 $layer=M1 $thickness=3.6e-08
+ $X=0.513 $Y=0.234 $X2=0.486 $Y2=0.234
r10 19 23 3.36447 $w=1.71023e-08 $l=2.15e-08 $layer=M1 $thickness=3.6e-08
+ $X=0.513 $Y=0.234 $X2=0.513 $Y2=0.2125
r11 4 50 19.3796 $a=3.24e-16 $layer=V0LISD $X=0.378 $Y=0.2025 $X2=0.378
+ $Y2=0.234
r12 3 47 19.3796 $a=3.24e-16 $layer=V0LISD $X=0.27 $Y=0.2025 $X2=0.27 $Y2=0.234
r13 1 35 19.3796 $a=3.24e-16 $layer=V0LISD $X=0.054 $Y=0.2025 $X2=0.054
+ $Y2=0.234
r14 54 55 6.29612 $w=1.3e-08 $l=2.7e-08 $layer=M1 $thickness=3.6e-08 $X=0.459
+ $Y=0.234 $X2=0.486 $Y2=0.234
r15 53 54 6.29612 $w=1.3e-08 $l=2.7e-08 $layer=M1 $thickness=3.6e-08 $X=0.432
+ $Y=0.234 $X2=0.459 $Y2=0.234
r16 52 53 6.29612 $w=1.3e-08 $l=2.7e-08 $layer=M1 $thickness=3.6e-08 $X=0.405
+ $Y=0.234 $X2=0.432 $Y2=0.234
r17 51 52 3.14806 $w=1.3e-08 $l=1.35e-08 $layer=M1 $thickness=3.6e-08 $X=0.3915
+ $Y=0.234 $X2=0.405 $Y2=0.234
r18 50 51 3.14806 $w=1.3e-08 $l=1.35e-08 $layer=M1 $thickness=3.6e-08 $X=0.378
+ $Y=0.234 $X2=0.3915 $Y2=0.234
r19 49 50 3.14806 $w=1.3e-08 $l=1.35e-08 $layer=M1 $thickness=3.6e-08 $X=0.3645
+ $Y=0.234 $X2=0.378 $Y2=0.234
r20 48 49 10.4935 $w=1.3e-08 $l=4.5e-08 $layer=M1 $thickness=3.6e-08 $X=0.3195
+ $Y=0.234 $X2=0.3645 $Y2=0.234
r21 47 48 11.5429 $w=1.3e-08 $l=4.95e-08 $layer=M1 $thickness=3.6e-08 $X=0.27
+ $Y=0.234 $X2=0.3195 $Y2=0.234
r22 46 47 3.14806 $w=1.3e-08 $l=1.35e-08 $layer=M1 $thickness=3.6e-08 $X=0.2565
+ $Y=0.234 $X2=0.27 $Y2=0.234
r23 45 46 3.14806 $w=1.3e-08 $l=1.35e-08 $layer=M1 $thickness=3.6e-08 $X=0.243
+ $Y=0.234 $X2=0.2565 $Y2=0.234
r24 44 45 5.82974 $w=1.3e-08 $l=2.5e-08 $layer=M1 $thickness=3.6e-08 $X=0.218
+ $Y=0.234 $X2=0.243 $Y2=0.234
r25 43 44 4.19742 $w=1.3e-08 $l=1.8e-08 $layer=M1 $thickness=3.6e-08 $X=0.2
+ $Y=0.234 $X2=0.218 $Y2=0.234
r26 42 43 2.56509 $w=1.3e-08 $l=1.1e-08 $layer=M1 $thickness=3.6e-08 $X=0.189
+ $Y=0.234 $X2=0.2 $Y2=0.234
r27 41 42 6.29612 $w=1.3e-08 $l=2.7e-08 $layer=M1 $thickness=3.6e-08 $X=0.162
+ $Y=0.234 $X2=0.189 $Y2=0.234
r28 40 41 6.29612 $w=1.3e-08 $l=2.7e-08 $layer=M1 $thickness=3.6e-08 $X=0.135
+ $Y=0.234 $X2=0.162 $Y2=0.234
r29 39 40 2.56509 $w=1.3e-08 $l=1.1e-08 $layer=M1 $thickness=3.6e-08 $X=0.124
+ $Y=0.234 $X2=0.135 $Y2=0.234
r30 38 39 4.19742 $w=1.3e-08 $l=1.8e-08 $layer=M1 $thickness=3.6e-08 $X=0.106
+ $Y=0.234 $X2=0.124 $Y2=0.234
r31 37 38 5.82974 $w=1.3e-08 $l=2.5e-08 $layer=M1 $thickness=3.6e-08 $X=0.081
+ $Y=0.234 $X2=0.106 $Y2=0.234
r32 36 37 3.14806 $w=1.3e-08 $l=1.35e-08 $layer=M1 $thickness=3.6e-08 $X=0.0675
+ $Y=0.234 $X2=0.081 $Y2=0.234
r33 35 36 3.14806 $w=1.3e-08 $l=1.35e-08 $layer=M1 $thickness=3.6e-08 $X=0.054
+ $Y=0.234 $X2=0.0675 $Y2=0.234
r34 22 35 3.14806 $w=1.3e-08 $l=1.35e-08 $layer=M1 $thickness=3.6e-08 $X=0.0405
+ $Y=0.234 $X2=0.054 $Y2=0.234
r35 18 34 3.36447 $w=1.71023e-08 $l=2.15e-08 $layer=M1 $thickness=3.6e-08
+ $X=0.027 $Y=0.234 $X2=0.027 $Y2=0.2125
r36 18 22 1.49895 $w=1.63333e-08 $l=1.35e-08 $layer=M1 $thickness=3.6e-08
+ $X=0.027 $Y=0.234 $X2=0.0405 $Y2=0.234
r37 33 34 13.8748 $w=1.3e-08 $l=5.95e-08 $layer=M1 $thickness=3.6e-08 $X=0.027
+ $Y=0.153 $X2=0.027 $Y2=0.2125
r38 20 33 13.8748 $w=1.3e-08 $l=5.95e-08 $layer=M1 $thickness=3.6e-08 $X=0.027
+ $Y=0.0935 $X2=0.027 $Y2=0.153
r39 17 32 0.915974 $w=1.70909e-08 $l=1.1e-08 $layer=M1 $thickness=3.6e-08
+ $X=0.027 $Y=0.072 $X2=0.038 $Y2=0.072
r40 17 20 3.36447 $w=1.71023e-08 $l=2.15e-08 $layer=M1 $thickness=3.6e-08
+ $X=0.027 $Y=0.072 $X2=0.027 $Y2=0.0935
r41 31 32 4.19742 $w=1.3e-08 $l=1.8e-08 $layer=M1 $thickness=3.6e-08 $X=0.056
+ $Y=0.072 $X2=0.038 $Y2=0.072
r42 30 31 5.82974 $w=1.3e-08 $l=2.5e-08 $layer=M1 $thickness=3.6e-08 $X=0.081
+ $Y=0.072 $X2=0.056 $Y2=0.072
r43 21 28 3.14806 $w=1.3e-08 $l=1.35e-08 $layer=M1 $thickness=3.6e-08 $X=0.0945
+ $Y=0.072 $X2=0.108 $Y2=0.072
r44 21 30 3.14806 $w=1.3e-08 $l=1.35e-08 $layer=M1 $thickness=3.6e-08 $X=0.0945
+ $Y=0.072 $X2=0.081 $Y2=0.072
r45 2 28 19.3796 $a=3.24e-16 $layer=V0LISD $X=0.108 $Y=0.0675 $X2=0.108
+ $Y2=0.072
r46 27 25 0.0308642 $w=8.1e-08 $l=2.5e-09 $layer=N_src_drn $thickness=1e-09
+ $X=0.1253 $Y=0.0675 $X2=0.1225 $Y2=0.0675
r47 2 25 0.179012 $w=8.1e-08 $l=1.45e-08 $layer=N_src_drn $thickness=1e-09
+ $X=0.108 $Y=0.0675 $X2=0.1225 $Y2=0.0675
r48 13 2 0.179012 $w=8.1e-08 $l=1.45e-08 $layer=N_src_drn $thickness=1e-09
+ $X=0.0935 $Y=0.0675 $X2=0.108 $Y2=0.0675
r49 26 13 0.0308642 $w=8.1e-08 $l=2.5e-09 $layer=N_src_drn $thickness=1e-09
+ $X=0.0906 $Y=0.0675 $X2=0.0935 $Y2=0.0675
r50 4 16 1e-05 $l=2e-09 $X=0.378 $Y=0.2025 $X2=0.38 $Y2=0.2025
r51 1 14 1e-05 $l=2e-09 $X=0.054 $Y=0.2025 $X2=0.056 $Y2=0.2025
.ends

.subckt PM_OAI222xp33_ASAP7_75t_R%A1 vss 15 5 11 4 3 1
c1 1 vss 0.00292262f $X=0.081 $Y=0.135
c2 3 vss 0.0707045f $X=0.081 $Y=0.0245
c3 4 vss 0.00494815f $X=0.081 $Y=0.116
r1 15 14 5.88804 $w=1.3e-08 $l=2.53e-08 $layer=M1 $thickness=3.6e-08 $X=0.081
+ $Y=0.194 $X2=0.081 $Y2=0.1687
r2 13 14 7.87015 $w=1.3e-08 $l=3.37e-08 $layer=M1 $thickness=3.6e-08 $X=0.081
+ $Y=0.135 $X2=0.081 $Y2=0.1687
r3 4 13 4.4306 $w=1.3e-08 $l=1.9e-08 $layer=M1 $thickness=3.6e-08 $X=0.081
+ $Y=0.116 $X2=0.081 $Y2=0.135
r4 1 8 10.4265 $w=1.765e-08 $layer=LIG $thickness=5.2e-08 $X=0.081 $Y=0.135
+ $X2=0.081 $Y2=0.135
r5 1 13 19.3796 $a=3.24e-16 $layer=V0LIG $X=0.081 $Y=0.135 $X2=0.081 $Y2=0.135
r6 11 10 14.6259 $w=2.1e-08 $l=4.3e-08 $layer=Gate_1 $thickness=5.6e-08
+ $X=0.081 $Y=0.2025 $X2=0.081 $Y2=0.1595
r7 9 10 2.7211 $w=2.1e-08 $l=8e-09 $layer=Gate_1 $thickness=5.6e-08 $X=0.081
+ $Y=0.1515 $X2=0.081 $Y2=0.1595
r8 8 9 5.79936 $w=2.03333e-08 $l=1.65e-08 $layer=Gate_1 $thickness=5.6e-08
+ $X=0.081 $Y=0.135 $X2=0.081 $Y2=0.1515
r9 7 8 5.79936 $w=2.03333e-08 $l=1.65e-08 $layer=Gate_1 $thickness=5.6e-08
+ $X=0.081 $Y=0.1185 $X2=0.081 $Y2=0.135
r10 6 7 2.7211 $w=2.1e-08 $l=8e-09 $layer=Gate_1 $thickness=5.6e-08 $X=0.081
+ $Y=0.1105 $X2=0.081 $Y2=0.1185
r11 5 6 14.6259 $w=2.1e-08 $l=4.3e-08 $layer=Gate_1 $thickness=5.6e-08 $X=0.081
+ $Y=0.0675 $X2=0.081 $Y2=0.1105
r12 5 3 14.6259 $w=2.1e-08 $l=4.3e-08 $layer=Gate_1 $thickness=5.6e-08 $X=0.081
+ $Y=0.0675 $X2=0.081 $Y2=0.0245
.ends

.subckt PM_OAI222xp33_ASAP7_75t_R%A2 vss 11 5 9 4 3
c1 1 vss 0.00668435f $X=0.135 $Y=0.135
c2 3 vss 0.102311f $X=0.135 $Y=0.0245
c3 4 vss 0.00437499f $X=0.135 $Y=0.1122
r1 12 13 2.85657 $w=1.3e-08 $l=1.23e-08 $layer=M1 $thickness=3.6e-08 $X=0.135
+ $Y=0.1227 $X2=0.135 $Y2=0.135
r2 11 12 0.874462 $w=1.3e-08 $l=3.7e-09 $layer=M1 $thickness=3.6e-08 $X=0.135
+ $Y=0.119 $X2=0.135 $Y2=0.1227
r3 11 4 1.57403 $w=1.3e-08 $l=6.8e-09 $layer=M1 $thickness=3.6e-08 $X=0.135
+ $Y=0.119 $X2=0.135 $Y2=0.1122
r4 1 7 10.4265 $w=1.765e-08 $layer=LIG $thickness=5.2e-08 $X=0.135 $Y=0.135
+ $X2=0.135 $Y2=0.135
r5 1 13 19.3796 $a=3.24e-16 $layer=V0LIG $X=0.135 $Y=0.135 $X2=0.135 $Y2=0.135
r6 9 8 16.4967 $w=2.1e-08 $l=4.85e-08 $layer=Gate_1 $thickness=5.6e-08 $X=0.135
+ $Y=0.2025 $X2=0.135 $Y2=0.154
r7 7 8 6.6497 $w=2.04211e-08 $l=1.9e-08 $layer=Gate_1 $thickness=5.6e-08
+ $X=0.135 $Y=0.135 $X2=0.135 $Y2=0.154
r8 6 7 6.6497 $w=2.04211e-08 $l=1.9e-08 $layer=Gate_1 $thickness=5.6e-08
+ $X=0.135 $Y=0.116 $X2=0.135 $Y2=0.135
r9 5 6 16.4967 $w=2.1e-08 $l=4.85e-08 $layer=Gate_1 $thickness=5.6e-08 $X=0.135
+ $Y=0.0675 $X2=0.135 $Y2=0.116
r10 5 3 14.6259 $w=2.1e-08 $l=4.3e-08 $layer=Gate_1 $thickness=5.6e-08 $X=0.135
+ $Y=0.0675 $X2=0.135 $Y2=0.0245
.ends

* End of included file OAI222xp33_ASAP7_75t_R.pex.sp.pex

*
.subckt OAI222xp33_ASAP7_75t_CUSTOM_4_25_0_7 VSS VDD A1 A2 B2 B1 C1 C2 Y
*
* VSS VSS
* VDD VDD
* A1 A1
* A2 A2
* B2 B2
* B1 B1
* C1 C1
* C2 C2
* Y Y
*
*

M0 N_M0_d N_M0_g noxref_9 VSS nmos_rvt L=2e-08 W=8.1e-08 nfin=3 $X=0.071
+ $Y=0.027
M1 noxref_9 N_M1_g N_M1_s VSS nmos_rvt L=2e-08 W=8.1e-08 nfin=3 $X=0.125
+ $Y=0.027
M2 noxref_10 N_M2_g noxref_9 VSS nmos_rvt L=2e-08 W=8.1e-08 nfin=3 $X=0.179
+ $Y=0.027
M3 noxref_9 N_M3_g noxref_10 VSS nmos_rvt L=2e-08 W=8.1e-08 nfin=3 $X=0.233
+ $Y=0.027
M4 noxref_10 N_M4_g VSS VSS nmos_rvt L=2e-08 W=8.1e-08 nfin=3 $X=0.395 $Y=0.027
M5 VSS N_M5_g noxref_10 VSS nmos_rvt L=2e-08 W=8.1e-08 nfin=3 $X=0.449 $Y=0.027
M6 noxref_12 N_M6_g N_M6_s VDD pmos_rvt L=2e-08 W=8.1e-08 nfin=3 $X=0.071
+ $Y=0.162
M7 VDD N_M7_g noxref_12 VDD pmos_rvt L=2e-08 W=8.1e-08 nfin=3 $X=0.125 $Y=0.162
M8 noxref_13 N_M8_g VDD VDD pmos_rvt L=2e-08 W=8.1e-08 nfin=3 $X=0.179 $Y=0.162
M9 N_M9_d N_M9_g noxref_13 VDD pmos_rvt L=2e-08 W=8.1e-08 nfin=3 $X=0.233
+ $Y=0.162
M10 noxref_14 N_M10_g N_M10_s VDD pmos_rvt L=2e-08 W=8.1e-08 nfin=3 $X=0.395
+ $Y=0.162
M11 VDD N_M11_g noxref_14 VDD pmos_rvt L=2e-08 W=8.1e-08 nfin=3 $X=0.449
+ $Y=0.162

* .include "OAI222xp33_ASAP7_75t_R.pex.sp.pxi"

* Start of included file OAI222xp33_ASAP7_75t_R.pex.sp.pxi
x_PM_OAI222xp33_ASAP7_75t_R%B2 vss B2 N_M2_g N_M8_g N_B2_3 N_B2_4
+ PM_OAI222xp33_ASAP7_75t_R%B2
cc_1 N_B2_3 N_A2_3 0.00317797f $X=0.189 $Y=0.0245
cc_2 N_B2_4 N_A2_4 0.00505748f $X=0.189 $Y=0.116
x_PM_OAI222xp33_ASAP7_75t_R%C1 vss C1 N_M4_g N_M10_g N_C1_4 N_C1_3
+ PM_OAI222xp33_ASAP7_75t_R%C1
x_PM_OAI222xp33_ASAP7_75t_R%B1 vss B1 N_M3_g N_M9_g N_B1_4 N_B1_3
+ PM_OAI222xp33_ASAP7_75t_R%B1
cc_3 N_B1_4 N_B2_4 0.00330152f $X=0.243 $Y=0.1102
cc_4 N_B1_3 N_B2_3 0.00696531f $X=0.243 $Y=0.0245
x_PM_OAI222xp33_ASAP7_75t_R%C2 vss C2 N_M5_g N_M11_g N_C2_4 N_C2_3
+ PM_OAI222xp33_ASAP7_75t_R%C2
cc_5 N_C2_4 N_C1_4 0.00456836f $X=0.459 $Y=0.098
cc_6 N_C2_3 N_C1_3 0.00708468f $X=0.459 $Y=0.0245
x_PM_OAI222xp33_ASAP7_75t_R%Y vss Y N_M0_d N_M1_s N_M6_s N_M9_d N_M10_s N_Y_2
+ N_Y_21 N_Y_22 N_Y_1 N_Y_13 N_Y_14 N_Y_20 N_Y_3 N_Y_15 N_Y_4 N_Y_16 N_Y_23
+ PM_OAI222xp33_ASAP7_75t_R%Y
cc_7 N_Y_2 N_A1_3 0.00168035f $X=0.108 $Y=0.0675
cc_8 N_Y_21 N_A1_3 0.000992524f $X=0.0945 $Y=0.072
cc_9 N_Y_22 N_A1_4 0.001123f $X=0.0405 $Y=0.234
cc_10 N_Y_1 N_A1_3 0.00156078f $X=0.054 $Y=0.2025
cc_11 N_Y_13 N_A1_1 0.00173064f $X=0.0935 $Y=0.0675
cc_12 N_Y_14 N_A1_3 0.0151289f $X=0.056 $Y=0.2025
cc_13 N_Y_20 N_A1_4 0.00657554f $X=0.027 $Y=0.0935
cc_14 N_Y_13 N_A1_3 0.0547758f $X=0.0935 $Y=0.0675
cc_15 N_Y_21 N_A2_3 0.00053071f $X=0.0945 $Y=0.072
cc_16 N_Y_2 N_A2_3 0.000804264f $X=0.108 $Y=0.0675
cc_17 N_Y_22 N_A2_4 0.00129552f $X=0.0405 $Y=0.234
cc_18 N_Y_2 N_A2_4 0.00217544f $X=0.108 $Y=0.0675
cc_19 N_Y_13 N_A2_3 0.0364225f $X=0.0935 $Y=0.0675
cc_20 N_Y_22 N_B2_4 0.0035739f $X=0.0405 $Y=0.234
cc_21 N_Y_22 N_B1_3 0.00149546f $X=0.0405 $Y=0.234
cc_22 N_Y_3 N_B1_3 0.00182841f $X=0.27 $Y=0.2025
cc_23 N_Y_3 N_B1_4 0.00230209f $X=0.27 $Y=0.2025
cc_24 N_Y_15 N_B1_3 0.0367278f $X=0.2555 $Y=0.2025
cc_25 N_Y_4 N_C1_3 0.00218863f $X=0.378 $Y=0.2025
cc_26 N_Y_22 N_C1_3 0.00148823f $X=0.0405 $Y=0.234
cc_27 N_Y_4 N_C1_4 0.00243742f $X=0.378 $Y=0.2025
cc_28 N_Y_16 N_C1_3 0.0365179f $X=0.38 $Y=0.2025
cc_29 N_Y_22 N_C2_4 0.00119669f $X=0.0405 $Y=0.234
cc_30 N_Y_23 N_C2_4 0.00739171f $X=0.513 $Y=0.2125
x_PM_OAI222xp33_ASAP7_75t_R%A1 vss A1 N_M0_g N_M6_g N_A1_4 N_A1_3 N_A1_1
+ PM_OAI222xp33_ASAP7_75t_R%A1
x_PM_OAI222xp33_ASAP7_75t_R%A2 vss A2 N_M1_g N_M7_g N_A2_4 N_A2_3
+ PM_OAI222xp33_ASAP7_75t_R%A2
cc_31 N_A2_4 N_A1_4 0.00330366f $X=0.135 $Y=0.1122
cc_32 N_A2_3 N_A1_3 0.00694646f $X=0.135 $Y=0.0245

* End of included file OAI222xp33_ASAP7_75t_R.pex.sp.pxi
.ends

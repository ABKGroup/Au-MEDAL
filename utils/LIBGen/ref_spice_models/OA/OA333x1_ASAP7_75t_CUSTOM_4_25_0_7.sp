.subckt PM_OA333x1_ASAP7_75t_R%C3 vss 14 5 9 3 4
c1 1 vss 0.00668866f $X=0.135 $Y=0.135
c2 3 vss 0.139672f $X=0.135 $Y=0.0245
c3 4 vss 0.00638375f $X=0.135 $Y=0.0925
r1 14 13 1.45744 $w=1.3e-08 $l=6.3e-09 $layer=M1 $thickness=3.6e-08 $X=0.127
+ $Y=0.156 $X2=0.135 $Y2=0.1497
r2 12 13 3.43955 $w=1.3e-08 $l=1.47e-08 $layer=M1 $thickness=3.6e-08 $X=0.135
+ $Y=0.135 $X2=0.135 $Y2=0.1497
r3 11 12 3.38125 $w=1.3e-08 $l=1.45e-08 $layer=M1 $thickness=3.6e-08 $X=0.135
+ $Y=0.1205 $X2=0.135 $Y2=0.135
r4 4 11 6.52931 $w=1.3e-08 $l=2.8e-08 $layer=M1 $thickness=3.6e-08 $X=0.135
+ $Y=0.0925 $X2=0.135 $Y2=0.1205
r5 1 7 10.4265 $w=1.765e-08 $layer=LIG $thickness=5.2e-08 $X=0.135 $Y=0.135
+ $X2=0.135 $Y2=0.135
r6 1 12 19.3796 $a=3.24e-16 $layer=V0LIG $X=0.135 $Y=0.135 $X2=0.135 $Y2=0.135
r7 9 8 16.4967 $w=2.1e-08 $l=4.85e-08 $layer=Gate_1 $thickness=5.6e-08 $X=0.135
+ $Y=0.2025 $X2=0.135 $Y2=0.154
r8 7 8 6.6497 $w=2.04211e-08 $l=1.9e-08 $layer=Gate_1 $thickness=5.6e-08
+ $X=0.135 $Y=0.135 $X2=0.135 $Y2=0.154
r9 6 7 6.6497 $w=2.04211e-08 $l=1.9e-08 $layer=Gate_1 $thickness=5.6e-08
+ $X=0.135 $Y=0.116 $X2=0.135 $Y2=0.135
r10 5 6 16.4967 $w=2.1e-08 $l=4.85e-08 $layer=Gate_1 $thickness=5.6e-08
+ $X=0.135 $Y=0.0675 $X2=0.135 $Y2=0.116
r11 5 3 14.6259 $w=2.1e-08 $l=4.3e-08 $layer=Gate_1 $thickness=5.6e-08 $X=0.135
+ $Y=0.0675 $X2=0.135 $Y2=0.0245
.ends

.subckt PM_OA333x1_ASAP7_75t_R%B1 vss 13 5 9 4 3
c1 1 vss 0.00476073f $X=0.297 $Y=0.135
c2 3 vss 0.102694f $X=0.297 $Y=0.0245
c3 4 vss 0.00718655f $X=0.297 $Y=0.116
r1 13 12 1.22425 $w=1.3e-08 $l=5.3e-09 $layer=M1 $thickness=3.6e-08 $X=0.297
+ $Y=0.154 $X2=0.297 $Y2=0.1487
r2 11 12 3.20636 $w=1.3e-08 $l=1.37e-08 $layer=M1 $thickness=3.6e-08 $X=0.297
+ $Y=0.135 $X2=0.297 $Y2=0.1487
r3 4 11 4.4306 $w=1.3e-08 $l=1.9e-08 $layer=M1 $thickness=3.6e-08 $X=0.297
+ $Y=0.116 $X2=0.297 $Y2=0.135
r4 1 7 10.4265 $w=1.765e-08 $layer=LIG $thickness=5.2e-08 $X=0.297 $Y=0.135
+ $X2=0.297 $Y2=0.135
r5 1 11 19.3796 $a=3.24e-16 $layer=V0LIG $X=0.297 $Y=0.135 $X2=0.297 $Y2=0.135
r6 9 8 16.4967 $w=2.1e-08 $l=4.85e-08 $layer=Gate_1 $thickness=5.6e-08 $X=0.297
+ $Y=0.2025 $X2=0.297 $Y2=0.154
r7 7 8 6.6497 $w=2.04211e-08 $l=1.9e-08 $layer=Gate_1 $thickness=5.6e-08
+ $X=0.297 $Y=0.135 $X2=0.297 $Y2=0.154
r8 6 7 6.6497 $w=2.04211e-08 $l=1.9e-08 $layer=Gate_1 $thickness=5.6e-08
+ $X=0.297 $Y=0.116 $X2=0.297 $Y2=0.135
r9 5 6 16.4967 $w=2.1e-08 $l=4.85e-08 $layer=Gate_1 $thickness=5.6e-08 $X=0.297
+ $Y=0.0675 $X2=0.297 $Y2=0.116
r10 5 3 14.6259 $w=2.1e-08 $l=4.3e-08 $layer=Gate_1 $thickness=5.6e-08 $X=0.297
+ $Y=0.0675 $X2=0.297 $Y2=0.0245
.ends

.subckt PM_OA333x1_ASAP7_75t_R%B2 vss 13 5 9 4 3
c1 1 vss 0.00471963f $X=0.351 $Y=0.135
c2 3 vss 0.121277f $X=0.351 $Y=0.0245
c3 4 vss 0.00511686f $X=0.351 $Y=0.116
r1 13 12 1.34084 $w=1.3e-08 $l=5.8e-09 $layer=M1 $thickness=3.6e-08 $X=0.35
+ $Y=0.155 $X2=0.351 $Y2=0.1492
r2 11 12 3.32295 $w=1.3e-08 $l=1.42e-08 $layer=M1 $thickness=3.6e-08 $X=0.351
+ $Y=0.135 $X2=0.351 $Y2=0.1492
r3 4 11 4.4306 $w=1.3e-08 $l=1.9e-08 $layer=M1 $thickness=3.6e-08 $X=0.351
+ $Y=0.116 $X2=0.351 $Y2=0.135
r4 1 7 10.4265 $w=1.765e-08 $layer=LIG $thickness=5.2e-08 $X=0.351 $Y=0.135
+ $X2=0.351 $Y2=0.135
r5 1 11 19.3796 $a=3.24e-16 $layer=V0LIG $X=0.351 $Y=0.135 $X2=0.351 $Y2=0.135
r6 9 8 16.4967 $w=2.1e-08 $l=4.85e-08 $layer=Gate_1 $thickness=5.6e-08 $X=0.351
+ $Y=0.2025 $X2=0.351 $Y2=0.154
r7 7 8 6.6497 $w=2.04211e-08 $l=1.9e-08 $layer=Gate_1 $thickness=5.6e-08
+ $X=0.351 $Y=0.135 $X2=0.351 $Y2=0.154
r8 6 7 6.6497 $w=2.04211e-08 $l=1.9e-08 $layer=Gate_1 $thickness=5.6e-08
+ $X=0.351 $Y=0.116 $X2=0.351 $Y2=0.135
r9 5 6 16.4967 $w=2.1e-08 $l=4.85e-08 $layer=Gate_1 $thickness=5.6e-08 $X=0.351
+ $Y=0.0675 $X2=0.351 $Y2=0.116
r10 5 3 14.6259 $w=2.1e-08 $l=4.3e-08 $layer=Gate_1 $thickness=5.6e-08 $X=0.351
+ $Y=0.0675 $X2=0.351 $Y2=0.0245
.ends

.subckt PM_OA333x1_ASAP7_75t_R%B3 vss 13 5 9 4 3
c1 1 vss 0.00577086f $X=0.405 $Y=0.135
c2 3 vss 0.140066f $X=0.405 $Y=0.0245
c3 4 vss 0.00551635f $X=0.405 $Y=0.116
r1 13 12 1.34084 $w=1.3e-08 $l=5.8e-09 $layer=M1 $thickness=3.6e-08 $X=0.4
+ $Y=0.155 $X2=0.405 $Y2=0.1492
r2 11 12 3.32295 $w=1.3e-08 $l=1.42e-08 $layer=M1 $thickness=3.6e-08 $X=0.405
+ $Y=0.135 $X2=0.405 $Y2=0.1492
r3 4 11 4.4306 $w=1.3e-08 $l=1.9e-08 $layer=M1 $thickness=3.6e-08 $X=0.405
+ $Y=0.116 $X2=0.405 $Y2=0.135
r4 1 7 10.4265 $w=1.765e-08 $layer=LIG $thickness=5.2e-08 $X=0.405 $Y=0.135
+ $X2=0.405 $Y2=0.135
r5 1 11 19.3796 $a=3.24e-16 $layer=V0LIG $X=0.405 $Y=0.135 $X2=0.405 $Y2=0.135
r6 9 8 16.4967 $w=2.1e-08 $l=4.85e-08 $layer=Gate_1 $thickness=5.6e-08 $X=0.405
+ $Y=0.2025 $X2=0.405 $Y2=0.154
r7 7 8 6.6497 $w=2.04211e-08 $l=1.9e-08 $layer=Gate_1 $thickness=5.6e-08
+ $X=0.405 $Y=0.135 $X2=0.405 $Y2=0.154
r8 6 7 6.6497 $w=2.04211e-08 $l=1.9e-08 $layer=Gate_1 $thickness=5.6e-08
+ $X=0.405 $Y=0.116 $X2=0.405 $Y2=0.135
r9 5 6 16.4967 $w=2.1e-08 $l=4.85e-08 $layer=Gate_1 $thickness=5.6e-08 $X=0.405
+ $Y=0.0675 $X2=0.405 $Y2=0.116
r10 5 3 14.6259 $w=2.1e-08 $l=4.3e-08 $layer=Gate_1 $thickness=5.6e-08 $X=0.405
+ $Y=0.0675 $X2=0.405 $Y2=0.0245
.ends

.subckt PM_OA333x1_ASAP7_75t_R%A3 vss 11 5 9 3 4
c1 1 vss 0.00426742f $X=0.459 $Y=0.135
c2 3 vss 0.103279f $X=0.459 $Y=0.0245
c3 4 vss 0.00615201f $X=0.459 $Y=0.1122
r1 12 13 2.85657 $w=1.3e-08 $l=1.23e-08 $layer=M1 $thickness=3.6e-08 $X=0.459
+ $Y=0.1227 $X2=0.459 $Y2=0.135
r2 11 12 0.874462 $w=1.3e-08 $l=3.7e-09 $layer=M1 $thickness=3.6e-08 $X=0.462
+ $Y=0.119 $X2=0.459 $Y2=0.1227
r3 11 4 1.57403 $w=1.3e-08 $l=6.8e-09 $layer=M1 $thickness=3.6e-08 $X=0.462
+ $Y=0.119 $X2=0.459 $Y2=0.1122
r4 1 7 10.4265 $w=1.765e-08 $layer=LIG $thickness=5.2e-08 $X=0.459 $Y=0.135
+ $X2=0.459 $Y2=0.135
r5 1 13 19.3796 $a=3.24e-16 $layer=V0LIG $X=0.459 $Y=0.135 $X2=0.459 $Y2=0.135
r6 9 8 16.4967 $w=2.1e-08 $l=4.85e-08 $layer=Gate_1 $thickness=5.6e-08 $X=0.459
+ $Y=0.2025 $X2=0.459 $Y2=0.154
r7 7 8 6.6497 $w=2.04211e-08 $l=1.9e-08 $layer=Gate_1 $thickness=5.6e-08
+ $X=0.459 $Y=0.135 $X2=0.459 $Y2=0.154
r8 6 7 6.6497 $w=2.04211e-08 $l=1.9e-08 $layer=Gate_1 $thickness=5.6e-08
+ $X=0.459 $Y=0.116 $X2=0.459 $Y2=0.135
r9 5 6 16.4967 $w=2.1e-08 $l=4.85e-08 $layer=Gate_1 $thickness=5.6e-08 $X=0.459
+ $Y=0.0675 $X2=0.459 $Y2=0.116
r10 5 3 14.6259 $w=2.1e-08 $l=4.3e-08 $layer=Gate_1 $thickness=5.6e-08 $X=0.459
+ $Y=0.0675 $X2=0.459 $Y2=0.0245
.ends

.subckt PM_OA333x1_ASAP7_75t_R%A2 vss 13 5 9 3 1 4
c1 1 vss 0.00295064f $X=0.513 $Y=0.135
c2 3 vss 0.0833771f $X=0.513 $Y=0.0245
c3 4 vss 0.00533248f $X=0.513 $Y=0.116
r1 13 12 1.34084 $w=1.3e-08 $l=5.8e-09 $layer=M1 $thickness=3.6e-08 $X=0.511
+ $Y=0.155 $X2=0.513 $Y2=0.1492
r2 11 12 3.32295 $w=1.3e-08 $l=1.42e-08 $layer=M1 $thickness=3.6e-08 $X=0.513
+ $Y=0.135 $X2=0.513 $Y2=0.1492
r3 4 11 4.4306 $w=1.3e-08 $l=1.9e-08 $layer=M1 $thickness=3.6e-08 $X=0.513
+ $Y=0.116 $X2=0.513 $Y2=0.135
r4 1 7 10.4265 $w=1.765e-08 $layer=LIG $thickness=5.2e-08 $X=0.513 $Y=0.135
+ $X2=0.513 $Y2=0.135
r5 1 11 19.3796 $a=3.24e-16 $layer=V0LIG $X=0.513 $Y=0.135 $X2=0.513 $Y2=0.135
r6 9 8 16.4967 $w=2.1e-08 $l=4.85e-08 $layer=Gate_1 $thickness=5.6e-08 $X=0.513
+ $Y=0.2025 $X2=0.513 $Y2=0.154
r7 7 8 6.6497 $w=2.04211e-08 $l=1.9e-08 $layer=Gate_1 $thickness=5.6e-08
+ $X=0.513 $Y=0.135 $X2=0.513 $Y2=0.154
r8 6 7 6.6497 $w=2.04211e-08 $l=1.9e-08 $layer=Gate_1 $thickness=5.6e-08
+ $X=0.513 $Y=0.116 $X2=0.513 $Y2=0.135
r9 5 6 16.4967 $w=2.1e-08 $l=4.85e-08 $layer=Gate_1 $thickness=5.6e-08 $X=0.513
+ $Y=0.0675 $X2=0.513 $Y2=0.116
r10 5 3 14.6259 $w=2.1e-08 $l=4.3e-08 $layer=Gate_1 $thickness=5.6e-08 $X=0.513
+ $Y=0.0675 $X2=0.513 $Y2=0.0245
.ends

.subckt PM_OA333x1_ASAP7_75t_R%A1 vss 15 5 11 3 4 1
c1 1 vss 0.00250734f $X=0.567 $Y=0.135
c2 3 vss 0.0708375f $X=0.567 $Y=0.0245
c3 4 vss 0.00446296f $X=0.567 $Y=0.116
r1 15 14 1.34084 $w=1.3e-08 $l=5.8e-09 $layer=M1 $thickness=3.6e-08 $X=0.575
+ $Y=0.155 $X2=0.567 $Y2=0.1492
r2 13 14 3.32295 $w=1.3e-08 $l=1.42e-08 $layer=M1 $thickness=3.6e-08 $X=0.567
+ $Y=0.135 $X2=0.567 $Y2=0.1492
r3 4 13 4.4306 $w=1.3e-08 $l=1.9e-08 $layer=M1 $thickness=3.6e-08 $X=0.567
+ $Y=0.116 $X2=0.567 $Y2=0.135
r4 1 8 10.4265 $w=1.765e-08 $layer=LIG $thickness=5.2e-08 $X=0.567 $Y=0.135
+ $X2=0.567 $Y2=0.135
r5 1 13 19.3796 $a=3.24e-16 $layer=V0LIG $X=0.567 $Y=0.135 $X2=0.567 $Y2=0.135
r6 11 10 14.6259 $w=2.1e-08 $l=4.3e-08 $layer=Gate_1 $thickness=5.6e-08
+ $X=0.567 $Y=0.2025 $X2=0.567 $Y2=0.1595
r7 9 10 2.7211 $w=2.1e-08 $l=8e-09 $layer=Gate_1 $thickness=5.6e-08 $X=0.567
+ $Y=0.1515 $X2=0.567 $Y2=0.1595
r8 8 9 5.79936 $w=2.03333e-08 $l=1.65e-08 $layer=Gate_1 $thickness=5.6e-08
+ $X=0.567 $Y=0.135 $X2=0.567 $Y2=0.1515
r9 7 8 5.79936 $w=2.03333e-08 $l=1.65e-08 $layer=Gate_1 $thickness=5.6e-08
+ $X=0.567 $Y=0.1185 $X2=0.567 $Y2=0.135
r10 6 7 2.7211 $w=2.1e-08 $l=8e-09 $layer=Gate_1 $thickness=5.6e-08 $X=0.567
+ $Y=0.1105 $X2=0.567 $Y2=0.1185
r11 5 6 14.6259 $w=2.1e-08 $l=4.3e-08 $layer=Gate_1 $thickness=5.6e-08 $X=0.567
+ $Y=0.0675 $X2=0.567 $Y2=0.1105
r12 5 3 14.6259 $w=2.1e-08 $l=4.3e-08 $layer=Gate_1 $thickness=5.6e-08 $X=0.567
+ $Y=0.0675 $X2=0.567 $Y2=0.0245
.ends

.subckt PM_OA333x1_ASAP7_75t_R%3 vss 29 35 71 72 76 88 91 92 20 1 24 15 18 3 26
+ 4 27 16 5 17 6 28 19 25 21
c1 1 vss 0.00371895f $X=0.081 $Y=0.135
c2 3 vss 0.00502396f $X=0.27 $Y=0.2025
c3 4 vss 0.00985816f $X=0.486 $Y=0.0675
c4 5 vss 0.00807902f $X=0.594 $Y=0.0675
c5 6 vss 0.0064161f $X=0.594 $Y=0.2025
c6 15 vss 0.0808572f $X=0.081 $Y=0.0245
c7 16 vss 0.00516638f $X=0.4715 $Y=0.0675
c8 17 vss 0.0385745f $X=0.5795 $Y=0.0675
c9 18 vss 0.00324969f $X=0.2555 $Y=0.2025
c10 19 vss 0.0375397f $X=0.5795 $Y=0.2025
c11 20 vss 0.00144359f $X=0.081 $Y=0.195
c12 21 vss 0.00285442f $X=0.108 $Y=0.234
c13 22 vss 0.00170651f $X=0.621 $Y=0.072
c14 23 vss 0.00284078f $X=0.621 $Y=0.234
c15 24 vss 0.00153641f $X=0.081 $Y=0.1205
c16 25 vss 0.000815507f $X=0.108 $Y=0.2145
c17 26 vss 0.0433215f $X=0.1215 $Y=0.234
c18 27 vss 0.0117703f $X=0.5805 $Y=0.072
c19 28 vss 0.00426548f $X=0.621 $Y=0.2125
r1 92 90 0.0308642 $w=8.1e-08 $l=2.5e-09 $layer=N_src_drn $thickness=1e-09
+ $X=0.5033 $Y=0.0675 $X2=0.5005 $Y2=0.0675
r2 4 90 0.179012 $w=8.1e-08 $l=1.45e-08 $layer=N_src_drn $thickness=1e-09
+ $X=0.486 $Y=0.0675 $X2=0.5005 $Y2=0.0675
r3 16 4 0.179012 $w=8.1e-08 $l=1.45e-08 $layer=N_src_drn $thickness=1e-09
+ $X=0.4715 $Y=0.0675 $X2=0.486 $Y2=0.0675
r4 91 16 0.0308642 $w=8.1e-08 $l=2.5e-09 $layer=N_src_drn $thickness=1e-09
+ $X=0.4686 $Y=0.0675 $X2=0.4715 $Y2=0.0675
r5 17 5 0.154321 $w=8.1e-08 $l=1.25e-08 $layer=N_src_drn $thickness=1e-09
+ $X=0.5795 $Y=0.0675 $X2=0.594 $Y2=0.0675
r6 88 17 0.0308642 $w=8.1e-08 $l=2.5e-09 $layer=N_src_drn $thickness=1e-09
+ $X=0.5766 $Y=0.0675 $X2=0.5795 $Y2=0.0675
r7 4 84 19.3796 $a=3.24e-16 $layer=V0LISD $X=0.486 $Y=0.0675 $X2=0.486 $Y2=0.072
r8 5 77 19.3796 $a=3.24e-16 $layer=V0LISD $X=0.594 $Y=0.0675 $X2=0.594 $Y2=0.072
r9 84 85 3.14806 $w=1.3e-08 $l=1.35e-08 $layer=M1 $thickness=3.6e-08 $X=0.486
+ $Y=0.072 $X2=0.4995 $Y2=0.072
r10 82 85 3.14806 $w=1.3e-08 $l=1.35e-08 $layer=M1 $thickness=3.6e-08 $X=0.513
+ $Y=0.072 $X2=0.4995 $Y2=0.072
r11 81 82 6.29612 $w=1.3e-08 $l=2.7e-08 $layer=M1 $thickness=3.6e-08 $X=0.54
+ $Y=0.072 $X2=0.513 $Y2=0.072
r12 80 81 5.47996 $w=1.3e-08 $l=2.35e-08 $layer=M1 $thickness=3.6e-08 $X=0.5635
+ $Y=0.072 $X2=0.54 $Y2=0.072
r13 79 80 2.09871 $w=1.3e-08 $l=9e-09 $layer=M1 $thickness=3.6e-08 $X=0.5725
+ $Y=0.072 $X2=0.5635 $Y2=0.072
r14 77 78 3.14806 $w=1.3e-08 $l=1.35e-08 $layer=M1 $thickness=3.6e-08 $X=0.594
+ $Y=0.072 $X2=0.6075 $Y2=0.072
r15 27 77 3.14806 $w=1.3e-08 $l=1.35e-08 $layer=M1 $thickness=3.6e-08 $X=0.5805
+ $Y=0.072 $X2=0.594 $Y2=0.072
r16 27 79 1.86552 $w=1.3e-08 $l=8e-09 $layer=M1 $thickness=3.6e-08 $X=0.5805
+ $Y=0.072 $X2=0.5725 $Y2=0.072
r17 22 74 3.36447 $w=1.71023e-08 $l=2.15e-08 $layer=M1 $thickness=3.6e-08
+ $X=0.621 $Y=0.072 $X2=0.621 $Y2=0.0935
r18 22 78 1.49895 $w=1.63333e-08 $l=1.35e-08 $layer=M1 $thickness=3.6e-08
+ $X=0.621 $Y=0.072 $X2=0.6075 $Y2=0.072
r19 19 6 0.154321 $w=8.1e-08 $l=1.25e-08 $layer=P_src_drn $thickness=1e-09
+ $X=0.5795 $Y=0.2025 $X2=0.594 $Y2=0.2025
r20 76 19 0.0308642 $w=8.1e-08 $l=2.5e-09 $layer=P_src_drn $thickness=1e-09
+ $X=0.5766 $Y=0.2025 $X2=0.5795 $Y2=0.2025
r21 73 74 13.8748 $w=1.3e-08 $l=5.95e-08 $layer=M1 $thickness=3.6e-08 $X=0.621
+ $Y=0.153 $X2=0.621 $Y2=0.0935
r22 28 73 13.8748 $w=1.3e-08 $l=5.95e-08 $layer=M1 $thickness=3.6e-08 $X=0.621
+ $Y=0.2125 $X2=0.621 $Y2=0.153
r23 72 70 0.0308642 $w=8.1e-08 $l=2.5e-09 $layer=P_src_drn $thickness=1e-09
+ $X=0.2873 $Y=0.2025 $X2=0.2845 $Y2=0.2025
r24 3 70 0.179012 $w=8.1e-08 $l=1.45e-08 $layer=P_src_drn $thickness=1e-09
+ $X=0.27 $Y=0.2025 $X2=0.2845 $Y2=0.2025
r25 18 3 0.179012 $w=8.1e-08 $l=1.45e-08 $layer=P_src_drn $thickness=1e-09
+ $X=0.2555 $Y=0.2025 $X2=0.27 $Y2=0.2025
r26 71 18 0.0308642 $w=8.1e-08 $l=2.5e-09 $layer=P_src_drn $thickness=1e-09
+ $X=0.2526 $Y=0.2025 $X2=0.2555 $Y2=0.2025
r27 6 67 19.3796 $a=3.24e-16 $layer=V0LISD $X=0.594 $Y=0.2025 $X2=0.594
+ $Y2=0.234
r28 23 68 1.49895 $w=1.63333e-08 $l=1.35e-08 $layer=M1 $thickness=3.6e-08
+ $X=0.621 $Y=0.234 $X2=0.6075 $Y2=0.234
r29 23 28 3.36447 $w=1.71023e-08 $l=2.15e-08 $layer=M1 $thickness=3.6e-08
+ $X=0.621 $Y=0.234 $X2=0.621 $Y2=0.2125
r30 3 52 19.3796 $a=3.24e-16 $layer=V0LISD $X=0.27 $Y=0.2025 $X2=0.27 $Y2=0.234
r31 67 68 3.14806 $w=1.3e-08 $l=1.35e-08 $layer=M1 $thickness=3.6e-08 $X=0.594
+ $Y=0.234 $X2=0.6075 $Y2=0.234
r32 66 67 3.14806 $w=1.3e-08 $l=1.35e-08 $layer=M1 $thickness=3.6e-08 $X=0.5805
+ $Y=0.234 $X2=0.594 $Y2=0.234
r33 65 66 3.14806 $w=1.3e-08 $l=1.35e-08 $layer=M1 $thickness=3.6e-08 $X=0.567
+ $Y=0.234 $X2=0.5805 $Y2=0.234
r34 64 65 6.29612 $w=1.3e-08 $l=2.7e-08 $layer=M1 $thickness=3.6e-08 $X=0.54
+ $Y=0.234 $X2=0.567 $Y2=0.234
r35 63 64 6.29612 $w=1.3e-08 $l=2.7e-08 $layer=M1 $thickness=3.6e-08 $X=0.513
+ $Y=0.234 $X2=0.54 $Y2=0.234
r36 62 63 6.29612 $w=1.3e-08 $l=2.7e-08 $layer=M1 $thickness=3.6e-08 $X=0.486
+ $Y=0.234 $X2=0.513 $Y2=0.234
r37 61 62 6.29612 $w=1.3e-08 $l=2.7e-08 $layer=M1 $thickness=3.6e-08 $X=0.459
+ $Y=0.234 $X2=0.486 $Y2=0.234
r38 60 61 6.29612 $w=1.3e-08 $l=2.7e-08 $layer=M1 $thickness=3.6e-08 $X=0.432
+ $Y=0.234 $X2=0.459 $Y2=0.234
r39 59 60 6.29612 $w=1.3e-08 $l=2.7e-08 $layer=M1 $thickness=3.6e-08 $X=0.405
+ $Y=0.234 $X2=0.432 $Y2=0.234
r40 58 59 2.3319 $w=1.3e-08 $l=1e-08 $layer=M1 $thickness=3.6e-08 $X=0.395
+ $Y=0.234 $X2=0.405 $Y2=0.234
r41 57 58 4.19742 $w=1.3e-08 $l=1.8e-08 $layer=M1 $thickness=3.6e-08 $X=0.377
+ $Y=0.234 $X2=0.395 $Y2=0.234
r42 56 57 6.06293 $w=1.3e-08 $l=2.6e-08 $layer=M1 $thickness=3.6e-08 $X=0.351
+ $Y=0.234 $X2=0.377 $Y2=0.234
r43 55 56 6.29612 $w=1.3e-08 $l=2.7e-08 $layer=M1 $thickness=3.6e-08 $X=0.324
+ $Y=0.234 $X2=0.351 $Y2=0.234
r44 54 55 6.29612 $w=1.3e-08 $l=2.7e-08 $layer=M1 $thickness=3.6e-08 $X=0.297
+ $Y=0.234 $X2=0.324 $Y2=0.234
r45 53 54 3.14806 $w=1.3e-08 $l=1.35e-08 $layer=M1 $thickness=3.6e-08 $X=0.2835
+ $Y=0.234 $X2=0.297 $Y2=0.234
r46 52 53 3.14806 $w=1.3e-08 $l=1.35e-08 $layer=M1 $thickness=3.6e-08 $X=0.27
+ $Y=0.234 $X2=0.2835 $Y2=0.234
r47 51 52 3.14806 $w=1.3e-08 $l=1.35e-08 $layer=M1 $thickness=3.6e-08 $X=0.2565
+ $Y=0.234 $X2=0.27 $Y2=0.234
r48 50 51 3.14806 $w=1.3e-08 $l=1.35e-08 $layer=M1 $thickness=3.6e-08 $X=0.243
+ $Y=0.234 $X2=0.2565 $Y2=0.234
r49 49 50 2.3319 $w=1.3e-08 $l=1e-08 $layer=M1 $thickness=3.6e-08 $X=0.233
+ $Y=0.234 $X2=0.243 $Y2=0.234
r50 48 49 4.19742 $w=1.3e-08 $l=1.8e-08 $layer=M1 $thickness=3.6e-08 $X=0.215
+ $Y=0.234 $X2=0.233 $Y2=0.234
r51 47 48 6.06293 $w=1.3e-08 $l=2.6e-08 $layer=M1 $thickness=3.6e-08 $X=0.189
+ $Y=0.234 $X2=0.215 $Y2=0.234
r52 46 47 5.94634 $w=1.3e-08 $l=2.55e-08 $layer=M1 $thickness=3.6e-08 $X=0.1635
+ $Y=0.234 $X2=0.189 $Y2=0.234
r53 45 46 4.19742 $w=1.3e-08 $l=1.8e-08 $layer=M1 $thickness=3.6e-08 $X=0.1455
+ $Y=0.234 $X2=0.1635 $Y2=0.234
r54 44 45 2.44849 $w=1.3e-08 $l=1.05e-08 $layer=M1 $thickness=3.6e-08 $X=0.135
+ $Y=0.234 $X2=0.1455 $Y2=0.234
r55 26 44 3.14806 $w=1.3e-08 $l=1.35e-08 $layer=M1 $thickness=3.6e-08 $X=0.1215
+ $Y=0.234 $X2=0.135 $Y2=0.234
r56 21 25 2.89809 $w=1.75231e-08 $l=1.95e-08 $layer=M1 $thickness=3.6e-08
+ $X=0.108 $Y=0.234 $X2=0.108 $Y2=0.2145
r57 21 26 1.49895 $w=1.63333e-08 $l=1.35e-08 $layer=M1 $thickness=3.6e-08
+ $X=0.108 $Y=0.234 $X2=0.1215 $Y2=0.234
r58 25 43 3.36689 $w=1.53077e-08 $l=1.95e-08 $layer=M1 $thickness=3.6e-08
+ $X=0.108 $Y=0.2145 $X2=0.108 $Y2=0.195
r59 42 43 1.96775 $w=1.63333e-08 $l=1.35e-08 $layer=M1 $thickness=3.6e-08
+ $X=0.0945 $Y=0.195 $X2=0.108 $Y2=0.195
r60 20 41 3.48349 $w=1.525e-08 $l=2e-08 $layer=M1 $thickness=3.6e-08 $X=0.081
+ $Y=0.195 $X2=0.081 $Y2=0.175
r61 20 42 1.96775 $w=1.63333e-08 $l=1.35e-08 $layer=M1 $thickness=3.6e-08
+ $X=0.081 $Y=0.195 $X2=0.0945 $Y2=0.195
r62 40 41 4.89699 $w=1.3e-08 $l=2.1e-08 $layer=M1 $thickness=3.6e-08 $X=0.081
+ $Y=0.154 $X2=0.081 $Y2=0.175
r63 39 40 4.43061 $w=1.3e-08 $l=1.9e-08 $layer=M1 $thickness=3.6e-08 $X=0.081
+ $Y=0.135 $X2=0.081 $Y2=0.154
r64 24 39 3.38125 $w=1.3e-08 $l=1.45e-08 $layer=M1 $thickness=3.6e-08 $X=0.081
+ $Y=0.1205 $X2=0.081 $Y2=0.135
r65 1 32 6.54019 $w=2.09524e-08 $layer=Gate_1 $thickness=5.21905e-08 $X=0.081
+ $Y=0.135 $X2=0.081 $Y2=0.135
r66 1 39 19.3796 $a=3.24e-16 $layer=V0LIG $X=0.081 $Y=0.135 $X2=0.081 $Y2=0.135
r67 35 34 14.6259 $w=2.1e-08 $l=4.3e-08 $layer=Gate_1 $thickness=5.6e-08
+ $X=0.081 $Y=0.2025 $X2=0.081 $Y2=0.1595
r68 33 34 2.7211 $w=2.1e-08 $l=8e-09 $layer=Gate_1 $thickness=5.6e-08 $X=0.081
+ $Y=0.1515 $X2=0.081 $Y2=0.1595
r69 32 33 5.79936 $w=2.03333e-08 $l=1.65e-08 $layer=Gate_1 $thickness=5.6e-08
+ $X=0.081 $Y=0.135 $X2=0.081 $Y2=0.1515
r70 31 32 5.79936 $w=2.03333e-08 $l=1.65e-08 $layer=Gate_1 $thickness=5.6e-08
+ $X=0.081 $Y=0.1185 $X2=0.081 $Y2=0.135
r71 30 31 2.7211 $w=2.1e-08 $l=8e-09 $layer=Gate_1 $thickness=5.6e-08 $X=0.081
+ $Y=0.1105 $X2=0.081 $Y2=0.1185
r72 29 30 14.6259 $w=2.1e-08 $l=4.3e-08 $layer=Gate_1 $thickness=5.6e-08
+ $X=0.081 $Y=0.0675 $X2=0.081 $Y2=0.1105
r73 29 15 14.6259 $w=2.1e-08 $l=4.3e-08 $layer=Gate_1 $thickness=5.6e-08
+ $X=0.081 $Y=0.0675 $X2=0.081 $Y2=0.0245
.ends

.subckt PM_OA333x1_ASAP7_75t_R%Y vss 19 13 27 8 11 7
c1 7 vss 0.0481859f $X=0.056 $Y=0.0675
c2 8 vss 0.0470197f $X=0.056 $Y=0.2025
c3 9 vss 0.00648643f $X=0.0405 $Y=0.036
c4 10 vss 0.00565491f $X=0.027 $Y=0.234
c5 11 vss 0.00604981f $X=0.027 $Y=0.0575
r1 27 26 0.0308642 $w=8.1e-08 $l=2.5e-09 $layer=P_src_drn $thickness=1e-09
+ $X=0.0713 $Y=0.2025 $X2=0.0685 $Y2=0.2025
r2 8 26 0.154321 $w=8.1e-08 $l=1.25e-08 $layer=P_src_drn $thickness=1e-09
+ $X=0.056 $Y=0.2025 $X2=0.0685 $Y2=0.2025
r3 8 24 19.3796 $a=3.24e-16 $layer=V0LISD $X=0.056 $Y=0.2025 $X2=0.054 $Y2=0.234
r4 23 24 3.14806 $w=1.3e-08 $l=1.35e-08 $layer=M1 $thickness=3.6e-08 $X=0.0405
+ $Y=0.234 $X2=0.054 $Y2=0.234
r5 10 22 3.36689 $w=1.53077e-08 $l=1.95e-08 $layer=M1 $thickness=3.6e-08
+ $X=0.027 $Y=0.234 $X2=0.027 $Y2=0.2145
r6 10 23 1.96775 $w=1.63333e-08 $l=1.35e-08 $layer=M1 $thickness=3.6e-08
+ $X=0.027 $Y=0.234 $X2=0.0405 $Y2=0.234
r7 21 22 4.5472 $w=1.3e-08 $l=1.95e-08 $layer=M1 $thickness=3.6e-08 $X=0.027
+ $Y=0.195 $X2=0.027 $Y2=0.2145
r8 20 21 7.05399 $w=1.3e-08 $l=3.03e-08 $layer=M1 $thickness=3.6e-08 $X=0.027
+ $Y=0.1647 $X2=0.027 $Y2=0.195
r9 19 20 5.07188 $w=1.3e-08 $l=2.17e-08 $layer=M1 $thickness=3.6e-08 $X=0.03
+ $Y=0.143 $X2=0.027 $Y2=0.1647
r10 19 18 3.32295 $w=1.3e-08 $l=1.43e-08 $layer=M1 $thickness=3.6e-08 $X=0.03
+ $Y=0.143 $X2=0.027 $Y2=0.1287
r11 17 18 8.45313 $w=1.3e-08 $l=3.62e-08 $layer=M1 $thickness=3.6e-08 $X=0.027
+ $Y=0.0925 $X2=0.027 $Y2=0.1287
r12 11 16 3.83327 $w=1.5093e-08 $l=2.15e-08 $layer=M1 $thickness=3.6e-08
+ $X=0.027 $Y=0.0575 $X2=0.027 $Y2=0.036
r13 11 17 8.16164 $w=1.3e-08 $l=3.5e-08 $layer=M1 $thickness=3.6e-08 $X=0.027
+ $Y=0.0575 $X2=0.027 $Y2=0.0925
r14 9 14 3.14806 $w=1.3e-08 $l=1.35e-08 $layer=M1 $thickness=3.6e-08 $X=0.0405
+ $Y=0.036 $X2=0.054 $Y2=0.036
r15 9 16 1.96775 $w=1.63333e-08 $l=1.35e-08 $layer=M1 $thickness=3.6e-08
+ $X=0.0405 $Y=0.036 $X2=0.027 $Y2=0.036
r16 7 14 19.3796 $a=3.24e-16 $layer=V0LISD $X=0.056 $Y=0.0675 $X2=0.054
+ $Y2=0.036
r17 13 12 0.0308642 $w=8.1e-08 $l=2.5e-09 $layer=N_src_drn $thickness=1e-09
+ $X=0.0713 $Y=0.0675 $X2=0.0685 $Y2=0.0675
r18 7 12 0.154321 $w=8.1e-08 $l=1.25e-08 $layer=N_src_drn $thickness=1e-09
+ $X=0.056 $Y=0.0675 $X2=0.0685 $Y2=0.0675
.ends

.subckt PM_OA333x1_ASAP7_75t_R%C2 vss 13 5 9 4 3
c1 1 vss 0.00462223f $X=0.189 $Y=0.135
c2 3 vss 0.12114f $X=0.189 $Y=0.0245
c3 4 vss 0.00791249f $X=0.189 $Y=0.116
r1 13 12 1.22425 $w=1.3e-08 $l=5.3e-09 $layer=M1 $thickness=3.6e-08 $X=0.183
+ $Y=0.154 $X2=0.189 $Y2=0.1487
r2 11 12 3.20636 $w=1.3e-08 $l=1.37e-08 $layer=M1 $thickness=3.6e-08 $X=0.189
+ $Y=0.135 $X2=0.189 $Y2=0.1487
r3 4 11 4.43061 $w=1.3e-08 $l=1.9e-08 $layer=M1 $thickness=3.6e-08 $X=0.189
+ $Y=0.116 $X2=0.189 $Y2=0.135
r4 1 7 10.4265 $w=1.765e-08 $layer=LIG $thickness=5.2e-08 $X=0.189 $Y=0.135
+ $X2=0.189 $Y2=0.135
r5 1 11 19.3796 $a=3.24e-16 $layer=V0LIG $X=0.189 $Y=0.135 $X2=0.189 $Y2=0.135
r6 9 8 16.4967 $w=2.1e-08 $l=4.85e-08 $layer=Gate_1 $thickness=5.6e-08 $X=0.189
+ $Y=0.2025 $X2=0.189 $Y2=0.154
r7 7 8 6.6497 $w=2.04211e-08 $l=1.9e-08 $layer=Gate_1 $thickness=5.6e-08
+ $X=0.189 $Y=0.135 $X2=0.189 $Y2=0.154
r8 6 7 6.6497 $w=2.04211e-08 $l=1.9e-08 $layer=Gate_1 $thickness=5.6e-08
+ $X=0.189 $Y=0.116 $X2=0.189 $Y2=0.135
r9 5 6 16.4967 $w=2.1e-08 $l=4.85e-08 $layer=Gate_1 $thickness=5.6e-08 $X=0.189
+ $Y=0.0675 $X2=0.189 $Y2=0.116
r10 5 3 14.6259 $w=2.1e-08 $l=4.3e-08 $layer=Gate_1 $thickness=5.6e-08 $X=0.189
+ $Y=0.0675 $X2=0.189 $Y2=0.0245
.ends

.subckt PM_OA333x1_ASAP7_75t_R%C1 vss 13 5 9 4 3
c1 1 vss 0.00474401f $X=0.243 $Y=0.135
c2 3 vss 0.102491f $X=0.243 $Y=0.0245
c3 4 vss 0.00665651f $X=0.243 $Y=0.116
r1 13 12 1.34084 $w=1.3e-08 $l=5.8e-09 $layer=M1 $thickness=3.6e-08 $X=0.241
+ $Y=0.155 $X2=0.243 $Y2=0.1492
r2 11 12 3.32295 $w=1.3e-08 $l=1.42e-08 $layer=M1 $thickness=3.6e-08 $X=0.243
+ $Y=0.135 $X2=0.243 $Y2=0.1492
r3 4 11 4.4306 $w=1.3e-08 $l=1.9e-08 $layer=M1 $thickness=3.6e-08 $X=0.243
+ $Y=0.116 $X2=0.243 $Y2=0.135
r4 1 7 10.4265 $w=1.765e-08 $layer=LIG $thickness=5.2e-08 $X=0.243 $Y=0.135
+ $X2=0.243 $Y2=0.135
r5 1 11 19.3796 $a=3.24e-16 $layer=V0LIG $X=0.243 $Y=0.135 $X2=0.243 $Y2=0.135
r6 9 8 16.4967 $w=2.1e-08 $l=4.85e-08 $layer=Gate_1 $thickness=5.6e-08 $X=0.243
+ $Y=0.2025 $X2=0.243 $Y2=0.154
r7 7 8 6.6497 $w=2.04211e-08 $l=1.9e-08 $layer=Gate_1 $thickness=5.6e-08
+ $X=0.243 $Y=0.135 $X2=0.243 $Y2=0.154
r8 6 7 6.6497 $w=2.04211e-08 $l=1.9e-08 $layer=Gate_1 $thickness=5.6e-08
+ $X=0.243 $Y=0.116 $X2=0.243 $Y2=0.135
r9 5 6 16.4967 $w=2.1e-08 $l=4.85e-08 $layer=Gate_1 $thickness=5.6e-08 $X=0.243
+ $Y=0.0675 $X2=0.243 $Y2=0.116
r10 5 3 14.6259 $w=2.1e-08 $l=4.3e-08 $layer=Gate_1 $thickness=5.6e-08 $X=0.243
+ $Y=0.0675 $X2=0.243 $Y2=0.0245
.ends

* End of included file OA333x1_ASAP7_75t_R.pex.sp.pex

*
.subckt OA333x1_ASAP7_75t_CUSTOM_4_25_0_7 VSS VDD C3 C2 C1 B1 B2 B3 A3 A2 A1 Y
*
* VSS VSS
* VDD VDD
* C3 C3
* C2 C2
* C1 C1
* B1 B1
* B2 B2
* B3 B3
* A3 A3
* A2 A2
* A1 A1
* Y Y
*
*

M0 VSS N_M0_g N_M0_s VSS nmos_rvt L=2e-08 W=8.1e-08 nfin=3 $X=0.071 $Y=0.027
M1 noxref_14 N_M1_g VSS VSS nmos_rvt L=2e-08 W=8.1e-08 nfin=3 $X=0.125 $Y=0.027
M2 VSS N_M2_g noxref_14 VSS nmos_rvt L=2e-08 W=8.1e-08 nfin=3 $X=0.179 $Y=0.027
M3 noxref_14 N_M3_g VSS VSS nmos_rvt L=2e-08 W=8.1e-08 nfin=3 $X=0.233 $Y=0.027
M4 noxref_15 N_M4_g noxref_14 VSS nmos_rvt L=2e-08 W=8.1e-08 nfin=3 $X=0.287
+ $Y=0.027
M5 noxref_14 N_M5_g noxref_15 VSS nmos_rvt L=2e-08 W=8.1e-08 nfin=3 $X=0.341
+ $Y=0.027
M6 noxref_15 N_M6_g noxref_14 VSS nmos_rvt L=2e-08 W=8.1e-08 nfin=3 $X=0.395
+ $Y=0.027
M7 N_M7_d N_M7_g noxref_15 VSS nmos_rvt L=2e-08 W=8.1e-08 nfin=3 $X=0.449
+ $Y=0.027
M8 noxref_15 N_M8_g N_M8_s VSS nmos_rvt L=2e-08 W=8.1e-08 nfin=3 $X=0.503
+ $Y=0.027
M9 N_M9_d N_M9_g noxref_15 VSS nmos_rvt L=2e-08 W=8.1e-08 nfin=3 $X=0.557
+ $Y=0.027
M10 VDD N_M10_g N_M10_s VDD pmos_rvt L=2e-08 W=8.1e-08 nfin=3 $X=0.071 $Y=0.162
M11 noxref_16 N_M11_g VDD VDD pmos_rvt L=2e-08 W=8.1e-08 nfin=3 $X=0.125
+ $Y=0.162
M12 noxref_17 N_M12_g noxref_16 VDD pmos_rvt L=2e-08 W=8.1e-08 nfin=3 $X=0.179
+ $Y=0.162
M13 N_M13_d N_M13_g noxref_17 VDD pmos_rvt L=2e-08 W=8.1e-08 nfin=3 $X=0.233
+ $Y=0.162
M14 noxref_18 N_M14_g N_M14_s VDD pmos_rvt L=2e-08 W=8.1e-08 nfin=3 $X=0.287
+ $Y=0.162
M15 noxref_19 N_M15_g noxref_18 VDD pmos_rvt L=2e-08 W=8.1e-08 nfin=3 $X=0.341
+ $Y=0.162
M16 VDD N_M16_g noxref_19 VDD pmos_rvt L=2e-08 W=8.1e-08 nfin=3 $X=0.395
+ $Y=0.162
M17 noxref_20 N_M17_g VDD VDD pmos_rvt L=2e-08 W=8.1e-08 nfin=3 $X=0.449
+ $Y=0.162
M18 noxref_21 N_M18_g noxref_20 VDD pmos_rvt L=2e-08 W=8.1e-08 nfin=3 $X=0.503
+ $Y=0.162
M19 N_M19_d N_M19_g noxref_21 VDD pmos_rvt L=2e-08 W=8.1e-08 nfin=3 $X=0.557
+ $Y=0.162

* .include "OA333x1_ASAP7_75t_R.pex.sp.pxi"

* Start of included file OA333x1_ASAP7_75t_R.pex.sp.pxi
x_PM_OA333x1_ASAP7_75t_R%C3 vss C3 N_M1_g N_M11_g N_C3_3 N_C3_4
+ PM_OA333x1_ASAP7_75t_R%C3
cc_1 N_C3_3 N_3_20 0.000608561f $X=0.135 $Y=0.0245
cc_2 N_C3_3 N_3_1 0.00193579f $X=0.135 $Y=0.0245
cc_3 N_C3_4 N_3_24 0.00306559f $X=0.135 $Y=0.0925
cc_4 N_C3_3 N_3_15 0.00351502f $X=0.135 $Y=0.0245
x_PM_OA333x1_ASAP7_75t_R%B1 vss B1 N_M4_g N_M14_g N_B1_4 N_B1_3
+ PM_OA333x1_ASAP7_75t_R%B1
cc_5 N_B1_4 N_3_26 0.00123237f $X=0.297 $Y=0.116
cc_6 N_B1_3 N_3_3 0.0015125f $X=0.297 $Y=0.0245
cc_7 N_B1_4 N_3_3 0.00183394f $X=0.297 $Y=0.116
cc_8 N_B1_3 N_3_18 0.0360532f $X=0.297 $Y=0.0245
cc_9 N_B1_3 N_C1_3 0.00317569f $X=0.297 $Y=0.0245
cc_10 N_B1_4 N_C1_4 0.00499301f $X=0.297 $Y=0.116
x_PM_OA333x1_ASAP7_75t_R%B2 vss B2 N_M5_g N_M15_g N_B2_4 N_B2_3
+ PM_OA333x1_ASAP7_75t_R%B2
cc_11 N_B2_4 N_3_3 0.00033579f $X=0.351 $Y=0.116
cc_12 N_B2_4 N_3_26 0.00327434f $X=0.351 $Y=0.116
cc_13 N_B2_4 N_B1_4 0.00333721f $X=0.351 $Y=0.116
cc_14 N_B2_3 N_B1_3 0.00692092f $X=0.351 $Y=0.0245
x_PM_OA333x1_ASAP7_75t_R%B3 vss B3 N_M6_g N_M16_g N_B3_4 N_B3_3
+ PM_OA333x1_ASAP7_75t_R%B3
cc_15 N_B3_4 N_3_26 0.00280285f $X=0.405 $Y=0.116
cc_16 N_B3_4 N_B2_4 0.00334073f $X=0.405 $Y=0.116
cc_17 N_B3_3 N_B2_3 0.00702997f $X=0.405 $Y=0.0245
x_PM_OA333x1_ASAP7_75t_R%A3 vss A3 N_M7_g N_M17_g N_A3_3 N_A3_4
+ PM_OA333x1_ASAP7_75t_R%A3
cc_18 N_A3_3 N_3_4 0.00115527f $X=0.459 $Y=0.0245
cc_19 N_A3_3 N_3_27 0.000603646f $X=0.459 $Y=0.0245
cc_20 N_A3_4 N_3_26 0.00132743f $X=0.459 $Y=0.1122
cc_21 N_A3_4 N_3_4 0.00211967f $X=0.459 $Y=0.1122
cc_22 N_A3_3 N_3_16 0.0355328f $X=0.459 $Y=0.0245
cc_23 N_A3_3 N_B3_3 0.0031747f $X=0.459 $Y=0.0245
cc_24 N_A3_4 N_B3_4 0.00518212f $X=0.459 $Y=0.1122
x_PM_OA333x1_ASAP7_75t_R%A2 vss A2 N_M8_g N_M18_g N_A2_3 N_A2_1 N_A2_4
+ PM_OA333x1_ASAP7_75t_R%A2
cc_25 N_A2_3 N_3_4 0.00158048f $X=0.513 $Y=0.0245
cc_26 N_A2_1 N_3_16 0.000812315f $X=0.513 $Y=0.135
cc_27 N_A2_4 N_3_27 0.00109371f $X=0.513 $Y=0.116
cc_28 N_A2_4 N_3_26 0.00141931f $X=0.513 $Y=0.116
cc_29 N_A2_4 N_3_4 0.00278658f $X=0.513 $Y=0.116
cc_30 N_A2_3 N_3_16 0.0351419f $X=0.513 $Y=0.0245
cc_31 N_A2_4 N_A3_4 0.00334567f $X=0.513 $Y=0.116
cc_32 N_A2_3 N_A3_3 0.00695167f $X=0.513 $Y=0.0245
x_PM_OA333x1_ASAP7_75t_R%A1 vss A1 N_M9_g N_M19_g N_A1_3 N_A1_4 N_A1_1
+ PM_OA333x1_ASAP7_75t_R%A1
cc_33 N_A1_3 N_3_5 0.00210425f $X=0.567 $Y=0.0245
cc_34 N_A1_3 N_3_17 0.0152422f $X=0.567 $Y=0.0245
cc_35 N_A1_3 N_3_27 0.00104906f $X=0.567 $Y=0.0245
cc_36 N_A1_4 N_3_26 0.00114071f $X=0.567 $Y=0.116
cc_37 N_A1_3 N_3_6 0.00155808f $X=0.567 $Y=0.0245
cc_38 N_A1_1 N_3_17 0.00182982f $X=0.567 $Y=0.135
cc_39 N_A1_4 N_3_28 0.00658686f $X=0.567 $Y=0.116
cc_40 N_A1_3 N_3_19 0.0544897f $X=0.567 $Y=0.0245
cc_41 N_A1_4 N_A2_4 0.00333124f $X=0.567 $Y=0.116
cc_42 N_A1_3 N_A2_3 0.00708475f $X=0.567 $Y=0.0245
x_PM_OA333x1_ASAP7_75t_R%3 vss N_M0_g N_M10_g N_M13_d N_M14_s N_M19_d N_M9_d
+ N_M7_d N_M8_s N_3_20 N_3_1 N_3_24 N_3_15 N_3_18 N_3_3 N_3_26 N_3_4 N_3_27
+ N_3_16 N_3_5 N_3_17 N_3_6 N_3_28 N_3_19 N_3_25 N_3_21 PM_OA333x1_ASAP7_75t_R%3
x_PM_OA333x1_ASAP7_75t_R%Y vss Y N_M0_s N_M10_s N_Y_8 N_Y_11 N_Y_7
+ PM_OA333x1_ASAP7_75t_R%Y
cc_43 N_Y_8 N_3_20 0.00256568f $X=0.056 $Y=0.2025
cc_44 N_Y_8 N_3_25 0.00034497f $X=0.056 $Y=0.2025
cc_45 N_Y_8 N_3_21 0.000406002f $X=0.056 $Y=0.2025
cc_46 N_Y_8 N_3_1 0.00252186f $X=0.056 $Y=0.2025
cc_47 N_Y_11 N_3_24 0.00443748f $X=0.027 $Y=0.0575
cc_48 N_Y_7 N_3_15 0.0148613f $X=0.056 $Y=0.0675
cc_49 N_Y_8 N_3_15 0.0563601f $X=0.056 $Y=0.2025
x_PM_OA333x1_ASAP7_75t_R%C2 vss C2 N_M2_g N_M12_g N_C2_4 N_C2_3
+ PM_OA333x1_ASAP7_75t_R%C2
cc_50 N_C2_4 N_3_18 0.000188903f $X=0.189 $Y=0.116
cc_51 N_C2_4 N_3_3 0.00033642f $X=0.189 $Y=0.116
cc_52 N_C2_4 N_3_26 0.00151697f $X=0.189 $Y=0.116
cc_53 N_C2_4 N_3_20 0.00237968f $X=0.189 $Y=0.116
cc_54 N_C2_4 N_C3_4 0.00380643f $X=0.189 $Y=0.116
cc_55 N_C2_3 N_C3_3 0.00699099f $X=0.189 $Y=0.0245
x_PM_OA333x1_ASAP7_75t_R%C1 vss C1 N_M3_g N_M13_g N_C1_4 N_C1_3
+ PM_OA333x1_ASAP7_75t_R%C1
cc_56 N_C1_4 N_3_26 0.00125372f $X=0.243 $Y=0.116
cc_57 N_C1_3 N_3_3 0.00151236f $X=0.243 $Y=0.0245
cc_58 N_C1_4 N_3_3 0.00184178f $X=0.243 $Y=0.116
cc_59 N_C1_3 N_3_18 0.036053f $X=0.243 $Y=0.0245
cc_60 N_C1_4 N_C2_4 0.00370348f $X=0.243 $Y=0.116
cc_61 N_C1_3 N_C2_3 0.00706024f $X=0.243 $Y=0.0245

* End of included file OA333x1_ASAP7_75t_R.pex.sp.pxi
.ends

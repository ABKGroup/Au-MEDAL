.subckt PM_OAI32xp33_ASAP7_75t_R%A2 vss 14 5 9 1 4 3
c1 1 vss 0.00243976f $X=0.135 $Y=0.135
c2 3 vss 0.103256f $X=0.135 $Y=0.0245
c3 4 vss 0.0062371f $X=0.135 $Y=0.0755
r1 14 13 5.59655 $w=1.3e-08 $l=2.4e-08 $layer=M1 $thickness=3.6e-08 $X=0.135
+ $Y=0.1915 $X2=0.135 $Y2=0.1675
r2 12 13 7.57867 $w=1.3e-08 $l=3.25e-08 $layer=M1 $thickness=3.6e-08 $X=0.135
+ $Y=0.135 $X2=0.135 $Y2=0.1675
r3 11 12 7.34548 $w=1.3e-08 $l=3.15e-08 $layer=M1 $thickness=3.6e-08 $X=0.135
+ $Y=0.1035 $X2=0.135 $Y2=0.135
r4 4 11 6.52931 $w=1.3e-08 $l=2.8e-08 $layer=M1 $thickness=3.6e-08 $X=0.135
+ $Y=0.0755 $X2=0.135 $Y2=0.1035
r5 1 7 10.4265 $w=1.765e-08 $layer=LIG $thickness=5.2e-08 $X=0.135 $Y=0.135
+ $X2=0.135 $Y2=0.135
r6 1 12 19.3796 $a=3.24e-16 $layer=V0LIG $X=0.135 $Y=0.135 $X2=0.135 $Y2=0.135
r7 9 8 16.4967 $w=2.1e-08 $l=4.85e-08 $layer=Gate_1 $thickness=5.6e-08 $X=0.135
+ $Y=0.2025 $X2=0.135 $Y2=0.154
r8 7 8 6.6497 $w=2.04211e-08 $l=1.9e-08 $layer=Gate_1 $thickness=5.6e-08
+ $X=0.135 $Y=0.135 $X2=0.135 $Y2=0.154
r9 6 7 11.2416 $w=2.06615e-08 $l=3.25e-08 $layer=Gate_1 $thickness=5.6e-08
+ $X=0.135 $Y=0.1025 $X2=0.135 $Y2=0.135
r10 5 6 16.4967 $w=2.1e-08 $l=4.85e-08 $layer=Gate_1 $thickness=5.6e-08
+ $X=0.135 $Y=0.054 $X2=0.135 $Y2=0.1025
r11 5 3 10.0341 $w=2.1e-08 $l=2.95e-08 $layer=Gate_1 $thickness=5.6e-08
+ $X=0.135 $Y=0.054 $X2=0.135 $Y2=0.0245
.ends

.subckt PM_OAI32xp33_ASAP7_75t_R%B1 vss 13 5 9 4 3
c1 1 vss 0.00490443f $X=0.243 $Y=0.135
c2 3 vss 0.0891244f $X=0.243 $Y=0.0245
c3 4 vss 0.00352518f $X=0.243 $Y=0.116
r1 13 12 0.816164 $w=1.3e-08 $l=3.5e-09 $layer=M1 $thickness=3.6e-08 $X=0.243
+ $Y=0.1505 $X2=0.243 $Y2=0.147
r2 11 12 2.79828 $w=1.3e-08 $l=1.2e-08 $layer=M1 $thickness=3.6e-08 $X=0.243
+ $Y=0.135 $X2=0.243 $Y2=0.147
r3 4 11 4.4306 $w=1.3e-08 $l=1.9e-08 $layer=M1 $thickness=3.6e-08 $X=0.243
+ $Y=0.116 $X2=0.243 $Y2=0.135
r4 1 7 10.4265 $w=1.765e-08 $layer=LIG $thickness=5.2e-08 $X=0.243 $Y=0.135
+ $X2=0.243 $Y2=0.135
r5 1 11 19.3796 $a=3.24e-16 $layer=V0LIG $X=0.243 $Y=0.135 $X2=0.243 $Y2=0.135
r6 9 8 16.4967 $w=2.1e-08 $l=4.85e-08 $layer=Gate_1 $thickness=5.6e-08 $X=0.243
+ $Y=0.216 $X2=0.243 $Y2=0.1675
r7 7 8 11.2416 $w=2.06615e-08 $l=3.25e-08 $layer=Gate_1 $thickness=5.6e-08
+ $X=0.243 $Y=0.135 $X2=0.243 $Y2=0.1675
r8 6 7 11.2416 $w=2.06615e-08 $l=3.25e-08 $layer=Gate_1 $thickness=5.6e-08
+ $X=0.243 $Y=0.1025 $X2=0.243 $Y2=0.135
r9 5 6 16.4967 $w=2.1e-08 $l=4.85e-08 $layer=Gate_1 $thickness=5.6e-08 $X=0.243
+ $Y=0.054 $X2=0.243 $Y2=0.1025
r10 5 3 10.0341 $w=2.1e-08 $l=2.95e-08 $layer=Gate_1 $thickness=5.6e-08
+ $X=0.243 $Y=0.054 $X2=0.243 $Y2=0.0245
.ends

.subckt PM_OAI32xp33_ASAP7_75t_R%B2 vss 13 5 11 4 3
c1 1 vss 0.0025406f $X=0.297 $Y=0.135
c2 3 vss 0.05711f $X=0.297 $Y=0.0245
c3 4 vss 0.00748582f $X=0.297 $Y=0.111
r1 14 15 3.14806 $w=1.3e-08 $l=1.35e-08 $layer=M1 $thickness=3.6e-08 $X=0.297
+ $Y=0.1215 $X2=0.297 $Y2=0.135
r2 13 14 1.16595 $w=1.3e-08 $l=5e-09 $layer=M1 $thickness=3.6e-08 $X=0.298
+ $Y=0.1165 $X2=0.297 $Y2=0.1215
r3 13 4 1.28254 $w=1.3e-08 $l=5.5e-09 $layer=M1 $thickness=3.6e-08 $X=0.298
+ $Y=0.1165 $X2=0.297 $Y2=0.111
r4 1 8 10.4265 $w=1.765e-08 $layer=LIG $thickness=5.2e-08 $X=0.297 $Y=0.135
+ $X2=0.297 $Y2=0.135
r5 1 15 19.3796 $a=3.24e-16 $layer=V0LIG $X=0.297 $Y=0.135 $X2=0.297 $Y2=0.135
r6 11 10 14.6259 $w=2.1e-08 $l=4.3e-08 $layer=Gate_1 $thickness=5.6e-08
+ $X=0.297 $Y=0.216 $X2=0.297 $Y2=0.173
r7 9 10 7.31297 $w=2.1e-08 $l=2.15e-08 $layer=Gate_1 $thickness=5.6e-08
+ $X=0.297 $Y=0.1515 $X2=0.297 $Y2=0.173
r8 8 9 5.79936 $w=2.03333e-08 $l=1.65e-08 $layer=Gate_1 $thickness=5.6e-08
+ $X=0.297 $Y=0.135 $X2=0.297 $Y2=0.1515
r9 7 8 5.79936 $w=2.03333e-08 $l=1.65e-08 $layer=Gate_1 $thickness=5.6e-08
+ $X=0.297 $Y=0.1185 $X2=0.297 $Y2=0.135
r10 6 7 7.31297 $w=2.1e-08 $l=2.15e-08 $layer=Gate_1 $thickness=5.6e-08
+ $X=0.297 $Y=0.097 $X2=0.297 $Y2=0.1185
r11 5 6 14.6259 $w=2.1e-08 $l=4.3e-08 $layer=Gate_1 $thickness=5.6e-08 $X=0.297
+ $Y=0.054 $X2=0.297 $Y2=0.097
r12 5 3 10.0341 $w=2.1e-08 $l=2.95e-08 $layer=Gate_1 $thickness=5.6e-08
+ $X=0.297 $Y=0.054 $X2=0.297 $Y2=0.0245
.ends

.subckt PM_OAI32xp33_ASAP7_75t_R%Y vss 29 20 21 49 51 15 1 11 16 10 17 3 12
c1 1 vss 0.0074121f $X=0.054 $Y=0.2025
c2 2 vss 0.0079902f $X=0.27 $Y=0.054
c3 3 vss 0.00620158f $X=0.324 $Y=0.216
c4 10 vss 0.00392611f $X=0.2555 $Y=0.054
c5 11 vss 0.0375587f $X=0.056 $Y=0.2025
c6 12 vss 0.0277678f $X=0.3095 $Y=0.216
c7 13 vss 0.0023545f $X=0.351 $Y=0.072
c8 14 vss 0.00275261f $X=0.351 $Y=0.2302
c9 15 vss 0.0263728f $X=0.3105 $Y=0.234
c10 16 vss 0.00746867f $X=0.2585 $Y=0.072
c11 17 vss 0.00484697f $X=0.351 $Y=0.0935
r1 51 50 0.0308642 $w=8.1e-08 $l=2.5e-09 $layer=P_src_drn $thickness=1e-09
+ $X=0.0713 $Y=0.2025 $X2=0.0685 $Y2=0.2025
r2 11 50 0.154321 $w=8.1e-08 $l=1.25e-08 $layer=P_src_drn $thickness=1e-09
+ $X=0.056 $Y=0.2025 $X2=0.0685 $Y2=0.2025
r3 12 3 0.231482 $w=5.4e-08 $l=1.25e-08 $layer=P_src_drn $thickness=1e-09
+ $X=0.3095 $Y=0.216 $X2=0.324 $Y2=0.216
r4 49 12 0.0462963 $w=5.4e-08 $l=2.5e-09 $layer=P_src_drn $thickness=1e-09
+ $X=0.3066 $Y=0.216 $X2=0.3095 $Y2=0.216
r5 1 46 19.3796 $a=3.24e-16 $layer=V0LISD $X=0.054 $Y=0.2025 $X2=0.054 $Y2=0.234
r6 3 31 19.3796 $a=3.24e-16 $layer=V0LISD $X=0.324 $Y=0.216 $X2=0.324 $Y2=0.234
r7 46 47 3.14806 $w=1.3e-08 $l=1.35e-08 $layer=M1 $thickness=3.6e-08 $X=0.054
+ $Y=0.234 $X2=0.0675 $Y2=0.234
r8 44 47 3.14806 $w=1.3e-08 $l=1.35e-08 $layer=M1 $thickness=3.6e-08 $X=0.081
+ $Y=0.234 $X2=0.0675 $Y2=0.234
r9 43 44 3.14806 $w=1.3e-08 $l=1.35e-08 $layer=M1 $thickness=3.6e-08 $X=0.0945
+ $Y=0.234 $X2=0.081 $Y2=0.234
r10 42 43 4.19742 $w=1.3e-08 $l=1.8e-08 $layer=M1 $thickness=3.6e-08 $X=0.1125
+ $Y=0.234 $X2=0.0945 $Y2=0.234
r11 41 42 5.24677 $w=1.3e-08 $l=2.25e-08 $layer=M1 $thickness=3.6e-08 $X=0.135
+ $Y=0.234 $X2=0.1125 $Y2=0.234
r12 40 41 6.29612 $w=1.3e-08 $l=2.7e-08 $layer=M1 $thickness=3.6e-08 $X=0.162
+ $Y=0.234 $X2=0.135 $Y2=0.234
r13 39 40 6.29612 $w=1.3e-08 $l=2.7e-08 $layer=M1 $thickness=3.6e-08 $X=0.189
+ $Y=0.234 $X2=0.162 $Y2=0.234
r14 38 39 4.89699 $w=1.3e-08 $l=2.1e-08 $layer=M1 $thickness=3.6e-08 $X=0.21
+ $Y=0.234 $X2=0.189 $Y2=0.234
r15 37 38 4.19742 $w=1.3e-08 $l=1.8e-08 $layer=M1 $thickness=3.6e-08 $X=0.228
+ $Y=0.234 $X2=0.21 $Y2=0.234
r16 36 37 3.49785 $w=1.3e-08 $l=1.5e-08 $layer=M1 $thickness=3.6e-08 $X=0.243
+ $Y=0.234 $X2=0.228 $Y2=0.234
r17 35 36 2.56509 $w=1.3e-08 $l=1.1e-08 $layer=M1 $thickness=3.6e-08 $X=0.254
+ $Y=0.234 $X2=0.243 $Y2=0.234
r18 34 35 4.19742 $w=1.3e-08 $l=1.8e-08 $layer=M1 $thickness=3.6e-08 $X=0.272
+ $Y=0.234 $X2=0.254 $Y2=0.234
r19 33 34 5.82974 $w=1.3e-08 $l=2.5e-08 $layer=M1 $thickness=3.6e-08 $X=0.297
+ $Y=0.234 $X2=0.272 $Y2=0.234
r20 31 32 3.14806 $w=1.3e-08 $l=1.35e-08 $layer=M1 $thickness=3.6e-08 $X=0.324
+ $Y=0.234 $X2=0.3375 $Y2=0.234
r21 15 31 3.14806 $w=1.3e-08 $l=1.35e-08 $layer=M1 $thickness=3.6e-08 $X=0.3105
+ $Y=0.234 $X2=0.324 $Y2=0.234
r22 15 33 3.14806 $w=1.3e-08 $l=1.35e-08 $layer=M1 $thickness=3.6e-08 $X=0.3105
+ $Y=0.234 $X2=0.297 $Y2=0.234
r23 29 32 1.10038 $w=5e-09 $l=1.36473e-08 $layer=M1 $thickness=3.6e-08 $X=0.349
+ $Y=0.236 $X2=0.3375 $Y2=0.234
r24 29 14 0.586756 $w=1.8e-08 $l=5.8e-09 $layer=M1 $thickness=3.6e-08 $X=0.349
+ $Y=0.236 $X2=0.351 $Y2=0.2302
r25 14 28 3.45061 $w=1.44789e-08 $l=1.77e-08 $layer=M1 $thickness=3.6e-08
+ $X=0.351 $Y=0.2302 $X2=0.351 $Y2=0.2125
r26 27 28 13.8748 $w=1.3e-08 $l=5.95e-08 $layer=M1 $thickness=3.6e-08 $X=0.351
+ $Y=0.153 $X2=0.351 $Y2=0.2125
r27 17 27 13.8748 $w=1.3e-08 $l=5.95e-08 $layer=M1 $thickness=3.6e-08 $X=0.351
+ $Y=0.0935 $X2=0.351 $Y2=0.153
r28 13 26 0.915974 $w=1.70909e-08 $l=1.1e-08 $layer=M1 $thickness=3.6e-08
+ $X=0.351 $Y=0.072 $X2=0.34 $Y2=0.072
r29 13 17 3.36447 $w=1.71023e-08 $l=2.15e-08 $layer=M1 $thickness=3.6e-08
+ $X=0.351 $Y=0.072 $X2=0.351 $Y2=0.0935
r30 25 26 4.19742 $w=1.3e-08 $l=1.8e-08 $layer=M1 $thickness=3.6e-08 $X=0.322
+ $Y=0.072 $X2=0.34 $Y2=0.072
r31 24 25 5.82974 $w=1.3e-08 $l=2.5e-08 $layer=M1 $thickness=3.6e-08 $X=0.297
+ $Y=0.072 $X2=0.322 $Y2=0.072
r32 23 24 3.14806 $w=1.3e-08 $l=1.35e-08 $layer=M1 $thickness=3.6e-08 $X=0.2835
+ $Y=0.072 $X2=0.297 $Y2=0.072
r33 22 23 3.14806 $w=1.3e-08 $l=1.35e-08 $layer=M1 $thickness=3.6e-08 $X=0.27
+ $Y=0.072 $X2=0.2835 $Y2=0.072
r34 16 22 2.68168 $w=1.3e-08 $l=1.15e-08 $layer=M1 $thickness=3.6e-08 $X=0.2585
+ $Y=0.072 $X2=0.27 $Y2=0.072
r35 2 22 19.3796 $a=3.24e-16 $layer=V0LISD $X=0.27 $Y=0.054 $X2=0.27 $Y2=0.072
r36 21 19 0.0462963 $w=5.4e-08 $l=2.5e-09 $layer=N_src_drn $thickness=1e-09
+ $X=0.2873 $Y=0.054 $X2=0.2845 $Y2=0.054
r37 2 19 0.268519 $w=5.4e-08 $l=1.45e-08 $layer=N_src_drn $thickness=1e-09
+ $X=0.27 $Y=0.054 $X2=0.2845 $Y2=0.054
r38 10 2 0.268519 $w=5.4e-08 $l=1.45e-08 $layer=N_src_drn $thickness=1e-09
+ $X=0.2555 $Y=0.054 $X2=0.27 $Y2=0.054
r39 20 10 0.0462963 $w=5.4e-08 $l=2.5e-09 $layer=N_src_drn $thickness=1e-09
+ $X=0.2526 $Y=0.054 $X2=0.2555 $Y2=0.054
r40 1 11 1e-05 $l=2e-09 $X=0.054 $Y=0.2025 $X2=0.056 $Y2=0.2025
.ends

.subckt PM_OAI32xp33_ASAP7_75t_R%A3 vss 15 6 10 3 5
c1 1 vss 0.00395227f $X=0.189 $Y=0.135
c2 3 vss 0.135173f $X=0.189 $Y=0.0245
c3 4 vss 0.00645328f $X=0.1832 $Y=0.072
c4 5 vss 0.00444493f $X=0.189 $Y=0.0935
r1 15 4 0.382667 $w=1.8e-08 $l=3.8e-09 $layer=M1 $thickness=3.6e-08 $X=0.187
+ $Y=0.0755 $X2=0.1832 $Y2=0.072
r2 12 13 4.4306 $w=1.3e-08 $l=1.9e-08 $layer=M1 $thickness=3.6e-08 $X=0.189
+ $Y=0.116 $X2=0.189 $Y2=0.135
r3 5 12 5.24677 $w=1.3e-08 $l=2.25e-08 $layer=M1 $thickness=3.6e-08 $X=0.189
+ $Y=0.0935 $X2=0.189 $Y2=0.116
r4 15 5 2.96589 $w=1.31923e-08 $l=2.15928e-08 $layer=M1 $thickness=3.6e-08
+ $X=0.187 $Y=0.0755 $X2=0.189 $Y2=0.0935
r5 1 8 10.4265 $w=1.765e-08 $layer=LIG $thickness=5.2e-08 $X=0.189 $Y=0.135
+ $X2=0.189 $Y2=0.135
r6 1 13 19.3796 $a=3.24e-16 $layer=V0LIG $X=0.189 $Y=0.135 $X2=0.189 $Y2=0.135
r7 10 9 16.4967 $w=2.1e-08 $l=4.85e-08 $layer=Gate_1 $thickness=5.6e-08
+ $X=0.189 $Y=0.2025 $X2=0.189 $Y2=0.154
r8 8 9 6.6497 $w=2.04211e-08 $l=1.9e-08 $layer=Gate_1 $thickness=5.6e-08
+ $X=0.189 $Y=0.135 $X2=0.189 $Y2=0.154
r9 7 8 11.2416 $w=2.06615e-08 $l=3.25e-08 $layer=Gate_1 $thickness=5.6e-08
+ $X=0.189 $Y=0.1025 $X2=0.189 $Y2=0.135
r10 6 7 16.4967 $w=2.1e-08 $l=4.85e-08 $layer=Gate_1 $thickness=5.6e-08
+ $X=0.189 $Y=0.054 $X2=0.189 $Y2=0.1025
r11 6 3 10.0341 $w=2.1e-08 $l=2.95e-08 $layer=Gate_1 $thickness=5.6e-08
+ $X=0.189 $Y=0.054 $X2=0.189 $Y2=0.0245
.ends

.subckt PM_OAI32xp33_ASAP7_75t_R%A1 vss 13 5 11 3 4
c1 1 vss 0.00323885f $X=0.081 $Y=0.135
c2 3 vss 0.0869162f $X=0.081 $Y=0.0245
c3 4 vss 0.0116794f $X=0.081 $Y=0.081
r1 14 15 5.94634 $w=1.3e-08 $l=2.55e-08 $layer=M1 $thickness=3.6e-08 $X=0.081
+ $Y=0.1095 $X2=0.081 $Y2=0.135
r2 13 14 3.96423 $w=1.3e-08 $l=1.7e-08 $layer=M1 $thickness=3.6e-08 $X=0.078
+ $Y=0.0925 $X2=0.081 $Y2=0.1095
r3 13 4 2.68168 $w=1.3e-08 $l=1.15e-08 $layer=M1 $thickness=3.6e-08 $X=0.078
+ $Y=0.0925 $X2=0.081 $Y2=0.081
r4 1 8 10.4265 $w=1.765e-08 $layer=LIG $thickness=5.2e-08 $X=0.081 $Y=0.135
+ $X2=0.081 $Y2=0.135
r5 1 15 19.3796 $a=3.24e-16 $layer=V0LIG $X=0.081 $Y=0.135 $X2=0.081 $Y2=0.135
r6 11 10 14.6259 $w=2.1e-08 $l=4.3e-08 $layer=Gate_1 $thickness=5.6e-08
+ $X=0.081 $Y=0.2025 $X2=0.081 $Y2=0.1595
r7 9 10 2.7211 $w=2.1e-08 $l=8e-09 $layer=Gate_1 $thickness=5.6e-08 $X=0.081
+ $Y=0.1515 $X2=0.081 $Y2=0.1595
r8 8 9 5.79936 $w=2.03333e-08 $l=1.65e-08 $layer=Gate_1 $thickness=5.6e-08
+ $X=0.081 $Y=0.135 $X2=0.081 $Y2=0.1515
r9 7 8 5.79936 $w=2.03333e-08 $l=1.65e-08 $layer=Gate_1 $thickness=5.6e-08
+ $X=0.081 $Y=0.1185 $X2=0.081 $Y2=0.135
r10 6 7 7.31297 $w=2.1e-08 $l=2.15e-08 $layer=Gate_1 $thickness=5.6e-08
+ $X=0.081 $Y=0.097 $X2=0.081 $Y2=0.1185
r11 5 6 14.6259 $w=2.1e-08 $l=4.3e-08 $layer=Gate_1 $thickness=5.6e-08 $X=0.081
+ $Y=0.054 $X2=0.081 $Y2=0.097
r12 5 3 10.0341 $w=2.1e-08 $l=2.95e-08 $layer=Gate_1 $thickness=5.6e-08
+ $X=0.081 $Y=0.054 $X2=0.081 $Y2=0.0245
.ends

* End of included file OAI32xp33_ASAP7_75t_R.pex.sp.pex

*
.subckt OAI32xp33_ASAP7_75t_CUSTOM_4_25_0_7 VSS VDD A1 A2 A3 B1 B2 Y
*
* VSS VSS
* VDD VDD
* A1 A1
* A2 A2
* A3 A3
* B1 B1
* B2 B2
* Y Y
*
*

M0 noxref_8 N_M0_g VSS VSS nmos_rvt L=2e-08 W=5.4e-08 nfin=2 $X=0.071 $Y=0.027
M1 VSS N_M1_g noxref_8 VSS nmos_rvt L=2e-08 W=5.4e-08 nfin=2 $X=0.125 $Y=0.027
M2 noxref_8 N_M2_g VSS VSS nmos_rvt L=2e-08 W=5.4e-08 nfin=2 $X=0.179 $Y=0.027
M3 N_M3_d N_M3_g noxref_8 VSS nmos_rvt L=2e-08 W=5.4e-08 nfin=2 $X=0.233
+ $Y=0.027
M4 noxref_8 N_M4_g N_M4_s VSS nmos_rvt L=2e-08 W=5.4e-08 nfin=2 $X=0.287
+ $Y=0.027
M5 noxref_10 N_M5_g N_M5_s VDD pmos_rvt L=2e-08 W=8.1e-08 nfin=3 $X=0.071
+ $Y=0.162
M6 noxref_11 N_M6_g noxref_10 VDD pmos_rvt L=2e-08 W=8.1e-08 nfin=3 $X=0.125
+ $Y=0.162
M7 VDD N_M7_g noxref_11 VDD pmos_rvt L=2e-08 W=8.1e-08 nfin=3 $X=0.179 $Y=0.162
M8 noxref_12 N_M8_g VDD VDD pmos_rvt L=2e-08 W=5.4e-08 nfin=2 $X=0.233 $Y=0.189
M9 N_M9_d N_M9_g noxref_12 VDD pmos_rvt L=2e-08 W=5.4e-08 nfin=2 $X=0.287
+ $Y=0.189

* .include "OAI32xp33_ASAP7_75t_R.pex.sp.pxi"

* Start of included file OAI32xp33_ASAP7_75t_R.pex.sp.pxi
x_PM_OAI32xp33_ASAP7_75t_R%A2 vss A2 N_M1_g N_M6_g N_A2_1 N_A2_4 N_A2_3
+ PM_OAI32xp33_ASAP7_75t_R%A2
cc_1 N_A2_1 N_A1_3 0.00158165f $X=0.135 $Y=0.135
cc_2 N_A2_4 N_A1_4 0.004846f $X=0.135 $Y=0.0755
cc_3 N_A2_3 N_A1_3 0.007935f $X=0.135 $Y=0.0245
x_PM_OAI32xp33_ASAP7_75t_R%B1 vss B1 N_M3_g N_M8_g N_B1_4 N_B1_3
+ PM_OAI32xp33_ASAP7_75t_R%B1
cc_4 N_B1_4 N_A3_5 0.00380959f $X=0.243 $Y=0.116
cc_5 N_B1_3 N_A3_3 0.00739231f $X=0.243 $Y=0.0245
x_PM_OAI32xp33_ASAP7_75t_R%B2 vss B2 N_M4_g N_M9_g N_B2_4 N_B2_3
+ PM_OAI32xp33_ASAP7_75t_R%B2
cc_6 N_B2_4 N_B1_4 0.00337567f $X=0.297 $Y=0.111
cc_7 N_B2_3 N_B1_3 0.0108513f $X=0.297 $Y=0.0245
x_PM_OAI32xp33_ASAP7_75t_R%Y vss Y N_M3_d N_M4_s N_M9_d N_M5_s N_Y_15 N_Y_1
+ N_Y_11 N_Y_16 N_Y_10 N_Y_17 N_Y_3 N_Y_12 PM_OAI32xp33_ASAP7_75t_R%Y
cc_8 N_Y_15 N_A1_3 0.00134824f $X=0.3105 $Y=0.234
cc_9 N_Y_1 N_A1_3 0.00181257f $X=0.054 $Y=0.2025
cc_10 N_Y_1 N_A1_4 0.0021657f $X=0.054 $Y=0.2025
cc_11 N_Y_11 N_A1_3 0.037038f $X=0.056 $Y=0.2025
cc_12 N_Y_15 N_A2_4 0.00357779f $X=0.3105 $Y=0.234
cc_13 N_Y_15 N_A3_5 0.00416092f $X=0.3105 $Y=0.234
cc_14 N_Y_16 N_B1_4 0.000525437f $X=0.2585 $Y=0.072
cc_15 N_Y_15 N_B1_4 0.00331796f $X=0.3105 $Y=0.234
cc_16 N_Y_10 N_B1_3 0.0267932f $X=0.2555 $Y=0.054
cc_17 N_Y_17 N_B2_3 0.000739302f $X=0.351 $Y=0.0935
cc_18 N_Y_10 N_B2_3 0.0114328f $X=0.2555 $Y=0.054
cc_19 N_Y_3 N_B2_3 0.000913499f $X=0.324 $Y=0.216
cc_20 N_Y_16 N_B2_4 0.00103295f $X=0.2585 $Y=0.072
cc_21 N_Y_15 N_B2_4 0.00113739f $X=0.3105 $Y=0.234
cc_22 N_Y_17 N_B2_4 0.00659289f $X=0.351 $Y=0.0935
cc_23 N_Y_12 N_B2_3 0.0414758f $X=0.3095 $Y=0.216
x_PM_OAI32xp33_ASAP7_75t_R%A3 vss A3 N_M2_g N_M7_g N_A3_3 N_A3_5
+ PM_OAI32xp33_ASAP7_75t_R%A3
cc_24 N_A3_3 N_A2_1 0.00152442f $X=0.189 $Y=0.0245
cc_25 N_A3_5 N_A2_4 0.00454278f $X=0.189 $Y=0.0935
cc_26 N_A3_3 N_A2_3 0.00818351f $X=0.189 $Y=0.0245
x_PM_OAI32xp33_ASAP7_75t_R%A1 vss A1 N_M0_g N_M5_g N_A1_3 N_A1_4
+ PM_OAI32xp33_ASAP7_75t_R%A1

* End of included file OAI32xp33_ASAP7_75t_R.pex.sp.pxi
.ends

.subckt PM_OA211x2_ASAP7_75t_R%A1 vss 13 5 9 4 3 1
c1 1 vss 0.00582747f $X=0.135 $Y=0.135
c2 3 vss 0.0950182f $X=0.135 $Y=0.0245
c3 4 vss 0.00383696f $X=0.135 $Y=0.135
r1 13 12 5.07188 $w=1.3e-08 $l=2.18e-08 $layer=M1 $thickness=3.6e-08 $X=0.134
+ $Y=0.187 $X2=0.135 $Y2=0.1652
r2 4 12 7.05399 $w=1.3e-08 $l=3.02e-08 $layer=M1 $thickness=3.6e-08 $X=0.135
+ $Y=0.135 $X2=0.135 $Y2=0.1652
r3 1 7 10.4265 $w=1.765e-08 $layer=LIG $thickness=5.2e-08 $X=0.135 $Y=0.135
+ $X2=0.135 $Y2=0.135
r4 1 4 19.3796 $a=3.24e-16 $layer=V0LIG $X=0.135 $Y=0.135 $X2=0.135 $Y2=0.135
r5 9 8 16.4967 $w=2.1e-08 $l=4.85e-08 $layer=Gate_1 $thickness=5.6e-08 $X=0.135
+ $Y=0.216 $X2=0.135 $Y2=0.1675
r6 7 8 11.2416 $w=2.06615e-08 $l=3.25e-08 $layer=Gate_1 $thickness=5.6e-08
+ $X=0.135 $Y=0.135 $X2=0.135 $Y2=0.1675
r7 6 7 6.6497 $w=2.04211e-08 $l=1.9e-08 $layer=Gate_1 $thickness=5.6e-08
+ $X=0.135 $Y=0.116 $X2=0.135 $Y2=0.135
r8 5 6 16.4967 $w=2.1e-08 $l=4.85e-08 $layer=Gate_1 $thickness=5.6e-08 $X=0.135
+ $Y=0.0675 $X2=0.135 $Y2=0.116
r9 5 3 14.6259 $w=2.1e-08 $l=4.3e-08 $layer=Gate_1 $thickness=5.6e-08 $X=0.135
+ $Y=0.0675 $X2=0.135 $Y2=0.0245
.ends

.subckt PM_OA211x2_ASAP7_75t_R%C vss 12 5 9 4 3 1
c1 1 vss 0.00576865f $X=0.243 $Y=0.1345
c2 3 vss 0.107536f $X=0.243 $Y=0.0245
c3 4 vss 0.00235833f $X=0.243 $Y=0.1142
r1 13 14 2.3902 $w=1.3e-08 $l=1.03e-08 $layer=M1 $thickness=3.6e-08 $X=0.243
+ $Y=0.1247 $X2=0.243 $Y2=0.135
r2 12 13 0.408082 $w=1.3e-08 $l=1.7e-09 $layer=M1 $thickness=3.6e-08 $X=0.241
+ $Y=0.123 $X2=0.243 $Y2=0.1247
r3 12 4 2.04041 $w=1.3e-08 $l=8.8e-09 $layer=M1 $thickness=3.6e-08 $X=0.241
+ $Y=0.123 $X2=0.243 $Y2=0.1142
r4 1 7 10.1312 $w=1.77047e-08 $l=5e-10 $layer=LIG $thickness=5.2093e-08
+ $X=0.243 $Y=0.1345 $X2=0.243 $Y2=0.135
r5 1 14 19.3796 $a=3.24e-16 $layer=V0LIG $X=0.243 $Y=0.1345 $X2=0.243 $Y2=0.135
r6 9 8 16.4967 $w=2.1e-08 $l=4.85e-08 $layer=Gate_1 $thickness=5.6e-08 $X=0.243
+ $Y=0.2295 $X2=0.243 $Y2=0.181
r7 7 8 15.8334 $w=2.07609e-08 $l=4.6e-08 $layer=Gate_1 $thickness=5.6e-08
+ $X=0.243 $Y=0.135 $X2=0.243 $Y2=0.181
r8 6 7 6.6497 $w=2.04211e-08 $l=1.9e-08 $layer=Gate_1 $thickness=5.6e-08
+ $X=0.243 $Y=0.116 $X2=0.243 $Y2=0.135
r9 5 6 16.4967 $w=2.1e-08 $l=4.85e-08 $layer=Gate_1 $thickness=5.6e-08 $X=0.243
+ $Y=0.0675 $X2=0.243 $Y2=0.116
r10 5 3 14.6259 $w=2.1e-08 $l=4.3e-08 $layer=Gate_1 $thickness=5.6e-08 $X=0.243
+ $Y=0.0675 $X2=0.243 $Y2=0.0245
.ends

.subckt PM_OA211x2_ASAP7_75t_R%Y vss 23 16 17 30 31 8 1 12 11 7
c1 1 vss 0.00846688f $X=0.324 $Y=0.0675
c2 2 vss 0.00871561f $X=0.324 $Y=0.2025
c3 7 vss 0.00444449f $X=0.3095 $Y=0.0675
c4 8 vss 0.00450524f $X=0.3095 $Y=0.2025
c5 9 vss 0.00289794f $X=0.405 $Y=0.036
c6 10 vss 0.00289773f $X=0.405 $Y=0.234
c7 11 vss 0.0103725f $X=0.296 $Y=0.036
c8 12 vss 0.00949895f $X=0.3105 $Y=0.234
c9 13 vss 0.00847214f $X=0.405 $Y=0.054
r1 31 29 0.0308642 $w=8.1e-08 $l=2.5e-09 $layer=P_src_drn $thickness=1e-09
+ $X=0.3413 $Y=0.2025 $X2=0.3385 $Y2=0.2025
r2 2 29 0.179012 $w=8.1e-08 $l=1.45e-08 $layer=P_src_drn $thickness=1e-09
+ $X=0.324 $Y=0.2025 $X2=0.3385 $Y2=0.2025
r3 8 2 0.179012 $w=8.1e-08 $l=1.45e-08 $layer=P_src_drn $thickness=1e-09
+ $X=0.3095 $Y=0.2025 $X2=0.324 $Y2=0.2025
r4 30 8 0.0308642 $w=8.1e-08 $l=2.5e-09 $layer=P_src_drn $thickness=1e-09
+ $X=0.3066 $Y=0.2025 $X2=0.3095 $Y2=0.2025
r5 2 25 19.3796 $a=3.24e-16 $layer=V0LISD $X=0.324 $Y=0.2025 $X2=0.324 $Y2=0.234
r6 25 26 9.44419 $w=1.3e-08 $l=4.05e-08 $layer=M1 $thickness=3.6e-08 $X=0.324
+ $Y=0.234 $X2=0.3645 $Y2=0.234
r7 12 25 3.14806 $w=1.3e-08 $l=1.35e-08 $layer=M1 $thickness=3.6e-08 $X=0.3105
+ $Y=0.234 $X2=0.324 $Y2=0.234
r8 10 24 0.624487 $w=2.20462e-08 $l=9.8e-09 $layer=M1 $thickness=3.6e-08
+ $X=0.405 $Y=0.234 $X2=0.405 $Y2=0.2242
r9 10 26 7.79507 $w=1.41111e-08 $l=4.05e-08 $layer=M1 $thickness=3.6e-08
+ $X=0.405 $Y=0.234 $X2=0.3645 $Y2=0.234
r10 23 24 0.291487 $w=1.3e-08 $l=1.2e-09 $layer=M1 $thickness=3.6e-08 $X=0.405
+ $Y=0.223 $X2=0.405 $Y2=0.2242
r11 23 22 1.92382 $w=1.3e-08 $l=8.3e-09 $layer=M1 $thickness=3.6e-08 $X=0.405
+ $Y=0.223 $X2=0.405 $Y2=0.2147
r12 21 22 18.5969 $w=1.3e-08 $l=7.97e-08 $layer=M1 $thickness=3.6e-08 $X=0.405
+ $Y=0.135 $X2=0.405 $Y2=0.2147
r13 13 21 18.8884 $w=1.3e-08 $l=8.1e-08 $layer=M1 $thickness=3.6e-08 $X=0.405
+ $Y=0.054 $X2=0.405 $Y2=0.135
r14 9 20 7.79507 $w=1.41111e-08 $l=4.05e-08 $layer=M1 $thickness=3.6e-08
+ $X=0.405 $Y=0.036 $X2=0.3645 $Y2=0.036
r15 9 13 2.5483 $w=1.79e-08 $l=1.8e-08 $layer=M1 $thickness=3.6e-08 $X=0.405
+ $Y=0.036 $X2=0.405 $Y2=0.054
r16 19 20 9.44419 $w=1.3e-08 $l=4.05e-08 $layer=M1 $thickness=3.6e-08 $X=0.324
+ $Y=0.036 $X2=0.3645 $Y2=0.036
r17 18 19 3.14806 $w=1.3e-08 $l=1.35e-08 $layer=M1 $thickness=3.6e-08 $X=0.3105
+ $Y=0.036 $X2=0.324 $Y2=0.036
r18 11 18 3.38125 $w=1.3e-08 $l=1.45e-08 $layer=M1 $thickness=3.6e-08 $X=0.296
+ $Y=0.036 $X2=0.3105 $Y2=0.036
r19 1 19 19.3796 $a=3.24e-16 $layer=V0LISD $X=0.324 $Y=0.0675 $X2=0.324
+ $Y2=0.036
r20 17 15 0.0308642 $w=8.1e-08 $l=2.5e-09 $layer=N_src_drn $thickness=1e-09
+ $X=0.3413 $Y=0.0675 $X2=0.3385 $Y2=0.0675
r21 1 15 0.179012 $w=8.1e-08 $l=1.45e-08 $layer=N_src_drn $thickness=1e-09
+ $X=0.324 $Y=0.0675 $X2=0.3385 $Y2=0.0675
r22 7 1 0.179012 $w=8.1e-08 $l=1.45e-08 $layer=N_src_drn $thickness=1e-09
+ $X=0.3095 $Y=0.0675 $X2=0.324 $Y2=0.0675
r23 16 7 0.0308642 $w=8.1e-08 $l=2.5e-09 $layer=N_src_drn $thickness=1e-09
+ $X=0.3066 $Y=0.0675 $X2=0.3095 $Y2=0.0675
.ends

.subckt PM_OA211x2_ASAP7_75t_R%7 vss 26 30 44 48 62 63 76 77 79 22 4 21 3 14 15
+ 5 16 17 24 1 25 12 20 13 19
c1 1 vss 0.00734226f $X=0.2875 $Y=0.134
c2 3 vss 0.00707311f $X=0.054 $Y=0.216
c3 4 vss 0.0101425f $X=0.108 $Y=0.0675
c4 5 vss 0.00651713f $X=0.216 $Y=0.2295
c5 12 vss 0.0834441f $X=0.297 $Y=0.0245
c6 13 vss 0.0846973f $X=0.351 $Y=0.134
c7 14 vss 0.00707041f $X=0.0935 $Y=0.0675
c8 15 vss 0.0301782f $X=0.056 $Y=0.216
c9 16 vss 0.00439986f $X=0.2015 $Y=0.2295
c10 17 vss 0.000521671f $X=0.243 $Y=0.1945
c11 18 vss 0.00290885f $X=0.243 $Y=0.234
c12 19 vss 0.000903858f $X=0.297 $Y=0.072
c13 20 vss 0.000935689f $X=0.297 $Y=0.198
c14 21 vss 0.020357f $X=0.2025 $Y=0.234
c15 22 vss 0.0147292f $X=0.287 $Y=0.072
c16 23 vss 0.000617836f $X=0.243 $Y=0.216
c17 24 vss 0.00159542f $X=0.27 $Y=0.198
c18 25 vss 0.00329671f $X=0.297 $Y=0.0935
r1 79 78 0.0462963 $w=5.4e-08 $l=2.5e-09 $layer=P_src_drn $thickness=1e-09
+ $X=0.0713 $Y=0.216 $X2=0.0685 $Y2=0.216
r2 15 78 0.231482 $w=5.4e-08 $l=1.25e-08 $layer=P_src_drn $thickness=1e-09
+ $X=0.056 $Y=0.216 $X2=0.0685 $Y2=0.216
r3 77 75 0.0925926 $w=2.7e-08 $l=2.5e-09 $layer=P_src_drn $thickness=1e-09
+ $X=0.2333 $Y=0.2295 $X2=0.2305 $Y2=0.2295
r4 5 75 0.537037 $w=2.7e-08 $l=1.45e-08 $layer=P_src_drn $thickness=1e-09
+ $X=0.216 $Y=0.2295 $X2=0.2305 $Y2=0.2295
r5 16 5 0.537037 $w=2.7e-08 $l=1.45e-08 $layer=P_src_drn $thickness=1e-09
+ $X=0.2015 $Y=0.2295 $X2=0.216 $Y2=0.2295
r6 76 16 0.0925926 $w=2.7e-08 $l=2.5e-09 $layer=P_src_drn $thickness=1e-09
+ $X=0.1986 $Y=0.2295 $X2=0.2015 $Y2=0.2295
r7 3 72 19.3796 $a=3.24e-16 $layer=V0LISD $X=0.054 $Y=0.216 $X2=0.054 $Y2=0.234
r8 5 64 19.3796 $a=3.24e-16 $layer=V0LISD $X=0.216 $Y=0.2295 $X2=0.216 $Y2=0.234
r9 72 73 5.24677 $w=1.3e-08 $l=2.25e-08 $layer=M1 $thickness=3.6e-08 $X=0.054
+ $Y=0.234 $X2=0.0765 $Y2=0.234
r10 70 73 4.19742 $w=1.3e-08 $l=1.8e-08 $layer=M1 $thickness=3.6e-08 $X=0.0945
+ $Y=0.234 $X2=0.0765 $Y2=0.234
r11 69 70 4.19742 $w=1.3e-08 $l=1.8e-08 $layer=M1 $thickness=3.6e-08 $X=0.1125
+ $Y=0.234 $X2=0.0945 $Y2=0.234
r12 68 69 5.24677 $w=1.3e-08 $l=2.25e-08 $layer=M1 $thickness=3.6e-08 $X=0.135
+ $Y=0.234 $X2=0.1125 $Y2=0.234
r13 67 68 6.29612 $w=1.3e-08 $l=2.7e-08 $layer=M1 $thickness=3.6e-08 $X=0.162
+ $Y=0.234 $X2=0.135 $Y2=0.234
r14 66 67 6.29612 $w=1.3e-08 $l=2.7e-08 $layer=M1 $thickness=3.6e-08 $X=0.189
+ $Y=0.234 $X2=0.162 $Y2=0.234
r15 64 65 3.14806 $w=1.3e-08 $l=1.35e-08 $layer=M1 $thickness=3.6e-08 $X=0.216
+ $Y=0.234 $X2=0.2295 $Y2=0.234
r16 21 64 3.14806 $w=1.3e-08 $l=1.35e-08 $layer=M1 $thickness=3.6e-08 $X=0.2025
+ $Y=0.234 $X2=0.216 $Y2=0.234
r17 21 66 3.14806 $w=1.3e-08 $l=1.35e-08 $layer=M1 $thickness=3.6e-08 $X=0.2025
+ $Y=0.234 $X2=0.189 $Y2=0.234
r18 18 23 2.5483 $w=1.79e-08 $l=1.8e-08 $layer=M1 $thickness=3.6e-08 $X=0.243
+ $Y=0.234 $X2=0.243 $Y2=0.216
r19 18 65 1.49895 $w=1.63333e-08 $l=1.35e-08 $layer=M1 $thickness=3.6e-08
+ $X=0.243 $Y=0.234 $X2=0.2295 $Y2=0.234
r20 23 59 2.45586 $w=1.44e-08 $l=1.25e-08 $layer=M1 $thickness=3.6e-08 $X=0.243
+ $Y=0.216 $X2=0.243 $Y2=0.2035
r21 63 61 0.0308642 $w=8.1e-08 $l=2.5e-09 $layer=N_src_drn $thickness=1e-09
+ $X=0.1253 $Y=0.0675 $X2=0.1225 $Y2=0.0675
r22 4 61 0.179012 $w=8.1e-08 $l=1.45e-08 $layer=N_src_drn $thickness=1e-09
+ $X=0.108 $Y=0.0675 $X2=0.1225 $Y2=0.0675
r23 14 4 0.179012 $w=8.1e-08 $l=1.45e-08 $layer=N_src_drn $thickness=1e-09
+ $X=0.0935 $Y=0.0675 $X2=0.108 $Y2=0.0675
r24 62 14 0.0308642 $w=8.1e-08 $l=2.5e-09 $layer=N_src_drn $thickness=1e-09
+ $X=0.0906 $Y=0.0675 $X2=0.0935 $Y2=0.0675
r25 17 59 0.9184 $w=1.8e-08 $l=9e-09 $layer=M1 $thickness=3.6e-08 $X=0.243
+ $Y=0.1945 $X2=0.243 $Y2=0.2035
r26 4 57 19.3796 $a=3.24e-16 $layer=V0LISD $X=0.108 $Y=0.0675 $X2=0.108
+ $Y2=0.072
r27 24 59 4.55457 $w=1.3814e-08 $l=2.75545e-08 $layer=M1 $thickness=3.6e-08
+ $X=0.27 $Y=0.198 $X2=0.243 $Y2=0.2035
r28 57 58 3.14806 $w=1.3e-08 $l=1.35e-08 $layer=M1 $thickness=3.6e-08 $X=0.108
+ $Y=0.072 $X2=0.1215 $Y2=0.072
r29 56 58 3.14806 $w=1.3e-08 $l=1.35e-08 $layer=M1 $thickness=3.6e-08 $X=0.135
+ $Y=0.072 $X2=0.1215 $Y2=0.072
r30 55 56 5.82974 $w=1.3e-08 $l=2.5e-08 $layer=M1 $thickness=3.6e-08 $X=0.16
+ $Y=0.072 $X2=0.135 $Y2=0.072
r31 54 55 4.19742 $w=1.3e-08 $l=1.8e-08 $layer=M1 $thickness=3.6e-08 $X=0.178
+ $Y=0.072 $X2=0.16 $Y2=0.072
r32 53 54 2.56509 $w=1.3e-08 $l=1.1e-08 $layer=M1 $thickness=3.6e-08 $X=0.189
+ $Y=0.072 $X2=0.178 $Y2=0.072
r33 52 53 6.29612 $w=1.3e-08 $l=2.7e-08 $layer=M1 $thickness=3.6e-08 $X=0.216
+ $Y=0.072 $X2=0.189 $Y2=0.072
r34 51 52 6.29612 $w=1.3e-08 $l=2.7e-08 $layer=M1 $thickness=3.6e-08 $X=0.243
+ $Y=0.072 $X2=0.216 $Y2=0.072
r35 50 51 6.06293 $w=1.3e-08 $l=2.6e-08 $layer=M1 $thickness=3.6e-08 $X=0.269
+ $Y=0.072 $X2=0.243 $Y2=0.072
r36 22 50 4.19742 $w=1.3e-08 $l=1.8e-08 $layer=M1 $thickness=3.6e-08 $X=0.287
+ $Y=0.072 $X2=0.269 $Y2=0.072
r37 20 41 3.36447 $w=1.71023e-08 $l=2.15e-08 $layer=M1 $thickness=3.6e-08
+ $X=0.297 $Y=0.198 $X2=0.297 $Y2=0.1765
r38 20 24 4.64701 $w=1.46667e-08 $l=2.7e-08 $layer=M1 $thickness=3.6e-08
+ $X=0.297 $Y=0.198 $X2=0.27 $Y2=0.198
r39 19 25 3.36447 $w=1.71023e-08 $l=2.15e-08 $layer=M1 $thickness=3.6e-08
+ $X=0.297 $Y=0.072 $X2=0.297 $Y2=0.0935
r40 19 22 0.682785 $w=1.75e-08 $l=1e-08 $layer=M1 $thickness=3.6e-08 $X=0.297
+ $Y=0.072 $X2=0.287 $Y2=0.072
r41 48 47 14.6259 $w=2.1e-08 $l=4.3e-08 $layer=Gate_1 $thickness=5.6e-08
+ $X=0.351 $Y=0.2025 $X2=0.351 $Y2=0.1595
r42 46 47 2.89117 $w=2.1e-08 $l=8.5e-09 $layer=Gate_1 $thickness=5.6e-08
+ $X=0.351 $Y=0.151 $X2=0.351 $Y2=0.1595
r43 44 45 14.6259 $w=2.1e-08 $l=4.3e-08 $layer=Gate_1 $thickness=5.6e-08
+ $X=0.351 $Y=0.0675 $X2=0.351 $Y2=0.1105
r44 42 45 2.55104 $w=2.1e-08 $l=7.5e-09 $layer=Gate_1 $thickness=5.6e-08
+ $X=0.351 $Y=0.118 $X2=0.351 $Y2=0.1105
r45 13 36 6.54019 $w=2.09524e-08 $layer=Gate_1 $thickness=5.21905e-08 $X=0.351
+ $Y=0.134 $X2=0.351 $Y2=0.134
r46 13 42 5.62929 $w=2.03125e-08 $l=1.6e-08 $layer=Gate_1 $thickness=5.6e-08
+ $X=0.351 $Y=0.134 $X2=0.351 $Y2=0.118
r47 13 46 5.96942 $w=2.03529e-08 $l=1.7e-08 $layer=Gate_1 $thickness=5.6e-08
+ $X=0.351 $Y=0.134 $X2=0.351 $Y2=0.151
r48 40 41 5.36336 $w=1.3e-08 $l=2.3e-08 $layer=M1 $thickness=3.6e-08 $X=0.297
+ $Y=0.1535 $X2=0.297 $Y2=0.1765
r49 39 40 4.5472 $w=1.3e-08 $l=1.95e-08 $layer=M1 $thickness=3.6e-08 $X=0.297
+ $Y=0.134 $X2=0.297 $Y2=0.1535
r50 38 39 4.31401 $w=1.3e-08 $l=1.85e-08 $layer=M1 $thickness=3.6e-08 $X=0.297
+ $Y=0.1155 $X2=0.297 $Y2=0.134
r51 25 38 5.13017 $w=1.3e-08 $l=2.2e-08 $layer=M1 $thickness=3.6e-08 $X=0.297
+ $Y=0.0935 $X2=0.297 $Y2=0.1155
r52 35 36 12.6539 $w=1.77815e-08 $l=2.7e-08 $layer=LIG $thickness=4.8e-08
+ $X=0.324 $Y=0.134 $X2=0.351 $Y2=0.134
r53 33 35 10.1729 $w=1.54914e-08 $l=1.75e-08 $layer=LIG $thickness=4.8e-08
+ $X=0.3065 $Y=0.134 $X2=0.324 $Y2=0.134
r54 32 33 2.48102 $w=2.2e-08 $l=9.5e-09 $layer=LIG $thickness=4.8e-08 $X=0.297
+ $Y=0.134 $X2=0.3065 $Y2=0.134
r55 32 39 19.3796 $a=3.24e-16 $layer=V0LIG $X=0.297 $Y=0.134 $X2=0.297 $Y2=0.134
r56 1 32 2.48102 $w=2.2e-08 $l=9.5e-09 $layer=LIG $thickness=4.8e-08 $X=0.2875
+ $Y=0.134 $X2=0.297 $Y2=0.134
r57 30 29 16.6668 $w=2.1e-08 $l=4.9e-08 $layer=Gate_1 $thickness=5.6e-08
+ $X=0.297 $Y=0.2025 $X2=0.297 $Y2=0.1535
r58 28 29 6.81977 $w=2.04359e-08 $l=1.95e-08 $layer=Gate_1 $thickness=5.6e-08
+ $X=0.297 $Y=0.134 $X2=0.297 $Y2=0.1535
r59 28 33 4.05918 $w=2.0087e-08 $l=9.5e-09 $layer=Gate_1 $thickness=5.56522e-08
+ $X=0.297 $Y=0.134 $X2=0.3065 $Y2=0.134
r60 28 32 6.27904 $w=2.09e-08 $layer=Gate_1 $thickness=5.24e-08 $X=0.297
+ $Y=0.134 $X2=0.297 $Y2=0.134
r61 27 28 6.47963 $w=2.04054e-08 $l=1.85e-08 $layer=Gate_1 $thickness=5.6e-08
+ $X=0.297 $Y=0.1155 $X2=0.297 $Y2=0.134
r62 26 27 16.3266 $w=2.1e-08 $l=4.8e-08 $layer=Gate_1 $thickness=5.6e-08
+ $X=0.297 $Y=0.0675 $X2=0.297 $Y2=0.1155
r63 26 12 14.6259 $w=2.1e-08 $l=4.3e-08 $layer=Gate_1 $thickness=5.6e-08
+ $X=0.297 $Y=0.0675 $X2=0.297 $Y2=0.0245
r64 3 15 1e-05 $l=2e-09 $X=0.054 $Y=0.216 $X2=0.056 $Y2=0.216
.ends

.subckt PM_OA211x2_ASAP7_75t_R%A2 vss 19 8 14 7 3 1 6
c1 1 vss 0.00332539f $X=0.081 $Y=0.135
c2 3 vss 0.0671899f $X=0.081 $Y=0.0245
c3 4 vss 0.00145288f $X=0.027 $Y=0.135
c4 5 vss 0.00826651f $X=0.027 $Y=0.116
c5 6 vss 0.00557974f $X=0.027 $Y=0.172
c6 7 vss 0.00287404f $X=0.056 $Y=0.135
r1 19 20 2.73998 $w=1.3e-08 $l=1.17e-08 $layer=M1 $thickness=3.6e-08 $X=0.018
+ $Y=0.083 $X2=0.027 $Y2=0.0947
r2 5 20 4.95528 $w=1.3e-08 $l=2.13e-08 $layer=M1 $thickness=3.6e-08 $X=0.027
+ $Y=0.116 $X2=0.027 $Y2=0.0947
r3 4 17 1.38478 $w=1.70909e-08 $l=1.1e-08 $layer=M1 $thickness=3.6e-08 $X=0.027
+ $Y=0.135 $X2=0.038 $Y2=0.135
r4 4 5 3.2503 $w=1.53684e-08 $l=1.9e-08 $layer=M1 $thickness=3.6e-08 $X=0.027
+ $Y=0.135 $X2=0.027 $Y2=0.116
r5 4 6 7.44771 $w=1.42162e-08 $l=3.7e-08 $layer=M1 $thickness=3.6e-08 $X=0.027
+ $Y=0.135 $X2=0.027 $Y2=0.172
r6 7 16 5.82974 $w=1.3e-08 $l=2.5e-08 $layer=M1 $thickness=3.6e-08 $X=0.056
+ $Y=0.135 $X2=0.081 $Y2=0.135
r7 7 17 4.19742 $w=1.3e-08 $l=1.8e-08 $layer=M1 $thickness=3.6e-08 $X=0.056
+ $Y=0.135 $X2=0.038 $Y2=0.135
r8 1 11 10.4265 $w=1.765e-08 $layer=LIG $thickness=5.2e-08 $X=0.081 $Y=0.135
+ $X2=0.081 $Y2=0.135
r9 1 16 19.3796 $a=3.24e-16 $layer=V0LIG $X=0.081 $Y=0.135 $X2=0.081 $Y2=0.135
r10 14 13 14.6259 $w=2.1e-08 $l=4.3e-08 $layer=Gate_1 $thickness=5.6e-08
+ $X=0.081 $Y=0.216 $X2=0.081 $Y2=0.173
r11 12 13 7.31297 $w=2.1e-08 $l=2.15e-08 $layer=Gate_1 $thickness=5.6e-08
+ $X=0.081 $Y=0.1515 $X2=0.081 $Y2=0.173
r12 11 12 5.79936 $w=2.03333e-08 $l=1.65e-08 $layer=Gate_1 $thickness=5.6e-08
+ $X=0.081 $Y=0.135 $X2=0.081 $Y2=0.1515
r13 10 11 5.79936 $w=2.03333e-08 $l=1.65e-08 $layer=Gate_1 $thickness=5.6e-08
+ $X=0.081 $Y=0.1185 $X2=0.081 $Y2=0.135
r14 9 10 2.7211 $w=2.1e-08 $l=8e-09 $layer=Gate_1 $thickness=5.6e-08 $X=0.081
+ $Y=0.1105 $X2=0.081 $Y2=0.1185
r15 8 9 14.6259 $w=2.1e-08 $l=4.3e-08 $layer=Gate_1 $thickness=5.6e-08 $X=0.081
+ $Y=0.0675 $X2=0.081 $Y2=0.1105
r16 8 3 14.6259 $w=2.1e-08 $l=4.3e-08 $layer=Gate_1 $thickness=5.6e-08 $X=0.081
+ $Y=0.0675 $X2=0.081 $Y2=0.0245
.ends

.subckt PM_OA211x2_ASAP7_75t_R%B vss 13 5 9 4 3
c1 1 vss 0.00486755f $X=0.189 $Y=0.135
c2 3 vss 0.0965271f $X=0.189 $Y=0.0245
c3 4 vss 0.00318642f $X=0.189 $Y=0.116
r1 13 12 0.524677 $w=1.3e-08 $l=2.3e-09 $layer=M1 $thickness=3.6e-08 $X=0.188
+ $Y=0.148 $X2=0.189 $Y2=0.1457
r2 11 12 2.50679 $w=1.3e-08 $l=1.07e-08 $layer=M1 $thickness=3.6e-08 $X=0.189
+ $Y=0.135 $X2=0.189 $Y2=0.1457
r3 4 11 4.43061 $w=1.3e-08 $l=1.9e-08 $layer=M1 $thickness=3.6e-08 $X=0.189
+ $Y=0.116 $X2=0.189 $Y2=0.135
r4 1 7 10.4265 $w=1.765e-08 $layer=LIG $thickness=5.2e-08 $X=0.189 $Y=0.135
+ $X2=0.189 $Y2=0.135
r5 1 11 19.3796 $a=3.24e-16 $layer=V0LIG $X=0.189 $Y=0.135 $X2=0.189 $Y2=0.135
r6 9 8 16.4967 $w=2.1e-08 $l=4.85e-08 $layer=Gate_1 $thickness=5.6e-08 $X=0.189
+ $Y=0.2295 $X2=0.189 $Y2=0.181
r7 7 8 15.8334 $w=2.07609e-08 $l=4.6e-08 $layer=Gate_1 $thickness=5.6e-08
+ $X=0.189 $Y=0.135 $X2=0.189 $Y2=0.181
r8 6 7 6.6497 $w=2.04211e-08 $l=1.9e-08 $layer=Gate_1 $thickness=5.6e-08
+ $X=0.189 $Y=0.116 $X2=0.189 $Y2=0.135
r9 5 6 16.4967 $w=2.1e-08 $l=4.85e-08 $layer=Gate_1 $thickness=5.6e-08 $X=0.189
+ $Y=0.0675 $X2=0.189 $Y2=0.116
r10 5 3 14.6259 $w=2.1e-08 $l=4.3e-08 $layer=Gate_1 $thickness=5.6e-08 $X=0.189
+ $Y=0.0675 $X2=0.189 $Y2=0.0245
.ends

* End of included file OA211x2_ASAP7_75t_R.pex.sp.pex

*
.subckt OA211x2_ASAP7_75t_CUSTOM_4_25_0_7 VSS VDD A2 A1 B C Y
*
* VSS VSS
* VDD VDD
* A2 A2
* A1 A1
* B B
* C C
* Y Y
*
*

M0 N_M0_d N_M0_g noxref_8 VSS nmos_rvt L=2e-08 W=8.1e-08 nfin=3 $X=0.071
+ $Y=0.027
M1 noxref_8 N_M1_g N_M1_s VSS nmos_rvt L=2e-08 W=8.1e-08 nfin=3 $X=0.125
+ $Y=0.027
M2 noxref_10 N_M2_g noxref_8 VSS nmos_rvt L=2e-08 W=8.1e-08 nfin=3 $X=0.179
+ $Y=0.027
M3 VSS N_M3_g noxref_10 VSS nmos_rvt L=2e-08 W=8.1e-08 nfin=3 $X=0.233 $Y=0.027
M4 N_M4_d N_M4_g VSS VSS nmos_rvt L=2e-08 W=8.1e-08 nfin=3 $X=0.287 $Y=0.027
M5 N_M5_d N_M5_g VSS VSS nmos_rvt L=2e-08 W=8.1e-08 nfin=3 $X=0.341 $Y=0.027
M6 noxref_11 N_M6_g N_M6_s VDD pmos_rvt L=2e-08 W=5.4e-08 nfin=2 $X=0.071
+ $Y=0.189
M7 VDD N_M7_g noxref_11 VDD pmos_rvt L=2e-08 W=5.4e-08 nfin=2 $X=0.125 $Y=0.189
M8 N_M8_d N_M8_g VDD VDD pmos_rvt L=2e-08 W=2.7e-08 nfin=1 $X=0.179 $Y=0.216
M9 VDD N_M9_g N_M9_s VDD pmos_rvt L=2e-08 W=2.7e-08 nfin=1 $X=0.233 $Y=0.216
M10 N_M10_d N_M10_g VDD VDD pmos_rvt L=2e-08 W=8.1e-08 nfin=3 $X=0.287 $Y=0.162
M11 N_M11_d N_M11_g VDD VDD pmos_rvt L=2e-08 W=8.1e-08 nfin=3 $X=0.341 $Y=0.162

* .include "OA211x2_ASAP7_75t_R.pex.sp.pxi"

* Start of included file OA211x2_ASAP7_75t_R.pex.sp.pxi
x_PM_OA211x2_ASAP7_75t_R%A1 vss A1 N_M1_g N_M7_g N_A1_4 N_A1_3 N_A1_1
+ PM_OA211x2_ASAP7_75t_R%A1
cc_1 N_A1_4 N_A2_7 0.001926f $X=0.135 $Y=0.135
cc_2 N_A1_3 N_A2_3 0.00898647f $X=0.135 $Y=0.0245
x_PM_OA211x2_ASAP7_75t_R%C vss C N_M3_g N_M9_g N_C_4 N_C_3 N_C_1
+ PM_OA211x2_ASAP7_75t_R%C
cc_3 N_C_4 N_B_4 0.00239989f $X=0.243 $Y=0.1142
cc_4 N_C_3 N_B_3 0.0112736f $X=0.243 $Y=0.0245
x_PM_OA211x2_ASAP7_75t_R%Y vss Y N_M4_d N_M5_d N_M10_d N_M11_d N_Y_8 N_Y_1
+ N_Y_12 N_Y_11 N_Y_7 PM_OA211x2_ASAP7_75t_R%Y
cc_5 N_Y_8 N_7_20 0.000319692f $X=0.3095 $Y=0.2025
cc_6 N_Y_8 N_7_24 0.00042858f $X=0.3095 $Y=0.2025
cc_7 N_Y_8 N_7_1 0.0014674f $X=0.3095 $Y=0.2025
cc_8 N_Y_8 N_7_22 0.000823492f $X=0.3095 $Y=0.2025
cc_9 N_Y_8 N_7_13 0.0590307f $X=0.3095 $Y=0.2025
cc_10 N_Y_8 N_7_25 0.00172061f $X=0.3095 $Y=0.2025
cc_11 N_Y_1 N_7_13 0.0021098f $X=0.324 $Y=0.0675
cc_12 N_Y_12 N_7_20 0.00266429f $X=0.3105 $Y=0.234
cc_13 N_Y_11 N_7_19 0.00308118f $X=0.296 $Y=0.036
cc_14 N_Y_7 N_7_1 0.004876f $X=0.3095 $Y=0.0675
cc_15 N_Y_7 N_7_13 0.0103199f $X=0.3095 $Y=0.0675
cc_16 N_Y_7 N_7_12 0.018513f $X=0.3095 $Y=0.0675
cc_17 N_Y_8 N_7_12 0.0483556f $X=0.3095 $Y=0.2025
x_PM_OA211x2_ASAP7_75t_R%7 vss N_M4_g N_M10_g N_M5_g N_M11_g N_M0_d N_M1_s
+ N_M8_d N_M9_s N_M6_s N_7_22 N_7_4 N_7_21 N_7_3 N_7_14 N_7_15 N_7_5 N_7_16
+ N_7_17 N_7_24 N_7_1 N_7_25 N_7_12 N_7_20 N_7_13 N_7_19
+ PM_OA211x2_ASAP7_75t_R%7
cc_18 N_7_22 N_A2_3 0.000342128f $X=0.287 $Y=0.072
cc_19 N_7_4 N_A2_3 0.00180773f $X=0.108 $Y=0.0675
cc_20 N_7_21 N_A2_7 0.00104191f $X=0.2025 $Y=0.234
cc_21 N_7_3 N_A2_3 0.00111342f $X=0.054 $Y=0.216
cc_22 N_7_14 N_A2_1 0.00112372f $X=0.0935 $Y=0.0675
cc_23 N_7_22 N_A2_7 0.00120645f $X=0.287 $Y=0.072
cc_24 N_7_21 N_A2_6 0.00132293f $X=0.2025 $Y=0.234
cc_25 N_7_15 N_A2_3 0.0109355f $X=0.056 $Y=0.216
cc_26 N_7_14 N_A2_3 0.0503793f $X=0.0935 $Y=0.0675
cc_27 N_7_4 N_A1_3 0.00129816f $X=0.108 $Y=0.0675
cc_28 N_7_14 N_A1_1 0.000857613f $X=0.0935 $Y=0.0675
cc_29 N_7_22 N_A1_4 0.0011089f $X=0.287 $Y=0.072
cc_30 N_7_21 N_A1_4 0.00139006f $X=0.2025 $Y=0.234
cc_31 N_7_4 N_A1_4 0.00299174f $X=0.108 $Y=0.0675
cc_32 N_7_14 N_A1_3 0.0361611f $X=0.0935 $Y=0.0675
cc_33 N_7_5 N_B_3 0.000348214f $X=0.216 $Y=0.2295
cc_34 N_7_22 N_B_3 0.000374776f $X=0.287 $Y=0.072
cc_35 N_7_21 N_B_4 0.0010259f $X=0.2025 $Y=0.234
cc_36 N_7_22 N_B_4 0.00141867f $X=0.287 $Y=0.072
cc_37 N_7_16 N_B_3 0.00640149f $X=0.2015 $Y=0.2295
cc_38 N_7_17 N_B_4 0.00338659f $X=0.243 $Y=0.1945
cc_39 N_7_14 N_B_3 0.0100158f $X=0.0935 $Y=0.0675
cc_40 N_7_24 N_C_3 0.000381304f $X=0.27 $Y=0.198
cc_41 N_7_17 N_C_3 0.000549528f $X=0.243 $Y=0.1945
cc_42 N_7_1 N_C_3 0.00100863f $X=0.2875 $Y=0.134
cc_43 N_7_22 N_C_4 0.00136427f $X=0.287 $Y=0.072
cc_44 N_7_1 N_C_1 0.00138974f $X=0.2875 $Y=0.134
cc_45 N_7_16 N_C_3 0.00638077f $X=0.2015 $Y=0.2295
cc_46 N_7_25 N_C_4 0.00422007f $X=0.297 $Y=0.0935
cc_47 N_7_12 N_C_3 0.0128594f $X=0.297 $Y=0.0245
x_PM_OA211x2_ASAP7_75t_R%A2 vss A2 N_M0_g N_M6_g N_A2_7 N_A2_3 N_A2_1 N_A2_6
+ PM_OA211x2_ASAP7_75t_R%A2
x_PM_OA211x2_ASAP7_75t_R%B vss B N_M2_g N_M8_g N_B_4 N_B_3
+ PM_OA211x2_ASAP7_75t_R%B
cc_48 N_B_4 N_A1_4 0.00314994f $X=0.189 $Y=0.116
cc_49 N_B_3 N_A1_3 0.00707802f $X=0.189 $Y=0.0245

* End of included file OA211x2_ASAP7_75t_R.pex.sp.pxi
.ends

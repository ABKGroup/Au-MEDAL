.subckt PM_OAI31xp33_ASAP7_75t_R%A3 vss 15 5 11 3 4
c1 1 vss 0.00556312f $X=0.081 $Y=0.135
c2 3 vss 0.126045f $X=0.081 $Y=0.0245
c3 4 vss 0.0146331f $X=0.081 $Y=0.0985
r1 15 4 8.74462 $w=1.3e-08 $l=3.75e-08 $layer=M1 $thickness=3.6e-08 $X=0.0855
+ $Y=0.1355 $X2=0.081 $Y2=0.0985
r2 1 8 6.54019 $w=2.09524e-08 $layer=Gate_1 $thickness=5.21905e-08 $X=0.081
+ $Y=0.135 $X2=0.081 $Y2=0.135
r3 15 1 19.3796 $a=3.24e-16 $layer=V0LIG $X=0.0855 $Y=0.1355 $X2=0.081 $Y2=0.135
r4 11 10 14.6259 $w=2.1e-08 $l=4.3e-08 $layer=Gate_1 $thickness=5.6e-08
+ $X=0.081 $Y=0.2025 $X2=0.081 $Y2=0.1595
r5 9 10 2.7211 $w=2.1e-08 $l=8e-09 $layer=Gate_1 $thickness=5.6e-08 $X=0.081
+ $Y=0.1515 $X2=0.081 $Y2=0.1595
r6 8 9 5.79936 $w=2.03333e-08 $l=1.65e-08 $layer=Gate_1 $thickness=5.6e-08
+ $X=0.081 $Y=0.135 $X2=0.081 $Y2=0.1515
r7 7 8 5.79936 $w=2.03333e-08 $l=1.65e-08 $layer=Gate_1 $thickness=5.6e-08
+ $X=0.081 $Y=0.1185 $X2=0.081 $Y2=0.135
r8 6 7 7.31297 $w=2.1e-08 $l=2.15e-08 $layer=Gate_1 $thickness=5.6e-08 $X=0.081
+ $Y=0.097 $X2=0.081 $Y2=0.1185
r9 5 6 14.6259 $w=2.1e-08 $l=4.3e-08 $layer=Gate_1 $thickness=5.6e-08 $X=0.081
+ $Y=0.054 $X2=0.081 $Y2=0.097
r10 5 3 10.0341 $w=2.1e-08 $l=2.95e-08 $layer=Gate_1 $thickness=5.6e-08
+ $X=0.081 $Y=0.054 $X2=0.081 $Y2=0.0245
.ends

.subckt PM_OAI31xp33_ASAP7_75t_R%B vss 15 5 11 4 3 1
c1 1 vss 0.011672f $X=0.243 $Y=0.135
c2 3 vss 0.0728185f $X=0.243 $Y=0.0245
c3 4 vss 0.00668749f $X=0.243 $Y=0.1165
r1 15 4 4.5472 $w=1.3e-08 $l=1.95e-08 $layer=M1 $thickness=3.6e-08 $X=0.2405
+ $Y=0.1355 $X2=0.243 $Y2=0.1165
r2 1 8 6.54019 $w=2.09524e-08 $layer=Gate_1 $thickness=5.21905e-08 $X=0.243
+ $Y=0.135 $X2=0.243 $Y2=0.135
r3 15 1 19.3796 $a=3.24e-16 $layer=V0LIG $X=0.2405 $Y=0.1355 $X2=0.243 $Y2=0.135
r4 11 10 14.6259 $w=2.1e-08 $l=4.3e-08 $layer=Gate_1 $thickness=5.6e-08
+ $X=0.243 $Y=0.216 $X2=0.243 $Y2=0.173
r5 9 10 7.31297 $w=2.1e-08 $l=2.15e-08 $layer=Gate_1 $thickness=5.6e-08
+ $X=0.243 $Y=0.1515 $X2=0.243 $Y2=0.173
r6 8 9 5.79936 $w=2.03333e-08 $l=1.65e-08 $layer=Gate_1 $thickness=5.6e-08
+ $X=0.243 $Y=0.135 $X2=0.243 $Y2=0.1515
r7 7 8 5.79936 $w=2.03333e-08 $l=1.65e-08 $layer=Gate_1 $thickness=5.6e-08
+ $X=0.243 $Y=0.1185 $X2=0.243 $Y2=0.135
r8 6 7 7.31297 $w=2.1e-08 $l=2.15e-08 $layer=Gate_1 $thickness=5.6e-08 $X=0.243
+ $Y=0.097 $X2=0.243 $Y2=0.1185
r9 5 6 14.6259 $w=2.1e-08 $l=4.3e-08 $layer=Gate_1 $thickness=5.6e-08 $X=0.243
+ $Y=0.054 $X2=0.243 $Y2=0.097
r10 5 3 10.0341 $w=2.1e-08 $l=2.95e-08 $layer=Gate_1 $thickness=5.6e-08
+ $X=0.243 $Y=0.054 $X2=0.243 $Y2=0.0245
.ends

.subckt PM_OAI31xp33_ASAP7_75t_R%A2 vss 13 5 9 1 4 3
c1 1 vss 0.00246529f $X=0.135 $Y=0.135
c2 3 vss 0.103195f $X=0.135 $Y=0.0245
c3 4 vss 0.00982643f $X=0.135 $Y=0.0985
r1 13 4 8.74462 $w=1.3e-08 $l=3.75e-08 $layer=M1 $thickness=3.6e-08 $X=0.1355
+ $Y=0.1355 $X2=0.135 $Y2=0.0985
r2 1 7 6.54019 $w=2.09524e-08 $layer=Gate_1 $thickness=5.21905e-08 $X=0.135
+ $Y=0.135 $X2=0.135 $Y2=0.135
r3 13 1 19.3796 $a=3.24e-16 $layer=V0LIG $X=0.1355 $Y=0.1355 $X2=0.135 $Y2=0.135
r4 9 8 16.4967 $w=2.1e-08 $l=4.85e-08 $layer=Gate_1 $thickness=5.6e-08 $X=0.135
+ $Y=0.2025 $X2=0.135 $Y2=0.154
r5 7 8 6.6497 $w=2.04211e-08 $l=1.9e-08 $layer=Gate_1 $thickness=5.6e-08
+ $X=0.135 $Y=0.135 $X2=0.135 $Y2=0.154
r6 6 7 11.2416 $w=2.06615e-08 $l=3.25e-08 $layer=Gate_1 $thickness=5.6e-08
+ $X=0.135 $Y=0.1025 $X2=0.135 $Y2=0.135
r7 5 6 16.4967 $w=2.1e-08 $l=4.85e-08 $layer=Gate_1 $thickness=5.6e-08 $X=0.135
+ $Y=0.054 $X2=0.135 $Y2=0.1025
r8 5 3 10.0341 $w=2.1e-08 $l=2.95e-08 $layer=Gate_1 $thickness=5.6e-08 $X=0.135
+ $Y=0.054 $X2=0.135 $Y2=0.0245
.ends

.subckt PM_OAI31xp33_ASAP7_75t_R%A1 vss 15 5 9 3 4
c1 1 vss 0.00977124f $X=0.189 $Y=0.135
c2 3 vss 0.0855629f $X=0.189 $Y=0.0245
c3 4 vss 0.00923487f $X=0.189 $Y=0.0935
r1 15 14 4.5472 $w=1.3e-08 $l=1.95e-08 $layer=M1 $thickness=3.6e-08 $X=0.1895
+ $Y=0.1355 $X2=0.189 $Y2=0.1165
r2 4 14 5.36336 $w=1.3e-08 $l=2.3e-08 $layer=M1 $thickness=3.6e-08 $X=0.189
+ $Y=0.0935 $X2=0.189 $Y2=0.1165
r3 1 7 6.54019 $w=2.09524e-08 $layer=Gate_1 $thickness=5.21905e-08 $X=0.189
+ $Y=0.135 $X2=0.189 $Y2=0.135
r4 15 1 19.3796 $a=3.24e-16 $layer=V0LIG $X=0.1895 $Y=0.1355 $X2=0.189 $Y2=0.135
r5 9 8 16.4967 $w=2.1e-08 $l=4.85e-08 $layer=Gate_1 $thickness=5.6e-08 $X=0.189
+ $Y=0.2025 $X2=0.189 $Y2=0.154
r6 7 8 6.6497 $w=2.04211e-08 $l=1.9e-08 $layer=Gate_1 $thickness=5.6e-08
+ $X=0.189 $Y=0.135 $X2=0.189 $Y2=0.154
r7 6 7 11.2416 $w=2.06615e-08 $l=3.25e-08 $layer=Gate_1 $thickness=5.6e-08
+ $X=0.189 $Y=0.1025 $X2=0.189 $Y2=0.135
r8 5 6 16.4967 $w=2.1e-08 $l=4.85e-08 $layer=Gate_1 $thickness=5.6e-08 $X=0.189
+ $Y=0.054 $X2=0.189 $Y2=0.1025
r9 5 3 10.0341 $w=2.1e-08 $l=2.95e-08 $layer=Gate_1 $thickness=5.6e-08 $X=0.189
+ $Y=0.054 $X2=0.189 $Y2=0.0245
.ends

.subckt PM_OAI31xp33_ASAP7_75t_R%Y vss 21 16 32 35 1 8 10 13 7 14
c1 1 vss 0.00637604f $X=0.216 $Y=0.216
c2 2 vss 0.00697352f $X=0.27 $Y=0.054
c3 7 vss 0.026348f $X=0.2555 $Y=0.054
c4 8 vss 0.00260919f $X=0.2015 $Y=0.1975
c5 9 vss 4.08373e-20 $X=0.2015 $Y=0.1755
c6 10 vss 0.000344131f $X=0.2015 $Y=0.2245
c7 11 vss 0.00321488f $X=0.2585 $Y=0.072
c8 12 vss 0.00278216f $X=0.297 $Y=0.234
c9 13 vss 0.00792897f $X=0.272 $Y=0.234
c10 14 vss 0.00475961f $X=0.297 $Y=0.0935
r1 10 1 0.391892 $w=3.7e-08 $l=1.45e-08 $layer=P_src_drn $thickness=1e-09
+ $X=0.2015 $Y=0.2245 $X2=0.216 $Y2=0.216
r2 9 1 0.462963 $w=2.7e-08 $l=1.25e-08 $layer=P_src_drn $thickness=1e-09
+ $X=0.2015 $Y=0.1755 $X2=0.216 $Y2=0.216
r3 35 34 0.147059 $w=1.7e-08 $l=2.5e-09 $layer=P_src_drn $thickness=1e-09
+ $X=0.2333 $Y=0.216 $X2=0.2305 $Y2=0.1975
r4 33 34 0.264706 $w=1.7e-08 $l=4.5e-09 $layer=P_src_drn $thickness=1e-09
+ $X=0.226 $Y=0.1975 $X2=0.2305 $Y2=0.1975
r5 1 33 0.705882 $w=1.7e-08 $l=1.2e-08 $layer=P_src_drn $thickness=1e-09
+ $X=0.216 $Y=0.216 $X2=0.226 $Y2=0.1975
r6 8 1 0.735294 $w=1.7e-08 $l=1.25e-08 $layer=P_src_drn $thickness=1e-09
+ $X=0.2015 $Y=0.1975 $X2=0.216 $Y2=0.216
r7 32 8 0.147059 $w=1.7e-08 $l=2.5e-09 $layer=P_src_drn $thickness=1e-09
+ $X=0.1986 $Y=0.2025 $X2=0.2015 $Y2=0.1975
r8 1 28 19.3796 $a=3.24e-16 $layer=V0LISD $X=0.216 $Y=0.216 $X2=0.216 $Y2=0.234
r9 28 29 2.68168 $w=1.3e-08 $l=1.15e-08 $layer=M1 $thickness=3.6e-08 $X=0.216
+ $Y=0.234 $X2=0.2275 $Y2=0.234
r10 26 29 1.04935 $w=1.3e-08 $l=4.5e-09 $layer=M1 $thickness=3.6e-08 $X=0.232
+ $Y=0.234 $X2=0.2275 $Y2=0.234
r11 25 26 2.56509 $w=1.3e-08 $l=1.1e-08 $layer=M1 $thickness=3.6e-08 $X=0.243
+ $Y=0.234 $X2=0.232 $Y2=0.234
r12 24 25 2.56509 $w=1.3e-08 $l=1.1e-08 $layer=M1 $thickness=3.6e-08 $X=0.254
+ $Y=0.234 $X2=0.243 $Y2=0.234
r13 13 24 4.19742 $w=1.3e-08 $l=1.8e-08 $layer=M1 $thickness=3.6e-08 $X=0.272
+ $Y=0.234 $X2=0.254 $Y2=0.234
r14 12 23 3.36447 $w=1.71023e-08 $l=2.15e-08 $layer=M1 $thickness=3.6e-08
+ $X=0.297 $Y=0.234 $X2=0.297 $Y2=0.2125
r15 12 13 4.18063 $w=1.48e-08 $l=2.5e-08 $layer=M1 $thickness=3.6e-08 $X=0.297
+ $Y=0.234 $X2=0.272 $Y2=0.234
r16 22 23 13.2335 $w=1.3e-08 $l=5.68e-08 $layer=M1 $thickness=3.6e-08 $X=0.297
+ $Y=0.1557 $X2=0.297 $Y2=0.2125
r17 21 22 10.4352 $w=1.3e-08 $l=4.47e-08 $layer=M1 $thickness=3.6e-08 $X=0.299
+ $Y=0.111 $X2=0.297 $Y2=0.1557
r18 21 20 0.641272 $w=1.3e-08 $l=2.8e-09 $layer=M1 $thickness=3.6e-08 $X=0.299
+ $Y=0.111 $X2=0.297 $Y2=0.1082
r19 14 19 3.83327 $w=1.5093e-08 $l=2.15e-08 $layer=M1 $thickness=3.6e-08
+ $X=0.297 $Y=0.0935 $X2=0.297 $Y2=0.072
r20 14 20 3.43955 $w=1.3e-08 $l=1.47e-08 $layer=M1 $thickness=3.6e-08 $X=0.297
+ $Y=0.0935 $X2=0.297 $Y2=0.1082
r21 18 19 1.96775 $w=1.63333e-08 $l=1.35e-08 $layer=M1 $thickness=3.6e-08
+ $X=0.2835 $Y=0.072 $X2=0.297 $Y2=0.072
r22 17 18 3.14806 $w=1.3e-08 $l=1.35e-08 $layer=M1 $thickness=3.6e-08 $X=0.27
+ $Y=0.072 $X2=0.2835 $Y2=0.072
r23 11 17 2.68168 $w=1.3e-08 $l=1.15e-08 $layer=M1 $thickness=3.6e-08 $X=0.2585
+ $Y=0.072 $X2=0.27 $Y2=0.072
r24 2 17 19.3796 $a=3.24e-16 $layer=V0LISD $X=0.27 $Y=0.054 $X2=0.27 $Y2=0.072
r25 7 2 0.231482 $w=5.4e-08 $l=1.25e-08 $layer=N_src_drn $thickness=1e-09
+ $X=0.2555 $Y=0.054 $X2=0.27 $Y2=0.054
r26 16 7 0.0462963 $w=5.4e-08 $l=2.5e-09 $layer=N_src_drn $thickness=1e-09
+ $X=0.2526 $Y=0.054 $X2=0.2555 $Y2=0.054
.ends

* End of included file OAI31xp33_ASAP7_75t_R.pex.sp.pex

*
.subckt OAI31xp33_ASAP7_75t_CUSTOM_4_25_0_7 VSS VDD A3 A2 A1 B Y
*
* VSS VSS
* VDD VDD
* A3 A3
* A2 A2
* A1 A1
* B B
* Y Y
*
*

M0 noxref_7 N_M0_g VSS VSS nmos_rvt L=2e-08 W=5.4e-08 nfin=2 $X=0.071 $Y=0.027
M1 VSS N_M1_g noxref_7 VSS nmos_rvt L=2e-08 W=5.4e-08 nfin=2 $X=0.125 $Y=0.027
M2 noxref_7 N_M2_g VSS VSS nmos_rvt L=2e-08 W=5.4e-08 nfin=2 $X=0.179 $Y=0.027
M3 N_M3_d N_M3_g noxref_7 VSS nmos_rvt L=2e-08 W=5.4e-08 nfin=2 $X=0.233
+ $Y=0.027
M4 noxref_9 N_M4_g VDD VDD pmos_rvt L=2e-08 W=8.1e-08 nfin=3 $X=0.071 $Y=0.162
M5 noxref_10 N_M5_g noxref_9 VDD pmos_rvt L=2e-08 W=8.1e-08 nfin=3 $X=0.125
+ $Y=0.162
M6 N_M6_d N_M6_g noxref_10 VDD pmos_rvt L=2e-08 W=8.1e-08 nfin=3 $X=0.179
+ $Y=0.162
M7 VDD N_M7_g N_M7_s VDD pmos_rvt L=2e-08 W=5.4e-08 nfin=2 $X=0.233 $Y=0.189

* .include "OAI31xp33_ASAP7_75t_R.pex.sp.pxi"

* Start of included file OAI31xp33_ASAP7_75t_R.pex.sp.pxi
x_PM_OAI31xp33_ASAP7_75t_R%A3 vss A3 N_M0_g N_M4_g N_A3_3 N_A3_4
+ PM_OAI31xp33_ASAP7_75t_R%A3
x_PM_OAI31xp33_ASAP7_75t_R%B vss B N_M3_g N_M7_g N_B_4 N_B_3 N_B_1
+ PM_OAI31xp33_ASAP7_75t_R%B
cc_1 N_B_4 N_A1_4 0.00373941f $X=0.243 $Y=0.1165
cc_2 N_B_3 N_A1_3 0.00706469f $X=0.243 $Y=0.0245
x_PM_OAI31xp33_ASAP7_75t_R%A2 vss A2 N_M1_g N_M5_g N_A2_1 N_A2_4 N_A2_3
+ PM_OAI31xp33_ASAP7_75t_R%A2
cc_3 N_A2_1 N_A3_3 0.00165344f $X=0.135 $Y=0.135
cc_4 N_A2_4 N_A3_4 0.00637256f $X=0.135 $Y=0.0985
cc_5 N_A2_3 N_A3_3 0.00801959f $X=0.135 $Y=0.0245
x_PM_OAI31xp33_ASAP7_75t_R%A1 vss A1 N_M2_g N_M6_g N_A1_3 N_A1_4
+ PM_OAI31xp33_ASAP7_75t_R%A1
cc_6 N_A1_3 N_A2_1 0.00161783f $X=0.189 $Y=0.0245
cc_7 N_A1_4 N_A2_4 0.00532291f $X=0.189 $Y=0.0935
cc_8 N_A1_3 N_A2_3 0.00786004f $X=0.189 $Y=0.0245
x_PM_OAI31xp33_ASAP7_75t_R%Y vss Y N_M3_d N_M6_d N_M7_s N_Y_1 N_Y_8 N_Y_10
+ N_Y_13 N_Y_7 N_Y_14 PM_OAI31xp33_ASAP7_75t_R%Y
cc_9 N_Y_1 N_A2_4 0.0015595f $X=0.216 $Y=0.216
cc_10 N_Y_1 N_A1_3 0.00137808f $X=0.216 $Y=0.216
cc_11 N_Y_1 N_A1_4 0.00141157f $X=0.216 $Y=0.216
cc_12 N_Y_8 N_A1_3 0.00915404f $X=0.2015 $Y=0.1975
cc_13 N_Y_10 N_A1_3 0.0309662f $X=0.2015 $Y=0.2245
cc_14 N_Y_13 N_B_3 0.000890148f $X=0.272 $Y=0.234
cc_15 N_Y_1 N_B_3 0.00121327f $X=0.216 $Y=0.216
cc_16 N_Y_8 N_B_1 0.00129581f $X=0.2015 $Y=0.1975
cc_17 N_Y_7 N_B_3 0.0100383f $X=0.2555 $Y=0.054
cc_18 N_Y_10 N_B_3 0.00477409f $X=0.2015 $Y=0.2245
cc_19 N_Y_14 N_B_4 0.00571053f $X=0.297 $Y=0.0935
cc_20 N_Y_8 N_B_3 0.0486428f $X=0.2015 $Y=0.1975

* End of included file OAI31xp33_ASAP7_75t_R.pex.sp.pxi
.ends

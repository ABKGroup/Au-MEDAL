.subckt PM_OAI33xp33_ASAP7_75t_R%A2 vss 15 5 9 4 3
c1 1 vss 0.00262325f $X=0.135 $Y=0.135
c2 3 vss 0.103465f $X=0.135 $Y=0.0245
c3 4 vss 0.0108445f $X=0.135 $Y=0.098
r1 15 14 2.73998 $w=1.3e-08 $l=1.18e-08 $layer=M1 $thickness=3.6e-08 $X=0.133
+ $Y=0.167 $X2=0.135 $Y2=0.1552
r2 13 14 4.72209 $w=1.3e-08 $l=2.02e-08 $layer=M1 $thickness=3.6e-08 $X=0.135
+ $Y=0.135 $X2=0.135 $Y2=0.1552
r3 4 13 8.62802 $w=1.3e-08 $l=3.7e-08 $layer=M1 $thickness=3.6e-08 $X=0.135
+ $Y=0.098 $X2=0.135 $Y2=0.135
r4 1 7 6.74717 $w=2e-08 $layer=Gate_1 $thickness=5.2e-08 $X=0.135 $Y=0.135
+ $X2=0.135 $Y2=0.135
r5 1 13 19.3796 $a=3.24e-16 $layer=V0LIG $X=0.135 $Y=0.135 $X2=0.135 $Y2=0.135
r6 9 8 16.6668 $w=2.1e-08 $l=4.9e-08 $layer=Gate_1 $thickness=5.6e-08 $X=0.135
+ $Y=0.2025 $X2=0.135 $Y2=0.1535
r7 7 8 6.46262 $w=2.04595e-08 $l=1.85e-08 $layer=Gate_1 $thickness=5.6e-08
+ $X=0.135 $Y=0.135 $X2=0.135 $Y2=0.1535
r8 6 7 11.0545 $w=2.06875e-08 $l=3.2e-08 $layer=Gate_1 $thickness=5.6e-08
+ $X=0.135 $Y=0.103 $X2=0.135 $Y2=0.135
r9 5 6 16.6668 $w=2.1e-08 $l=4.9e-08 $layer=Gate_1 $thickness=5.6e-08 $X=0.135
+ $Y=0.054 $X2=0.135 $Y2=0.103
r10 5 3 10.0341 $w=2.1e-08 $l=2.95e-08 $layer=Gate_1 $thickness=5.6e-08
+ $X=0.135 $Y=0.054 $X2=0.135 $Y2=0.0245
.ends

.subckt PM_OAI33xp33_ASAP7_75t_R%A3 vss 13 5 9 4 3 1
c1 1 vss 0.00497883f $X=0.189 $Y=0.135
c2 3 vss 0.0827058f $X=0.189 $Y=0.0245
c3 4 vss 0.00740625f $X=0.189 $Y=0.0892
r1 16 17 4.4306 $w=1.3e-08 $l=1.9e-08 $layer=M1 $thickness=3.6e-08 $X=0.189
+ $Y=0.116 $X2=0.189 $Y2=0.135
r2 14 16 3.20636 $w=1.3e-08 $l=1.38e-08 $layer=M1 $thickness=3.6e-08 $X=0.189
+ $Y=0.1022 $X2=0.189 $Y2=0.116
r3 13 14 0.991056 $w=1.3e-08 $l=4.2e-09 $layer=M1 $thickness=3.6e-08 $X=0.186
+ $Y=0.098 $X2=0.189 $Y2=0.1022
r4 13 4 2.04041 $w=1.3e-08 $l=8.8e-09 $layer=M1 $thickness=3.6e-08 $X=0.186
+ $Y=0.098 $X2=0.189 $Y2=0.0892
r5 1 7 6.74717 $w=2e-08 $layer=Gate_1 $thickness=5.2e-08 $X=0.189 $Y=0.135
+ $X2=0.189 $Y2=0.135
r6 1 17 19.3796 $a=3.24e-16 $layer=V0LIG $X=0.189 $Y=0.135 $X2=0.189 $Y2=0.135
r7 9 8 16.6668 $w=2.1e-08 $l=4.9e-08 $layer=Gate_1 $thickness=5.6e-08 $X=0.189
+ $Y=0.2025 $X2=0.189 $Y2=0.1535
r8 7 8 6.46262 $w=2.04595e-08 $l=1.85e-08 $layer=Gate_1 $thickness=5.6e-08
+ $X=0.189 $Y=0.135 $X2=0.189 $Y2=0.1535
r9 6 7 11.0545 $w=2.06875e-08 $l=3.2e-08 $layer=Gate_1 $thickness=5.6e-08
+ $X=0.189 $Y=0.103 $X2=0.189 $Y2=0.135
r10 5 6 16.6668 $w=2.1e-08 $l=4.9e-08 $layer=Gate_1 $thickness=5.6e-08 $X=0.189
+ $Y=0.054 $X2=0.189 $Y2=0.103
r11 5 3 10.0341 $w=2.1e-08 $l=2.95e-08 $layer=Gate_1 $thickness=5.6e-08
+ $X=0.189 $Y=0.054 $X2=0.189 $Y2=0.0245
.ends

.subckt PM_OAI33xp33_ASAP7_75t_R%B2 vss 15 5 9 4 3 1
c1 1 vss 0.00185256f $X=0.297 $Y=0.135
c2 3 vss 0.0756399f $X=0.297 $Y=0.0245
c3 4 vss 0.00465677f $X=0.297 $Y=0.116
r1 15 14 0.524677 $w=1.3e-08 $l=2.3e-09 $layer=M1 $thickness=3.6e-08 $X=0.303
+ $Y=0.148 $X2=0.297 $Y2=0.1457
r2 13 14 2.50679 $w=1.3e-08 $l=1.07e-08 $layer=M1 $thickness=3.6e-08 $X=0.297
+ $Y=0.135 $X2=0.297 $Y2=0.1457
r3 4 13 4.4306 $w=1.3e-08 $l=1.9e-08 $layer=M1 $thickness=3.6e-08 $X=0.297
+ $Y=0.116 $X2=0.297 $Y2=0.135
r4 1 7 6.74717 $w=2e-08 $layer=Gate_1 $thickness=5.2e-08 $X=0.297 $Y=0.135
+ $X2=0.297 $Y2=0.135
r5 1 13 19.3796 $a=3.24e-16 $layer=V0LIG $X=0.297 $Y=0.135 $X2=0.297 $Y2=0.135
r6 9 8 16.6668 $w=2.1e-08 $l=4.9e-08 $layer=Gate_1 $thickness=5.6e-08 $X=0.297
+ $Y=0.2025 $X2=0.297 $Y2=0.1535
r7 7 8 6.46262 $w=2.04595e-08 $l=1.85e-08 $layer=Gate_1 $thickness=5.6e-08
+ $X=0.297 $Y=0.135 $X2=0.297 $Y2=0.1535
r8 6 7 11.0545 $w=2.06875e-08 $l=3.2e-08 $layer=Gate_1 $thickness=5.6e-08
+ $X=0.297 $Y=0.103 $X2=0.297 $Y2=0.135
r9 5 6 16.6668 $w=2.1e-08 $l=4.9e-08 $layer=Gate_1 $thickness=5.6e-08 $X=0.297
+ $Y=0.054 $X2=0.297 $Y2=0.103
r10 5 3 10.0341 $w=2.1e-08 $l=2.95e-08 $layer=Gate_1 $thickness=5.6e-08
+ $X=0.297 $Y=0.054 $X2=0.297 $Y2=0.0245
.ends

.subckt PM_OAI33xp33_ASAP7_75t_R%B3 vss 17 5 11 4 3
c1 1 vss 0.00624072f $X=0.351 $Y=0.135
c2 3 vss 0.0987205f $X=0.351 $Y=0.0245
c3 4 vss 0.0035808f $X=0.351 $Y=0.116
r1 17 16 1.34084 $w=1.3e-08 $l=5.8e-09 $layer=M1 $thickness=3.6e-08 $X=0.347
+ $Y=0.155 $X2=0.351 $Y2=0.1492
r2 15 16 3.32295 $w=1.3e-08 $l=1.42e-08 $layer=M1 $thickness=3.6e-08 $X=0.351
+ $Y=0.135 $X2=0.351 $Y2=0.1492
r3 4 15 4.4306 $w=1.3e-08 $l=1.9e-08 $layer=M1 $thickness=3.6e-08 $X=0.351
+ $Y=0.116 $X2=0.351 $Y2=0.135
r4 1 8 6.74717 $w=2e-08 $layer=Gate_1 $thickness=5.2e-08 $X=0.351 $Y=0.135
+ $X2=0.351 $Y2=0.135
r5 1 15 19.3796 $a=3.24e-16 $layer=V0LIG $X=0.351 $Y=0.135 $X2=0.351 $Y2=0.135
r6 11 10 14.6259 $w=2.1e-08 $l=4.3e-08 $layer=Gate_1 $thickness=5.6e-08
+ $X=0.351 $Y=0.2025 $X2=0.351 $Y2=0.1595
r7 9 10 2.89117 $w=2.1e-08 $l=8.5e-09 $layer=Gate_1 $thickness=5.6e-08 $X=0.351
+ $Y=0.151 $X2=0.351 $Y2=0.1595
r8 8 9 5.61228 $w=2.0375e-08 $l=1.6e-08 $layer=Gate_1 $thickness=5.6e-08
+ $X=0.351 $Y=0.135 $X2=0.351 $Y2=0.151
r9 7 8 5.61228 $w=2.0375e-08 $l=1.6e-08 $layer=Gate_1 $thickness=5.6e-08
+ $X=0.351 $Y=0.119 $X2=0.351 $Y2=0.135
r10 6 7 7.48304 $w=2.1e-08 $l=2.2e-08 $layer=Gate_1 $thickness=5.6e-08 $X=0.351
+ $Y=0.097 $X2=0.351 $Y2=0.119
r11 5 6 14.6259 $w=2.1e-08 $l=4.3e-08 $layer=Gate_1 $thickness=5.6e-08 $X=0.351
+ $Y=0.054 $X2=0.351 $Y2=0.097
r12 5 3 10.0341 $w=2.1e-08 $l=2.95e-08 $layer=Gate_1 $thickness=5.6e-08
+ $X=0.351 $Y=0.054 $X2=0.351 $Y2=0.0245
.ends

.subckt PM_OAI33xp33_ASAP7_75t_R%Y vss 35 20 21 34 48 49 12 1 15 10 16 17 11
c1 1 vss 0.00633327f $X=0.216 $Y=0.2025
c2 2 vss 0.00791904f $X=0.27 $Y=0.054
c3 3 vss 0.00684745f $X=0.378 $Y=0.054
c4 10 vss 0.00367546f $X=0.2555 $Y=0.054
c5 11 vss 0.0279168f $X=0.3635 $Y=0.054
c6 12 vss 0.00254217f $X=0.2015 $Y=0.2025
c7 13 vss 0.00149191f $X=0.405 $Y=0.072
c8 14 vss 0.00295411f $X=0.405 $Y=0.2307
c9 15 vss 0.0176016f $X=0.378 $Y=0.234
c10 16 vss 0.00992976f $X=0.2585 $Y=0.072
c11 17 vss 0.005383f $X=0.405 $Y=0.0935
r1 49 47 0.0308642 $w=8.1e-08 $l=2.5e-09 $layer=P_src_drn $thickness=1e-09
+ $X=0.2333 $Y=0.2025 $X2=0.2305 $Y2=0.2025
r2 1 47 0.179012 $w=8.1e-08 $l=1.45e-08 $layer=P_src_drn $thickness=1e-09
+ $X=0.216 $Y=0.2025 $X2=0.2305 $Y2=0.2025
r3 12 1 0.179012 $w=8.1e-08 $l=1.45e-08 $layer=P_src_drn $thickness=1e-09
+ $X=0.2015 $Y=0.2025 $X2=0.216 $Y2=0.2025
r4 48 12 0.0308642 $w=8.1e-08 $l=2.5e-09 $layer=P_src_drn $thickness=1e-09
+ $X=0.1986 $Y=0.2025 $X2=0.2015 $Y2=0.2025
r5 1 44 19.3796 $a=3.24e-16 $layer=V0LISD $X=0.216 $Y=0.2025 $X2=0.216 $Y2=0.234
r6 44 45 3.14806 $w=1.3e-08 $l=1.35e-08 $layer=M1 $thickness=3.6e-08 $X=0.216
+ $Y=0.234 $X2=0.2295 $Y2=0.234
r7 42 45 3.14806 $w=1.3e-08 $l=1.35e-08 $layer=M1 $thickness=3.6e-08 $X=0.243
+ $Y=0.234 $X2=0.2295 $Y2=0.234
r8 41 42 2.56509 $w=1.3e-08 $l=1.1e-08 $layer=M1 $thickness=3.6e-08 $X=0.254
+ $Y=0.234 $X2=0.243 $Y2=0.234
r9 40 41 4.19742 $w=1.3e-08 $l=1.8e-08 $layer=M1 $thickness=3.6e-08 $X=0.272
+ $Y=0.234 $X2=0.254 $Y2=0.234
r10 39 40 5.82974 $w=1.3e-08 $l=2.5e-08 $layer=M1 $thickness=3.6e-08 $X=0.297
+ $Y=0.234 $X2=0.272 $Y2=0.234
r11 38 39 6.29612 $w=1.3e-08 $l=2.7e-08 $layer=M1 $thickness=3.6e-08 $X=0.324
+ $Y=0.234 $X2=0.297 $Y2=0.234
r12 37 38 6.29612 $w=1.3e-08 $l=2.7e-08 $layer=M1 $thickness=3.6e-08 $X=0.351
+ $Y=0.234 $X2=0.324 $Y2=0.234
r13 35 15 4.24844 $w=9e-09 $l=2.71662e-08 $layer=M1 $thickness=3.6e-08 $X=0.406
+ $Y=0.237 $X2=0.378 $Y2=0.234
r14 15 37 6.29612 $w=1.3e-08 $l=2.7e-08 $layer=M1 $thickness=3.6e-08 $X=0.378
+ $Y=0.234 $X2=0.351 $Y2=0.234
r15 35 14 0.637778 $w=1.8e-08 $l=6.3e-09 $layer=M1 $thickness=3.6e-08 $X=0.406
+ $Y=0.237 $X2=0.405 $Y2=0.2307
r16 14 32 3.50163 $w=1.45753e-08 $l=1.82e-08 $layer=M1 $thickness=3.6e-08
+ $X=0.405 $Y=0.2307 $X2=0.405 $Y2=0.2125
r17 11 3 0.231482 $w=5.4e-08 $l=1.25e-08 $layer=N_src_drn $thickness=1e-09
+ $X=0.3635 $Y=0.054 $X2=0.378 $Y2=0.054
r18 34 11 0.0462963 $w=5.4e-08 $l=2.5e-09 $layer=N_src_drn $thickness=1e-09
+ $X=0.3606 $Y=0.054 $X2=0.3635 $Y2=0.054
r19 31 32 13.8748 $w=1.3e-08 $l=5.95e-08 $layer=M1 $thickness=3.6e-08 $X=0.405
+ $Y=0.153 $X2=0.405 $Y2=0.2125
r20 17 31 13.8748 $w=1.3e-08 $l=5.95e-08 $layer=M1 $thickness=3.6e-08 $X=0.405
+ $Y=0.0935 $X2=0.405 $Y2=0.153
r21 3 29 19.3796 $a=3.24e-16 $layer=V0LISD $X=0.378 $Y=0.054 $X2=0.378 $Y2=0.072
r22 13 30 1.49895 $w=1.63333e-08 $l=1.35e-08 $layer=M1 $thickness=3.6e-08
+ $X=0.405 $Y=0.072 $X2=0.3915 $Y2=0.072
r23 13 17 3.36447 $w=1.71023e-08 $l=2.15e-08 $layer=M1 $thickness=3.6e-08
+ $X=0.405 $Y=0.072 $X2=0.405 $Y2=0.0935
r24 29 30 3.14806 $w=1.3e-08 $l=1.35e-08 $layer=M1 $thickness=3.6e-08 $X=0.378
+ $Y=0.072 $X2=0.3915 $Y2=0.072
r25 28 29 3.14806 $w=1.3e-08 $l=1.35e-08 $layer=M1 $thickness=3.6e-08 $X=0.3645
+ $Y=0.072 $X2=0.378 $Y2=0.072
r26 27 28 3.14806 $w=1.3e-08 $l=1.35e-08 $layer=M1 $thickness=3.6e-08 $X=0.351
+ $Y=0.072 $X2=0.3645 $Y2=0.072
r27 26 27 2.56509 $w=1.3e-08 $l=1.1e-08 $layer=M1 $thickness=3.6e-08 $X=0.34
+ $Y=0.072 $X2=0.351 $Y2=0.072
r28 25 26 4.19742 $w=1.3e-08 $l=1.8e-08 $layer=M1 $thickness=3.6e-08 $X=0.322
+ $Y=0.072 $X2=0.34 $Y2=0.072
r29 24 25 5.82974 $w=1.3e-08 $l=2.5e-08 $layer=M1 $thickness=3.6e-08 $X=0.297
+ $Y=0.072 $X2=0.322 $Y2=0.072
r30 23 24 3.14806 $w=1.3e-08 $l=1.35e-08 $layer=M1 $thickness=3.6e-08 $X=0.2835
+ $Y=0.072 $X2=0.297 $Y2=0.072
r31 22 23 3.14806 $w=1.3e-08 $l=1.35e-08 $layer=M1 $thickness=3.6e-08 $X=0.27
+ $Y=0.072 $X2=0.2835 $Y2=0.072
r32 16 22 2.68168 $w=1.3e-08 $l=1.15e-08 $layer=M1 $thickness=3.6e-08 $X=0.2585
+ $Y=0.072 $X2=0.27 $Y2=0.072
r33 2 22 19.3796 $a=3.24e-16 $layer=V0LISD $X=0.27 $Y=0.054 $X2=0.27 $Y2=0.072
r34 21 19 0.0462963 $w=5.4e-08 $l=2.5e-09 $layer=N_src_drn $thickness=1e-09
+ $X=0.2873 $Y=0.054 $X2=0.2845 $Y2=0.054
r35 2 19 0.268519 $w=5.4e-08 $l=1.45e-08 $layer=N_src_drn $thickness=1e-09
+ $X=0.27 $Y=0.054 $X2=0.2845 $Y2=0.054
r36 10 2 0.268519 $w=5.4e-08 $l=1.45e-08 $layer=N_src_drn $thickness=1e-09
+ $X=0.2555 $Y=0.054 $X2=0.27 $Y2=0.054
r37 20 10 0.0462963 $w=5.4e-08 $l=2.5e-09 $layer=N_src_drn $thickness=1e-09
+ $X=0.2526 $Y=0.054 $X2=0.2555 $Y2=0.054
.ends

.subckt PM_OAI33xp33_ASAP7_75t_R%A1 vss 17 5 11 4 3
c1 1 vss 0.0053558f $X=0.081 $Y=0.135
c2 3 vss 0.126125f $X=0.081 $Y=0.0245
c3 4 vss 0.0146786f $X=0.081 $Y=0.098
r1 17 16 3.32295 $w=1.3e-08 $l=1.43e-08 $layer=M1 $thickness=3.6e-08 $X=0.082
+ $Y=0.172 $X2=0.081 $Y2=0.1577
r2 15 16 5.30507 $w=1.3e-08 $l=2.27e-08 $layer=M1 $thickness=3.6e-08 $X=0.081
+ $Y=0.135 $X2=0.081 $Y2=0.1577
r3 4 15 8.62802 $w=1.3e-08 $l=3.7e-08 $layer=M1 $thickness=3.6e-08 $X=0.081
+ $Y=0.098 $X2=0.081 $Y2=0.135
r4 1 8 6.74717 $w=2e-08 $layer=Gate_1 $thickness=5.2e-08 $X=0.081 $Y=0.135
+ $X2=0.081 $Y2=0.135
r5 1 15 19.3796 $a=3.24e-16 $layer=V0LIG $X=0.081 $Y=0.135 $X2=0.081 $Y2=0.135
r6 11 10 14.6259 $w=2.1e-08 $l=4.3e-08 $layer=Gate_1 $thickness=5.6e-08
+ $X=0.081 $Y=0.2025 $X2=0.081 $Y2=0.1595
r7 9 10 2.89117 $w=2.1e-08 $l=8.5e-09 $layer=Gate_1 $thickness=5.6e-08 $X=0.081
+ $Y=0.151 $X2=0.081 $Y2=0.1595
r8 8 9 5.61228 $w=2.0375e-08 $l=1.6e-08 $layer=Gate_1 $thickness=5.6e-08
+ $X=0.081 $Y=0.135 $X2=0.081 $Y2=0.151
r9 7 8 5.61228 $w=2.0375e-08 $l=1.6e-08 $layer=Gate_1 $thickness=5.6e-08
+ $X=0.081 $Y=0.119 $X2=0.081 $Y2=0.135
r10 6 7 7.48304 $w=2.1e-08 $l=2.2e-08 $layer=Gate_1 $thickness=5.6e-08 $X=0.081
+ $Y=0.097 $X2=0.081 $Y2=0.119
r11 5 6 14.6259 $w=2.1e-08 $l=4.3e-08 $layer=Gate_1 $thickness=5.6e-08 $X=0.081
+ $Y=0.054 $X2=0.081 $Y2=0.097
r12 5 3 10.0341 $w=2.1e-08 $l=2.95e-08 $layer=Gate_1 $thickness=5.6e-08
+ $X=0.081 $Y=0.054 $X2=0.081 $Y2=0.0245
.ends

.subckt PM_OAI33xp33_ASAP7_75t_R%B1 vss 15 5 9 4 3 1
c1 1 vss 0.00611315f $X=0.243 $Y=0.135
c2 3 vss 0.0567106f $X=0.243 $Y=0.0245
c3 4 vss 0.0043854f $X=0.243 $Y=0.116
r1 15 14 0.524677 $w=1.3e-08 $l=2.3e-09 $layer=M1 $thickness=3.6e-08 $X=0.239
+ $Y=0.148 $X2=0.243 $Y2=0.1457
r2 13 14 2.50679 $w=1.3e-08 $l=1.07e-08 $layer=M1 $thickness=3.6e-08 $X=0.243
+ $Y=0.135 $X2=0.243 $Y2=0.1457
r3 4 13 4.4306 $w=1.3e-08 $l=1.9e-08 $layer=M1 $thickness=3.6e-08 $X=0.243
+ $Y=0.116 $X2=0.243 $Y2=0.135
r4 1 7 6.74717 $w=2e-08 $layer=Gate_1 $thickness=5.2e-08 $X=0.243 $Y=0.135
+ $X2=0.243 $Y2=0.135
r5 1 13 19.3796 $a=3.24e-16 $layer=V0LIG $X=0.243 $Y=0.135 $X2=0.243 $Y2=0.135
r6 9 8 16.6668 $w=2.1e-08 $l=4.9e-08 $layer=Gate_1 $thickness=5.6e-08 $X=0.243
+ $Y=0.2025 $X2=0.243 $Y2=0.1535
r7 7 8 6.46262 $w=2.04595e-08 $l=1.85e-08 $layer=Gate_1 $thickness=5.6e-08
+ $X=0.243 $Y=0.135 $X2=0.243 $Y2=0.1535
r8 6 7 11.0545 $w=2.06875e-08 $l=3.2e-08 $layer=Gate_1 $thickness=5.6e-08
+ $X=0.243 $Y=0.103 $X2=0.243 $Y2=0.135
r9 5 6 16.6668 $w=2.1e-08 $l=4.9e-08 $layer=Gate_1 $thickness=5.6e-08 $X=0.243
+ $Y=0.054 $X2=0.243 $Y2=0.103
r10 5 3 10.0341 $w=2.1e-08 $l=2.95e-08 $layer=Gate_1 $thickness=5.6e-08
+ $X=0.243 $Y=0.054 $X2=0.243 $Y2=0.0245
.ends

* End of included file OAI33xp33_ASAP7_75t_R.pex.sp.pex

*
.subckt OAI33xp33_ASAP7_75t_CUSTOM_4_25_0_7 VSS VDD A1 A2 A3 B1 B2 B3 Y
*
* VSS VSS
* VDD VDD
* A1 A1
* A2 A2
* A3 A3
* B1 B1
* B2 B2
* B3 B3
* Y Y
*
*

M0 noxref_9 N_M0_g VSS VSS nmos_rvt L=2e-08 W=5.4e-08 nfin=2 $X=0.071 $Y=0.027
M1 VSS N_M1_g noxref_9 VSS nmos_rvt L=2e-08 W=5.4e-08 nfin=2 $X=0.125 $Y=0.027
M2 noxref_9 N_M2_g VSS VSS nmos_rvt L=2e-08 W=5.4e-08 nfin=2 $X=0.179 $Y=0.027
M3 N_M3_d N_M3_g noxref_9 VSS nmos_rvt L=2e-08 W=5.4e-08 nfin=2 $X=0.233
+ $Y=0.027
M4 noxref_9 N_M4_g N_M4_s VSS nmos_rvt L=2e-08 W=5.4e-08 nfin=2 $X=0.287
+ $Y=0.027
M5 N_M5_d N_M5_g noxref_9 VSS nmos_rvt L=2e-08 W=5.4e-08 nfin=2 $X=0.341
+ $Y=0.027
M6 noxref_11 N_M6_g VDD VDD pmos_rvt L=2e-08 W=8.1e-08 nfin=3 $X=0.071 $Y=0.162
M7 noxref_12 N_M7_g noxref_11 VDD pmos_rvt L=2e-08 W=8.1e-08 nfin=3 $X=0.125
+ $Y=0.162
M8 N_M8_d N_M8_g noxref_12 VDD pmos_rvt L=2e-08 W=8.1e-08 nfin=3 $X=0.179
+ $Y=0.162
M9 noxref_13 N_M9_g N_M9_s VDD pmos_rvt L=2e-08 W=8.1e-08 nfin=3 $X=0.233
+ $Y=0.162
M10 noxref_14 N_M10_g noxref_13 VDD pmos_rvt L=2e-08 W=8.1e-08 nfin=3 $X=0.287
+ $Y=0.162
M11 VDD N_M11_g noxref_14 VDD pmos_rvt L=2e-08 W=8.1e-08 nfin=3 $X=0.341
+ $Y=0.162

* .include "OAI33xp33_ASAP7_75t_R.pex.sp.pxi"

* Start of included file OAI33xp33_ASAP7_75t_R.pex.sp.pxi
x_PM_OAI33xp33_ASAP7_75t_R%A2 vss A2 N_M1_g N_M7_g N_A2_4 N_A2_3
+ PM_OAI33xp33_ASAP7_75t_R%A2
cc_1 N_A2_4 N_A1_4 0.00638651f $X=0.135 $Y=0.098
cc_2 N_A2_3 N_A1_3 0.0094829f $X=0.135 $Y=0.0245
x_PM_OAI33xp33_ASAP7_75t_R%A3 vss A3 N_M2_g N_M8_g N_A3_4 N_A3_3 N_A3_1
+ PM_OAI33xp33_ASAP7_75t_R%A3
cc_3 N_A3_4 N_A2_4 0.00522678f $X=0.189 $Y=0.0892
cc_4 N_A3_3 N_A2_3 0.00925767f $X=0.189 $Y=0.0245
x_PM_OAI33xp33_ASAP7_75t_R%B2 vss B2 N_M4_g N_M10_g N_B2_4 N_B2_3 N_B2_1
+ PM_OAI33xp33_ASAP7_75t_R%B2
cc_5 N_B2_4 N_B1_4 0.00336245f $X=0.297 $Y=0.116
cc_6 N_B2_3 N_B1_3 0.00918991f $X=0.297 $Y=0.0245
x_PM_OAI33xp33_ASAP7_75t_R%B3 vss B3 N_M5_g N_M11_g N_B3_4 N_B3_3
+ PM_OAI33xp33_ASAP7_75t_R%B3
cc_7 N_B3_4 N_B2_4 0.00343175f $X=0.351 $Y=0.116
cc_8 N_B3_3 N_B2_3 0.00921003f $X=0.351 $Y=0.0245
x_PM_OAI33xp33_ASAP7_75t_R%Y vss Y N_M3_d N_M4_s N_M5_d N_M8_d N_M9_s N_Y_12
+ N_Y_1 N_Y_15 N_Y_10 N_Y_16 N_Y_17 N_Y_11 PM_OAI33xp33_ASAP7_75t_R%Y
cc_9 N_Y_12 N_A3_1 0.000966631f $X=0.2015 $Y=0.2025
cc_10 N_Y_1 N_A3_4 0.00137847f $X=0.216 $Y=0.2025
cc_11 N_Y_1 N_A3_3 0.00140677f $X=0.216 $Y=0.2025
cc_12 N_Y_12 N_A3_3 0.0361268f $X=0.2015 $Y=0.2025
cc_13 N_Y_12 N_B1_4 0.000580166f $X=0.2015 $Y=0.2025
cc_14 N_Y_12 N_B1_1 0.000966631f $X=0.2015 $Y=0.2025
cc_15 N_Y_15 N_B1_4 0.00115709f $X=0.378 $Y=0.234
cc_16 N_Y_1 N_B1_3 0.00133579f $X=0.216 $Y=0.2025
cc_17 N_Y_1 N_B1_4 0.00239792f $X=0.216 $Y=0.2025
cc_18 N_Y_10 N_B1_3 0.0105631f $X=0.2555 $Y=0.054
cc_19 N_Y_12 N_B1_3 0.0505117f $X=0.2015 $Y=0.2025
cc_20 N_Y_10 N_B2_1 0.000472403f $X=0.2555 $Y=0.054
cc_21 N_Y_15 N_B2_4 0.00144044f $X=0.378 $Y=0.234
cc_22 N_Y_16 N_B2_4 0.0037125f $X=0.2585 $Y=0.072
cc_23 N_Y_10 N_B2_3 0.0266522f $X=0.2555 $Y=0.054
cc_24 N_Y_16 N_B3_3 0.00109654f $X=0.2585 $Y=0.072
cc_25 N_Y_15 N_B3_4 0.00118933f $X=0.378 $Y=0.234
cc_26 N_Y_17 N_B3_4 0.00609165f $X=0.405 $Y=0.0935
cc_27 N_Y_11 N_B3_3 0.0271234f $X=0.3635 $Y=0.054
x_PM_OAI33xp33_ASAP7_75t_R%A1 vss A1 N_M0_g N_M6_g N_A1_4 N_A1_3
+ PM_OAI33xp33_ASAP7_75t_R%A1
x_PM_OAI33xp33_ASAP7_75t_R%B1 vss B1 N_M3_g N_M9_g N_B1_4 N_B1_3 N_B1_1
+ PM_OAI33xp33_ASAP7_75t_R%B1
cc_28 N_B1_4 N_A3_4 0.00362653f $X=0.243 $Y=0.116
cc_29 N_B1_3 N_A3_3 0.007117f $X=0.243 $Y=0.0245

* End of included file OAI33xp33_ASAP7_75t_R.pex.sp.pxi
.ends

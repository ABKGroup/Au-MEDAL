.subckt PM_OA22x2_ASAP7_75t_R%B1 vss 14 5 11 3
c1 1 vss 0.00714576f $X=0.459 $Y=0.135
c2 3 vss 0.142712f $X=0.459 $Y=0.0245
c3 4 vss 0.0161055f $X=0.459 $Y=0.0755
r1 14 13 7.34548 $w=1.3e-08 $l=3.15e-08 $layer=M1 $thickness=3.6e-08 $X=0.458
+ $Y=0.138 $X2=0.459 $Y2=0.1035
r2 4 13 6.52931 $w=1.3e-08 $l=2.8e-08 $layer=M1 $thickness=3.6e-08 $X=0.459
+ $Y=0.0755 $X2=0.459 $Y2=0.1035
r3 1 8 10.4265 $w=1.765e-08 $layer=LIG $thickness=5.2e-08 $X=0.459 $Y=0.135
+ $X2=0.459 $Y2=0.135
r4 14 1 19.3796 $a=3.24e-16 $layer=V0LIG $X=0.458 $Y=0.138 $X2=0.459 $Y2=0.135
r5 11 10 14.6259 $w=2.1e-08 $l=4.3e-08 $layer=Gate_1 $thickness=5.6e-08
+ $X=0.459 $Y=0.2025 $X2=0.459 $Y2=0.1595
r6 9 10 2.7211 $w=2.1e-08 $l=8e-09 $layer=Gate_1 $thickness=5.6e-08 $X=0.459
+ $Y=0.1515 $X2=0.459 $Y2=0.1595
r7 8 9 5.79936 $w=2.03333e-08 $l=1.65e-08 $layer=Gate_1 $thickness=5.6e-08
+ $X=0.459 $Y=0.135 $X2=0.459 $Y2=0.1515
r8 7 8 5.79936 $w=2.03333e-08 $l=1.65e-08 $layer=Gate_1 $thickness=5.6e-08
+ $X=0.459 $Y=0.1185 $X2=0.459 $Y2=0.135
r9 6 7 2.7211 $w=2.1e-08 $l=8e-09 $layer=Gate_1 $thickness=5.6e-08 $X=0.459
+ $Y=0.1105 $X2=0.459 $Y2=0.1185
r10 5 6 14.6259 $w=2.1e-08 $l=4.3e-08 $layer=Gate_1 $thickness=5.6e-08 $X=0.459
+ $Y=0.0675 $X2=0.459 $Y2=0.1105
r11 5 3 14.6259 $w=2.1e-08 $l=4.3e-08 $layer=Gate_1 $thickness=5.6e-08 $X=0.459
+ $Y=0.0675 $X2=0.459 $Y2=0.0245
.ends

.subckt PM_OA22x2_ASAP7_75t_R%A2 vss 11 5 9 3 4 1
c1 1 vss 0.00674355f $X=0.351 $Y=0.135
c2 3 vss 0.0648757f $X=0.351 $Y=0.0245
c3 4 vss 0.00420518f $X=0.351 $Y=0.116
r1 11 4 4.4306 $w=1.3e-08 $l=1.9e-08 $layer=M1 $thickness=3.6e-08 $X=0.35
+ $Y=0.137 $X2=0.351 $Y2=0.116
r2 1 7 10.4265 $w=1.765e-08 $layer=LIG $thickness=5.2e-08 $X=0.351 $Y=0.135
+ $X2=0.351 $Y2=0.135
r3 11 1 19.3796 $a=3.24e-16 $layer=V0LIG $X=0.35 $Y=0.137 $X2=0.351 $Y2=0.135
r4 9 8 16.4967 $w=2.1e-08 $l=4.85e-08 $layer=Gate_1 $thickness=5.6e-08 $X=0.351
+ $Y=0.2025 $X2=0.351 $Y2=0.154
r5 7 8 6.6497 $w=2.04211e-08 $l=1.9e-08 $layer=Gate_1 $thickness=5.6e-08
+ $X=0.351 $Y=0.135 $X2=0.351 $Y2=0.154
r6 6 7 6.6497 $w=2.04211e-08 $l=1.9e-08 $layer=Gate_1 $thickness=5.6e-08
+ $X=0.351 $Y=0.116 $X2=0.351 $Y2=0.135
r7 5 6 16.4967 $w=2.1e-08 $l=4.85e-08 $layer=Gate_1 $thickness=5.6e-08 $X=0.351
+ $Y=0.0675 $X2=0.351 $Y2=0.116
r8 5 3 14.6259 $w=2.1e-08 $l=4.3e-08 $layer=Gate_1 $thickness=5.6e-08 $X=0.351
+ $Y=0.0675 $X2=0.351 $Y2=0.0245
.ends

.subckt PM_OA22x2_ASAP7_75t_R%3 vss 21 27 38 42 62 63 66 67 3 19 20 11 4 12 1
+ 18 13 15 16 10 9
c1 1 vss 0.0166586f $X=0.081 $Y=0.135
c2 3 vss 0.00987805f $X=0.324 $Y=0.0675
c3 4 vss 0.00662222f $X=0.378 $Y=0.2025
c4 9 vss 0.0840199f $X=0.081 $Y=0.0245
c5 10 vss 0.0842142f $X=0.135 $Y=0.135
c6 11 vss 0.00738782f $X=0.3095 $Y=0.0675
c7 12 vss 0.00626503f $X=0.3635 $Y=0.2025
c8 13 vss 0.00222982f $X=0.189 $Y=0.072
c9 14 vss 0.000521677f $X=0.189 $Y=0.135
c10 15 vss 0.00329095f $X=0.189 $Y=0.234
c11 16 vss 0.0017395f $X=0.1395 $Y=0.135
c12 17 vss 0.002338f $X=0.189 $Y=0.116
c13 18 vss 0.0048891f $X=0.189 $Y=0.172
c14 19 vss 0.0129136f $X=0.227 $Y=0.072
c15 20 vss 0.0212019f $X=0.243 $Y=0.234
r1 66 65 0.0308642 $w=8.1e-08 $l=2.5e-09 $layer=P_src_drn $thickness=1e-09
+ $X=0.3953 $Y=0.2025 $X2=0.3925 $Y2=0.2025
r2 4 65 0.179012 $w=8.1e-08 $l=1.45e-08 $layer=P_src_drn $thickness=1e-09
+ $X=0.378 $Y=0.2025 $X2=0.3925 $Y2=0.2025
r3 12 4 0.179012 $w=8.1e-08 $l=1.45e-08 $layer=P_src_drn $thickness=1e-09
+ $X=0.3635 $Y=0.2025 $X2=0.378 $Y2=0.2025
r4 67 12 0.0308642 $w=8.1e-08 $l=2.5e-09 $layer=P_src_drn $thickness=1e-09
+ $X=0.3606 $Y=0.2025 $X2=0.3635 $Y2=0.2025
r5 63 61 0.0308642 $w=8.1e-08 $l=2.5e-09 $layer=N_src_drn $thickness=1e-09
+ $X=0.3413 $Y=0.0675 $X2=0.3385 $Y2=0.0675
r6 3 61 0.179012 $w=8.1e-08 $l=1.45e-08 $layer=N_src_drn $thickness=1e-09
+ $X=0.324 $Y=0.0675 $X2=0.3385 $Y2=0.0675
r7 11 3 0.179012 $w=8.1e-08 $l=1.45e-08 $layer=N_src_drn $thickness=1e-09
+ $X=0.3095 $Y=0.0675 $X2=0.324 $Y2=0.0675
r8 62 11 0.0308642 $w=8.1e-08 $l=2.5e-09 $layer=N_src_drn $thickness=1e-09
+ $X=0.3066 $Y=0.0675 $X2=0.3095 $Y2=0.0675
r9 4 58 19.3796 $a=3.24e-16 $layer=V0LISD $X=0.378 $Y=0.2025 $X2=0.378 $Y2=0.234
r10 3 51 19.3796 $a=3.24e-16 $layer=V0LISD $X=0.324 $Y=0.0675 $X2=0.324
+ $Y2=0.072
r11 57 58 2.3319 $w=1.3e-08 $l=1e-08 $layer=M1 $thickness=3.6e-08 $X=0.368
+ $Y=0.234 $X2=0.378 $Y2=0.234
r12 56 57 1.04935 $w=1.3e-08 $l=4.5e-09 $layer=M1 $thickness=3.6e-08 $X=0.3635
+ $Y=0.234 $X2=0.368 $Y2=0.234
r13 55 56 2.91487 $w=1.3e-08 $l=1.25e-08 $layer=M1 $thickness=3.6e-08 $X=0.351
+ $Y=0.234 $X2=0.3635 $Y2=0.234
r14 54 55 3.14806 $w=1.3e-08 $l=1.35e-08 $layer=M1 $thickness=3.6e-08 $X=0.3375
+ $Y=0.234 $X2=0.351 $Y2=0.234
r15 53 54 4.19742 $w=1.3e-08 $l=1.8e-08 $layer=M1 $thickness=3.6e-08 $X=0.3195
+ $Y=0.234 $X2=0.3375 $Y2=0.234
r16 52 53 5.24677 $w=1.3e-08 $l=2.25e-08 $layer=M1 $thickness=3.6e-08 $X=0.297
+ $Y=0.234 $X2=0.3195 $Y2=0.234
r17 20 52 12.5922 $w=1.3e-08 $l=5.4e-08 $layer=M1 $thickness=3.6e-08 $X=0.243
+ $Y=0.234 $X2=0.297 $Y2=0.234
r18 50 51 3.14806 $w=1.3e-08 $l=1.35e-08 $layer=M1 $thickness=3.6e-08 $X=0.3105
+ $Y=0.072 $X2=0.324 $Y2=0.072
r19 49 50 3.14806 $w=1.3e-08 $l=1.35e-08 $layer=M1 $thickness=3.6e-08 $X=0.297
+ $Y=0.072 $X2=0.3105 $Y2=0.072
r20 48 49 5.82974 $w=1.3e-08 $l=2.5e-08 $layer=M1 $thickness=3.6e-08 $X=0.272
+ $Y=0.072 $X2=0.297 $Y2=0.072
r21 19 48 10.4935 $w=1.3e-08 $l=4.5e-08 $layer=M1 $thickness=3.6e-08 $X=0.227
+ $Y=0.072 $X2=0.272 $Y2=0.072
r22 15 47 3.36447 $w=1.71023e-08 $l=2.15e-08 $layer=M1 $thickness=3.6e-08
+ $X=0.189 $Y=0.234 $X2=0.189 $Y2=0.2125
r23 15 20 10.9431 $w=1.38333e-08 $l=5.4e-08 $layer=M1 $thickness=3.6e-08
+ $X=0.189 $Y=0.234 $X2=0.243 $Y2=0.234
r24 13 46 3.36447 $w=1.71023e-08 $l=2.15e-08 $layer=M1 $thickness=3.6e-08
+ $X=0.189 $Y=0.072 $X2=0.189 $Y2=0.0935
r25 13 19 7.2121 $w=1.41842e-08 $l=3.8e-08 $layer=M1 $thickness=3.6e-08
+ $X=0.189 $Y=0.072 $X2=0.227 $Y2=0.072
r26 18 47 9.44419 $w=1.3e-08 $l=4.05e-08 $layer=M1 $thickness=3.6e-08 $X=0.189
+ $Y=0.172 $X2=0.189 $Y2=0.2125
r27 17 46 5.24677 $w=1.3e-08 $l=2.25e-08 $layer=M1 $thickness=3.6e-08 $X=0.189
+ $Y=0.116 $X2=0.189 $Y2=0.0935
r28 14 45 3.2503 $w=1.53684e-08 $l=1.9e-08 $layer=M1 $thickness=3.6e-08
+ $X=0.189 $Y=0.135 $X2=0.17 $Y2=0.135
r29 14 17 3.2503 $w=1.53684e-08 $l=1.9e-08 $layer=M1 $thickness=3.6e-08
+ $X=0.189 $Y=0.135 $X2=0.189 $Y2=0.116
r30 14 18 7.44771 $w=1.42162e-08 $l=3.7e-08 $layer=M1 $thickness=3.6e-08
+ $X=0.189 $Y=0.135 $X2=0.189 $Y2=0.172
r31 44 45 4.43061 $w=1.3e-08 $l=1.9e-08 $layer=M1 $thickness=3.6e-08 $X=0.151
+ $Y=0.135 $X2=0.17 $Y2=0.135
r32 16 44 2.68168 $w=1.3e-08 $l=1.15e-08 $layer=M1 $thickness=3.6e-08 $X=0.1395
+ $Y=0.135 $X2=0.151 $Y2=0.135
r33 42 41 14.6259 $w=2.1e-08 $l=4.3e-08 $layer=Gate_1 $thickness=5.6e-08
+ $X=0.135 $Y=0.2025 $X2=0.135 $Y2=0.1595
r34 40 41 2.7211 $w=2.1e-08 $l=8e-09 $layer=Gate_1 $thickness=5.6e-08 $X=0.135
+ $Y=0.1515 $X2=0.135 $Y2=0.1595
r35 38 39 14.6259 $w=2.1e-08 $l=4.3e-08 $layer=Gate_1 $thickness=5.6e-08
+ $X=0.135 $Y=0.0675 $X2=0.135 $Y2=0.1105
r36 36 39 2.7211 $w=2.1e-08 $l=8e-09 $layer=Gate_1 $thickness=5.6e-08 $X=0.135
+ $Y=0.1185 $X2=0.135 $Y2=0.1105
r37 10 33 3.9286 $w=2e-08 $layer=Gate_1 $thickness=5.6e-08 $X=0.135 $Y=0.135
+ $X2=0.135 $Y2=0.135
r38 10 36 5.79936 $w=2.03333e-08 $l=1.65e-08 $layer=Gate_1 $thickness=5.6e-08
+ $X=0.135 $Y=0.135 $X2=0.135 $Y2=0.1185
r39 10 40 5.79936 $w=2.03333e-08 $l=1.65e-08 $layer=Gate_1 $thickness=5.6e-08
+ $X=0.135 $Y=0.135 $X2=0.135 $Y2=0.1515
r40 34 44 19.3796 $a=3.24e-16 $layer=V0LIG $X=0.1525 $Y=0.135 $X2=0.151
+ $Y2=0.135
r41 32 34 4.82216 $w=1.64167e-08 $l=9e-09 $layer=LIG $thickness=4.8e-08
+ $X=0.1435 $Y=0.135 $X2=0.1525 $Y2=0.135
r42 31 32 2.6116 $w=2.2e-08 $l=1e-08 $layer=LIG $thickness=4.8e-08 $X=0.1335
+ $Y=0.135 $X2=0.1435 $Y2=0.135
r43 31 33 2.21986 $w=2.2e-08 $l=1.5e-09 $layer=LIG $thickness=4.8e-08 $X=0.1335
+ $Y=0.135 $X2=0.135 $Y2=0.135
r44 30 31 12.2622 $w=1.75333e-08 $l=2.55e-08 $layer=LIG $thickness=4.8e-08
+ $X=0.108 $Y=0.135 $X2=0.1335 $Y2=0.135
r45 1 24 6.54019 $w=2.09524e-08 $layer=Gate_1 $thickness=5.21905e-08 $X=0.081
+ $Y=0.135 $X2=0.081 $Y2=0.135
r46 1 30 12.6539 $w=1.77815e-08 $l=2.7e-08 $layer=LIG $thickness=4.8e-08
+ $X=0.081 $Y=0.135 $X2=0.108 $Y2=0.135
r47 27 26 14.6259 $w=2.1e-08 $l=4.3e-08 $layer=Gate_1 $thickness=5.6e-08
+ $X=0.081 $Y=0.2025 $X2=0.081 $Y2=0.1595
r48 25 26 2.7211 $w=2.1e-08 $l=8e-09 $layer=Gate_1 $thickness=5.6e-08 $X=0.081
+ $Y=0.1515 $X2=0.081 $Y2=0.1595
r49 24 25 5.79936 $w=2.03333e-08 $l=1.65e-08 $layer=Gate_1 $thickness=5.6e-08
+ $X=0.081 $Y=0.135 $X2=0.081 $Y2=0.1515
r50 23 24 5.79936 $w=2.03333e-08 $l=1.65e-08 $layer=Gate_1 $thickness=5.6e-08
+ $X=0.081 $Y=0.1185 $X2=0.081 $Y2=0.135
r51 22 23 2.7211 $w=2.1e-08 $l=8e-09 $layer=Gate_1 $thickness=5.6e-08 $X=0.081
+ $Y=0.1105 $X2=0.081 $Y2=0.1185
r52 21 22 14.6259 $w=2.1e-08 $l=4.3e-08 $layer=Gate_1 $thickness=5.6e-08
+ $X=0.081 $Y=0.0675 $X2=0.081 $Y2=0.1105
r53 21 9 14.6259 $w=2.1e-08 $l=4.3e-08 $layer=Gate_1 $thickness=5.6e-08
+ $X=0.081 $Y=0.0675 $X2=0.081 $Y2=0.0245
.ends

.subckt PM_OA22x2_ASAP7_75t_R%A1 vss 15 5 11 3 4
c1 1 vss 0.00501114f $X=0.297 $Y=0.135
c2 3 vss 0.106609f $X=0.297 $Y=0.0245
c3 4 vss 0.00493827f $X=0.297 $Y=0.116
r1 15 14 5.65485 $w=1.3e-08 $l=2.43e-08 $layer=M1 $thickness=3.6e-08 $X=0.296
+ $Y=0.192 $X2=0.297 $Y2=0.1677
r2 13 14 7.63696 $w=1.3e-08 $l=3.27e-08 $layer=M1 $thickness=3.6e-08 $X=0.297
+ $Y=0.135 $X2=0.297 $Y2=0.1677
r3 4 13 4.4306 $w=1.3e-08 $l=1.9e-08 $layer=M1 $thickness=3.6e-08 $X=0.297
+ $Y=0.116 $X2=0.297 $Y2=0.135
r4 1 8 10.4265 $w=1.765e-08 $layer=LIG $thickness=5.2e-08 $X=0.297 $Y=0.135
+ $X2=0.297 $Y2=0.135
r5 1 13 19.3796 $a=3.24e-16 $layer=V0LIG $X=0.297 $Y=0.135 $X2=0.297 $Y2=0.135
r6 11 10 14.6259 $w=2.1e-08 $l=4.3e-08 $layer=Gate_1 $thickness=5.6e-08
+ $X=0.297 $Y=0.2025 $X2=0.297 $Y2=0.1595
r7 9 10 2.7211 $w=2.1e-08 $l=8e-09 $layer=Gate_1 $thickness=5.6e-08 $X=0.297
+ $Y=0.1515 $X2=0.297 $Y2=0.1595
r8 8 9 5.79936 $w=2.03333e-08 $l=1.65e-08 $layer=Gate_1 $thickness=5.6e-08
+ $X=0.297 $Y=0.135 $X2=0.297 $Y2=0.1515
r9 7 8 5.79936 $w=2.03333e-08 $l=1.65e-08 $layer=Gate_1 $thickness=5.6e-08
+ $X=0.297 $Y=0.1185 $X2=0.297 $Y2=0.135
r10 6 7 2.7211 $w=2.1e-08 $l=8e-09 $layer=Gate_1 $thickness=5.6e-08 $X=0.297
+ $Y=0.1105 $X2=0.297 $Y2=0.1185
r11 5 6 14.6259 $w=2.1e-08 $l=4.3e-08 $layer=Gate_1 $thickness=5.6e-08 $X=0.297
+ $Y=0.0675 $X2=0.297 $Y2=0.1105
r12 5 3 14.6259 $w=2.1e-08 $l=4.3e-08 $layer=Gate_1 $thickness=5.6e-08 $X=0.297
+ $Y=0.0675 $X2=0.297 $Y2=0.0245
.ends

.subckt PM_OA22x2_ASAP7_75t_R%B2 vss 15 6 10 3 4 5
c1 1 vss 0.00628667f $X=0.405 $Y=0.135
c2 3 vss 0.10182f $X=0.405 $Y=0.0245
c3 4 vss 0.00811374f $X=0.405 $Y=0.072
c4 5 vss 0.00441443f $X=0.405 $Y=0.0935
r1 4 5 3.83327 $w=1.5093e-08 $l=2.15e-08 $layer=M1 $thickness=3.6e-08 $X=0.405
+ $Y=0.072 $X2=0.405 $Y2=0.0935
r2 15 14 3.78933 $w=1.3e-08 $l=1.63e-08 $layer=M1 $thickness=3.6e-08 $X=0.405
+ $Y=0.176 $X2=0.405 $Y2=0.1597
r3 13 14 5.77145 $w=1.3e-08 $l=2.47e-08 $layer=M1 $thickness=3.6e-08 $X=0.405
+ $Y=0.135 $X2=0.405 $Y2=0.1597
r4 12 13 4.4306 $w=1.3e-08 $l=1.9e-08 $layer=M1 $thickness=3.6e-08 $X=0.405
+ $Y=0.116 $X2=0.405 $Y2=0.135
r5 5 12 5.24677 $w=1.3e-08 $l=2.25e-08 $layer=M1 $thickness=3.6e-08 $X=0.405
+ $Y=0.0935 $X2=0.405 $Y2=0.116
r6 1 8 10.4265 $w=1.765e-08 $layer=LIG $thickness=5.2e-08 $X=0.405 $Y=0.135
+ $X2=0.405 $Y2=0.135
r7 1 13 19.3796 $a=3.24e-16 $layer=V0LIG $X=0.405 $Y=0.135 $X2=0.405 $Y2=0.135
r8 10 9 16.4967 $w=2.1e-08 $l=4.85e-08 $layer=Gate_1 $thickness=5.6e-08
+ $X=0.405 $Y=0.2025 $X2=0.405 $Y2=0.154
r9 8 9 6.6497 $w=2.04211e-08 $l=1.9e-08 $layer=Gate_1 $thickness=5.6e-08
+ $X=0.405 $Y=0.135 $X2=0.405 $Y2=0.154
r10 7 8 6.6497 $w=2.04211e-08 $l=1.9e-08 $layer=Gate_1 $thickness=5.6e-08
+ $X=0.405 $Y=0.116 $X2=0.405 $Y2=0.135
r11 6 7 16.4967 $w=2.1e-08 $l=4.85e-08 $layer=Gate_1 $thickness=5.6e-08
+ $X=0.405 $Y=0.0675 $X2=0.405 $Y2=0.116
r12 6 3 14.6259 $w=2.1e-08 $l=4.3e-08 $layer=Gate_1 $thickness=5.6e-08 $X=0.405
+ $Y=0.0675 $X2=0.405 $Y2=0.0245
.ends

.subckt PM_OA22x2_ASAP7_75t_R%Y vss 21 14 15 29 30 7 11 8
c1 1 vss 0.00901157f $X=0.108 $Y=0.0675
c2 2 vss 0.00901157f $X=0.108 $Y=0.2025
c3 7 vss 0.0043243f $X=0.0935 $Y=0.0675
c4 8 vss 0.00432665f $X=0.0935 $Y=0.2025
c5 9 vss 0.00626829f $X=0.095 $Y=0.036
c6 10 vss 0.0062031f $X=0.081 $Y=0.234
c7 11 vss 0.00778894f $X=0.081 $Y=0.054
r1 30 28 0.0308642 $w=8.1e-08 $l=2.5e-09 $layer=P_src_drn $thickness=1e-09
+ $X=0.1253 $Y=0.2025 $X2=0.1225 $Y2=0.2025
r2 2 28 0.179012 $w=8.1e-08 $l=1.45e-08 $layer=P_src_drn $thickness=1e-09
+ $X=0.108 $Y=0.2025 $X2=0.1225 $Y2=0.2025
r3 8 2 0.179012 $w=8.1e-08 $l=1.45e-08 $layer=P_src_drn $thickness=1e-09
+ $X=0.0935 $Y=0.2025 $X2=0.108 $Y2=0.2025
r4 29 8 0.0308642 $w=8.1e-08 $l=2.5e-09 $layer=P_src_drn $thickness=1e-09
+ $X=0.0906 $Y=0.2025 $X2=0.0935 $Y2=0.2025
r5 2 25 19.3796 $a=3.24e-16 $layer=V0LISD $X=0.108 $Y=0.2025 $X2=0.108 $Y2=0.234
r6 24 25 3.03147 $w=1.3e-08 $l=1.3e-08 $layer=M1 $thickness=3.6e-08 $X=0.095
+ $Y=0.234 $X2=0.108 $Y2=0.234
r7 10 23 7.91516 $w=1.55941e-08 $l=4.95e-08 $layer=M1 $thickness=3.6e-08
+ $X=0.081 $Y=0.234 $X2=0.081 $Y2=0.1845
r8 10 24 1.9532 $w=1.65714e-08 $l=1.4e-08 $layer=M1 $thickness=3.6e-08 $X=0.081
+ $Y=0.234 $X2=0.095 $Y2=0.234
r9 22 23 7.10752 $w=1.5e-08 $l=4.18e-08 $layer=M1 $thickness=3.6e-08 $X=0.081
+ $Y=0.1427 $X2=0.081 $Y2=0.1845
r10 21 22 0.29792 $w=1.5e-08 $l=1.7e-09 $layer=M1 $thickness=3.6e-08 $X=0.081
+ $Y=0.141 $X2=0.081 $Y2=0.1427
r11 21 20 1.31936 $w=1.5e-08 $l=7.8e-09 $layer=M1 $thickness=3.6e-08 $X=0.081
+ $Y=0.141 $X2=0.081 $Y2=0.1332
r12 19 20 6.5968 $w=1.5e-08 $l=3.87e-08 $layer=M1 $thickness=3.6e-08 $X=0.081
+ $Y=0.0945 $X2=0.081 $Y2=0.1332
r13 11 18 2.5526 $w=1.65789e-08 $l=1.8e-08 $layer=M1 $thickness=3.6e-08
+ $X=0.081 $Y=0.054 $X2=0.081 $Y2=0.036
r14 11 19 6.89472 $w=1.5e-08 $l=4.05e-08 $layer=M1 $thickness=3.6e-08 $X=0.081
+ $Y=0.054 $X2=0.081 $Y2=0.0945
r15 9 16 3.03147 $w=1.3e-08 $l=1.3e-08 $layer=M1 $thickness=3.6e-08 $X=0.095
+ $Y=0.036 $X2=0.108 $Y2=0.036
r16 9 18 1.9532 $w=1.65714e-08 $l=1.4e-08 $layer=M1 $thickness=3.6e-08 $X=0.095
+ $Y=0.036 $X2=0.081 $Y2=0.036
r17 1 16 19.3796 $a=3.24e-16 $layer=V0LISD $X=0.108 $Y=0.0675 $X2=0.108
+ $Y2=0.036
r18 15 13 0.0308642 $w=8.1e-08 $l=2.5e-09 $layer=N_src_drn $thickness=1e-09
+ $X=0.1253 $Y=0.0675 $X2=0.1225 $Y2=0.0675
r19 1 13 0.179012 $w=8.1e-08 $l=1.45e-08 $layer=N_src_drn $thickness=1e-09
+ $X=0.108 $Y=0.0675 $X2=0.1225 $Y2=0.0675
r20 7 1 0.179012 $w=8.1e-08 $l=1.45e-08 $layer=N_src_drn $thickness=1e-09
+ $X=0.0935 $Y=0.0675 $X2=0.108 $Y2=0.0675
r21 14 7 0.0308642 $w=8.1e-08 $l=2.5e-09 $layer=N_src_drn $thickness=1e-09
+ $X=0.0906 $Y=0.0675 $X2=0.0935 $Y2=0.0675
.ends

* End of included file OA22x2_ASAP7_75t_R.pex.sp.pex

*
.subckt OA22x2_ASAP7_75t_CUSTOM_4_25_0_7 VSS VDD A1 A2 B2 B1 Y
*
* VSS VSS
* VDD VDD
* A1 A1
* A2 A2
* B2 B2
* B1 B1
* Y Y
*
*

M0 N_M0_d N_M0_g VSS VSS nmos_rvt L=2e-08 W=8.1e-08 nfin=3 $X=0.071 $Y=0.027
M1 N_M1_d N_M1_g VSS VSS nmos_rvt L=2e-08 W=8.1e-08 nfin=3 $X=0.125 $Y=0.027
M2 N_M2_d N_M2_g noxref_9 VSS nmos_rvt L=2e-08 W=8.1e-08 nfin=3 $X=0.287
+ $Y=0.027
M3 noxref_9 N_M3_g N_M3_s VSS nmos_rvt L=2e-08 W=8.1e-08 nfin=3 $X=0.341
+ $Y=0.027
M4 VSS N_M4_g noxref_9 VSS nmos_rvt L=2e-08 W=8.1e-08 nfin=3 $X=0.395 $Y=0.027
M5 noxref_9 N_M5_g VSS VSS nmos_rvt L=2e-08 W=8.1e-08 nfin=3 $X=0.449 $Y=0.027
M6 N_M6_d N_M6_g VDD VDD pmos_rvt L=2e-08 W=8.1e-08 nfin=3 $X=0.071 $Y=0.162
M7 N_M7_d N_M7_g VDD VDD pmos_rvt L=2e-08 W=8.1e-08 nfin=3 $X=0.125 $Y=0.162
M8 noxref_10 N_M8_g VDD VDD pmos_rvt L=2e-08 W=8.1e-08 nfin=3 $X=0.287 $Y=0.162
M9 N_M9_d N_M9_g noxref_10 VDD pmos_rvt L=2e-08 W=8.1e-08 nfin=3 $X=0.341
+ $Y=0.162
M10 noxref_11 N_M10_g N_M10_s VDD pmos_rvt L=2e-08 W=8.1e-08 nfin=3 $X=0.395
+ $Y=0.162
M11 VDD N_M11_g noxref_11 VDD pmos_rvt L=2e-08 W=8.1e-08 nfin=3 $X=0.449
+ $Y=0.162

* .include "OA22x2_ASAP7_75t_R.pex.sp.pxi"

* Start of included file OA22x2_ASAP7_75t_R.pex.sp.pxi
x_PM_OA22x2_ASAP7_75t_R%B1 vss B1 N_M5_g N_M11_g N_B1_3 PM_OA22x2_ASAP7_75t_R%B1
cc_1 N_B1_3 N_B2_5 0.0050211f $X=0.459 $Y=0.0245
cc_2 N_B1_3 N_B2_3 0.00745133f $X=0.459 $Y=0.0245
x_PM_OA22x2_ASAP7_75t_R%A2 vss A2 N_M3_g N_M9_g N_A2_3 N_A2_4 N_A2_1
+ PM_OA22x2_ASAP7_75t_R%A2
cc_3 N_A2_3 N_3_19 0.000436736f $X=0.351 $Y=0.0245
cc_4 N_A2_3 N_3_4 0.00191042f $X=0.351 $Y=0.0245
cc_5 N_A2_3 N_3_3 0.000801783f $X=0.351 $Y=0.0245
cc_6 N_A2_4 N_3_20 0.00116023f $X=0.351 $Y=0.116
cc_7 N_A2_1 N_3_11 0.00145896f $X=0.351 $Y=0.135
cc_8 N_A2_4 N_3_4 0.00245283f $X=0.351 $Y=0.116
cc_9 N_A2_3 N_3_11 0.0148007f $X=0.351 $Y=0.0245
cc_10 N_A2_3 N_3_12 0.0548453f $X=0.351 $Y=0.0245
cc_11 N_A2_4 N_A1_4 0.00331707f $X=0.351 $Y=0.116
cc_12 N_A2_3 N_A1_3 0.00696179f $X=0.351 $Y=0.0245
x_PM_OA22x2_ASAP7_75t_R%3 vss N_M0_g N_M6_g N_M1_g N_M7_g N_M2_d N_M3_s N_M10_s
+ N_M9_d N_3_3 N_3_19 N_3_20 N_3_11 N_3_4 N_3_12 N_3_1 N_3_18 N_3_13 N_3_15
+ N_3_16 N_3_10 N_3_9 PM_OA22x2_ASAP7_75t_R%3
x_PM_OA22x2_ASAP7_75t_R%A1 vss A1 N_M2_g N_M8_g N_A1_3 N_A1_4
+ PM_OA22x2_ASAP7_75t_R%A1
cc_13 N_A1_3 N_3_3 0.00140651f $X=0.297 $Y=0.0245
cc_14 N_A1_4 N_3_19 0.00123267f $X=0.297 $Y=0.116
cc_15 N_A1_4 N_3_20 0.00147899f $X=0.297 $Y=0.116
cc_16 N_A1_4 N_3_3 0.00329139f $X=0.297 $Y=0.116
cc_17 N_A1_3 N_3_11 0.0365472f $X=0.297 $Y=0.0245
x_PM_OA22x2_ASAP7_75t_R%B2 vss B2 N_M4_g N_M10_g N_B2_3 N_B2_4 N_B2_5
+ PM_OA22x2_ASAP7_75t_R%B2
cc_18 N_B2_3 N_3_20 0.000593385f $X=0.405 $Y=0.0245
cc_19 N_B2_4 N_3_19 0.000799028f $X=0.405 $Y=0.072
cc_20 N_B2_5 N_3_4 0.00133033f $X=0.405 $Y=0.0935
cc_21 N_B2_3 N_3_4 0.00139814f $X=0.405 $Y=0.0245
cc_22 N_B2_3 N_3_12 0.0362569f $X=0.405 $Y=0.0245
cc_23 N_B2_3 N_A2_3 0.0031798f $X=0.405 $Y=0.0245
cc_24 N_B2_5 N_A2_4 0.00610394f $X=0.405 $Y=0.0935
x_PM_OA22x2_ASAP7_75t_R%Y vss Y N_M0_d N_M1_d N_M6_d N_M7_d N_Y_7 N_Y_11 N_Y_8
+ PM_OA22x2_ASAP7_75t_R%Y
cc_25 N_Y_7 N_3_1 0.000472383f $X=0.0935 $Y=0.0675
cc_26 N_Y_7 N_3_18 0.000510239f $X=0.0935 $Y=0.0675
cc_27 N_Y_7 N_3_13 0.000530672f $X=0.0935 $Y=0.0675
cc_28 N_Y_7 N_3_15 0.000542024f $X=0.0935 $Y=0.0675
cc_29 N_Y_7 N_3_16 0.000928212f $X=0.0935 $Y=0.0675
cc_30 N_Y_7 N_3_10 0.0214134f $X=0.0935 $Y=0.0675
cc_31 N_Y_11 N_3_1 0.00219827f $X=0.081 $Y=0.054
cc_32 N_Y_8 N_3_1 0.00549195f $X=0.0935 $Y=0.2025
cc_33 N_Y_8 N_3_10 0.0643373f $X=0.0935 $Y=0.2025
cc_34 N_Y_7 N_3_9 0.0490465f $X=0.0935 $Y=0.0675

* End of included file OA22x2_ASAP7_75t_R.pex.sp.pxi
.ends

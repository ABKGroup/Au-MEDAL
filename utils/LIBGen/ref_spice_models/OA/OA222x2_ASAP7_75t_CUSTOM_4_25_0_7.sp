.subckt PM_OA222x2_ASAP7_75t_R%B2 vss 13 5 9 3 4
c1 1 vss 0.00614861f $X=0.189 $Y=0.135
c2 3 vss 0.140146f $X=0.189 $Y=0.0245
c3 4 vss 0.00499697f $X=0.189 $Y=0.116
r1 13 12 0.408082 $w=1.3e-08 $l=1.8e-09 $layer=M1 $thickness=3.6e-08 $X=0.189
+ $Y=0.147 $X2=0.189 $Y2=0.1452
r2 11 12 2.39019 $w=1.3e-08 $l=1.02e-08 $layer=M1 $thickness=3.6e-08 $X=0.189
+ $Y=0.135 $X2=0.189 $Y2=0.1452
r3 4 11 4.4306 $w=1.3e-08 $l=1.9e-08 $layer=M1 $thickness=3.6e-08 $X=0.189
+ $Y=0.116 $X2=0.189 $Y2=0.135
r4 1 7 10.4265 $w=1.765e-08 $layer=LIG $thickness=5.2e-08 $X=0.189 $Y=0.135
+ $X2=0.189 $Y2=0.135
r5 1 11 19.3796 $a=3.24e-16 $layer=V0LIG $X=0.189 $Y=0.135 $X2=0.189 $Y2=0.135
r6 9 8 16.4967 $w=2.1e-08 $l=4.85e-08 $layer=Gate_1 $thickness=5.6e-08 $X=0.189
+ $Y=0.2025 $X2=0.189 $Y2=0.154
r7 7 8 6.6497 $w=2.04211e-08 $l=1.9e-08 $layer=Gate_1 $thickness=5.6e-08
+ $X=0.189 $Y=0.135 $X2=0.189 $Y2=0.154
r8 6 7 6.6497 $w=2.04211e-08 $l=1.9e-08 $layer=Gate_1 $thickness=5.6e-08
+ $X=0.189 $Y=0.116 $X2=0.189 $Y2=0.135
r9 5 6 16.4967 $w=2.1e-08 $l=4.85e-08 $layer=Gate_1 $thickness=5.6e-08 $X=0.189
+ $Y=0.0675 $X2=0.189 $Y2=0.116
r10 5 3 14.6259 $w=2.1e-08 $l=4.3e-08 $layer=Gate_1 $thickness=5.6e-08 $X=0.189
+ $Y=0.0675 $X2=0.189 $Y2=0.0245
.ends

.subckt PM_OA222x2_ASAP7_75t_R%B1 vss 15 5 11 4 3
c1 1 vss 0.00538526f $X=0.243 $Y=0.135
c2 3 vss 0.105699f $X=0.243 $Y=0.0245
c3 4 vss 0.00731845f $X=0.243 $Y=0.116
r1 15 14 0.408082 $w=1.3e-08 $l=1.8e-09 $layer=M1 $thickness=3.6e-08 $X=0.243
+ $Y=0.147 $X2=0.243 $Y2=0.1452
r2 13 14 2.39019 $w=1.3e-08 $l=1.02e-08 $layer=M1 $thickness=3.6e-08 $X=0.243
+ $Y=0.135 $X2=0.243 $Y2=0.1452
r3 4 13 4.4306 $w=1.3e-08 $l=1.9e-08 $layer=M1 $thickness=3.6e-08 $X=0.243
+ $Y=0.116 $X2=0.243 $Y2=0.135
r4 1 8 10.4265 $w=1.765e-08 $layer=LIG $thickness=5.2e-08 $X=0.243 $Y=0.135
+ $X2=0.243 $Y2=0.135
r5 1 13 19.3796 $a=3.24e-16 $layer=V0LIG $X=0.243 $Y=0.135 $X2=0.243 $Y2=0.135
r6 11 10 14.6259 $w=2.1e-08 $l=4.3e-08 $layer=Gate_1 $thickness=5.6e-08
+ $X=0.243 $Y=0.2025 $X2=0.243 $Y2=0.1595
r7 9 10 2.7211 $w=2.1e-08 $l=8e-09 $layer=Gate_1 $thickness=5.6e-08 $X=0.243
+ $Y=0.1515 $X2=0.243 $Y2=0.1595
r8 8 9 5.79936 $w=2.03333e-08 $l=1.65e-08 $layer=Gate_1 $thickness=5.6e-08
+ $X=0.243 $Y=0.135 $X2=0.243 $Y2=0.1515
r9 7 8 5.79936 $w=2.03333e-08 $l=1.65e-08 $layer=Gate_1 $thickness=5.6e-08
+ $X=0.243 $Y=0.1185 $X2=0.243 $Y2=0.135
r10 6 7 2.7211 $w=2.1e-08 $l=8e-09 $layer=Gate_1 $thickness=5.6e-08 $X=0.243
+ $Y=0.1105 $X2=0.243 $Y2=0.1185
r11 5 6 14.6259 $w=2.1e-08 $l=4.3e-08 $layer=Gate_1 $thickness=5.6e-08 $X=0.243
+ $Y=0.0675 $X2=0.243 $Y2=0.1105
r12 5 3 14.6259 $w=2.1e-08 $l=4.3e-08 $layer=Gate_1 $thickness=5.6e-08 $X=0.243
+ $Y=0.0675 $X2=0.243 $Y2=0.0245
.ends

.subckt PM_OA222x2_ASAP7_75t_R%C1 vss 17 5 11 4 3
c1 1 vss 0.00502954f $X=0.405 $Y=0.135
c2 3 vss 0.105414f $X=0.405 $Y=0.0245
c3 4 vss 0.0102974f $X=0.405 $Y=0.0935
r1 17 16 0.408082 $w=1.3e-08 $l=1.8e-09 $layer=M1 $thickness=3.6e-08 $X=0.405
+ $Y=0.147 $X2=0.405 $Y2=0.1452
r2 15 16 2.39019 $w=1.3e-08 $l=1.02e-08 $layer=M1 $thickness=3.6e-08 $X=0.405
+ $Y=0.135 $X2=0.405 $Y2=0.1452
r3 14 15 4.4306 $w=1.3e-08 $l=1.9e-08 $layer=M1 $thickness=3.6e-08 $X=0.405
+ $Y=0.116 $X2=0.405 $Y2=0.135
r4 4 14 5.24677 $w=1.3e-08 $l=2.25e-08 $layer=M1 $thickness=3.6e-08 $X=0.405
+ $Y=0.0935 $X2=0.405 $Y2=0.116
r5 1 8 10.4265 $w=1.765e-08 $layer=LIG $thickness=5.2e-08 $X=0.405 $Y=0.135
+ $X2=0.405 $Y2=0.135
r6 1 15 19.3796 $a=3.24e-16 $layer=V0LIG $X=0.405 $Y=0.135 $X2=0.405 $Y2=0.135
r7 11 10 14.6259 $w=2.1e-08 $l=4.3e-08 $layer=Gate_1 $thickness=5.6e-08
+ $X=0.405 $Y=0.2025 $X2=0.405 $Y2=0.1595
r8 9 10 2.7211 $w=2.1e-08 $l=8e-09 $layer=Gate_1 $thickness=5.6e-08 $X=0.405
+ $Y=0.1515 $X2=0.405 $Y2=0.1595
r9 8 9 5.79936 $w=2.03333e-08 $l=1.65e-08 $layer=Gate_1 $thickness=5.6e-08
+ $X=0.405 $Y=0.135 $X2=0.405 $Y2=0.1515
r10 7 8 5.79936 $w=2.03333e-08 $l=1.65e-08 $layer=Gate_1 $thickness=5.6e-08
+ $X=0.405 $Y=0.1185 $X2=0.405 $Y2=0.135
r11 6 7 2.7211 $w=2.1e-08 $l=8e-09 $layer=Gate_1 $thickness=5.6e-08 $X=0.405
+ $Y=0.1105 $X2=0.405 $Y2=0.1185
r12 5 6 14.6259 $w=2.1e-08 $l=4.3e-08 $layer=Gate_1 $thickness=5.6e-08 $X=0.405
+ $Y=0.0675 $X2=0.405 $Y2=0.1105
r13 5 3 14.6259 $w=2.1e-08 $l=4.3e-08 $layer=Gate_1 $thickness=5.6e-08 $X=0.405
+ $Y=0.0675 $X2=0.405 $Y2=0.0245
.ends

.subckt PM_OA222x2_ASAP7_75t_R%C2 vss 13 5 9 4 3
c1 1 vss 0.00583054f $X=0.459 $Y=0.135
c2 3 vss 0.1394f $X=0.459 $Y=0.0245
c3 4 vss 0.00754639f $X=0.459 $Y=0.098
r1 13 12 0.408082 $w=1.3e-08 $l=1.8e-09 $layer=M1 $thickness=3.6e-08 $X=0.459
+ $Y=0.147 $X2=0.459 $Y2=0.1452
r2 11 12 2.39019 $w=1.3e-08 $l=1.02e-08 $layer=M1 $thickness=3.6e-08 $X=0.459
+ $Y=0.135 $X2=0.459 $Y2=0.1452
r3 4 11 8.62802 $w=1.3e-08 $l=3.7e-08 $layer=M1 $thickness=3.6e-08 $X=0.459
+ $Y=0.098 $X2=0.459 $Y2=0.135
r4 1 7 10.4265 $w=1.765e-08 $layer=LIG $thickness=5.2e-08 $X=0.459 $Y=0.135
+ $X2=0.459 $Y2=0.135
r5 1 11 19.3796 $a=3.24e-16 $layer=V0LIG $X=0.459 $Y=0.135 $X2=0.459 $Y2=0.135
r6 9 8 16.4967 $w=2.1e-08 $l=4.85e-08 $layer=Gate_1 $thickness=5.6e-08 $X=0.459
+ $Y=0.2025 $X2=0.459 $Y2=0.154
r7 7 8 6.6497 $w=2.04211e-08 $l=1.9e-08 $layer=Gate_1 $thickness=5.6e-08
+ $X=0.459 $Y=0.135 $X2=0.459 $Y2=0.154
r8 6 7 6.6497 $w=2.04211e-08 $l=1.9e-08 $layer=Gate_1 $thickness=5.6e-08
+ $X=0.459 $Y=0.116 $X2=0.459 $Y2=0.135
r9 5 6 16.4967 $w=2.1e-08 $l=4.85e-08 $layer=Gate_1 $thickness=5.6e-08 $X=0.459
+ $Y=0.0675 $X2=0.459 $Y2=0.116
r10 5 3 14.6259 $w=2.1e-08 $l=4.3e-08 $layer=Gate_1 $thickness=5.6e-08 $X=0.459
+ $Y=0.0675 $X2=0.459 $Y2=0.0245
.ends

.subckt PM_OA222x2_ASAP7_75t_R%Y vss 26 18 19 34 35 7 2 13 8
c1 1 vss 0.00948784f $X=0.54 $Y=0.0675
c2 2 vss 0.00739152f $X=0.54 $Y=0.2025
c3 7 vss 0.00440232f $X=0.5255 $Y=0.0675
c4 8 vss 0.00440531f $X=0.5255 $Y=0.2025
c5 9 vss 0.00256647f $X=0.54 $Y=0.234
c6 10 vss 0.00292321f $X=0.621 $Y=0.036
c7 11 vss 0.00291902f $X=0.621 $Y=0.234
c8 12 vss 0.00916752f $X=0.5285 $Y=0.036
c9 13 vss 0.00128236f $X=0.54 $Y=0.1945
c10 14 vss 0.00595911f $X=0.583 $Y=0.234
c11 15 vss 0.00851024f $X=0.621 $Y=0.0575
r1 35 33 0.0308642 $w=8.1e-08 $l=2.5e-09 $layer=P_src_drn $thickness=1e-09
+ $X=0.5573 $Y=0.2025 $X2=0.5545 $Y2=0.2025
r2 2 33 0.179012 $w=8.1e-08 $l=1.45e-08 $layer=P_src_drn $thickness=1e-09
+ $X=0.54 $Y=0.2025 $X2=0.5545 $Y2=0.2025
r3 8 2 0.179012 $w=8.1e-08 $l=1.45e-08 $layer=P_src_drn $thickness=1e-09
+ $X=0.5255 $Y=0.2025 $X2=0.54 $Y2=0.2025
r4 34 8 0.0308642 $w=8.1e-08 $l=2.5e-09 $layer=P_src_drn $thickness=1e-09
+ $X=0.5226 $Y=0.2025 $X2=0.5255 $Y2=0.2025
r5 2 30 19.3796 $a=3.24e-16 $layer=V0LISD $X=0.54 $Y=0.2025 $X2=0.54 $Y2=0.209
r6 30 31 2.91487 $w=1.3e-08 $l=1.25e-08 $layer=M1 $thickness=3.6e-08 $X=0.54
+ $Y=0.209 $X2=0.54 $Y2=0.2215
r7 13 30 3.38125 $w=1.3e-08 $l=1.45e-08 $layer=M1 $thickness=3.6e-08 $X=0.54
+ $Y=0.1945 $X2=0.54 $Y2=0.209
r8 9 29 1.03257 $w=1.6913e-08 $l=1.15e-08 $layer=M1 $thickness=3.6e-08 $X=0.54
+ $Y=0.234 $X2=0.5515 $Y2=0.234
r9 9 31 1.26576 $w=2.0056e-08 $l=1.25e-08 $layer=M1 $thickness=3.6e-08 $X=0.54
+ $Y=0.234 $X2=0.54 $Y2=0.2215
r10 14 29 7.34548 $w=1.3e-08 $l=3.15e-08 $layer=M1 $thickness=3.6e-08 $X=0.583
+ $Y=0.234 $X2=0.5515 $Y2=0.234
r11 11 28 4.64701 $w=1.62667e-08 $l=2.7e-08 $layer=M1 $thickness=3.6e-08
+ $X=0.621 $Y=0.234 $X2=0.621 $Y2=0.207
r12 11 14 7.2121 $w=1.41842e-08 $l=3.8e-08 $layer=M1 $thickness=3.6e-08
+ $X=0.621 $Y=0.234 $X2=0.583 $Y2=0.234
r13 27 28 9.0361 $w=1.3e-08 $l=3.88e-08 $layer=M1 $thickness=3.6e-08 $X=0.621
+ $Y=0.1682 $X2=0.621 $Y2=0.207
r14 26 27 4.95528 $w=1.3e-08 $l=2.12e-08 $layer=M1 $thickness=3.6e-08 $X=0.624
+ $Y=0.147 $X2=0.621 $Y2=0.1682
r15 26 25 0.408082 $w=1.3e-08 $l=1.8e-09 $layer=M1 $thickness=3.6e-08 $X=0.624
+ $Y=0.147 $X2=0.621 $Y2=0.1452
r16 24 25 2.3902 $w=1.3e-08 $l=1.02e-08 $layer=M1 $thickness=3.6e-08 $X=0.621
+ $Y=0.135 $X2=0.621 $Y2=0.1452
r17 23 24 8.62802 $w=1.3e-08 $l=3.7e-08 $layer=M1 $thickness=3.6e-08 $X=0.621
+ $Y=0.098 $X2=0.621 $Y2=0.135
r18 15 23 9.44419 $w=1.3e-08 $l=4.05e-08 $layer=M1 $thickness=3.6e-08 $X=0.621
+ $Y=0.0575 $X2=0.621 $Y2=0.098
r19 10 22 7.2121 $w=1.41842e-08 $l=3.8e-08 $layer=M1 $thickness=3.6e-08
+ $X=0.621 $Y=0.036 $X2=0.583 $Y2=0.036
r20 10 15 3.36447 $w=1.71023e-08 $l=2.15e-08 $layer=M1 $thickness=3.6e-08
+ $X=0.621 $Y=0.036 $X2=0.621 $Y2=0.0575
r21 21 22 7.34548 $w=1.3e-08 $l=3.15e-08 $layer=M1 $thickness=3.6e-08 $X=0.5515
+ $Y=0.036 $X2=0.583 $Y2=0.036
r22 20 21 2.68168 $w=1.3e-08 $l=1.15e-08 $layer=M1 $thickness=3.6e-08 $X=0.54
+ $Y=0.036 $X2=0.5515 $Y2=0.036
r23 12 20 2.68168 $w=1.3e-08 $l=1.15e-08 $layer=M1 $thickness=3.6e-08 $X=0.5285
+ $Y=0.036 $X2=0.54 $Y2=0.036
r24 1 20 19.3796 $a=3.24e-16 $layer=V0LISD $X=0.54 $Y=0.0675 $X2=0.54 $Y2=0.036
r25 19 17 0.0308642 $w=8.1e-08 $l=2.5e-09 $layer=N_src_drn $thickness=1e-09
+ $X=0.5573 $Y=0.0675 $X2=0.5545 $Y2=0.0675
r26 1 17 0.179012 $w=8.1e-08 $l=1.45e-08 $layer=N_src_drn $thickness=1e-09
+ $X=0.54 $Y=0.0675 $X2=0.5545 $Y2=0.0675
r27 7 1 0.179012 $w=8.1e-08 $l=1.45e-08 $layer=N_src_drn $thickness=1e-09
+ $X=0.5255 $Y=0.0675 $X2=0.54 $Y2=0.0675
r28 18 7 0.0308642 $w=8.1e-08 $l=2.5e-09 $layer=N_src_drn $thickness=1e-09
+ $X=0.5226 $Y=0.0675 $X2=0.5255 $Y2=0.0675
.ends

.subckt PM_OA222x2_ASAP7_75t_R%9 vss 30 34 45 49 75 77 81 89 90 18 4 26 27 3 17
+ 25 5 19 6 20 1 28 15 23 29 24 16
c1 1 vss 0.00728911f $X=0.513 $Y=0.135
c2 3 vss 0.00696655f $X=0.054 $Y=0.2025
c3 4 vss 0.0100305f $X=0.108 $Y=0.0675
c4 5 vss 0.00687538f $X=0.27 $Y=0.2025
c5 6 vss 0.00687816f $X=0.378 $Y=0.2025
c6 15 vss 0.0808679f $X=0.513 $Y=0.0245
c7 16 vss 0.0836372f $X=0.567 $Y=0.135
c8 17 vss 0.00640593f $X=0.0935 $Y=0.0675
c9 18 vss 0.0397329f $X=0.056 $Y=0.2025
c10 19 vss 0.0398783f $X=0.2555 $Y=0.2025
c11 20 vss 0.0398782f $X=0.38 $Y=0.2025
c12 21 vss 0.0027446f $X=0.018 $Y=0.072
c13 22 vss 0.00315698f $X=0.018 $Y=0.234
c14 23 vss 0.000442538f $X=0.495 $Y=0.135
c15 24 vss 0.00283085f $X=0.495 $Y=0.234
c16 25 vss 0.0078288f $X=0.018 $Y=0.2125
c17 26 vss 0.00979591f $X=0.0335 $Y=0.072
c18 27 vss 0.0425148f $X=0.477 $Y=0.234
c19 28 vss 0.00262572f $X=0.495 $Y=0.1665
c20 29 vss 0.00161419f $X=0.54 $Y=0.135
r1 90 88 0.0308642 $w=8.1e-08 $l=2.5e-09 $layer=N_src_drn $thickness=1e-09
+ $X=0.1253 $Y=0.0675 $X2=0.1225 $Y2=0.0675
r2 4 88 0.179012 $w=8.1e-08 $l=1.45e-08 $layer=N_src_drn $thickness=1e-09
+ $X=0.108 $Y=0.0675 $X2=0.1225 $Y2=0.0675
r3 17 4 0.179012 $w=8.1e-08 $l=1.45e-08 $layer=N_src_drn $thickness=1e-09
+ $X=0.0935 $Y=0.0675 $X2=0.108 $Y2=0.0675
r4 89 17 0.0308642 $w=8.1e-08 $l=2.5e-09 $layer=N_src_drn $thickness=1e-09
+ $X=0.0906 $Y=0.0675 $X2=0.0935 $Y2=0.0675
r5 4 85 19.3796 $a=3.24e-16 $layer=V0LISD $X=0.108 $Y=0.0675 $X2=0.108 $Y2=0.072
r6 84 85 3.14806 $w=1.3e-08 $l=1.35e-08 $layer=M1 $thickness=3.6e-08 $X=0.0945
+ $Y=0.072 $X2=0.108 $Y2=0.072
r7 83 84 3.14806 $w=1.3e-08 $l=1.35e-08 $layer=M1 $thickness=3.6e-08 $X=0.081
+ $Y=0.072 $X2=0.0945 $Y2=0.072
r8 82 83 5.82974 $w=1.3e-08 $l=2.5e-08 $layer=M1 $thickness=3.6e-08 $X=0.056
+ $Y=0.072 $X2=0.081 $Y2=0.072
r9 26 82 5.24677 $w=1.3e-08 $l=2.25e-08 $layer=M1 $thickness=3.6e-08 $X=0.0335
+ $Y=0.072 $X2=0.056 $Y2=0.072
r10 21 79 3.36447 $w=1.71023e-08 $l=2.15e-08 $layer=M1 $thickness=3.6e-08
+ $X=0.018 $Y=0.072 $X2=0.018 $Y2=0.0935
r11 21 26 1.96533 $w=1.59032e-08 $l=1.55e-08 $layer=M1 $thickness=3.6e-08
+ $X=0.018 $Y=0.072 $X2=0.0335 $Y2=0.072
r12 81 80 0.0308642 $w=8.1e-08 $l=2.5e-09 $layer=P_src_drn $thickness=1e-09
+ $X=0.0713 $Y=0.2025 $X2=0.0685 $Y2=0.2025
r13 18 80 0.154321 $w=8.1e-08 $l=1.25e-08 $layer=P_src_drn $thickness=1e-09
+ $X=0.056 $Y=0.2025 $X2=0.0685 $Y2=0.2025
r14 78 79 13.8748 $w=1.3e-08 $l=5.95e-08 $layer=M1 $thickness=3.6e-08 $X=0.018
+ $Y=0.153 $X2=0.018 $Y2=0.0935
r15 25 78 13.8748 $w=1.3e-08 $l=5.95e-08 $layer=M1 $thickness=3.6e-08 $X=0.018
+ $Y=0.2125 $X2=0.018 $Y2=0.153
r16 19 5 0.154321 $w=8.1e-08 $l=1.25e-08 $layer=P_src_drn $thickness=1e-09
+ $X=0.2555 $Y=0.2025 $X2=0.27 $Y2=0.2025
r17 77 19 0.0308642 $w=8.1e-08 $l=2.5e-09 $layer=P_src_drn $thickness=1e-09
+ $X=0.2526 $Y=0.2025 $X2=0.2555 $Y2=0.2025
r18 75 74 0.0308642 $w=8.1e-08 $l=2.5e-09 $layer=P_src_drn $thickness=1e-09
+ $X=0.3953 $Y=0.2025 $X2=0.3925 $Y2=0.2025
r19 20 74 0.154321 $w=8.1e-08 $l=1.25e-08 $layer=P_src_drn $thickness=1e-09
+ $X=0.38 $Y=0.2025 $X2=0.3925 $Y2=0.2025
r20 3 72 19.3796 $a=3.24e-16 $layer=V0LISD $X=0.054 $Y=0.2025 $X2=0.054
+ $Y2=0.234
r21 22 71 2.5483 $w=1.55e-08 $l=1.8e-08 $layer=M1 $thickness=3.6e-08 $X=0.018
+ $Y=0.234 $X2=0.036 $Y2=0.234
r22 22 25 3.36447 $w=1.71023e-08 $l=2.15e-08 $layer=M1 $thickness=3.6e-08
+ $X=0.018 $Y=0.234 $X2=0.018 $Y2=0.2125
r23 5 60 19.3796 $a=3.24e-16 $layer=V0LISD $X=0.27 $Y=0.2025 $X2=0.27 $Y2=0.234
r24 6 57 19.3796 $a=3.24e-16 $layer=V0LISD $X=0.378 $Y=0.2025 $X2=0.378
+ $Y2=0.234
r25 72 73 3.14806 $w=1.3e-08 $l=1.35e-08 $layer=M1 $thickness=3.6e-08 $X=0.054
+ $Y=0.234 $X2=0.0675 $Y2=0.234
r26 71 72 4.19742 $w=1.3e-08 $l=1.8e-08 $layer=M1 $thickness=3.6e-08 $X=0.036
+ $Y=0.234 $X2=0.054 $Y2=0.234
r27 70 73 3.14806 $w=1.3e-08 $l=1.35e-08 $layer=M1 $thickness=3.6e-08 $X=0.081
+ $Y=0.234 $X2=0.0675 $Y2=0.234
r28 69 70 5.82974 $w=1.3e-08 $l=2.5e-08 $layer=M1 $thickness=3.6e-08 $X=0.106
+ $Y=0.234 $X2=0.081 $Y2=0.234
r29 68 69 4.19742 $w=1.3e-08 $l=1.8e-08 $layer=M1 $thickness=3.6e-08 $X=0.124
+ $Y=0.234 $X2=0.106 $Y2=0.234
r30 67 68 2.56509 $w=1.3e-08 $l=1.1e-08 $layer=M1 $thickness=3.6e-08 $X=0.135
+ $Y=0.234 $X2=0.124 $Y2=0.234
r31 66 67 6.29612 $w=1.3e-08 $l=2.7e-08 $layer=M1 $thickness=3.6e-08 $X=0.162
+ $Y=0.234 $X2=0.135 $Y2=0.234
r32 65 66 6.29612 $w=1.3e-08 $l=2.7e-08 $layer=M1 $thickness=3.6e-08 $X=0.189
+ $Y=0.234 $X2=0.162 $Y2=0.234
r33 64 65 2.56509 $w=1.3e-08 $l=1.1e-08 $layer=M1 $thickness=3.6e-08 $X=0.2
+ $Y=0.234 $X2=0.189 $Y2=0.234
r34 63 64 4.19742 $w=1.3e-08 $l=1.8e-08 $layer=M1 $thickness=3.6e-08 $X=0.218
+ $Y=0.234 $X2=0.2 $Y2=0.234
r35 62 63 5.82974 $w=1.3e-08 $l=2.5e-08 $layer=M1 $thickness=3.6e-08 $X=0.243
+ $Y=0.234 $X2=0.218 $Y2=0.234
r36 60 61 11.5429 $w=1.3e-08 $l=4.95e-08 $layer=M1 $thickness=3.6e-08 $X=0.27
+ $Y=0.234 $X2=0.3195 $Y2=0.234
r37 59 60 3.14806 $w=1.3e-08 $l=1.35e-08 $layer=M1 $thickness=3.6e-08 $X=0.2565
+ $Y=0.234 $X2=0.27 $Y2=0.234
r38 59 62 3.14806 $w=1.3e-08 $l=1.35e-08 $layer=M1 $thickness=3.6e-08 $X=0.2565
+ $Y=0.234 $X2=0.243 $Y2=0.234
r39 57 58 3.14806 $w=1.3e-08 $l=1.35e-08 $layer=M1 $thickness=3.6e-08 $X=0.378
+ $Y=0.234 $X2=0.3915 $Y2=0.234
r40 56 57 3.14806 $w=1.3e-08 $l=1.35e-08 $layer=M1 $thickness=3.6e-08 $X=0.3645
+ $Y=0.234 $X2=0.378 $Y2=0.234
r41 56 61 10.4935 $w=1.3e-08 $l=4.5e-08 $layer=M1 $thickness=3.6e-08 $X=0.3645
+ $Y=0.234 $X2=0.3195 $Y2=0.234
r42 55 58 3.14806 $w=1.3e-08 $l=1.35e-08 $layer=M1 $thickness=3.6e-08 $X=0.405
+ $Y=0.234 $X2=0.3915 $Y2=0.234
r43 54 55 6.29612 $w=1.3e-08 $l=2.7e-08 $layer=M1 $thickness=3.6e-08 $X=0.432
+ $Y=0.234 $X2=0.405 $Y2=0.234
r44 53 54 6.29612 $w=1.3e-08 $l=2.7e-08 $layer=M1 $thickness=3.6e-08 $X=0.459
+ $Y=0.234 $X2=0.432 $Y2=0.234
r45 27 53 4.19742 $w=1.3e-08 $l=1.8e-08 $layer=M1 $thickness=3.6e-08 $X=0.477
+ $Y=0.234 $X2=0.459 $Y2=0.234
r46 24 52 3.36447 $w=1.71023e-08 $l=2.15e-08 $layer=M1 $thickness=3.6e-08
+ $X=0.495 $Y=0.234 $X2=0.495 $Y2=0.2125
r47 24 27 2.5483 $w=1.55e-08 $l=1.8e-08 $layer=M1 $thickness=3.6e-08 $X=0.495
+ $Y=0.234 $X2=0.477 $Y2=0.234
r48 51 52 4.19742 $w=1.3e-08 $l=1.8e-08 $layer=M1 $thickness=3.6e-08 $X=0.495
+ $Y=0.1945 $X2=0.495 $Y2=0.2125
r49 28 51 6.52931 $w=1.3e-08 $l=2.8e-08 $layer=M1 $thickness=3.6e-08 $X=0.495
+ $Y=0.1665 $X2=0.495 $Y2=0.1945
r50 23 41 3.01468 $w=1.525e-08 $l=2e-08 $layer=M1 $thickness=3.6e-08 $X=0.495
+ $Y=0.135 $X2=0.515 $Y2=0.135
r51 23 28 5.69636 $w=1.58e-08 $l=3.15e-08 $layer=M1 $thickness=3.6e-08 $X=0.495
+ $Y=0.135 $X2=0.495 $Y2=0.1665
r52 49 48 14.6259 $w=2.1e-08 $l=4.3e-08 $layer=Gate_1 $thickness=5.6e-08
+ $X=0.567 $Y=0.2025 $X2=0.567 $Y2=0.1595
r53 47 48 2.7211 $w=2.1e-08 $l=8e-09 $layer=Gate_1 $thickness=5.6e-08 $X=0.567
+ $Y=0.1515 $X2=0.567 $Y2=0.1595
r54 45 46 14.6259 $w=2.1e-08 $l=4.3e-08 $layer=Gate_1 $thickness=5.6e-08
+ $X=0.567 $Y=0.0675 $X2=0.567 $Y2=0.1105
r55 43 46 2.7211 $w=2.1e-08 $l=8e-09 $layer=Gate_1 $thickness=5.6e-08 $X=0.567
+ $Y=0.1185 $X2=0.567 $Y2=0.1105
r56 16 38 6.54019 $w=2.09524e-08 $layer=Gate_1 $thickness=5.21905e-08 $X=0.567
+ $Y=0.135 $X2=0.567 $Y2=0.135
r57 16 43 5.79936 $w=2.03333e-08 $l=1.65e-08 $layer=Gate_1 $thickness=5.6e-08
+ $X=0.567 $Y=0.135 $X2=0.567 $Y2=0.1185
r58 16 47 5.79936 $w=2.03333e-08 $l=1.65e-08 $layer=Gate_1 $thickness=5.6e-08
+ $X=0.567 $Y=0.135 $X2=0.567 $Y2=0.1515
r59 40 41 3.14806 $w=1.3e-08 $l=1.35e-08 $layer=M1 $thickness=3.6e-08 $X=0.5285
+ $Y=0.135 $X2=0.515 $Y2=0.135
r60 29 37 19.3796 $a=3.24e-16 $layer=V0LIG $X=0.54 $Y=0.135 $X2=0.54 $Y2=0.135
r61 29 40 2.68168 $w=1.3e-08 $l=1.15e-08 $layer=M1 $thickness=3.6e-08 $X=0.54
+ $Y=0.135 $X2=0.5285 $Y2=0.135
r62 37 38 12.6539 $w=1.77815e-08 $l=2.7e-08 $layer=LIG $thickness=4.8e-08
+ $X=0.54 $Y=0.135 $X2=0.567 $Y2=0.135
r63 1 32 6.54019 $w=2.09524e-08 $layer=Gate_1 $thickness=5.21905e-08 $X=0.513
+ $Y=0.135 $X2=0.513 $Y2=0.135
r64 1 37 12.6539 $w=1.77815e-08 $l=2.7e-08 $layer=LIG $thickness=4.8e-08
+ $X=0.513 $Y=0.135 $X2=0.54 $Y2=0.135
r65 34 33 16.4967 $w=2.1e-08 $l=4.85e-08 $layer=Gate_1 $thickness=5.6e-08
+ $X=0.513 $Y=0.2025 $X2=0.513 $Y2=0.154
r66 32 33 6.6497 $w=2.04211e-08 $l=1.9e-08 $layer=Gate_1 $thickness=5.6e-08
+ $X=0.513 $Y=0.135 $X2=0.513 $Y2=0.154
r67 31 32 6.6497 $w=2.04211e-08 $l=1.9e-08 $layer=Gate_1 $thickness=5.6e-08
+ $X=0.513 $Y=0.116 $X2=0.513 $Y2=0.135
r68 30 31 16.4967 $w=2.1e-08 $l=4.85e-08 $layer=Gate_1 $thickness=5.6e-08
+ $X=0.513 $Y=0.0675 $X2=0.513 $Y2=0.116
r69 30 15 14.6259 $w=2.1e-08 $l=4.3e-08 $layer=Gate_1 $thickness=5.6e-08
+ $X=0.513 $Y=0.0675 $X2=0.513 $Y2=0.0245
r70 3 18 1e-05 $l=2e-09 $X=0.054 $Y=0.2025 $X2=0.056 $Y2=0.2025
r71 6 20 1e-05 $l=2e-09 $X=0.378 $Y=0.2025 $X2=0.38 $Y2=0.2025
.ends

.subckt PM_OA222x2_ASAP7_75t_R%A1 vss 15 5 11 4 3 1
c1 1 vss 0.00293599f $X=0.081 $Y=0.135
c2 3 vss 0.0707351f $X=0.081 $Y=0.0245
c3 4 vss 0.00513188f $X=0.081 $Y=0.116
r1 15 14 0.408082 $w=1.3e-08 $l=1.8e-09 $layer=M1 $thickness=3.6e-08 $X=0.081
+ $Y=0.147 $X2=0.081 $Y2=0.1452
r2 13 14 2.39019 $w=1.3e-08 $l=1.02e-08 $layer=M1 $thickness=3.6e-08 $X=0.081
+ $Y=0.135 $X2=0.081 $Y2=0.1452
r3 4 13 4.4306 $w=1.3e-08 $l=1.9e-08 $layer=M1 $thickness=3.6e-08 $X=0.081
+ $Y=0.116 $X2=0.081 $Y2=0.135
r4 1 8 10.4265 $w=1.765e-08 $layer=LIG $thickness=5.2e-08 $X=0.081 $Y=0.135
+ $X2=0.081 $Y2=0.135
r5 1 13 19.3796 $a=3.24e-16 $layer=V0LIG $X=0.081 $Y=0.135 $X2=0.081 $Y2=0.135
r6 11 10 14.6259 $w=2.1e-08 $l=4.3e-08 $layer=Gate_1 $thickness=5.6e-08
+ $X=0.081 $Y=0.2025 $X2=0.081 $Y2=0.1595
r7 9 10 2.7211 $w=2.1e-08 $l=8e-09 $layer=Gate_1 $thickness=5.6e-08 $X=0.081
+ $Y=0.1515 $X2=0.081 $Y2=0.1595
r8 8 9 5.79936 $w=2.03333e-08 $l=1.65e-08 $layer=Gate_1 $thickness=5.6e-08
+ $X=0.081 $Y=0.135 $X2=0.081 $Y2=0.1515
r9 7 8 5.79936 $w=2.03333e-08 $l=1.65e-08 $layer=Gate_1 $thickness=5.6e-08
+ $X=0.081 $Y=0.1185 $X2=0.081 $Y2=0.135
r10 6 7 2.7211 $w=2.1e-08 $l=8e-09 $layer=Gate_1 $thickness=5.6e-08 $X=0.081
+ $Y=0.1105 $X2=0.081 $Y2=0.1185
r11 5 6 14.6259 $w=2.1e-08 $l=4.3e-08 $layer=Gate_1 $thickness=5.6e-08 $X=0.081
+ $Y=0.0675 $X2=0.081 $Y2=0.1105
r12 5 3 14.6259 $w=2.1e-08 $l=4.3e-08 $layer=Gate_1 $thickness=5.6e-08 $X=0.081
+ $Y=0.0675 $X2=0.081 $Y2=0.0245
.ends

.subckt PM_OA222x2_ASAP7_75t_R%A2 vss 13 5 9 4 3
c1 1 vss 0.00667619f $X=0.135 $Y=0.135
c2 3 vss 0.102306f $X=0.135 $Y=0.0245
c3 4 vss 0.0043757f $X=0.135 $Y=0.116
r1 13 12 0.408082 $w=1.3e-08 $l=1.8e-09 $layer=M1 $thickness=3.6e-08 $X=0.135
+ $Y=0.147 $X2=0.135 $Y2=0.1452
r2 11 12 2.39019 $w=1.3e-08 $l=1.02e-08 $layer=M1 $thickness=3.6e-08 $X=0.135
+ $Y=0.135 $X2=0.135 $Y2=0.1452
r3 4 11 4.4306 $w=1.3e-08 $l=1.9e-08 $layer=M1 $thickness=3.6e-08 $X=0.135
+ $Y=0.116 $X2=0.135 $Y2=0.135
r4 1 7 10.4265 $w=1.765e-08 $layer=LIG $thickness=5.2e-08 $X=0.135 $Y=0.135
+ $X2=0.135 $Y2=0.135
r5 1 11 19.3796 $a=3.24e-16 $layer=V0LIG $X=0.135 $Y=0.135 $X2=0.135 $Y2=0.135
r6 9 8 16.4967 $w=2.1e-08 $l=4.85e-08 $layer=Gate_1 $thickness=5.6e-08 $X=0.135
+ $Y=0.2025 $X2=0.135 $Y2=0.154
r7 7 8 6.6497 $w=2.04211e-08 $l=1.9e-08 $layer=Gate_1 $thickness=5.6e-08
+ $X=0.135 $Y=0.135 $X2=0.135 $Y2=0.154
r8 6 7 6.6497 $w=2.04211e-08 $l=1.9e-08 $layer=Gate_1 $thickness=5.6e-08
+ $X=0.135 $Y=0.116 $X2=0.135 $Y2=0.135
r9 5 6 16.4967 $w=2.1e-08 $l=4.85e-08 $layer=Gate_1 $thickness=5.6e-08 $X=0.135
+ $Y=0.0675 $X2=0.135 $Y2=0.116
r10 5 3 14.6259 $w=2.1e-08 $l=4.3e-08 $layer=Gate_1 $thickness=5.6e-08 $X=0.135
+ $Y=0.0675 $X2=0.135 $Y2=0.0245
.ends

* End of included file OA222x2_ASAP7_75t_R.pex.sp.pex

*
.subckt OA222x2_ASAP7_75t_CUSTOM_4_25_0_7 VSS VDD A1 A2 B2 B1 C1 C2 Y
*
* VSS VSS
* VDD VDD
* A1 A1
* A2 A2
* B2 B2
* B1 B1
* C1 C1
* C2 C2
* Y Y
*
*

M0 N_M0_d N_M0_g noxref_10 VSS nmos_rvt L=2e-08 W=8.1e-08 nfin=3 $X=0.071
+ $Y=0.027
M1 noxref_10 N_M1_g N_M1_s VSS nmos_rvt L=2e-08 W=8.1e-08 nfin=3 $X=0.125
+ $Y=0.027
M2 noxref_11 N_M2_g noxref_10 VSS nmos_rvt L=2e-08 W=8.1e-08 nfin=3 $X=0.179
+ $Y=0.027
M3 noxref_10 N_M3_g noxref_11 VSS nmos_rvt L=2e-08 W=8.1e-08 nfin=3 $X=0.233
+ $Y=0.027
M4 noxref_11 N_M4_g VSS VSS nmos_rvt L=2e-08 W=8.1e-08 nfin=3 $X=0.395 $Y=0.027
M5 VSS N_M5_g noxref_11 VSS nmos_rvt L=2e-08 W=8.1e-08 nfin=3 $X=0.449 $Y=0.027
M6 N_M6_d N_M6_g VSS VSS nmos_rvt L=2e-08 W=8.1e-08 nfin=3 $X=0.503 $Y=0.027
M7 N_M7_d N_M7_g VSS VSS nmos_rvt L=2e-08 W=8.1e-08 nfin=3 $X=0.557 $Y=0.027
M8 noxref_13 N_M8_g N_M8_s VDD pmos_rvt L=2e-08 W=8.1e-08 nfin=3 $X=0.071
+ $Y=0.162
M9 VDD N_M9_g noxref_13 VDD pmos_rvt L=2e-08 W=8.1e-08 nfin=3 $X=0.125 $Y=0.162
M10 noxref_14 N_M10_g VDD VDD pmos_rvt L=2e-08 W=8.1e-08 nfin=3 $X=0.179
+ $Y=0.162
M11 N_M11_d N_M11_g noxref_14 VDD pmos_rvt L=2e-08 W=8.1e-08 nfin=3 $X=0.233
+ $Y=0.162
M12 noxref_15 N_M12_g N_M12_s VDD pmos_rvt L=2e-08 W=8.1e-08 nfin=3 $X=0.395
+ $Y=0.162
M13 VDD N_M13_g noxref_15 VDD pmos_rvt L=2e-08 W=8.1e-08 nfin=3 $X=0.449
+ $Y=0.162
M14 N_M14_d N_M14_g VDD VDD pmos_rvt L=2e-08 W=8.1e-08 nfin=3 $X=0.503 $Y=0.162
M15 N_M15_d N_M15_g VDD VDD pmos_rvt L=2e-08 W=8.1e-08 nfin=3 $X=0.557 $Y=0.162

* .include "OA222x2_ASAP7_75t_R.pex.sp.pxi"

* Start of included file OA222x2_ASAP7_75t_R.pex.sp.pxi
x_PM_OA222x2_ASAP7_75t_R%B2 vss B2 N_M2_g N_M10_g N_B2_3 N_B2_4
+ PM_OA222x2_ASAP7_75t_R%B2
cc_1 N_B2_3 N_A2_3 0.00317797f $X=0.189 $Y=0.0245
cc_2 N_B2_4 N_A2_4 0.00508495f $X=0.189 $Y=0.116
x_PM_OA222x2_ASAP7_75t_R%B1 vss B1 N_M3_g N_M11_g N_B1_4 N_B1_3
+ PM_OA222x2_ASAP7_75t_R%B1
cc_3 N_B1_4 N_B2_4 0.00332764f $X=0.243 $Y=0.116
cc_4 N_B1_3 N_B2_3 0.00696703f $X=0.243 $Y=0.0245
x_PM_OA222x2_ASAP7_75t_R%C1 vss C1 N_M4_g N_M12_g N_C1_4 N_C1_3
+ PM_OA222x2_ASAP7_75t_R%C1
x_PM_OA222x2_ASAP7_75t_R%C2 vss C2 N_M5_g N_M13_g N_C2_4 N_C2_3
+ PM_OA222x2_ASAP7_75t_R%C2
cc_5 N_C2_4 N_C1_4 0.00461451f $X=0.459 $Y=0.098
cc_6 N_C2_3 N_C1_3 0.00702754f $X=0.459 $Y=0.0245
x_PM_OA222x2_ASAP7_75t_R%Y vss Y N_M6_d N_M7_d N_M14_d N_M15_d N_Y_7 N_Y_2
+ N_Y_13 N_Y_8 PM_OA222x2_ASAP7_75t_R%Y
cc_7 N_Y_7 N_9_23 0.000220271f $X=0.5255 $Y=0.0675
cc_8 N_Y_7 N_9_29 0.00277216f $X=0.5255 $Y=0.0675
cc_9 N_Y_7 N_9_28 0.000603705f $X=0.5255 $Y=0.0675
cc_10 N_Y_7 N_9_15 0.0193333f $X=0.5255 $Y=0.0675
cc_11 N_Y_7 N_9_1 0.000849072f $X=0.5255 $Y=0.0675
cc_12 N_Y_7 N_9_24 0.00109795f $X=0.5255 $Y=0.0675
cc_13 N_Y_2 N_9_15 0.00195547f $X=0.54 $Y=0.2025
cc_14 N_Y_13 N_9_28 0.00281428f $X=0.54 $Y=0.1945
cc_15 N_Y_8 N_9_1 0.0047134f $X=0.5255 $Y=0.2025
cc_16 N_Y_8 N_9_16 0.0103423f $X=0.5255 $Y=0.2025
cc_17 N_Y_8 N_9_15 0.0552065f $X=0.5255 $Y=0.2025
cc_18 N_Y_7 N_9_16 0.0503873f $X=0.5255 $Y=0.0675
x_PM_OA222x2_ASAP7_75t_R%9 vss N_M6_g N_M14_g N_M7_g N_M15_g N_M12_s N_M11_d
+ N_M8_s N_M0_d N_M1_s N_9_18 N_9_4 N_9_26 N_9_27 N_9_3 N_9_17 N_9_25 N_9_5
+ N_9_19 N_9_6 N_9_20 N_9_1 N_9_28 N_9_15 N_9_23 N_9_29 N_9_24 N_9_16
+ PM_OA222x2_ASAP7_75t_R%9
cc_19 N_9_18 N_A1_3 0.0155501f $X=0.056 $Y=0.2025
cc_20 N_9_4 N_A1_3 0.00165546f $X=0.108 $Y=0.0675
cc_21 N_9_26 N_A1_3 0.00105828f $X=0.0335 $Y=0.072
cc_22 N_9_27 N_A1_4 0.00119196f $X=0.477 $Y=0.234
cc_23 N_9_3 N_A1_3 0.00159002f $X=0.054 $Y=0.2025
cc_24 N_9_17 N_A1_1 0.00173064f $X=0.0935 $Y=0.0675
cc_25 N_9_25 N_A1_4 0.00587419f $X=0.018 $Y=0.2125
cc_26 N_9_17 N_A1_3 0.0543571f $X=0.0935 $Y=0.0675
cc_27 N_9_4 N_A2_3 0.00150398f $X=0.108 $Y=0.0675
cc_28 N_9_26 N_A2_3 0.000530558f $X=0.0335 $Y=0.072
cc_29 N_9_27 N_A2_4 0.00130106f $X=0.477 $Y=0.234
cc_30 N_9_4 N_A2_4 0.00218236f $X=0.108 $Y=0.0675
cc_31 N_9_17 N_A2_3 0.0357175f $X=0.0935 $Y=0.0675
cc_32 N_9_27 N_B2_4 0.00341295f $X=0.477 $Y=0.234
cc_33 N_9_5 N_B1_3 0.00223914f $X=0.27 $Y=0.2025
cc_34 N_9_27 N_B1_3 0.00148471f $X=0.477 $Y=0.234
cc_35 N_9_5 N_B1_4 0.0023141f $X=0.27 $Y=0.2025
cc_36 N_9_19 N_B1_3 0.0362287f $X=0.2555 $Y=0.2025
cc_37 N_9_6 N_C1_3 0.00217316f $X=0.378 $Y=0.2025
cc_38 N_9_27 N_C1_3 0.0014802f $X=0.477 $Y=0.234
cc_39 N_9_6 N_C1_4 0.00241267f $X=0.378 $Y=0.2025
cc_40 N_9_20 N_C1_3 0.0365723f $X=0.38 $Y=0.2025
cc_41 N_9_6 N_C2_4 0.000278141f $X=0.378 $Y=0.2025
cc_42 N_9_27 N_C2_4 0.000984333f $X=0.477 $Y=0.234
cc_43 N_9_1 N_C2_4 0.00142091f $X=0.513 $Y=0.135
cc_44 N_9_28 N_C2_4 0.00217971f $X=0.495 $Y=0.1665
cc_45 N_9_15 N_C2_3 0.00362846f $X=0.513 $Y=0.0245
cc_46 N_9_23 N_C2_4 0.00657085f $X=0.495 $Y=0.135
x_PM_OA222x2_ASAP7_75t_R%A1 vss A1 N_M0_g N_M8_g N_A1_4 N_A1_3 N_A1_1
+ PM_OA222x2_ASAP7_75t_R%A1
x_PM_OA222x2_ASAP7_75t_R%A2 vss A2 N_M1_g N_M9_g N_A2_4 N_A2_3
+ PM_OA222x2_ASAP7_75t_R%A2
cc_47 N_A2_4 N_A1_4 0.00332235f $X=0.135 $Y=0.116
cc_48 N_A2_3 N_A1_3 0.00694674f $X=0.135 $Y=0.0245

* End of included file OA222x2_ASAP7_75t_R.pex.sp.pxi
.ends

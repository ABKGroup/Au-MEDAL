.subckt PM_OAI21x1_ASAP7_75t_R%A2 vss 5 7 11 21 24 6 1 3 4
c1 1 vss 0.0135002f $X=0.189 $Y=0.135
c2 3 vss 0.139704f $X=0.189 $Y=0.0245
c3 4 vss 0.139638f $X=0.243 $Y=0.135
c4 5 vss 0.00392561f $X=0.2085 $Y=0.1355
c5 6 vss 0.00072317f $X=0.229 $Y=0.136
r1 5 6 0.763861 $w=3.26364e-08 $l=2.05e-08 $layer=M1 $thickness=3.6e-08
+ $X=0.2085 $Y=0.1355 $X2=0.229 $Y2=0.136
r2 6 26 2.56509 $w=1.3e-08 $l=1.1e-08 $layer=M1 $thickness=3.6e-08 $X=0.229
+ $Y=0.136 $X2=0.24 $Y2=0.136
r3 24 23 16.4967 $w=2.1e-08 $l=4.85e-08 $layer=Gate_1 $thickness=5.6e-08
+ $X=0.243 $Y=0.2025 $X2=0.243 $Y2=0.154
r4 21 22 16.4967 $w=2.1e-08 $l=4.85e-08 $layer=Gate_1 $thickness=5.6e-08
+ $X=0.243 $Y=0.0675 $X2=0.243 $Y2=0.116
r5 4 18 3.9286 $w=2e-08 $layer=Gate_1 $thickness=5.6e-08 $X=0.243 $Y=0.135
+ $X2=0.243 $Y2=0.135
r6 4 22 6.6497 $w=2.04211e-08 $l=1.9e-08 $layer=Gate_1 $thickness=5.6e-08
+ $X=0.243 $Y=0.135 $X2=0.243 $Y2=0.116
r7 4 23 6.6497 $w=2.04211e-08 $l=1.9e-08 $layer=Gate_1 $thickness=5.6e-08
+ $X=0.243 $Y=0.135 $X2=0.243 $Y2=0.154
r8 16 18 2.08928 $w=2.2e-08 $l=2e-09 $layer=LIG $thickness=4.8e-08 $X=0.241
+ $Y=0.135 $X2=0.243 $Y2=0.135
r9 16 26 19.3796 $a=3.24e-16 $layer=V0LIG $X=0.241 $Y=0.135 $X2=0.24 $Y2=0.136
r10 15 16 2.68 $w=2.12556e-08 $l=9e-09 $layer=LIG $thickness=4.8e-08 $X=0.232
+ $Y=0.135 $X2=0.241 $Y2=0.135
r11 14 15 10.0423 $w=1.53e-08 $l=1.7e-08 $layer=LIG $thickness=4.8e-08 $X=0.215
+ $Y=0.135 $X2=0.232 $Y2=0.135
r12 1 9 6.54019 $w=2.09524e-08 $layer=Gate_1 $thickness=5.21905e-08 $X=0.189
+ $Y=0.135 $X2=0.189 $Y2=0.135
r13 1 14 12.0632 $w=1.78769e-08 $l=2.6e-08 $layer=LIG $thickness=4.8e-08
+ $X=0.189 $Y=0.135 $X2=0.215 $Y2=0.135
r14 11 10 16.4967 $w=2.1e-08 $l=4.85e-08 $layer=Gate_1 $thickness=5.6e-08
+ $X=0.189 $Y=0.2025 $X2=0.189 $Y2=0.154
r15 9 10 6.6497 $w=2.04211e-08 $l=1.9e-08 $layer=Gate_1 $thickness=5.6e-08
+ $X=0.189 $Y=0.135 $X2=0.189 $Y2=0.154
r16 8 9 6.6497 $w=2.04211e-08 $l=1.9e-08 $layer=Gate_1 $thickness=5.6e-08
+ $X=0.189 $Y=0.116 $X2=0.189 $Y2=0.135
r17 7 8 16.4967 $w=2.1e-08 $l=4.85e-08 $layer=Gate_1 $thickness=5.6e-08
+ $X=0.189 $Y=0.0675 $X2=0.189 $Y2=0.116
r18 7 3 14.6259 $w=2.1e-08 $l=4.3e-08 $layer=Gate_1 $thickness=5.6e-08 $X=0.189
+ $Y=0.0675 $X2=0.189 $Y2=0.0245
.ends

.subckt PM_OAI21x1_ASAP7_75t_R%B vss 24 12 18 43 47 1 2 10 5 6 11 9 7 8
c1 1 vss 0.00448509f $X=0.081 $Y=0.135
c2 2 vss 0.00448509f $X=0.351 $Y=0.135
c3 5 vss 0.0887692f $X=0.081 $Y=0.0245
c4 6 vss 0.0887599f $X=0.351 $Y=0.135
c5 7 vss 0.00144508f $X=0.081 $Y=0.072
c6 8 vss 0.00144508f $X=0.351 $Y=0.072
c7 9 vss 0.00522099f $X=0.081 $Y=0.1025
c8 10 vss 0.0271882f $X=0.0945 $Y=0.072
c9 11 vss 0.00349267f $X=0.351 $Y=0.09
r1 47 46 14.6259 $w=2.1e-08 $l=4.3e-08 $layer=Gate_1 $thickness=5.6e-08
+ $X=0.351 $Y=0.2025 $X2=0.351 $Y2=0.1595
r2 45 46 2.7211 $w=2.1e-08 $l=8e-09 $layer=Gate_1 $thickness=5.6e-08 $X=0.351
+ $Y=0.1515 $X2=0.351 $Y2=0.1595
r3 43 44 14.6259 $w=2.1e-08 $l=4.3e-08 $layer=Gate_1 $thickness=5.6e-08
+ $X=0.351 $Y=0.0675 $X2=0.351 $Y2=0.1105
r4 41 44 2.7211 $w=2.1e-08 $l=8e-09 $layer=Gate_1 $thickness=5.6e-08 $X=0.351
+ $Y=0.1185 $X2=0.351 $Y2=0.1105
r5 6 41 5.79936 $w=2.03333e-08 $l=1.65e-08 $layer=Gate_1 $thickness=5.6e-08
+ $X=0.351 $Y=0.135 $X2=0.351 $Y2=0.1185
r6 6 45 5.79936 $w=2.03333e-08 $l=1.65e-08 $layer=Gate_1 $thickness=5.6e-08
+ $X=0.351 $Y=0.135 $X2=0.351 $Y2=0.1515
r7 2 37 19.3796 $a=3.24e-16 $layer=V0LIG $X=0.351 $Y=0.135 $X2=0.351 $Y2=0.136
r8 2 6 6.54019 $w=2.09524e-08 $layer=Gate_1 $thickness=5.21905e-08 $X=0.351
+ $Y=0.135 $X2=0.351 $Y2=0.135
r9 36 37 4.5472 $w=1.3e-08 $l=1.95e-08 $layer=M1 $thickness=3.6e-08 $X=0.351
+ $Y=0.1165 $X2=0.351 $Y2=0.136
r10 35 36 3.26466 $w=1.3e-08 $l=1.4e-08 $layer=M1 $thickness=3.6e-08 $X=0.351
+ $Y=0.1025 $X2=0.351 $Y2=0.1165
r11 11 35 2.91487 $w=1.3e-08 $l=1.25e-08 $layer=M1 $thickness=3.6e-08 $X=0.351
+ $Y=0.09 $X2=0.351 $Y2=0.1025
r12 8 34 1.49895 $w=1.63333e-08 $l=1.35e-08 $layer=M1 $thickness=3.6e-08
+ $X=0.351 $Y=0.072 $X2=0.3375 $Y2=0.072
r13 8 11 2.5483 $w=1.79e-08 $l=1.8e-08 $layer=M1 $thickness=3.6e-08 $X=0.351
+ $Y=0.072 $X2=0.351 $Y2=0.09
r14 33 34 4.19742 $w=1.3e-08 $l=1.8e-08 $layer=M1 $thickness=3.6e-08 $X=0.3195
+ $Y=0.072 $X2=0.3375 $Y2=0.072
r15 32 33 5.24677 $w=1.3e-08 $l=2.25e-08 $layer=M1 $thickness=3.6e-08 $X=0.297
+ $Y=0.072 $X2=0.3195 $Y2=0.072
r16 31 32 5.82974 $w=1.3e-08 $l=2.5e-08 $layer=M1 $thickness=3.6e-08 $X=0.272
+ $Y=0.072 $X2=0.297 $Y2=0.072
r17 30 31 7.11229 $w=1.3e-08 $l=3.05e-08 $layer=M1 $thickness=3.6e-08 $X=0.2415
+ $Y=0.072 $X2=0.272 $Y2=0.072
r18 29 30 7.69526 $w=1.3e-08 $l=3.3e-08 $layer=M1 $thickness=3.6e-08 $X=0.2085
+ $Y=0.072 $X2=0.2415 $Y2=0.072
r19 28 29 9.67737 $w=1.3e-08 $l=4.15e-08 $layer=M1 $thickness=3.6e-08 $X=0.167
+ $Y=0.072 $X2=0.2085 $Y2=0.072
r20 27 28 7.46207 $w=1.3e-08 $l=3.2e-08 $layer=M1 $thickness=3.6e-08 $X=0.135
+ $Y=0.072 $X2=0.167 $Y2=0.072
r21 26 27 5.24677 $w=1.3e-08 $l=2.25e-08 $layer=M1 $thickness=3.6e-08 $X=0.1125
+ $Y=0.072 $X2=0.135 $Y2=0.072
r22 10 26 4.19742 $w=1.3e-08 $l=1.8e-08 $layer=M1 $thickness=3.6e-08 $X=0.0945
+ $Y=0.072 $X2=0.1125 $Y2=0.072
r23 7 22 2.5483 $w=1.79e-08 $l=1.8e-08 $layer=M1 $thickness=3.6e-08 $X=0.081
+ $Y=0.072 $X2=0.081 $Y2=0.09
r24 7 10 1.49895 $w=1.63333e-08 $l=1.35e-08 $layer=M1 $thickness=3.6e-08
+ $X=0.081 $Y=0.072 $X2=0.0945 $Y2=0.072
r25 24 23 4.5472 $w=1.3e-08 $l=1.95e-08 $layer=M1 $thickness=3.6e-08 $X=0.0835
+ $Y=0.1355 $X2=0.081 $Y2=0.1165
r26 9 22 2.91487 $w=1.3e-08 $l=1.25e-08 $layer=M1 $thickness=3.6e-08 $X=0.081
+ $Y=0.1025 $X2=0.081 $Y2=0.09
r27 9 23 3.26466 $w=1.3e-08 $l=1.4e-08 $layer=M1 $thickness=3.6e-08 $X=0.081
+ $Y=0.1025 $X2=0.081 $Y2=0.1165
r28 1 15 6.54019 $w=2.09524e-08 $layer=Gate_1 $thickness=5.21905e-08 $X=0.081
+ $Y=0.135 $X2=0.081 $Y2=0.135
r29 24 1 19.3796 $a=3.24e-16 $layer=V0LIG $X=0.0835 $Y=0.1355 $X2=0.081
+ $Y2=0.135
r30 18 17 14.6259 $w=2.1e-08 $l=4.3e-08 $layer=Gate_1 $thickness=5.6e-08
+ $X=0.081 $Y=0.2025 $X2=0.081 $Y2=0.1595
r31 16 17 2.7211 $w=2.1e-08 $l=8e-09 $layer=Gate_1 $thickness=5.6e-08 $X=0.081
+ $Y=0.1515 $X2=0.081 $Y2=0.1595
r32 15 16 5.79936 $w=2.03333e-08 $l=1.65e-08 $layer=Gate_1 $thickness=5.6e-08
+ $X=0.081 $Y=0.135 $X2=0.081 $Y2=0.1515
r33 14 15 5.79936 $w=2.03333e-08 $l=1.65e-08 $layer=Gate_1 $thickness=5.6e-08
+ $X=0.081 $Y=0.1185 $X2=0.081 $Y2=0.135
r34 13 14 2.7211 $w=2.1e-08 $l=8e-09 $layer=Gate_1 $thickness=5.6e-08 $X=0.081
+ $Y=0.1105 $X2=0.081 $Y2=0.1185
r35 12 13 14.6259 $w=2.1e-08 $l=4.3e-08 $layer=Gate_1 $thickness=5.6e-08
+ $X=0.081 $Y=0.0675 $X2=0.081 $Y2=0.1105
r36 12 5 14.6259 $w=2.1e-08 $l=4.3e-08 $layer=Gate_1 $thickness=5.6e-08
+ $X=0.081 $Y=0.0675 $X2=0.081 $Y2=0.0245
.ends

.subckt PM_OAI21x1_ASAP7_75t_R%A1 vss 29 12 16 34 37 1 2 11 5 6 9 10 7 8
c1 1 vss 0.00628387f $X=0.135 $Y=0.135
c2 2 vss 0.00624411f $X=0.297 $Y=0.135
c3 5 vss 0.101632f $X=0.135 $Y=0.135
c4 6 vss 0.101625f $X=0.297 $Y=0.0245
c5 7 vss 0.00146139f $X=0.135 $Y=0.1945
c6 8 vss 0.00152983f $X=0.297 $Y=0.198
c7 9 vss 0.00244791f $X=0.135 $Y=0.18
c8 10 vss 0.00452041f $X=0.272 $Y=0.198
c9 11 vss 0.00263771f $X=0.297 $Y=0.1165
r1 37 36 16.4967 $w=2.1e-08 $l=4.85e-08 $layer=Gate_1 $thickness=5.6e-08
+ $X=0.135 $Y=0.2025 $X2=0.135 $Y2=0.154
r2 34 35 16.4967 $w=2.1e-08 $l=4.85e-08 $layer=Gate_1 $thickness=5.6e-08
+ $X=0.135 $Y=0.0675 $X2=0.135 $Y2=0.116
r3 5 35 6.6497 $w=2.04211e-08 $l=1.9e-08 $layer=Gate_1 $thickness=5.6e-08
+ $X=0.135 $Y=0.135 $X2=0.135 $Y2=0.116
r4 5 36 6.6497 $w=2.04211e-08 $l=1.9e-08 $layer=Gate_1 $thickness=5.6e-08
+ $X=0.135 $Y=0.135 $X2=0.135 $Y2=0.154
r5 29 1 19.3796 $a=3.24e-16 $layer=V0LIG $X=0.1345 $Y=0.1355 $X2=0.135 $Y2=0.135
r6 1 5 6.54019 $w=2.09524e-08 $layer=Gate_1 $thickness=5.21905e-08 $X=0.135
+ $Y=0.135 $X2=0.135 $Y2=0.135
r7 29 30 5.13017 $w=1.3e-08 $l=2.2e-08 $layer=M1 $thickness=3.6e-08 $X=0.1345
+ $Y=0.1355 $X2=0.135 $Y2=0.158
r8 9 30 5.13017 $w=1.3e-08 $l=2.2e-08 $layer=M1 $thickness=3.6e-08 $X=0.135
+ $Y=0.18 $X2=0.135 $Y2=0.158
r9 7 26 5.92461 $w=1.39649e-08 $l=3.21908e-08 $layer=M1 $thickness=3.6e-08
+ $X=0.135 $Y=0.1945 $X2=0.167 $Y2=0.198
r10 7 9 2.65995 $w=1.48966e-08 $l=1.45e-08 $layer=M1 $thickness=3.6e-08
+ $X=0.135 $Y=0.1945 $X2=0.135 $Y2=0.18
r11 25 26 9.67737 $w=1.3e-08 $l=4.15e-08 $layer=M1 $thickness=3.6e-08 $X=0.2085
+ $Y=0.198 $X2=0.167 $Y2=0.198
r12 24 25 7.69526 $w=1.3e-08 $l=3.3e-08 $layer=M1 $thickness=3.6e-08 $X=0.2415
+ $Y=0.198 $X2=0.2085 $Y2=0.198
r13 10 24 7.11229 $w=1.3e-08 $l=3.05e-08 $layer=M1 $thickness=3.6e-08 $X=0.272
+ $Y=0.198 $X2=0.2415 $Y2=0.198
r14 8 23 2.5483 $w=1.79e-08 $l=1.8e-08 $layer=M1 $thickness=3.6e-08 $X=0.297
+ $Y=0.198 $X2=0.297 $Y2=0.18
r15 8 10 4.18063 $w=1.48e-08 $l=2.5e-08 $layer=M1 $thickness=3.6e-08 $X=0.297
+ $Y=0.198 $X2=0.272 $Y2=0.198
r16 22 23 4.08082 $w=1.3e-08 $l=1.75e-08 $layer=M1 $thickness=3.6e-08 $X=0.297
+ $Y=0.1625 $X2=0.297 $Y2=0.18
r17 21 22 3.03147 $w=1.3e-08 $l=1.3e-08 $layer=M1 $thickness=3.6e-08 $X=0.297
+ $Y=0.1495 $X2=0.297 $Y2=0.1625
r18 20 21 3.14806 $w=1.3e-08 $l=1.35e-08 $layer=M1 $thickness=3.6e-08 $X=0.297
+ $Y=0.136 $X2=0.297 $Y2=0.1495
r19 11 20 4.5472 $w=1.3e-08 $l=1.95e-08 $layer=M1 $thickness=3.6e-08 $X=0.297
+ $Y=0.1165 $X2=0.297 $Y2=0.136
r20 2 14 6.54019 $w=2.09524e-08 $layer=Gate_1 $thickness=5.21905e-08 $X=0.297
+ $Y=0.135 $X2=0.297 $Y2=0.135
r21 2 20 19.3796 $a=3.24e-16 $layer=V0LIG $X=0.297 $Y=0.135 $X2=0.297 $Y2=0.136
r22 16 15 16.4967 $w=2.1e-08 $l=4.85e-08 $layer=Gate_1 $thickness=5.6e-08
+ $X=0.297 $Y=0.2025 $X2=0.297 $Y2=0.154
r23 14 15 6.6497 $w=2.04211e-08 $l=1.9e-08 $layer=Gate_1 $thickness=5.6e-08
+ $X=0.297 $Y=0.135 $X2=0.297 $Y2=0.154
r24 13 14 6.6497 $w=2.04211e-08 $l=1.9e-08 $layer=Gate_1 $thickness=5.6e-08
+ $X=0.297 $Y=0.116 $X2=0.297 $Y2=0.135
r25 12 13 16.4967 $w=2.1e-08 $l=4.85e-08 $layer=Gate_1 $thickness=5.6e-08
+ $X=0.297 $Y=0.0675 $X2=0.297 $Y2=0.116
r26 12 6 14.6259 $w=2.1e-08 $l=4.3e-08 $layer=Gate_1 $thickness=5.6e-08
+ $X=0.297 $Y=0.0675 $X2=0.297 $Y2=0.0245
.ends

.subckt PM_OAI21x1_ASAP7_75t_R%Y vss 29 25 47 48 51 52 59 16 3 2 22 1 4 13 14
+ 17 19 23 21 15
c1 1 vss 0.00908939f $X=0.054 $Y=0.0675
c2 2 vss 0.00730305f $X=0.108 $Y=0.2025
c3 3 vss 0.00742653f $X=0.324 $Y=0.2025
c4 4 vss 0.00908939f $X=0.378 $Y=0.0675
c5 13 vss 0.0377606f $X=0.056 $Y=0.0675
c6 14 vss 0.0377606f $X=0.3635 $Y=0.0675
c7 15 vss 0.00397185f $X=0.0935 $Y=0.2025
c8 16 vss 0.0037492f $X=0.3095 $Y=0.2025
c9 17 vss 0.00551194f $X=0.0405 $Y=0.036
c10 18 vss 0.00297978f $X=0.027 $Y=0.234
c11 19 vss 0.00551194f $X=0.405 $Y=0.036
c12 20 vss 0.00295568f $X=0.405 $Y=0.234
c13 21 vss 0.00617236f $X=0.027 $Y=0.054
c14 22 vss 0.031204f $X=0.0495 $Y=0.234
c15 23 vss 0.00618185f $X=0.405 $Y=0.216
r1 14 4 0.154321 $w=8.1e-08 $l=1.25e-08 $layer=N_src_drn $thickness=1e-09
+ $X=0.3635 $Y=0.0675 $X2=0.378 $Y2=0.0675
r2 59 14 0.0308642 $w=8.1e-08 $l=2.5e-09 $layer=N_src_drn $thickness=1e-09
+ $X=0.3606 $Y=0.0675 $X2=0.3635 $Y2=0.0675
r3 4 56 19.3796 $a=3.24e-16 $layer=V0LISD $X=0.378 $Y=0.0675 $X2=0.378 $Y2=0.036
r4 56 57 3.14806 $w=1.3e-08 $l=1.35e-08 $layer=M1 $thickness=3.6e-08 $X=0.378
+ $Y=0.036 $X2=0.3915 $Y2=0.036
r5 19 55 3.01711 $w=1.55e-08 $l=1.8e-08 $layer=M1 $thickness=3.6e-08 $X=0.405
+ $Y=0.036 $X2=0.405 $Y2=0.054
r6 19 57 1.96775 $w=1.63333e-08 $l=1.35e-08 $layer=M1 $thickness=3.6e-08
+ $X=0.405 $Y=0.036 $X2=0.3915 $Y2=0.036
r7 54 55 12.7088 $w=1.3e-08 $l=5.45e-08 $layer=M1 $thickness=3.6e-08 $X=0.405
+ $Y=0.1085 $X2=0.405 $Y2=0.054
r8 53 54 16.7897 $w=1.3e-08 $l=7.2e-08 $layer=M1 $thickness=3.6e-08 $X=0.405
+ $Y=0.1805 $X2=0.405 $Y2=0.1085
r9 23 53 8.27824 $w=1.3e-08 $l=3.55e-08 $layer=M1 $thickness=3.6e-08 $X=0.405
+ $Y=0.216 $X2=0.405 $Y2=0.1805
r10 52 50 0.0308642 $w=8.1e-08 $l=2.5e-09 $layer=P_src_drn $thickness=1e-09
+ $X=0.3413 $Y=0.2025 $X2=0.3385 $Y2=0.2025
r11 3 50 0.179012 $w=8.1e-08 $l=1.45e-08 $layer=P_src_drn $thickness=1e-09
+ $X=0.324 $Y=0.2025 $X2=0.3385 $Y2=0.2025
r12 16 3 0.179012 $w=8.1e-08 $l=1.45e-08 $layer=P_src_drn $thickness=1e-09
+ $X=0.3095 $Y=0.2025 $X2=0.324 $Y2=0.2025
r13 51 16 0.0308642 $w=8.1e-08 $l=2.5e-09 $layer=P_src_drn $thickness=1e-09
+ $X=0.3066 $Y=0.2025 $X2=0.3095 $Y2=0.2025
r14 48 46 0.0308642 $w=8.1e-08 $l=2.5e-09 $layer=P_src_drn $thickness=1e-09
+ $X=0.1253 $Y=0.2025 $X2=0.1225 $Y2=0.2025
r15 2 46 0.179012 $w=8.1e-08 $l=1.45e-08 $layer=P_src_drn $thickness=1e-09
+ $X=0.108 $Y=0.2025 $X2=0.1225 $Y2=0.2025
r16 15 2 0.179012 $w=8.1e-08 $l=1.45e-08 $layer=P_src_drn $thickness=1e-09
+ $X=0.0935 $Y=0.2025 $X2=0.108 $Y2=0.2025
r17 47 15 0.0308642 $w=8.1e-08 $l=2.5e-09 $layer=P_src_drn $thickness=1e-09
+ $X=0.0906 $Y=0.2025 $X2=0.0935 $Y2=0.2025
r18 20 44 3.59766 $w=1.5e-08 $l=2.25e-08 $layer=M1 $thickness=3.6e-08 $X=0.405
+ $Y=0.234 $X2=0.3825 $Y2=0.234
r19 20 23 2.5483 $w=1.79e-08 $l=1.8e-08 $layer=M1 $thickness=3.6e-08 $X=0.405
+ $Y=0.234 $X2=0.405 $Y2=0.216
r20 3 40 19.3796 $a=3.24e-16 $layer=V0LISD $X=0.324 $Y=0.2025 $X2=0.324
+ $Y2=0.234
r21 2 36 19.3796 $a=3.24e-16 $layer=V0LISD $X=0.108 $Y=0.2025 $X2=0.108
+ $Y2=0.234
r22 43 44 4.19742 $w=1.3e-08 $l=1.8e-08 $layer=M1 $thickness=3.6e-08 $X=0.3645
+ $Y=0.234 $X2=0.3825 $Y2=0.234
r23 42 43 3.14806 $w=1.3e-08 $l=1.35e-08 $layer=M1 $thickness=3.6e-08 $X=0.351
+ $Y=0.234 $X2=0.3645 $Y2=0.234
r24 41 42 3.14806 $w=1.3e-08 $l=1.35e-08 $layer=M1 $thickness=3.6e-08 $X=0.3375
+ $Y=0.234 $X2=0.351 $Y2=0.234
r25 40 41 3.14806 $w=1.3e-08 $l=1.35e-08 $layer=M1 $thickness=3.6e-08 $X=0.324
+ $Y=0.234 $X2=0.3375 $Y2=0.234
r26 39 40 3.14806 $w=1.3e-08 $l=1.35e-08 $layer=M1 $thickness=3.6e-08 $X=0.3105
+ $Y=0.234 $X2=0.324 $Y2=0.234
r27 38 39 22.0364 $w=1.3e-08 $l=9.45e-08 $layer=M1 $thickness=3.6e-08 $X=0.216
+ $Y=0.234 $X2=0.3105 $Y2=0.234
r28 37 38 22.0364 $w=1.3e-08 $l=9.45e-08 $layer=M1 $thickness=3.6e-08 $X=0.1215
+ $Y=0.234 $X2=0.216 $Y2=0.234
r29 36 37 3.14806 $w=1.3e-08 $l=1.35e-08 $layer=M1 $thickness=3.6e-08 $X=0.108
+ $Y=0.234 $X2=0.1215 $Y2=0.234
r30 35 36 3.14806 $w=1.3e-08 $l=1.35e-08 $layer=M1 $thickness=3.6e-08 $X=0.0945
+ $Y=0.234 $X2=0.108 $Y2=0.234
r31 34 35 3.14806 $w=1.3e-08 $l=1.35e-08 $layer=M1 $thickness=3.6e-08 $X=0.081
+ $Y=0.234 $X2=0.0945 $Y2=0.234
r32 33 34 3.14806 $w=1.3e-08 $l=1.35e-08 $layer=M1 $thickness=3.6e-08 $X=0.0675
+ $Y=0.234 $X2=0.081 $Y2=0.234
r33 22 33 4.19742 $w=1.3e-08 $l=1.8e-08 $layer=M1 $thickness=3.6e-08 $X=0.0495
+ $Y=0.234 $X2=0.0675 $Y2=0.234
r34 18 32 2.5483 $w=1.79e-08 $l=1.8e-08 $layer=M1 $thickness=3.6e-08 $X=0.027
+ $Y=0.234 $X2=0.027 $Y2=0.216
r35 18 22 3.59766 $w=1.5e-08 $l=2.25e-08 $layer=M1 $thickness=3.6e-08 $X=0.027
+ $Y=0.234 $X2=0.0495 $Y2=0.234
r36 31 32 2.91487 $w=1.3e-08 $l=1.25e-08 $layer=M1 $thickness=3.6e-08 $X=0.027
+ $Y=0.2035 $X2=0.027 $Y2=0.216
r37 30 31 11.1348 $w=1.3e-08 $l=4.78e-08 $layer=M1 $thickness=3.6e-08 $X=0.027
+ $Y=0.1557 $X2=0.027 $Y2=0.2035
r38 29 30 10.4352 $w=1.3e-08 $l=4.47e-08 $layer=M1 $thickness=3.6e-08 $X=0.025
+ $Y=0.111 $X2=0.027 $Y2=0.1557
r39 29 28 5.65485 $w=1.3e-08 $l=2.43e-08 $layer=M1 $thickness=3.6e-08 $X=0.025
+ $Y=0.111 $X2=0.027 $Y2=0.0867
r40 21 27 3.01711 $w=1.55e-08 $l=1.8e-08 $layer=M1 $thickness=3.6e-08 $X=0.027
+ $Y=0.054 $X2=0.027 $Y2=0.036
r41 21 28 7.63696 $w=1.3e-08 $l=3.27e-08 $layer=M1 $thickness=3.6e-08 $X=0.027
+ $Y=0.054 $X2=0.027 $Y2=0.0867
r42 17 26 3.14806 $w=1.3e-08 $l=1.35e-08 $layer=M1 $thickness=3.6e-08 $X=0.0405
+ $Y=0.036 $X2=0.054 $Y2=0.036
r43 17 27 1.96775 $w=1.63333e-08 $l=1.35e-08 $layer=M1 $thickness=3.6e-08
+ $X=0.0405 $Y=0.036 $X2=0.027 $Y2=0.036
r44 1 26 19.3796 $a=3.24e-16 $layer=V0LISD $X=0.054 $Y=0.0675 $X2=0.054
+ $Y2=0.036
r45 25 24 0.0308642 $w=8.1e-08 $l=2.5e-09 $layer=N_src_drn $thickness=1e-09
+ $X=0.0713 $Y=0.0675 $X2=0.0685 $Y2=0.0675
r46 13 24 0.154321 $w=8.1e-08 $l=1.25e-08 $layer=N_src_drn $thickness=1e-09
+ $X=0.056 $Y=0.0675 $X2=0.0685 $Y2=0.0675
r47 1 13 1e-05 $l=2e-09 $X=0.054 $Y=0.0675 $X2=0.056 $Y2=0.0675
.ends

* End of included file OAI21x1_ASAP7_75t_R.pex.sp.pex

*
.subckt OAI21x1_ASAP7_75t_CUSTOM_4_25_0_7 VSS VDD B A1 A2 Y
*
* VSS VSS
* VDD VDD
* B B
* A1 A1
* A2 A2
* Y Y
*
*

M0 noxref_6 N_M0_g N_M0_s VSS nmos_rvt L=2e-08 W=8.1e-08 nfin=3 $X=0.071
+ $Y=0.027
M1 VSS N_M1_g noxref_6 VSS nmos_rvt L=2e-08 W=8.1e-08 nfin=3 $X=0.125 $Y=0.027
M2 noxref_6 N_M2_g VSS VSS nmos_rvt L=2e-08 W=8.1e-08 nfin=3 $X=0.179 $Y=0.027
M3 noxref_6 N_M3_g VSS VSS nmos_rvt L=2e-08 W=8.1e-08 nfin=3 $X=0.233 $Y=0.027
M4 VSS N_M4_g noxref_6 VSS nmos_rvt L=2e-08 W=8.1e-08 nfin=3 $X=0.287 $Y=0.027
M5 noxref_6 N_M5_g N_M5_s VSS nmos_rvt L=2e-08 W=8.1e-08 nfin=3 $X=0.341
+ $Y=0.027
M6 N_M6_d N_M6_g VDD VDD pmos_rvt L=2e-08 W=8.1e-08 nfin=3 $X=0.071 $Y=0.162
M7 N_M7_d N_M7_g noxref_8 VDD pmos_rvt L=2e-08 W=8.1e-08 nfin=3 $X=0.125
+ $Y=0.162
M8 noxref_8 N_M8_g VDD VDD pmos_rvt L=2e-08 W=8.1e-08 nfin=3 $X=0.179 $Y=0.162
M9 noxref_9 N_M9_g VDD VDD pmos_rvt L=2e-08 W=8.1e-08 nfin=3 $X=0.233 $Y=0.162
M10 N_M10_d N_M10_g noxref_9 VDD pmos_rvt L=2e-08 W=8.1e-08 nfin=3 $X=0.287
+ $Y=0.162
M11 N_M11_d N_M11_g VDD VDD pmos_rvt L=2e-08 W=8.1e-08 nfin=3 $X=0.341 $Y=0.162

* .include "OAI21x1_ASAP7_75t_R.pex.sp.pxi"

* Start of included file OAI21x1_ASAP7_75t_R.pex.sp.pxi
x_PM_OAI21x1_ASAP7_75t_R%A2 vss A2 N_M2_g N_M8_g N_M3_g N_M9_g N_A2_6 N_A2_1
+ N_A2_3 N_A2_4 PM_OAI21x1_ASAP7_75t_R%A2
cc_1 A2 N_B_10 0.00555231f $X=0.2085 $Y=0.1355
cc_2 A2 N_A1_9 0.00149138f $X=0.2085 $Y=0.1355
cc_3 N_A2_6 N_A1_11 0.00187078f $X=0.229 $Y=0.136
cc_4 N_A2_1 N_A1_1 0.00262389f $X=0.189 $Y=0.135
cc_5 N_A2_3 N_A1_5 0.00510635f $X=0.189 $Y=0.0245
cc_6 N_A2_4 N_A1_6 0.00512042f $X=0.243 $Y=0.135
cc_7 A2 N_A1_10 0.00739895f $X=0.2085 $Y=0.1355
x_PM_OAI21x1_ASAP7_75t_R%B vss B N_M0_g N_M6_g N_M5_g N_M11_g N_B_1 N_B_2
+ N_B_10 N_B_5 N_B_6 N_B_11 N_B_9 N_B_7 N_B_8 PM_OAI21x1_ASAP7_75t_R%B
x_PM_OAI21x1_ASAP7_75t_R%A1 vss A1 N_M4_g N_M10_g N_M1_g N_M7_g N_A1_1 N_A1_2
+ N_A1_11 N_A1_5 N_A1_6 N_A1_9 N_A1_10 N_A1_7 N_A1_8 PM_OAI21x1_ASAP7_75t_R%A1
cc_8 N_A1_1 N_B_1 0.00189286f $X=0.135 $Y=0.135
cc_9 N_A1_2 N_B_2 0.00107967f $X=0.297 $Y=0.135
cc_10 N_A1_11 N_B_10 0.00238918f $X=0.297 $Y=0.1165
cc_11 N_A1_5 N_B_5 0.00325991f $X=0.135 $Y=0.135
cc_12 N_A1_6 N_B_6 0.00326445f $X=0.297 $Y=0.0245
cc_13 N_A1_11 N_B_11 0.00333914f $X=0.297 $Y=0.1165
cc_14 N_A1_9 N_B_9 0.00587097f $X=0.135 $Y=0.18
x_PM_OAI21x1_ASAP7_75t_R%Y vss Y N_M0_s N_M6_d N_M7_d N_M10_d N_M11_d N_M5_s
+ N_Y_16 N_Y_3 N_Y_2 N_Y_22 N_Y_1 N_Y_4 N_Y_13 N_Y_14 N_Y_17 N_Y_19 N_Y_23
+ N_Y_21 N_Y_15 PM_OAI21x1_ASAP7_75t_R%Y
cc_15 N_Y_16 N_B_10 0.000670664f $X=0.3095 $Y=0.2025
cc_16 N_Y_3 N_B_6 0.000807811f $X=0.324 $Y=0.2025
cc_17 N_Y_2 N_B_1 0.000837314f $X=0.108 $Y=0.2025
cc_18 N_Y_3 N_B_2 0.000837314f $X=0.324 $Y=0.2025
cc_19 N_Y_2 N_B_5 0.00106708f $X=0.108 $Y=0.2025
cc_20 N_Y_22 N_B_9 0.00127371f $X=0.0495 $Y=0.234
cc_21 N_Y_1 N_B_5 0.00132999f $X=0.054 $Y=0.0675
cc_22 N_Y_4 N_B_6 0.00132999f $X=0.378 $Y=0.0675
cc_23 N_Y_13 N_B_1 0.00160186f $X=0.056 $Y=0.0675
cc_24 N_Y_14 N_B_2 0.00160186f $X=0.3635 $Y=0.0675
cc_25 N_Y_17 N_B_7 0.0016102f $X=0.0405 $Y=0.036
cc_26 N_Y_19 N_B_8 0.0016102f $X=0.405 $Y=0.036
cc_27 N_Y_23 N_B_11 0.00501245f $X=0.405 $Y=0.216
cc_28 N_Y_13 N_B_5 0.0147837f $X=0.056 $Y=0.0675
cc_29 N_Y_14 N_B_6 0.0147837f $X=0.3635 $Y=0.0675
cc_30 N_Y_21 N_B_9 0.00679955f $X=0.027 $Y=0.054
cc_31 N_Y_15 N_B_5 0.0524837f $X=0.0935 $Y=0.2025
cc_32 N_Y_16 N_B_6 0.0550181f $X=0.3095 $Y=0.2025
cc_33 N_Y_15 N_A1_9 0.000683349f $X=0.0935 $Y=0.2025
cc_34 N_Y_15 N_A1_1 0.00081011f $X=0.0935 $Y=0.2025
cc_35 N_Y_16 N_A1_2 0.00081011f $X=0.3095 $Y=0.2025
cc_36 N_Y_3 N_A1_11 0.000825545f $X=0.324 $Y=0.2025
cc_37 N_Y_22 N_A1_7 0.00137566f $X=0.0495 $Y=0.234
cc_38 N_Y_22 N_A1_8 0.00142157f $X=0.0495 $Y=0.234
cc_39 N_Y_2 N_A1_5 0.00150812f $X=0.108 $Y=0.2025
cc_40 N_Y_3 N_A1_6 0.00157669f $X=0.324 $Y=0.2025
cc_41 N_Y_16 N_A1_6 0.0343415f $X=0.3095 $Y=0.2025
cc_42 N_Y_22 N_A1_10 0.0121335f $X=0.0495 $Y=0.234
cc_43 N_Y_15 N_A1_5 0.0366811f $X=0.0935 $Y=0.2025

* End of included file OAI21x1_ASAP7_75t_R.pex.sp.pxi
.ends

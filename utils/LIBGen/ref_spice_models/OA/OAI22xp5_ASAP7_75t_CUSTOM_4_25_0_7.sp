.subckt PM_OAI22xp5_ASAP7_75t_R%B1 vss 14 6 12 3
c1 1 vss 0.00719301f $X=0.243 $Y=0.135
c2 3 vss 0.142759f $X=0.243 $Y=0.0245
c3 4 vss 0.00823868f $X=0.243 $Y=0.234
c4 5 vss 0.0126017f $X=0.243 $Y=0.1035
r1 4 18 3.83327 $w=1.5093e-08 $l=2.15e-08 $layer=M1 $thickness=3.6e-08 $X=0.243
+ $Y=0.234 $X2=0.243 $Y2=0.2125
r2 17 18 7.11229 $w=1.3e-08 $l=3.05e-08 $layer=M1 $thickness=3.6e-08 $X=0.243
+ $Y=0.182 $X2=0.243 $Y2=0.2125
r3 15 17 6.52931 $w=1.3e-08 $l=2.8e-08 $layer=M1 $thickness=3.6e-08 $X=0.243
+ $Y=0.154 $X2=0.243 $Y2=0.182
r4 14 15 4.43061 $w=1.3e-08 $l=1.9e-08 $layer=M1 $thickness=3.6e-08 $X=0.242
+ $Y=0.138 $X2=0.243 $Y2=0.154
r5 14 5 7.34548 $w=1.3e-08 $l=3.15e-08 $layer=M1 $thickness=3.6e-08 $X=0.242
+ $Y=0.138 $X2=0.243 $Y2=0.1035
r6 1 9 10.4265 $w=1.765e-08 $layer=LIG $thickness=5.2e-08 $X=0.243 $Y=0.135
+ $X2=0.243 $Y2=0.135
r7 14 1 19.3796 $a=3.24e-16 $layer=V0LIG $X=0.242 $Y=0.138 $X2=0.243 $Y2=0.135
r8 12 11 14.6259 $w=2.1e-08 $l=4.3e-08 $layer=Gate_1 $thickness=5.6e-08
+ $X=0.243 $Y=0.2025 $X2=0.243 $Y2=0.1595
r9 10 11 2.7211 $w=2.1e-08 $l=8e-09 $layer=Gate_1 $thickness=5.6e-08 $X=0.243
+ $Y=0.1515 $X2=0.243 $Y2=0.1595
r10 9 10 5.79936 $w=2.03333e-08 $l=1.65e-08 $layer=Gate_1 $thickness=5.6e-08
+ $X=0.243 $Y=0.135 $X2=0.243 $Y2=0.1515
r11 8 9 5.79936 $w=2.03333e-08 $l=1.65e-08 $layer=Gate_1 $thickness=5.6e-08
+ $X=0.243 $Y=0.1185 $X2=0.243 $Y2=0.135
r12 7 8 2.7211 $w=2.1e-08 $l=8e-09 $layer=Gate_1 $thickness=5.6e-08 $X=0.243
+ $Y=0.1105 $X2=0.243 $Y2=0.1185
r13 6 7 14.6259 $w=2.1e-08 $l=4.3e-08 $layer=Gate_1 $thickness=5.6e-08 $X=0.243
+ $Y=0.0675 $X2=0.243 $Y2=0.1105
r14 6 3 14.6259 $w=2.1e-08 $l=4.3e-08 $layer=Gate_1 $thickness=5.6e-08 $X=0.243
+ $Y=0.0675 $X2=0.243 $Y2=0.0245
.ends

.subckt PM_OAI22xp5_ASAP7_75t_R%B2 vss 12 6 10 5 3 1
c1 1 vss 0.0065908f $X=0.189 $Y=0.135
c2 3 vss 0.101954f $X=0.189 $Y=0.0245
c3 4 vss 0.00827195f $X=0.189 $Y=0.072
c4 5 vss 0.00374584f $X=0.189 $Y=0.116
r1 4 14 3.83327 $w=1.5093e-08 $l=2.15e-08 $layer=M1 $thickness=3.6e-08 $X=0.189
+ $Y=0.072 $X2=0.189 $Y2=0.0935
r2 12 5 4.43061 $w=1.3e-08 $l=1.9e-08 $layer=M1 $thickness=3.6e-08 $X=0.189
+ $Y=0.138 $X2=0.189 $Y2=0.116
r3 5 14 5.24677 $w=1.3e-08 $l=2.25e-08 $layer=M1 $thickness=3.6e-08 $X=0.189
+ $Y=0.116 $X2=0.189 $Y2=0.0935
r4 1 8 10.4265 $w=1.765e-08 $layer=LIG $thickness=5.2e-08 $X=0.189 $Y=0.135
+ $X2=0.189 $Y2=0.135
r5 12 1 19.3796 $a=3.24e-16 $layer=V0LIG $X=0.189 $Y=0.138 $X2=0.189 $Y2=0.135
r6 10 9 16.4967 $w=2.1e-08 $l=4.85e-08 $layer=Gate_1 $thickness=5.6e-08
+ $X=0.189 $Y=0.2025 $X2=0.189 $Y2=0.154
r7 8 9 6.6497 $w=2.04211e-08 $l=1.9e-08 $layer=Gate_1 $thickness=5.6e-08
+ $X=0.189 $Y=0.135 $X2=0.189 $Y2=0.154
r8 7 8 6.6497 $w=2.04211e-08 $l=1.9e-08 $layer=Gate_1 $thickness=5.6e-08
+ $X=0.189 $Y=0.116 $X2=0.189 $Y2=0.135
r9 6 7 16.4967 $w=2.1e-08 $l=4.85e-08 $layer=Gate_1 $thickness=5.6e-08 $X=0.189
+ $Y=0.0675 $X2=0.189 $Y2=0.116
r10 6 3 14.6259 $w=2.1e-08 $l=4.3e-08 $layer=Gate_1 $thickness=5.6e-08 $X=0.189
+ $Y=0.0675 $X2=0.189 $Y2=0.0245
.ends

.subckt PM_OAI22xp5_ASAP7_75t_R%Y vss 23 16 17 36 37 12 13 11 7 8 2
c1 1 vss 0.00960353f $X=0.108 $Y=0.0675
c2 2 vss 0.00654131f $X=0.162 $Y=0.2025
c3 7 vss 0.00454539f $X=0.0935 $Y=0.0675
c4 8 vss 0.00265042f $X=0.1475 $Y=0.2025
c5 9 vss 0.00232635f $X=0.027 $Y=0.072
c6 10 vss 0.00297417f $X=0.027 $Y=0.234
c7 11 vss 0.00621605f $X=0.027 $Y=0.0935
c8 12 vss 0.00704056f $X=0.0945 $Y=0.072
c9 13 vss 0.0133084f $X=0.054 $Y=0.234
r1 37 35 0.0308642 $w=8.1e-08 $l=2.5e-09 $layer=P_src_drn $thickness=1e-09
+ $X=0.1793 $Y=0.2025 $X2=0.1765 $Y2=0.2025
r2 2 35 0.179012 $w=8.1e-08 $l=1.45e-08 $layer=P_src_drn $thickness=1e-09
+ $X=0.162 $Y=0.2025 $X2=0.1765 $Y2=0.2025
r3 8 2 0.179012 $w=8.1e-08 $l=1.45e-08 $layer=P_src_drn $thickness=1e-09
+ $X=0.1475 $Y=0.2025 $X2=0.162 $Y2=0.2025
r4 36 8 0.0308642 $w=8.1e-08 $l=2.5e-09 $layer=P_src_drn $thickness=1e-09
+ $X=0.1446 $Y=0.2025 $X2=0.1475 $Y2=0.2025
r5 2 32 19.3796 $a=3.24e-16 $layer=V0LISD $X=0.162 $Y=0.2025 $X2=0.162 $Y2=0.234
r6 31 32 2.3319 $w=1.3e-08 $l=1e-08 $layer=M1 $thickness=3.6e-08 $X=0.152
+ $Y=0.234 $X2=0.162 $Y2=0.234
r7 30 31 1.04935 $w=1.3e-08 $l=4.5e-09 $layer=M1 $thickness=3.6e-08 $X=0.1475
+ $Y=0.234 $X2=0.152 $Y2=0.234
r8 29 30 2.91487 $w=1.3e-08 $l=1.25e-08 $layer=M1 $thickness=3.6e-08 $X=0.135
+ $Y=0.234 $X2=0.1475 $Y2=0.234
r9 28 29 3.14806 $w=1.3e-08 $l=1.35e-08 $layer=M1 $thickness=3.6e-08 $X=0.1215
+ $Y=0.234 $X2=0.135 $Y2=0.234
r10 27 28 4.19742 $w=1.3e-08 $l=1.8e-08 $layer=M1 $thickness=3.6e-08 $X=0.1035
+ $Y=0.234 $X2=0.1215 $Y2=0.234
r11 26 27 5.24677 $w=1.3e-08 $l=2.25e-08 $layer=M1 $thickness=3.6e-08 $X=0.081
+ $Y=0.234 $X2=0.1035 $Y2=0.234
r12 13 26 6.29612 $w=1.3e-08 $l=2.7e-08 $layer=M1 $thickness=3.6e-08 $X=0.054
+ $Y=0.234 $X2=0.081 $Y2=0.234
r13 10 25 3.36447 $w=1.71023e-08 $l=2.15e-08 $layer=M1 $thickness=3.6e-08
+ $X=0.027 $Y=0.234 $X2=0.027 $Y2=0.2125
r14 10 13 4.64701 $w=1.46667e-08 $l=2.7e-08 $layer=M1 $thickness=3.6e-08
+ $X=0.027 $Y=0.234 $X2=0.054 $Y2=0.234
r15 24 25 11.7178 $w=1.3e-08 $l=5.03e-08 $layer=M1 $thickness=3.6e-08 $X=0.027
+ $Y=0.1622 $X2=0.027 $Y2=0.2125
r16 23 24 8.91951 $w=1.3e-08 $l=3.82e-08 $layer=M1 $thickness=3.6e-08 $X=0.02
+ $Y=0.124 $X2=0.027 $Y2=0.1622
r17 23 22 2.15701 $w=1.3e-08 $l=9.3e-09 $layer=M1 $thickness=3.6e-08 $X=0.02
+ $Y=0.124 $X2=0.027 $Y2=0.1147
r18 11 22 4.95528 $w=1.3e-08 $l=2.12e-08 $layer=M1 $thickness=3.6e-08 $X=0.027
+ $Y=0.0935 $X2=0.027 $Y2=0.1147
r19 9 21 0.915974 $w=1.70909e-08 $l=1.1e-08 $layer=M1 $thickness=3.6e-08
+ $X=0.027 $Y=0.072 $X2=0.038 $Y2=0.072
r20 9 11 3.36447 $w=1.71023e-08 $l=2.15e-08 $layer=M1 $thickness=3.6e-08
+ $X=0.027 $Y=0.072 $X2=0.027 $Y2=0.0935
r21 20 21 4.19742 $w=1.3e-08 $l=1.8e-08 $layer=M1 $thickness=3.6e-08 $X=0.056
+ $Y=0.072 $X2=0.038 $Y2=0.072
r22 19 20 5.82974 $w=1.3e-08 $l=2.5e-08 $layer=M1 $thickness=3.6e-08 $X=0.081
+ $Y=0.072 $X2=0.056 $Y2=0.072
r23 12 18 3.14806 $w=1.3e-08 $l=1.35e-08 $layer=M1 $thickness=3.6e-08 $X=0.0945
+ $Y=0.072 $X2=0.108 $Y2=0.072
r24 12 19 3.14806 $w=1.3e-08 $l=1.35e-08 $layer=M1 $thickness=3.6e-08 $X=0.0945
+ $Y=0.072 $X2=0.081 $Y2=0.072
r25 1 18 19.3796 $a=3.24e-16 $layer=V0LISD $X=0.108 $Y=0.0675 $X2=0.108
+ $Y2=0.072
r26 17 15 0.0308642 $w=8.1e-08 $l=2.5e-09 $layer=N_src_drn $thickness=1e-09
+ $X=0.1253 $Y=0.0675 $X2=0.1225 $Y2=0.0675
r27 1 15 0.179012 $w=8.1e-08 $l=1.45e-08 $layer=N_src_drn $thickness=1e-09
+ $X=0.108 $Y=0.0675 $X2=0.1225 $Y2=0.0675
r28 7 1 0.179012 $w=8.1e-08 $l=1.45e-08 $layer=N_src_drn $thickness=1e-09
+ $X=0.0935 $Y=0.0675 $X2=0.108 $Y2=0.0675
r29 16 7 0.0308642 $w=8.1e-08 $l=2.5e-09 $layer=N_src_drn $thickness=1e-09
+ $X=0.0906 $Y=0.0675 $X2=0.0935 $Y2=0.0675
.ends

.subckt PM_OAI22xp5_ASAP7_75t_R%A1 vss 13 5 11 4 3
c1 1 vss 0.00476715f $X=0.081 $Y=0.135
c2 3 vss 0.107704f $X=0.081 $Y=0.0245
c3 4 vss 0.00449107f $X=0.081 $Y=0.116
r1 13 4 4.4306 $w=1.3e-08 $l=1.9e-08 $layer=M1 $thickness=3.6e-08 $X=0.081
+ $Y=0.137 $X2=0.081 $Y2=0.116
r2 1 8 10.4265 $w=1.765e-08 $layer=LIG $thickness=5.2e-08 $X=0.081 $Y=0.135
+ $X2=0.081 $Y2=0.135
r3 13 1 19.3796 $a=3.24e-16 $layer=V0LIG $X=0.081 $Y=0.137 $X2=0.081 $Y2=0.135
r4 11 10 14.6259 $w=2.1e-08 $l=4.3e-08 $layer=Gate_1 $thickness=5.6e-08
+ $X=0.081 $Y=0.2025 $X2=0.081 $Y2=0.1595
r5 9 10 2.7211 $w=2.1e-08 $l=8e-09 $layer=Gate_1 $thickness=5.6e-08 $X=0.081
+ $Y=0.1515 $X2=0.081 $Y2=0.1595
r6 8 9 5.79936 $w=2.03333e-08 $l=1.65e-08 $layer=Gate_1 $thickness=5.6e-08
+ $X=0.081 $Y=0.135 $X2=0.081 $Y2=0.1515
r7 7 8 5.79936 $w=2.03333e-08 $l=1.65e-08 $layer=Gate_1 $thickness=5.6e-08
+ $X=0.081 $Y=0.1185 $X2=0.081 $Y2=0.135
r8 6 7 2.7211 $w=2.1e-08 $l=8e-09 $layer=Gate_1 $thickness=5.6e-08 $X=0.081
+ $Y=0.1105 $X2=0.081 $Y2=0.1185
r9 5 6 14.6259 $w=2.1e-08 $l=4.3e-08 $layer=Gate_1 $thickness=5.6e-08 $X=0.081
+ $Y=0.0675 $X2=0.081 $Y2=0.1105
r10 5 3 14.6259 $w=2.1e-08 $l=4.3e-08 $layer=Gate_1 $thickness=5.6e-08 $X=0.081
+ $Y=0.0675 $X2=0.081 $Y2=0.0245
.ends

.subckt PM_OAI22xp5_ASAP7_75t_R%A2 vss 11 5 9 4 3 1
c1 1 vss 0.00760877f $X=0.135 $Y=0.135
c2 3 vss 0.0653112f $X=0.135 $Y=0.0245
c3 4 vss 0.00482995f $X=0.135 $Y=0.116
r1 11 4 4.43061 $w=1.3e-08 $l=1.9e-08 $layer=M1 $thickness=3.6e-08 $X=0.134
+ $Y=0.137 $X2=0.135 $Y2=0.116
r2 1 7 10.4265 $w=1.765e-08 $layer=LIG $thickness=5.2e-08 $X=0.135 $Y=0.135
+ $X2=0.135 $Y2=0.135
r3 11 1 19.3796 $a=3.24e-16 $layer=V0LIG $X=0.134 $Y=0.137 $X2=0.135 $Y2=0.135
r4 9 8 16.4967 $w=2.1e-08 $l=4.85e-08 $layer=Gate_1 $thickness=5.6e-08 $X=0.135
+ $Y=0.2025 $X2=0.135 $Y2=0.154
r5 7 8 6.6497 $w=2.04211e-08 $l=1.9e-08 $layer=Gate_1 $thickness=5.6e-08
+ $X=0.135 $Y=0.135 $X2=0.135 $Y2=0.154
r6 6 7 6.6497 $w=2.04211e-08 $l=1.9e-08 $layer=Gate_1 $thickness=5.6e-08
+ $X=0.135 $Y=0.116 $X2=0.135 $Y2=0.135
r7 5 6 16.4967 $w=2.1e-08 $l=4.85e-08 $layer=Gate_1 $thickness=5.6e-08 $X=0.135
+ $Y=0.0675 $X2=0.135 $Y2=0.116
r8 5 3 14.6259 $w=2.1e-08 $l=4.3e-08 $layer=Gate_1 $thickness=5.6e-08 $X=0.135
+ $Y=0.0675 $X2=0.135 $Y2=0.0245
.ends

* End of included file OAI22xp5_ASAP7_75t_R.pex.sp.pex

*
.subckt OAI22xp5_ASAP7_75t_CUSTOM_4_25_0_7 VSS VDD A1 A2 B2 B1 Y
*
* VSS VSS
* VDD VDD
* A1 A1
* A2 A2
* B2 B2
* B1 B1
* Y Y
*
*

M0 N_M0_d N_M0_g noxref_8 VSS nmos_rvt L=2e-08 W=8.1e-08 nfin=3 $X=0.071
+ $Y=0.027
M1 noxref_8 N_M1_g N_M1_s VSS nmos_rvt L=2e-08 W=8.1e-08 nfin=3 $X=0.125
+ $Y=0.027
M2 VSS N_M2_g noxref_8 VSS nmos_rvt L=2e-08 W=8.1e-08 nfin=3 $X=0.179 $Y=0.027
M3 noxref_8 N_M3_g VSS VSS nmos_rvt L=2e-08 W=8.1e-08 nfin=3 $X=0.233 $Y=0.027
M4 noxref_9 N_M4_g VDD VDD pmos_rvt L=2e-08 W=8.1e-08 nfin=3 $X=0.071 $Y=0.162
M5 N_M5_d N_M5_g noxref_9 VDD pmos_rvt L=2e-08 W=8.1e-08 nfin=3 $X=0.125
+ $Y=0.162
M6 noxref_10 N_M6_g N_M6_s VDD pmos_rvt L=2e-08 W=8.1e-08 nfin=3 $X=0.179
+ $Y=0.162
M7 VDD N_M7_g noxref_10 VDD pmos_rvt L=2e-08 W=8.1e-08 nfin=3 $X=0.233 $Y=0.162

* .include "OAI22xp5_ASAP7_75t_R.pex.sp.pxi"

* Start of included file OAI22xp5_ASAP7_75t_R.pex.sp.pxi
x_PM_OAI22xp5_ASAP7_75t_R%B1 vss B1 N_M3_g N_M7_g N_B1_3
+ PM_OAI22xp5_ASAP7_75t_R%B1
cc_1 N_B1_3 N_B2_5 0.00388484f $X=0.243 $Y=0.0245
cc_2 N_B1_3 N_B2_3 0.00750465f $X=0.243 $Y=0.0245
x_PM_OAI22xp5_ASAP7_75t_R%B2 vss B2 N_M2_g N_M6_g N_B2_5 N_B2_3 N_B2_1
+ PM_OAI22xp5_ASAP7_75t_R%B2
cc_3 N_B2_5 N_A2_4 0.00308524f $X=0.189 $Y=0.116
cc_4 N_B2_3 N_A2_3 0.00547199f $X=0.189 $Y=0.0245
x_PM_OAI22xp5_ASAP7_75t_R%Y vss Y N_M0_d N_M1_s N_M5_d N_M6_s N_Y_12 N_Y_13
+ N_Y_11 N_Y_7 N_Y_8 N_Y_2 PM_OAI22xp5_ASAP7_75t_R%Y
cc_5 N_Y_12 N_A1_4 0.000952969f $X=0.0945 $Y=0.072
cc_6 N_Y_13 N_A1_4 0.0011041f $X=0.054 $Y=0.234
cc_7 N_Y_11 N_A1_4 0.00591864f $X=0.027 $Y=0.0935
cc_8 N_Y_7 N_A1_3 0.0368512f $X=0.0935 $Y=0.0675
cc_9 N_Y_13 N_A2_4 0.00113556f $X=0.054 $Y=0.234
cc_10 N_Y_8 N_A2_1 0.00142628f $X=0.1475 $Y=0.2025
cc_11 N_Y_2 N_A2_3 0.00145218f $X=0.162 $Y=0.2025
cc_12 N_Y_2 N_A2_4 0.0025098f $X=0.162 $Y=0.2025
cc_13 N_Y_7 N_A2_3 0.014512f $X=0.0935 $Y=0.0675
cc_14 N_Y_8 N_A2_3 0.0554176f $X=0.1475 $Y=0.2025
cc_15 N_Y_8 N_B2_1 0.000773101f $X=0.1475 $Y=0.2025
cc_16 N_Y_2 N_B2_3 0.00115372f $X=0.162 $Y=0.2025
cc_17 N_Y_8 N_B2_3 0.0360294f $X=0.1475 $Y=0.2025
x_PM_OAI22xp5_ASAP7_75t_R%A1 vss A1 N_M0_g N_M4_g N_A1_4 N_A1_3
+ PM_OAI22xp5_ASAP7_75t_R%A1
x_PM_OAI22xp5_ASAP7_75t_R%A2 vss A2 N_M1_g N_M5_g N_A2_4 N_A2_3 N_A2_1
+ PM_OAI22xp5_ASAP7_75t_R%A2
cc_18 N_A2_4 N_A1_4 0.00330715f $X=0.135 $Y=0.116
cc_19 N_A2_3 N_A1_3 0.00692583f $X=0.135 $Y=0.0245

* End of included file OAI22xp5_ASAP7_75t_R.pex.sp.pxi
.ends

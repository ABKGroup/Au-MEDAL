.subckt PM_NAND2x1p5_ASAP7_75t_R%A vss 24 10 27 30 33 36 1 9 5 3 4 8
c1 1 vss 0.0156514f $X=0.075 $Y=0.1345
c2 3 vss 0.0551734f $X=0.081 $Y=0.0245
c3 4 vss 0.0948397f $X=0.135 $Y=0.1345
c4 5 vss 0.0827417f $X=0.189 $Y=0.1345
c5 6 vss 0.00280147f $X=0.027 $Y=0.135
c6 7 vss 0.0209627f $X=0.027 $Y=0.098
c7 8 vss 0.0200607f $X=0.027 $Y=0.172
c8 9 vss 0.00522403f $X=0.0485 $Y=0.135
r1 6 9 3.83327 $w=1.5093e-08 $l=2.15e-08 $layer=M1 $thickness=3.6e-08 $X=0.027
+ $Y=0.135 $X2=0.0485 $Y2=0.135
r2 6 7 7.44771 $w=1.42162e-08 $l=3.7e-08 $layer=M1 $thickness=3.6e-08 $X=0.027
+ $Y=0.135 $X2=0.027 $Y2=0.098
r3 6 8 7.44771 $w=1.42162e-08 $l=3.7e-08 $layer=M1 $thickness=3.6e-08 $X=0.027
+ $Y=0.135 $X2=0.027 $Y2=0.172
r4 36 35 16.4967 $w=2.1e-08 $l=4.85e-08 $layer=Gate_1 $thickness=5.6e-08
+ $X=0.189 $Y=0.216 $X2=0.189 $Y2=0.1675
r5 33 34 16.3266 $w=2.1e-08 $l=4.8e-08 $layer=Gate_1 $thickness=5.6e-08
+ $X=0.189 $Y=0.0675 $X2=0.189 $Y2=0.1155
r6 5 22 6.4735 $w=2.13953e-08 $layer=Gate_1 $thickness=5.22791e-08 $X=0.189
+ $Y=0.1345 $X2=0.189 $Y2=0.1345
r7 5 34 6.6582 $w=2.03947e-08 $l=1.9e-08 $layer=Gate_1 $thickness=5.6e-08
+ $X=0.189 $Y=0.1345 $X2=0.189 $Y2=0.1155
r8 5 35 11.4201 $w=2.06515e-08 $l=3.3e-08 $layer=Gate_1 $thickness=5.6e-08
+ $X=0.189 $Y=0.1345 $X2=0.189 $Y2=0.1675
r9 30 29 16.4967 $w=2.1e-08 $l=4.85e-08 $layer=Gate_1 $thickness=5.6e-08
+ $X=0.135 $Y=0.2025 $X2=0.135 $Y2=0.154
r10 27 28 16.3266 $w=2.1e-08 $l=4.8e-08 $layer=Gate_1 $thickness=5.6e-08
+ $X=0.135 $Y=0.0675 $X2=0.135 $Y2=0.1155
r11 4 20 6.4735 $w=2.13953e-08 $layer=Gate_1 $thickness=5.22791e-08 $X=0.135
+ $Y=0.1345 $X2=0.135 $Y2=0.1345
r12 4 28 6.6582 $w=2.03947e-08 $l=1.9e-08 $layer=Gate_1 $thickness=5.6e-08
+ $X=0.135 $Y=0.1345 $X2=0.135 $Y2=0.1155
r13 4 29 6.82827 $w=2.04103e-08 $l=1.95e-08 $layer=Gate_1 $thickness=5.6e-08
+ $X=0.135 $Y=0.1345 $X2=0.135 $Y2=0.154
r14 24 9 5.01358 $w=1.3e-08 $l=2.15e-08 $layer=M1 $thickness=3.6e-08 $X=0.07
+ $Y=0.136 $X2=0.0485 $Y2=0.135
r15 21 22 10.1596 $w=1.87815e-08 $l=2.7e-08 $layer=LIG $thickness=4.8e-08
+ $X=0.162 $Y=0.1345 $X2=0.189 $Y2=0.1345
r16 20 21 10.1596 $w=1.87815e-08 $l=2.7e-08 $layer=LIG $thickness=4.8e-08
+ $X=0.135 $Y=0.1345 $X2=0.162 $Y2=0.1345
r17 19 20 10.1596 $w=1.87815e-08 $l=2.7e-08 $layer=LIG $thickness=4.8e-08
+ $X=0.108 $Y=0.1345 $X2=0.135 $Y2=0.1345
r18 24 18 19.3796 $a=3.24e-16 $layer=V0LIG $X=0.07 $Y=0.136 $X2=0.066 $Y2=0.1345
r19 16 19 9.21311 $w=1.80478e-08 $l=2.3e-08 $layer=LIG $thickness=4.8e-08
+ $X=0.085 $Y=0.1345 $X2=0.108 $Y2=0.1345
r20 1 16 2.36633 $w=2.3e-08 $l=1e-08 $layer=LIG $thickness=4.8e-08 $X=0.075
+ $Y=0.1345 $X2=0.085 $Y2=0.1345
r21 1 18 3.23868 $w=1.92778e-08 $l=9e-09 $layer=LIG $thickness=4.8e-08 $X=0.075
+ $Y=0.1345 $X2=0.066 $Y2=0.1345
r22 13 16 5.52696 $w=2.10286e-08 $l=4e-09 $layer=Gate_1 $thickness=5.32571e-08
+ $X=0.081 $Y=0.1345 $X2=0.085 $Y2=0.1345
r23 12 13 5.80786 $w=2.0303e-08 $l=1.65e-08 $layer=Gate_1 $thickness=5.6e-08
+ $X=0.081 $Y=0.118 $X2=0.081 $Y2=0.1345
r24 11 12 2.55104 $w=2.1e-08 $l=7.5e-09 $layer=Gate_1 $thickness=5.6e-08
+ $X=0.081 $Y=0.1105 $X2=0.081 $Y2=0.118
r25 10 11 14.6259 $w=2.1e-08 $l=4.3e-08 $layer=Gate_1 $thickness=5.6e-08
+ $X=0.081 $Y=0.0675 $X2=0.081 $Y2=0.1105
r26 10 3 14.6259 $w=2.1e-08 $l=4.3e-08 $layer=Gate_1 $thickness=5.6e-08
+ $X=0.081 $Y=0.0675 $X2=0.081 $Y2=0.0245
.ends

.subckt PM_NAND2x1p5_ASAP7_75t_R%Y vss 38 28 29 42 54 57 58 60 18 1 19 16 25 5
+ 20 2 3 4 23 17 24
c1 1 vss 0.0073513f $X=0.108 $Y=0.2025
c2 2 vss 0.00768991f $X=0.216 $Y=0.216
c3 3 vss 0.00407332f $X=0.27 $Y=0.0675
c4 4 vss 0.00707091f $X=0.324 $Y=0.2025
c5 5 vss 0.00576959f $X=0.378 $Y=0.0675
c6 16 vss 0.00203921f $X=0.2555 $Y=0.0675
c7 17 vss 0.0357255f $X=0.3635 $Y=0.0675
c8 18 vss 0.0034418f $X=0.11 $Y=0.2025
c9 19 vss 0.0038295f $X=0.2015 $Y=0.216
c10 20 vss 0.00342255f $X=0.3095 $Y=0.2025
c11 21 vss 0.00264451f $X=0.405 $Y=0.036
c12 22 vss 0.00278695f $X=0.405 $Y=0.234
c13 23 vss 0.025964f $X=0.367 $Y=0.234
c14 24 vss 0.0102623f $X=0.27 $Y=0.036
c15 25 vss 0.00524454f $X=0.405 $Y=0.054
r1 60 59 0.0308642 $w=8.1e-08 $l=2.5e-09 $layer=P_src_drn $thickness=1e-09
+ $X=0.1253 $Y=0.2025 $X2=0.1225 $Y2=0.2025
r2 18 59 0.154321 $w=8.1e-08 $l=1.25e-08 $layer=P_src_drn $thickness=1e-09
+ $X=0.11 $Y=0.2025 $X2=0.1225 $Y2=0.2025
r3 58 56 0.0462963 $w=5.4e-08 $l=2.5e-09 $layer=P_src_drn $thickness=1e-09
+ $X=0.2333 $Y=0.216 $X2=0.2305 $Y2=0.216
r4 2 56 0.268519 $w=5.4e-08 $l=1.45e-08 $layer=P_src_drn $thickness=1e-09
+ $X=0.216 $Y=0.216 $X2=0.2305 $Y2=0.216
r5 19 2 0.268519 $w=5.4e-08 $l=1.45e-08 $layer=P_src_drn $thickness=1e-09
+ $X=0.2015 $Y=0.216 $X2=0.216 $Y2=0.216
r6 57 19 0.0462963 $w=5.4e-08 $l=2.5e-09 $layer=P_src_drn $thickness=1e-09
+ $X=0.1986 $Y=0.216 $X2=0.2015 $Y2=0.216
r7 20 4 0.154321 $w=8.1e-08 $l=1.25e-08 $layer=P_src_drn $thickness=1e-09
+ $X=0.3095 $Y=0.2025 $X2=0.324 $Y2=0.2025
r8 54 20 0.0308642 $w=8.1e-08 $l=2.5e-09 $layer=P_src_drn $thickness=1e-09
+ $X=0.3066 $Y=0.2025 $X2=0.3095 $Y2=0.2025
r9 1 51 19.3796 $a=3.24e-16 $layer=V0LISD $X=0.108 $Y=0.2025 $X2=0.108 $Y2=0.234
r10 2 47 19.3796 $a=3.24e-16 $layer=V0LISD $X=0.216 $Y=0.216 $X2=0.216 $Y2=0.234
r11 4 44 19.3796 $a=3.24e-16 $layer=V0LISD $X=0.324 $Y=0.2025 $X2=0.324
+ $Y2=0.234
r12 51 52 3.14806 $w=1.3e-08 $l=1.35e-08 $layer=M1 $thickness=3.6e-08 $X=0.108
+ $Y=0.234 $X2=0.1215 $Y2=0.234
r13 49 52 3.14806 $w=1.3e-08 $l=1.35e-08 $layer=M1 $thickness=3.6e-08 $X=0.135
+ $Y=0.234 $X2=0.1215 $Y2=0.234
r14 47 48 5.82974 $w=1.3e-08 $l=2.5e-08 $layer=M1 $thickness=3.6e-08 $X=0.216
+ $Y=0.234 $X2=0.241 $Y2=0.234
r15 46 47 9.44419 $w=1.3e-08 $l=4.05e-08 $layer=M1 $thickness=3.6e-08 $X=0.1755
+ $Y=0.234 $X2=0.216 $Y2=0.234
r16 46 49 9.44419 $w=1.3e-08 $l=4.05e-08 $layer=M1 $thickness=3.6e-08 $X=0.1755
+ $Y=0.234 $X2=0.135 $Y2=0.234
r17 44 45 2.68168 $w=1.3e-08 $l=1.15e-08 $layer=M1 $thickness=3.6e-08 $X=0.324
+ $Y=0.234 $X2=0.3355 $Y2=0.234
r18 43 44 8.86121 $w=1.3e-08 $l=3.8e-08 $layer=M1 $thickness=3.6e-08 $X=0.286
+ $Y=0.234 $X2=0.324 $Y2=0.234
r19 43 48 10.4935 $w=1.3e-08 $l=4.5e-08 $layer=M1 $thickness=3.6e-08 $X=0.286
+ $Y=0.234 $X2=0.241 $Y2=0.234
r20 23 45 7.34548 $w=1.3e-08 $l=3.15e-08 $layer=M1 $thickness=3.6e-08 $X=0.367
+ $Y=0.234 $X2=0.3355 $Y2=0.234
r21 22 40 3.36447 $w=1.71023e-08 $l=2.15e-08 $layer=M1 $thickness=3.6e-08
+ $X=0.405 $Y=0.234 $X2=0.405 $Y2=0.2125
r22 22 23 7.2121 $w=1.41842e-08 $l=3.8e-08 $layer=M1 $thickness=3.6e-08
+ $X=0.405 $Y=0.234 $X2=0.367 $Y2=0.234
r23 17 5 0.154321 $w=8.1e-08 $l=1.25e-08 $layer=N_src_drn $thickness=1e-09
+ $X=0.3635 $Y=0.0675 $X2=0.378 $Y2=0.0675
r24 42 17 0.0308642 $w=8.1e-08 $l=2.5e-09 $layer=N_src_drn $thickness=1e-09
+ $X=0.3606 $Y=0.0675 $X2=0.3635 $Y2=0.0675
r25 39 40 9.26929 $w=1.3e-08 $l=3.98e-08 $layer=M1 $thickness=3.6e-08 $X=0.405
+ $Y=0.1727 $X2=0.405 $Y2=0.2125
r26 38 39 6.47102 $w=1.3e-08 $l=2.77e-08 $layer=M1 $thickness=3.6e-08 $X=0.405
+ $Y=0.145 $X2=0.405 $Y2=0.1727
r27 38 37 0.174892 $w=1.3e-08 $l=8e-10 $layer=M1 $thickness=3.6e-08 $X=0.405
+ $Y=0.145 $X2=0.405 $Y2=0.1442
r28 36 37 2.15701 $w=1.3e-08 $l=9.2e-09 $layer=M1 $thickness=3.6e-08 $X=0.405
+ $Y=0.135 $X2=0.405 $Y2=0.1442
r29 35 36 7.34548 $w=1.3e-08 $l=3.15e-08 $layer=M1 $thickness=3.6e-08 $X=0.405
+ $Y=0.1035 $X2=0.405 $Y2=0.135
r30 34 35 7.34548 $w=1.3e-08 $l=3.15e-08 $layer=M1 $thickness=3.6e-08 $X=0.405
+ $Y=0.072 $X2=0.405 $Y2=0.1035
r31 25 34 4.19742 $w=1.3e-08 $l=1.8e-08 $layer=M1 $thickness=3.6e-08 $X=0.405
+ $Y=0.054 $X2=0.405 $Y2=0.072
r32 5 32 19.3796 $a=3.24e-16 $layer=V0LISD $X=0.378 $Y=0.0675 $X2=0.378
+ $Y2=0.036
r33 21 33 1.49895 $w=1.63333e-08 $l=1.35e-08 $layer=M1 $thickness=3.6e-08
+ $X=0.405 $Y=0.036 $X2=0.3915 $Y2=0.036
r34 21 25 2.5483 $w=1.79e-08 $l=1.8e-08 $layer=M1 $thickness=3.6e-08 $X=0.405
+ $Y=0.036 $X2=0.405 $Y2=0.054
r35 32 33 3.14806 $w=1.3e-08 $l=1.35e-08 $layer=M1 $thickness=3.6e-08 $X=0.378
+ $Y=0.036 $X2=0.3915 $Y2=0.036
r36 31 32 5.71315 $w=1.3e-08 $l=2.45e-08 $layer=M1 $thickness=3.6e-08 $X=0.3535
+ $Y=0.036 $X2=0.378 $Y2=0.036
r37 30 31 10.4935 $w=1.3e-08 $l=4.5e-08 $layer=M1 $thickness=3.6e-08 $X=0.3085
+ $Y=0.036 $X2=0.3535 $Y2=0.036
r38 24 30 8.97781 $w=1.3e-08 $l=3.85e-08 $layer=M1 $thickness=3.6e-08 $X=0.27
+ $Y=0.036 $X2=0.3085 $Y2=0.036
r39 3 24 19.3796 $a=3.24e-16 $layer=V0LISD $X=0.27 $Y=0.0675 $X2=0.27 $Y2=0.036
r40 29 27 0.0308642 $w=8.1e-08 $l=2.5e-09 $layer=N_src_drn $thickness=1e-09
+ $X=0.2873 $Y=0.0675 $X2=0.2845 $Y2=0.0675
r41 3 27 0.179012 $w=8.1e-08 $l=1.45e-08 $layer=N_src_drn $thickness=1e-09
+ $X=0.27 $Y=0.0675 $X2=0.2845 $Y2=0.0675
r42 16 3 0.179012 $w=8.1e-08 $l=1.45e-08 $layer=N_src_drn $thickness=1e-09
+ $X=0.2555 $Y=0.0675 $X2=0.27 $Y2=0.0675
r43 28 16 0.0308642 $w=8.1e-08 $l=2.5e-09 $layer=N_src_drn $thickness=1e-09
+ $X=0.2526 $Y=0.0675 $X2=0.2555 $Y2=0.0675
r44 1 18 1e-05 $l=2e-09 $X=0.108 $Y=0.2025 $X2=0.11 $Y2=0.2025
.ends

.subckt PM_NAND2x1p5_ASAP7_75t_R%B vss 39 10 14 28 31 35 9 7 8 6 3 4 5 1
c1 1 vss 0.0176149f $X=0.2335 $Y=0.135
c2 3 vss 0.0507394f $X=0.243 $Y=0.0245
c3 4 vss 0.0736799f $X=0.297 $Y=0.135
c4 5 vss 0.0230932f $X=0.351 $Y=0.135
c5 6 vss 0.00598736f $X=0.135 $Y=0.1307
c6 7 vss 0.00750506f $X=0.135 $Y=0.1035
c7 8 vss 0.00747849f $X=0.135 $Y=0.172
c8 9 vss 0.00811505f $X=0.218 $Y=0.135
r1 8 40 6.91198 $w=1.35906e-08 $l=3.18e-08 $layer=M1 $thickness=3.6e-08
+ $X=0.135 $Y=0.172 $X2=0.135 $Y2=0.1402
r2 39 40 0.433689 $w=1.8e-08 $l=4.2e-09 $layer=M1 $thickness=3.6e-08 $X=0.135
+ $Y=0.136 $X2=0.135 $Y2=0.1402
r3 39 6 0.535733 $w=1.8e-08 $l=5.3e-09 $layer=M1 $thickness=3.6e-08 $X=0.135
+ $Y=0.136 $X2=0.135 $Y2=0.1307
r4 6 7 5.73148 $w=1.38716e-08 $l=2.72e-08 $layer=M1 $thickness=3.6e-08 $X=0.135
+ $Y=0.1307 $X2=0.135 $Y2=0.1035
r5 35 36 14.6259 $w=2.1e-08 $l=4.3e-08 $layer=Gate_1 $thickness=5.6e-08
+ $X=0.351 $Y=0.0675 $X2=0.351 $Y2=0.1105
r6 33 36 2.7211 $w=2.1e-08 $l=8e-09 $layer=Gate_1 $thickness=5.6e-08 $X=0.351
+ $Y=0.1185 $X2=0.351 $Y2=0.1105
r7 5 22 6.54019 $w=2.09524e-08 $layer=Gate_1 $thickness=5.21905e-08 $X=0.351
+ $Y=0.135 $X2=0.351 $Y2=0.135
r8 5 33 5.79936 $w=2.03333e-08 $l=1.65e-08 $layer=Gate_1 $thickness=5.6e-08
+ $X=0.351 $Y=0.135 $X2=0.351 $Y2=0.1185
r9 31 30 16.4967 $w=2.1e-08 $l=4.85e-08 $layer=Gate_1 $thickness=5.6e-08
+ $X=0.297 $Y=0.2025 $X2=0.297 $Y2=0.154
r10 28 29 16.4967 $w=2.1e-08 $l=4.85e-08 $layer=Gate_1 $thickness=5.6e-08
+ $X=0.297 $Y=0.0675 $X2=0.297 $Y2=0.116
r11 4 20 6.54019 $w=2.09524e-08 $layer=Gate_1 $thickness=5.21905e-08 $X=0.297
+ $Y=0.135 $X2=0.297 $Y2=0.135
r12 4 29 6.6497 $w=2.04211e-08 $l=1.9e-08 $layer=Gate_1 $thickness=5.6e-08
+ $X=0.297 $Y=0.135 $X2=0.297 $Y2=0.116
r13 4 30 6.6497 $w=2.04211e-08 $l=1.9e-08 $layer=Gate_1 $thickness=5.6e-08
+ $X=0.297 $Y=0.135 $X2=0.297 $Y2=0.154
r14 39 26 6.81353 $w=1.01579e-08 $l=3.80132e-08 $layer=M1 $thickness=3.6e-08
+ $X=0.135 $Y=0.136 $X2=0.173 $Y2=0.135
r15 9 24 5.82974 $w=1.3e-08 $l=2.5e-08 $layer=M1 $thickness=3.6e-08 $X=0.218
+ $Y=0.135 $X2=0.243 $Y2=0.135
r16 9 26 10.4935 $w=1.3e-08 $l=4.5e-08 $layer=M1 $thickness=3.6e-08 $X=0.218
+ $Y=0.135 $X2=0.173 $Y2=0.135
r17 21 22 12.6539 $w=1.77815e-08 $l=2.7e-08 $layer=LIG $thickness=4.8e-08
+ $X=0.324 $Y=0.135 $X2=0.351 $Y2=0.135
r18 20 21 12.6539 $w=1.77815e-08 $l=2.7e-08 $layer=LIG $thickness=4.8e-08
+ $X=0.297 $Y=0.135 $X2=0.324 $Y2=0.135
r19 19 20 12.6539 $w=1.77815e-08 $l=2.7e-08 $layer=LIG $thickness=4.8e-08
+ $X=0.27 $Y=0.135 $X2=0.297 $Y2=0.135
r20 17 19 10.1729 $w=1.54914e-08 $l=1.75e-08 $layer=LIG $thickness=4.8e-08
+ $X=0.2525 $Y=0.135 $X2=0.27 $Y2=0.135
r21 16 17 2.48102 $w=2.2e-08 $l=9.5e-09 $layer=LIG $thickness=4.8e-08 $X=0.243
+ $Y=0.135 $X2=0.2525 $Y2=0.135
r22 16 24 19.3796 $a=3.24e-16 $layer=V0LIG $X=0.243 $Y=0.135 $X2=0.243 $Y2=0.135
r23 1 16 2.48102 $w=2.2e-08 $l=9.5e-09 $layer=LIG $thickness=4.8e-08 $X=0.2335
+ $Y=0.135 $X2=0.243 $Y2=0.135
r24 14 13 16.4967 $w=2.1e-08 $l=4.85e-08 $layer=Gate_1 $thickness=5.6e-08
+ $X=0.243 $Y=0.216 $X2=0.243 $Y2=0.1675
r25 12 13 11.2416 $w=2.06615e-08 $l=3.25e-08 $layer=Gate_1 $thickness=5.6e-08
+ $X=0.243 $Y=0.135 $X2=0.243 $Y2=0.1675
r26 12 17 4.05918 $w=2.0087e-08 $l=9.5e-09 $layer=Gate_1 $thickness=5.56522e-08
+ $X=0.243 $Y=0.135 $X2=0.2525 $Y2=0.135
r27 12 16 6.27904 $w=2.09e-08 $layer=Gate_1 $thickness=5.24e-08 $X=0.243
+ $Y=0.135 $X2=0.243 $Y2=0.135
r28 11 12 6.6497 $w=2.04211e-08 $l=1.9e-08 $layer=Gate_1 $thickness=5.6e-08
+ $X=0.243 $Y=0.116 $X2=0.243 $Y2=0.135
r29 10 11 16.4967 $w=2.1e-08 $l=4.85e-08 $layer=Gate_1 $thickness=5.6e-08
+ $X=0.243 $Y=0.0675 $X2=0.243 $Y2=0.116
r30 10 3 14.6259 $w=2.1e-08 $l=4.3e-08 $layer=Gate_1 $thickness=5.6e-08
+ $X=0.243 $Y=0.0675 $X2=0.243 $Y2=0.0245
.ends

.subckt PM_NAND2x1p5_ASAP7_75t_R%5 vss 18 19 34 35 38 39 11 1 12 13 14 3 15 2
c1 1 vss 0.00859461f $X=0.108 $Y=0.0675
c2 2 vss 0.00641715f $X=0.216 $Y=0.0675
c3 3 vss 0.00265308f $X=0.324 $Y=0.0675
c4 11 vss 0.00426638f $X=0.0935 $Y=0.0675
c5 12 vss 0.00304502f $X=0.2015 $Y=0.0675
c6 13 vss 0.00186219f $X=0.3095 $Y=0.0675
c7 14 vss 0.0119428f $X=0.0965 $Y=0.036
c8 15 vss 0.00169651f $X=0.2045 $Y=0.072
r1 39 37 0.0308642 $w=8.1e-08 $l=2.5e-09 $layer=N_src_drn $thickness=1e-09
+ $X=0.3413 $Y=0.0675 $X2=0.3385 $Y2=0.0675
r2 3 37 0.179012 $w=8.1e-08 $l=1.45e-08 $layer=N_src_drn $thickness=1e-09
+ $X=0.324 $Y=0.0675 $X2=0.3385 $Y2=0.0675
r3 13 3 0.179012 $w=8.1e-08 $l=1.45e-08 $layer=N_src_drn $thickness=1e-09
+ $X=0.3095 $Y=0.0675 $X2=0.324 $Y2=0.0675
r4 38 13 0.0308642 $w=8.1e-08 $l=2.5e-09 $layer=N_src_drn $thickness=1e-09
+ $X=0.3066 $Y=0.0675 $X2=0.3095 $Y2=0.0675
r5 3 30 19.3796 $a=3.24e-16 $layer=V0LISD $X=0.324 $Y=0.0675 $X2=0.324 $Y2=0.072
r6 35 33 0.0308642 $w=8.1e-08 $l=2.5e-09 $layer=N_src_drn $thickness=1e-09
+ $X=0.2333 $Y=0.0675 $X2=0.2305 $Y2=0.0675
r7 2 33 0.179012 $w=8.1e-08 $l=1.45e-08 $layer=N_src_drn $thickness=1e-09
+ $X=0.216 $Y=0.0675 $X2=0.2305 $Y2=0.0675
r8 12 2 0.179012 $w=8.1e-08 $l=1.45e-08 $layer=N_src_drn $thickness=1e-09
+ $X=0.2015 $Y=0.0675 $X2=0.216 $Y2=0.0675
r9 34 12 0.0308642 $w=8.1e-08 $l=2.5e-09 $layer=N_src_drn $thickness=1e-09
+ $X=0.1986 $Y=0.0675 $X2=0.2015 $Y2=0.0675
r10 29 30 8.39483 $w=1.3e-08 $l=3.6e-08 $layer=M1 $thickness=3.6e-08 $X=0.288
+ $Y=0.072 $X2=0.324 $Y2=0.072
r11 28 29 6.7625 $w=1.3e-08 $l=2.9e-08 $layer=M1 $thickness=3.6e-08 $X=0.259
+ $Y=0.072 $X2=0.288 $Y2=0.072
r12 27 28 4.19742 $w=1.3e-08 $l=1.8e-08 $layer=M1 $thickness=3.6e-08 $X=0.241
+ $Y=0.072 $X2=0.259 $Y2=0.072
r13 26 27 5.82974 $w=1.3e-08 $l=2.5e-08 $layer=M1 $thickness=3.6e-08 $X=0.216
+ $Y=0.072 $X2=0.241 $Y2=0.072
r14 15 26 2.68168 $w=1.3e-08 $l=1.15e-08 $layer=M1 $thickness=3.6e-08 $X=0.2045
+ $Y=0.072 $X2=0.216 $Y2=0.072
r15 2 25 19.3796 $a=3.24e-16 $layer=V0LISD $X=0.216 $Y=0.0675 $X2=0.216
+ $Y2=0.036
r16 2 26 19.3796 $a=3.24e-16 $layer=V0LISD $X=0.216 $Y=0.0675 $X2=0.216
+ $Y2=0.072
r17 24 25 2.68168 $w=1.3e-08 $l=1.15e-08 $layer=M1 $thickness=3.6e-08 $X=0.2045
+ $Y=0.036 $X2=0.216 $Y2=0.036
r18 23 24 7.34548 $w=1.3e-08 $l=3.15e-08 $layer=M1 $thickness=3.6e-08 $X=0.173
+ $Y=0.036 $X2=0.2045 $Y2=0.036
r19 22 23 8.86121 $w=1.3e-08 $l=3.8e-08 $layer=M1 $thickness=3.6e-08 $X=0.135
+ $Y=0.036 $X2=0.173 $Y2=0.036
r20 21 22 3.14806 $w=1.3e-08 $l=1.35e-08 $layer=M1 $thickness=3.6e-08 $X=0.1215
+ $Y=0.036 $X2=0.135 $Y2=0.036
r21 20 21 3.14806 $w=1.3e-08 $l=1.35e-08 $layer=M1 $thickness=3.6e-08 $X=0.108
+ $Y=0.036 $X2=0.1215 $Y2=0.036
r22 14 20 2.68168 $w=1.3e-08 $l=1.15e-08 $layer=M1 $thickness=3.6e-08 $X=0.0965
+ $Y=0.036 $X2=0.108 $Y2=0.036
r23 1 20 19.3796 $a=3.24e-16 $layer=V0LISD $X=0.108 $Y=0.0675 $X2=0.108
+ $Y2=0.036
r24 19 17 0.0308642 $w=8.1e-08 $l=2.5e-09 $layer=N_src_drn $thickness=1e-09
+ $X=0.1253 $Y=0.0675 $X2=0.1225 $Y2=0.0675
r25 1 17 0.179012 $w=8.1e-08 $l=1.45e-08 $layer=N_src_drn $thickness=1e-09
+ $X=0.108 $Y=0.0675 $X2=0.1225 $Y2=0.0675
r26 11 1 0.179012 $w=8.1e-08 $l=1.45e-08 $layer=N_src_drn $thickness=1e-09
+ $X=0.0935 $Y=0.0675 $X2=0.108 $Y2=0.0675
r27 18 11 0.0308642 $w=8.1e-08 $l=2.5e-09 $layer=N_src_drn $thickness=1e-09
+ $X=0.0906 $Y=0.0675 $X2=0.0935 $Y2=0.0675
.ends

* End of included file NAND2x1p5_ASAP7_75t_R.pex.sp.pex

*
.subckt NAND2x1p5_ASAP7_75t_CUSTOM_4_25_0_7 VSS VDD A B Y
*
* VSS VSS
* VDD VDD
* A A
* B B
* Y Y
*
*

M0 N_M0_d N_M0_g VSS VSS nmos_rvt L=2e-08 W=8.1e-08 nfin=3 $X=0.071 $Y=0.027
M1 N_M1_d N_M1_g VSS VSS nmos_rvt L=2e-08 W=8.1e-08 nfin=3 $X=0.125 $Y=0.027
M2 N_M2_d N_M2_g VSS VSS nmos_rvt L=2e-08 W=8.1e-08 nfin=3 $X=0.179 $Y=0.027
M3 N_M3_d N_M3_g N_M3_s VSS nmos_rvt L=2e-08 W=8.1e-08 nfin=3 $X=0.233 $Y=0.027
M4 N_M4_d N_M4_g N_M4_s VSS nmos_rvt L=2e-08 W=8.1e-08 nfin=3 $X=0.287 $Y=0.027
M5 N_M5_d N_M5_g N_M5_s VSS nmos_rvt L=2e-08 W=8.1e-08 nfin=3 $X=0.341 $Y=0.027
M6 VDD N_M6_g N_M6_s VDD pmos_rvt L=2e-08 W=8.1e-08 nfin=3 $X=0.125 $Y=0.162
M7 VDD N_M7_g N_M7_s VDD pmos_rvt L=2e-08 W=5.4e-08 nfin=2 $X=0.179 $Y=0.189
M8 VDD N_M8_g N_M8_s VDD pmos_rvt L=2e-08 W=5.4e-08 nfin=2 $X=0.233 $Y=0.189
M9 VDD N_M9_g N_M9_s VDD pmos_rvt L=2e-08 W=8.1e-08 nfin=3 $X=0.287 $Y=0.162

* .include "NAND2x1p5_ASAP7_75t_R.pex.sp.pxi"

* Start of included file NAND2x1p5_ASAP7_75t_R.pex.sp.pxi
x_PM_NAND2x1p5_ASAP7_75t_R%A vss A N_M0_g N_M1_g N_M6_g N_M2_g N_M7_g N_A_1
+ N_A_9 N_A_5 N_A_3 N_A_4 N_A_8 PM_NAND2x1p5_ASAP7_75t_R%A
x_PM_NAND2x1p5_ASAP7_75t_R%Y vss Y N_M3_d N_M4_d N_M5_d N_M9_s N_M7_s N_M8_s
+ N_M6_s N_Y_18 N_Y_1 N_Y_19 N_Y_16 N_Y_25 N_Y_5 N_Y_20 N_Y_2 N_Y_3 N_Y_4
+ N_Y_23 N_Y_17 N_Y_24 PM_NAND2x1p5_ASAP7_75t_R%Y
cc_1 N_Y_18 N_A_5 0.000542338f $X=0.11 $Y=0.2025
cc_2 N_Y_18 N_A_8 0.000619881f $X=0.11 $Y=0.2025
cc_3 N_Y_1 N_A_4 0.00226644f $X=0.108 $Y=0.2025
cc_4 N_Y_18 N_A_1 0.0028111f $X=0.11 $Y=0.2025
cc_5 N_Y_19 N_A_5 0.0237867f $X=0.2015 $Y=0.216
cc_6 N_Y_18 N_A_3 0.0188376f $X=0.11 $Y=0.2025
cc_7 N_Y_18 N_A_4 0.0528171f $X=0.11 $Y=0.2025
cc_8 N_Y_16 N_B_1 0.000461143f $X=0.2555 $Y=0.0675
cc_9 N_Y_16 N_B_3 0.032505f $X=0.2555 $Y=0.0675
cc_10 N_Y_25 N_B_1 0.000684633f $X=0.405 $Y=0.054
cc_11 N_Y_5 N_B_5 0.000742597f $X=0.378 $Y=0.0675
cc_12 N_Y_20 N_B_4 0.0115985f $X=0.3095 $Y=0.2025
cc_13 N_Y_2 N_B_9 0.00120683f $X=0.216 $Y=0.216
cc_14 N_Y_3 N_B_4 0.00164965f $X=0.27 $Y=0.0675
cc_15 N_Y_4 N_B_4 0.00198639f $X=0.324 $Y=0.2025
cc_16 N_Y_23 N_B_9 0.00222813f $X=0.367 $Y=0.234
cc_17 N_Y_1 N_B_8 0.00242985f $X=0.108 $Y=0.2025
cc_18 N_Y_19 N_B_3 0.0101945f $X=0.2015 $Y=0.216
cc_19 N_Y_20 N_B_1 0.00679718f $X=0.3095 $Y=0.2025
cc_20 N_Y_17 N_B_5 0.0522243f $X=0.3635 $Y=0.0675
cc_21 N_Y_20 N_B_5 0.0205898f $X=0.3095 $Y=0.2025
cc_22 N_Y_16 N_B_4 0.0696729f $X=0.2555 $Y=0.0675
cc_23 N_Y_25 N_5_15 0.000571348f $X=0.405 $Y=0.054
cc_24 N_Y_3 N_5_15 0.000936677f $X=0.27 $Y=0.0675
cc_25 N_Y_16 N_5_13 0.00214602f $X=0.2555 $Y=0.0675
cc_26 N_Y_3 N_5_2 0.00389009f $X=0.27 $Y=0.0675
cc_27 N_Y_5 N_5_3 0.00396775f $X=0.378 $Y=0.0675
cc_28 N_Y_24 N_5_15 0.0117955f $X=0.27 $Y=0.036
x_PM_NAND2x1p5_ASAP7_75t_R%B vss B N_M3_g N_M8_g N_M4_g N_M9_g N_M5_g N_B_9
+ N_B_7 N_B_8 N_B_6 N_B_3 N_B_4 N_B_5 N_B_1 PM_NAND2x1p5_ASAP7_75t_R%B
cc_29 N_B_9 N_A_1 0.000887526f $X=0.218 $Y=0.135
cc_30 N_B_7 N_A_1 0.000890727f $X=0.135 $Y=0.1035
cc_31 N_B_8 N_A_1 0.000913063f $X=0.135 $Y=0.172
cc_32 N_B_6 N_A_9 0.00101666f $X=0.135 $Y=0.1307
cc_33 N_B_6 N_A_1 0.00287571f $X=0.135 $Y=0.1307
cc_34 N_B_3 N_A_5 0.00712531f $X=0.243 $Y=0.0245
x_PM_NAND2x1p5_ASAP7_75t_R%5 vss N_M0_d N_M1_d N_M2_d N_M3_s N_M4_s N_M5_s
+ N_5_11 N_5_1 N_5_12 N_5_13 N_5_14 N_5_3 N_5_15 N_5_2
+ PM_NAND2x1p5_ASAP7_75t_R%5
cc_35 N_5_11 N_A_5 0.0010262f $X=0.0935 $Y=0.0675
cc_36 N_5_1 N_A_3 0.00174165f $X=0.108 $Y=0.0675
cc_37 N_5_11 N_A_1 0.0031568f $X=0.0935 $Y=0.0675
cc_38 N_5_12 N_A_5 0.0319766f $X=0.2015 $Y=0.0675
cc_39 N_5_11 N_A_3 0.035421f $X=0.0935 $Y=0.0675
cc_40 N_5_11 N_A_4 0.0308164f $X=0.0935 $Y=0.0675
cc_41 N_5_13 N_B_4 0.0371283f $X=0.3095 $Y=0.0675
cc_42 N_5_13 N_B_3 0.000953116f $X=0.3095 $Y=0.0675
cc_43 N_5_14 N_B_7 0.00124299f $X=0.0965 $Y=0.036
cc_44 N_5_3 N_B_5 0.00149622f $X=0.324 $Y=0.0675
cc_45 N_5_1 N_B_7 0.00234414f $X=0.108 $Y=0.0675
cc_46 N_5_13 N_B_1 0.00311421f $X=0.3095 $Y=0.0675
cc_47 N_5_15 N_B_9 0.00322421f $X=0.2045 $Y=0.072
cc_48 N_5_12 N_B_3 0.0320431f $X=0.2015 $Y=0.0675
cc_49 N_5_13 N_B_5 0.0293643f $X=0.3095 $Y=0.0675

* End of included file NAND2x1p5_ASAP7_75t_R.pex.sp.pxi
.ends

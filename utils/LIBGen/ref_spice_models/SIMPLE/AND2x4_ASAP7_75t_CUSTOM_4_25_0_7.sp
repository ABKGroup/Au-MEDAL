.subckt PM_AND2x4_ASAP7_75t_R%7__2 vss 2 3 1
c1 1 vss 0.000802927f $X=0.108 $Y=0.0675
r1 2 1 0.209877 $w=8.1e-08 $l=1.7e-08 $layer=N_src_drn $thickness=1e-09
+ $X=0.0906 $Y=0.0675 $X2=0.108 $Y2=0.0675
r2 3 1 0.209877 $w=8.1e-08 $l=1.7e-08 $layer=N_src_drn $thickness=1e-09
+ $X=0.1253 $Y=0.0675 $X2=0.108 $Y2=0.0675
.ends

.subckt PM_AND2x4_ASAP7_75t_R%8 vss 2 3 1
c1 1 vss 0.000749489f $X=0.216 $Y=0.0675
r1 2 1 0.209877 $w=8.1e-08 $l=1.7e-08 $layer=N_src_drn $thickness=1e-09
+ $X=0.1986 $Y=0.0675 $X2=0.216 $Y2=0.0675
r2 3 1 0.209877 $w=8.1e-08 $l=1.7e-08 $layer=N_src_drn $thickness=1e-09
+ $X=0.2333 $Y=0.0675 $X2=0.216 $Y2=0.0675
.ends

.subckt PM_AND2x4_ASAP7_75t_R%Y vss 31 24 25 36 37 44 45 48 49 15 4 1 20 2 14
+ 13 16
c1 1 vss 0.00888447f $X=0.324 $Y=0.0675
c2 2 vss 0.00838764f $X=0.324 $Y=0.2025
c3 3 vss 0.00834147f $X=0.432 $Y=0.0675
c4 4 vss 0.00834147f $X=0.432 $Y=0.2025
c5 13 vss 0.00433565f $X=0.3095 $Y=0.0675
c6 14 vss 0.00427831f $X=0.4175 $Y=0.0675
c7 15 vss 0.00432989f $X=0.3095 $Y=0.2025
c8 16 vss 0.00427716f $X=0.4175 $Y=0.2025
c9 17 vss 0.00300999f $X=0.459 $Y=0.036
c10 18 vss 0.00300999f $X=0.459 $Y=0.234
c11 19 vss 0.0138896f $X=0.3125 $Y=0.036
c12 20 vss 0.0126525f $X=0.3125 $Y=0.234
c13 21 vss 0.00794763f $X=0.459 $Y=0.083
r1 49 47 0.0308642 $w=8.1e-08 $l=2.5e-09 $layer=P_src_drn $thickness=1e-09
+ $X=0.4493 $Y=0.2025 $X2=0.4465 $Y2=0.2025
r2 4 47 0.179012 $w=8.1e-08 $l=1.45e-08 $layer=P_src_drn $thickness=1e-09
+ $X=0.432 $Y=0.2025 $X2=0.4465 $Y2=0.2025
r3 16 4 0.179012 $w=8.1e-08 $l=1.45e-08 $layer=P_src_drn $thickness=1e-09
+ $X=0.4175 $Y=0.2025 $X2=0.432 $Y2=0.2025
r4 48 16 0.0308642 $w=8.1e-08 $l=2.5e-09 $layer=P_src_drn $thickness=1e-09
+ $X=0.4146 $Y=0.2025 $X2=0.4175 $Y2=0.2025
r5 45 43 0.0308642 $w=8.1e-08 $l=2.5e-09 $layer=P_src_drn $thickness=1e-09
+ $X=0.3413 $Y=0.2025 $X2=0.3385 $Y2=0.2025
r6 2 43 0.179012 $w=8.1e-08 $l=1.45e-08 $layer=P_src_drn $thickness=1e-09
+ $X=0.324 $Y=0.2025 $X2=0.3385 $Y2=0.2025
r7 15 2 0.179012 $w=8.1e-08 $l=1.45e-08 $layer=P_src_drn $thickness=1e-09
+ $X=0.3095 $Y=0.2025 $X2=0.324 $Y2=0.2025
r8 44 15 0.0308642 $w=8.1e-08 $l=2.5e-09 $layer=P_src_drn $thickness=1e-09
+ $X=0.3066 $Y=0.2025 $X2=0.3095 $Y2=0.2025
r9 4 40 19.3796 $a=3.24e-16 $layer=V0LISD $X=0.432 $Y=0.2025 $X2=0.432 $Y2=0.234
r10 2 38 19.3796 $a=3.24e-16 $layer=V0LISD $X=0.324 $Y=0.2025 $X2=0.324
+ $Y2=0.234
r11 40 41 3.14806 $w=1.3e-08 $l=1.35e-08 $layer=M1 $thickness=3.6e-08 $X=0.432
+ $Y=0.234 $X2=0.4455 $Y2=0.234
r12 39 40 12.5922 $w=1.3e-08 $l=5.4e-08 $layer=M1 $thickness=3.6e-08 $X=0.378
+ $Y=0.234 $X2=0.432 $Y2=0.234
r13 38 39 12.5922 $w=1.3e-08 $l=5.4e-08 $layer=M1 $thickness=3.6e-08 $X=0.324
+ $Y=0.234 $X2=0.378 $Y2=0.234
r14 20 38 2.68168 $w=1.3e-08 $l=1.15e-08 $layer=M1 $thickness=3.6e-08 $X=0.3125
+ $Y=0.234 $X2=0.324 $Y2=0.234
r15 18 33 3.36447 $w=1.71023e-08 $l=2.15e-08 $layer=M1 $thickness=3.6e-08
+ $X=0.459 $Y=0.234 $X2=0.459 $Y2=0.2125
r16 18 41 1.49895 $w=1.63333e-08 $l=1.35e-08 $layer=M1 $thickness=3.6e-08
+ $X=0.459 $Y=0.234 $X2=0.4455 $Y2=0.234
r17 37 35 0.0308642 $w=8.1e-08 $l=2.5e-09 $layer=N_src_drn $thickness=1e-09
+ $X=0.4493 $Y=0.0675 $X2=0.4465 $Y2=0.0675
r18 3 35 0.179012 $w=8.1e-08 $l=1.45e-08 $layer=N_src_drn $thickness=1e-09
+ $X=0.432 $Y=0.0675 $X2=0.4465 $Y2=0.0675
r19 14 3 0.179012 $w=8.1e-08 $l=1.45e-08 $layer=N_src_drn $thickness=1e-09
+ $X=0.4175 $Y=0.0675 $X2=0.432 $Y2=0.0675
r20 36 14 0.0308642 $w=8.1e-08 $l=2.5e-09 $layer=N_src_drn $thickness=1e-09
+ $X=0.4146 $Y=0.0675 $X2=0.4175 $Y2=0.0675
r21 32 33 8.97781 $w=1.3e-08 $l=3.85e-08 $layer=M1 $thickness=3.6e-08 $X=0.459
+ $Y=0.174 $X2=0.459 $Y2=0.2125
r22 31 32 6.17953 $w=1.3e-08 $l=2.65e-08 $layer=M1 $thickness=3.6e-08 $X=0.4575
+ $Y=0.1475 $X2=0.459 $Y2=0.174
r23 31 30 3.14806 $w=1.3e-08 $l=1.35e-08 $layer=M1 $thickness=3.6e-08 $X=0.4575
+ $Y=0.1475 $X2=0.459 $Y2=0.134
r24 21 30 11.8927 $w=1.3e-08 $l=5.1e-08 $layer=M1 $thickness=3.6e-08 $X=0.459
+ $Y=0.083 $X2=0.459 $Y2=0.134
r25 3 28 19.3796 $a=3.24e-16 $layer=V0LISD $X=0.432 $Y=0.0675 $X2=0.432
+ $Y2=0.036
r26 17 29 1.49895 $w=1.63333e-08 $l=1.35e-08 $layer=M1 $thickness=3.6e-08
+ $X=0.459 $Y=0.036 $X2=0.4455 $Y2=0.036
r27 17 21 9.31081 $w=1.48766e-08 $l=4.7e-08 $layer=M1 $thickness=3.6e-08
+ $X=0.459 $Y=0.036 $X2=0.459 $Y2=0.083
r28 28 29 3.14806 $w=1.3e-08 $l=1.35e-08 $layer=M1 $thickness=3.6e-08 $X=0.432
+ $Y=0.036 $X2=0.4455 $Y2=0.036
r29 27 28 12.5922 $w=1.3e-08 $l=5.4e-08 $layer=M1 $thickness=3.6e-08 $X=0.378
+ $Y=0.036 $X2=0.432 $Y2=0.036
r30 26 27 12.5922 $w=1.3e-08 $l=5.4e-08 $layer=M1 $thickness=3.6e-08 $X=0.324
+ $Y=0.036 $X2=0.378 $Y2=0.036
r31 19 26 2.68168 $w=1.3e-08 $l=1.15e-08 $layer=M1 $thickness=3.6e-08 $X=0.3125
+ $Y=0.036 $X2=0.324 $Y2=0.036
r32 1 26 19.3796 $a=3.24e-16 $layer=V0LISD $X=0.324 $Y=0.0675 $X2=0.324
+ $Y2=0.036
r33 25 23 0.0308642 $w=8.1e-08 $l=2.5e-09 $layer=N_src_drn $thickness=1e-09
+ $X=0.3413 $Y=0.0675 $X2=0.3385 $Y2=0.0675
r34 1 23 0.179012 $w=8.1e-08 $l=1.45e-08 $layer=N_src_drn $thickness=1e-09
+ $X=0.324 $Y=0.0675 $X2=0.3385 $Y2=0.0675
r35 13 1 0.179012 $w=8.1e-08 $l=1.45e-08 $layer=N_src_drn $thickness=1e-09
+ $X=0.3095 $Y=0.0675 $X2=0.324 $Y2=0.0675
r36 24 13 0.0308642 $w=8.1e-08 $l=2.5e-09 $layer=N_src_drn $thickness=1e-09
+ $X=0.3066 $Y=0.0675 $X2=0.3095 $Y2=0.0675
.ends

.subckt PM_AND2x4_ASAP7_75t_R%5 vss 29 33 49 52 55 58 62 66 89 90 93 94 97 98 3
+ 16 18 17 5 1 4 23 27 28 20 24 25 12 19 14 13 22 15
c1 1 vss 0.0172903f $X=0.2875 $Y=0.135
c2 3 vss 0.00805097f $X=0.108 $Y=0.216
c3 4 vss 0.00377094f $X=0.162 $Y=0.0675
c4 5 vss 0.00769255f $X=0.216 $Y=0.216
c5 12 vss 0.0853715f $X=0.297 $Y=0.0245
c6 13 vss 0.0806004f $X=0.351 $Y=0.135
c7 14 vss 0.0811507f $X=0.405 $Y=0.135
c8 15 vss 0.0899152f $X=0.459 $Y=0.135
c9 16 vss 0.00864057f $X=0.1475 $Y=0.0675
c10 17 vss 0.00803374f $X=0.0935 $Y=0.216
c11 18 vss 0.00805576f $X=0.2015 $Y=0.216
c12 19 vss 0.000412505f $X=0.1885 $Y=0.191
c13 20 vss 0.000456287f $X=0.189 $Y=0.073
c14 21 vss 0.00633266f $X=0.189 $Y=0.234
c15 22 vss 0.00133922f $X=0.297 $Y=0.191
c16 23 vss 0.0112628f $X=0.1795 $Y=0.234
c17 24 vss 0.00236729f $X=0.1795 $Y=0.073
c18 25 vss 0.00309067f $X=0.189 $Y=0.166
c19 26 vss 0.000693055f $X=0.189 $Y=0.2125
c20 27 vss 0.00438957f $X=0.27 $Y=0.191
c21 28 vss 0.00327788f $X=0.297 $Y=0.1235
r1 98 96 0.0462963 $w=5.4e-08 $l=2.5e-09 $layer=P_src_drn $thickness=1e-09
+ $X=0.1253 $Y=0.216 $X2=0.1225 $Y2=0.216
r2 3 96 0.268519 $w=5.4e-08 $l=1.45e-08 $layer=P_src_drn $thickness=1e-09
+ $X=0.108 $Y=0.216 $X2=0.1225 $Y2=0.216
r3 17 3 0.268519 $w=5.4e-08 $l=1.45e-08 $layer=P_src_drn $thickness=1e-09
+ $X=0.0935 $Y=0.216 $X2=0.108 $Y2=0.216
r4 97 17 0.0462963 $w=5.4e-08 $l=2.5e-09 $layer=P_src_drn $thickness=1e-09
+ $X=0.0906 $Y=0.216 $X2=0.0935 $Y2=0.216
r5 94 92 0.0308642 $w=8.1e-08 $l=2.5e-09 $layer=N_src_drn $thickness=1e-09
+ $X=0.1793 $Y=0.0675 $X2=0.1765 $Y2=0.0675
r6 4 92 0.179012 $w=8.1e-08 $l=1.45e-08 $layer=N_src_drn $thickness=1e-09
+ $X=0.162 $Y=0.0675 $X2=0.1765 $Y2=0.0675
r7 16 4 0.179012 $w=8.1e-08 $l=1.45e-08 $layer=N_src_drn $thickness=1e-09
+ $X=0.1475 $Y=0.0675 $X2=0.162 $Y2=0.0675
r8 93 16 0.0308642 $w=8.1e-08 $l=2.5e-09 $layer=N_src_drn $thickness=1e-09
+ $X=0.1446 $Y=0.0675 $X2=0.1475 $Y2=0.0675
r9 90 88 0.0462963 $w=5.4e-08 $l=2.5e-09 $layer=P_src_drn $thickness=1e-09
+ $X=0.2333 $Y=0.216 $X2=0.2305 $Y2=0.216
r10 5 88 0.268519 $w=5.4e-08 $l=1.45e-08 $layer=P_src_drn $thickness=1e-09
+ $X=0.216 $Y=0.216 $X2=0.2305 $Y2=0.216
r11 18 5 0.268519 $w=5.4e-08 $l=1.45e-08 $layer=P_src_drn $thickness=1e-09
+ $X=0.2015 $Y=0.216 $X2=0.216 $Y2=0.216
r12 89 18 0.0462963 $w=5.4e-08 $l=2.5e-09 $layer=P_src_drn $thickness=1e-09
+ $X=0.1986 $Y=0.216 $X2=0.2015 $Y2=0.216
r13 3 86 19.3796 $a=3.24e-16 $layer=V0LISD $X=0.108 $Y=0.216 $X2=0.107 $Y2=0.234
r14 4 77 19.3796 $a=3.24e-16 $layer=V0LISD $X=0.162 $Y=0.0675 $X2=0.162
+ $Y2=0.073
r15 5 74 19.3796 $a=3.24e-16 $layer=V0LISD $X=0.216 $Y=0.216 $X2=0.216 $Y2=0.234
r16 83 84 1.28254 $w=1.3e-08 $l=5.5e-09 $layer=M1 $thickness=3.6e-08 $X=0.116
+ $Y=0.234 $X2=0.1215 $Y2=0.234
r17 83 86 2.09871 $w=1.3e-08 $l=9e-09 $layer=M1 $thickness=3.6e-08 $X=0.116
+ $Y=0.234 $X2=0.107 $Y2=0.234
r18 82 84 3.14806 $w=1.3e-08 $l=1.35e-08 $layer=M1 $thickness=3.6e-08 $X=0.135
+ $Y=0.234 $X2=0.1215 $Y2=0.234
r19 81 82 6.17953 $w=1.3e-08 $l=2.65e-08 $layer=M1 $thickness=3.6e-08 $X=0.1615
+ $Y=0.234 $X2=0.135 $Y2=0.234
r20 23 81 4.19742 $w=1.3e-08 $l=1.8e-08 $layer=M1 $thickness=3.6e-08 $X=0.1795
+ $Y=0.234 $X2=0.1615 $Y2=0.234
r21 77 78 3.03147 $w=1.3e-08 $l=1.3e-08 $layer=M1 $thickness=3.6e-08 $X=0.162
+ $Y=0.073 $X2=0.175 $Y2=0.073
r22 24 78 1.04935 $w=1.3e-08 $l=4.5e-09 $layer=M1 $thickness=3.6e-08 $X=0.1795
+ $Y=0.073 $X2=0.175 $Y2=0.073
r23 73 74 3.14806 $w=1.3e-08 $l=1.35e-08 $layer=M1 $thickness=3.6e-08 $X=0.2025
+ $Y=0.234 $X2=0.216 $Y2=0.234
r24 21 26 3.83327 $w=1.5093e-08 $l=2.15e-08 $layer=M1 $thickness=3.6e-08
+ $X=0.189 $Y=0.234 $X2=0.189 $Y2=0.2125
r25 21 73 1.96775 $w=1.63333e-08 $l=1.35e-08 $layer=M1 $thickness=3.6e-08
+ $X=0.189 $Y=0.234 $X2=0.2025 $Y2=0.234
r26 21 23 1.03499 $w=1.77368e-08 $l=9.5e-09 $layer=M1 $thickness=3.6e-08
+ $X=0.189 $Y=0.234 $X2=0.1795 $Y2=0.234
r27 20 72 3.36447 $w=1.71023e-08 $l=2.15e-08 $layer=M1 $thickness=3.6e-08
+ $X=0.189 $Y=0.073 $X2=0.189 $Y2=0.0945
r28 20 24 0.56619 $w=1.77368e-08 $l=9.5e-09 $layer=M1 $thickness=3.6e-08
+ $X=0.189 $Y=0.073 $X2=0.1795 $Y2=0.073
r29 71 72 7.92845 $w=1.3e-08 $l=3.4e-08 $layer=M1 $thickness=3.6e-08 $X=0.189
+ $Y=0.1285 $X2=0.189 $Y2=0.0945
r30 25 71 8.74462 $w=1.3e-08 $l=3.75e-08 $layer=M1 $thickness=3.6e-08 $X=0.189
+ $Y=0.166 $X2=0.189 $Y2=0.1285
r31 19 70 4.79259 $w=1.48269e-08 $l=2.6e-08 $layer=M1 $thickness=3.6e-08
+ $X=0.1885 $Y=0.191 $X2=0.2145 $Y2=0.191
r32 19 25 4.67599 $w=1.48627e-08 $l=2.5005e-08 $layer=M1 $thickness=3.6e-08
+ $X=0.1885 $Y=0.191 $X2=0.189 $Y2=0.166
r33 19 26 3.85983 $w=1.51591e-08 $l=2.15058e-08 $layer=M1 $thickness=3.6e-08
+ $X=0.1885 $Y=0.191 $X2=0.189 $Y2=0.2125
r34 69 70 4.19742 $w=1.3e-08 $l=1.8e-08 $layer=M1 $thickness=3.6e-08 $X=0.2325
+ $Y=0.191 $X2=0.2145 $Y2=0.191
r35 68 69 2.44849 $w=1.3e-08 $l=1.05e-08 $layer=M1 $thickness=3.6e-08 $X=0.243
+ $Y=0.191 $X2=0.2325 $Y2=0.191
r36 27 68 6.29612 $w=1.3e-08 $l=2.7e-08 $layer=M1 $thickness=3.6e-08 $X=0.27
+ $Y=0.191 $X2=0.243 $Y2=0.191
r37 22 47 4.18063 $w=1.6528e-08 $l=2.5e-08 $layer=M1 $thickness=3.6e-08
+ $X=0.297 $Y=0.191 $X2=0.297 $Y2=0.166
r38 22 27 4.64701 $w=1.46667e-08 $l=2.7e-08 $layer=M1 $thickness=3.6e-08
+ $X=0.297 $Y=0.191 $X2=0.27 $Y2=0.191
r39 66 65 14.6259 $w=2.1e-08 $l=4.3e-08 $layer=Gate_1 $thickness=5.6e-08
+ $X=0.459 $Y=0.2025 $X2=0.459 $Y2=0.1595
r40 64 65 2.7211 $w=2.1e-08 $l=8e-09 $layer=Gate_1 $thickness=5.6e-08 $X=0.459
+ $Y=0.1515 $X2=0.459 $Y2=0.1595
r41 62 63 14.6259 $w=2.1e-08 $l=4.3e-08 $layer=Gate_1 $thickness=5.6e-08
+ $X=0.459 $Y=0.0675 $X2=0.459 $Y2=0.1105
r42 60 63 2.7211 $w=2.1e-08 $l=8e-09 $layer=Gate_1 $thickness=5.6e-08 $X=0.459
+ $Y=0.1185 $X2=0.459 $Y2=0.1105
r43 15 43 6.54019 $w=2.09524e-08 $layer=Gate_1 $thickness=5.21905e-08 $X=0.459
+ $Y=0.135 $X2=0.459 $Y2=0.135
r44 15 60 5.79936 $w=2.03333e-08 $l=1.65e-08 $layer=Gate_1 $thickness=5.6e-08
+ $X=0.459 $Y=0.135 $X2=0.459 $Y2=0.1185
r45 15 64 5.79936 $w=2.03333e-08 $l=1.65e-08 $layer=Gate_1 $thickness=5.6e-08
+ $X=0.459 $Y=0.135 $X2=0.459 $Y2=0.1515
r46 58 57 16.4967 $w=2.1e-08 $l=4.85e-08 $layer=Gate_1 $thickness=5.6e-08
+ $X=0.405 $Y=0.2025 $X2=0.405 $Y2=0.154
r47 55 56 16.4967 $w=2.1e-08 $l=4.85e-08 $layer=Gate_1 $thickness=5.6e-08
+ $X=0.405 $Y=0.0675 $X2=0.405 $Y2=0.116
r48 14 41 6.54019 $w=2.09524e-08 $layer=Gate_1 $thickness=5.21905e-08 $X=0.405
+ $Y=0.135 $X2=0.405 $Y2=0.135
r49 14 56 6.6497 $w=2.04211e-08 $l=1.9e-08 $layer=Gate_1 $thickness=5.6e-08
+ $X=0.405 $Y=0.135 $X2=0.405 $Y2=0.116
r50 14 57 6.6497 $w=2.04211e-08 $l=1.9e-08 $layer=Gate_1 $thickness=5.6e-08
+ $X=0.405 $Y=0.135 $X2=0.405 $Y2=0.154
r51 52 51 16.4967 $w=2.1e-08 $l=4.85e-08 $layer=Gate_1 $thickness=5.6e-08
+ $X=0.351 $Y=0.2025 $X2=0.351 $Y2=0.154
r52 49 50 16.4967 $w=2.1e-08 $l=4.85e-08 $layer=Gate_1 $thickness=5.6e-08
+ $X=0.351 $Y=0.0675 $X2=0.351 $Y2=0.116
r53 13 39 6.54019 $w=2.09524e-08 $layer=Gate_1 $thickness=5.21905e-08 $X=0.351
+ $Y=0.135 $X2=0.351 $Y2=0.135
r54 13 50 6.6497 $w=2.04211e-08 $l=1.9e-08 $layer=Gate_1 $thickness=5.6e-08
+ $X=0.351 $Y=0.135 $X2=0.351 $Y2=0.116
r55 13 51 6.6497 $w=2.04211e-08 $l=1.9e-08 $layer=Gate_1 $thickness=5.6e-08
+ $X=0.351 $Y=0.135 $X2=0.351 $Y2=0.154
r56 46 47 4.43061 $w=1.3e-08 $l=1.9e-08 $layer=M1 $thickness=3.6e-08 $X=0.297
+ $Y=0.147 $X2=0.297 $Y2=0.166
r57 45 46 2.79828 $w=1.3e-08 $l=1.2e-08 $layer=M1 $thickness=3.6e-08 $X=0.297
+ $Y=0.135 $X2=0.297 $Y2=0.147
r58 28 45 2.68168 $w=1.3e-08 $l=1.15e-08 $layer=M1 $thickness=3.6e-08 $X=0.297
+ $Y=0.1235 $X2=0.297 $Y2=0.135
r59 42 43 12.6539 $w=1.77815e-08 $l=2.7e-08 $layer=LIG $thickness=4.8e-08
+ $X=0.432 $Y=0.135 $X2=0.459 $Y2=0.135
r60 41 42 12.6539 $w=1.77815e-08 $l=2.7e-08 $layer=LIG $thickness=4.8e-08
+ $X=0.405 $Y=0.135 $X2=0.432 $Y2=0.135
r61 40 41 12.6539 $w=1.77815e-08 $l=2.7e-08 $layer=LIG $thickness=4.8e-08
+ $X=0.378 $Y=0.135 $X2=0.405 $Y2=0.135
r62 39 40 12.6539 $w=1.77815e-08 $l=2.7e-08 $layer=LIG $thickness=4.8e-08
+ $X=0.351 $Y=0.135 $X2=0.378 $Y2=0.135
r63 38 39 12.6539 $w=1.77815e-08 $l=2.7e-08 $layer=LIG $thickness=4.8e-08
+ $X=0.324 $Y=0.135 $X2=0.351 $Y2=0.135
r64 36 38 10.1729 $w=1.54914e-08 $l=1.75e-08 $layer=LIG $thickness=4.8e-08
+ $X=0.3065 $Y=0.135 $X2=0.324 $Y2=0.135
r65 35 36 2.48102 $w=2.2e-08 $l=9.5e-09 $layer=LIG $thickness=4.8e-08 $X=0.297
+ $Y=0.135 $X2=0.3065 $Y2=0.135
r66 35 45 19.3796 $a=3.24e-16 $layer=V0LIG $X=0.297 $Y=0.135 $X2=0.297 $Y2=0.135
r67 1 35 2.48102 $w=2.2e-08 $l=9.5e-09 $layer=LIG $thickness=4.8e-08 $X=0.2875
+ $Y=0.135 $X2=0.297 $Y2=0.135
r68 33 32 16.4967 $w=2.1e-08 $l=4.85e-08 $layer=Gate_1 $thickness=5.6e-08
+ $X=0.297 $Y=0.2025 $X2=0.297 $Y2=0.154
r69 31 32 6.6497 $w=2.04211e-08 $l=1.9e-08 $layer=Gate_1 $thickness=5.6e-08
+ $X=0.297 $Y=0.135 $X2=0.297 $Y2=0.154
r70 31 36 4.05918 $w=2.0087e-08 $l=9.5e-09 $layer=Gate_1 $thickness=5.56522e-08
+ $X=0.297 $Y=0.135 $X2=0.3065 $Y2=0.135
r71 31 35 6.27904 $w=2.09e-08 $layer=Gate_1 $thickness=5.24e-08 $X=0.297
+ $Y=0.135 $X2=0.297 $Y2=0.135
r72 30 31 6.6497 $w=2.04211e-08 $l=1.9e-08 $layer=Gate_1 $thickness=5.6e-08
+ $X=0.297 $Y=0.116 $X2=0.297 $Y2=0.135
r73 29 30 16.4967 $w=2.1e-08 $l=4.85e-08 $layer=Gate_1 $thickness=5.6e-08
+ $X=0.297 $Y=0.0675 $X2=0.297 $Y2=0.116
r74 29 12 14.6259 $w=2.1e-08 $l=4.3e-08 $layer=Gate_1 $thickness=5.6e-08
+ $X=0.297 $Y=0.0675 $X2=0.297 $Y2=0.0245
.ends

.subckt PM_AND2x4_ASAP7_75t_R%B vss 26 6 10 19 22 1 5 3 4
c1 1 vss 0.0107329f $X=0.189 $Y=0.135
c2 3 vss 0.0393767f $X=0.135 $Y=0.135
c3 4 vss 0.0395223f $X=0.189 $Y=0.0245
c4 5 vss 0.00586229f $X=0.135 $Y=0.1165
r1 26 25 0.991056 $w=1.3e-08 $l=4.3e-09 $layer=M1 $thickness=3.6e-08 $X=0.135
+ $Y=0.152 $X2=0.135 $Y2=0.1477
r2 24 25 2.97317 $w=1.3e-08 $l=1.27e-08 $layer=M1 $thickness=3.6e-08 $X=0.135
+ $Y=0.135 $X2=0.135 $Y2=0.1477
r3 5 24 4.31401 $w=1.3e-08 $l=1.85e-08 $layer=M1 $thickness=3.6e-08 $X=0.135
+ $Y=0.1165 $X2=0.135 $Y2=0.135
r4 22 21 16.8368 $w=2.1e-08 $l=4.95e-08 $layer=Gate_1 $thickness=5.6e-08
+ $X=0.135 $Y=0.216 $X2=0.135 $Y2=0.1665
r5 19 20 16.8368 $w=2.1e-08 $l=4.95e-08 $layer=Gate_1 $thickness=5.6e-08
+ $X=0.135 $Y=0.0675 $X2=0.135 $Y2=0.117
r6 3 14 6.69299 $w=1.9e-08 $layer=LIG $thickness=5.2e-08 $X=0.135 $Y=0.135
+ $X2=0.135 $Y2=0.135
r7 3 20 6.27555 $w=2.05e-08 $l=1.8e-08 $layer=Gate_1 $thickness=5.6e-08
+ $X=0.135 $Y=0.135 $X2=0.135 $Y2=0.117
r8 3 21 10.8674 $w=2.07143e-08 $l=3.15e-08 $layer=Gate_1 $thickness=5.6e-08
+ $X=0.135 $Y=0.135 $X2=0.135 $Y2=0.1665
r9 14 15 3.67195 $w=1.8e-08 $l=9.5e-09 $layer=LIG $thickness=4.8e-08 $X=0.135
+ $Y=0.135 $X2=0.1445 $Y2=0.135
r10 14 24 19.3796 $a=3.24e-16 $layer=V0LIG $X=0.135 $Y=0.135 $X2=0.135 $Y2=0.135
r11 12 15 26.4685 $w=1.14914e-08 $l=1.75e-08 $layer=LIG $thickness=4.8e-08
+ $X=0.162 $Y=0.135 $X2=0.1445 $Y2=0.135
r12 1 8 7.07951 $w=1.89474e-08 $layer=LIG $thickness=5.17895e-08 $X=0.189
+ $Y=0.135 $X2=0.189 $Y2=0.135
r13 1 12 30.1405 $w=1.37815e-08 $l=2.7e-08 $layer=LIG $thickness=4.8e-08
+ $X=0.189 $Y=0.135 $X2=0.162 $Y2=0.135
r14 10 9 16.8368 $w=2.1e-08 $l=4.95e-08 $layer=Gate_1 $thickness=5.6e-08
+ $X=0.189 $Y=0.216 $X2=0.189 $Y2=0.1665
r15 8 9 10.8674 $w=2.07143e-08 $l=3.15e-08 $layer=Gate_1 $thickness=5.6e-08
+ $X=0.189 $Y=0.135 $X2=0.189 $Y2=0.1665
r16 7 8 6.27555 $w=2.05e-08 $l=1.8e-08 $layer=Gate_1 $thickness=5.6e-08
+ $X=0.189 $Y=0.117 $X2=0.189 $Y2=0.135
r17 6 7 16.8368 $w=2.1e-08 $l=4.95e-08 $layer=Gate_1 $thickness=5.6e-08
+ $X=0.189 $Y=0.0675 $X2=0.189 $Y2=0.117
r18 6 4 14.6259 $w=2.1e-08 $l=4.3e-08 $layer=Gate_1 $thickness=5.6e-08 $X=0.189
+ $Y=0.0675 $X2=0.189 $Y2=0.0245
.ends

.subckt PM_AND2x4_ASAP7_75t_R%A vss 25 12 18 38 41 1 9 5 6 10 2 11
c1 1 vss 0.00446369f $X=0.081 $Y=0.135
c2 2 vss 0.0039868f $X=0.243 $Y=0.135
c3 5 vss 0.0789917f $X=0.081 $Y=0.0245
c4 6 vss 0.0949801f $X=0.243 $Y=0.135
c5 7 vss 0.00408772f $X=0.081 $Y=0.037
c6 8 vss 0.00381494f $X=0.243 $Y=0.0365
c7 9 vss 0.0138917f $X=0.081 $Y=0.0945
c8 10 vss 0.0152965f $X=0.092 $Y=0.037
c9 11 vss 0.00585352f $X=0.243 $Y=0.055
r1 41 40 16.8368 $w=2.1e-08 $l=4.95e-08 $layer=Gate_1 $thickness=5.6e-08
+ $X=0.243 $Y=0.216 $X2=0.243 $Y2=0.1665
r2 38 39 16.8368 $w=2.1e-08 $l=4.95e-08 $layer=Gate_1 $thickness=5.6e-08
+ $X=0.243 $Y=0.0675 $X2=0.243 $Y2=0.117
r3 6 39 6.27555 $w=2.05e-08 $l=1.8e-08 $layer=Gate_1 $thickness=5.6e-08
+ $X=0.243 $Y=0.135 $X2=0.243 $Y2=0.117
r4 6 40 10.8674 $w=2.07143e-08 $l=3.15e-08 $layer=Gate_1 $thickness=5.6e-08
+ $X=0.243 $Y=0.135 $X2=0.243 $Y2=0.1665
r5 2 33 19.3796 $a=3.24e-16 $layer=V0LIG $X=0.243 $Y=0.135 $X2=0.243 $Y2=0.135
r6 2 6 7.07951 $w=1.89474e-08 $layer=LIG $thickness=5.17895e-08 $X=0.243
+ $Y=0.135 $X2=0.243 $Y2=0.135
r7 32 33 2.68168 $w=1.3e-08 $l=1.15e-08 $layer=M1 $thickness=3.6e-08 $X=0.243
+ $Y=0.1235 $X2=0.243 $Y2=0.135
r8 31 32 7.22888 $w=1.3e-08 $l=3.1e-08 $layer=M1 $thickness=3.6e-08 $X=0.243
+ $Y=0.0925 $X2=0.243 $Y2=0.1235
r9 11 30 2.14973 $w=1.32632e-08 $l=9.5e-09 $layer=M1 $thickness=3.6e-08
+ $X=0.243 $Y=0.055 $X2=0.243 $Y2=0.0455
r10 11 31 8.74462 $w=1.3e-08 $l=3.75e-08 $layer=M1 $thickness=3.6e-08 $X=0.243
+ $Y=0.055 $X2=0.243 $Y2=0.0925
r11 8 30 0.9184 $w=1.8e-08 $l=9e-09 $layer=M1 $thickness=3.6e-08 $X=0.243
+ $Y=0.0365 $X2=0.243 $Y2=0.0455
r12 29 30 4.24844 $w=1.31351e-08 $l=2.83064e-08 $layer=M1 $thickness=3.6e-08
+ $X=0.216 $Y=0.037 $X2=0.243 $Y2=0.0455
r13 28 29 13.8748 $w=1.3e-08 $l=5.95e-08 $layer=M1 $thickness=3.6e-08 $X=0.1565
+ $Y=0.037 $X2=0.216 $Y2=0.037
r14 27 28 12.1259 $w=1.3e-08 $l=5.2e-08 $layer=M1 $thickness=3.6e-08 $X=0.1045
+ $Y=0.037 $X2=0.1565 $Y2=0.037
r15 10 27 2.91487 $w=1.3e-08 $l=1.25e-08 $layer=M1 $thickness=3.6e-08 $X=0.092
+ $Y=0.037 $X2=0.1045 $Y2=0.037
r16 7 23 2.5483 $w=1.79e-08 $l=1.8e-08 $layer=M1 $thickness=3.6e-08 $X=0.081
+ $Y=0.037 $X2=0.081 $Y2=0.055
r17 7 10 0.915974 $w=1.70909e-08 $l=1.1e-08 $layer=M1 $thickness=3.6e-08
+ $X=0.081 $Y=0.037 $X2=0.092 $Y2=0.037
r18 25 24 4.31401 $w=1.3e-08 $l=1.85e-08 $layer=M1 $thickness=3.6e-08 $X=0.083
+ $Y=0.14 $X2=0.081 $Y2=0.1165
r19 22 23 4.19742 $w=1.3e-08 $l=1.8e-08 $layer=M1 $thickness=3.6e-08 $X=0.081
+ $Y=0.073 $X2=0.081 $Y2=0.055
r20 9 22 5.01358 $w=1.3e-08 $l=2.15e-08 $layer=M1 $thickness=3.6e-08 $X=0.081
+ $Y=0.0945 $X2=0.081 $Y2=0.073
r21 9 24 5.13017 $w=1.3e-08 $l=2.2e-08 $layer=M1 $thickness=3.6e-08 $X=0.081
+ $Y=0.0945 $X2=0.081 $Y2=0.1165
r22 1 15 7.07951 $w=1.89474e-08 $layer=LIG $thickness=5.17895e-08 $X=0.081
+ $Y=0.135 $X2=0.081 $Y2=0.135
r23 25 1 19.3796 $a=3.24e-16 $layer=V0LIG $X=0.083 $Y=0.14 $X2=0.081 $Y2=0.135
r24 18 17 14.6259 $w=2.1e-08 $l=4.3e-08 $layer=Gate_1 $thickness=5.6e-08
+ $X=0.081 $Y=0.216 $X2=0.081 $Y2=0.173
r25 16 17 7.65311 $w=2.1e-08 $l=2.25e-08 $layer=Gate_1 $thickness=5.6e-08
+ $X=0.081 $Y=0.1505 $X2=0.081 $Y2=0.173
r26 15 16 5.4252 $w=2.04194e-08 $l=1.55e-08 $layer=Gate_1 $thickness=5.6e-08
+ $X=0.081 $Y=0.135 $X2=0.081 $Y2=0.1505
r27 14 15 5.4252 $w=2.04194e-08 $l=1.55e-08 $layer=Gate_1 $thickness=5.6e-08
+ $X=0.081 $Y=0.1195 $X2=0.081 $Y2=0.135
r28 13 14 3.06124 $w=2.1e-08 $l=9e-09 $layer=Gate_1 $thickness=5.6e-08 $X=0.081
+ $Y=0.1105 $X2=0.081 $Y2=0.1195
r29 12 13 14.6259 $w=2.1e-08 $l=4.3e-08 $layer=Gate_1 $thickness=5.6e-08
+ $X=0.081 $Y=0.0675 $X2=0.081 $Y2=0.1105
r30 12 5 14.6259 $w=2.1e-08 $l=4.3e-08 $layer=Gate_1 $thickness=5.6e-08
+ $X=0.081 $Y=0.0675 $X2=0.081 $Y2=0.0245
.ends

* End of included file AND2x4_ASAP7_75t_R.pex.sp.pex

*
.subckt AND2x4_ASAP7_75t_CUSTOM_4_25_0_7 VSS VDD A B Y
*
* VSS VSS
* VDD VDD
* A A
* B B
* Y Y
*
*

M0 VSS N_M0_g N_M0_s VSS nmos_rvt L=2e-08 W=8.1e-08 nfin=3 $X=0.071 $Y=0.027
M1 N_M1_d N_M1_g N_M1_s VSS nmos_rvt L=2e-08 W=8.1e-08 nfin=3 $X=0.125 $Y=0.027
M2 N_M2_d N_M2_g N_M2_s VSS nmos_rvt L=2e-08 W=8.1e-08 nfin=3 $X=0.179 $Y=0.027
M3 VSS N_M3_g N_M3_s VSS nmos_rvt L=2e-08 W=8.1e-08 nfin=3 $X=0.233 $Y=0.027
M4 N_M4_d N_M4_g VSS VSS nmos_rvt L=2e-08 W=8.1e-08 nfin=3 $X=0.287 $Y=0.027
M5 N_M5_d N_M5_g VSS VSS nmos_rvt L=2e-08 W=8.1e-08 nfin=3 $X=0.341 $Y=0.027
M6 N_M6_d N_M6_g VSS VSS nmos_rvt L=2e-08 W=8.1e-08 nfin=3 $X=0.395 $Y=0.027
M7 N_M7_d N_M7_g VSS VSS nmos_rvt L=2e-08 W=8.1e-08 nfin=3 $X=0.449 $Y=0.027
M8 N_M8_d N_M8_g VDD VDD pmos_rvt L=2e-08 W=5.4e-08 nfin=2 $X=0.071 $Y=0.189
M9 VDD N_M9_g N_M9_s VDD pmos_rvt L=2e-08 W=5.4e-08 nfin=2 $X=0.125 $Y=0.189
M10 VDD N_M10_g N_M10_s VDD pmos_rvt L=2e-08 W=5.4e-08 nfin=2 $X=0.179 $Y=0.189
M11 N_M11_d N_M11_g VDD VDD pmos_rvt L=2e-08 W=5.4e-08 nfin=2 $X=0.233 $Y=0.189
M12 N_M12_d N_M12_g VDD VDD pmos_rvt L=2e-08 W=8.1e-08 nfin=3 $X=0.287 $Y=0.162
M13 N_M13_d N_M13_g VDD VDD pmos_rvt L=2e-08 W=8.1e-08 nfin=3 $X=0.341 $Y=0.162
M14 N_M14_d N_M14_g VDD VDD pmos_rvt L=2e-08 W=8.1e-08 nfin=3 $X=0.395 $Y=0.162
M15 N_M15_d N_M15_g VDD VDD pmos_rvt L=2e-08 W=8.1e-08 nfin=3 $X=0.449 $Y=0.162

* .include "AND2x4_ASAP7_75t_R.pex.sp.pxi"

* Start of included file AND2x4_ASAP7_75t_R.pex.sp.pxi
x_PM_AND2x4_ASAP7_75t_R%7__2 vss N_M0_s N_M1_d N_7__2_1
+ PM_AND2x4_ASAP7_75t_R%7__2
cc_1 N_7__2_1 N_A_5 0.0168366f $X=0.108 $Y=0.0675
cc_2 N_7__2_1 N_B_3 0.0167932f $X=0.108 $Y=0.0675
x_PM_AND2x4_ASAP7_75t_R%8 vss N_M2_d N_M3_s N_8_1 PM_AND2x4_ASAP7_75t_R%8
cc_3 N_8_1 N_A_6 0.0169768f $X=0.216 $Y=0.0675
cc_4 N_8_1 N_B_4 0.0169147f $X=0.216 $Y=0.0675
x_PM_AND2x4_ASAP7_75t_R%Y vss Y N_M4_d N_M5_d N_M6_d N_M7_d N_M12_d N_M13_d
+ N_M14_d N_M15_d N_Y_15 N_Y_4 N_Y_1 N_Y_20 N_Y_2 N_Y_14 N_Y_13 N_Y_16
+ PM_AND2x4_ASAP7_75t_R%Y
cc_5 N_Y_15 N_5_27 0.000401919f $X=0.3095 $Y=0.2025
cc_6 N_Y_15 N_5_1 0.00155176f $X=0.3095 $Y=0.2025
cc_7 N_Y_15 N_5_14 0.00370014f $X=0.3095 $Y=0.2025
cc_8 N_Y_15 N_5_13 0.000808875f $X=0.3095 $Y=0.2025
cc_9 N_Y_15 N_5_28 0.00105609f $X=0.3095 $Y=0.2025
cc_10 N_Y_4 N_5_14 0.00155377f $X=0.432 $Y=0.2025
cc_11 N_Y_1 N_5_12 0.00178671f $X=0.324 $Y=0.0675
cc_12 N_Y_20 N_5_22 0.00184341f $X=0.3125 $Y=0.234
cc_13 N_Y_2 N_5_12 0.00211073f $X=0.324 $Y=0.2025
cc_14 N_Y_14 N_5_1 0.0087944f $X=0.4175 $Y=0.0675
cc_15 N_Y_13 N_5_12 0.0100734f $X=0.3095 $Y=0.0675
cc_16 N_Y_14 N_5_15 0.0280557f $X=0.4175 $Y=0.0675
cc_17 N_Y_13 N_5_13 0.0538388f $X=0.3095 $Y=0.0675
cc_18 N_Y_16 N_5_15 0.0639785f $X=0.4175 $Y=0.2025
cc_19 N_Y_16 N_5_14 0.0361279f $X=0.4175 $Y=0.2025
cc_20 N_Y_15 N_5_12 0.066565f $X=0.3095 $Y=0.2025
x_PM_AND2x4_ASAP7_75t_R%5 vss N_M4_g N_M12_g N_M5_g N_M13_g N_M6_g N_M14_g
+ N_M7_g N_M15_g N_M10_s N_M11_d N_M1_s N_M2_s N_M8_d N_M9_s N_5_3 N_5_16
+ N_5_18 N_5_17 N_5_5 N_5_1 N_5_4 N_5_23 N_5_27 N_5_28 N_5_20 N_5_24 N_5_25
+ N_5_12 N_5_19 N_5_14 N_5_13 N_5_22 N_5_15 PM_AND2x4_ASAP7_75t_R%5
cc_21 N_5_3 N_A_5 0.000974109f $X=0.108 $Y=0.216
cc_22 N_5_16 N_A_5 0.000263472f $X=0.1475 $Y=0.0675
cc_23 N_5_18 N_A_6 0.0108988f $X=0.2015 $Y=0.216
cc_24 N_5_17 N_A_1 0.000336434f $X=0.0935 $Y=0.216
cc_25 N_5_5 N_A_6 0.000390697f $X=0.216 $Y=0.216
cc_26 N_5_1 N_A_6 0.000407838f $X=0.2875 $Y=0.135
cc_27 N_5_4 N_A_10 0.00171499f $X=0.162 $Y=0.0675
cc_28 N_5_23 N_A_9 0.000605287f $X=0.1795 $Y=0.234
cc_29 N_5_1 N_A_2 0.00241221f $X=0.2875 $Y=0.135
cc_30 N_5_27 N_A_11 0.000972924f $X=0.27 $Y=0.191
cc_31 N_5_28 N_A_11 0.00101189f $X=0.297 $Y=0.1235
cc_32 N_5_20 N_A_10 0.00151276f $X=0.189 $Y=0.073
cc_33 N_5_24 N_A_9 0.0021238f $X=0.1795 $Y=0.073
cc_34 N_5_25 N_A_11 0.00526431f $X=0.189 $Y=0.166
cc_35 N_5_24 N_A_10 0.00739707f $X=0.1795 $Y=0.073
cc_36 N_5_12 N_A_6 0.0173843f $X=0.297 $Y=0.0245
cc_37 N_5_17 N_A_5 0.0259487f $X=0.0935 $Y=0.216
cc_38 N_5_17 N_B_4 0.00033868f $X=0.0935 $Y=0.216
cc_39 N_5_19 N_B_4 0.000377523f $X=0.1885 $Y=0.191
cc_40 N_5_5 N_B_4 0.000417947f $X=0.216 $Y=0.216
cc_41 N_5_4 N_B_5 0.000435247f $X=0.162 $Y=0.0675
cc_42 N_5_3 N_B_3 0.000696305f $X=0.108 $Y=0.216
cc_43 N_5_4 N_B_1 0.00072994f $X=0.162 $Y=0.0675
cc_44 N_5_24 N_B_5 0.00090002f $X=0.1795 $Y=0.073
cc_45 N_5_23 N_B_5 0.000959624f $X=0.1795 $Y=0.234
cc_46 N_5_4 N_B_4 0.00208937f $X=0.162 $Y=0.0675
cc_47 N_5_16 N_B_1 0.00347886f $X=0.1475 $Y=0.0675
cc_48 N_5_17 N_B_3 0.0105732f $X=0.0935 $Y=0.216
cc_49 N_5_18 N_B_4 0.0106233f $X=0.2015 $Y=0.216
cc_50 N_5_25 N_B_5 0.00627356f $X=0.189 $Y=0.166
cc_51 N_5_16 N_B_3 0.0528277f $X=0.1475 $Y=0.0675
cc_52 N_5_16 N_B_4 0.0468557f $X=0.1475 $Y=0.0675
x_PM_AND2x4_ASAP7_75t_R%B vss B N_M2_g N_M10_g N_M1_g N_M9_g N_B_1 N_B_5 N_B_3
+ N_B_4 PM_AND2x4_ASAP7_75t_R%B
cc_53 N_B_1 N_A_1 0.00304618f $X=0.189 $Y=0.135
cc_54 N_B_5 N_A_9 0.00389269f $X=0.135 $Y=0.1165
cc_55 N_B_3 N_A_5 0.00708234f $X=0.135 $Y=0.135
cc_56 N_B_4 N_A_6 0.0082769f $X=0.189 $Y=0.0245
x_PM_AND2x4_ASAP7_75t_R%A vss A N_M0_g N_M8_g N_M3_g N_M11_g N_A_1 N_A_9 N_A_5
+ N_A_6 N_A_10 N_A_2 N_A_11 PM_AND2x4_ASAP7_75t_R%A

* End of included file AND2x4_ASAP7_75t_R.pex.sp.pxi
.ends

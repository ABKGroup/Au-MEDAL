.subckt PM_XNOR2x1_ASAP7_75t_R%8 vss 2 3 1
c1 1 vss 0.000807028f $X=0.108 $Y=0.0675
r1 2 1 0.209877 $w=8.1e-08 $l=1.7e-08 $layer=N_src_drn $thickness=1e-09
+ $X=0.0906 $Y=0.0675 $X2=0.108 $Y2=0.0675
r2 3 1 0.209877 $w=8.1e-08 $l=1.7e-08 $layer=N_src_drn $thickness=1e-09
+ $X=0.1253 $Y=0.0675 $X2=0.108 $Y2=0.0675
.ends

.subckt PM_XNOR2x1_ASAP7_75t_R%A vss 45 15 21 31 35 58 62 1 8 10 11 9 2 12 6 5 7
c1 1 vss 0.0198661f $X=0.297 $Y=0.135
c2 2 vss 0.0051845f $X=0.567 $Y=0.135
c3 5 vss 0.0488301f $X=0.135 $Y=0.135
c4 6 vss 0.106145f $X=0.297 $Y=0.0245
c5 7 vss 0.106274f $X=0.567 $Y=0.135
c6 8 vss 0.00188446f $X=0.135 $Y=0.198
c7 9 vss 0.0026498f $X=0.567 $Y=0.198
c8 10 vss 0.00148385f $X=0.135 $Y=0.1265
c9 11 vss 0.00346357f $X=0.567 $Y=0.166
c10 12 vss 0.0226863f $X=0.1235 $Y=0.189
r1 62 61 14.6259 $w=2.1e-08 $l=4.3e-08 $layer=Gate_1 $thickness=5.6e-08
+ $X=0.567 $Y=0.2025 $X2=0.567 $Y2=0.1595
r2 60 61 2.7211 $w=2.1e-08 $l=8e-09 $layer=Gate_1 $thickness=5.6e-08 $X=0.567
+ $Y=0.1515 $X2=0.567 $Y2=0.1595
r3 58 59 14.6259 $w=2.1e-08 $l=4.3e-08 $layer=Gate_1 $thickness=5.6e-08
+ $X=0.567 $Y=0.0675 $X2=0.567 $Y2=0.1105
r4 56 59 2.7211 $w=2.1e-08 $l=8e-09 $layer=Gate_1 $thickness=5.6e-08 $X=0.567
+ $Y=0.1185 $X2=0.567 $Y2=0.1105
r5 7 56 5.79936 $w=2.03333e-08 $l=1.65e-08 $layer=Gate_1 $thickness=5.6e-08
+ $X=0.567 $Y=0.135 $X2=0.567 $Y2=0.1185
r6 7 60 5.79936 $w=2.03333e-08 $l=1.65e-08 $layer=Gate_1 $thickness=5.6e-08
+ $X=0.567 $Y=0.135 $X2=0.567 $Y2=0.1515
r7 2 54 19.3796 $a=3.24e-16 $layer=V0LIG $X=0.567 $Y=0.135 $X2=0.567 $Y2=0.135
r8 2 7 10.4265 $w=1.765e-08 $layer=LIG $thickness=5.2e-08 $X=0.567 $Y=0.135
+ $X2=0.567 $Y2=0.135
r9 54 55 3.03147 $w=1.3e-08 $l=1.3e-08 $layer=M1 $thickness=3.6e-08 $X=0.567
+ $Y=0.135 $X2=0.567 $Y2=0.148
r10 11 52 4.31401 $w=1.3e-08 $l=1.85e-08 $layer=M1 $thickness=3.6e-08 $X=0.567
+ $Y=0.166 $X2=0.567 $Y2=0.1845
r11 11 55 4.19742 $w=1.3e-08 $l=1.8e-08 $layer=M1 $thickness=3.6e-08 $X=0.567
+ $Y=0.166 $X2=0.567 $Y2=0.148
r12 9 49 39.0693 $a=1.62e-16 $layer=V1 $X=0.567 $Y=0.198 $X2=0.567 $Y2=0.189
r13 9 52 1.96775 $w=1.63333e-08 $l=1.35e-08 $layer=M1 $thickness=3.6e-08
+ $X=0.567 $Y=0.198 $X2=0.567 $Y2=0.1845
r14 49 52 39.0693 $a=1.62e-16 $layer=V1 $X=0.567 $Y=0.189 $X2=0.567 $Y2=0.1845
r15 48 49 5.71315 $w=1.3e-08 $l=2.45e-08 $layer=M2 $thickness=3.6e-08 $X=0.5425
+ $Y=0.189 $X2=0.567 $Y2=0.189
r16 47 48 30.3147 $w=1.3e-08 $l=1.3e-07 $layer=M2 $thickness=3.6e-08 $X=0.4125
+ $Y=0.189 $X2=0.5425 $Y2=0.189
r17 46 47 36.3193 $w=1.3e-08 $l=1.558e-07 $layer=M2 $thickness=3.6e-08
+ $X=0.2567 $Y=0.189 $X2=0.4125 $Y2=0.189
r18 45 46 9.73567 $w=1.3e-08 $l=4.17e-08 $layer=M2 $thickness=3.6e-08 $X=0.215
+ $Y=0.189 $X2=0.2567 $Y2=0.189
r19 45 44 8.33653 $w=1.3e-08 $l=3.58e-08 $layer=M2 $thickness=3.6e-08 $X=0.215
+ $Y=0.189 $X2=0.1792 $Y2=0.189
r20 43 44 10.3186 $w=1.3e-08 $l=4.42e-08 $layer=M2 $thickness=3.6e-08 $X=0.135
+ $Y=0.189 $X2=0.1792 $Y2=0.189
r21 12 43 2.68168 $w=1.3e-08 $l=1.15e-08 $layer=M2 $thickness=3.6e-08 $X=0.1235
+ $Y=0.189 $X2=0.135 $Y2=0.189
r22 8 41 1.96775 $w=1.63333e-08 $l=1.35e-08 $layer=M1 $thickness=3.6e-08
+ $X=0.135 $Y=0.198 $X2=0.135 $Y2=0.1845
r23 8 43 39.0693 $a=1.62e-16 $layer=V1 $X=0.135 $Y=0.198 $X2=0.135 $Y2=0.189
r24 41 43 39.0693 $a=1.62e-16 $layer=V1 $X=0.135 $Y=0.1845 $X2=0.135 $Y2=0.189
r25 40 41 5.24677 $w=1.3e-08 $l=2.25e-08 $layer=M1 $thickness=3.6e-08 $X=0.135
+ $Y=0.162 $X2=0.135 $Y2=0.1845
r26 38 40 4.31401 $w=1.3e-08 $l=1.85e-08 $layer=M1 $thickness=3.6e-08 $X=0.135
+ $Y=0.1435 $X2=0.135 $Y2=0.162
r27 37 38 1.98211 $w=1.3e-08 $l=8.5e-09 $layer=M1 $thickness=3.6e-08 $X=0.135
+ $Y=0.135 $X2=0.135 $Y2=0.1435
r28 10 37 1.98211 $w=1.3e-08 $l=8.5e-09 $layer=M1 $thickness=3.6e-08 $X=0.135
+ $Y=0.1265 $X2=0.135 $Y2=0.135
r29 35 34 14.6259 $w=2.1e-08 $l=4.3e-08 $layer=Gate_1 $thickness=5.6e-08
+ $X=0.135 $Y=0.2025 $X2=0.135 $Y2=0.1595
r30 33 34 3.23131 $w=2.1e-08 $l=9.5e-09 $layer=Gate_1 $thickness=5.6e-08
+ $X=0.135 $Y=0.15 $X2=0.135 $Y2=0.1595
r31 31 32 14.6259 $w=2.1e-08 $l=4.3e-08 $layer=Gate_1 $thickness=5.6e-08
+ $X=0.135 $Y=0.0675 $X2=0.135 $Y2=0.1105
r32 29 32 3.23131 $w=2.1e-08 $l=9.5e-09 $layer=Gate_1 $thickness=5.6e-08
+ $X=0.135 $Y=0.12 $X2=0.135 $Y2=0.1105
r33 5 25 7.11151 $w=1.78824e-08 $layer=LIG $thickness=5.17647e-08 $X=0.135
+ $Y=0.135 $X2=0.135 $Y2=0.135
r34 5 29 5.23813 $w=2.04667e-08 $l=1.5e-08 $layer=Gate_1 $thickness=5.6e-08
+ $X=0.135 $Y=0.135 $X2=0.135 $Y2=0.12
r35 5 33 5.23813 $w=2.04667e-08 $l=1.5e-08 $layer=Gate_1 $thickness=5.6e-08
+ $X=0.135 $Y=0.135 $X2=0.135 $Y2=0.15
r36 25 26 4.49071 $w=1.6e-08 $l=9.5e-09 $layer=LIG $thickness=4.8e-08 $X=0.135
+ $Y=0.135 $X2=0.1445 $Y2=0.135
r37 25 37 28.9687 $a=2.88e-16 $layer=V0LIG $X=0.135 $Y=0.135 $X2=0.135 $Y2=0.135
r38 23 26 165.742 $w=9.34685e-09 $l=7.15e-08 $layer=LIG $thickness=4.8e-08
+ $X=0.216 $Y=0.135 $X2=0.1445 $Y2=0.135
r39 1 18 7.58422 $w=1.77778e-08 $layer=LIG $thickness=5.15556e-08 $X=0.297
+ $Y=0.135 $X2=0.297 $Y2=0.135
r40 1 23 170.233 $w=1.01272e-08 $l=8.1e-08 $layer=LIG $thickness=4.8e-08
+ $X=0.297 $Y=0.135 $X2=0.216 $Y2=0.135
r41 21 20 14.6259 $w=2.1e-08 $l=4.3e-08 $layer=Gate_1 $thickness=5.6e-08
+ $X=0.297 $Y=0.2025 $X2=0.297 $Y2=0.1595
r42 19 20 3.23131 $w=2.1e-08 $l=9.5e-09 $layer=Gate_1 $thickness=5.6e-08
+ $X=0.297 $Y=0.15 $X2=0.297 $Y2=0.1595
r43 18 19 5.23813 $w=2.04667e-08 $l=1.5e-08 $layer=Gate_1 $thickness=5.6e-08
+ $X=0.297 $Y=0.135 $X2=0.297 $Y2=0.15
r44 17 18 5.23813 $w=2.04667e-08 $l=1.5e-08 $layer=Gate_1 $thickness=5.6e-08
+ $X=0.297 $Y=0.12 $X2=0.297 $Y2=0.135
r45 16 17 3.23131 $w=2.1e-08 $l=9.5e-09 $layer=Gate_1 $thickness=5.6e-08
+ $X=0.297 $Y=0.1105 $X2=0.297 $Y2=0.12
r46 15 16 14.6259 $w=2.1e-08 $l=4.3e-08 $layer=Gate_1 $thickness=5.6e-08
+ $X=0.297 $Y=0.0675 $X2=0.297 $Y2=0.1105
r47 15 6 14.6259 $w=2.1e-08 $l=4.3e-08 $layer=Gate_1 $thickness=5.6e-08
+ $X=0.297 $Y=0.0675 $X2=0.297 $Y2=0.0245
.ends

.subckt PM_XNOR2x1_ASAP7_75t_R%Y vss 31 24 25 50 51 53 55 20 17 16 1 4 14 19 21
+ 15 13 2 3
c1 1 vss 0.00622665f $X=0.27 $Y=0.2025
c2 2 vss 0.00923516f $X=0.432 $Y=0.0675
c3 3 vss 0.00823998f $X=0.432 $Y=0.2025
c4 4 vss 0.00749309f $X=0.594 $Y=0.2025
c5 13 vss 0.00433035f $X=0.4175 $Y=0.0675
c6 14 vss 0.0359263f $X=0.272 $Y=0.2025
c7 15 vss 0.00443685f $X=0.4175 $Y=0.2025
c8 16 vss 0.0361912f $X=0.5795 $Y=0.2025
c9 17 vss 0.00343089f $X=0.4205 $Y=0.086
c10 18 vss 0.00202088f $X=0.459 $Y=0.234
c11 19 vss 0.0155602f $X=0.4205 $Y=0.234
c12 20 vss 0.0021381f $X=0.459 $Y=0.108
c13 21 vss 0.0125918f $X=0.486 $Y=0.234
r1 16 4 0.154321 $w=8.1e-08 $l=1.25e-08 $layer=P_src_drn $thickness=1e-09
+ $X=0.5795 $Y=0.2025 $X2=0.594 $Y2=0.2025
r2 55 16 0.0308642 $w=8.1e-08 $l=2.5e-09 $layer=P_src_drn $thickness=1e-09
+ $X=0.5766 $Y=0.2025 $X2=0.5795 $Y2=0.2025
r3 53 52 0.0308642 $w=8.1e-08 $l=2.5e-09 $layer=P_src_drn $thickness=1e-09
+ $X=0.2873 $Y=0.2025 $X2=0.2845 $Y2=0.2025
r4 14 52 0.154321 $w=8.1e-08 $l=1.25e-08 $layer=P_src_drn $thickness=1e-09
+ $X=0.272 $Y=0.2025 $X2=0.2845 $Y2=0.2025
r5 51 49 0.0308642 $w=8.1e-08 $l=2.5e-09 $layer=P_src_drn $thickness=1e-09
+ $X=0.4493 $Y=0.2025 $X2=0.4465 $Y2=0.2025
r6 3 49 0.179012 $w=8.1e-08 $l=1.45e-08 $layer=P_src_drn $thickness=1e-09
+ $X=0.432 $Y=0.2025 $X2=0.4465 $Y2=0.2025
r7 15 3 0.179012 $w=8.1e-08 $l=1.45e-08 $layer=P_src_drn $thickness=1e-09
+ $X=0.4175 $Y=0.2025 $X2=0.432 $Y2=0.2025
r8 50 15 0.0308642 $w=8.1e-08 $l=2.5e-09 $layer=P_src_drn $thickness=1e-09
+ $X=0.4146 $Y=0.2025 $X2=0.4175 $Y2=0.2025
r9 4 45 19.3796 $a=3.24e-16 $layer=V0LISD $X=0.594 $Y=0.2025 $X2=0.594 $Y2=0.234
r10 1 39 19.3796 $a=3.24e-16 $layer=V0LISD $X=0.27 $Y=0.2025 $X2=0.27 $Y2=0.234
r11 3 35 19.3796 $a=3.24e-16 $layer=V0LISD $X=0.432 $Y=0.2025 $X2=0.432
+ $Y2=0.234
r12 44 45 3.14806 $w=1.3e-08 $l=1.35e-08 $layer=M1 $thickness=3.6e-08 $X=0.5805
+ $Y=0.234 $X2=0.594 $Y2=0.234
r13 43 44 6.8791 $w=1.3e-08 $l=2.95e-08 $layer=M1 $thickness=3.6e-08 $X=0.551
+ $Y=0.234 $X2=0.5805 $Y2=0.234
r14 42 43 6.29612 $w=1.3e-08 $l=2.7e-08 $layer=M1 $thickness=3.6e-08 $X=0.524
+ $Y=0.234 $X2=0.551 $Y2=0.234
r15 41 42 2.56509 $w=1.3e-08 $l=1.1e-08 $layer=M1 $thickness=3.6e-08 $X=0.513
+ $Y=0.234 $X2=0.524 $Y2=0.234
r16 21 41 6.29612 $w=1.3e-08 $l=2.7e-08 $layer=M1 $thickness=3.6e-08 $X=0.486
+ $Y=0.234 $X2=0.513 $Y2=0.234
r17 39 40 17.839 $w=1.3e-08 $l=7.65e-08 $layer=M1 $thickness=3.6e-08 $X=0.27
+ $Y=0.234 $X2=0.3465 $Y2=0.234
r18 37 40 16.2067 $w=1.3e-08 $l=6.95e-08 $layer=M1 $thickness=3.6e-08 $X=0.416
+ $Y=0.234 $X2=0.3465 $Y2=0.234
r19 35 36 3.14806 $w=1.3e-08 $l=1.35e-08 $layer=M1 $thickness=3.6e-08 $X=0.432
+ $Y=0.234 $X2=0.4455 $Y2=0.234
r20 19 35 2.68168 $w=1.3e-08 $l=1.15e-08 $layer=M1 $thickness=3.6e-08 $X=0.4205
+ $Y=0.234 $X2=0.432 $Y2=0.234
r21 19 37 1.04935 $w=1.3e-08 $l=4.5e-09 $layer=M1 $thickness=3.6e-08 $X=0.4205
+ $Y=0.234 $X2=0.416 $Y2=0.234
r22 18 34 3.01711 $w=1.55e-08 $l=1.8e-08 $layer=M1 $thickness=3.6e-08 $X=0.459
+ $Y=0.234 $X2=0.459 $Y2=0.216
r23 18 36 1.96775 $w=1.63333e-08 $l=1.35e-08 $layer=M1 $thickness=3.6e-08
+ $X=0.459 $Y=0.234 $X2=0.4455 $Y2=0.234
r24 18 21 5.11582 $w=1.46667e-08 $l=2.7e-08 $layer=M1 $thickness=3.6e-08
+ $X=0.459 $Y=0.234 $X2=0.486 $Y2=0.234
r25 33 34 4.19742 $w=1.3e-08 $l=1.8e-08 $layer=M1 $thickness=3.6e-08 $X=0.459
+ $Y=0.198 $X2=0.459 $Y2=0.216
r26 32 33 3.32295 $w=1.3e-08 $l=1.43e-08 $layer=M1 $thickness=3.6e-08 $X=0.459
+ $Y=0.1837 $X2=0.459 $Y2=0.198
r27 31 32 1.34084 $w=1.3e-08 $l=5.7e-09 $layer=M1 $thickness=3.6e-08 $X=0.457
+ $Y=0.178 $X2=0.459 $Y2=0.1837
r28 31 30 3.08976 $w=1.3e-08 $l=1.33e-08 $layer=M1 $thickness=3.6e-08 $X=0.457
+ $Y=0.178 $X2=0.459 $Y2=0.1647
r29 29 30 6.58761 $w=1.3e-08 $l=2.82e-08 $layer=M1 $thickness=3.6e-08 $X=0.459
+ $Y=0.1365 $X2=0.459 $Y2=0.1647
r30 20 28 3.94987 $w=1.50455e-08 $l=2.2e-08 $layer=M1 $thickness=3.6e-08
+ $X=0.459 $Y=0.108 $X2=0.459 $Y2=0.086
r31 20 29 6.64591 $w=1.3e-08 $l=2.85e-08 $layer=M1 $thickness=3.6e-08 $X=0.459
+ $Y=0.108 $X2=0.459 $Y2=0.1365
r32 27 28 1.96775 $w=1.63333e-08 $l=1.35e-08 $layer=M1 $thickness=3.6e-08
+ $X=0.4455 $Y=0.086 $X2=0.459 $Y2=0.086
r33 26 27 3.14806 $w=1.3e-08 $l=1.35e-08 $layer=M1 $thickness=3.6e-08 $X=0.432
+ $Y=0.086 $X2=0.4455 $Y2=0.086
r34 17 26 2.68168 $w=1.3e-08 $l=1.15e-08 $layer=M1 $thickness=3.6e-08 $X=0.4205
+ $Y=0.086 $X2=0.432 $Y2=0.086
r35 2 26 19.3796 $a=3.24e-16 $layer=V0LISD $X=0.432 $Y=0.0675 $X2=0.432
+ $Y2=0.086
r36 25 23 0.0308642 $w=8.1e-08 $l=2.5e-09 $layer=N_src_drn $thickness=1e-09
+ $X=0.4493 $Y=0.0675 $X2=0.4465 $Y2=0.0675
r37 2 23 0.179012 $w=8.1e-08 $l=1.45e-08 $layer=N_src_drn $thickness=1e-09
+ $X=0.432 $Y=0.0675 $X2=0.4465 $Y2=0.0675
r38 13 2 0.179012 $w=8.1e-08 $l=1.45e-08 $layer=N_src_drn $thickness=1e-09
+ $X=0.4175 $Y=0.0675 $X2=0.432 $Y2=0.0675
r39 24 13 0.0308642 $w=8.1e-08 $l=2.5e-09 $layer=N_src_drn $thickness=1e-09
+ $X=0.4146 $Y=0.0675 $X2=0.4175 $Y2=0.0675
r40 1 14 1e-05 $l=2e-09 $X=0.27 $Y=0.2025 $X2=0.272 $Y2=0.2025
.ends

.subckt PM_XNOR2x1_ASAP7_75t_R%B vss 40 28 34 78 81 84 87 9 2 16 1 24 22 19 23
+ 17 15 21 18 3 25 13 8 7 20
c1 1 vss 0.0092246f $X=0.072 $Y=0.135
c2 2 vss 0.00592225f $X=0.351 $Y=0.135
c3 3 vss 0.00586628f $X=0.513 $Y=0.135
c4 7 vss 0.0856128f $X=0.081 $Y=0.0245
c5 8 vss 0.140135f $X=0.351 $Y=0.135
c6 9 vss 0.140201f $X=0.513 $Y=0.135
c7 10 vss 0.00364996f $X=0.027 $Y=0.036
c8 11 vss 0.00113208f $X=0.027 $Y=0.135
c9 12 vss 0.00355536f $X=0.222 $Y=0.036
c10 13 vss 0.000590827f $X=0.222 $Y=0.0745
c11 14 vss 0.00341497f $X=0.314 $Y=0.071
c12 15 vss 0.000371517f $X=0.314 $Y=0.135
c13 16 vss 0.00613285f $X=0.027 $Y=0.1235
c14 17 vss 0.00952118f $X=0.027 $Y=0.1665
c15 18 vss 0.017731f $X=0.057 $Y=0.036
c16 19 vss 0.00125643f $X=0.0455 $Y=0.135
c17 20 vss 0.00108061f $X=0.222 $Y=0.056
c18 21 vss 0.00596664f $X=0.2435 $Y=0.076
c19 22 vss 0.00163926f $X=0.314 $Y=0.0875
c20 23 vss 0.000850913f $X=0.3325 $Y=0.135
c21 24 vss 0.00593176f $X=0.513 $Y=0.071
c22 25 vss 0.0120812f $X=0.3015 $Y=0.081
r1 87 86 16.4967 $w=2.1e-08 $l=4.85e-08 $layer=Gate_1 $thickness=5.6e-08
+ $X=0.351 $Y=0.2025 $X2=0.351 $Y2=0.154
r2 84 85 16.4967 $w=2.1e-08 $l=4.85e-08 $layer=Gate_1 $thickness=5.6e-08
+ $X=0.351 $Y=0.0675 $X2=0.351 $Y2=0.116
r3 8 85 6.6497 $w=2.04211e-08 $l=1.9e-08 $layer=Gate_1 $thickness=5.6e-08
+ $X=0.351 $Y=0.135 $X2=0.351 $Y2=0.116
r4 8 86 6.6497 $w=2.04211e-08 $l=1.9e-08 $layer=Gate_1 $thickness=5.6e-08
+ $X=0.351 $Y=0.135 $X2=0.351 $Y2=0.154
r5 81 80 16.4967 $w=2.1e-08 $l=4.85e-08 $layer=Gate_1 $thickness=5.6e-08
+ $X=0.513 $Y=0.2025 $X2=0.513 $Y2=0.154
r6 78 79 16.4967 $w=2.1e-08 $l=4.85e-08 $layer=Gate_1 $thickness=5.6e-08
+ $X=0.513 $Y=0.0675 $X2=0.513 $Y2=0.116
r7 9 79 6.6497 $w=2.04211e-08 $l=1.9e-08 $layer=Gate_1 $thickness=5.6e-08
+ $X=0.513 $Y=0.135 $X2=0.513 $Y2=0.116
r8 9 80 6.6497 $w=2.04211e-08 $l=1.9e-08 $layer=Gate_1 $thickness=5.6e-08
+ $X=0.513 $Y=0.135 $X2=0.513 $Y2=0.154
r9 2 73 19.3796 $a=3.24e-16 $layer=V0LIG $X=0.351 $Y=0.135 $X2=0.351 $Y2=0.135
r10 2 8 8.65438 $w=1.80211e-08 $layer=LIG $thickness=5.26316e-08 $X=0.351
+ $Y=0.135 $X2=0.351 $Y2=0.135
r11 3 71 19.3796 $a=3.24e-16 $layer=V0LIG $X=0.513 $Y=0.135 $X2=0.513 $Y2=0.135
r12 3 9 10.4265 $w=1.765e-08 $layer=LIG $thickness=5.2e-08 $X=0.513 $Y=0.135
+ $X2=0.513 $Y2=0.135
r13 23 73 4.31401 $w=1.3e-08 $l=1.85e-08 $layer=M1 $thickness=3.6e-08 $X=0.3325
+ $Y=0.135 $X2=0.351 $Y2=0.135
r14 70 71 2.68168 $w=1.3e-08 $l=1.15e-08 $layer=M1 $thickness=3.6e-08 $X=0.513
+ $Y=0.1235 $X2=0.513 $Y2=0.135
r15 69 70 3.61444 $w=1.3e-08 $l=1.55e-08 $layer=M1 $thickness=3.6e-08 $X=0.513
+ $Y=0.108 $X2=0.513 $Y2=0.1235
r16 68 69 3.61444 $w=1.3e-08 $l=1.55e-08 $layer=M1 $thickness=3.6e-08 $X=0.513
+ $Y=0.0925 $X2=0.513 $Y2=0.108
r17 67 68 2.09871 $w=1.3e-08 $l=9e-09 $layer=M1 $thickness=3.6e-08 $X=0.513
+ $Y=0.0835 $X2=0.513 $Y2=0.0925
r18 66 67 2.09871 $w=1.3e-08 $l=9e-09 $layer=M1 $thickness=3.6e-08 $X=0.513
+ $Y=0.0745 $X2=0.513 $Y2=0.0835
r19 24 66 0.816164 $w=1.3e-08 $l=3.5e-09 $layer=M1 $thickness=3.6e-08 $X=0.513
+ $Y=0.071 $X2=0.513 $Y2=0.0745
r20 15 61 1.03257 $w=2.06696e-08 $l=1.15e-08 $layer=M1 $thickness=3.6e-08
+ $X=0.314 $Y=0.135 $X2=0.314 $Y2=0.1235
r21 15 23 2.6649 $w=1.54324e-08 $l=1.85e-08 $layer=M1 $thickness=3.6e-08
+ $X=0.314 $Y=0.135 $X2=0.3325 $Y2=0.135
r22 64 67 19.5347 $a=3.24e-16 $layer=V1 $X=0.513 $Y=0.081 $X2=0.513 $Y2=0.0835
r23 63 64 23.2024 $w=1.3e-08 $l=9.95e-08 $layer=M2 $thickness=3.6e-08 $X=0.4135
+ $Y=0.081 $X2=0.513 $Y2=0.081
r24 62 63 23.2024 $w=1.3e-08 $l=9.95e-08 $layer=M2 $thickness=3.6e-08 $X=0.314
+ $Y=0.081 $X2=0.4135 $Y2=0.081
r25 25 62 2.91487 $w=1.3e-08 $l=1.25e-08 $layer=M2 $thickness=3.6e-08 $X=0.3015
+ $Y=0.081 $X2=0.314 $Y2=0.081
r26 60 61 3.61444 $w=1.3e-08 $l=1.55e-08 $layer=M1 $thickness=3.6e-08 $X=0.314
+ $Y=0.108 $X2=0.314 $Y2=0.1235
r27 59 60 3.61444 $w=1.3e-08 $l=1.55e-08 $layer=M1 $thickness=3.6e-08 $X=0.314
+ $Y=0.0925 $X2=0.314 $Y2=0.108
r28 22 59 1.16595 $w=1.3e-08 $l=5e-09 $layer=M1 $thickness=3.6e-08 $X=0.314
+ $Y=0.0875 $X2=0.314 $Y2=0.0925
r29 22 58 0.991152 $w=1.60769e-08 $l=6.5e-09 $layer=M1 $thickness=3.6e-08
+ $X=0.314 $Y=0.0875 $X2=0.314 $Y2=0.081
r30 22 62 70.3248 $a=9e-17 $layer=V1 $X=0.314 $Y=0.0875 $X2=0.314 $Y2=0.081
r31 58 62 27.048 $a=2.34e-16 $layer=V1 $X=0.314 $Y=0.081 $X2=0.314 $Y2=0.081
r32 56 58 0.663289 $w=1.8e-08 $l=6.5e-09 $layer=M1 $thickness=3.6e-08 $X=0.314
+ $Y=0.0745 $X2=0.314 $Y2=0.081
r33 14 56 0.357156 $w=1.8e-08 $l=3.5e-09 $layer=M1 $thickness=3.6e-08 $X=0.314
+ $Y=0.071 $X2=0.314 $Y2=0.0745
r34 14 57 0.255111 $w=1.8e-08 $l=2.5e-09 $layer=M1 $thickness=3.6e-08 $X=0.314
+ $Y=0.071 $X2=0.314 $Y2=0.0685
r35 55 56 5.96826 $w=1.3463e-08 $l=3.35336e-08 $layer=M1 $thickness=3.6e-08
+ $X=0.2805 $Y=0.076 $X2=0.314 $Y2=0.0745
r36 55 57 5.86622 $w=1.32885e-08 $l=3.43293e-08 $layer=M1 $thickness=3.6e-08
+ $X=0.2805 $Y=0.076 $X2=0.314 $Y2=0.0685
r37 55 58 6.12133 $w=1.37018e-08 $l=3.38711e-08 $layer=M1 $thickness=3.6e-08
+ $X=0.2805 $Y=0.076 $X2=0.314 $Y2=0.081
r38 21 55 8.62802 $w=1.3e-08 $l=3.7e-08 $layer=M1 $thickness=3.6e-08 $X=0.2435
+ $Y=0.076 $X2=0.2805 $Y2=0.076
r39 13 20 3.33042 $w=1.5027e-08 $l=1.85e-08 $layer=M1 $thickness=3.6e-08
+ $X=0.222 $Y=0.0745 $X2=0.222 $Y2=0.056
r40 13 21 3.68021 $w=1.4875e-08 $l=2.15523e-08 $layer=M1 $thickness=3.6e-08
+ $X=0.222 $Y=0.0745 $X2=0.2435 $Y2=0.076
r41 12 53 2.89809 $w=1.53077e-08 $l=1.95e-08 $layer=M1 $thickness=3.6e-08
+ $X=0.222 $Y=0.036 $X2=0.2025 $Y2=0.036
r42 12 20 3.01468 $w=1.741e-08 $l=2e-08 $layer=M1 $thickness=3.6e-08 $X=0.222
+ $Y=0.036 $X2=0.222 $Y2=0.056
r43 52 53 4.5472 $w=1.3e-08 $l=1.95e-08 $layer=M1 $thickness=3.6e-08 $X=0.183
+ $Y=0.036 $X2=0.2025 $Y2=0.036
r44 51 52 5.59655 $w=1.3e-08 $l=2.4e-08 $layer=M1 $thickness=3.6e-08 $X=0.159
+ $Y=0.036 $X2=0.183 $Y2=0.036
r45 50 51 5.59655 $w=1.3e-08 $l=2.4e-08 $layer=M1 $thickness=3.6e-08 $X=0.135
+ $Y=0.036 $X2=0.159 $Y2=0.036
r46 49 50 4.31401 $w=1.3e-08 $l=1.85e-08 $layer=M1 $thickness=3.6e-08 $X=0.1165
+ $Y=0.036 $X2=0.135 $Y2=0.036
r47 48 49 3.96423 $w=1.3e-08 $l=1.7e-08 $layer=M1 $thickness=3.6e-08 $X=0.0995
+ $Y=0.036 $X2=0.1165 $Y2=0.036
r48 47 48 3.38125 $w=1.3e-08 $l=1.45e-08 $layer=M1 $thickness=3.6e-08 $X=0.085
+ $Y=0.036 $X2=0.0995 $Y2=0.036
r49 18 47 6.52931 $w=1.3e-08 $l=2.8e-08 $layer=M1 $thickness=3.6e-08 $X=0.057
+ $Y=0.036 $X2=0.085 $Y2=0.036
r50 10 43 4.76361 $w=1.62073e-08 $l=2.75e-08 $layer=M1 $thickness=3.6e-08
+ $X=0.027 $Y=0.036 $X2=0.027 $Y2=0.0635
r51 10 18 5.34658 $w=1.45e-08 $l=3e-08 $layer=M1 $thickness=3.6e-08 $X=0.027
+ $Y=0.036 $X2=0.057 $Y2=0.036
r52 42 43 8.86121 $w=1.3e-08 $l=3.8e-08 $layer=M1 $thickness=3.6e-08 $X=0.027
+ $Y=0.1015 $X2=0.027 $Y2=0.0635
r53 16 42 5.13018 $w=1.3e-08 $l=2.2e-08 $layer=M1 $thickness=3.6e-08 $X=0.027
+ $Y=0.1235 $X2=0.027 $Y2=0.1015
r54 11 19 3.1337 $w=1.54324e-08 $l=1.85e-08 $layer=M1 $thickness=3.6e-08
+ $X=0.027 $Y=0.135 $X2=0.0455 $Y2=0.135
r55 11 16 1.50137 $w=1.6913e-08 $l=1.15e-08 $layer=M1 $thickness=3.6e-08
+ $X=0.027 $Y=0.135 $X2=0.027 $Y2=0.1235
r56 11 17 6.16517 $w=1.44286e-08 $l=3.15e-08 $layer=M1 $thickness=3.6e-08
+ $X=0.027 $Y=0.135 $X2=0.027 $Y2=0.1665
r57 40 19 4.31401 $w=1.3e-08 $l=1.85e-08 $layer=M1 $thickness=3.6e-08 $X=0.06
+ $Y=0.136 $X2=0.0455 $Y2=0.135
r58 40 38 19.3796 $a=3.24e-16 $layer=V0LIG $X=0.06 $Y=0.136 $X2=0.063 $Y2=0.135
r59 1 36 2.6116 $w=2.2e-08 $l=1e-08 $layer=LIG $thickness=4.8e-08 $X=0.072
+ $Y=0.135 $X2=0.082 $Y2=0.135
r60 1 38 4.98695 $w=1.60444e-08 $l=9e-09 $layer=LIG $thickness=4.8e-08 $X=0.072
+ $Y=0.135 $X2=0.063 $Y2=0.135
r61 34 33 14.6259 $w=2.1e-08 $l=4.3e-08 $layer=Gate_1 $thickness=5.6e-08
+ $X=0.081 $Y=0.2025 $X2=0.081 $Y2=0.1595
r62 32 33 2.7211 $w=2.1e-08 $l=8e-09 $layer=Gate_1 $thickness=5.6e-08 $X=0.081
+ $Y=0.1515 $X2=0.081 $Y2=0.1595
r63 31 32 5.79936 $w=2.03333e-08 $l=1.65e-08 $layer=Gate_1 $thickness=5.6e-08
+ $X=0.081 $Y=0.135 $X2=0.081 $Y2=0.1515
r64 31 36 6.27904 $w=2.09e-08 $l=1e-09 $layer=Gate_1 $thickness=5.24e-08
+ $X=0.081 $Y=0.135 $X2=0.082 $Y2=0.135
r65 30 31 5.79936 $w=2.03333e-08 $l=1.65e-08 $layer=Gate_1 $thickness=5.6e-08
+ $X=0.081 $Y=0.1185 $X2=0.081 $Y2=0.135
r66 29 30 2.7211 $w=2.1e-08 $l=8e-09 $layer=Gate_1 $thickness=5.6e-08 $X=0.081
+ $Y=0.1105 $X2=0.081 $Y2=0.1185
r67 28 29 14.6259 $w=2.1e-08 $l=4.3e-08 $layer=Gate_1 $thickness=5.6e-08
+ $X=0.081 $Y=0.0675 $X2=0.081 $Y2=0.1105
r68 28 7 14.6259 $w=2.1e-08 $l=4.3e-08 $layer=Gate_1 $thickness=5.6e-08
+ $X=0.081 $Y=0.0675 $X2=0.081 $Y2=0.0245
.ends

.subckt PM_XNOR2x1_ASAP7_75t_R%5 vss 21 25 36 39 51 58 59 12 1 17 4 20 19 16 3
+ 10 9 11 13 15
c1 1 vss 0.00738448f $X=0.3955 $Y=0.135
c2 3 vss 0.00928836f $X=0.108 $Y=0.2025
c3 4 vss 0.0112241f $X=0.175 $Y=0.0675
c4 9 vss 0.081184f $X=0.405 $Y=0.0245
c5 10 vss 0.0810039f $X=0.459 $Y=0.135
c6 11 vss 0.0418527f $X=0.1475 $Y=0.0675
c7 12 vss 0.0088134f $X=0.0935 $Y=0.2025
c8 13 vss 0.00046522f $X=0.1835 $Y=0.198
c9 14 vss 0.00295923f $X=0.1835 $Y=0.234
c10 15 vss 0.000442314f $X=0.405 $Y=0.198
c11 16 vss 0.00884044f $X=0.159 $Y=0.234
c12 17 vss 0.00215864f $X=0.183 $Y=0.1665
c13 18 vss 0.000706291f $X=0.1835 $Y=0.216
c14 19 vss 0.00602356f $X=0.3805 $Y=0.198
c15 20 vss 0.00141658f $X=0.405 $Y=0.135
r1 59 57 0.0308642 $w=8.1e-08 $l=2.5e-09 $layer=P_src_drn $thickness=1e-09
+ $X=0.1253 $Y=0.2025 $X2=0.1225 $Y2=0.2025
r2 3 57 0.179012 $w=8.1e-08 $l=1.45e-08 $layer=P_src_drn $thickness=1e-09
+ $X=0.108 $Y=0.2025 $X2=0.1225 $Y2=0.2025
r3 12 3 0.179012 $w=8.1e-08 $l=1.45e-08 $layer=P_src_drn $thickness=1e-09
+ $X=0.0935 $Y=0.2025 $X2=0.108 $Y2=0.2025
r4 58 12 0.0308642 $w=8.1e-08 $l=2.5e-09 $layer=P_src_drn $thickness=1e-09
+ $X=0.0906 $Y=0.2025 $X2=0.0935 $Y2=0.2025
r5 3 52 19.3796 $a=3.24e-16 $layer=V0LISD $X=0.108 $Y=0.2025 $X2=0.112 $Y2=0.234
r6 52 53 4.31401 $w=1.3e-08 $l=1.85e-08 $layer=M1 $thickness=3.6e-08 $X=0.112
+ $Y=0.234 $X2=0.1305 $Y2=0.234
r7 16 53 6.64591 $w=1.3e-08 $l=2.85e-08 $layer=M1 $thickness=3.6e-08 $X=0.159
+ $Y=0.234 $X2=0.1305 $Y2=0.234
r8 11 4 0.154321 $w=8.1e-08 $l=1.25e-08 $layer=N_src_drn $thickness=1e-09
+ $X=0.1475 $Y=0.0675 $X2=0.175 $Y2=0.0675
r9 51 11 0.0308642 $w=8.1e-08 $l=2.5e-09 $layer=N_src_drn $thickness=1e-09
+ $X=0.1446 $Y=0.0675 $X2=0.1475 $Y2=0.0675
r10 14 18 2.23928 $w=1.65e-08 $l=1.8e-08 $layer=M1 $thickness=3.6e-08 $X=0.1835
+ $Y=0.234 $X2=0.1835 $Y2=0.216
r11 14 16 3.94193 $w=1.70327e-08 $l=2.45e-08 $layer=M1 $thickness=3.6e-08
+ $X=0.1835 $Y=0.234 $X2=0.159 $Y2=0.234
r12 4 47 19.3796 $a=3.24e-16 $layer=V0LISD $X=0.175 $Y=0.0675 $X2=0.183
+ $Y2=0.096
r13 47 48 3.96423 $w=1.3e-08 $l=1.7e-08 $layer=M1 $thickness=3.6e-08 $X=0.183
+ $Y=0.096 $X2=0.183 $Y2=0.113
r14 45 48 4.5472 $w=1.3e-08 $l=1.95e-08 $layer=M1 $thickness=3.6e-08 $X=0.183
+ $Y=0.1325 $X2=0.183 $Y2=0.113
r15 17 45 7.92845 $w=1.3e-08 $l=3.4e-08 $layer=M1 $thickness=3.6e-08 $X=0.183
+ $Y=0.1665 $X2=0.183 $Y2=0.1325
r16 13 44 3.27685 $w=1.54359e-08 $l=1.95e-08 $layer=M1 $thickness=3.6e-08
+ $X=0.1835 $Y=0.198 $X2=0.203 $Y2=0.198
r17 13 17 6.19173 $w=1.44844e-08 $l=3.1504e-08 $layer=M1 $thickness=3.6e-08
+ $X=0.1835 $Y=0.198 $X2=0.183 $Y2=0.1665
r18 13 18 2.64331 $w=1.65e-08 $l=1.8e-08 $layer=M1 $thickness=3.6e-08 $X=0.1835
+ $Y=0.198 $X2=0.1835 $Y2=0.216
r19 43 44 7.34548 $w=1.3e-08 $l=3.15e-08 $layer=M1 $thickness=3.6e-08 $X=0.2345
+ $Y=0.198 $X2=0.203 $Y2=0.198
r20 42 43 10.7267 $w=1.3e-08 $l=4.6e-08 $layer=M1 $thickness=3.6e-08 $X=0.2805
+ $Y=0.198 $X2=0.2345 $Y2=0.198
r21 41 42 12.7088 $w=1.3e-08 $l=5.45e-08 $layer=M1 $thickness=3.6e-08 $X=0.335
+ $Y=0.198 $X2=0.2805 $Y2=0.198
r22 19 41 10.6101 $w=1.3e-08 $l=4.55e-08 $layer=M1 $thickness=3.6e-08 $X=0.3805
+ $Y=0.198 $X2=0.335 $Y2=0.198
r23 15 34 5.69636 $w=1.58e-08 $l=3.15e-08 $layer=M1 $thickness=3.6e-08 $X=0.405
+ $Y=0.198 $X2=0.405 $Y2=0.1665
r24 15 19 4.06404 $w=1.48367e-08 $l=2.45e-08 $layer=M1 $thickness=3.6e-08
+ $X=0.405 $Y=0.198 $X2=0.3805 $Y2=0.198
r25 39 38 16.4967 $w=2.1e-08 $l=4.85e-08 $layer=Gate_1 $thickness=5.6e-08
+ $X=0.459 $Y=0.2025 $X2=0.459 $Y2=0.154
r26 36 37 16.4967 $w=2.1e-08 $l=4.85e-08 $layer=Gate_1 $thickness=5.6e-08
+ $X=0.459 $Y=0.0675 $X2=0.459 $Y2=0.116
r27 10 31 6.54019 $w=2.09524e-08 $layer=Gate_1 $thickness=5.21905e-08 $X=0.459
+ $Y=0.135 $X2=0.459 $Y2=0.135
r28 10 37 6.6497 $w=2.04211e-08 $l=1.9e-08 $layer=Gate_1 $thickness=5.6e-08
+ $X=0.459 $Y=0.135 $X2=0.459 $Y2=0.116
r29 10 38 6.6497 $w=2.04211e-08 $l=1.9e-08 $layer=Gate_1 $thickness=5.6e-08
+ $X=0.459 $Y=0.135 $X2=0.459 $Y2=0.154
r30 20 27 19.3796 $a=3.24e-16 $layer=V0LIG $X=0.405 $Y=0.135 $X2=0.405 $Y2=0.135
r31 20 34 7.34548 $w=1.3e-08 $l=3.15e-08 $layer=M1 $thickness=3.6e-08 $X=0.405
+ $Y=0.135 $X2=0.405 $Y2=0.1665
r32 30 31 12.6539 $w=1.77815e-08 $l=2.7e-08 $layer=LIG $thickness=4.8e-08
+ $X=0.432 $Y=0.135 $X2=0.459 $Y2=0.135
r33 28 30 10.1729 $w=1.54914e-08 $l=1.75e-08 $layer=LIG $thickness=4.8e-08
+ $X=0.4145 $Y=0.135 $X2=0.432 $Y2=0.135
r34 27 28 2.48102 $w=2.2e-08 $l=9.5e-09 $layer=LIG $thickness=4.8e-08 $X=0.405
+ $Y=0.135 $X2=0.4145 $Y2=0.135
r35 1 27 2.48102 $w=2.2e-08 $l=9.5e-09 $layer=LIG $thickness=4.8e-08 $X=0.3955
+ $Y=0.135 $X2=0.405 $Y2=0.135
r36 25 24 16.4967 $w=2.1e-08 $l=4.85e-08 $layer=Gate_1 $thickness=5.6e-08
+ $X=0.405 $Y=0.2025 $X2=0.405 $Y2=0.154
r37 23 24 6.6497 $w=2.04211e-08 $l=1.9e-08 $layer=Gate_1 $thickness=5.6e-08
+ $X=0.405 $Y=0.135 $X2=0.405 $Y2=0.154
r38 23 28 4.05918 $w=2.0087e-08 $l=9.5e-09 $layer=Gate_1 $thickness=5.56522e-08
+ $X=0.405 $Y=0.135 $X2=0.4145 $Y2=0.135
r39 23 27 6.27904 $w=2.09e-08 $layer=Gate_1 $thickness=5.24e-08 $X=0.405
+ $Y=0.135 $X2=0.405 $Y2=0.135
r40 22 23 6.6497 $w=2.04211e-08 $l=1.9e-08 $layer=Gate_1 $thickness=5.6e-08
+ $X=0.405 $Y=0.116 $X2=0.405 $Y2=0.135
r41 21 22 16.4967 $w=2.1e-08 $l=4.85e-08 $layer=Gate_1 $thickness=5.6e-08
+ $X=0.405 $Y=0.0675 $X2=0.405 $Y2=0.116
r42 21 9 14.6259 $w=2.1e-08 $l=4.3e-08 $layer=Gate_1 $thickness=5.6e-08
+ $X=0.405 $Y=0.0675 $X2=0.405 $Y2=0.0245
.ends

* End of included file XNOR2x1_ASAP7_75t_R.pex.sp.pex

*
.subckt XNOR2x1_ASAP7_75t_CUSTOM_4_25_0_7 VSS VDD B A Y
*
* VSS VSS
* VDD VDD
* B B
* A A
* Y Y
*
*

M0 N_M0_d N_M0_g VSS VSS nmos_rvt L=2e-08 W=8.1e-08 nfin=3 $X=0.071 $Y=0.027
M1 N_M1_d N_M1_g N_M1_s VSS nmos_rvt L=2e-08 W=8.1e-08 nfin=3 $X=0.125 $Y=0.027
M2 VSS N_M2_g noxref_6 VSS nmos_rvt L=2e-08 W=8.1e-08 nfin=3 $X=0.287 $Y=0.027
M3 noxref_6 N_M3_g VSS VSS nmos_rvt L=2e-08 W=8.1e-08 nfin=3 $X=0.341 $Y=0.027
M4 N_M4_d N_M4_g noxref_6 VSS nmos_rvt L=2e-08 W=8.1e-08 nfin=3 $X=0.395
+ $Y=0.027
M5 N_M5_d N_M5_g noxref_6 VSS nmos_rvt L=2e-08 W=8.1e-08 nfin=3 $X=0.449
+ $Y=0.027
M6 noxref_6 N_M6_g VSS VSS nmos_rvt L=2e-08 W=8.1e-08 nfin=3 $X=0.503 $Y=0.027
M7 VSS N_M7_g noxref_6 VSS nmos_rvt L=2e-08 W=8.1e-08 nfin=3 $X=0.557 $Y=0.027
M8 N_M8_d N_M8_g VDD VDD pmos_rvt L=2e-08 W=8.1e-08 nfin=3 $X=0.071 $Y=0.162
M9 VDD N_M9_g N_M9_s VDD pmos_rvt L=2e-08 W=8.1e-08 nfin=3 $X=0.125 $Y=0.162
M10 N_M10_d N_M10_g noxref_9 VDD pmos_rvt L=2e-08 W=8.1e-08 nfin=3 $X=0.287
+ $Y=0.162
M11 noxref_9 N_M11_g VDD VDD pmos_rvt L=2e-08 W=8.1e-08 nfin=3 $X=0.341 $Y=0.162
M12 N_M12_d N_M12_g VDD VDD pmos_rvt L=2e-08 W=8.1e-08 nfin=3 $X=0.395 $Y=0.162
M13 N_M13_d N_M13_g VDD VDD pmos_rvt L=2e-08 W=8.1e-08 nfin=3 $X=0.449 $Y=0.162
M14 noxref_10 N_M14_g VDD VDD pmos_rvt L=2e-08 W=8.1e-08 nfin=3 $X=0.503
+ $Y=0.162
M15 N_M15_d N_M15_g noxref_10 VDD pmos_rvt L=2e-08 W=8.1e-08 nfin=3 $X=0.557
+ $Y=0.162

* .include "XNOR2x1_ASAP7_75t_R.pex.sp.pxi"

* Start of included file XNOR2x1_ASAP7_75t_R.pex.sp.pxi
x_PM_XNOR2x1_ASAP7_75t_R%8 vss N_M0_d N_M1_s N_8_1 PM_XNOR2x1_ASAP7_75t_R%8
cc_1 N_8_1 N_B_7 0.0167478f $X=0.108 $Y=0.0675
cc_2 N_8_1 N_A_5 0.0166373f $X=0.108 $Y=0.0675
x_PM_XNOR2x1_ASAP7_75t_R%A vss A N_M2_g N_M10_g N_M1_g N_M9_g N_M7_g N_M15_g
+ N_A_1 N_A_8 N_A_10 N_A_11 N_A_9 N_A_2 N_A_12 N_A_6 N_A_5 N_A_7
+ PM_XNOR2x1_ASAP7_75t_R%A
cc_3 N_A_1 N_B_9 0.000128381f $X=0.297 $Y=0.135
cc_4 N_A_8 N_B_9 0.000134197f $X=0.135 $Y=0.198
cc_5 N_A_1 N_B_2 0.000807347f $X=0.297 $Y=0.135
cc_6 N_A_10 N_B_16 0.000184597f $X=0.135 $Y=0.1265
cc_7 N_A_1 N_B_1 0.00158272f $X=0.297 $Y=0.135
cc_8 N_A_11 N_B_24 0.00298209f $X=0.567 $Y=0.166
cc_9 N_A_1 N_B_22 0.000339273f $X=0.297 $Y=0.135
cc_10 N_A_8 N_B_19 0.000376791f $X=0.135 $Y=0.198
cc_11 N_A_9 N_B_24 0.000384563f $X=0.567 $Y=0.198
cc_12 N_A_1 N_B_23 0.0004219f $X=0.297 $Y=0.135
cc_13 N_A_8 N_B_17 0.000435453f $X=0.135 $Y=0.198
cc_14 N_A_1 N_B_15 0.000484631f $X=0.297 $Y=0.135
cc_15 N_A_1 N_B_21 0.000514815f $X=0.297 $Y=0.135
cc_16 N_A_10 N_B_18 0.00061454f $X=0.135 $Y=0.1265
cc_17 N_A_2 N_B_3 0.00218837f $X=0.567 $Y=0.135
cc_18 N_A_10 N_B_19 0.00161511f $X=0.135 $Y=0.1265
cc_19 N_A_12 N_B_25 0.00215205f $X=0.1235 $Y=0.189
cc_20 N_A_1 N_B_13 0.00224264f $X=0.297 $Y=0.135
cc_21 N_A_12 N_B_23 0.00389346f $X=0.1235 $Y=0.189
cc_22 N_A_6 N_B_8 0.00489556f $X=0.297 $Y=0.0245
cc_23 N_A_5 N_B_7 0.00497672f $X=0.135 $Y=0.135
cc_24 N_A_7 N_B_9 0.00548301f $X=0.567 $Y=0.135
x_PM_XNOR2x1_ASAP7_75t_R%Y vss Y N_M4_d N_M5_d N_M12_d N_M13_d N_M10_d N_M15_d
+ N_Y_20 N_Y_17 N_Y_16 N_Y_1 N_Y_4 N_Y_14 N_Y_19 N_Y_21 N_Y_15 N_Y_13 N_Y_2
+ N_Y_3 PM_XNOR2x1_ASAP7_75t_R%Y
cc_25 N_Y_20 N_B_2 0.000414377f $X=0.459 $Y=0.108
cc_26 N_Y_20 N_B_3 0.000603823f $X=0.459 $Y=0.108
cc_27 N_Y_20 N_B_9 0.00019658f $X=0.459 $Y=0.108
cc_28 N_Y_20 N_B_23 0.000475246f $X=0.459 $Y=0.108
cc_29 N_Y_20 N_B_8 0.000388783f $X=0.459 $Y=0.108
cc_30 N_Y_17 N_B_24 0.000635807f $X=0.4205 $Y=0.086
cc_31 N_Y_17 N_B_25 0.00194877f $X=0.4205 $Y=0.086
cc_32 N_Y_20 N_B_24 0.004807f $X=0.459 $Y=0.108
cc_33 N_Y_16 N_A_9 0.000590221f $X=0.5795 $Y=0.2025
cc_34 N_Y_16 N_A_2 0.00123985f $X=0.5795 $Y=0.2025
cc_35 N_Y_16 N_A_6 0.000422611f $X=0.5795 $Y=0.2025
cc_36 N_Y_16 N_A_11 0.000722988f $X=0.5795 $Y=0.2025
cc_37 N_Y_20 N_A_12 0.00146251f $X=0.459 $Y=0.108
cc_38 N_Y_1 N_A_6 0.00163697f $X=0.27 $Y=0.2025
cc_39 N_Y_4 N_A_7 0.00175638f $X=0.594 $Y=0.2025
cc_40 N_Y_14 N_A_1 0.0021614f $X=0.272 $Y=0.2025
cc_41 N_Y_19 N_A_12 0.00414423f $X=0.4205 $Y=0.234
cc_42 N_Y_21 N_A_9 0.00613475f $X=0.486 $Y=0.234
cc_43 N_Y_14 N_A_6 0.0340209f $X=0.272 $Y=0.2025
cc_44 N_Y_16 N_A_7 0.0345694f $X=0.5795 $Y=0.2025
cc_45 N_Y_15 N_5_19 0.000590242f $X=0.4175 $Y=0.2025
cc_46 N_Y_15 N_5_1 0.000646683f $X=0.4175 $Y=0.2025
cc_47 N_Y_15 N_5_10 0.0374751f $X=0.4175 $Y=0.2025
cc_48 N_Y_13 N_5_9 0.0296163f $X=0.4175 $Y=0.0675
cc_49 N_Y_1 N_5_19 0.00115213f $X=0.27 $Y=0.2025
cc_50 N_Y_2 N_5_10 0.00143404f $X=0.432 $Y=0.0675
cc_51 N_Y_19 N_5_15 0.00151231f $X=0.4205 $Y=0.234
cc_52 N_Y_3 N_5_9 0.00189845f $X=0.432 $Y=0.2025
cc_53 N_Y_20 N_5_20 0.00387878f $X=0.459 $Y=0.108
cc_54 N_Y_13 N_5_1 0.00496712f $X=0.4175 $Y=0.0675
cc_55 N_Y_19 N_5_19 0.0108523f $X=0.4205 $Y=0.234
cc_56 N_Y_15 N_5_9 0.0670844f $X=0.4175 $Y=0.2025
x_PM_XNOR2x1_ASAP7_75t_R%B vss B N_M0_g N_M8_g N_M6_g N_M14_g N_M3_g N_M11_g
+ N_B_9 N_B_2 N_B_16 N_B_1 N_B_24 N_B_22 N_B_19 N_B_23 N_B_17 N_B_15 N_B_21
+ N_B_18 N_B_3 N_B_25 N_B_13 N_B_8 N_B_7 N_B_20 PM_XNOR2x1_ASAP7_75t_R%B
x_PM_XNOR2x1_ASAP7_75t_R%5 vss N_M4_g N_M12_g N_M5_g N_M13_g N_M1_d N_M8_d
+ N_M9_s N_5_12 N_5_1 N_5_17 N_5_4 N_5_20 N_5_19 N_5_16 N_5_3 N_5_10 N_5_9
+ N_5_11 N_5_13 N_5_15 PM_XNOR2x1_ASAP7_75t_R%5
cc_57 N_5_12 N_B_19 0.000160761f $X=0.0935 $Y=0.2025
cc_58 N_5_12 N_B_1 0.00112622f $X=0.0935 $Y=0.2025
cc_59 N_5_12 N_B_22 0.00026318f $X=0.0935 $Y=0.2025
cc_60 N_5_12 N_B_20 0.000335717f $X=0.0935 $Y=0.2025
cc_61 N_5_1 N_B_23 0.000361299f $X=0.3955 $Y=0.135
cc_62 N_5_1 N_B_3 0.00039407f $X=0.3955 $Y=0.135
cc_63 N_5_17 N_B_21 0.000438309f $X=0.183 $Y=0.1665
cc_64 N_5_4 N_B_13 0.0004651f $X=0.175 $Y=0.0675
cc_65 N_5_20 N_B_25 0.000489054f $X=0.405 $Y=0.135
cc_66 N_5_19 N_B_15 0.000510249f $X=0.3805 $Y=0.198
cc_67 N_5_1 N_B_2 0.00173949f $X=0.3955 $Y=0.135
cc_68 N_5_16 N_B_17 0.000838083f $X=0.159 $Y=0.234
cc_69 N_5_3 N_B_7 0.00094974f $X=0.108 $Y=0.2025
cc_70 N_5_19 N_B_23 0.00198254f $X=0.3805 $Y=0.198
cc_71 N_5_20 N_B_23 0.00225339f $X=0.405 $Y=0.135
cc_72 N_5_17 N_B_13 0.002721f $X=0.183 $Y=0.1665
cc_73 N_5_10 N_B_9 0.00335626f $X=0.459 $Y=0.135
cc_74 N_5_9 N_B_8 0.00343721f $X=0.405 $Y=0.0245
cc_75 N_5_4 N_B_18 0.0038005f $X=0.175 $Y=0.0675
cc_76 N_5_12 N_B_7 0.0351056f $X=0.0935 $Y=0.2025
cc_77 N_5_11 N_A_12 0.000293197f $X=0.1475 $Y=0.0675
cc_78 N_5_11 N_A_8 0.000728404f $X=0.1475 $Y=0.0675
cc_79 N_5_16 N_A_8 0.0050339f $X=0.159 $Y=0.234
cc_80 N_5_4 N_A_1 0.00554015f $X=0.175 $Y=0.0675
cc_81 N_5_20 N_A_12 0.000648031f $X=0.405 $Y=0.135
cc_82 N_5_13 N_A_8 0.000661472f $X=0.1835 $Y=0.198
cc_83 N_5_3 N_A_1 0.000840914f $X=0.108 $Y=0.2025
cc_84 N_5_3 N_A_5 0.00146324f $X=0.108 $Y=0.2025
cc_85 N_5_4 N_A_5 0.00250938f $X=0.175 $Y=0.0675
cc_86 N_5_12 N_A_5 0.0146078f $X=0.0935 $Y=0.2025
cc_87 N_5_17 N_A_10 0.00537305f $X=0.183 $Y=0.1665
cc_88 N_5_19 N_A_12 0.00745513f $X=0.3805 $Y=0.198
cc_89 N_5_11 N_A_5 0.0549547f $X=0.1475 $Y=0.0675

* End of included file XNOR2x1_ASAP7_75t_R.pex.sp.pxi
.ends

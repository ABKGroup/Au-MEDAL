.subckt PM_NOR2x1_ASAP7_75t_R%A vss 31 11 15 28 1 7 10 4 9 3
c1 1 vss 0.00766139f $X=0.135 $Y=0.1355
c2 3 vss 0.0554686f $X=0.081 $Y=0.1355
c3 4 vss 0.0826508f $X=0.135 $Y=0.0245
c4 5 vss 0.00854478f $X=0.027 $Y=0.036
c5 6 vss 0.0018614f $X=0.027 $Y=0.135
c6 7 vss 0.00533967f $X=0.027 $Y=0.198
c7 8 vss 0.0101973f $X=0.027 $Y=0.1035
c8 9 vss 0.00539265f $X=0.027 $Y=0.1665
c9 10 vss 0.00271867f $X=0.0455 $Y=0.135
r1 7 9 6.16517 $w=1.44286e-08 $l=3.15e-08 $layer=M1 $thickness=3.6e-08 $X=0.027
+ $Y=0.198 $X2=0.027 $Y2=0.1665
r2 5 34 3.01711 $w=1.55e-08 $l=1.8e-08 $layer=M1 $thickness=3.6e-08 $X=0.027
+ $Y=0.036 $X2=0.027 $Y2=0.054
r3 33 34 4.19742 $w=1.3e-08 $l=1.8e-08 $layer=M1 $thickness=3.6e-08 $X=0.027
+ $Y=0.072 $X2=0.027 $Y2=0.054
r4 8 33 7.34548 $w=1.3e-08 $l=3.15e-08 $layer=M1 $thickness=3.6e-08 $X=0.027
+ $Y=0.1035 $X2=0.027 $Y2=0.072
r5 6 10 3.1337 $w=1.54324e-08 $l=1.85e-08 $layer=M1 $thickness=3.6e-08 $X=0.027
+ $Y=0.135 $X2=0.0455 $Y2=0.135
r6 6 8 6.16517 $w=1.44286e-08 $l=3.15e-08 $layer=M1 $thickness=3.6e-08 $X=0.027
+ $Y=0.135 $X2=0.027 $Y2=0.1035
r7 6 9 6.16517 $w=1.44286e-08 $l=3.15e-08 $layer=M1 $thickness=3.6e-08 $X=0.027
+ $Y=0.135 $X2=0.027 $Y2=0.1665
r8 31 30 2.79828 $w=1.3e-08 $l=1.2e-08 $layer=M1 $thickness=3.6e-08 $X=0.07
+ $Y=0.134 $X2=0.058 $Y2=0.135
r9 10 30 2.91487 $w=1.3e-08 $l=1.25e-08 $layer=M1 $thickness=3.6e-08 $X=0.0455
+ $Y=0.135 $X2=0.058 $Y2=0.135
r10 28 27 14.6259 $w=2.1e-08 $l=4.3e-08 $layer=Gate_1 $thickness=5.6e-08
+ $X=0.081 $Y=0.2025 $X2=0.081 $Y2=0.1595
r11 26 27 2.55104 $w=2.1e-08 $l=7.5e-09 $layer=Gate_1 $thickness=5.6e-08
+ $X=0.081 $Y=0.152 $X2=0.081 $Y2=0.1595
r12 3 20 4.10717 $w=2e-08 $layer=Gate_1 $thickness=5.6e-08 $X=0.081 $Y=0.1355
+ $X2=0.081 $Y2=0.1355
r13 3 26 5.80786 $w=2.0303e-08 $l=1.65e-08 $layer=Gate_1 $thickness=5.6e-08
+ $X=0.081 $Y=0.1355 $X2=0.081 $Y2=0.152
r14 31 22 19.3796 $a=3.24e-16 $layer=V0LIG $X=0.07 $Y=0.134 $X2=0.066 $Y2=0.1355
r15 19 20 1.4198 $w=2.3e-08 $l=4e-09 $layer=LIG $thickness=4.8e-08 $X=0.085
+ $Y=0.1355 $X2=0.081 $Y2=0.1355
r16 18 19 2.36633 $w=2.3e-08 $l=1e-08 $layer=LIG $thickness=4.8e-08 $X=0.075
+ $Y=0.1355 $X2=0.085 $Y2=0.1355
r17 18 22 3.23868 $w=1.92778e-08 $l=9e-09 $layer=LIG $thickness=4.8e-08
+ $X=0.075 $Y=0.1355 $X2=0.066 $Y2=0.1355
r18 17 19 9.21311 $w=1.80478e-08 $l=2.3e-08 $layer=LIG $thickness=4.8e-08
+ $X=0.108 $Y=0.1355 $X2=0.085 $Y2=0.1355
r19 1 13 6.4735 $w=2.13953e-08 $layer=Gate_1 $thickness=5.22791e-08 $X=0.135
+ $Y=0.1355 $X2=0.135 $Y2=0.1355
r20 1 17 10.1596 $w=1.87815e-08 $l=2.7e-08 $layer=LIG $thickness=4.8e-08
+ $X=0.135 $Y=0.1355 $X2=0.108 $Y2=0.1355
r21 15 14 16.3266 $w=2.1e-08 $l=4.8e-08 $layer=Gate_1 $thickness=5.6e-08
+ $X=0.135 $Y=0.2025 $X2=0.135 $Y2=0.1545
r22 13 14 6.6582 $w=2.03947e-08 $l=1.9e-08 $layer=Gate_1 $thickness=5.6e-08
+ $X=0.135 $Y=0.1355 $X2=0.135 $Y2=0.1545
r23 12 13 6.82827 $w=2.04103e-08 $l=1.95e-08 $layer=Gate_1 $thickness=5.6e-08
+ $X=0.135 $Y=0.116 $X2=0.135 $Y2=0.1355
r24 11 12 16.4967 $w=2.1e-08 $l=4.85e-08 $layer=Gate_1 $thickness=5.6e-08
+ $X=0.135 $Y=0.0675 $X2=0.135 $Y2=0.116
r25 11 4 14.6259 $w=2.1e-08 $l=4.3e-08 $layer=Gate_1 $thickness=5.6e-08
+ $X=0.135 $Y=0.0675 $X2=0.135 $Y2=0.0245
.ends

.subckt PM_NOR2x1_ASAP7_75t_R%Y vss 31 19 28 41 42 10 1 12 2 17 11 3 16 15
c1 1 vss 0.00704317f $X=0.108 $Y=0.0675
c2 2 vss 0.00693739f $X=0.216 $Y=0.0675
c3 3 vss 0.00280114f $X=0.216 $Y=0.2025
c4 10 vss 0.00331879f $X=0.11 $Y=0.0675
c5 11 vss 0.00332566f $X=0.2015 $Y=0.0675
c6 12 vss 0.0019043f $X=0.2015 $Y=0.2025
c7 13 vss 0.00277474f $X=0.297 $Y=0.036
c8 14 vss 0.00103827f $X=0.297 $Y=0.198
c9 15 vss 0.0167233f $X=0.0965 $Y=0.036
c10 16 vss 0.000708005f $X=0.286 $Y=0.198
c11 17 vss 0.00389795f $X=0.297 $Y=0.054
r1 42 40 0.0308642 $w=8.1e-08 $l=2.5e-09 $layer=P_src_drn $thickness=1e-09
+ $X=0.2333 $Y=0.2025 $X2=0.2305 $Y2=0.2025
r2 3 40 0.179012 $w=8.1e-08 $l=1.45e-08 $layer=P_src_drn $thickness=1e-09
+ $X=0.216 $Y=0.2025 $X2=0.2305 $Y2=0.2025
r3 12 3 0.179012 $w=8.1e-08 $l=1.45e-08 $layer=P_src_drn $thickness=1e-09
+ $X=0.2015 $Y=0.2025 $X2=0.216 $Y2=0.2025
r4 41 12 0.0308642 $w=8.1e-08 $l=2.5e-09 $layer=P_src_drn $thickness=1e-09
+ $X=0.1986 $Y=0.2025 $X2=0.2015 $Y2=0.2025
r5 3 37 19.3796 $a=3.24e-16 $layer=V0LISD $X=0.216 $Y=0.2025 $X2=0.216 $Y2=0.198
r6 37 38 2.68168 $w=1.3e-08 $l=1.15e-08 $layer=M1 $thickness=3.6e-08 $X=0.216
+ $Y=0.198 $X2=0.2275 $Y2=0.198
r7 35 38 6.8791 $w=1.3e-08 $l=2.95e-08 $layer=M1 $thickness=3.6e-08 $X=0.257
+ $Y=0.198 $X2=0.2275 $Y2=0.198
r8 16 35 6.7625 $w=1.3e-08 $l=2.9e-08 $layer=M1 $thickness=3.6e-08 $X=0.286
+ $Y=0.198 $X2=0.257 $Y2=0.198
r9 14 34 5.69636 $w=1.58e-08 $l=3.15e-08 $layer=M1 $thickness=3.6e-08 $X=0.297
+ $Y=0.198 $X2=0.297 $Y2=0.1665
r10 14 16 0.915974 $w=1.70909e-08 $l=1.1e-08 $layer=M1 $thickness=3.6e-08
+ $X=0.297 $Y=0.198 $X2=0.286 $Y2=0.198
r11 33 34 7.34548 $w=1.3e-08 $l=3.15e-08 $layer=M1 $thickness=3.6e-08 $X=0.297
+ $Y=0.135 $X2=0.297 $Y2=0.1665
r12 32 33 2.15701 $w=1.3e-08 $l=9.3e-09 $layer=M1 $thickness=3.6e-08 $X=0.297
+ $Y=0.1257 $X2=0.297 $Y2=0.135
r13 31 32 0.174892 $w=1.3e-08 $l=7e-10 $layer=M1 $thickness=3.6e-08 $X=0.298
+ $Y=0.125 $X2=0.297 $Y2=0.1257
r14 31 30 5.18847 $w=1.3e-08 $l=2.23e-08 $layer=M1 $thickness=3.6e-08 $X=0.298
+ $Y=0.125 $X2=0.297 $Y2=0.1027
r15 29 30 7.17059 $w=1.3e-08 $l=3.07e-08 $layer=M1 $thickness=3.6e-08 $X=0.297
+ $Y=0.072 $X2=0.297 $Y2=0.1027
r16 17 29 4.19742 $w=1.3e-08 $l=1.8e-08 $layer=M1 $thickness=3.6e-08 $X=0.297
+ $Y=0.054 $X2=0.297 $Y2=0.072
r17 11 2 0.154321 $w=8.1e-08 $l=1.25e-08 $layer=N_src_drn $thickness=1e-09
+ $X=0.2015 $Y=0.0675 $X2=0.216 $Y2=0.0675
r18 28 11 0.0308642 $w=8.1e-08 $l=2.5e-09 $layer=N_src_drn $thickness=1e-09
+ $X=0.1986 $Y=0.0675 $X2=0.2015 $Y2=0.0675
r19 13 26 7.2121 $w=1.41842e-08 $l=3.8e-08 $layer=M1 $thickness=3.6e-08
+ $X=0.297 $Y=0.036 $X2=0.259 $Y2=0.036
r20 13 17 2.5483 $w=1.79e-08 $l=1.8e-08 $layer=M1 $thickness=3.6e-08 $X=0.297
+ $Y=0.036 $X2=0.297 $Y2=0.054
r21 2 24 19.3796 $a=3.24e-16 $layer=V0LISD $X=0.216 $Y=0.0675 $X2=0.216
+ $Y2=0.036
r22 25 26 7.34548 $w=1.3e-08 $l=3.15e-08 $layer=M1 $thickness=3.6e-08 $X=0.2275
+ $Y=0.036 $X2=0.259 $Y2=0.036
r23 24 25 2.68168 $w=1.3e-08 $l=1.15e-08 $layer=M1 $thickness=3.6e-08 $X=0.216
+ $Y=0.036 $X2=0.2275 $Y2=0.036
r24 23 24 9.44419 $w=1.3e-08 $l=4.05e-08 $layer=M1 $thickness=3.6e-08 $X=0.1755
+ $Y=0.036 $X2=0.216 $Y2=0.036
r25 22 23 10.4935 $w=1.3e-08 $l=4.5e-08 $layer=M1 $thickness=3.6e-08 $X=0.1305
+ $Y=0.036 $X2=0.1755 $Y2=0.036
r26 21 22 4.31401 $w=1.3e-08 $l=1.85e-08 $layer=M1 $thickness=3.6e-08 $X=0.112
+ $Y=0.036 $X2=0.1305 $Y2=0.036
r27 20 21 2.09871 $w=1.3e-08 $l=9e-09 $layer=M1 $thickness=3.6e-08 $X=0.103
+ $Y=0.036 $X2=0.112 $Y2=0.036
r28 15 20 1.51573 $w=1.3e-08 $l=6.5e-09 $layer=M1 $thickness=3.6e-08 $X=0.0965
+ $Y=0.036 $X2=0.103 $Y2=0.036
r29 1 21 19.3796 $a=3.24e-16 $layer=V0LISD $X=0.108 $Y=0.0675 $X2=0.112
+ $Y2=0.036
r30 19 18 0.0308642 $w=8.1e-08 $l=2.5e-09 $layer=N_src_drn $thickness=1e-09
+ $X=0.1253 $Y=0.0675 $X2=0.1225 $Y2=0.0675
r31 10 18 0.154321 $w=8.1e-08 $l=1.25e-08 $layer=N_src_drn $thickness=1e-09
+ $X=0.11 $Y=0.0675 $X2=0.1225 $Y2=0.0675
r32 1 10 1e-05 $l=2e-09 $X=0.108 $Y=0.0675 $X2=0.11 $Y2=0.0675
.ends

.subckt PM_NOR2x1_ASAP7_75t_R%5 vss 15 30 31 33 11 13 10 1 12 2 3
c1 1 vss 0.00827323f $X=0.054 $Y=0.2025
c2 2 vss 0.00599803f $X=0.162 $Y=0.2025
c3 3 vss 0.00610643f $X=0.27 $Y=0.2025
c4 10 vss 0.0369681f $X=0.056 $Y=0.2025
c5 11 vss 0.00317993f $X=0.1475 $Y=0.2025
c6 12 vss 0.0358596f $X=0.2555 $Y=0.2025
c7 13 vss 0.0197851f $X=0.0425 $Y=0.234
r1 12 3 0.154321 $w=8.1e-08 $l=1.25e-08 $layer=P_src_drn $thickness=1e-09
+ $X=0.2555 $Y=0.2025 $X2=0.27 $Y2=0.2025
r2 33 12 0.0308642 $w=8.1e-08 $l=2.5e-09 $layer=P_src_drn $thickness=1e-09
+ $X=0.2526 $Y=0.2025 $X2=0.2555 $Y2=0.2025
r3 31 29 0.0308642 $w=8.1e-08 $l=2.5e-09 $layer=P_src_drn $thickness=1e-09
+ $X=0.1793 $Y=0.2025 $X2=0.1765 $Y2=0.2025
r4 2 29 0.179012 $w=8.1e-08 $l=1.45e-08 $layer=P_src_drn $thickness=1e-09
+ $X=0.162 $Y=0.2025 $X2=0.1765 $Y2=0.2025
r5 11 2 0.179012 $w=8.1e-08 $l=1.45e-08 $layer=P_src_drn $thickness=1e-09
+ $X=0.1475 $Y=0.2025 $X2=0.162 $Y2=0.2025
r6 30 11 0.0308642 $w=8.1e-08 $l=2.5e-09 $layer=P_src_drn $thickness=1e-09
+ $X=0.1446 $Y=0.2025 $X2=0.1475 $Y2=0.2025
r7 3 26 19.3796 $a=3.24e-16 $layer=V0LISD $X=0.27 $Y=0.2025 $X2=0.27 $Y2=0.234
r8 2 23 19.3796 $a=3.24e-16 $layer=V0LISD $X=0.162 $Y=0.2025 $X2=0.162 $Y2=0.234
r9 25 26 8.97781 $w=1.3e-08 $l=3.85e-08 $layer=M1 $thickness=3.6e-08 $X=0.2315
+ $Y=0.234 $X2=0.27 $Y2=0.234
r10 24 25 10.4935 $w=1.3e-08 $l=4.5e-08 $layer=M1 $thickness=3.6e-08 $X=0.1865
+ $Y=0.234 $X2=0.2315 $Y2=0.234
r11 23 24 5.71315 $w=1.3e-08 $l=2.45e-08 $layer=M1 $thickness=3.6e-08 $X=0.162
+ $Y=0.234 $X2=0.1865 $Y2=0.234
r12 22 23 3.14806 $w=1.3e-08 $l=1.35e-08 $layer=M1 $thickness=3.6e-08 $X=0.1485
+ $Y=0.234 $X2=0.162 $Y2=0.234
r13 21 22 5.36336 $w=1.3e-08 $l=2.3e-08 $layer=M1 $thickness=3.6e-08 $X=0.1255
+ $Y=0.234 $X2=0.1485 $Y2=0.234
r14 20 21 5.82974 $w=1.3e-08 $l=2.5e-08 $layer=M1 $thickness=3.6e-08 $X=0.1005
+ $Y=0.234 $X2=0.1255 $Y2=0.234
r15 19 20 2.68168 $w=1.3e-08 $l=1.15e-08 $layer=M1 $thickness=3.6e-08 $X=0.089
+ $Y=0.234 $X2=0.1005 $Y2=0.234
r16 18 19 3.61444 $w=1.3e-08 $l=1.55e-08 $layer=M1 $thickness=3.6e-08 $X=0.0735
+ $Y=0.234 $X2=0.089 $Y2=0.234
r17 17 18 3.38125 $w=1.3e-08 $l=1.45e-08 $layer=M1 $thickness=3.6e-08 $X=0.059
+ $Y=0.234 $X2=0.0735 $Y2=0.234
r18 16 17 2.09871 $w=1.3e-08 $l=9e-09 $layer=M1 $thickness=3.6e-08 $X=0.05
+ $Y=0.234 $X2=0.059 $Y2=0.234
r19 13 16 1.74892 $w=1.3e-08 $l=7.5e-09 $layer=M1 $thickness=3.6e-08 $X=0.0425
+ $Y=0.234 $X2=0.05 $Y2=0.234
r20 1 16 19.3796 $a=3.24e-16 $layer=V0LISD $X=0.054 $Y=0.2025 $X2=0.05 $Y2=0.234
r21 15 14 0.0308642 $w=8.1e-08 $l=2.5e-09 $layer=P_src_drn $thickness=1e-09
+ $X=0.0713 $Y=0.2025 $X2=0.0685 $Y2=0.2025
r22 10 14 0.154321 $w=8.1e-08 $l=1.25e-08 $layer=P_src_drn $thickness=1e-09
+ $X=0.056 $Y=0.2025 $X2=0.0685 $Y2=0.2025
r23 1 10 1e-05 $l=2e-09 $X=0.054 $Y=0.2025 $X2=0.056 $Y2=0.2025
.ends

.subckt PM_NOR2x1_ASAP7_75t_R%B vss 21 11 15 28 8 6 1 7 3 4 5 10
c1 1 vss 0.00844602f $X=0.189 $Y=0.135
c2 3 vss 0.046821f $X=0.189 $Y=0.0245
c3 4 vss 0.0203654f $X=0.243 $Y=0.135
c4 5 vss 0.00443697f $X=0.135 $Y=0.072
c5 6 vss 0.00464089f $X=0.135 $Y=0.198
c6 7 vss 0.00326948f $X=0.135 $Y=0.135
c7 8 vss 0.0041884f $X=0.135 $Y=0.1035
c8 9 vss 0.00404092f $X=0.135 $Y=0.1665
c9 10 vss 0.00420447f $X=0.2045 $Y=0.135
r1 6 9 6.16517 $w=1.44286e-08 $l=3.15e-08 $layer=M1 $thickness=3.6e-08 $X=0.135
+ $Y=0.198 $X2=0.135 $Y2=0.1665
r2 5 8 6.16517 $w=1.44286e-08 $l=3.15e-08 $layer=M1 $thickness=3.6e-08 $X=0.135
+ $Y=0.072 $X2=0.135 $Y2=0.1035
r3 7 23 7.6809 $w=1.41842e-08 $l=3.8e-08 $layer=M1 $thickness=3.6e-08 $X=0.135
+ $Y=0.135 $X2=0.173 $Y2=0.135
r4 7 8 6.16517 $w=1.44286e-08 $l=3.15e-08 $layer=M1 $thickness=3.6e-08 $X=0.135
+ $Y=0.135 $X2=0.135 $Y2=0.1035
r5 7 9 6.16517 $w=1.44286e-08 $l=3.15e-08 $layer=M1 $thickness=3.6e-08 $X=0.135
+ $Y=0.135 $X2=0.135 $Y2=0.1665
r6 28 27 14.6259 $w=2.1e-08 $l=4.3e-08 $layer=Gate_1 $thickness=5.6e-08
+ $X=0.243 $Y=0.2025 $X2=0.243 $Y2=0.1595
r7 26 27 2.7211 $w=2.1e-08 $l=8e-09 $layer=Gate_1 $thickness=5.6e-08 $X=0.243
+ $Y=0.1515 $X2=0.243 $Y2=0.1595
r8 4 19 6.54019 $w=2.09524e-08 $layer=Gate_1 $thickness=5.21905e-08 $X=0.243
+ $Y=0.135 $X2=0.243 $Y2=0.135
r9 4 26 5.79936 $w=2.03333e-08 $l=1.65e-08 $layer=Gate_1 $thickness=5.6e-08
+ $X=0.243 $Y=0.135 $X2=0.243 $Y2=0.1515
r10 21 10 2.68168 $w=1.3e-08 $l=1.15e-08 $layer=M1 $thickness=3.6e-08 $X=0.215
+ $Y=0.134 $X2=0.2045 $Y2=0.135
r11 10 23 7.34548 $w=1.3e-08 $l=3.15e-08 $layer=M1 $thickness=3.6e-08 $X=0.2045
+ $Y=0.135 $X2=0.173 $Y2=0.135
r12 18 19 12.6539 $w=1.77815e-08 $l=2.7e-08 $layer=LIG $thickness=4.8e-08
+ $X=0.216 $Y=0.135 $X2=0.243 $Y2=0.135
r13 21 18 19.3796 $a=3.24e-16 $layer=V0LIG $X=0.215 $Y=0.134 $X2=0.216 $Y2=0.135
r14 1 13 6.54019 $w=2.09524e-08 $layer=Gate_1 $thickness=5.21905e-08 $X=0.189
+ $Y=0.135 $X2=0.189 $Y2=0.135
r15 1 18 12.6539 $w=1.77815e-08 $l=2.7e-08 $layer=LIG $thickness=4.8e-08
+ $X=0.189 $Y=0.135 $X2=0.216 $Y2=0.135
r16 15 14 16.4967 $w=2.1e-08 $l=4.85e-08 $layer=Gate_1 $thickness=5.6e-08
+ $X=0.189 $Y=0.2025 $X2=0.189 $Y2=0.154
r17 13 14 6.6497 $w=2.04211e-08 $l=1.9e-08 $layer=Gate_1 $thickness=5.6e-08
+ $X=0.189 $Y=0.135 $X2=0.189 $Y2=0.154
r18 12 13 6.6497 $w=2.04211e-08 $l=1.9e-08 $layer=Gate_1 $thickness=5.6e-08
+ $X=0.189 $Y=0.116 $X2=0.189 $Y2=0.135
r19 11 12 16.4967 $w=2.1e-08 $l=4.85e-08 $layer=Gate_1 $thickness=5.6e-08
+ $X=0.189 $Y=0.0675 $X2=0.189 $Y2=0.116
r20 11 3 14.6259 $w=2.1e-08 $l=4.3e-08 $layer=Gate_1 $thickness=5.6e-08
+ $X=0.189 $Y=0.0675 $X2=0.189 $Y2=0.0245
.ends

* End of included file NOR2x1_ASAP7_75t_R.pex.sp.pex

*
.subckt NOR2x1_ASAP7_75t_CUSTOM_4_25_0_7 VSS VDD A B Y
*
* VSS VSS
* VDD VDD
* A A
* B B
* Y Y
*
*

M0 VSS N_M0_g N_M0_s VSS nmos_rvt L=2e-08 W=8.1e-08 nfin=3 $X=0.125 $Y=0.027
M1 N_M1_d N_M1_g VSS VSS nmos_rvt L=2e-08 W=8.1e-08 nfin=3 $X=0.179 $Y=0.027
M2 VDD N_M2_g N_M2_s VDD pmos_rvt L=2e-08 W=8.1e-08 nfin=3 $X=0.071 $Y=0.162
M3 VDD N_M3_g N_M3_s VDD pmos_rvt L=2e-08 W=8.1e-08 nfin=3 $X=0.125 $Y=0.162
M4 N_M4_d N_M4_g N_M4_s VDD pmos_rvt L=2e-08 W=8.1e-08 nfin=3 $X=0.179 $Y=0.162
M5 N_M5_d N_M5_g N_M5_s VDD pmos_rvt L=2e-08 W=8.1e-08 nfin=3 $X=0.233 $Y=0.162

* .include "NOR2x1_ASAP7_75t_R.pex.sp.pxi"

* Start of included file NOR2x1_ASAP7_75t_R.pex.sp.pxi
x_PM_NOR2x1_ASAP7_75t_R%A vss A N_M0_g N_M3_g N_M2_g N_A_1 N_A_7 N_A_10 N_A_4
+ N_A_9 N_A_3 PM_NOR2x1_ASAP7_75t_R%A
x_PM_NOR2x1_ASAP7_75t_R%Y vss Y N_M0_s N_M1_d N_M4_d N_M5_d N_Y_10 N_Y_1 N_Y_12
+ N_Y_2 N_Y_17 N_Y_11 N_Y_3 N_Y_16 N_Y_15 PM_NOR2x1_ASAP7_75t_R%Y
cc_1 N_Y_10 N_A_4 0.0302046f $X=0.11 $Y=0.0675
cc_2 N_Y_1 N_A_4 0.00225177f $X=0.108 $Y=0.0675
cc_3 N_Y_10 N_A_1 0.00247016f $X=0.11 $Y=0.0675
cc_4 N_Y_10 N_A_3 0.0418551f $X=0.11 $Y=0.0675
cc_5 N_Y_12 N_B_5 0.000735938f $X=0.2015 $Y=0.2025
cc_6 N_Y_2 N_B_1 0.000946252f $X=0.216 $Y=0.0675
cc_7 N_Y_17 N_B_10 0.00106633f $X=0.297 $Y=0.054
cc_8 N_Y_11 N_B_3 0.0322647f $X=0.2015 $Y=0.0675
cc_9 N_Y_3 N_B_4 0.00170525f $X=0.216 $Y=0.2025
cc_10 N_Y_2 N_B_3 0.00226051f $X=0.216 $Y=0.0675
cc_11 N_Y_16 N_B_10 0.00304605f $X=0.286 $Y=0.198
cc_12 N_Y_15 N_B_5 0.00499548f $X=0.0965 $Y=0.036
cc_13 N_Y_12 N_B_1 0.00506125f $X=0.2015 $Y=0.2025
cc_14 N_Y_12 N_B_3 0.0557506f $X=0.2015 $Y=0.2025
cc_15 N_Y_12 N_B_4 0.050713f $X=0.2015 $Y=0.2025
cc_16 N_Y_12 N_5_13 0.000804615f $X=0.2015 $Y=0.2025
cc_17 N_Y_12 N_5_11 0.00109834f $X=0.2015 $Y=0.2025
cc_18 N_Y_3 N_5_2 0.00127845f $X=0.216 $Y=0.2025
cc_19 N_Y_3 N_5_3 0.00495651f $X=0.216 $Y=0.2025
cc_20 N_Y_16 N_5_13 0.0115985f $X=0.286 $Y=0.198
x_PM_NOR2x1_ASAP7_75t_R%5 vss N_M2_s N_M3_s N_M4_s N_M5_s N_5_11 N_5_13 N_5_10
+ N_5_1 N_5_12 N_5_2 N_5_3 PM_NOR2x1_ASAP7_75t_R%5
cc_21 N_5_11 N_A_9 0.000505466f $X=0.1475 $Y=0.2025
cc_22 N_5_13 N_A_7 0.00184475f $X=0.0425 $Y=0.234
cc_23 N_5_10 N_A_1 0.00205369f $X=0.056 $Y=0.2025
cc_24 N_5_1 N_A_3 0.00209242f $X=0.054 $Y=0.2025
cc_25 N_5_10 N_A_3 0.0335314f $X=0.056 $Y=0.2025
cc_26 N_5_11 N_A_4 0.0374879f $X=0.1475 $Y=0.2025
cc_27 N_5_12 N_B_3 0.00133005f $X=0.2555 $Y=0.2025
cc_28 N_5_12 N_B_1 0.00172072f $X=0.2555 $Y=0.2025
cc_29 N_5_13 N_B_6 0.00464617f $X=0.0425 $Y=0.234
cc_30 N_5_11 N_B_3 0.0331043f $X=0.1475 $Y=0.2025
cc_31 N_5_12 N_B_4 0.0368462f $X=0.2555 $Y=0.2025
x_PM_NOR2x1_ASAP7_75t_R%B vss B N_M1_g N_M4_g N_M5_g N_B_8 N_B_6 N_B_1 N_B_7
+ N_B_3 N_B_4 N_B_5 N_B_10 PM_NOR2x1_ASAP7_75t_R%B
cc_32 N_B_8 N_A_1 0.000635323f $X=0.135 $Y=0.1035
cc_33 N_B_6 N_A_7 0.000691128f $X=0.135 $Y=0.198
cc_34 N_B_1 N_A_1 0.000798409f $X=0.189 $Y=0.135
cc_35 N_B_7 N_A_10 0.00107732f $X=0.135 $Y=0.135
cc_36 N_B_7 N_A_1 0.00200129f $X=0.135 $Y=0.135
cc_37 N_B_3 N_A_4 0.00589108f $X=0.189 $Y=0.0245

* End of included file NOR2x1_ASAP7_75t_R.pex.sp.pxi
.ends

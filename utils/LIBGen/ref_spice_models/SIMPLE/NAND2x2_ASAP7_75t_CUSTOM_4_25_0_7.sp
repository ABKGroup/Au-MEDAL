.subckt PM_NAND2x2_ASAP7_75t_R%A vss 28 9 13 24 32 36 39 6 1 8 3 4 5 7
c1 1 vss 0.0233988f $X=0.351 $Y=0.1345
c2 3 vss 0.0875482f $X=0.189 $Y=0.1345
c3 4 vss 0.0513244f $X=0.243 $Y=0.1345
c4 5 vss 0.0513244f $X=0.297 $Y=0.1345
c5 6 vss 0.0875482f $X=0.351 $Y=0.0245
c6 7 vss 0.00615175f $X=0.27 $Y=0.198
c7 8 vss 0.00640757f $X=0.27 $Y=0.1115
r1 7 30 2.31754 $w=1.6e-08 $l=1.5e-08 $layer=M1 $thickness=3.6e-08 $X=0.27
+ $Y=0.198 $X2=0.27 $Y2=0.183
r2 39 38 16.4967 $w=2.1e-08 $l=4.85e-08 $layer=Gate_1 $thickness=5.6e-08
+ $X=0.189 $Y=0.2025 $X2=0.189 $Y2=0.154
r3 36 37 16.3266 $w=2.1e-08 $l=4.8e-08 $layer=Gate_1 $thickness=5.6e-08
+ $X=0.189 $Y=0.0675 $X2=0.189 $Y2=0.1155
r4 3 20 6.4735 $w=2.13953e-08 $layer=Gate_1 $thickness=5.22791e-08 $X=0.189
+ $Y=0.1345 $X2=0.189 $Y2=0.1345
r5 3 37 6.6582 $w=2.03947e-08 $l=1.9e-08 $layer=Gate_1 $thickness=5.6e-08
+ $X=0.189 $Y=0.1345 $X2=0.189 $Y2=0.1155
r6 3 38 6.82827 $w=2.04103e-08 $l=1.95e-08 $layer=Gate_1 $thickness=5.6e-08
+ $X=0.189 $Y=0.1345 $X2=0.189 $Y2=0.154
r7 32 33 16.3266 $w=2.1e-08 $l=4.8e-08 $layer=Gate_1 $thickness=5.6e-08
+ $X=0.243 $Y=0.0675 $X2=0.243 $Y2=0.1155
r8 4 18 6.4735 $w=2.13953e-08 $layer=Gate_1 $thickness=5.22791e-08 $X=0.243
+ $Y=0.1345 $X2=0.243 $Y2=0.1345
r9 4 33 6.6582 $w=2.03947e-08 $l=1.9e-08 $layer=Gate_1 $thickness=5.6e-08
+ $X=0.243 $Y=0.1345 $X2=0.243 $Y2=0.1155
r10 29 30 5.24677 $w=1.3e-08 $l=2.25e-08 $layer=M1 $thickness=3.6e-08 $X=0.27
+ $Y=0.1605 $X2=0.27 $Y2=0.183
r11 28 29 5.94634 $w=1.3e-08 $l=2.55e-08 $layer=M1 $thickness=3.6e-08 $X=0.272
+ $Y=0.136 $X2=0.27 $Y2=0.1605
r12 28 27 3.14806 $w=1.3e-08 $l=1.35e-08 $layer=M1 $thickness=3.6e-08 $X=0.272
+ $Y=0.136 $X2=0.27 $Y2=0.1215
r13 8 27 2.3319 $w=1.3e-08 $l=1e-08 $layer=M1 $thickness=3.6e-08 $X=0.27
+ $Y=0.1115 $X2=0.27 $Y2=0.1215
r14 24 25 16.3266 $w=2.1e-08 $l=4.8e-08 $layer=Gate_1 $thickness=5.6e-08
+ $X=0.297 $Y=0.0675 $X2=0.297 $Y2=0.1155
r15 5 16 6.4735 $w=2.13953e-08 $layer=Gate_1 $thickness=5.22791e-08 $X=0.297
+ $Y=0.1345 $X2=0.297 $Y2=0.1345
r16 5 25 6.6582 $w=2.03947e-08 $l=1.9e-08 $layer=Gate_1 $thickness=5.6e-08
+ $X=0.297 $Y=0.1345 $X2=0.297 $Y2=0.1155
r17 19 20 10.1596 $w=1.87815e-08 $l=2.7e-08 $layer=LIG $thickness=4.8e-08
+ $X=0.216 $Y=0.1345 $X2=0.189 $Y2=0.1345
r18 18 19 10.1596 $w=1.87815e-08 $l=2.7e-08 $layer=LIG $thickness=4.8e-08
+ $X=0.243 $Y=0.1345 $X2=0.216 $Y2=0.1345
r19 17 18 10.1596 $w=1.87815e-08 $l=2.7e-08 $layer=LIG $thickness=4.8e-08
+ $X=0.27 $Y=0.1345 $X2=0.243 $Y2=0.1345
r20 28 17 19.3796 $a=3.24e-16 $layer=V0LIG $X=0.272 $Y=0.136 $X2=0.27 $Y2=0.1345
r21 16 17 10.1596 $w=1.87815e-08 $l=2.7e-08 $layer=LIG $thickness=4.8e-08
+ $X=0.297 $Y=0.1345 $X2=0.27 $Y2=0.1345
r22 15 16 10.1596 $w=1.87815e-08 $l=2.7e-08 $layer=LIG $thickness=4.8e-08
+ $X=0.324 $Y=0.1345 $X2=0.297 $Y2=0.1345
r23 1 11 6.4735 $w=2.13953e-08 $layer=Gate_1 $thickness=5.22791e-08 $X=0.351
+ $Y=0.1345 $X2=0.351 $Y2=0.1345
r24 1 15 10.1596 $w=1.87815e-08 $l=2.7e-08 $layer=LIG $thickness=4.8e-08
+ $X=0.351 $Y=0.1345 $X2=0.324 $Y2=0.1345
r25 13 12 16.4967 $w=2.1e-08 $l=4.85e-08 $layer=Gate_1 $thickness=5.6e-08
+ $X=0.351 $Y=0.2025 $X2=0.351 $Y2=0.154
r26 11 12 6.82827 $w=2.04103e-08 $l=1.95e-08 $layer=Gate_1 $thickness=5.6e-08
+ $X=0.351 $Y=0.1345 $X2=0.351 $Y2=0.154
r27 10 11 6.6582 $w=2.03947e-08 $l=1.9e-08 $layer=Gate_1 $thickness=5.6e-08
+ $X=0.351 $Y=0.1155 $X2=0.351 $Y2=0.1345
r28 9 10 16.3266 $w=2.1e-08 $l=4.8e-08 $layer=Gate_1 $thickness=5.6e-08
+ $X=0.351 $Y=0.0675 $X2=0.351 $Y2=0.1155
r29 9 6 14.6259 $w=2.1e-08 $l=4.3e-08 $layer=Gate_1 $thickness=5.6e-08 $X=0.351
+ $Y=0.0675 $X2=0.351 $Y2=0.0245
.ends

.subckt PM_NAND2x2_ASAP7_75t_R%Y vss 72 36 37 62 64 66 68 81 82 20 2 1 5 19 21
+ 24 6 30 32 31 29 33 23 22 3 4 27 25
c1 1 vss 0.00278608f $X=0.108 $Y=0.0675
c2 2 vss 0.00692237f $X=0.108 $Y=0.2025
c3 3 vss 0.00644016f $X=0.216 $Y=0.2025
c4 4 vss 0.00645245f $X=0.324 $Y=0.2025
c5 5 vss 0.00278608f $X=0.432 $Y=0.0675
c6 6 vss 0.00696079f $X=0.432 $Y=0.2025
c7 19 vss 0.00194261f $X=0.0935 $Y=0.0675
c8 20 vss 0.00194261f $X=0.4175 $Y=0.0675
c9 21 vss 0.00333608f $X=0.11 $Y=0.2025
c10 22 vss 0.00330799f $X=0.2015 $Y=0.2025
c11 23 vss 0.00330799f $X=0.326 $Y=0.2025
c12 24 vss 0.00333874f $X=0.4175 $Y=0.2025
c13 25 vss 0.0010454f $X=0.027 $Y=0.072
c14 26 vss 0.00273178f $X=0.027 $Y=0.234
c15 27 vss 0.00104487f $X=0.513 $Y=0.072
c16 28 vss 0.00276789f $X=0.513 $Y=0.234
c17 29 vss 0.0037304f $X=0.027 $Y=0.09
c18 30 vss 0.000801374f $X=0.0855 $Y=0.072
c19 31 vss 0.0373436f $X=0.054 $Y=0.234
c20 32 vss 0.000801374f $X=0.502 $Y=0.072
c21 33 vss 0.00373266f $X=0.513 $Y=0.216
r1 82 80 0.0308642 $w=8.1e-08 $l=2.5e-09 $layer=N_src_drn $thickness=1e-09
+ $X=0.4493 $Y=0.0675 $X2=0.4465 $Y2=0.0675
r2 5 80 0.179012 $w=8.1e-08 $l=1.45e-08 $layer=N_src_drn $thickness=1e-09
+ $X=0.432 $Y=0.0675 $X2=0.4465 $Y2=0.0675
r3 20 5 0.179012 $w=8.1e-08 $l=1.45e-08 $layer=N_src_drn $thickness=1e-09
+ $X=0.4175 $Y=0.0675 $X2=0.432 $Y2=0.0675
r4 81 20 0.0308642 $w=8.1e-08 $l=2.5e-09 $layer=N_src_drn $thickness=1e-09
+ $X=0.4146 $Y=0.0675 $X2=0.4175 $Y2=0.0675
r5 5 77 19.3796 $a=3.24e-16 $layer=V0LISD $X=0.432 $Y=0.0675 $X2=0.432 $Y2=0.072
r6 77 78 5.24677 $w=1.3e-08 $l=2.25e-08 $layer=M1 $thickness=3.6e-08 $X=0.432
+ $Y=0.072 $X2=0.4545 $Y2=0.072
r7 75 78 6.8791 $w=1.3e-08 $l=2.95e-08 $layer=M1 $thickness=3.6e-08 $X=0.484
+ $Y=0.072 $X2=0.4545 $Y2=0.072
r8 32 75 4.19742 $w=1.3e-08 $l=1.8e-08 $layer=M1 $thickness=3.6e-08 $X=0.502
+ $Y=0.072 $X2=0.484 $Y2=0.072
r9 27 74 2.5483 $w=1.79e-08 $l=1.8e-08 $layer=M1 $thickness=3.6e-08 $X=0.513
+ $Y=0.072 $X2=0.513 $Y2=0.09
r10 27 32 0.915974 $w=1.70909e-08 $l=1.1e-08 $layer=M1 $thickness=3.6e-08
+ $X=0.513 $Y=0.072 $X2=0.502 $Y2=0.072
r11 72 73 3.78933 $w=1.3e-08 $l=1.62e-08 $layer=M1 $thickness=3.6e-08 $X=0.514
+ $Y=0.145 $X2=0.513 $Y2=0.1612
r12 72 71 5.42166 $w=1.3e-08 $l=2.33e-08 $layer=M1 $thickness=3.6e-08 $X=0.514
+ $Y=0.145 $X2=0.513 $Y2=0.1217
r13 71 74 7.40378 $w=1.3e-08 $l=3.17e-08 $layer=M1 $thickness=3.6e-08 $X=0.513
+ $Y=0.1217 $X2=0.513 $Y2=0.09
r14 70 73 5.07188 $w=1.3e-08 $l=2.18e-08 $layer=M1 $thickness=3.6e-08 $X=0.513
+ $Y=0.183 $X2=0.513 $Y2=0.1612
r15 69 70 3.49785 $w=1.3e-08 $l=1.5e-08 $layer=M1 $thickness=3.6e-08 $X=0.513
+ $Y=0.198 $X2=0.513 $Y2=0.183
r16 33 69 4.19742 $w=1.3e-08 $l=1.8e-08 $layer=M1 $thickness=3.6e-08 $X=0.513
+ $Y=0.216 $X2=0.513 $Y2=0.198
r17 24 6 0.154321 $w=8.1e-08 $l=1.25e-08 $layer=P_src_drn $thickness=1e-09
+ $X=0.4175 $Y=0.2025 $X2=0.432 $Y2=0.2025
r18 68 24 0.0308642 $w=8.1e-08 $l=2.5e-09 $layer=P_src_drn $thickness=1e-09
+ $X=0.4146 $Y=0.2025 $X2=0.4175 $Y2=0.2025
r19 66 65 0.0308642 $w=8.1e-08 $l=2.5e-09 $layer=P_src_drn $thickness=1e-09
+ $X=0.3413 $Y=0.2025 $X2=0.3385 $Y2=0.2025
r20 23 65 0.154321 $w=8.1e-08 $l=1.25e-08 $layer=P_src_drn $thickness=1e-09
+ $X=0.326 $Y=0.2025 $X2=0.3385 $Y2=0.2025
r21 22 3 0.154321 $w=8.1e-08 $l=1.25e-08 $layer=P_src_drn $thickness=1e-09
+ $X=0.2015 $Y=0.2025 $X2=0.216 $Y2=0.2025
r22 64 22 0.0308642 $w=8.1e-08 $l=2.5e-09 $layer=P_src_drn $thickness=1e-09
+ $X=0.1986 $Y=0.2025 $X2=0.2015 $Y2=0.2025
r23 62 61 0.0308642 $w=8.1e-08 $l=2.5e-09 $layer=P_src_drn $thickness=1e-09
+ $X=0.1253 $Y=0.2025 $X2=0.1225 $Y2=0.2025
r24 21 61 0.154321 $w=8.1e-08 $l=1.25e-08 $layer=P_src_drn $thickness=1e-09
+ $X=0.11 $Y=0.2025 $X2=0.1225 $Y2=0.2025
r25 28 60 4.64701 $w=1.46667e-08 $l=2.7e-08 $layer=M1 $thickness=3.6e-08
+ $X=0.513 $Y=0.234 $X2=0.486 $Y2=0.234
r26 28 33 2.5483 $w=1.79e-08 $l=1.8e-08 $layer=M1 $thickness=3.6e-08 $X=0.513
+ $Y=0.234 $X2=0.513 $Y2=0.216
r27 6 57 19.3796 $a=3.24e-16 $layer=V0LISD $X=0.432 $Y=0.2025 $X2=0.432
+ $Y2=0.234
r28 4 55 19.3796 $a=3.24e-16 $layer=V0LISD $X=0.324 $Y=0.2025 $X2=0.3275
+ $Y2=0.234
r29 3 49 19.3796 $a=3.24e-16 $layer=V0LISD $X=0.216 $Y=0.2025 $X2=0.2125
+ $Y2=0.234
r30 2 46 19.3796 $a=3.24e-16 $layer=V0LISD $X=0.108 $Y=0.2025 $X2=0.104
+ $Y2=0.234
r31 59 60 6.29612 $w=1.3e-08 $l=2.7e-08 $layer=M1 $thickness=3.6e-08 $X=0.459
+ $Y=0.234 $X2=0.486 $Y2=0.234
r32 58 59 3.14806 $w=1.3e-08 $l=1.35e-08 $layer=M1 $thickness=3.6e-08 $X=0.4455
+ $Y=0.234 $X2=0.459 $Y2=0.234
r33 57 58 3.14806 $w=1.3e-08 $l=1.35e-08 $layer=M1 $thickness=3.6e-08 $X=0.432
+ $Y=0.234 $X2=0.4455 $Y2=0.234
r34 56 57 12.5922 $w=1.3e-08 $l=5.4e-08 $layer=M1 $thickness=3.6e-08 $X=0.378
+ $Y=0.234 $X2=0.432 $Y2=0.234
r35 55 56 11.7761 $w=1.3e-08 $l=5.05e-08 $layer=M1 $thickness=3.6e-08 $X=0.3275
+ $Y=0.234 $X2=0.378 $Y2=0.234
r36 54 55 2.09871 $w=1.3e-08 $l=9e-09 $layer=M1 $thickness=3.6e-08 $X=0.3185
+ $Y=0.234 $X2=0.3275 $Y2=0.234
r37 53 54 5.01358 $w=1.3e-08 $l=2.15e-08 $layer=M1 $thickness=3.6e-08 $X=0.297
+ $Y=0.234 $X2=0.3185 $Y2=0.234
r38 52 53 8.51143 $w=1.3e-08 $l=3.65e-08 $layer=M1 $thickness=3.6e-08 $X=0.2605
+ $Y=0.234 $X2=0.297 $Y2=0.234
r39 51 52 6.29612 $w=1.3e-08 $l=2.7e-08 $layer=M1 $thickness=3.6e-08 $X=0.2335
+ $Y=0.234 $X2=0.2605 $Y2=0.234
r40 50 51 2.79828 $w=1.3e-08 $l=1.2e-08 $layer=M1 $thickness=3.6e-08 $X=0.2215
+ $Y=0.234 $X2=0.2335 $Y2=0.234
r41 49 50 2.09871 $w=1.3e-08 $l=9e-09 $layer=M1 $thickness=3.6e-08 $X=0.2125
+ $Y=0.234 $X2=0.2215 $Y2=0.234
r42 48 49 11.7761 $w=1.3e-08 $l=5.05e-08 $layer=M1 $thickness=3.6e-08 $X=0.162
+ $Y=0.234 $X2=0.2125 $Y2=0.234
r43 47 48 11.4263 $w=1.3e-08 $l=4.9e-08 $layer=M1 $thickness=3.6e-08 $X=0.113
+ $Y=0.234 $X2=0.162 $Y2=0.234
r44 46 47 2.09871 $w=1.3e-08 $l=9e-09 $layer=M1 $thickness=3.6e-08 $X=0.104
+ $Y=0.234 $X2=0.113 $Y2=0.234
r45 45 46 4.31401 $w=1.3e-08 $l=1.85e-08 $layer=M1 $thickness=3.6e-08 $X=0.0855
+ $Y=0.234 $X2=0.104 $Y2=0.234
r46 31 45 7.34548 $w=1.3e-08 $l=3.15e-08 $layer=M1 $thickness=3.6e-08 $X=0.054
+ $Y=0.234 $X2=0.0855 $Y2=0.234
r47 26 44 2.5483 $w=1.79e-08 $l=1.8e-08 $layer=M1 $thickness=3.6e-08 $X=0.027
+ $Y=0.234 $X2=0.027 $Y2=0.216
r48 26 31 4.64701 $w=1.46667e-08 $l=2.7e-08 $layer=M1 $thickness=3.6e-08
+ $X=0.027 $Y=0.234 $X2=0.054 $Y2=0.234
r49 43 44 4.19742 $w=1.3e-08 $l=1.8e-08 $layer=M1 $thickness=3.6e-08 $X=0.027
+ $Y=0.198 $X2=0.027 $Y2=0.216
r50 42 43 12.5922 $w=1.3e-08 $l=5.4e-08 $layer=M1 $thickness=3.6e-08 $X=0.027
+ $Y=0.144 $X2=0.027 $Y2=0.198
r51 29 42 12.5922 $w=1.3e-08 $l=5.4e-08 $layer=M1 $thickness=3.6e-08 $X=0.027
+ $Y=0.09 $X2=0.027 $Y2=0.144
r52 25 41 0.915974 $w=1.70909e-08 $l=1.1e-08 $layer=M1 $thickness=3.6e-08
+ $X=0.027 $Y=0.072 $X2=0.038 $Y2=0.072
r53 25 29 2.5483 $w=1.79e-08 $l=1.8e-08 $layer=M1 $thickness=3.6e-08 $X=0.027
+ $Y=0.072 $X2=0.027 $Y2=0.09
r54 40 41 4.19742 $w=1.3e-08 $l=1.8e-08 $layer=M1 $thickness=3.6e-08 $X=0.056
+ $Y=0.072 $X2=0.038 $Y2=0.072
r55 30 38 5.24677 $w=1.3e-08 $l=2.25e-08 $layer=M1 $thickness=3.6e-08 $X=0.0855
+ $Y=0.072 $X2=0.108 $Y2=0.072
r56 30 40 6.8791 $w=1.3e-08 $l=2.95e-08 $layer=M1 $thickness=3.6e-08 $X=0.0855
+ $Y=0.072 $X2=0.056 $Y2=0.072
r57 1 38 19.3796 $a=3.24e-16 $layer=V0LISD $X=0.108 $Y=0.0675 $X2=0.108
+ $Y2=0.072
r58 37 35 0.0308642 $w=8.1e-08 $l=2.5e-09 $layer=N_src_drn $thickness=1e-09
+ $X=0.1253 $Y=0.0675 $X2=0.1225 $Y2=0.0675
r59 1 35 0.179012 $w=8.1e-08 $l=1.45e-08 $layer=N_src_drn $thickness=1e-09
+ $X=0.108 $Y=0.0675 $X2=0.1225 $Y2=0.0675
r60 19 1 0.179012 $w=8.1e-08 $l=1.45e-08 $layer=N_src_drn $thickness=1e-09
+ $X=0.0935 $Y=0.0675 $X2=0.108 $Y2=0.0675
r61 36 19 0.0308642 $w=8.1e-08 $l=2.5e-09 $layer=N_src_drn $thickness=1e-09
+ $X=0.0906 $Y=0.0675 $X2=0.0935 $Y2=0.0675
r62 4 23 1e-05 $l=2e-09 $X=0.324 $Y=0.2025 $X2=0.326 $Y2=0.2025
r63 2 21 1e-05 $l=2e-09 $X=0.108 $Y=0.2025 $X2=0.11 $Y2=0.2025
.ends

.subckt PM_NAND2x2_ASAP7_75t_R%5 vss 23 40 41 44 45 48 49 51 20 17 19 3 1 5 2 4
+ 21 16 18
c1 1 vss 0.0059509f $X=0.054 $Y=0.0675
c2 2 vss 0.00600392f $X=0.162 $Y=0.0675
c3 3 vss 0.00835774f $X=0.27 $Y=0.0675
c4 4 vss 0.00600392f $X=0.378 $Y=0.0675
c5 5 vss 0.0059509f $X=0.486 $Y=0.0675
c6 16 vss 0.0352176f $X=0.056 $Y=0.0675
c7 17 vss 0.00309755f $X=0.1475 $Y=0.0675
c8 18 vss 0.00432568f $X=0.2555 $Y=0.0675
c9 19 vss 0.00309755f $X=0.3635 $Y=0.0675
c10 20 vss 0.0352176f $X=0.4715 $Y=0.0675
c11 21 vss 0.03556f $X=0.0425 $Y=0.036
r1 20 5 0.154321 $w=8.1e-08 $l=1.25e-08 $layer=N_src_drn $thickness=1e-09
+ $X=0.4715 $Y=0.0675 $X2=0.486 $Y2=0.0675
r2 51 20 0.0308642 $w=8.1e-08 $l=2.5e-09 $layer=N_src_drn $thickness=1e-09
+ $X=0.4686 $Y=0.0675 $X2=0.4715 $Y2=0.0675
r3 49 47 0.0308642 $w=8.1e-08 $l=2.5e-09 $layer=N_src_drn $thickness=1e-09
+ $X=0.3953 $Y=0.0675 $X2=0.3925 $Y2=0.0675
r4 4 47 0.179012 $w=8.1e-08 $l=1.45e-08 $layer=N_src_drn $thickness=1e-09
+ $X=0.378 $Y=0.0675 $X2=0.3925 $Y2=0.0675
r5 19 4 0.179012 $w=8.1e-08 $l=1.45e-08 $layer=N_src_drn $thickness=1e-09
+ $X=0.3635 $Y=0.0675 $X2=0.378 $Y2=0.0675
r6 48 19 0.0308642 $w=8.1e-08 $l=2.5e-09 $layer=N_src_drn $thickness=1e-09
+ $X=0.3606 $Y=0.0675 $X2=0.3635 $Y2=0.0675
r7 45 43 0.0308642 $w=8.1e-08 $l=2.5e-09 $layer=N_src_drn $thickness=1e-09
+ $X=0.2873 $Y=0.0675 $X2=0.2845 $Y2=0.0675
r8 3 43 0.179012 $w=8.1e-08 $l=1.45e-08 $layer=N_src_drn $thickness=1e-09
+ $X=0.27 $Y=0.0675 $X2=0.2845 $Y2=0.0675
r9 18 3 0.179012 $w=8.1e-08 $l=1.45e-08 $layer=N_src_drn $thickness=1e-09
+ $X=0.2555 $Y=0.0675 $X2=0.27 $Y2=0.0675
r10 44 18 0.0308642 $w=8.1e-08 $l=2.5e-09 $layer=N_src_drn $thickness=1e-09
+ $X=0.2526 $Y=0.0675 $X2=0.2555 $Y2=0.0675
r11 41 39 0.0308642 $w=8.1e-08 $l=2.5e-09 $layer=N_src_drn $thickness=1e-09
+ $X=0.1793 $Y=0.0675 $X2=0.1765 $Y2=0.0675
r12 2 39 0.179012 $w=8.1e-08 $l=1.45e-08 $layer=N_src_drn $thickness=1e-09
+ $X=0.162 $Y=0.0675 $X2=0.1765 $Y2=0.0675
r13 17 2 0.179012 $w=8.1e-08 $l=1.45e-08 $layer=N_src_drn $thickness=1e-09
+ $X=0.1475 $Y=0.0675 $X2=0.162 $Y2=0.0675
r14 40 17 0.0308642 $w=8.1e-08 $l=2.5e-09 $layer=N_src_drn $thickness=1e-09
+ $X=0.1446 $Y=0.0675 $X2=0.1475 $Y2=0.0675
r15 5 36 19.3796 $a=3.24e-16 $layer=V0LISD $X=0.486 $Y=0.0675 $X2=0.486
+ $Y2=0.036
r16 4 33 19.3796 $a=3.24e-16 $layer=V0LISD $X=0.378 $Y=0.0675 $X2=0.378
+ $Y2=0.036
r17 3 30 19.3796 $a=3.24e-16 $layer=V0LISD $X=0.27 $Y=0.0675 $X2=0.27 $Y2=0.036
r18 2 27 19.3796 $a=3.24e-16 $layer=V0LISD $X=0.162 $Y=0.0675 $X2=0.162
+ $Y2=0.036
r19 35 36 8.97781 $w=1.3e-08 $l=3.85e-08 $layer=M1 $thickness=3.6e-08 $X=0.4475
+ $Y=0.036 $X2=0.486 $Y2=0.036
r20 34 35 10.4935 $w=1.3e-08 $l=4.5e-08 $layer=M1 $thickness=3.6e-08 $X=0.4025
+ $Y=0.036 $X2=0.4475 $Y2=0.036
r21 33 34 5.71315 $w=1.3e-08 $l=2.45e-08 $layer=M1 $thickness=3.6e-08 $X=0.378
+ $Y=0.036 $X2=0.4025 $Y2=0.036
r22 32 33 5.47996 $w=1.3e-08 $l=2.35e-08 $layer=M1 $thickness=3.6e-08 $X=0.3545
+ $Y=0.036 $X2=0.378 $Y2=0.036
r23 31 32 10.4935 $w=1.3e-08 $l=4.5e-08 $layer=M1 $thickness=3.6e-08 $X=0.3095
+ $Y=0.036 $X2=0.3545 $Y2=0.036
r24 30 31 9.211 $w=1.3e-08 $l=3.95e-08 $layer=M1 $thickness=3.6e-08 $X=0.27
+ $Y=0.036 $X2=0.3095 $Y2=0.036
r25 29 30 9.211 $w=1.3e-08 $l=3.95e-08 $layer=M1 $thickness=3.6e-08 $X=0.2305
+ $Y=0.036 $X2=0.27 $Y2=0.036
r26 28 29 10.4935 $w=1.3e-08 $l=4.5e-08 $layer=M1 $thickness=3.6e-08 $X=0.1855
+ $Y=0.036 $X2=0.2305 $Y2=0.036
r27 27 28 5.47996 $w=1.3e-08 $l=2.35e-08 $layer=M1 $thickness=3.6e-08 $X=0.162
+ $Y=0.036 $X2=0.1855 $Y2=0.036
r28 26 27 5.71315 $w=1.3e-08 $l=2.45e-08 $layer=M1 $thickness=3.6e-08 $X=0.1375
+ $Y=0.036 $X2=0.162 $Y2=0.036
r29 25 26 10.4935 $w=1.3e-08 $l=4.5e-08 $layer=M1 $thickness=3.6e-08 $X=0.0925
+ $Y=0.036 $X2=0.1375 $Y2=0.036
r30 24 25 8.97781 $w=1.3e-08 $l=3.85e-08 $layer=M1 $thickness=3.6e-08 $X=0.054
+ $Y=0.036 $X2=0.0925 $Y2=0.036
r31 21 24 2.68168 $w=1.3e-08 $l=1.15e-08 $layer=M1 $thickness=3.6e-08 $X=0.0425
+ $Y=0.036 $X2=0.054 $Y2=0.036
r32 1 24 19.3796 $a=3.24e-16 $layer=V0LISD $X=0.054 $Y=0.0675 $X2=0.054
+ $Y2=0.036
r33 23 22 0.0308642 $w=8.1e-08 $l=2.5e-09 $layer=N_src_drn $thickness=1e-09
+ $X=0.0713 $Y=0.0675 $X2=0.0685 $Y2=0.0675
r34 16 22 0.154321 $w=8.1e-08 $l=1.25e-08 $layer=N_src_drn $thickness=1e-09
+ $X=0.056 $Y=0.0675 $X2=0.0685 $Y2=0.0675
r35 1 16 1e-05 $l=2e-09 $X=0.054 $Y=0.0675 $X2=0.056 $Y2=0.0675
.ends

.subckt PM_NAND2x2_ASAP7_75t_R%B vss 37 23 40 43 64 69 72 20 19 21 17 12 1 2 14
+ 6 7 9 15 18 5 8 11 13 10 16 22
c1 1 vss 0.00839241f $X=0.0715 $Y=0.135
c2 2 vss 0.00839241f $X=0.4495 $Y=0.135
c3 5 vss 0.0203087f $X=0.081 $Y=0.0245
c4 6 vss 0.0469755f $X=0.135 $Y=0.135
c5 7 vss 0.0469755f $X=0.405 $Y=0.135
c6 8 vss 0.0203087f $X=0.459 $Y=0.135
c7 9 vss 0.00324443f $X=0.081 $Y=0.108
c8 10 vss 0.00406114f $X=0.081 $Y=0.198
c9 11 vss 0.0037352f $X=0.209 $Y=0.072
c10 12 vss 0.00355536f $X=0.209 $Y=0.1025
c11 13 vss 0.0037352f $X=0.331 $Y=0.072
c12 14 vss 0.00355536f $X=0.331 $Y=0.1025
c13 15 vss 0.00324443f $X=0.459 $Y=0.108
c14 16 vss 0.00371999f $X=0.081 $Y=0.1215
c15 17 vss 0.00470113f $X=0.0995 $Y=0.108
c16 18 vss 0.00353739f $X=0.209 $Y=0.09
c17 19 vss 0.00525449f $X=0.23 $Y=0.072
c18 20 vss 0.00353739f $X=0.331 $Y=0.09
c19 21 vss 0.00473866f $X=0.379 $Y=0.108
c20 22 vss 0.00382394f $X=0.459 $Y=0.1215
r1 72 71 16.4967 $w=2.1e-08 $l=4.85e-08 $layer=Gate_1 $thickness=5.6e-08
+ $X=0.405 $Y=0.2025 $X2=0.405 $Y2=0.154
r2 69 70 16.4967 $w=2.1e-08 $l=4.85e-08 $layer=Gate_1 $thickness=5.6e-08
+ $X=0.405 $Y=0.0675 $X2=0.405 $Y2=0.116
r3 7 59 6.54019 $w=2.09524e-08 $layer=Gate_1 $thickness=5.21905e-08 $X=0.405
+ $Y=0.135 $X2=0.405 $Y2=0.135
r4 7 70 6.6497 $w=2.04211e-08 $l=1.9e-08 $layer=Gate_1 $thickness=5.6e-08
+ $X=0.405 $Y=0.135 $X2=0.405 $Y2=0.116
r5 7 71 6.6497 $w=2.04211e-08 $l=1.9e-08 $layer=Gate_1 $thickness=5.6e-08
+ $X=0.405 $Y=0.135 $X2=0.405 $Y2=0.154
r6 64 65 14.6259 $w=2.1e-08 $l=4.3e-08 $layer=Gate_1 $thickness=5.6e-08
+ $X=0.459 $Y=0.0675 $X2=0.459 $Y2=0.1105
r7 62 65 2.7211 $w=2.1e-08 $l=8e-09 $layer=Gate_1 $thickness=5.6e-08 $X=0.459
+ $Y=0.1185 $X2=0.459 $Y2=0.1105
r8 8 56 6.27904 $w=2.09e-08 $layer=Gate_1 $thickness=5.24e-08 $X=0.459 $Y=0.135
+ $X2=0.459 $Y2=0.135
r9 8 62 5.79936 $w=2.03333e-08 $l=1.65e-08 $layer=Gate_1 $thickness=5.6e-08
+ $X=0.459 $Y=0.135 $X2=0.459 $Y2=0.1185
r10 58 59 12.6539 $w=1.77815e-08 $l=2.7e-08 $layer=LIG $thickness=4.8e-08
+ $X=0.432 $Y=0.135 $X2=0.405 $Y2=0.135
r11 2 56 2.48102 $w=2.2e-08 $l=9.5e-09 $layer=LIG $thickness=4.8e-08 $X=0.4495
+ $Y=0.135 $X2=0.459 $Y2=0.135
r12 2 58 10.1729 $w=1.54914e-08 $l=1.75e-08 $layer=LIG $thickness=4.8e-08
+ $X=0.4495 $Y=0.135 $X2=0.432 $Y2=0.135
r13 54 56 19.3796 $a=3.24e-16 $layer=V0LIG $X=0.459 $Y=0.135 $X2=0.459 $Y2=0.135
r14 22 54 3.14806 $w=1.3e-08 $l=1.35e-08 $layer=M1 $thickness=3.6e-08 $X=0.459
+ $Y=0.1215 $X2=0.459 $Y2=0.135
r15 15 53 4.18063 $w=1.48e-08 $l=2.5e-08 $layer=M1 $thickness=3.6e-08 $X=0.459
+ $Y=0.108 $X2=0.434 $Y2=0.108
r16 15 22 1.49895 $w=1.95333e-08 $l=1.35e-08 $layer=M1 $thickness=3.6e-08
+ $X=0.459 $Y=0.108 $X2=0.459 $Y2=0.1215
r17 21 53 12.8254 $w=1.3e-08 $l=5.5e-08 $layer=M1 $thickness=3.6e-08 $X=0.379
+ $Y=0.108 $X2=0.434 $Y2=0.108
r18 14 20 2.45586 $w=1.44e-08 $l=1.25e-08 $layer=M1 $thickness=3.6e-08 $X=0.331
+ $Y=0.1025 $X2=0.331 $Y2=0.09
r19 14 21 9.45156 $w=1.34118e-08 $l=4.83141e-08 $layer=M1 $thickness=3.6e-08
+ $X=0.331 $Y=0.1025 $X2=0.379 $Y2=0.108
r20 13 51 5.46317 $w=1.44754e-08 $l=3.05e-08 $layer=M1 $thickness=3.6e-08
+ $X=0.331 $Y=0.072 $X2=0.3005 $Y2=0.072
r21 13 20 2.5483 $w=1.79e-08 $l=1.8e-08 $layer=M1 $thickness=3.6e-08 $X=0.331
+ $Y=0.072 $X2=0.331 $Y2=0.09
r22 50 51 7.11229 $w=1.3e-08 $l=3.05e-08 $layer=M1 $thickness=3.6e-08 $X=0.27
+ $Y=0.072 $X2=0.3005 $Y2=0.072
r23 49 50 4.31401 $w=1.3e-08 $l=1.85e-08 $layer=M1 $thickness=3.6e-08 $X=0.2515
+ $Y=0.072 $X2=0.27 $Y2=0.072
r24 19 49 5.01358 $w=1.3e-08 $l=2.15e-08 $layer=M1 $thickness=3.6e-08 $X=0.23
+ $Y=0.072 $X2=0.2515 $Y2=0.072
r25 11 18 2.5483 $w=1.79e-08 $l=1.8e-08 $layer=M1 $thickness=3.6e-08 $X=0.209
+ $Y=0.072 $X2=0.209 $Y2=0.09
r26 11 19 3.24787 $w=1.51429e-08 $l=2.1e-08 $layer=M1 $thickness=3.6e-08
+ $X=0.209 $Y=0.072 $X2=0.23 $Y2=0.072
r27 12 47 9.45156 $w=1.34118e-08 $l=4.83141e-08 $layer=M1 $thickness=3.6e-08
+ $X=0.209 $Y=0.1025 $X2=0.161 $Y2=0.108
r28 12 18 2.45586 $w=1.44e-08 $l=1.25e-08 $layer=M1 $thickness=3.6e-08 $X=0.209
+ $Y=0.1025 $X2=0.209 $Y2=0.09
r29 46 47 10.6101 $w=1.3e-08 $l=4.55e-08 $layer=M1 $thickness=3.6e-08 $X=0.1155
+ $Y=0.108 $X2=0.161 $Y2=0.108
r30 17 46 3.73104 $w=1.3e-08 $l=1.6e-08 $layer=M1 $thickness=3.6e-08 $X=0.0995
+ $Y=0.108 $X2=0.1155 $Y2=0.108
r31 10 38 5.17411 $w=1.46514e-08 $l=2.73e-08 $layer=M1 $thickness=3.6e-08
+ $X=0.081 $Y=0.198 $X2=0.081 $Y2=0.1707
r32 9 16 1.49895 $w=1.95333e-08 $l=1.35e-08 $layer=M1 $thickness=3.6e-08
+ $X=0.081 $Y=0.108 $X2=0.081 $Y2=0.1215
r33 9 17 2.6649 $w=1.54324e-08 $l=1.85e-08 $layer=M1 $thickness=3.6e-08
+ $X=0.081 $Y=0.108 $X2=0.0995 $Y2=0.108
r34 43 42 16.4967 $w=2.1e-08 $l=4.85e-08 $layer=Gate_1 $thickness=5.6e-08
+ $X=0.135 $Y=0.2025 $X2=0.135 $Y2=0.154
r35 40 41 16.4967 $w=2.1e-08 $l=4.85e-08 $layer=Gate_1 $thickness=5.6e-08
+ $X=0.135 $Y=0.0675 $X2=0.135 $Y2=0.116
r36 6 33 6.54019 $w=2.09524e-08 $layer=Gate_1 $thickness=5.21905e-08 $X=0.135
+ $Y=0.135 $X2=0.135 $Y2=0.135
r37 6 41 6.6497 $w=2.04211e-08 $l=1.9e-08 $layer=Gate_1 $thickness=5.6e-08
+ $X=0.135 $Y=0.135 $X2=0.135 $Y2=0.116
r38 6 42 6.6497 $w=2.04211e-08 $l=1.9e-08 $layer=Gate_1 $thickness=5.6e-08
+ $X=0.135 $Y=0.135 $X2=0.135 $Y2=0.154
r39 37 38 4.37231 $w=1.3e-08 $l=1.87e-08 $layer=M1 $thickness=3.6e-08 $X=0.084
+ $Y=0.152 $X2=0.081 $Y2=0.1707
r40 37 36 0.991057 $w=1.3e-08 $l=4.3e-09 $layer=M1 $thickness=3.6e-08 $X=0.084
+ $Y=0.152 $X2=0.081 $Y2=0.1477
r41 35 36 2.97317 $w=1.3e-08 $l=1.27e-08 $layer=M1 $thickness=3.6e-08 $X=0.081
+ $Y=0.135 $X2=0.081 $Y2=0.1477
r42 16 35 3.14806 $w=1.3e-08 $l=1.35e-08 $layer=M1 $thickness=3.6e-08 $X=0.081
+ $Y=0.1215 $X2=0.081 $Y2=0.135
r43 32 33 12.6539 $w=1.77815e-08 $l=2.7e-08 $layer=LIG $thickness=4.8e-08
+ $X=0.108 $Y=0.135 $X2=0.135 $Y2=0.135
r44 30 32 10.1729 $w=1.54914e-08 $l=1.75e-08 $layer=LIG $thickness=4.8e-08
+ $X=0.0905 $Y=0.135 $X2=0.108 $Y2=0.135
r45 29 30 2.48102 $w=2.2e-08 $l=9.5e-09 $layer=LIG $thickness=4.8e-08 $X=0.081
+ $Y=0.135 $X2=0.0905 $Y2=0.135
r46 29 35 19.3796 $a=3.24e-16 $layer=V0LIG $X=0.081 $Y=0.135 $X2=0.081 $Y2=0.135
r47 1 29 2.48102 $w=2.2e-08 $l=9.5e-09 $layer=LIG $thickness=4.8e-08 $X=0.0715
+ $Y=0.135 $X2=0.081 $Y2=0.135
r48 26 30 4.05918 $w=2.0087e-08 $l=9.5e-09 $layer=Gate_1 $thickness=5.56522e-08
+ $X=0.081 $Y=0.135 $X2=0.0905 $Y2=0.135
r49 26 29 6.27904 $w=2.09e-08 $layer=Gate_1 $thickness=5.24e-08 $X=0.081
+ $Y=0.135 $X2=0.081 $Y2=0.135
r50 25 26 5.79936 $w=2.03333e-08 $l=1.65e-08 $layer=Gate_1 $thickness=5.6e-08
+ $X=0.081 $Y=0.1185 $X2=0.081 $Y2=0.135
r51 24 25 2.7211 $w=2.1e-08 $l=8e-09 $layer=Gate_1 $thickness=5.6e-08 $X=0.081
+ $Y=0.1105 $X2=0.081 $Y2=0.1185
r52 23 24 14.6259 $w=2.1e-08 $l=4.3e-08 $layer=Gate_1 $thickness=5.6e-08
+ $X=0.081 $Y=0.0675 $X2=0.081 $Y2=0.1105
r53 23 5 14.6259 $w=2.1e-08 $l=4.3e-08 $layer=Gate_1 $thickness=5.6e-08
+ $X=0.081 $Y=0.0675 $X2=0.081 $Y2=0.0245
.ends

* End of included file NAND2x2_ASAP7_75t_R.pex.sp.pex

*
.subckt NAND2x2_ASAP7_75t_CUSTOM_4_25_0_7 VSS VDD B A Y
*
* VSS VSS
* VDD VDD
* B B
* A A
* Y Y
*
*

M0 N_M0_d N_M0_g N_M0_s VSS nmos_rvt L=2e-08 W=8.1e-08 nfin=3 $X=0.071 $Y=0.027
M1 N_M1_d N_M1_g N_M1_s VSS nmos_rvt L=2e-08 W=8.1e-08 nfin=3 $X=0.125 $Y=0.027
M2 VSS N_M2_g N_M2_s VSS nmos_rvt L=2e-08 W=8.1e-08 nfin=3 $X=0.179 $Y=0.027
M3 VSS N_M3_g N_M3_s VSS nmos_rvt L=2e-08 W=8.1e-08 nfin=3 $X=0.233 $Y=0.027
M4 VSS N_M4_g N_M4_s VSS nmos_rvt L=2e-08 W=8.1e-08 nfin=3 $X=0.287 $Y=0.027
M5 VSS N_M5_g N_M5_s VSS nmos_rvt L=2e-08 W=8.1e-08 nfin=3 $X=0.341 $Y=0.027
M6 N_M6_d N_M6_g N_M6_s VSS nmos_rvt L=2e-08 W=8.1e-08 nfin=3 $X=0.395 $Y=0.027
M7 N_M7_d N_M7_g N_M7_s VSS nmos_rvt L=2e-08 W=8.1e-08 nfin=3 $X=0.449 $Y=0.027
M8 VDD N_M8_g N_M8_s VDD pmos_rvt L=2e-08 W=8.1e-08 nfin=3 $X=0.125 $Y=0.162
M9 N_M9_d N_M9_g VDD VDD pmos_rvt L=2e-08 W=8.1e-08 nfin=3 $X=0.179 $Y=0.162
M10 N_M10_d N_M10_g VDD VDD pmos_rvt L=2e-08 W=8.1e-08 nfin=3 $X=0.341 $Y=0.162
M11 VDD N_M11_g N_M11_s VDD pmos_rvt L=2e-08 W=8.1e-08 nfin=3 $X=0.395 $Y=0.162

* .include "NAND2x2_ASAP7_75t_R.pex.sp.pxi"

* Start of included file NAND2x2_ASAP7_75t_R.pex.sp.pxi
x_PM_NAND2x2_ASAP7_75t_R%A vss A N_M5_g N_M10_g N_M4_g N_M3_g N_M2_g N_M9_g
+ N_A_6 N_A_1 N_A_8 N_A_3 N_A_4 N_A_5 N_A_7 PM_NAND2x2_ASAP7_75t_R%A
cc_1 N_A_6 N_B_20 0.000226007f $X=0.351 $Y=0.0245
cc_2 N_A_6 N_B_19 0.000282433f $X=0.351 $Y=0.0245
cc_3 N_A_1 N_B_21 0.000526083f $X=0.351 $Y=0.1345
cc_4 N_A_1 N_B_17 0.000576768f $X=0.351 $Y=0.1345
cc_5 N_A_8 N_B_12 0.00066444f $X=0.27 $Y=0.1115
cc_6 N_A_1 N_B_1 0.000833291f $X=0.351 $Y=0.1345
cc_7 N_A_1 N_B_2 0.000833291f $X=0.351 $Y=0.1345
cc_8 N_A_8 N_B_19 0.00131057f $X=0.27 $Y=0.1115
cc_9 N_A_1 N_B_19 0.00235318f $X=0.351 $Y=0.1345
cc_10 N_A_8 N_B_14 0.00280425f $X=0.27 $Y=0.1115
cc_11 N_A_3 N_B_6 0.00340927f $X=0.189 $Y=0.1345
cc_12 N_A_6 N_B_7 0.00447173f $X=0.351 $Y=0.0245
x_PM_NAND2x2_ASAP7_75t_R%Y vss Y N_M0_d N_M1_d N_M8_s N_M9_d N_M10_d N_M11_s
+ N_M6_d N_M7_d N_Y_20 N_Y_2 N_Y_1 N_Y_5 N_Y_19 N_Y_21 N_Y_24 N_Y_6 N_Y_30
+ N_Y_32 N_Y_31 N_Y_29 N_Y_33 N_Y_23 N_Y_22 N_Y_3 N_Y_4 N_Y_27 N_Y_25
+ PM_NAND2x2_ASAP7_75t_R%Y
cc_13 N_Y_20 N_B_6 0.000292396f $X=0.4175 $Y=0.0675
cc_14 N_Y_2 N_B_10 0.000398062f $X=0.108 $Y=0.2025
cc_15 N_Y_1 N_B_17 0.000672004f $X=0.108 $Y=0.0675
cc_16 N_Y_5 N_B_21 0.000672004f $X=0.432 $Y=0.0675
cc_17 N_Y_1 N_B_1 0.000736958f $X=0.108 $Y=0.0675
cc_18 N_Y_5 N_B_2 0.000736958f $X=0.432 $Y=0.0675
cc_19 N_Y_19 N_B_5 0.0564416f $X=0.0935 $Y=0.0675
cc_20 N_Y_20 N_B_8 0.0564416f $X=0.4175 $Y=0.0675
cc_21 N_Y_21 N_B_6 0.0113188f $X=0.11 $Y=0.2025
cc_22 N_Y_24 N_B_7 0.0319109f $X=0.4175 $Y=0.2025
cc_23 N_Y_1 N_B_6 0.00184343f $X=0.108 $Y=0.0675
cc_24 N_Y_5 N_B_7 0.00184343f $X=0.432 $Y=0.0675
cc_25 N_Y_6 N_B_8 0.00235574f $X=0.432 $Y=0.2025
cc_26 N_Y_30 N_B_17 0.00237534f $X=0.0855 $Y=0.072
cc_27 N_Y_32 N_B_21 0.00247634f $X=0.502 $Y=0.072
cc_28 N_Y_2 N_B_6 0.00268328f $X=0.108 $Y=0.2025
cc_29 N_Y_31 N_B_10 0.00295194f $X=0.054 $Y=0.234
cc_30 N_Y_31 N_B_14 0.00356418f $X=0.054 $Y=0.234
cc_31 N_Y_30 N_B_9 0.0037556f $X=0.0855 $Y=0.072
cc_32 N_Y_32 N_B_15 0.0037556f $X=0.502 $Y=0.072
cc_33 N_Y_29 N_B_16 0.00433944f $X=0.027 $Y=0.09
cc_34 N_Y_33 N_B_22 0.00479313f $X=0.513 $Y=0.216
cc_35 N_Y_21 N_B_1 0.00486671f $X=0.11 $Y=0.2025
cc_36 N_Y_24 N_B_2 0.00486671f $X=0.4175 $Y=0.2025
cc_37 N_Y_21 N_B_5 0.0206168f $X=0.11 $Y=0.2025
cc_38 N_Y_19 N_B_6 0.0475074f $X=0.0935 $Y=0.0675
cc_39 N_Y_20 N_B_7 0.0490305f $X=0.4175 $Y=0.0675
cc_40 N_Y_23 N_A_8 0.0009795f $X=0.326 $Y=0.2025
cc_41 N_Y_22 N_A_3 0.0301326f $X=0.2015 $Y=0.2025
cc_42 N_Y_23 N_A_6 0.0301326f $X=0.326 $Y=0.2025
cc_43 N_Y_3 N_A_4 0.00225177f $X=0.216 $Y=0.2025
cc_44 N_Y_4 N_A_5 0.00225177f $X=0.324 $Y=0.2025
cc_45 N_Y_22 N_A_1 0.0052082f $X=0.2015 $Y=0.2025
cc_46 N_Y_31 N_A_7 0.00552559f $X=0.054 $Y=0.234
cc_47 N_Y_22 N_A_4 0.0402238f $X=0.2015 $Y=0.2025
cc_48 N_Y_23 N_A_5 0.040926f $X=0.326 $Y=0.2025
cc_49 N_Y_20 N_5_21 0.00058391f $X=0.4175 $Y=0.0675
cc_50 N_Y_31 N_5_21 0.000602189f $X=0.054 $Y=0.234
cc_51 N_Y_27 N_5_21 0.000625317f $X=0.513 $Y=0.072
cc_52 N_Y_25 N_5_21 0.000628877f $X=0.027 $Y=0.072
cc_53 N_Y_29 N_5_1 0.000637155f $X=0.027 $Y=0.09
cc_54 N_Y_30 N_5_1 0.000659821f $X=0.0855 $Y=0.072
cc_55 N_Y_32 N_5_5 0.000659821f $X=0.502 $Y=0.072
cc_56 N_Y_33 N_5_5 0.000690318f $X=0.513 $Y=0.216
cc_57 N_Y_1 N_5_21 0.00072465f $X=0.108 $Y=0.0675
cc_58 N_Y_5 N_5_21 0.00072465f $X=0.432 $Y=0.0675
cc_59 N_Y_19 N_5_16 0.00186303f $X=0.0935 $Y=0.0675
cc_60 N_Y_20 N_5_20 0.00186303f $X=0.4175 $Y=0.0675
cc_61 N_Y_1 N_5_2 0.00117027f $X=0.108 $Y=0.0675
cc_62 N_Y_5 N_5_4 0.00117027f $X=0.432 $Y=0.0675
cc_63 N_Y_30 N_5_21 0.00336878f $X=0.0855 $Y=0.072
cc_64 N_Y_32 N_5_21 0.00336878f $X=0.502 $Y=0.072
cc_65 N_Y_1 N_5_1 0.00467904f $X=0.108 $Y=0.0675
cc_66 N_Y_5 N_5_5 0.00467904f $X=0.432 $Y=0.0675
cc_67 N_Y_3 N_5_21 0.00927207f $X=0.216 $Y=0.2025
x_PM_NAND2x2_ASAP7_75t_R%5 vss N_M0_s N_M1_s N_M2_s N_M3_s N_M4_s N_M5_s N_M6_s
+ N_M7_s N_5_20 N_5_17 N_5_19 N_5_3 N_5_1 N_5_5 N_5_2 N_5_4 N_5_21 N_5_16
+ N_5_18 PM_NAND2x2_ASAP7_75t_R%5
cc_68 N_5_20 N_B_2 0.0017903f $X=0.4715 $Y=0.0675
cc_69 N_5_20 N_B_9 0.000229019f $X=0.4715 $Y=0.0675
cc_70 N_5_20 N_B_15 0.000229019f $X=0.4715 $Y=0.0675
cc_71 N_5_20 N_B_18 0.000258627f $X=0.4715 $Y=0.0675
cc_72 N_5_20 N_B_20 0.000258627f $X=0.4715 $Y=0.0675
cc_73 N_5_20 N_B_5 0.00041874f $X=0.4715 $Y=0.0675
cc_74 N_5_17 N_B_6 0.0329467f $X=0.1475 $Y=0.0675
cc_75 N_5_19 N_B_7 0.0329467f $X=0.3635 $Y=0.0675
cc_76 N_5_3 N_B_19 0.00127262f $X=0.27 $Y=0.0675
cc_77 N_5_1 N_B_5 0.00102919f $X=0.054 $Y=0.0675
cc_78 N_5_5 N_B_8 0.00102919f $X=0.486 $Y=0.0675
cc_79 N_5_2 N_B_17 0.00116154f $X=0.162 $Y=0.0675
cc_80 N_5_4 N_B_21 0.00116315f $X=0.378 $Y=0.0675
cc_81 N_5_21 N_B_11 0.00126201f $X=0.0425 $Y=0.036
cc_82 N_5_21 N_B_13 0.00126201f $X=0.0425 $Y=0.036
cc_83 N_5_2 N_B_6 0.0014167f $X=0.162 $Y=0.0675
cc_84 N_5_4 N_B_7 0.0014167f $X=0.378 $Y=0.0675
cc_85 N_5_16 N_B_1 0.00157287f $X=0.056 $Y=0.0675
cc_86 N_5_16 N_B_5 0.0328592f $X=0.056 $Y=0.0675
cc_87 N_5_21 N_B_19 0.0107164f $X=0.0425 $Y=0.036
cc_88 N_5_20 N_B_8 0.0344775f $X=0.4715 $Y=0.0675
cc_89 N_5_18 N_A_3 0.000639102f $X=0.2555 $Y=0.0675
cc_90 N_5_18 N_A_6 0.000639102f $X=0.2555 $Y=0.0675
cc_91 N_5_3 N_A_4 0.00172397f $X=0.27 $Y=0.0675
cc_92 N_5_18 N_A_1 0.0036565f $X=0.2555 $Y=0.0675
cc_93 N_5_17 N_A_3 0.0325175f $X=0.1475 $Y=0.0675
cc_94 N_5_19 N_A_6 0.0325175f $X=0.3635 $Y=0.0675
cc_95 N_5_18 N_A_4 0.0187468f $X=0.2555 $Y=0.0675
cc_96 N_5_18 N_A_5 0.0497856f $X=0.2555 $Y=0.0675
x_PM_NAND2x2_ASAP7_75t_R%B vss B N_M0_g N_M1_g N_M8_g N_M7_g N_M6_g N_M11_g
+ N_B_20 N_B_19 N_B_21 N_B_17 N_B_12 N_B_1 N_B_2 N_B_14 N_B_6 N_B_7 N_B_9
+ N_B_15 N_B_18 N_B_5 N_B_8 N_B_11 N_B_13 N_B_10 N_B_16 N_B_22
+ PM_NAND2x2_ASAP7_75t_R%B

* End of included file NAND2x2_ASAP7_75t_R.pex.sp.pxi
.ends

.subckt PM_NOR2xp33_ASAP7_75t_R%6 vss 2 3 1
c1 1 vss 0.000696455f $X=0.108 $Y=0.216
r1 2 1 0.314815 $w=5.4e-08 $l=1.7e-08 $layer=P_src_drn $thickness=1e-09
+ $X=0.0906 $Y=0.216 $X2=0.108 $Y2=0.216
r2 3 1 0.314815 $w=5.4e-08 $l=1.7e-08 $layer=P_src_drn $thickness=1e-09
+ $X=0.1253 $Y=0.216 $X2=0.108 $Y2=0.216
.ends

.subckt PM_NOR2xp33_ASAP7_75t_R%Y vss 23 16 17 28 7 8 2 12 11 13
c1 1 vss 0.00634596f $X=0.108 $Y=0.0405
c2 2 vss 0.00639961f $X=0.162 $Y=0.216
c3 7 vss 0.00323056f $X=0.0935 $Y=0.0405
c4 8 vss 0.0280235f $X=0.1475 $Y=0.216
c5 9 vss 0.00306376f $X=0.189 $Y=0.036
c6 10 vss 0.00281211f $X=0.189 $Y=0.234
c7 11 vss 0.00843984f $X=0.0965 $Y=0.036
c8 12 vss 0.00364823f $X=0.162 $Y=0.234
c9 13 vss 0.00637799f $X=0.189 $Y=0.054
r1 8 2 0.231482 $w=5.4e-08 $l=1.25e-08 $layer=P_src_drn $thickness=1e-09
+ $X=0.1475 $Y=0.216 $X2=0.162 $Y2=0.216
r2 28 8 0.0462963 $w=5.4e-08 $l=2.5e-09 $layer=P_src_drn $thickness=1e-09
+ $X=0.1446 $Y=0.216 $X2=0.1475 $Y2=0.216
r3 2 12 19.3796 $a=3.24e-16 $layer=V0LISD $X=0.162 $Y=0.216 $X2=0.162 $Y2=0.234
r4 10 25 2.5483 $w=1.79e-08 $l=1.8e-08 $layer=M1 $thickness=3.6e-08 $X=0.189
+ $Y=0.234 $X2=0.189 $Y2=0.216
r5 10 12 4.64701 $w=1.46667e-08 $l=2.7e-08 $layer=M1 $thickness=3.6e-08
+ $X=0.189 $Y=0.234 $X2=0.162 $Y2=0.234
r6 24 25 4.19742 $w=1.3e-08 $l=1.8e-08 $layer=M1 $thickness=3.6e-08 $X=0.189
+ $Y=0.198 $X2=0.189 $Y2=0.216
r7 23 24 14.691 $w=1.3e-08 $l=6.3e-08 $layer=M1 $thickness=3.6e-08 $X=0.19
+ $Y=0.135 $X2=0.189 $Y2=0.198
r8 23 22 14.691 $w=1.3e-08 $l=6.3e-08 $layer=M1 $thickness=3.6e-08 $X=0.19
+ $Y=0.135 $X2=0.189 $Y2=0.072
r9 13 22 4.19742 $w=1.3e-08 $l=1.8e-08 $layer=M1 $thickness=3.6e-08 $X=0.189
+ $Y=0.054 $X2=0.189 $Y2=0.072
r10 9 21 4.64701 $w=1.46667e-08 $l=2.7e-08 $layer=M1 $thickness=3.6e-08
+ $X=0.189 $Y=0.036 $X2=0.162 $Y2=0.036
r11 9 13 2.5483 $w=1.79e-08 $l=1.8e-08 $layer=M1 $thickness=3.6e-08 $X=0.189
+ $Y=0.036 $X2=0.189 $Y2=0.054
r12 20 21 7.34548 $w=1.3e-08 $l=3.15e-08 $layer=M1 $thickness=3.6e-08 $X=0.1305
+ $Y=0.036 $X2=0.162 $Y2=0.036
r13 19 20 4.31401 $w=1.3e-08 $l=1.85e-08 $layer=M1 $thickness=3.6e-08 $X=0.112
+ $Y=0.036 $X2=0.1305 $Y2=0.036
r14 18 19 2.09871 $w=1.3e-08 $l=9e-09 $layer=M1 $thickness=3.6e-08 $X=0.103
+ $Y=0.036 $X2=0.112 $Y2=0.036
r15 11 18 1.51573 $w=1.3e-08 $l=6.5e-09 $layer=M1 $thickness=3.6e-08 $X=0.0965
+ $Y=0.036 $X2=0.103 $Y2=0.036
r16 1 19 19.3796 $a=3.24e-16 $layer=V0LISD $X=0.108 $Y=0.0405 $X2=0.112
+ $Y2=0.036
r17 17 15 0.0925926 $w=2.7e-08 $l=2.5e-09 $layer=N_src_drn $thickness=1e-09
+ $X=0.1253 $Y=0.0405 $X2=0.1225 $Y2=0.0405
r18 1 15 0.537037 $w=2.7e-08 $l=1.45e-08 $layer=N_src_drn $thickness=1e-09
+ $X=0.108 $Y=0.0405 $X2=0.1225 $Y2=0.0405
r19 7 1 0.537037 $w=2.7e-08 $l=1.45e-08 $layer=N_src_drn $thickness=1e-09
+ $X=0.0935 $Y=0.0405 $X2=0.108 $Y2=0.0405
r20 16 7 0.0925926 $w=2.7e-08 $l=2.5e-09 $layer=N_src_drn $thickness=1e-09
+ $X=0.0906 $Y=0.0405 $X2=0.0935 $Y2=0.0405
.ends

.subckt PM_NOR2xp33_ASAP7_75t_R%B vss 6 7 13 4 5 1 3
c1 1 vss 0.00181656f $X=0.135 $Y=0.135
c2 3 vss 0.0340189f $X=0.135 $Y=0.0245
c3 4 vss 0.00240253f $X=0.135 $Y=0.072
c4 5 vss 0.00413902f $X=0.1345 $Y=0.198
c5 6 vss 0.00524774f $X=0.135 $Y=0.135
r1 5 18 6.11415 $w=1.4371e-08 $l=3.1504e-08 $layer=M1 $thickness=3.6e-08
+ $X=0.1345 $Y=0.198 $X2=0.135 $Y2=0.1665
r2 4 17 6.16517 $w=1.44286e-08 $l=3.15e-08 $layer=M1 $thickness=3.6e-08
+ $X=0.135 $Y=0.072 $X2=0.135 $Y2=0.1035
r3 6 17 7.34548 $w=1.3e-08 $l=3.15e-08 $layer=M1 $thickness=3.6e-08 $X=0.135
+ $Y=0.135 $X2=0.135 $Y2=0.1035
r4 6 18 7.34548 $w=1.3e-08 $l=3.15e-08 $layer=M1 $thickness=3.6e-08 $X=0.135
+ $Y=0.135 $X2=0.135 $Y2=0.1665
r5 1 10 7.07951 $w=1.89474e-08 $layer=LIG $thickness=5.17895e-08 $X=0.135
+ $Y=0.135 $X2=0.135 $Y2=0.135
r6 6 1 19.3796 $a=3.24e-16 $layer=V0LIG $X=0.135 $Y=0.135 $X2=0.135 $Y2=0.135
r7 13 12 14.6259 $w=2.1e-08 $l=4.3e-08 $layer=Gate_1 $thickness=5.6e-08
+ $X=0.135 $Y=0.216 $X2=0.135 $Y2=0.173
r8 11 12 7.65311 $w=2.1e-08 $l=2.25e-08 $layer=Gate_1 $thickness=5.6e-08
+ $X=0.135 $Y=0.1505 $X2=0.135 $Y2=0.173
r9 10 11 5.4252 $w=2.04194e-08 $l=1.55e-08 $layer=Gate_1 $thickness=5.6e-08
+ $X=0.135 $Y=0.135 $X2=0.135 $Y2=0.1505
r10 9 10 5.4252 $w=2.04194e-08 $l=1.55e-08 $layer=Gate_1 $thickness=5.6e-08
+ $X=0.135 $Y=0.1195 $X2=0.135 $Y2=0.135
r11 8 9 12.245 $w=2.1e-08 $l=3.6e-08 $layer=Gate_1 $thickness=5.6e-08 $X=0.135
+ $Y=0.0835 $X2=0.135 $Y2=0.1195
r12 7 8 14.6259 $w=2.1e-08 $l=4.3e-08 $layer=Gate_1 $thickness=5.6e-08 $X=0.135
+ $Y=0.0405 $X2=0.135 $Y2=0.0835
r13 7 3 5.44221 $w=2.1e-08 $l=1.6e-08 $layer=Gate_1 $thickness=5.6e-08 $X=0.135
+ $Y=0.0405 $X2=0.135 $Y2=0.0245
.ends

.subckt PM_NOR2xp33_ASAP7_75t_R%A vss 22 10 16 9 1 3 4
c1 1 vss 0.00429599f $X=0.072 $Y=0.135
c2 3 vss 0.05998f $X=0.081 $Y=0.0245
c3 4 vss 0.00680297f $X=0.027 $Y=0.036
c4 5 vss 0.00106659f $X=0.027 $Y=0.135
c5 6 vss 0.00735382f $X=0.027 $Y=0.234
c6 7 vss 0.00604095f $X=0.027 $Y=0.1035
c7 8 vss 0.00650925f $X=0.027 $Y=0.1665
c8 9 vss 0.00137902f $X=0.0455 $Y=0.135
r1 6 27 3.01711 $w=1.55e-08 $l=1.8e-08 $layer=M1 $thickness=3.6e-08 $X=0.027
+ $Y=0.234 $X2=0.027 $Y2=0.216
r2 4 25 3.01711 $w=1.55e-08 $l=1.8e-08 $layer=M1 $thickness=3.6e-08 $X=0.027
+ $Y=0.036 $X2=0.027 $Y2=0.054
r3 26 27 4.19742 $w=1.3e-08 $l=1.8e-08 $layer=M1 $thickness=3.6e-08 $X=0.027
+ $Y=0.198 $X2=0.027 $Y2=0.216
r4 8 26 7.34548 $w=1.3e-08 $l=3.15e-08 $layer=M1 $thickness=3.6e-08 $X=0.027
+ $Y=0.1665 $X2=0.027 $Y2=0.198
r5 24 25 4.19742 $w=1.3e-08 $l=1.8e-08 $layer=M1 $thickness=3.6e-08 $X=0.027
+ $Y=0.072 $X2=0.027 $Y2=0.054
r6 7 24 7.34548 $w=1.3e-08 $l=3.15e-08 $layer=M1 $thickness=3.6e-08 $X=0.027
+ $Y=0.1035 $X2=0.027 $Y2=0.072
r7 5 9 3.1337 $w=1.54324e-08 $l=1.85e-08 $layer=M1 $thickness=3.6e-08 $X=0.027
+ $Y=0.135 $X2=0.0455 $Y2=0.135
r8 5 7 6.16517 $w=1.44286e-08 $l=3.15e-08 $layer=M1 $thickness=3.6e-08 $X=0.027
+ $Y=0.135 $X2=0.027 $Y2=0.1035
r9 5 8 6.16517 $w=1.44286e-08 $l=3.15e-08 $layer=M1 $thickness=3.6e-08 $X=0.027
+ $Y=0.135 $X2=0.027 $Y2=0.1665
r10 22 9 4.31401 $w=1.3e-08 $l=1.85e-08 $layer=M1 $thickness=3.6e-08 $X=0.06
+ $Y=0.135 $X2=0.0455 $Y2=0.135
r11 22 20 19.3796 $a=3.24e-16 $layer=V0LIG $X=0.06 $Y=0.135 $X2=0.063 $Y2=0.135
r12 1 18 3.86521 $w=1.8e-08 $l=1e-08 $layer=LIG $thickness=4.8e-08 $X=0.072
+ $Y=0.135 $X2=0.082 $Y2=0.135
r13 1 20 12.7513 $w=1.20444e-08 $l=9e-09 $layer=LIG $thickness=4.8e-08 $X=0.072
+ $Y=0.135 $X2=0.063 $Y2=0.135
r14 16 15 14.6259 $w=2.1e-08 $l=4.3e-08 $layer=Gate_1 $thickness=5.6e-08
+ $X=0.081 $Y=0.216 $X2=0.081 $Y2=0.173
r15 14 15 7.65311 $w=2.1e-08 $l=2.25e-08 $layer=Gate_1 $thickness=5.6e-08
+ $X=0.081 $Y=0.1505 $X2=0.081 $Y2=0.173
r16 13 14 5.4252 $w=2.04194e-08 $l=1.55e-08 $layer=Gate_1 $thickness=5.6e-08
+ $X=0.081 $Y=0.135 $X2=0.081 $Y2=0.1505
r17 13 18 6.69299 $w=1.9e-08 $l=1e-09 $layer=LIG $thickness=5.2e-08 $X=0.081
+ $Y=0.135 $X2=0.082 $Y2=0.135
r18 12 13 5.4252 $w=2.04194e-08 $l=1.55e-08 $layer=Gate_1 $thickness=5.6e-08
+ $X=0.081 $Y=0.1195 $X2=0.081 $Y2=0.135
r19 11 12 12.245 $w=2.1e-08 $l=3.6e-08 $layer=Gate_1 $thickness=5.6e-08
+ $X=0.081 $Y=0.0835 $X2=0.081 $Y2=0.1195
r20 10 11 14.6259 $w=2.1e-08 $l=4.3e-08 $layer=Gate_1 $thickness=5.6e-08
+ $X=0.081 $Y=0.0405 $X2=0.081 $Y2=0.0835
r21 10 3 5.44221 $w=2.1e-08 $l=1.6e-08 $layer=Gate_1 $thickness=5.6e-08
+ $X=0.081 $Y=0.0405 $X2=0.081 $Y2=0.0245
.ends

* End of included file NOR2xp33_ASAP7_75t_R.pex.sp.pex

*
.subckt NOR2xp33_ASAP7_75t_CUSTOM_4_25_0_7 VSS VDD A B Y
*
* VSS VSS
* VDD VDD
* A A
* B B
* Y Y
*
*

M0 N_M0_d N_M0_g VSS VSS nmos_rvt L=2e-08 W=2.7e-08 nfin=1 $X=0.071 $Y=0.027
M1 VSS N_M1_g N_M1_s VSS nmos_rvt L=2e-08 W=2.7e-08 nfin=1 $X=0.125 $Y=0.027
M2 N_M2_d N_M2_g VDD VDD pmos_rvt L=2e-08 W=5.4e-08 nfin=2 $X=0.071 $Y=0.189
M3 N_M3_d N_M3_g N_M3_s VDD pmos_rvt L=2e-08 W=5.4e-08 nfin=2 $X=0.125 $Y=0.189

* .include "NOR2xp33_ASAP7_75t_R.pex.sp.pxi"

* Start of included file NOR2xp33_ASAP7_75t_R.pex.sp.pxi
x_PM_NOR2xp33_ASAP7_75t_R%6 vss N_M2_d N_M3_s N_6_1 PM_NOR2xp33_ASAP7_75t_R%6
cc_1 N_6_1 N_A_3 0.0121126f $X=0.108 $Y=0.216
cc_2 N_6_1 N_B_3 0.0121222f $X=0.108 $Y=0.216
x_PM_NOR2xp33_ASAP7_75t_R%Y vss Y N_M0_d N_M1_s N_M3_d N_Y_7 N_Y_8 N_Y_2 N_Y_12
+ N_Y_11 N_Y_13 PM_NOR2xp33_ASAP7_75t_R%Y
cc_3 N_Y_7 N_A_4 0.000806098f $X=0.0935 $Y=0.0405
cc_4 N_Y_7 N_A_3 0.0175263f $X=0.0935 $Y=0.0405
cc_5 N_Y_8 N_B_1 0.00132375f $X=0.1475 $Y=0.216
cc_6 N_Y_2 N_B_3 0.00104851f $X=0.162 $Y=0.216
cc_7 N_Y_12 N_B_5 0.00233405f $X=0.162 $Y=0.234
cc_8 N_Y_7 N_B_3 0.00648525f $X=0.0935 $Y=0.0405
cc_9 N_Y_11 N_B_4 0.00429923f $X=0.0965 $Y=0.036
cc_10 N_Y_13 B 0.00587224f $X=0.189 $Y=0.054
cc_11 N_Y_8 N_B_3 0.0361072f $X=0.1475 $Y=0.216
x_PM_NOR2xp33_ASAP7_75t_R%B vss B N_M1_g N_M3_g N_B_4 N_B_5 N_B_1 N_B_3
+ PM_NOR2xp33_ASAP7_75t_R%B
cc_12 N_B_4 N_A_9 0.00047772f $X=0.135 $Y=0.072
cc_13 N_B_5 N_A_9 0.000650718f $X=0.1345 $Y=0.198
cc_14 N_B_1 N_A_1 0.00185675f $X=0.135 $Y=0.135
cc_15 B N_A_9 0.00192576f $X=0.135 $Y=0.135
cc_16 N_B_3 N_A_3 0.0129805f $X=0.135 $Y=0.0245
x_PM_NOR2xp33_ASAP7_75t_R%A vss A N_M0_g N_M2_g N_A_9 N_A_1 N_A_3 N_A_4
+ PM_NOR2xp33_ASAP7_75t_R%A

* End of included file NOR2xp33_ASAP7_75t_R.pex.sp.pxi
.ends

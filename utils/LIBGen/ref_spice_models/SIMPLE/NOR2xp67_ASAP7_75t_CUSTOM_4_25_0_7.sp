.subckt PM_NOR2xp67_ASAP7_75t_R%5 vss 15 29 30 32 11 1 13 10 2 12 3
c1 1 vss 0.0073641f $X=0.054 $Y=0.216
c2 2 vss 0.00546146f $X=0.162 $Y=0.216
c3 3 vss 0.00564027f $X=0.27 $Y=0.216
c4 10 vss 0.0276517f $X=0.056 $Y=0.216
c5 11 vss 0.00285613f $X=0.1475 $Y=0.216
c6 12 vss 0.0268597f $X=0.2555 $Y=0.216
c7 13 vss 0.0200047f $X=0.0425 $Y=0.234
r1 12 3 0.231482 $w=5.4e-08 $l=1.25e-08 $layer=P_src_drn $thickness=1e-09
+ $X=0.2555 $Y=0.216 $X2=0.27 $Y2=0.216
r2 32 12 0.0462963 $w=5.4e-08 $l=2.5e-09 $layer=P_src_drn $thickness=1e-09
+ $X=0.2526 $Y=0.216 $X2=0.2555 $Y2=0.216
r3 30 28 0.0462963 $w=5.4e-08 $l=2.5e-09 $layer=P_src_drn $thickness=1e-09
+ $X=0.1793 $Y=0.216 $X2=0.1765 $Y2=0.216
r4 2 28 0.268519 $w=5.4e-08 $l=1.45e-08 $layer=P_src_drn $thickness=1e-09
+ $X=0.162 $Y=0.216 $X2=0.1765 $Y2=0.216
r5 11 2 0.268519 $w=5.4e-08 $l=1.45e-08 $layer=P_src_drn $thickness=1e-09
+ $X=0.1475 $Y=0.216 $X2=0.162 $Y2=0.216
r6 29 11 0.0462963 $w=5.4e-08 $l=2.5e-09 $layer=P_src_drn $thickness=1e-09
+ $X=0.1446 $Y=0.216 $X2=0.1475 $Y2=0.216
r7 3 25 19.3796 $a=3.24e-16 $layer=V0LISD $X=0.27 $Y=0.216 $X2=0.27 $Y2=0.234
r8 2 22 19.3796 $a=3.24e-16 $layer=V0LISD $X=0.162 $Y=0.216 $X2=0.162 $Y2=0.234
r9 24 25 8.97781 $w=1.3e-08 $l=3.85e-08 $layer=M1 $thickness=3.6e-08 $X=0.2315
+ $Y=0.234 $X2=0.27 $Y2=0.234
r10 23 24 10.4935 $w=1.3e-08 $l=4.5e-08 $layer=M1 $thickness=3.6e-08 $X=0.1865
+ $Y=0.234 $X2=0.2315 $Y2=0.234
r11 22 23 5.71315 $w=1.3e-08 $l=2.45e-08 $layer=M1 $thickness=3.6e-08 $X=0.162
+ $Y=0.234 $X2=0.1865 $Y2=0.234
r12 21 22 3.14806 $w=1.3e-08 $l=1.35e-08 $layer=M1 $thickness=3.6e-08 $X=0.1485
+ $Y=0.234 $X2=0.162 $Y2=0.234
r13 20 21 5.36336 $w=1.3e-08 $l=2.3e-08 $layer=M1 $thickness=3.6e-08 $X=0.1255
+ $Y=0.234 $X2=0.1485 $Y2=0.234
r14 19 20 5.71315 $w=1.3e-08 $l=2.45e-08 $layer=M1 $thickness=3.6e-08 $X=0.101
+ $Y=0.234 $X2=0.1255 $Y2=0.234
r15 18 19 5.13017 $w=1.3e-08 $l=2.2e-08 $layer=M1 $thickness=3.6e-08 $X=0.079
+ $Y=0.234 $X2=0.101 $Y2=0.234
r16 17 18 4.6638 $w=1.3e-08 $l=2e-08 $layer=M1 $thickness=3.6e-08 $X=0.059
+ $Y=0.234 $X2=0.079 $Y2=0.234
r17 16 17 2.09871 $w=1.3e-08 $l=9e-09 $layer=M1 $thickness=3.6e-08 $X=0.05
+ $Y=0.234 $X2=0.059 $Y2=0.234
r18 13 16 1.74892 $w=1.3e-08 $l=7.5e-09 $layer=M1 $thickness=3.6e-08 $X=0.0425
+ $Y=0.234 $X2=0.05 $Y2=0.234
r19 1 16 19.3796 $a=3.24e-16 $layer=V0LISD $X=0.054 $Y=0.216 $X2=0.05 $Y2=0.234
r20 15 14 0.0462963 $w=5.4e-08 $l=2.5e-09 $layer=P_src_drn $thickness=1e-09
+ $X=0.0713 $Y=0.216 $X2=0.0685 $Y2=0.216
r21 10 14 0.231482 $w=5.4e-08 $l=1.25e-08 $layer=P_src_drn $thickness=1e-09
+ $X=0.056 $Y=0.216 $X2=0.0685 $Y2=0.216
r22 1 10 1e-05 $l=2e-09 $X=0.054 $Y=0.216 $X2=0.056 $Y2=0.216
.ends

.subckt PM_NOR2xp67_ASAP7_75t_R%Y vss 30 17 25 38 39 8 1 9 10 15 2 13 14
c1 1 vss 0.0111596f $X=0.108 $Y=0.054
c2 2 vss 0.00284793f $X=0.216 $Y=0.216
c3 8 vss 0.00268169f $X=0.0935 $Y=0.054
c4 9 vss 0.0026686f $X=0.164 $Y=0.054
c5 10 vss 0.00202274f $X=0.2015 $Y=0.216
c6 11 vss 0.0028497f $X=0.297 $Y=0.036
c7 12 vss 0.00104136f $X=0.297 $Y=0.198
c8 13 vss 0.0134147f $X=0.1505 $Y=0.036
c9 14 vss 0.000833665f $X=0.286 $Y=0.198
c10 15 vss 0.00433178f $X=0.297 $Y=0.054
r1 39 37 0.0462963 $w=5.4e-08 $l=2.5e-09 $layer=P_src_drn $thickness=1e-09
+ $X=0.2333 $Y=0.216 $X2=0.2305 $Y2=0.216
r2 2 37 0.268519 $w=5.4e-08 $l=1.45e-08 $layer=P_src_drn $thickness=1e-09
+ $X=0.216 $Y=0.216 $X2=0.2305 $Y2=0.216
r3 10 2 0.268519 $w=5.4e-08 $l=1.45e-08 $layer=P_src_drn $thickness=1e-09
+ $X=0.2015 $Y=0.216 $X2=0.216 $Y2=0.216
r4 38 10 0.0462963 $w=5.4e-08 $l=2.5e-09 $layer=P_src_drn $thickness=1e-09
+ $X=0.1986 $Y=0.216 $X2=0.2015 $Y2=0.216
r5 2 34 19.3796 $a=3.24e-16 $layer=V0LISD $X=0.216 $Y=0.216 $X2=0.216 $Y2=0.198
r6 34 35 5.82974 $w=1.3e-08 $l=2.5e-08 $layer=M1 $thickness=3.6e-08 $X=0.216
+ $Y=0.198 $X2=0.241 $Y2=0.198
r7 32 35 6.8791 $w=1.3e-08 $l=2.95e-08 $layer=M1 $thickness=3.6e-08 $X=0.2705
+ $Y=0.198 $X2=0.241 $Y2=0.198
r8 14 32 3.61444 $w=1.3e-08 $l=1.55e-08 $layer=M1 $thickness=3.6e-08 $X=0.286
+ $Y=0.198 $X2=0.2705 $Y2=0.198
r9 12 31 3.30617 $w=1.71506e-08 $l=2.13e-08 $layer=M1 $thickness=3.6e-08
+ $X=0.297 $Y=0.198 $X2=0.297 $Y2=0.1767
r10 12 14 0.915974 $w=1.70909e-08 $l=1.1e-08 $layer=M1 $thickness=3.6e-08
+ $X=0.297 $Y=0.198 $X2=0.286 $Y2=0.198
r11 30 31 2.97317 $w=1.3e-08 $l=1.27e-08 $layer=M1 $thickness=3.6e-08 $X=0.296
+ $Y=0.164 $X2=0.297 $Y2=0.1767
r12 30 29 2.39019 $w=1.3e-08 $l=1.03e-08 $layer=M1 $thickness=3.6e-08 $X=0.296
+ $Y=0.164 $X2=0.297 $Y2=0.1537
r13 28 29 4.37231 $w=1.3e-08 $l=1.87e-08 $layer=M1 $thickness=3.6e-08 $X=0.297
+ $Y=0.135 $X2=0.297 $Y2=0.1537
r14 27 28 7.34548 $w=1.3e-08 $l=3.15e-08 $layer=M1 $thickness=3.6e-08 $X=0.297
+ $Y=0.1035 $X2=0.297 $Y2=0.135
r15 26 27 7.34548 $w=1.3e-08 $l=3.15e-08 $layer=M1 $thickness=3.6e-08 $X=0.297
+ $Y=0.072 $X2=0.297 $Y2=0.1035
r16 15 26 4.19742 $w=1.3e-08 $l=1.8e-08 $layer=M1 $thickness=3.6e-08 $X=0.297
+ $Y=0.054 $X2=0.297 $Y2=0.072
r17 11 23 4.06404 $w=1.48367e-08 $l=2.45e-08 $layer=M1 $thickness=3.6e-08
+ $X=0.297 $Y=0.036 $X2=0.2725 $Y2=0.036
r18 11 15 2.5483 $w=1.79e-08 $l=1.8e-08 $layer=M1 $thickness=3.6e-08 $X=0.297
+ $Y=0.036 $X2=0.297 $Y2=0.054
r19 25 24 0.0462963 $w=5.4e-08 $l=2.5e-09 $layer=N_src_drn $thickness=1e-09
+ $X=0.1793 $Y=0.054 $X2=0.1765 $Y2=0.054
r20 9 24 0.231482 $w=5.4e-08 $l=1.25e-08 $layer=N_src_drn $thickness=1e-09
+ $X=0.164 $Y=0.054 $X2=0.1765 $Y2=0.054
r21 22 23 13.6416 $w=1.3e-08 $l=5.85e-08 $layer=M1 $thickness=3.6e-08 $X=0.214
+ $Y=0.036 $X2=0.2725 $Y2=0.036
r22 21 22 10.9599 $w=1.3e-08 $l=4.7e-08 $layer=M1 $thickness=3.6e-08 $X=0.167
+ $Y=0.036 $X2=0.214 $Y2=0.036
r23 20 21 2.09871 $w=1.3e-08 $l=9e-09 $layer=M1 $thickness=3.6e-08 $X=0.158
+ $Y=0.036 $X2=0.167 $Y2=0.036
r24 13 20 1.74892 $w=1.3e-08 $l=7.5e-09 $layer=M1 $thickness=3.6e-08 $X=0.1505
+ $Y=0.036 $X2=0.158 $Y2=0.036
r25 9 20 19.3796 $a=3.24e-16 $layer=V0LISD $X=0.164 $Y=0.054 $X2=0.158 $Y2=0.036
r26 18 9 4.04632 $w=5.02e-08 $l=2.7e-08 $layer=LISD $thickness=2.7e-08 $X=0.135
+ $Y=0.054 $X2=0.164 $Y2=0.054
r27 1 18 4.04632 $w=5.02e-08 $l=2.7e-08 $layer=LISD $thickness=2.7e-08 $X=0.108
+ $Y=0.054 $X2=0.135 $Y2=0.054
r28 8 1 0.231482 $w=5.4e-08 $l=1.25e-08 $layer=N_src_drn $thickness=1e-09
+ $X=0.0935 $Y=0.054 $X2=0.108 $Y2=0.054
r29 17 8 0.0462963 $w=5.4e-08 $l=2.5e-09 $layer=N_src_drn $thickness=1e-09
+ $X=0.0906 $Y=0.054 $X2=0.0935 $Y2=0.054
.ends

.subckt PM_NOR2xp67_ASAP7_75t_R%A vss 25 11 17 30 10 1 4 3 7
c1 1 vss 0.00459204f $X=0.0715 $Y=0.136
c2 3 vss 0.0684551f $X=0.081 $Y=0.0245
c3 4 vss 0.0345183f $X=0.135 $Y=0.136
c4 5 vss 0.0088633f $X=0.027 $Y=0.036
c5 6 vss 0.00170686f $X=0.027 $Y=0.136
c6 7 vss 0.00446024f $X=0.027 $Y=0.198
c7 8 vss 0.00997217f $X=0.027 $Y=0.104
c8 9 vss 0.00450947f $X=0.027 $Y=0.167
c9 10 vss 0.00243811f $X=0.0635 $Y=0.136
r1 7 9 6.04857 $w=1.44516e-08 $l=3.1e-08 $layer=M1 $thickness=3.6e-08 $X=0.027
+ $Y=0.198 $X2=0.027 $Y2=0.167
r2 5 33 3.01711 $w=1.55e-08 $l=1.8e-08 $layer=M1 $thickness=3.6e-08 $X=0.027
+ $Y=0.036 $X2=0.027 $Y2=0.054
r3 32 33 4.19742 $w=1.3e-08 $l=1.8e-08 $layer=M1 $thickness=3.6e-08 $X=0.027
+ $Y=0.072 $X2=0.027 $Y2=0.054
r4 8 32 7.46207 $w=1.3e-08 $l=3.2e-08 $layer=M1 $thickness=3.6e-08 $X=0.027
+ $Y=0.104 $X2=0.027 $Y2=0.072
r5 6 27 3.1337 $w=1.54324e-08 $l=1.85e-08 $layer=M1 $thickness=3.6e-08 $X=0.027
+ $Y=0.136 $X2=0.0455 $Y2=0.136
r6 6 8 6.28176 $w=1.44063e-08 $l=3.2e-08 $layer=M1 $thickness=3.6e-08 $X=0.027
+ $Y=0.136 $X2=0.027 $Y2=0.104
r7 6 9 6.04857 $w=1.44516e-08 $l=3.1e-08 $layer=M1 $thickness=3.6e-08 $X=0.027
+ $Y=0.136 $X2=0.027 $Y2=0.167
r8 30 29 16.3266 $w=2.1e-08 $l=4.8e-08 $layer=Gate_1 $thickness=5.6e-08
+ $X=0.135 $Y=0.216 $X2=0.135 $Y2=0.168
r9 4 23 6.54019 $w=2.09524e-08 $layer=Gate_1 $thickness=5.21905e-08 $X=0.135
+ $Y=0.136 $X2=0.135 $Y2=0.136
r10 4 29 11.0715 $w=2.06563e-08 $l=3.2e-08 $layer=Gate_1 $thickness=5.6e-08
+ $X=0.135 $Y=0.136 $X2=0.135 $Y2=0.168
r11 25 10 4.08082 $w=1.3e-08 $l=1.75e-08 $layer=M1 $thickness=3.6e-08 $X=0.081
+ $Y=0.13 $X2=0.0635 $Y2=0.136
r12 10 27 4.19742 $w=1.3e-08 $l=1.8e-08 $layer=M1 $thickness=3.6e-08 $X=0.0635
+ $Y=0.136 $X2=0.0455 $Y2=0.136
r13 22 23 12.6539 $w=1.77815e-08 $l=2.7e-08 $layer=LIG $thickness=4.8e-08
+ $X=0.108 $Y=0.136 $X2=0.135 $Y2=0.136
r14 20 22 10.1729 $w=1.54914e-08 $l=1.75e-08 $layer=LIG $thickness=4.8e-08
+ $X=0.0905 $Y=0.136 $X2=0.108 $Y2=0.136
r15 19 20 2.48102 $w=2.2e-08 $l=9.5e-09 $layer=LIG $thickness=4.8e-08 $X=0.081
+ $Y=0.136 $X2=0.0905 $Y2=0.136
r16 25 19 19.3796 $a=3.24e-16 $layer=V0LIG $X=0.081 $Y=0.13 $X2=0.081 $Y2=0.136
r17 1 19 2.48102 $w=2.2e-08 $l=9.5e-09 $layer=LIG $thickness=4.8e-08 $X=0.0715
+ $Y=0.136 $X2=0.081 $Y2=0.136
r18 17 16 14.6259 $w=2.1e-08 $l=4.3e-08 $layer=Gate_1 $thickness=5.6e-08
+ $X=0.081 $Y=0.216 $X2=0.081 $Y2=0.173
r19 15 16 7.1429 $w=2.1e-08 $l=2.1e-08 $layer=Gate_1 $thickness=5.6e-08
+ $X=0.081 $Y=0.152 $X2=0.081 $Y2=0.173
r20 14 15 5.62929 $w=2.03125e-08 $l=1.6e-08 $layer=Gate_1 $thickness=5.6e-08
+ $X=0.081 $Y=0.136 $X2=0.081 $Y2=0.152
r21 14 20 4.05918 $w=2.0087e-08 $l=9.5e-09 $layer=Gate_1 $thickness=5.56522e-08
+ $X=0.081 $Y=0.136 $X2=0.0905 $Y2=0.136
r22 14 19 6.27904 $w=2.09e-08 $layer=Gate_1 $thickness=5.24e-08 $X=0.081
+ $Y=0.136 $X2=0.081 $Y2=0.136
r23 13 14 5.96942 $w=2.03529e-08 $l=1.7e-08 $layer=Gate_1 $thickness=5.6e-08
+ $X=0.081 $Y=0.119 $X2=0.081 $Y2=0.136
r24 12 13 7.48304 $w=2.1e-08 $l=2.2e-08 $layer=Gate_1 $thickness=5.6e-08
+ $X=0.081 $Y=0.097 $X2=0.081 $Y2=0.119
r25 11 12 14.6259 $w=2.1e-08 $l=4.3e-08 $layer=Gate_1 $thickness=5.6e-08
+ $X=0.081 $Y=0.054 $X2=0.081 $Y2=0.097
r26 11 3 10.0341 $w=2.1e-08 $l=2.95e-08 $layer=Gate_1 $thickness=5.6e-08
+ $X=0.081 $Y=0.054 $X2=0.081 $Y2=0.0245
.ends

.subckt PM_NOR2xp67_ASAP7_75t_R%B vss 29 11 15 27 5 1 9 8 7 3 4 6 10
c1 1 vss 0.00733082f $X=0.189 $Y=0.136
c2 3 vss 0.0351287f $X=0.189 $Y=0.0245
c3 4 vss 0.0496079f $X=0.243 $Y=0.136
c4 5 vss 0.00323204f $X=0.135 $Y=0.198
c5 6 vss 0.0032088f $X=0.135 $Y=0.072
c6 7 vss 0.0019905f $X=0.135 $Y=0.1265
c7 8 vss 0.00264897f $X=0.135 $Y=0.1035
c8 9 vss 0.00254236f $X=0.135 $Y=0.1445
c9 10 vss 0.00304685f $X=0.218 $Y=0.135
r1 5 34 6.04857 $w=1.44516e-08 $l=3.1e-08 $layer=M1 $thickness=3.6e-08 $X=0.135
+ $Y=0.198 $X2=0.135 $Y2=0.167
r2 6 8 6.16517 $w=1.44286e-08 $l=3.15e-08 $layer=M1 $thickness=3.6e-08 $X=0.135
+ $Y=0.072 $X2=0.135 $Y2=0.1035
r3 9 33 0.983973 $w=1.77222e-08 $l=9e-09 $layer=M1 $thickness=3.6e-08 $X=0.135
+ $Y=0.1445 $X2=0.135 $Y2=0.1355
r4 9 34 5.24677 $w=1.3e-08 $l=2.25e-08 $layer=M1 $thickness=3.6e-08 $X=0.135
+ $Y=0.1445 $X2=0.135 $Y2=0.167
r5 7 32 2.26632 $w=1.325e-08 $l=2.03593e-08 $layer=M1 $thickness=3.6e-08
+ $X=0.135 $Y=0.1265 $X2=0.1535 $Y2=0.135
r6 7 33 0.9184 $w=1.8e-08 $l=9e-09 $layer=M1 $thickness=3.6e-08 $X=0.135
+ $Y=0.1265 $X2=0.135 $Y2=0.1355
r7 7 8 5.29779 $w=1.31087e-08 $l=2.3e-08 $layer=M1 $thickness=3.6e-08 $X=0.135
+ $Y=0.1265 $X2=0.135 $Y2=0.1035
r8 31 32 6.7625 $w=1.3e-08 $l=2.9e-08 $layer=M1 $thickness=3.6e-08 $X=0.1825
+ $Y=0.135 $X2=0.1535 $Y2=0.135
r9 29 10 5.82974 $w=1.3e-08 $l=2.5e-08 $layer=M1 $thickness=3.6e-08 $X=0.243
+ $Y=0.134 $X2=0.218 $Y2=0.135
r10 10 31 8.27824 $w=1.3e-08 $l=3.55e-08 $layer=M1 $thickness=3.6e-08 $X=0.218
+ $Y=0.135 $X2=0.1825 $Y2=0.135
r11 27 26 14.6259 $w=2.1e-08 $l=4.3e-08 $layer=Gate_1 $thickness=5.6e-08
+ $X=0.243 $Y=0.216 $X2=0.243 $Y2=0.173
r12 25 26 7.1429 $w=2.1e-08 $l=2.1e-08 $layer=Gate_1 $thickness=5.6e-08
+ $X=0.243 $Y=0.152 $X2=0.243 $Y2=0.173
r13 4 20 6.27904 $w=2.09e-08 $layer=Gate_1 $thickness=5.24e-08 $X=0.243
+ $Y=0.136 $X2=0.243 $Y2=0.136
r14 4 25 5.62929 $w=2.03125e-08 $l=1.6e-08 $layer=Gate_1 $thickness=5.6e-08
+ $X=0.243 $Y=0.136 $X2=0.243 $Y2=0.152
r15 29 20 19.3796 $a=3.24e-16 $layer=V0LIG $X=0.243 $Y=0.134 $X2=0.243 $Y2=0.136
r16 19 20 2.48102 $w=2.2e-08 $l=9.5e-09 $layer=LIG $thickness=4.8e-08 $X=0.2335
+ $Y=0.136 $X2=0.243 $Y2=0.136
r17 18 19 10.1729 $w=1.54914e-08 $l=1.75e-08 $layer=LIG $thickness=4.8e-08
+ $X=0.216 $Y=0.136 $X2=0.2335 $Y2=0.136
r18 1 13 6.54019 $w=2.09524e-08 $layer=Gate_1 $thickness=5.21905e-08 $X=0.189
+ $Y=0.136 $X2=0.189 $Y2=0.136
r19 1 18 12.6539 $w=1.77815e-08 $l=2.7e-08 $layer=LIG $thickness=4.8e-08
+ $X=0.189 $Y=0.136 $X2=0.216 $Y2=0.136
r20 15 14 16.3266 $w=2.1e-08 $l=4.8e-08 $layer=Gate_1 $thickness=5.6e-08
+ $X=0.189 $Y=0.216 $X2=0.189 $Y2=0.168
r21 13 14 11.0715 $w=2.06563e-08 $l=3.2e-08 $layer=Gate_1 $thickness=5.6e-08
+ $X=0.189 $Y=0.136 $X2=0.189 $Y2=0.168
r22 12 13 11.4116 $w=2.06667e-08 $l=3.3e-08 $layer=Gate_1 $thickness=5.6e-08
+ $X=0.189 $Y=0.103 $X2=0.189 $Y2=0.136
r23 11 12 16.6668 $w=2.1e-08 $l=4.9e-08 $layer=Gate_1 $thickness=5.6e-08
+ $X=0.189 $Y=0.054 $X2=0.189 $Y2=0.103
r24 11 3 10.0341 $w=2.1e-08 $l=2.95e-08 $layer=Gate_1 $thickness=5.6e-08
+ $X=0.189 $Y=0.054 $X2=0.189 $Y2=0.0245
.ends

* End of included file NOR2xp67_ASAP7_75t_R.pex.sp.pex

*
.subckt NOR2xp67_ASAP7_75t_CUSTOM_4_25_0_7 VSS VDD A B Y
*
* VSS VSS
* VDD VDD
* A A
* B B
* Y Y
*
*

M0 N_M0_d N_M0_g VSS VSS nmos_rvt L=2e-08 W=5.4e-08 nfin=2 $X=0.071 $Y=0.027
M1 VSS N_M1_g N_M1_s VSS nmos_rvt L=2e-08 W=5.4e-08 nfin=2 $X=0.179 $Y=0.027
M2 VDD N_M2_g N_M2_s VDD pmos_rvt L=2e-08 W=5.4e-08 nfin=2 $X=0.071 $Y=0.189
M3 VDD N_M3_g N_M3_s VDD pmos_rvt L=2e-08 W=5.4e-08 nfin=2 $X=0.125 $Y=0.189
M4 N_M4_d N_M4_g N_M4_s VDD pmos_rvt L=2e-08 W=5.4e-08 nfin=2 $X=0.179 $Y=0.189
M5 N_M5_d N_M5_g N_M5_s VDD pmos_rvt L=2e-08 W=5.4e-08 nfin=2 $X=0.233 $Y=0.189

* .include "NOR2xp67_ASAP7_75t_R.pex.sp.pxi"

* Start of included file NOR2xp67_ASAP7_75t_R.pex.sp.pxi
x_PM_NOR2xp67_ASAP7_75t_R%5 vss N_M2_s N_M3_s N_M4_s N_M5_s N_5_11 N_5_1 N_5_13
+ N_5_10 N_5_2 N_5_12 N_5_3 PM_NOR2xp67_ASAP7_75t_R%5
cc_1 N_5_11 N_A_1 0.000956076f $X=0.1475 $Y=0.216
cc_2 N_5_1 N_A_3 0.00116194f $X=0.054 $Y=0.216
cc_3 N_5_13 N_A_4 0.00147197f $X=0.0425 $Y=0.234
cc_4 N_5_13 N_A_7 0.00174172f $X=0.0425 $Y=0.234
cc_5 N_5_10 N_A_3 0.0243751f $X=0.056 $Y=0.216
cc_6 N_5_11 N_A_4 0.0267082f $X=0.1475 $Y=0.216
cc_7 N_5_11 N_B_4 0.000517526f $X=0.1475 $Y=0.216
cc_8 N_5_11 N_B_1 0.000651189f $X=0.1475 $Y=0.216
cc_9 N_5_2 N_B_3 0.000863448f $X=0.162 $Y=0.216
cc_10 N_5_13 N_B_5 0.00478025f $X=0.0425 $Y=0.234
cc_11 N_5_12 N_B_4 0.0241432f $X=0.2555 $Y=0.216
cc_12 N_5_11 N_B_3 0.0265085f $X=0.1475 $Y=0.216
x_PM_NOR2xp67_ASAP7_75t_R%Y vss Y N_M0_d N_M1_s N_M4_d N_M5_d N_Y_8 N_Y_1 N_Y_9
+ N_Y_10 N_Y_15 N_Y_2 N_Y_13 N_Y_14 PM_NOR2xp67_ASAP7_75t_R%Y
cc_13 N_Y_8 N_A_1 0.000998278f $X=0.0935 $Y=0.054
cc_14 N_Y_1 N_A_4 0.00195897f $X=0.108 $Y=0.054
cc_15 N_Y_9 N_A_4 0.0115176f $X=0.164 $Y=0.054
cc_16 N_Y_8 N_A_3 0.0213421f $X=0.0935 $Y=0.054
cc_17 N_Y_8 N_A_4 0.0449762f $X=0.0935 $Y=0.054
cc_18 N_Y_10 N_B_4 0.0218072f $X=0.2015 $Y=0.216
cc_19 N_Y_15 N_B_1 0.000783629f $X=0.297 $Y=0.054
cc_20 N_Y_2 N_B_3 0.000798062f $X=0.216 $Y=0.216
cc_21 N_Y_10 N_B_1 0.00160011f $X=0.2015 $Y=0.216
cc_22 N_Y_1 N_B_6 0.00169503f $X=0.108 $Y=0.054
cc_23 N_Y_15 N_B_10 0.00186423f $X=0.297 $Y=0.054
cc_24 N_Y_9 N_B_3 0.0105387f $X=0.164 $Y=0.054
cc_25 N_Y_13 N_B_6 0.0039293f $X=0.1505 $Y=0.036
cc_26 N_Y_14 N_B_10 0.00407526f $X=0.286 $Y=0.198
cc_27 N_Y_10 N_B_3 0.0433225f $X=0.2015 $Y=0.216
cc_28 N_Y_2 N_5_13 0.000766661f $X=0.216 $Y=0.216
cc_29 N_Y_10 N_5_11 0.00084637f $X=0.2015 $Y=0.216
cc_30 N_Y_2 N_5_2 0.00084962f $X=0.216 $Y=0.216
cc_31 N_Y_2 N_5_3 0.00344932f $X=0.216 $Y=0.216
cc_32 N_Y_14 N_5_13 0.010667f $X=0.286 $Y=0.198
x_PM_NOR2xp67_ASAP7_75t_R%A vss A N_M0_g N_M2_g N_M3_g N_A_10 N_A_1 N_A_4 N_A_3
+ N_A_7 PM_NOR2xp67_ASAP7_75t_R%A
x_PM_NOR2xp67_ASAP7_75t_R%B vss B N_M1_g N_M4_g N_M5_g N_B_5 N_B_1 N_B_9 N_B_8
+ N_B_7 N_B_3 N_B_4 N_B_6 N_B_10 PM_NOR2xp67_ASAP7_75t_R%B
cc_33 N_B_5 N_A_10 0.000645981f $X=0.135 $Y=0.198
cc_34 N_B_1 N_A_1 0.000746942f $X=0.189 $Y=0.136
cc_35 N_B_9 N_A_10 0.000816846f $X=0.135 $Y=0.1445
cc_36 N_B_8 N_A_10 0.00088512f $X=0.135 $Y=0.1035
cc_37 N_B_7 N_A_10 0.00184906f $X=0.135 $Y=0.1265
cc_38 N_B_7 N_A_1 0.0019909f $X=0.135 $Y=0.1265
cc_39 N_B_3 N_A_4 0.00960072f $X=0.189 $Y=0.0245

* End of included file NOR2xp67_ASAP7_75t_R.pex.sp.pxi
.ends

.subckt PM_NAND3x1_ASAP7_75t_R%6 vss 16 17 32 33 36 37 10 13 1 11 12 3 2
c1 1 vss 0.00931766f $X=0.108 $Y=0.0675
c2 2 vss 0.00589813f $X=0.216 $Y=0.0675
c3 3 vss 0.00301509f $X=0.324 $Y=0.0675
c4 10 vss 0.00413453f $X=0.0935 $Y=0.0675
c5 11 vss 0.00318685f $X=0.2015 $Y=0.0675
c6 12 vss 0.00190654f $X=0.3095 $Y=0.0675
c7 13 vss 0.0124275f $X=0.0965 $Y=0.072
r1 37 35 0.0308642 $w=8.1e-08 $l=2.5e-09 $layer=N_src_drn $thickness=1e-09
+ $X=0.3413 $Y=0.0675 $X2=0.3385 $Y2=0.0675
r2 3 35 0.179012 $w=8.1e-08 $l=1.45e-08 $layer=N_src_drn $thickness=1e-09
+ $X=0.324 $Y=0.0675 $X2=0.3385 $Y2=0.0675
r3 12 3 0.179012 $w=8.1e-08 $l=1.45e-08 $layer=N_src_drn $thickness=1e-09
+ $X=0.3095 $Y=0.0675 $X2=0.324 $Y2=0.0675
r4 36 12 0.0308642 $w=8.1e-08 $l=2.5e-09 $layer=N_src_drn $thickness=1e-09
+ $X=0.3066 $Y=0.0675 $X2=0.3095 $Y2=0.0675
r5 33 31 0.0308642 $w=8.1e-08 $l=2.5e-09 $layer=N_src_drn $thickness=1e-09
+ $X=0.2333 $Y=0.0675 $X2=0.2305 $Y2=0.0675
r6 2 31 0.179012 $w=8.1e-08 $l=1.45e-08 $layer=N_src_drn $thickness=1e-09
+ $X=0.216 $Y=0.0675 $X2=0.2305 $Y2=0.0675
r7 11 2 0.179012 $w=8.1e-08 $l=1.45e-08 $layer=N_src_drn $thickness=1e-09
+ $X=0.2015 $Y=0.0675 $X2=0.216 $Y2=0.0675
r8 32 11 0.0308642 $w=8.1e-08 $l=2.5e-09 $layer=N_src_drn $thickness=1e-09
+ $X=0.1986 $Y=0.0675 $X2=0.2015 $Y2=0.0675
r9 3 28 19.3796 $a=3.24e-16 $layer=V0LISD $X=0.324 $Y=0.0675 $X2=0.324 $Y2=0.072
r10 2 22 19.3796 $a=3.24e-16 $layer=V0LISD $X=0.216 $Y=0.0675 $X2=0.216
+ $Y2=0.072
r11 27 28 3.14806 $w=1.3e-08 $l=1.35e-08 $layer=M1 $thickness=3.6e-08 $X=0.3105
+ $Y=0.072 $X2=0.324 $Y2=0.072
r12 26 27 6.8791 $w=1.3e-08 $l=2.95e-08 $layer=M1 $thickness=3.6e-08 $X=0.281
+ $Y=0.072 $X2=0.3105 $Y2=0.072
r13 25 26 6.99569 $w=1.3e-08 $l=3e-08 $layer=M1 $thickness=3.6e-08 $X=0.251
+ $Y=0.072 $X2=0.281 $Y2=0.072
r14 24 25 1.51573 $w=1.3e-08 $l=6.5e-09 $layer=M1 $thickness=3.6e-08 $X=0.2445
+ $Y=0.072 $X2=0.251 $Y2=0.072
r15 23 24 2.44849 $w=1.3e-08 $l=1.05e-08 $layer=M1 $thickness=3.6e-08 $X=0.234
+ $Y=0.072 $X2=0.2445 $Y2=0.072
r16 22 23 4.19742 $w=1.3e-08 $l=1.8e-08 $layer=M1 $thickness=3.6e-08 $X=0.216
+ $Y=0.072 $X2=0.234 $Y2=0.072
r17 21 22 2.68168 $w=1.3e-08 $l=1.15e-08 $layer=M1 $thickness=3.6e-08 $X=0.2045
+ $Y=0.072 $X2=0.216 $Y2=0.072
r18 20 21 3.61444 $w=1.3e-08 $l=1.55e-08 $layer=M1 $thickness=3.6e-08 $X=0.189
+ $Y=0.072 $X2=0.2045 $Y2=0.072
r19 19 20 9.91056 $w=1.3e-08 $l=4.25e-08 $layer=M1 $thickness=3.6e-08 $X=0.1465
+ $Y=0.072 $X2=0.189 $Y2=0.072
r20 18 19 8.97781 $w=1.3e-08 $l=3.85e-08 $layer=M1 $thickness=3.6e-08 $X=0.108
+ $Y=0.072 $X2=0.1465 $Y2=0.072
r21 13 18 2.68168 $w=1.3e-08 $l=1.15e-08 $layer=M1 $thickness=3.6e-08 $X=0.0965
+ $Y=0.072 $X2=0.108 $Y2=0.072
r22 1 18 19.3796 $a=3.24e-16 $layer=V0LISD $X=0.108 $Y=0.0675 $X2=0.108
+ $Y2=0.072
r23 17 15 0.0308642 $w=8.1e-08 $l=2.5e-09 $layer=N_src_drn $thickness=1e-09
+ $X=0.1253 $Y=0.0675 $X2=0.1225 $Y2=0.0675
r24 1 15 0.179012 $w=8.1e-08 $l=1.45e-08 $layer=N_src_drn $thickness=1e-09
+ $X=0.108 $Y=0.0675 $X2=0.1225 $Y2=0.0675
r25 10 1 0.179012 $w=8.1e-08 $l=1.45e-08 $layer=N_src_drn $thickness=1e-09
+ $X=0.0935 $Y=0.0675 $X2=0.108 $Y2=0.0675
r26 16 10 0.0308642 $w=8.1e-08 $l=2.5e-09 $layer=N_src_drn $thickness=1e-09
+ $X=0.0906 $Y=0.0675 $X2=0.0935 $Y2=0.0675
.ends

.subckt PM_NAND3x1_ASAP7_75t_R%B vss 10 11 15 24 29 1 3 5 6 4 9 8 7
c1 1 vss 0.0166727f $X=0.243 $Y=0.135
c2 3 vss 0.0484222f $X=0.243 $Y=0.0245
c3 4 vss 0.051346f $X=0.297 $Y=0.135
c4 5 vss 0.0513568f $X=0.351 $Y=0.135
c5 6 vss 0.00489684f $X=0.297 $Y=0.117
c6 7 vss 0.0055948f $X=0.297 $Y=0.189
c7 8 vss 0.00670824f $X=0.267 $Y=0.189
c8 9 vss 0.00547528f $X=0.267 $Y=0.117
c9 10 vss 0.00592928f $X=0.296 $Y=0.137
r1 7 27 4.64701 $w=1.62667e-08 $l=2.7e-08 $layer=M1 $thickness=3.6e-08 $X=0.297
+ $Y=0.189 $X2=0.297 $Y2=0.162
r2 7 8 5.34658 $w=1.45e-08 $l=3e-08 $layer=M1 $thickness=3.6e-08 $X=0.297
+ $Y=0.189 $X2=0.267 $Y2=0.189
r3 10 6 2.5483 $w=1.79e-08 $l=1.8e-08 $layer=M1 $thickness=3.6e-08 $X=0.296
+ $Y=0.137 $X2=0.297 $Y2=0.117
r4 6 9 5.34658 $w=1.45e-08 $l=3e-08 $layer=M1 $thickness=3.6e-08 $X=0.297
+ $Y=0.117 $X2=0.267 $Y2=0.117
r5 29 30 16.6668 $w=2.1e-08 $l=4.9e-08 $layer=Gate_1 $thickness=5.6e-08
+ $X=0.351 $Y=0.0675 $X2=0.351 $Y2=0.1165
r6 5 21 6.74717 $w=2e-08 $layer=Gate_1 $thickness=5.2e-08 $X=0.351 $Y=0.135
+ $X2=0.351 $Y2=0.135
r7 5 30 6.46262 $w=2.04595e-08 $l=1.85e-08 $layer=Gate_1 $thickness=5.6e-08
+ $X=0.351 $Y=0.135 $X2=0.351 $Y2=0.1165
r8 10 27 6.29612 $w=1.3e-08 $l=2.7e-08 $layer=M1 $thickness=3.6e-08 $X=0.296
+ $Y=0.137 $X2=0.297 $Y2=0.162
r9 10 19 19.3796 $a=3.24e-16 $layer=V0LIG $X=0.296 $Y=0.137 $X2=0.297 $Y2=0.135
r10 24 25 16.6668 $w=2.1e-08 $l=4.9e-08 $layer=Gate_1 $thickness=5.6e-08
+ $X=0.297 $Y=0.0675 $X2=0.297 $Y2=0.1165
r11 4 19 6.74717 $w=2e-08 $layer=Gate_1 $thickness=5.2e-08 $X=0.297 $Y=0.135
+ $X2=0.297 $Y2=0.135
r12 4 25 6.46262 $w=2.04595e-08 $l=1.85e-08 $layer=Gate_1 $thickness=5.6e-08
+ $X=0.297 $Y=0.135 $X2=0.297 $Y2=0.1165
r13 20 21 20.114 $w=1.57815e-08 $l=2.7e-08 $layer=LIG $thickness=4.8e-08
+ $X=0.324 $Y=0.135 $X2=0.351 $Y2=0.135
r14 19 20 20.114 $w=1.57815e-08 $l=2.7e-08 $layer=LIG $thickness=4.8e-08
+ $X=0.297 $Y=0.135 $X2=0.324 $Y2=0.135
r15 18 19 20.114 $w=1.57815e-08 $l=2.7e-08 $layer=LIG $thickness=4.8e-08
+ $X=0.27 $Y=0.135 $X2=0.297 $Y2=0.135
r16 1 13 6.74717 $w=2e-08 $layer=Gate_1 $thickness=5.2e-08 $X=0.243 $Y=0.135
+ $X2=0.243 $Y2=0.135
r17 1 18 20.114 $w=1.57815e-08 $l=2.7e-08 $layer=LIG $thickness=4.8e-08
+ $X=0.243 $Y=0.135 $X2=0.27 $Y2=0.135
r18 15 14 16.6668 $w=2.1e-08 $l=4.9e-08 $layer=Gate_1 $thickness=5.6e-08
+ $X=0.243 $Y=0.2025 $X2=0.243 $Y2=0.1535
r19 13 14 6.46262 $w=2.04595e-08 $l=1.85e-08 $layer=Gate_1 $thickness=5.6e-08
+ $X=0.243 $Y=0.135 $X2=0.243 $Y2=0.1535
r20 12 13 6.46262 $w=2.04595e-08 $l=1.85e-08 $layer=Gate_1 $thickness=5.6e-08
+ $X=0.243 $Y=0.1165 $X2=0.243 $Y2=0.135
r21 11 12 16.6668 $w=2.1e-08 $l=4.9e-08 $layer=Gate_1 $thickness=5.6e-08
+ $X=0.243 $Y=0.0675 $X2=0.243 $Y2=0.1165
r22 11 3 14.6259 $w=2.1e-08 $l=4.3e-08 $layer=Gate_1 $thickness=5.6e-08
+ $X=0.243 $Y=0.0675 $X2=0.243 $Y2=0.0245
.ends

.subckt PM_NAND3x1_ASAP7_75t_R%7 vss 16 17 29 30 33 34 10 1 11 12 2 3 13
c1 1 vss 0.00404632f $X=0.27 $Y=0.0675
c2 2 vss 0.0038646f $X=0.378 $Y=0.0675
c3 3 vss 0.00397189f $X=0.486 $Y=0.0675
c4 10 vss 0.00184242f $X=0.2555 $Y=0.0675
c5 11 vss 0.00186334f $X=0.3635 $Y=0.0675
c6 12 vss 0.00185766f $X=0.4715 $Y=0.0675
c7 13 vss 0.0186102f $X=0.2585 $Y=0.036
r1 34 32 0.0308642 $w=8.1e-08 $l=2.5e-09 $layer=N_src_drn $thickness=1e-09
+ $X=0.5033 $Y=0.0675 $X2=0.5005 $Y2=0.0675
r2 3 32 0.179012 $w=8.1e-08 $l=1.45e-08 $layer=N_src_drn $thickness=1e-09
+ $X=0.486 $Y=0.0675 $X2=0.5005 $Y2=0.0675
r3 12 3 0.179012 $w=8.1e-08 $l=1.45e-08 $layer=N_src_drn $thickness=1e-09
+ $X=0.4715 $Y=0.0675 $X2=0.486 $Y2=0.0675
r4 33 12 0.0308642 $w=8.1e-08 $l=2.5e-09 $layer=N_src_drn $thickness=1e-09
+ $X=0.4686 $Y=0.0675 $X2=0.4715 $Y2=0.0675
r5 30 28 0.0308642 $w=8.1e-08 $l=2.5e-09 $layer=N_src_drn $thickness=1e-09
+ $X=0.3953 $Y=0.0675 $X2=0.3925 $Y2=0.0675
r6 2 28 0.179012 $w=8.1e-08 $l=1.45e-08 $layer=N_src_drn $thickness=1e-09
+ $X=0.378 $Y=0.0675 $X2=0.3925 $Y2=0.0675
r7 11 2 0.179012 $w=8.1e-08 $l=1.45e-08 $layer=N_src_drn $thickness=1e-09
+ $X=0.3635 $Y=0.0675 $X2=0.378 $Y2=0.0675
r8 29 11 0.0308642 $w=8.1e-08 $l=2.5e-09 $layer=N_src_drn $thickness=1e-09
+ $X=0.3606 $Y=0.0675 $X2=0.3635 $Y2=0.0675
r9 3 25 19.3796 $a=3.24e-16 $layer=V0LISD $X=0.486 $Y=0.0675 $X2=0.486 $Y2=0.036
r10 2 21 19.3796 $a=3.24e-16 $layer=V0LISD $X=0.378 $Y=0.0675 $X2=0.378
+ $Y2=0.036
r11 24 25 8.97781 $w=1.3e-08 $l=3.85e-08 $layer=M1 $thickness=3.6e-08 $X=0.4475
+ $Y=0.036 $X2=0.486 $Y2=0.036
r12 23 24 8.97781 $w=1.3e-08 $l=3.85e-08 $layer=M1 $thickness=3.6e-08 $X=0.409
+ $Y=0.036 $X2=0.4475 $Y2=0.036
r13 22 23 3.61444 $w=1.3e-08 $l=1.55e-08 $layer=M1 $thickness=3.6e-08 $X=0.3935
+ $Y=0.036 $X2=0.409 $Y2=0.036
r14 21 22 3.61444 $w=1.3e-08 $l=1.55e-08 $layer=M1 $thickness=3.6e-08 $X=0.378
+ $Y=0.036 $X2=0.3935 $Y2=0.036
r15 20 21 5.71315 $w=1.3e-08 $l=2.45e-08 $layer=M1 $thickness=3.6e-08 $X=0.3535
+ $Y=0.036 $X2=0.378 $Y2=0.036
r16 19 20 10.4935 $w=1.3e-08 $l=4.5e-08 $layer=M1 $thickness=3.6e-08 $X=0.3085
+ $Y=0.036 $X2=0.3535 $Y2=0.036
r17 18 19 8.97781 $w=1.3e-08 $l=3.85e-08 $layer=M1 $thickness=3.6e-08 $X=0.27
+ $Y=0.036 $X2=0.3085 $Y2=0.036
r18 13 18 2.68168 $w=1.3e-08 $l=1.15e-08 $layer=M1 $thickness=3.6e-08 $X=0.2585
+ $Y=0.036 $X2=0.27 $Y2=0.036
r19 1 18 19.3796 $a=3.24e-16 $layer=V0LISD $X=0.27 $Y=0.0675 $X2=0.27 $Y2=0.036
r20 17 15 0.0308642 $w=8.1e-08 $l=2.5e-09 $layer=N_src_drn $thickness=1e-09
+ $X=0.2873 $Y=0.0675 $X2=0.2845 $Y2=0.0675
r21 1 15 0.179012 $w=8.1e-08 $l=1.45e-08 $layer=N_src_drn $thickness=1e-09
+ $X=0.27 $Y=0.0675 $X2=0.2845 $Y2=0.0675
r22 10 1 0.179012 $w=8.1e-08 $l=1.45e-08 $layer=N_src_drn $thickness=1e-09
+ $X=0.2555 $Y=0.0675 $X2=0.27 $Y2=0.0675
r23 16 10 0.0308642 $w=8.1e-08 $l=2.5e-09 $layer=N_src_drn $thickness=1e-09
+ $X=0.2526 $Y=0.0675 $X2=0.2555 $Y2=0.0675
.ends

.subckt PM_NAND3x1_ASAP7_75t_R%Y vss 33 24 25 37 49 52 53 15 1 19 13 4 3 21 16
+ 20 2 14
c1 1 vss 0.00971685f $X=0.216 $Y=0.2025
c2 2 vss 0.00288332f $X=0.432 $Y=0.0675
c3 3 vss 0.00667858f $X=0.432 $Y=0.2025
c4 4 vss 0.00505737f $X=0.54 $Y=0.0675
c5 13 vss 0.0021709f $X=0.4175 $Y=0.0675
c6 14 vss 0.0356946f $X=0.5255 $Y=0.0675
c7 15 vss 0.00453974f $X=0.2015 $Y=0.2025
c8 16 vss 0.0033898f $X=0.4175 $Y=0.2025
c9 17 vss 0.00136755f $X=0.567 $Y=0.072
c10 18 vss 0.00279815f $X=0.567 $Y=0.234
c11 19 vss 0.0323745f $X=0.513 $Y=0.234
c12 20 vss 0.00233611f $X=0.4205 $Y=0.072
c13 21 vss 0.00415098f $X=0.567 $Y=0.0945
r1 52 51 0.0308642 $w=8.1e-08 $l=2.5e-09 $layer=P_src_drn $thickness=1e-09
+ $X=0.2333 $Y=0.2025 $X2=0.2305 $Y2=0.2025
r2 1 51 0.179012 $w=8.1e-08 $l=1.45e-08 $layer=P_src_drn $thickness=1e-09
+ $X=0.216 $Y=0.2025 $X2=0.2305 $Y2=0.2025
r3 15 1 0.179012 $w=8.1e-08 $l=1.45e-08 $layer=P_src_drn $thickness=1e-09
+ $X=0.2015 $Y=0.2025 $X2=0.216 $Y2=0.2025
r4 53 15 0.0308642 $w=8.1e-08 $l=2.5e-09 $layer=P_src_drn $thickness=1e-09
+ $X=0.1986 $Y=0.2025 $X2=0.2015 $Y2=0.2025
r5 16 3 0.154321 $w=8.1e-08 $l=1.25e-08 $layer=P_src_drn $thickness=1e-09
+ $X=0.4175 $Y=0.2025 $X2=0.432 $Y2=0.2025
r6 49 16 0.0308642 $w=8.1e-08 $l=2.5e-09 $layer=P_src_drn $thickness=1e-09
+ $X=0.4146 $Y=0.2025 $X2=0.4175 $Y2=0.2025
r7 1 46 19.3796 $a=3.24e-16 $layer=V0LISD $X=0.216 $Y=0.2025 $X2=0.216 $Y2=0.234
r8 3 39 19.3796 $a=3.24e-16 $layer=V0LISD $X=0.432 $Y=0.2025 $X2=0.432 $Y2=0.234
r9 46 47 4.19742 $w=1.3e-08 $l=1.8e-08 $layer=M1 $thickness=3.6e-08 $X=0.216
+ $Y=0.234 $X2=0.234 $Y2=0.234
r10 44 47 9.44419 $w=1.3e-08 $l=4.05e-08 $layer=M1 $thickness=3.6e-08 $X=0.2745
+ $Y=0.234 $X2=0.234 $Y2=0.234
r11 43 44 11.0765 $w=1.3e-08 $l=4.75e-08 $layer=M1 $thickness=3.6e-08 $X=0.322
+ $Y=0.234 $X2=0.2745 $Y2=0.234
r12 42 43 10.9599 $w=1.3e-08 $l=4.7e-08 $layer=M1 $thickness=3.6e-08 $X=0.369
+ $Y=0.234 $X2=0.322 $Y2=0.234
r13 41 42 7.46207 $w=1.3e-08 $l=3.2e-08 $layer=M1 $thickness=3.6e-08 $X=0.401
+ $Y=0.234 $X2=0.369 $Y2=0.234
r14 39 40 5.24677 $w=1.3e-08 $l=2.25e-08 $layer=M1 $thickness=3.6e-08 $X=0.432
+ $Y=0.234 $X2=0.4545 $Y2=0.234
r15 38 39 4.5472 $w=1.3e-08 $l=1.95e-08 $layer=M1 $thickness=3.6e-08 $X=0.4125
+ $Y=0.234 $X2=0.432 $Y2=0.234
r16 38 41 2.68168 $w=1.3e-08 $l=1.15e-08 $layer=M1 $thickness=3.6e-08 $X=0.4125
+ $Y=0.234 $X2=0.401 $Y2=0.234
r17 19 40 13.6416 $w=1.3e-08 $l=5.85e-08 $layer=M1 $thickness=3.6e-08 $X=0.513
+ $Y=0.234 $X2=0.4545 $Y2=0.234
r18 18 35 3.59766 $w=1.692e-08 $l=2.25e-08 $layer=M1 $thickness=3.6e-08
+ $X=0.567 $Y=0.234 $X2=0.567 $Y2=0.2115
r19 18 19 10.9431 $w=1.38333e-08 $l=5.4e-08 $layer=M1 $thickness=3.6e-08
+ $X=0.567 $Y=0.234 $X2=0.513 $Y2=0.234
r20 14 4 0.154321 $w=8.1e-08 $l=1.25e-08 $layer=N_src_drn $thickness=1e-09
+ $X=0.5255 $Y=0.0675 $X2=0.54 $Y2=0.0675
r21 37 14 0.0308642 $w=8.1e-08 $l=2.5e-09 $layer=N_src_drn $thickness=1e-09
+ $X=0.5226 $Y=0.0675 $X2=0.5255 $Y2=0.0675
r22 34 35 9.50248 $w=1.3e-08 $l=4.08e-08 $layer=M1 $thickness=3.6e-08 $X=0.567
+ $Y=0.1707 $X2=0.567 $Y2=0.2115
r23 33 34 6.47102 $w=1.3e-08 $l=2.77e-08 $layer=M1 $thickness=3.6e-08 $X=0.566
+ $Y=0.143 $X2=0.567 $Y2=0.1707
r24 33 32 4.13912 $w=1.3e-08 $l=1.78e-08 $layer=M1 $thickness=3.6e-08 $X=0.566
+ $Y=0.143 $X2=0.567 $Y2=0.1252
r25 21 32 7.17059 $w=1.3e-08 $l=3.07e-08 $layer=M1 $thickness=3.6e-08 $X=0.567
+ $Y=0.0945 $X2=0.567 $Y2=0.1252
r26 4 30 19.3796 $a=3.24e-16 $layer=V0LISD $X=0.54 $Y=0.0675 $X2=0.54 $Y2=0.072
r27 17 31 1.49895 $w=1.63333e-08 $l=1.35e-08 $layer=M1 $thickness=3.6e-08
+ $X=0.567 $Y=0.072 $X2=0.5535 $Y2=0.072
r28 17 21 3.59766 $w=1.692e-08 $l=2.25e-08 $layer=M1 $thickness=3.6e-08
+ $X=0.567 $Y=0.072 $X2=0.567 $Y2=0.0945
r29 30 31 3.14806 $w=1.3e-08 $l=1.35e-08 $layer=M1 $thickness=3.6e-08 $X=0.54
+ $Y=0.072 $X2=0.5535 $Y2=0.072
r30 29 30 5.71315 $w=1.3e-08 $l=2.45e-08 $layer=M1 $thickness=3.6e-08 $X=0.5155
+ $Y=0.072 $X2=0.54 $Y2=0.072
r31 28 29 7.34548 $w=1.3e-08 $l=3.15e-08 $layer=M1 $thickness=3.6e-08 $X=0.484
+ $Y=0.072 $X2=0.5155 $Y2=0.072
r32 27 28 6.8791 $w=1.3e-08 $l=2.95e-08 $layer=M1 $thickness=3.6e-08 $X=0.4545
+ $Y=0.072 $X2=0.484 $Y2=0.072
r33 26 27 5.24677 $w=1.3e-08 $l=2.25e-08 $layer=M1 $thickness=3.6e-08 $X=0.432
+ $Y=0.072 $X2=0.4545 $Y2=0.072
r34 20 26 2.68168 $w=1.3e-08 $l=1.15e-08 $layer=M1 $thickness=3.6e-08 $X=0.4205
+ $Y=0.072 $X2=0.432 $Y2=0.072
r35 2 26 19.3796 $a=3.24e-16 $layer=V0LISD $X=0.432 $Y=0.0675 $X2=0.432
+ $Y2=0.072
r36 25 23 0.0308642 $w=8.1e-08 $l=2.5e-09 $layer=N_src_drn $thickness=1e-09
+ $X=0.4493 $Y=0.0675 $X2=0.4465 $Y2=0.0675
r37 2 23 0.179012 $w=8.1e-08 $l=1.45e-08 $layer=N_src_drn $thickness=1e-09
+ $X=0.432 $Y=0.0675 $X2=0.4465 $Y2=0.0675
r38 13 2 0.179012 $w=8.1e-08 $l=1.45e-08 $layer=N_src_drn $thickness=1e-09
+ $X=0.4175 $Y=0.0675 $X2=0.432 $Y2=0.0675
r39 24 13 0.0308642 $w=8.1e-08 $l=2.5e-09 $layer=N_src_drn $thickness=1e-09
+ $X=0.4146 $Y=0.0675 $X2=0.4175 $Y2=0.0675
.ends

.subckt PM_NAND3x1_ASAP7_75t_R%C vss 22 7 27 31 34 1 5 6 4 3
c1 1 vss 0.0243842f $X=0.075 $Y=0.135
c2 3 vss 0.0612467f $X=0.081 $Y=0.0245
c3 4 vss 0.0900899f $X=0.135 $Y=0.135
c4 5 vss 0.0864017f $X=0.189 $Y=0.135
c5 6 vss 0.011068f $X=0.07 $Y=0.117
r1 34 33 16.6668 $w=2.1e-08 $l=4.9e-08 $layer=Gate_1 $thickness=5.6e-08
+ $X=0.189 $Y=0.2025 $X2=0.189 $Y2=0.1535
r2 31 32 16.6668 $w=2.1e-08 $l=4.9e-08 $layer=Gate_1 $thickness=5.6e-08
+ $X=0.189 $Y=0.0675 $X2=0.189 $Y2=0.1165
r3 5 19 6.74717 $w=2e-08 $layer=Gate_1 $thickness=5.2e-08 $X=0.189 $Y=0.135
+ $X2=0.189 $Y2=0.135
r4 5 32 6.46262 $w=2.04595e-08 $l=1.85e-08 $layer=Gate_1 $thickness=5.6e-08
+ $X=0.189 $Y=0.135 $X2=0.189 $Y2=0.1165
r5 5 33 6.46262 $w=2.04595e-08 $l=1.85e-08 $layer=Gate_1 $thickness=5.6e-08
+ $X=0.189 $Y=0.135 $X2=0.189 $Y2=0.1535
r6 27 28 16.6668 $w=2.1e-08 $l=4.9e-08 $layer=Gate_1 $thickness=5.6e-08
+ $X=0.135 $Y=0.0675 $X2=0.135 $Y2=0.1165
r7 4 17 6.74717 $w=2e-08 $layer=Gate_1 $thickness=5.2e-08 $X=0.135 $Y=0.135
+ $X2=0.135 $Y2=0.135
r8 4 28 6.46262 $w=2.04595e-08 $l=1.85e-08 $layer=Gate_1 $thickness=5.6e-08
+ $X=0.135 $Y=0.135 $X2=0.135 $Y2=0.1165
r9 22 6 4.19742 $w=1.3e-08 $l=1.8e-08 $layer=M1 $thickness=3.6e-08 $X=0.069
+ $Y=0.137 $X2=0.07 $Y2=0.117
r10 18 19 20.114 $w=1.57815e-08 $l=2.7e-08 $layer=LIG $thickness=4.8e-08
+ $X=0.162 $Y=0.135 $X2=0.189 $Y2=0.135
r11 17 18 20.114 $w=1.57815e-08 $l=2.7e-08 $layer=LIG $thickness=4.8e-08
+ $X=0.135 $Y=0.135 $X2=0.162 $Y2=0.135
r12 16 17 20.114 $w=1.57815e-08 $l=2.7e-08 $layer=LIG $thickness=4.8e-08
+ $X=0.108 $Y=0.135 $X2=0.135 $Y2=0.135
r13 22 15 19.3796 $a=3.24e-16 $layer=V0LIG $X=0.069 $Y=0.137 $X2=0.066 $Y2=0.135
r14 13 16 18.8437 $w=1.50478e-08 $l=2.3e-08 $layer=LIG $thickness=4.8e-08
+ $X=0.085 $Y=0.135 $X2=0.108 $Y2=0.135
r15 1 13 3.17572 $w=2e-08 $l=1e-08 $layer=LIG $thickness=4.8e-08 $X=0.075
+ $Y=0.135 $X2=0.085 $Y2=0.135
r16 1 15 6.25213 $w=1.62778e-08 $l=9e-09 $layer=LIG $thickness=4.8e-08 $X=0.075
+ $Y=0.135 $X2=0.066 $Y2=0.135
r17 10 13 5.47688 $w=2e-08 $l=4e-09 $layer=Gate_1 $thickness=5.3e-08 $X=0.081
+ $Y=0.135 $X2=0.085 $Y2=0.135
r18 9 10 5.61228 $w=2.0375e-08 $l=1.6e-08 $layer=Gate_1 $thickness=5.6e-08
+ $X=0.081 $Y=0.119 $X2=0.081 $Y2=0.135
r19 8 9 2.89117 $w=2.1e-08 $l=8.5e-09 $layer=Gate_1 $thickness=5.6e-08 $X=0.081
+ $Y=0.1105 $X2=0.081 $Y2=0.119
r20 7 8 14.6259 $w=2.1e-08 $l=4.3e-08 $layer=Gate_1 $thickness=5.6e-08 $X=0.081
+ $Y=0.0675 $X2=0.081 $Y2=0.1105
r21 7 3 14.6259 $w=2.1e-08 $l=4.3e-08 $layer=Gate_1 $thickness=5.6e-08 $X=0.081
+ $Y=0.0675 $X2=0.081 $Y2=0.0245
.ends

.subckt PM_NAND3x1_ASAP7_75t_R%A vss 10 11 15 24 30 3 1 8 4 5 7 6 9
c1 1 vss 0.0120483f $X=0.405 $Y=0.135
c2 3 vss 0.0486931f $X=0.405 $Y=0.0245
c3 4 vss 0.0119777f $X=0.459 $Y=0.135
c4 5 vss 0.0223945f $X=0.513 $Y=0.135
c5 6 vss 0.0049637f $X=0.459 $Y=0.117
c6 7 vss 0.00537823f $X=0.459 $Y=0.189
c7 8 vss 0.00600486f $X=0.434 $Y=0.117
c8 9 vss 0.0060608f $X=0.426 $Y=0.189
c9 10 vss 0.00517261f $X=0.459 $Y=0.137
r1 7 27 4.64701 $w=1.62667e-08 $l=2.7e-08 $layer=M1 $thickness=3.6e-08 $X=0.459
+ $Y=0.189 $X2=0.459 $Y2=0.162
r2 7 9 6.04615 $w=1.43636e-08 $l=3.3e-08 $layer=M1 $thickness=3.6e-08 $X=0.459
+ $Y=0.189 $X2=0.426 $Y2=0.189
r3 10 6 2.5483 $w=1.79e-08 $l=1.8e-08 $layer=M1 $thickness=3.6e-08 $X=0.459
+ $Y=0.137 $X2=0.459 $Y2=0.117
r4 6 8 4.18063 $w=1.48e-08 $l=2.5e-08 $layer=M1 $thickness=3.6e-08 $X=0.459
+ $Y=0.117 $X2=0.434 $Y2=0.117
r5 30 31 14.6259 $w=2.1e-08 $l=4.3e-08 $layer=Gate_1 $thickness=5.6e-08
+ $X=0.513 $Y=0.0675 $X2=0.513 $Y2=0.1105
r6 28 31 2.89117 $w=2.1e-08 $l=8.5e-09 $layer=Gate_1 $thickness=5.6e-08
+ $X=0.513 $Y=0.119 $X2=0.513 $Y2=0.1105
r7 5 21 6.74717 $w=2e-08 $layer=Gate_1 $thickness=5.2e-08 $X=0.513 $Y=0.135
+ $X2=0.513 $Y2=0.135
r8 5 28 5.61228 $w=2.0375e-08 $l=1.6e-08 $layer=Gate_1 $thickness=5.6e-08
+ $X=0.513 $Y=0.135 $X2=0.513 $Y2=0.119
r9 10 27 6.29612 $w=1.3e-08 $l=2.7e-08 $layer=M1 $thickness=3.6e-08 $X=0.459
+ $Y=0.137 $X2=0.459 $Y2=0.162
r10 10 19 19.3796 $a=3.24e-16 $layer=V0LIG $X=0.459 $Y=0.137 $X2=0.459 $Y2=0.135
r11 24 25 16.6668 $w=2.1e-08 $l=4.9e-08 $layer=Gate_1 $thickness=5.6e-08
+ $X=0.459 $Y=0.0675 $X2=0.459 $Y2=0.1165
r12 4 19 6.74717 $w=2e-08 $layer=Gate_1 $thickness=5.2e-08 $X=0.459 $Y=0.135
+ $X2=0.459 $Y2=0.135
r13 4 25 6.46262 $w=2.04595e-08 $l=1.85e-08 $layer=Gate_1 $thickness=5.6e-08
+ $X=0.459 $Y=0.135 $X2=0.459 $Y2=0.1165
r14 20 21 20.114 $w=1.57815e-08 $l=2.7e-08 $layer=LIG $thickness=4.8e-08
+ $X=0.486 $Y=0.135 $X2=0.513 $Y2=0.135
r15 19 20 20.114 $w=1.57815e-08 $l=2.7e-08 $layer=LIG $thickness=4.8e-08
+ $X=0.459 $Y=0.135 $X2=0.486 $Y2=0.135
r16 18 19 20.114 $w=1.57815e-08 $l=2.7e-08 $layer=LIG $thickness=4.8e-08
+ $X=0.432 $Y=0.135 $X2=0.459 $Y2=0.135
r17 1 13 6.74717 $w=2e-08 $layer=Gate_1 $thickness=5.2e-08 $X=0.405 $Y=0.135
+ $X2=0.405 $Y2=0.135
r18 1 18 20.114 $w=1.57815e-08 $l=2.7e-08 $layer=LIG $thickness=4.8e-08
+ $X=0.405 $Y=0.135 $X2=0.432 $Y2=0.135
r19 15 14 16.6668 $w=2.1e-08 $l=4.9e-08 $layer=Gate_1 $thickness=5.6e-08
+ $X=0.405 $Y=0.2025 $X2=0.405 $Y2=0.1535
r20 13 14 6.46262 $w=2.04595e-08 $l=1.85e-08 $layer=Gate_1 $thickness=5.6e-08
+ $X=0.405 $Y=0.135 $X2=0.405 $Y2=0.1535
r21 12 13 6.46262 $w=2.04595e-08 $l=1.85e-08 $layer=Gate_1 $thickness=5.6e-08
+ $X=0.405 $Y=0.1165 $X2=0.405 $Y2=0.135
r22 11 12 16.6668 $w=2.1e-08 $l=4.9e-08 $layer=Gate_1 $thickness=5.6e-08
+ $X=0.405 $Y=0.0675 $X2=0.405 $Y2=0.1165
r23 11 3 14.6259 $w=2.1e-08 $l=4.3e-08 $layer=Gate_1 $thickness=5.6e-08
+ $X=0.405 $Y=0.0675 $X2=0.405 $Y2=0.0245
.ends

* End of included file NAND3x1_ASAP7_75t_R.pex.sp.pex

*
.subckt NAND3x1_ASAP7_75t_CUSTOM_4_25_0_7 VSS VDD C B A Y
*
* VSS VSS
* VDD VDD
* C C
* B B
* A A
* Y Y
*
*

M0 N_M0_d N_M0_g VSS VSS nmos_rvt L=2e-08 W=8.1e-08 nfin=3 $X=0.071 $Y=0.027
M1 N_M1_d N_M1_g VSS VSS nmos_rvt L=2e-08 W=8.1e-08 nfin=3 $X=0.125 $Y=0.027
M2 N_M2_d N_M2_g VSS VSS nmos_rvt L=2e-08 W=8.1e-08 nfin=3 $X=0.179 $Y=0.027
M3 N_M3_d N_M3_g N_M3_s VSS nmos_rvt L=2e-08 W=8.1e-08 nfin=3 $X=0.233 $Y=0.027
M4 N_M4_d N_M4_g N_M4_s VSS nmos_rvt L=2e-08 W=8.1e-08 nfin=3 $X=0.287 $Y=0.027
M5 N_M5_d N_M5_g N_M5_s VSS nmos_rvt L=2e-08 W=8.1e-08 nfin=3 $X=0.341 $Y=0.027
M6 N_M6_d N_M6_g N_M6_s VSS nmos_rvt L=2e-08 W=8.1e-08 nfin=3 $X=0.395 $Y=0.027
M7 N_M7_d N_M7_g N_M7_s VSS nmos_rvt L=2e-08 W=8.1e-08 nfin=3 $X=0.449 $Y=0.027
M8 N_M8_d N_M8_g N_M8_s VSS nmos_rvt L=2e-08 W=8.1e-08 nfin=3 $X=0.503 $Y=0.027
M9 N_M9_d N_M9_g VDD VDD pmos_rvt L=2e-08 W=8.1e-08 nfin=3 $X=0.179 $Y=0.162
M10 VDD N_M10_g N_M10_s VDD pmos_rvt L=2e-08 W=8.1e-08 nfin=3 $X=0.233 $Y=0.162
M11 N_M11_d N_M11_g VDD VDD pmos_rvt L=2e-08 W=8.1e-08 nfin=3 $X=0.395 $Y=0.162

* .include "NAND3x1_ASAP7_75t_R.pex.sp.pxi"

* Start of included file NAND3x1_ASAP7_75t_R.pex.sp.pxi
x_PM_NAND3x1_ASAP7_75t_R%6 vss N_M0_d N_M1_d N_M2_d N_M3_s N_M4_s N_M5_s N_6_10
+ N_6_13 N_6_1 N_6_11 N_6_12 N_6_3 N_6_2 PM_NAND3x1_ASAP7_75t_R%6
cc_1 N_6_10 N_C_6 0.000898357f $X=0.0935 $Y=0.0675
cc_2 N_6_13 N_C_1 0.00115942f $X=0.0965 $Y=0.072
cc_3 N_6_1 N_C_4 0.00155643f $X=0.108 $Y=0.0675
cc_4 N_6_10 N_C_1 0.00316688f $X=0.0935 $Y=0.0675
cc_5 N_6_11 N_C_5 0.0320045f $X=0.2015 $Y=0.0675
cc_6 N_6_10 N_C_4 0.0180809f $X=0.0935 $Y=0.0675
cc_7 N_6_10 N_C_3 0.0482441f $X=0.0935 $Y=0.0675
cc_8 N_6_12 N_B_6 0.00127443f $X=0.3095 $Y=0.0675
cc_9 N_6_12 N_B_3 0.00116002f $X=0.3095 $Y=0.0675
cc_10 N_6_3 N_B_4 0.00148018f $X=0.324 $Y=0.0675
cc_11 N_6_12 N_B_1 0.00278417f $X=0.3095 $Y=0.0675
cc_12 N_6_13 N_B_9 0.00381973f $X=0.0965 $Y=0.072
cc_13 N_6_11 N_B_3 0.032151f $X=0.2015 $Y=0.0675
cc_14 N_6_12 N_B_5 0.0354922f $X=0.3095 $Y=0.0675
cc_15 N_6_12 N_B_4 0.0295701f $X=0.3095 $Y=0.0675
x_PM_NAND3x1_ASAP7_75t_R%B vss B N_M3_g N_M10_g N_M4_g N_M5_g N_B_1 N_B_3 N_B_5
+ N_B_6 N_B_4 N_B_9 N_B_8 N_B_7 PM_NAND3x1_ASAP7_75t_R%B
cc_16 N_B_1 N_C_1 0.00156619f $X=0.243 $Y=0.135
cc_17 N_B_3 N_C_5 0.00396325f $X=0.243 $Y=0.0245
x_PM_NAND3x1_ASAP7_75t_R%7 vss N_M3_d N_M4_d N_M5_d N_M6_s N_M7_s N_M8_s N_7_10
+ N_7_1 N_7_11 N_7_12 N_7_2 N_7_3 N_7_13 PM_NAND3x1_ASAP7_75t_R%7
cc_18 N_7_10 N_B_9 0.000358847f $X=0.2555 $Y=0.0675
cc_19 N_7_10 N_B_5 0.00107302f $X=0.2555 $Y=0.0675
cc_20 N_7_10 N_B_3 0.036504f $X=0.2555 $Y=0.0675
cc_21 N_7_1 N_B_3 0.00164387f $X=0.27 $Y=0.0675
cc_22 N_7_10 N_B_1 0.002737f $X=0.2555 $Y=0.0675
cc_23 N_7_11 N_B_5 0.031683f $X=0.3635 $Y=0.0675
cc_24 N_7_10 N_B_4 0.0283967f $X=0.2555 $Y=0.0675
cc_25 N_7_12 N_A_8 0.000460146f $X=0.4715 $Y=0.0675
cc_26 N_7_12 N_A_4 0.0188769f $X=0.4715 $Y=0.0675
cc_27 N_7_2 N_A_3 0.00086278f $X=0.378 $Y=0.0675
cc_28 N_7_3 N_A_4 0.00157625f $X=0.486 $Y=0.0675
cc_29 N_7_12 N_A_1 0.00271125f $X=0.4715 $Y=0.0675
cc_30 N_7_11 N_A_3 0.0321236f $X=0.3635 $Y=0.0675
cc_31 N_7_12 N_A_5 0.0468338f $X=0.4715 $Y=0.0675
cc_32 N_7_10 N_6_13 0.00106161f $X=0.2555 $Y=0.0675
cc_33 N_7_10 N_6_11 0.00107258f $X=0.2555 $Y=0.0675
cc_34 N_7_2 N_6_3 0.00125014f $X=0.378 $Y=0.0675
cc_35 N_7_1 N_6_3 0.00250908f $X=0.27 $Y=0.0675
cc_36 N_7_1 N_6_2 0.00385904f $X=0.27 $Y=0.0675
cc_37 N_7_13 N_6_13 0.0112008f $X=0.2585 $Y=0.036
x_PM_NAND3x1_ASAP7_75t_R%Y vss Y N_M6_d N_M7_d N_M8_d N_M11_d N_M10_s N_M9_d
+ N_Y_15 N_Y_1 N_Y_19 N_Y_13 N_Y_4 N_Y_3 N_Y_21 N_Y_16 N_Y_20 N_Y_2 N_Y_14
+ PM_NAND3x1_ASAP7_75t_R%Y
cc_38 N_Y_15 N_C_1 0.000917071f $X=0.2015 $Y=0.2025
cc_39 N_Y_15 N_C_5 0.0343159f $X=0.2015 $Y=0.2025
cc_40 N_Y_15 N_B_1 0.000826143f $X=0.2015 $Y=0.2025
cc_41 N_Y_1 N_B_3 0.00108351f $X=0.216 $Y=0.2025
cc_42 N_Y_19 N_B_8 0.00171889f $X=0.513 $Y=0.234
cc_43 N_Y_19 N_B_7 0.00356601f $X=0.513 $Y=0.234
cc_44 N_Y_15 N_B_3 0.0344649f $X=0.2015 $Y=0.2025
cc_45 N_Y_13 N_A_1 0.000598632f $X=0.4175 $Y=0.0675
cc_46 N_Y_4 N_A_5 0.000760714f $X=0.54 $Y=0.0675
cc_47 N_Y_3 A 0.000912641f $X=0.432 $Y=0.2025
cc_48 N_Y_21 N_A_1 0.00103874f $X=0.567 $Y=0.0945
cc_49 N_Y_16 N_A_3 0.0487566f $X=0.4175 $Y=0.2025
cc_50 N_Y_19 N_A_7 0.00124424f $X=0.513 $Y=0.234
cc_51 N_Y_20 N_A_8 0.00150057f $X=0.4205 $Y=0.072
cc_52 N_Y_2 N_A_4 0.00169028f $X=0.432 $Y=0.0675
cc_53 N_Y_3 N_A_3 0.00289184f $X=0.432 $Y=0.2025
cc_54 N_Y_20 N_A_6 0.00308335f $X=0.4205 $Y=0.072
cc_55 N_Y_19 N_A_9 0.00503213f $X=0.513 $Y=0.234
cc_56 N_Y_16 N_A_1 0.00601839f $X=0.4175 $Y=0.2025
cc_57 N_Y_14 N_A_5 0.0339324f $X=0.5255 $Y=0.0675
cc_58 N_Y_13 N_A_3 0.0183783f $X=0.4175 $Y=0.0675
cc_59 N_Y_16 N_A_4 0.0207503f $X=0.4175 $Y=0.2025
cc_60 N_Y_13 N_A_4 0.0507592f $X=0.4175 $Y=0.0675
cc_61 N_Y_13 N_7_13 0.000551292f $X=0.4175 $Y=0.0675
cc_62 N_Y_2 N_7_13 0.00072103f $X=0.432 $Y=0.0675
cc_63 N_Y_20 N_7_3 0.000783988f $X=0.4205 $Y=0.072
cc_64 N_Y_13 N_7_12 0.00214272f $X=0.4175 $Y=0.0675
cc_65 N_Y_4 N_7_3 0.00116516f $X=0.54 $Y=0.0675
cc_66 N_Y_2 N_7_2 0.0012219f $X=0.432 $Y=0.0675
cc_67 N_Y_2 N_7_3 0.00538636f $X=0.432 $Y=0.0675
cc_68 N_Y_20 N_7_13 0.00969314f $X=0.4205 $Y=0.072
x_PM_NAND3x1_ASAP7_75t_R%C vss C N_M0_g N_M1_g N_M2_g N_M9_g N_C_1 N_C_5 N_C_6
+ N_C_4 N_C_3 PM_NAND3x1_ASAP7_75t_R%C
x_PM_NAND3x1_ASAP7_75t_R%A vss A N_M6_g N_M11_g N_M7_g N_M8_g N_A_3 N_A_1 N_A_8
+ N_A_4 N_A_5 N_A_7 N_A_6 N_A_9 PM_NAND3x1_ASAP7_75t_R%A
cc_69 N_A_3 N_B_1 0.000263803f $X=0.405 $Y=0.0245
cc_70 N_A_1 N_B_1 0.00163108f $X=0.405 $Y=0.135
cc_71 N_A_3 N_B_5 0.00439792f $X=0.405 $Y=0.0245

* End of included file NAND3x1_ASAP7_75t_R.pex.sp.pxi
.ends

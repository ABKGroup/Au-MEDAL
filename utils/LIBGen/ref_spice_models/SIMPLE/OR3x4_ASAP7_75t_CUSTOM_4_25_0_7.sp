.subckt PM_OR3x4_ASAP7_75t_R%8 vss 2 3 1
c1 1 vss 0.000708033f $X=0.108 $Y=0.2025
r1 2 1 0.209877 $w=8.1e-08 $l=1.7e-08 $layer=P_src_drn $thickness=1e-09
+ $X=0.0906 $Y=0.2025 $X2=0.108 $Y2=0.2025
r2 3 1 0.209877 $w=8.1e-08 $l=1.7e-08 $layer=P_src_drn $thickness=1e-09
+ $X=0.1253 $Y=0.2025 $X2=0.108 $Y2=0.2025
.ends

.subckt PM_OR3x4_ASAP7_75t_R%9 vss 2 3 1
c1 1 vss 0.000749942f $X=0.162 $Y=0.2025
r1 2 1 0.209877 $w=8.1e-08 $l=1.7e-08 $layer=P_src_drn $thickness=1e-09
+ $X=0.1446 $Y=0.2025 $X2=0.162 $Y2=0.2025
r2 3 1 0.209877 $w=8.1e-08 $l=1.7e-08 $layer=P_src_drn $thickness=1e-09
+ $X=0.1793 $Y=0.2025 $X2=0.162 $Y2=0.2025
.ends

.subckt PM_OR3x4_ASAP7_75t_R%B vss 11 5 9 1 4 3
c1 1 vss 0.00710792f $X=0.135 $Y=0.1355
c2 3 vss 0.0466342f $X=0.135 $Y=0.0245
c3 4 vss 0.00481447f $X=0.135 $Y=0.098
r1 11 4 8.62802 $w=1.3e-08 $l=3.7e-08 $layer=M1 $thickness=3.6e-08 $X=0.136
+ $Y=0.134 $X2=0.135 $Y2=0.098
r2 1 7 10.9005 $w=1.765e-08 $layer=LIG $thickness=5.2e-08 $X=0.135 $Y=0.1355
+ $X2=0.135 $Y2=0.1355
r3 11 1 19.3796 $a=3.24e-16 $layer=V0LIG $X=0.136 $Y=0.134 $X2=0.135 $Y2=0.1355
r4 9 8 16.3266 $w=2.1e-08 $l=4.8e-08 $layer=Gate_1 $thickness=5.6e-08 $X=0.135
+ $Y=0.2025 $X2=0.135 $Y2=0.1545
r5 7 8 6.6582 $w=2.03947e-08 $l=1.9e-08 $layer=Gate_1 $thickness=5.6e-08
+ $X=0.135 $Y=0.1355 $X2=0.135 $Y2=0.1545
r6 6 7 6.82827 $w=2.04103e-08 $l=1.95e-08 $layer=Gate_1 $thickness=5.6e-08
+ $X=0.135 $Y=0.116 $X2=0.135 $Y2=0.1355
r7 5 6 16.4967 $w=2.1e-08 $l=4.85e-08 $layer=Gate_1 $thickness=5.6e-08 $X=0.135
+ $Y=0.0675 $X2=0.135 $Y2=0.116
r8 5 3 14.6259 $w=2.1e-08 $l=4.3e-08 $layer=Gate_1 $thickness=5.6e-08 $X=0.135
+ $Y=0.0675 $X2=0.135 $Y2=0.0245
.ends

.subckt PM_OR3x4_ASAP7_75t_R%Y vss 48 34 35 43 44 58 59 62 63 13 24 3 4 17 18 2
+ 1 23 15 14 16
c1 1 vss 0.00712238f $X=0.27 $Y=0.0675
c2 2 vss 0.00696987f $X=0.27 $Y=0.2025
c3 3 vss 0.00728918f $X=0.378 $Y=0.0675
c4 4 vss 0.00728918f $X=0.378 $Y=0.2025
c5 13 vss 0.00436826f $X=0.2555 $Y=0.0675
c6 14 vss 0.00432879f $X=0.3635 $Y=0.0675
c7 15 vss 0.00435495f $X=0.2555 $Y=0.2025
c8 16 vss 0.00431726f $X=0.3635 $Y=0.2025
c9 17 vss 0.00240819f $X=0.27 $Y=0.036
c10 18 vss 0.00240819f $X=0.27 $Y=0.234
c11 19 vss 0.00203072f $X=0.378 $Y=0.036
c12 20 vss 0.00203072f $X=0.378 $Y=0.234
c13 21 vss 0.00287278f $X=0.459 $Y=0.036
c14 22 vss 0.00287278f $X=0.459 $Y=0.234
c15 23 vss 0.00123635f $X=0.27 $Y=0.054
c16 24 vss 0.000936741f $X=0.27 $Y=0.1865
c17 25 vss 0.00832475f $X=0.2815 $Y=0.036
c18 26 vss 0.00832455f $X=0.3265 $Y=0.234
c19 27 vss 0.000939998f $X=0.378 $Y=0.054
c20 28 vss 0.000939998f $X=0.378 $Y=0.1865
c21 29 vss 0.00585622f $X=0.4185 $Y=0.036
c22 30 vss 0.00590846f $X=0.4185 $Y=0.234
c23 31 vss 0.00826948f $X=0.459 $Y=0.0655
r1 63 61 0.0308642 $w=8.1e-08 $l=2.5e-09 $layer=P_src_drn $thickness=1e-09
+ $X=0.2873 $Y=0.2025 $X2=0.2845 $Y2=0.2025
r2 2 61 0.179012 $w=8.1e-08 $l=1.45e-08 $layer=P_src_drn $thickness=1e-09
+ $X=0.27 $Y=0.2025 $X2=0.2845 $Y2=0.2025
r3 15 2 0.179012 $w=8.1e-08 $l=1.45e-08 $layer=P_src_drn $thickness=1e-09
+ $X=0.2555 $Y=0.2025 $X2=0.27 $Y2=0.2025
r4 62 15 0.0308642 $w=8.1e-08 $l=2.5e-09 $layer=P_src_drn $thickness=1e-09
+ $X=0.2526 $Y=0.2025 $X2=0.2555 $Y2=0.2025
r5 2 54 19.3796 $a=3.24e-16 $layer=V0LISD $X=0.27 $Y=0.2025 $X2=0.27 $Y2=0.198
r6 59 57 0.0308642 $w=8.1e-08 $l=2.5e-09 $layer=P_src_drn $thickness=1e-09
+ $X=0.3953 $Y=0.2025 $X2=0.3925 $Y2=0.2025
r7 4 57 0.179012 $w=8.1e-08 $l=1.45e-08 $layer=P_src_drn $thickness=1e-09
+ $X=0.378 $Y=0.2025 $X2=0.3925 $Y2=0.2025
r8 16 4 0.179012 $w=8.1e-08 $l=1.45e-08 $layer=P_src_drn $thickness=1e-09
+ $X=0.3635 $Y=0.2025 $X2=0.378 $Y2=0.2025
r9 58 16 0.0308642 $w=8.1e-08 $l=2.5e-09 $layer=P_src_drn $thickness=1e-09
+ $X=0.3606 $Y=0.2025 $X2=0.3635 $Y2=0.2025
r10 54 55 4.19742 $w=1.3e-08 $l=1.8e-08 $layer=M1 $thickness=3.6e-08 $X=0.27
+ $Y=0.198 $X2=0.27 $Y2=0.216
r11 24 54 2.68168 $w=1.3e-08 $l=1.15e-08 $layer=M1 $thickness=3.6e-08 $X=0.27
+ $Y=0.1865 $X2=0.27 $Y2=0.198
r12 4 52 19.3796 $a=3.24e-16 $layer=V0LISD $X=0.378 $Y=0.2025 $X2=0.378
+ $Y2=0.198
r13 18 51 1.03257 $w=1.6913e-08 $l=1.15e-08 $layer=M1 $thickness=3.6e-08
+ $X=0.27 $Y=0.234 $X2=0.2815 $Y2=0.234
r14 18 55 2.5483 $w=1.79e-08 $l=1.8e-08 $layer=M1 $thickness=3.6e-08 $X=0.27
+ $Y=0.234 $X2=0.27 $Y2=0.216
r15 52 53 4.19742 $w=1.3e-08 $l=1.8e-08 $layer=M1 $thickness=3.6e-08 $X=0.378
+ $Y=0.198 $X2=0.378 $Y2=0.216
r16 28 52 2.68168 $w=1.3e-08 $l=1.15e-08 $layer=M1 $thickness=3.6e-08 $X=0.378
+ $Y=0.1865 $X2=0.378 $Y2=0.198
r17 26 51 10.4935 $w=1.3e-08 $l=4.5e-08 $layer=M1 $thickness=3.6e-08 $X=0.3265
+ $Y=0.234 $X2=0.2815 $Y2=0.234
r18 20 30 8.26388 $w=1.41111e-08 $l=4.05e-08 $layer=M1 $thickness=3.6e-08
+ $X=0.378 $Y=0.234 $X2=0.4185 $Y2=0.234
r19 20 26 10.829 $w=1.38738e-08 $l=5.15e-08 $layer=M1 $thickness=3.6e-08
+ $X=0.378 $Y=0.234 $X2=0.3265 $Y2=0.234
r20 20 53 3.01711 $w=1.55e-08 $l=1.8e-08 $layer=M1 $thickness=3.6e-08 $X=0.378
+ $Y=0.234 $X2=0.378 $Y2=0.216
r21 22 50 5.22999 $w=1.59898e-08 $l=2.95e-08 $layer=M1 $thickness=3.6e-08
+ $X=0.459 $Y=0.234 $X2=0.459 $Y2=0.2045
r22 22 30 7.79507 $w=1.41111e-08 $l=4.05e-08 $layer=M1 $thickness=3.6e-08
+ $X=0.459 $Y=0.234 $X2=0.4185 $Y2=0.234
r23 49 50 8.97781 $w=1.3e-08 $l=3.85e-08 $layer=M1 $thickness=3.6e-08 $X=0.459
+ $Y=0.166 $X2=0.459 $Y2=0.2045
r24 48 49 4.31401 $w=1.3e-08 $l=1.85e-08 $layer=M1 $thickness=3.6e-08 $X=0.459
+ $Y=0.1475 $X2=0.459 $Y2=0.166
r25 48 47 0.46638 $w=1.3e-08 $l=2e-09 $layer=M1 $thickness=3.6e-08 $X=0.459
+ $Y=0.1475 $X2=0.459 $Y2=0.1455
r26 46 47 2.44849 $w=1.3e-08 $l=1.05e-08 $layer=M1 $thickness=3.6e-08 $X=0.459
+ $Y=0.135 $X2=0.459 $Y2=0.1455
r27 45 46 6.7625 $w=1.3e-08 $l=2.9e-08 $layer=M1 $thickness=3.6e-08 $X=0.459
+ $Y=0.106 $X2=0.459 $Y2=0.135
r28 31 45 9.44419 $w=1.3e-08 $l=4.05e-08 $layer=M1 $thickness=3.6e-08 $X=0.459
+ $Y=0.0655 $X2=0.459 $Y2=0.106
r29 44 42 0.0308642 $w=8.1e-08 $l=2.5e-09 $layer=N_src_drn $thickness=1e-09
+ $X=0.3953 $Y=0.0675 $X2=0.3925 $Y2=0.0675
r30 3 42 0.179012 $w=8.1e-08 $l=1.45e-08 $layer=N_src_drn $thickness=1e-09
+ $X=0.378 $Y=0.0675 $X2=0.3925 $Y2=0.0675
r31 14 3 0.179012 $w=8.1e-08 $l=1.45e-08 $layer=N_src_drn $thickness=1e-09
+ $X=0.3635 $Y=0.0675 $X2=0.378 $Y2=0.0675
r32 43 14 0.0308642 $w=8.1e-08 $l=2.5e-09 $layer=N_src_drn $thickness=1e-09
+ $X=0.3606 $Y=0.0675 $X2=0.3635 $Y2=0.0675
r33 21 29 7.79507 $w=1.41111e-08 $l=4.05e-08 $layer=M1 $thickness=3.6e-08
+ $X=0.459 $Y=0.036 $X2=0.4185 $Y2=0.036
r34 21 31 5.22999 $w=1.59898e-08 $l=2.95e-08 $layer=M1 $thickness=3.6e-08
+ $X=0.459 $Y=0.036 $X2=0.459 $Y2=0.0655
r35 3 39 19.3796 $a=3.24e-16 $layer=V0LISD $X=0.378 $Y=0.0675 $X2=0.378
+ $Y2=0.072
r36 27 39 4.19742 $w=1.3e-08 $l=1.8e-08 $layer=M1 $thickness=3.6e-08 $X=0.378
+ $Y=0.054 $X2=0.378 $Y2=0.072
r37 19 38 10.829 $w=1.38738e-08 $l=5.15e-08 $layer=M1 $thickness=3.6e-08
+ $X=0.378 $Y=0.036 $X2=0.3265 $Y2=0.036
r38 19 27 3.01711 $w=1.55e-08 $l=1.8e-08 $layer=M1 $thickness=3.6e-08 $X=0.378
+ $Y=0.036 $X2=0.378 $Y2=0.054
r39 19 29 8.26388 $w=1.41111e-08 $l=4.05e-08 $layer=M1 $thickness=3.6e-08
+ $X=0.378 $Y=0.036 $X2=0.4185 $Y2=0.036
r40 25 38 10.4935 $w=1.3e-08 $l=4.5e-08 $layer=M1 $thickness=3.6e-08 $X=0.2815
+ $Y=0.036 $X2=0.3265 $Y2=0.036
r41 17 23 2.5483 $w=1.79e-08 $l=1.8e-08 $layer=M1 $thickness=3.6e-08 $X=0.27
+ $Y=0.036 $X2=0.27 $Y2=0.054
r42 17 25 1.03257 $w=1.6913e-08 $l=1.15e-08 $layer=M1 $thickness=3.6e-08
+ $X=0.27 $Y=0.036 $X2=0.2815 $Y2=0.036
r43 23 36 4.19742 $w=1.3e-08 $l=1.8e-08 $layer=M1 $thickness=3.6e-08 $X=0.27
+ $Y=0.054 $X2=0.27 $Y2=0.072
r44 1 36 19.3796 $a=3.24e-16 $layer=V0LISD $X=0.27 $Y=0.0675 $X2=0.27 $Y2=0.072
r45 35 33 0.0308642 $w=8.1e-08 $l=2.5e-09 $layer=N_src_drn $thickness=1e-09
+ $X=0.2873 $Y=0.0675 $X2=0.2845 $Y2=0.0675
r46 1 33 0.179012 $w=8.1e-08 $l=1.45e-08 $layer=N_src_drn $thickness=1e-09
+ $X=0.27 $Y=0.0675 $X2=0.2845 $Y2=0.0675
r47 13 1 0.179012 $w=8.1e-08 $l=1.45e-08 $layer=N_src_drn $thickness=1e-09
+ $X=0.2555 $Y=0.0675 $X2=0.27 $Y2=0.0675
r48 34 13 0.0308642 $w=8.1e-08 $l=2.5e-09 $layer=N_src_drn $thickness=1e-09
+ $X=0.2526 $Y=0.0675 $X2=0.2555 $Y2=0.0675
.ends

.subckt PM_OR3x4_ASAP7_75t_R%6 vss 27 31 46 49 52 55 59 63 89 90 92 94 18 3 22
+ 23 4 16 5 17 1 24 25 12 20 21 19 14 15 26 13
c1 1 vss 0.0165816f $X=0.243 $Y=0.135
c2 3 vss 0.0108287f $X=0.054 $Y=0.0675
c3 4 vss 0.00901998f $X=0.054 $Y=0.2025
c4 5 vss 0.00879536f $X=0.162 $Y=0.0675
c5 12 vss 0.0811714f $X=0.243 $Y=0.0245
c6 13 vss 0.0805582f $X=0.297 $Y=0.135
c7 14 vss 0.0810917f $X=0.351 $Y=0.135
c8 15 vss 0.0884646f $X=0.405 $Y=0.135
c9 16 vss 0.0439535f $X=0.056 $Y=0.0675
c10 17 vss 0.00944097f $X=0.1475 $Y=0.0675
c11 18 vss 0.0439693f $X=0.056 $Y=0.2025
c12 19 vss 0.00272508f $X=0.232 $Y=0.036
c13 20 vss 0.000240074f $X=0.232 $Y=0.135
c14 21 vss 0.00274362f $X=0.232 $Y=0.234
c15 22 vss 0.0206188f $X=0.2105 $Y=0.036
c16 23 vss 0.0221115f $X=0.2105 $Y=0.234
c17 24 vss 0.00350844f $X=0.232 $Y=0.106
c18 25 vss 0.0036157f $X=0.232 $Y=0.164
c19 26 vss 0.00138226f $X=0.27 $Y=0.135
r1 94 93 0.0308642 $w=8.1e-08 $l=2.5e-09 $layer=P_src_drn $thickness=1e-09
+ $X=0.0713 $Y=0.2025 $X2=0.0685 $Y2=0.2025
r2 18 93 0.154321 $w=8.1e-08 $l=1.25e-08 $layer=P_src_drn $thickness=1e-09
+ $X=0.056 $Y=0.2025 $X2=0.0685 $Y2=0.2025
r3 92 91 0.0308642 $w=8.1e-08 $l=2.5e-09 $layer=N_src_drn $thickness=1e-09
+ $X=0.0713 $Y=0.0675 $X2=0.0685 $Y2=0.0675
r4 16 91 0.154321 $w=8.1e-08 $l=1.25e-08 $layer=N_src_drn $thickness=1e-09
+ $X=0.056 $Y=0.0675 $X2=0.0685 $Y2=0.0675
r5 90 88 0.0308642 $w=8.1e-08 $l=2.5e-09 $layer=N_src_drn $thickness=1e-09
+ $X=0.1793 $Y=0.0675 $X2=0.1765 $Y2=0.0675
r6 5 88 0.179012 $w=8.1e-08 $l=1.45e-08 $layer=N_src_drn $thickness=1e-09
+ $X=0.162 $Y=0.0675 $X2=0.1765 $Y2=0.0675
r7 17 5 0.179012 $w=8.1e-08 $l=1.45e-08 $layer=N_src_drn $thickness=1e-09
+ $X=0.1475 $Y=0.0675 $X2=0.162 $Y2=0.0675
r8 89 17 0.0308642 $w=8.1e-08 $l=2.5e-09 $layer=N_src_drn $thickness=1e-09
+ $X=0.1446 $Y=0.0675 $X2=0.1475 $Y2=0.0675
r9 4 85 19.3796 $a=3.24e-16 $layer=V0LISD $X=0.054 $Y=0.2025 $X2=0.054 $Y2=0.234
r10 3 77 19.3796 $a=3.24e-16 $layer=V0LISD $X=0.054 $Y=0.0675 $X2=0.054
+ $Y2=0.036
r11 5 71 19.3796 $a=3.24e-16 $layer=V0LISD $X=0.162 $Y=0.0675 $X2=0.162
+ $Y2=0.036
r12 85 86 3.14806 $w=1.3e-08 $l=1.35e-08 $layer=M1 $thickness=3.6e-08 $X=0.054
+ $Y=0.234 $X2=0.0675 $Y2=0.234
r13 83 86 3.14806 $w=1.3e-08 $l=1.35e-08 $layer=M1 $thickness=3.6e-08 $X=0.081
+ $Y=0.234 $X2=0.0675 $Y2=0.234
r14 82 83 6.29612 $w=1.3e-08 $l=2.7e-08 $layer=M1 $thickness=3.6e-08 $X=0.108
+ $Y=0.234 $X2=0.081 $Y2=0.234
r15 81 82 6.29612 $w=1.3e-08 $l=2.7e-08 $layer=M1 $thickness=3.6e-08 $X=0.135
+ $Y=0.234 $X2=0.108 $Y2=0.234
r16 80 81 6.29612 $w=1.3e-08 $l=2.7e-08 $layer=M1 $thickness=3.6e-08 $X=0.162
+ $Y=0.234 $X2=0.135 $Y2=0.234
r17 79 80 6.29612 $w=1.3e-08 $l=2.7e-08 $layer=M1 $thickness=3.6e-08 $X=0.189
+ $Y=0.234 $X2=0.162 $Y2=0.234
r18 23 79 5.01358 $w=1.3e-08 $l=2.15e-08 $layer=M1 $thickness=3.6e-08 $X=0.2105
+ $Y=0.234 $X2=0.189 $Y2=0.234
r19 77 78 3.14806 $w=1.3e-08 $l=1.35e-08 $layer=M1 $thickness=3.6e-08 $X=0.054
+ $Y=0.036 $X2=0.0675 $Y2=0.036
r20 75 78 3.14806 $w=1.3e-08 $l=1.35e-08 $layer=M1 $thickness=3.6e-08 $X=0.081
+ $Y=0.036 $X2=0.0675 $Y2=0.036
r21 74 75 6.29612 $w=1.3e-08 $l=2.7e-08 $layer=M1 $thickness=3.6e-08 $X=0.108
+ $Y=0.036 $X2=0.081 $Y2=0.036
r22 73 74 6.29612 $w=1.3e-08 $l=2.7e-08 $layer=M1 $thickness=3.6e-08 $X=0.135
+ $Y=0.036 $X2=0.108 $Y2=0.036
r23 71 72 3.14806 $w=1.3e-08 $l=1.35e-08 $layer=M1 $thickness=3.6e-08 $X=0.162
+ $Y=0.036 $X2=0.1755 $Y2=0.036
r24 70 71 3.14806 $w=1.3e-08 $l=1.35e-08 $layer=M1 $thickness=3.6e-08 $X=0.1485
+ $Y=0.036 $X2=0.162 $Y2=0.036
r25 70 73 3.14806 $w=1.3e-08 $l=1.35e-08 $layer=M1 $thickness=3.6e-08 $X=0.1485
+ $Y=0.036 $X2=0.135 $Y2=0.036
r26 69 72 3.14806 $w=1.3e-08 $l=1.35e-08 $layer=M1 $thickness=3.6e-08 $X=0.189
+ $Y=0.036 $X2=0.1755 $Y2=0.036
r27 22 69 5.01358 $w=1.3e-08 $l=2.15e-08 $layer=M1 $thickness=3.6e-08 $X=0.2105
+ $Y=0.036 $X2=0.189 $Y2=0.036
r28 21 68 3.36447 $w=1.71023e-08 $l=2.15e-08 $layer=M1 $thickness=3.6e-08
+ $X=0.232 $Y=0.234 $X2=0.232 $Y2=0.2125
r29 21 23 3.36447 $w=1.5093e-08 $l=2.15e-08 $layer=M1 $thickness=3.6e-08
+ $X=0.232 $Y=0.234 $X2=0.2105 $Y2=0.234
r30 19 66 3.36447 $w=1.71023e-08 $l=2.15e-08 $layer=M1 $thickness=3.6e-08
+ $X=0.232 $Y=0.036 $X2=0.232 $Y2=0.0575
r31 19 22 3.36447 $w=1.5093e-08 $l=2.15e-08 $layer=M1 $thickness=3.6e-08
+ $X=0.232 $Y=0.036 $X2=0.2105 $Y2=0.036
r32 67 68 4.78039 $w=1.3e-08 $l=2.05e-08 $layer=M1 $thickness=3.6e-08 $X=0.232
+ $Y=0.192 $X2=0.232 $Y2=0.2125
r33 25 67 6.52931 $w=1.3e-08 $l=2.8e-08 $layer=M1 $thickness=3.6e-08 $X=0.232
+ $Y=0.164 $X2=0.232 $Y2=0.192
r34 65 66 4.78039 $w=1.3e-08 $l=2.05e-08 $layer=M1 $thickness=3.6e-08 $X=0.232
+ $Y=0.078 $X2=0.232 $Y2=0.0575
r35 24 65 6.52931 $w=1.3e-08 $l=2.8e-08 $layer=M1 $thickness=3.6e-08 $X=0.232
+ $Y=0.106 $X2=0.232 $Y2=0.078
r36 20 43 3.2503 $w=1.53684e-08 $l=1.9e-08 $layer=M1 $thickness=3.6e-08
+ $X=0.232 $Y=0.135 $X2=0.251 $Y2=0.135
r37 20 24 5.5822 $w=1.45517e-08 $l=2.9e-08 $layer=M1 $thickness=3.6e-08
+ $X=0.232 $Y=0.135 $X2=0.232 $Y2=0.106
r38 20 25 5.5822 $w=1.45517e-08 $l=2.9e-08 $layer=M1 $thickness=3.6e-08
+ $X=0.232 $Y=0.135 $X2=0.232 $Y2=0.164
r39 63 62 14.6259 $w=2.1e-08 $l=4.3e-08 $layer=Gate_1 $thickness=5.6e-08
+ $X=0.405 $Y=0.2025 $X2=0.405 $Y2=0.1595
r40 61 62 2.7211 $w=2.1e-08 $l=8e-09 $layer=Gate_1 $thickness=5.6e-08 $X=0.405
+ $Y=0.1515 $X2=0.405 $Y2=0.1595
r41 59 60 14.6259 $w=2.1e-08 $l=4.3e-08 $layer=Gate_1 $thickness=5.6e-08
+ $X=0.405 $Y=0.0675 $X2=0.405 $Y2=0.1105
r42 57 60 2.7211 $w=2.1e-08 $l=8e-09 $layer=Gate_1 $thickness=5.6e-08 $X=0.405
+ $Y=0.1185 $X2=0.405 $Y2=0.1105
r43 15 41 6.54019 $w=2.09524e-08 $layer=Gate_1 $thickness=5.21905e-08 $X=0.405
+ $Y=0.135 $X2=0.405 $Y2=0.135
r44 15 57 5.79936 $w=2.03333e-08 $l=1.65e-08 $layer=Gate_1 $thickness=5.6e-08
+ $X=0.405 $Y=0.135 $X2=0.405 $Y2=0.1185
r45 15 61 5.79936 $w=2.03333e-08 $l=1.65e-08 $layer=Gate_1 $thickness=5.6e-08
+ $X=0.405 $Y=0.135 $X2=0.405 $Y2=0.1515
r46 55 54 16.4967 $w=2.1e-08 $l=4.85e-08 $layer=Gate_1 $thickness=5.6e-08
+ $X=0.351 $Y=0.2025 $X2=0.351 $Y2=0.154
r47 52 53 16.4967 $w=2.1e-08 $l=4.85e-08 $layer=Gate_1 $thickness=5.6e-08
+ $X=0.351 $Y=0.0675 $X2=0.351 $Y2=0.116
r48 14 39 6.54019 $w=2.09524e-08 $layer=Gate_1 $thickness=5.21905e-08 $X=0.351
+ $Y=0.135 $X2=0.351 $Y2=0.135
r49 14 53 6.6497 $w=2.04211e-08 $l=1.9e-08 $layer=Gate_1 $thickness=5.6e-08
+ $X=0.351 $Y=0.135 $X2=0.351 $Y2=0.116
r50 14 54 6.6497 $w=2.04211e-08 $l=1.9e-08 $layer=Gate_1 $thickness=5.6e-08
+ $X=0.351 $Y=0.135 $X2=0.351 $Y2=0.154
r51 49 48 16.4967 $w=2.1e-08 $l=4.85e-08 $layer=Gate_1 $thickness=5.6e-08
+ $X=0.297 $Y=0.2025 $X2=0.297 $Y2=0.154
r52 46 47 16.4967 $w=2.1e-08 $l=4.85e-08 $layer=Gate_1 $thickness=5.6e-08
+ $X=0.297 $Y=0.0675 $X2=0.297 $Y2=0.116
r53 13 37 6.54019 $w=2.09524e-08 $layer=Gate_1 $thickness=5.21905e-08 $X=0.297
+ $Y=0.135 $X2=0.297 $Y2=0.135
r54 13 47 6.6497 $w=2.04211e-08 $l=1.9e-08 $layer=Gate_1 $thickness=5.6e-08
+ $X=0.297 $Y=0.135 $X2=0.297 $Y2=0.116
r55 13 48 6.6497 $w=2.04211e-08 $l=1.9e-08 $layer=Gate_1 $thickness=5.6e-08
+ $X=0.297 $Y=0.135 $X2=0.297 $Y2=0.154
r56 26 35 19.3796 $a=3.24e-16 $layer=V0LIG $X=0.27 $Y=0.135 $X2=0.27 $Y2=0.135
r57 26 43 4.43061 $w=1.3e-08 $l=1.9e-08 $layer=M1 $thickness=3.6e-08 $X=0.27
+ $Y=0.135 $X2=0.251 $Y2=0.135
r58 40 41 12.6539 $w=1.77815e-08 $l=2.7e-08 $layer=LIG $thickness=4.8e-08
+ $X=0.378 $Y=0.135 $X2=0.405 $Y2=0.135
r59 39 40 12.6539 $w=1.77815e-08 $l=2.7e-08 $layer=LIG $thickness=4.8e-08
+ $X=0.351 $Y=0.135 $X2=0.378 $Y2=0.135
r60 38 39 12.6539 $w=1.77815e-08 $l=2.7e-08 $layer=LIG $thickness=4.8e-08
+ $X=0.324 $Y=0.135 $X2=0.351 $Y2=0.135
r61 37 38 12.6539 $w=1.77815e-08 $l=2.7e-08 $layer=LIG $thickness=4.8e-08
+ $X=0.297 $Y=0.135 $X2=0.324 $Y2=0.135
r62 36 37 4.97449 $w=2.00857e-08 $l=1.4e-08 $layer=LIG $thickness=4.8e-08
+ $X=0.283 $Y=0.135 $X2=0.297 $Y2=0.135
r63 35 36 7.6794 $w=1.53e-08 $l=1.3e-08 $layer=LIG $thickness=4.8e-08 $X=0.27
+ $Y=0.135 $X2=0.283 $Y2=0.135
r64 34 35 7.6794 $w=1.53e-08 $l=1.3e-08 $layer=LIG $thickness=4.8e-08 $X=0.257
+ $Y=0.135 $X2=0.27 $Y2=0.135
r65 1 29 6.54019 $w=2.09524e-08 $layer=Gate_1 $thickness=5.21905e-08 $X=0.243
+ $Y=0.135 $X2=0.243 $Y2=0.135
r66 1 34 4.97449 $w=2.00857e-08 $l=1.4e-08 $layer=LIG $thickness=4.8e-08
+ $X=0.243 $Y=0.135 $X2=0.257 $Y2=0.135
r67 31 30 16.4967 $w=2.1e-08 $l=4.85e-08 $layer=Gate_1 $thickness=5.6e-08
+ $X=0.243 $Y=0.2025 $X2=0.243 $Y2=0.154
r68 29 30 6.6497 $w=2.04211e-08 $l=1.9e-08 $layer=Gate_1 $thickness=5.6e-08
+ $X=0.243 $Y=0.135 $X2=0.243 $Y2=0.154
r69 28 29 6.6497 $w=2.04211e-08 $l=1.9e-08 $layer=Gate_1 $thickness=5.6e-08
+ $X=0.243 $Y=0.116 $X2=0.243 $Y2=0.135
r70 27 28 16.4967 $w=2.1e-08 $l=4.85e-08 $layer=Gate_1 $thickness=5.6e-08
+ $X=0.243 $Y=0.0675 $X2=0.243 $Y2=0.116
r71 27 12 14.6259 $w=2.1e-08 $l=4.3e-08 $layer=Gate_1 $thickness=5.6e-08
+ $X=0.243 $Y=0.0675 $X2=0.243 $Y2=0.0245
r72 4 18 1e-05 $l=2e-09 $X=0.054 $Y=0.2025 $X2=0.056 $Y2=0.2025
r73 3 16 1e-05 $l=2e-09 $X=0.054 $Y=0.0675 $X2=0.056 $Y2=0.0675
.ends

.subckt PM_OR3x4_ASAP7_75t_R%A vss 13 5 11 3 4 1
c1 1 vss 0.00277829f $X=0.081 $Y=0.1355
c2 3 vss 0.0524713f $X=0.081 $Y=0.0245
c3 4 vss 0.00899186f $X=0.081 $Y=0.098
r1 13 4 8.62802 $w=1.3e-08 $l=3.7e-08 $layer=M1 $thickness=3.6e-08 $X=0.081
+ $Y=0.134 $X2=0.081 $Y2=0.098
r2 1 8 10.9005 $w=1.765e-08 $layer=LIG $thickness=5.2e-08 $X=0.081 $Y=0.1355
+ $X2=0.081 $Y2=0.1355
r3 13 1 19.3796 $a=3.24e-16 $layer=V0LIG $X=0.081 $Y=0.134 $X2=0.081 $Y2=0.1355
r4 11 10 14.6259 $w=2.1e-08 $l=4.3e-08 $layer=Gate_1 $thickness=5.6e-08
+ $X=0.081 $Y=0.2025 $X2=0.081 $Y2=0.1595
r5 9 10 2.55104 $w=2.1e-08 $l=7.5e-09 $layer=Gate_1 $thickness=5.6e-08 $X=0.081
+ $Y=0.152 $X2=0.081 $Y2=0.1595
r6 8 9 5.80786 $w=2.0303e-08 $l=1.65e-08 $layer=Gate_1 $thickness=5.6e-08
+ $X=0.081 $Y=0.1355 $X2=0.081 $Y2=0.152
r7 7 8 5.97793 $w=2.03235e-08 $l=1.7e-08 $layer=Gate_1 $thickness=5.6e-08
+ $X=0.081 $Y=0.1185 $X2=0.081 $Y2=0.1355
r8 6 7 2.7211 $w=2.1e-08 $l=8e-09 $layer=Gate_1 $thickness=5.6e-08 $X=0.081
+ $Y=0.1105 $X2=0.081 $Y2=0.1185
r9 5 6 14.6259 $w=2.1e-08 $l=4.3e-08 $layer=Gate_1 $thickness=5.6e-08 $X=0.081
+ $Y=0.0675 $X2=0.081 $Y2=0.1105
r10 5 3 14.6259 $w=2.1e-08 $l=4.3e-08 $layer=Gate_1 $thickness=5.6e-08 $X=0.081
+ $Y=0.0675 $X2=0.081 $Y2=0.0245
.ends

.subckt PM_OR3x4_ASAP7_75t_R%C vss 12 5 9 3 4 1
c1 1 vss 0.00775668f $X=0.189 $Y=0.135
c2 3 vss 0.0843088f $X=0.189 $Y=0.0245
c3 4 vss 0.00489962f $X=0.189 $Y=0.098
r1 12 4 8.62802 $w=1.3e-08 $l=3.7e-08 $layer=M1 $thickness=3.6e-08 $X=0.187
+ $Y=0.134 $X2=0.189 $Y2=0.098
r2 1 7 10.6051 $w=1.77022e-08 $l=5e-10 $layer=LIG $thickness=5.20889e-08
+ $X=0.189 $Y=0.135 $X2=0.189 $Y2=0.1355
r3 12 1 19.3796 $a=3.24e-16 $layer=V0LIG $X=0.187 $Y=0.134 $X2=0.189 $Y2=0.135
r4 9 8 16.3266 $w=2.1e-08 $l=4.8e-08 $layer=Gate_1 $thickness=5.6e-08 $X=0.189
+ $Y=0.2025 $X2=0.189 $Y2=0.1545
r5 7 8 6.6582 $w=2.03947e-08 $l=1.9e-08 $layer=Gate_1 $thickness=5.6e-08
+ $X=0.189 $Y=0.1355 $X2=0.189 $Y2=0.1545
r6 6 7 6.82827 $w=2.04103e-08 $l=1.95e-08 $layer=Gate_1 $thickness=5.6e-08
+ $X=0.189 $Y=0.116 $X2=0.189 $Y2=0.1355
r7 5 6 16.4967 $w=2.1e-08 $l=4.85e-08 $layer=Gate_1 $thickness=5.6e-08 $X=0.189
+ $Y=0.0675 $X2=0.189 $Y2=0.116
r8 5 3 14.6259 $w=2.1e-08 $l=4.3e-08 $layer=Gate_1 $thickness=5.6e-08 $X=0.189
+ $Y=0.0675 $X2=0.189 $Y2=0.0245
.ends

* End of included file OR3x4_ASAP7_75t_R.pex.sp.pex

*
.subckt OR3x4_ASAP7_75t_CUSTOM_4_25_0_7 VSS VDD A B C Y
*
* VSS VSS
* VDD VDD
* A A
* B B
* C C
* Y Y
*
*

M0 VSS N_M0_g N_M0_s VSS nmos_rvt L=2e-08 W=8.1e-08 nfin=3 $X=0.071 $Y=0.027
M1 N_M1_d N_M1_g VSS VSS nmos_rvt L=2e-08 W=8.1e-08 nfin=3 $X=0.125 $Y=0.027
M2 VSS N_M2_g N_M2_s VSS nmos_rvt L=2e-08 W=8.1e-08 nfin=3 $X=0.179 $Y=0.027
M3 N_M3_d N_M3_g VSS VSS nmos_rvt L=2e-08 W=8.1e-08 nfin=3 $X=0.233 $Y=0.027
M4 N_M4_d N_M4_g VSS VSS nmos_rvt L=2e-08 W=8.1e-08 nfin=3 $X=0.287 $Y=0.027
M5 N_M5_d N_M5_g VSS VSS nmos_rvt L=2e-08 W=8.1e-08 nfin=3 $X=0.341 $Y=0.027
M6 N_M6_d N_M6_g VSS VSS nmos_rvt L=2e-08 W=8.1e-08 nfin=3 $X=0.395 $Y=0.027
M7 N_M7_d N_M7_g N_M7_s VDD pmos_rvt L=2e-08 W=8.1e-08 nfin=3 $X=0.071 $Y=0.162
M8 N_M8_d N_M8_g N_M8_s VDD pmos_rvt L=2e-08 W=8.1e-08 nfin=3 $X=0.125 $Y=0.162
M9 VDD N_M9_g N_M9_s VDD pmos_rvt L=2e-08 W=8.1e-08 nfin=3 $X=0.179 $Y=0.162
M10 N_M10_d N_M10_g VDD VDD pmos_rvt L=2e-08 W=8.1e-08 nfin=3 $X=0.233 $Y=0.162
M11 N_M11_d N_M11_g VDD VDD pmos_rvt L=2e-08 W=8.1e-08 nfin=3 $X=0.287 $Y=0.162
M12 N_M12_d N_M12_g VDD VDD pmos_rvt L=2e-08 W=8.1e-08 nfin=3 $X=0.341 $Y=0.162
M13 N_M13_d N_M13_g VDD VDD pmos_rvt L=2e-08 W=8.1e-08 nfin=3 $X=0.395 $Y=0.162

* .include "OR3x4_ASAP7_75t_R.pex.sp.pxi"

* Start of included file OR3x4_ASAP7_75t_R.pex.sp.pxi
x_PM_OR3x4_ASAP7_75t_R%8 vss N_M7_d N_M8_s N_8_1 PM_OR3x4_ASAP7_75t_R%8
cc_1 N_8_1 N_A_3 0.0167058f $X=0.108 $Y=0.2025
cc_2 N_8_1 N_B_3 0.0167763f $X=0.108 $Y=0.2025
x_PM_OR3x4_ASAP7_75t_R%9 vss N_M8_d N_M9_s N_9_1 PM_OR3x4_ASAP7_75t_R%9
cc_3 N_9_1 N_B_3 0.0169231f $X=0.162 $Y=0.2025
cc_4 N_9_1 N_C_3 0.0167989f $X=0.162 $Y=0.2025
x_PM_OR3x4_ASAP7_75t_R%B vss B N_M1_g N_M8_g N_B_1 N_B_4 N_B_3
+ PM_OR3x4_ASAP7_75t_R%B
cc_5 N_B_1 N_A_3 0.00127597f $X=0.135 $Y=0.1355
cc_6 N_B_4 N_A_4 0.00471744f $X=0.135 $Y=0.098
cc_7 N_B_3 N_A_3 0.00592276f $X=0.135 $Y=0.0245
x_PM_OR3x4_ASAP7_75t_R%Y vss Y N_M3_d N_M4_d N_M5_d N_M6_d N_M12_d N_M13_d
+ N_M10_d N_M11_d N_Y_13 N_Y_24 N_Y_3 N_Y_4 N_Y_17 N_Y_18 N_Y_2 N_Y_1 N_Y_23
+ N_Y_15 N_Y_14 N_Y_16 PM_OR3x4_ASAP7_75t_R%Y
cc_8 N_Y_13 N_6_1 0.00175884f $X=0.2555 $Y=0.0675
cc_9 N_Y_13 N_6_22 0.000188601f $X=0.2555 $Y=0.0675
cc_10 N_Y_13 N_6_23 0.000203775f $X=0.2555 $Y=0.0675
cc_11 N_Y_13 N_6_21 0.000295207f $X=0.2555 $Y=0.0675
cc_12 N_Y_13 N_6_19 0.000295315f $X=0.2555 $Y=0.0675
cc_13 N_Y_13 N_6_24 0.000694906f $X=0.2555 $Y=0.0675
cc_14 N_Y_13 N_6_25 0.000694906f $X=0.2555 $Y=0.0675
cc_15 N_Y_13 N_6_12 0.0370521f $X=0.2555 $Y=0.0675
cc_16 N_Y_13 N_6_14 0.000826233f $X=0.2555 $Y=0.0675
cc_17 N_Y_13 N_6_15 0.000826276f $X=0.2555 $Y=0.0675
cc_18 N_Y_24 N_6_26 0.00125494f $X=0.27 $Y=0.1865
cc_19 N_Y_3 N_6_15 0.00145959f $X=0.378 $Y=0.0675
cc_20 N_Y_4 N_6_15 0.00145959f $X=0.378 $Y=0.2025
cc_21 N_Y_17 N_6_19 0.00146574f $X=0.27 $Y=0.036
cc_22 N_Y_18 N_6_21 0.00146588f $X=0.27 $Y=0.234
cc_23 N_Y_2 N_6_12 0.00192521f $X=0.27 $Y=0.2025
cc_24 N_Y_1 N_6_12 0.00192556f $X=0.27 $Y=0.0675
cc_25 N_Y_23 N_6_24 0.00374608f $X=0.27 $Y=0.054
cc_26 N_Y_24 N_6_25 0.00375001f $X=0.27 $Y=0.1865
cc_27 N_Y_15 N_6_1 0.00981887f $X=0.2555 $Y=0.2025
cc_28 N_Y_15 N_6_12 0.0100654f $X=0.2555 $Y=0.2025
cc_29 N_Y_14 N_6_15 0.0101893f $X=0.3635 $Y=0.0675
cc_30 N_Y_16 N_6_14 0.0102988f $X=0.3635 $Y=0.2025
cc_31 N_Y_15 N_6_13 0.0181486f $X=0.2555 $Y=0.2025
cc_32 N_Y_14 N_6_14 0.0547298f $X=0.3635 $Y=0.0675
cc_33 N_Y_16 N_6_15 0.0545444f $X=0.3635 $Y=0.2025
cc_34 N_Y_13 N_6_13 0.0661747f $X=0.2555 $Y=0.0675
x_PM_OR3x4_ASAP7_75t_R%6 vss N_M3_g N_M10_g N_M4_g N_M11_g N_M5_g N_M12_g
+ N_M6_g N_M13_g N_M1_d N_M2_s N_M0_s N_M7_s N_6_18 N_6_3 N_6_22 N_6_23 N_6_4
+ N_6_16 N_6_5 N_6_17 N_6_1 N_6_24 N_6_25 N_6_12 N_6_20 N_6_21 N_6_19 N_6_14
+ N_6_15 N_6_26 N_6_13 PM_OR3x4_ASAP7_75t_R%6
cc_35 N_6_18 N_A_3 0.0155447f $X=0.056 $Y=0.2025
cc_36 N_6_3 N_A_3 0.00214889f $X=0.054 $Y=0.0675
cc_37 N_6_22 N_A_4 0.00119448f $X=0.2105 $Y=0.036
cc_38 N_6_23 N_A_4 0.00126982f $X=0.2105 $Y=0.234
cc_39 N_6_4 N_A_3 0.00170293f $X=0.054 $Y=0.2025
cc_40 N_6_18 N_A_1 0.00186783f $X=0.056 $Y=0.2025
cc_41 N_6_3 N_A_4 0.00407027f $X=0.054 $Y=0.0675
cc_42 N_6_16 N_A_3 0.0545966f $X=0.056 $Y=0.0675
cc_43 N_6_5 N_B_3 0.00148519f $X=0.162 $Y=0.0675
cc_44 N_6_17 N_B_1 0.000882504f $X=0.1475 $Y=0.0675
cc_45 N_6_22 N_B_4 0.00110709f $X=0.2105 $Y=0.036
cc_46 N_6_23 N_B_4 0.00141616f $X=0.2105 $Y=0.234
cc_47 N_6_5 N_B_4 0.00325321f $X=0.162 $Y=0.0675
cc_48 N_6_17 N_B_3 0.0356349f $X=0.1475 $Y=0.0675
cc_49 N_6_1 N_C_3 0.000440501f $X=0.243 $Y=0.135
cc_50 N_6_5 N_C_3 0.00191882f $X=0.162 $Y=0.0675
cc_51 N_6_22 N_C_4 0.000918872f $X=0.2105 $Y=0.036
cc_52 N_6_23 N_C_4 0.00108171f $X=0.2105 $Y=0.234
cc_53 N_6_17 N_C_1 0.00131274f $X=0.1475 $Y=0.0675
cc_54 N_6_24 N_C_4 0.00161618f $X=0.232 $Y=0.106
cc_55 N_6_25 N_C_4 0.00164085f $X=0.232 $Y=0.164
cc_56 N_6_12 N_C_3 0.00165788f $X=0.243 $Y=0.0245
cc_57 N_6_20 N_C_4 0.00669864f $X=0.232 $Y=0.135
cc_58 N_6_17 N_C_3 0.0365377f $X=0.1475 $Y=0.0675
x_PM_OR3x4_ASAP7_75t_R%A vss A N_M0_g N_M7_g N_A_3 N_A_4 N_A_1
+ PM_OR3x4_ASAP7_75t_R%A
x_PM_OR3x4_ASAP7_75t_R%C vss C N_M2_g N_M9_g N_C_3 N_C_4 N_C_1
+ PM_OR3x4_ASAP7_75t_R%C
cc_59 N_C_3 N_B_1 0.00128179f $X=0.189 $Y=0.0245
cc_60 N_C_4 N_B_4 0.00463602f $X=0.189 $Y=0.098
cc_61 N_C_3 N_B_3 0.00576184f $X=0.189 $Y=0.0245

* End of included file OR3x4_ASAP7_75t_R.pex.sp.pxi
.ends

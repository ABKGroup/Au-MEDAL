.subckt PM_NAND3x2_ASAP7_75t_R%7 vss 28 29 53 54 57 58 61 62 65 66 69 70 25 19
+ 2 5 23 20 4 24 6 1 21 22 3
c1 1 vss 0.00277375f $X=0.27 $Y=0.0675
c2 2 vss 0.00584539f $X=0.378 $Y=0.0675
c3 3 vss 0.0088668f $X=0.486 $Y=0.0675
c4 4 vss 0.00883573f $X=0.594 $Y=0.0675
c5 5 vss 0.00583627f $X=0.702 $Y=0.0675
c6 6 vss 0.00277656f $X=0.81 $Y=0.0675
c7 19 vss 0.00192046f $X=0.2555 $Y=0.0675
c8 20 vss 0.00318319f $X=0.3635 $Y=0.0675
c9 21 vss 0.00410995f $X=0.4715 $Y=0.0675
c10 22 vss 0.00411027f $X=0.5795 $Y=0.0675
c11 23 vss 0.00315651f $X=0.6875 $Y=0.0675
c12 24 vss 0.00192362f $X=0.7955 $Y=0.0675
c13 25 vss 0.0273945f $X=0.556 $Y=0.072
r1 70 68 0.0308642 $w=8.1e-08 $l=2.5e-09 $layer=N_src_drn $thickness=1e-09
+ $X=0.8273 $Y=0.0675 $X2=0.8245 $Y2=0.0675
r2 6 68 0.179012 $w=8.1e-08 $l=1.45e-08 $layer=N_src_drn $thickness=1e-09
+ $X=0.81 $Y=0.0675 $X2=0.8245 $Y2=0.0675
r3 24 6 0.179012 $w=8.1e-08 $l=1.45e-08 $layer=N_src_drn $thickness=1e-09
+ $X=0.7955 $Y=0.0675 $X2=0.81 $Y2=0.0675
r4 69 24 0.0308642 $w=8.1e-08 $l=2.5e-09 $layer=N_src_drn $thickness=1e-09
+ $X=0.7926 $Y=0.0675 $X2=0.7955 $Y2=0.0675
r5 66 64 0.0308642 $w=8.1e-08 $l=2.5e-09 $layer=N_src_drn $thickness=1e-09
+ $X=0.7193 $Y=0.0675 $X2=0.7165 $Y2=0.0675
r6 5 64 0.179012 $w=8.1e-08 $l=1.45e-08 $layer=N_src_drn $thickness=1e-09
+ $X=0.702 $Y=0.0675 $X2=0.7165 $Y2=0.0675
r7 23 5 0.179012 $w=8.1e-08 $l=1.45e-08 $layer=N_src_drn $thickness=1e-09
+ $X=0.6875 $Y=0.0675 $X2=0.702 $Y2=0.0675
r8 65 23 0.0308642 $w=8.1e-08 $l=2.5e-09 $layer=N_src_drn $thickness=1e-09
+ $X=0.6846 $Y=0.0675 $X2=0.6875 $Y2=0.0675
r9 62 60 0.0308642 $w=8.1e-08 $l=2.5e-09 $layer=N_src_drn $thickness=1e-09
+ $X=0.2873 $Y=0.0675 $X2=0.2845 $Y2=0.0675
r10 1 60 0.179012 $w=8.1e-08 $l=1.45e-08 $layer=N_src_drn $thickness=1e-09
+ $X=0.27 $Y=0.0675 $X2=0.2845 $Y2=0.0675
r11 19 1 0.179012 $w=8.1e-08 $l=1.45e-08 $layer=N_src_drn $thickness=1e-09
+ $X=0.2555 $Y=0.0675 $X2=0.27 $Y2=0.0675
r12 61 19 0.0308642 $w=8.1e-08 $l=2.5e-09 $layer=N_src_drn $thickness=1e-09
+ $X=0.2526 $Y=0.0675 $X2=0.2555 $Y2=0.0675
r13 58 56 0.0308642 $w=8.1e-08 $l=2.5e-09 $layer=N_src_drn $thickness=1e-09
+ $X=0.3953 $Y=0.0675 $X2=0.3925 $Y2=0.0675
r14 2 56 0.179012 $w=8.1e-08 $l=1.45e-08 $layer=N_src_drn $thickness=1e-09
+ $X=0.378 $Y=0.0675 $X2=0.3925 $Y2=0.0675
r15 20 2 0.179012 $w=8.1e-08 $l=1.45e-08 $layer=N_src_drn $thickness=1e-09
+ $X=0.3635 $Y=0.0675 $X2=0.378 $Y2=0.0675
r16 57 20 0.0308642 $w=8.1e-08 $l=2.5e-09 $layer=N_src_drn $thickness=1e-09
+ $X=0.3606 $Y=0.0675 $X2=0.3635 $Y2=0.0675
r17 54 52 0.0308642 $w=8.1e-08 $l=2.5e-09 $layer=N_src_drn $thickness=1e-09
+ $X=0.5033 $Y=0.0675 $X2=0.5005 $Y2=0.0675
r18 3 52 0.179012 $w=8.1e-08 $l=1.45e-08 $layer=N_src_drn $thickness=1e-09
+ $X=0.486 $Y=0.0675 $X2=0.5005 $Y2=0.0675
r19 21 3 0.179012 $w=8.1e-08 $l=1.45e-08 $layer=N_src_drn $thickness=1e-09
+ $X=0.4715 $Y=0.0675 $X2=0.486 $Y2=0.0675
r20 53 21 0.0308642 $w=8.1e-08 $l=2.5e-09 $layer=N_src_drn $thickness=1e-09
+ $X=0.4686 $Y=0.0675 $X2=0.4715 $Y2=0.0675
r21 6 49 19.3796 $a=3.24e-16 $layer=V0LISD $X=0.81 $Y=0.0675 $X2=0.81 $Y2=0.072
r22 5 44 19.3796 $a=3.24e-16 $layer=V0LISD $X=0.702 $Y=0.0675 $X2=0.702
+ $Y2=0.072
r23 1 38 19.3796 $a=3.24e-16 $layer=V0LISD $X=0.27 $Y=0.0675 $X2=0.27 $Y2=0.072
r24 2 34 19.3796 $a=3.24e-16 $layer=V0LISD $X=0.378 $Y=0.0675 $X2=0.378
+ $Y2=0.072
r25 3 31 19.3796 $a=3.24e-16 $layer=V0LISD $X=0.486 $Y=0.0675 $X2=0.486
+ $Y2=0.072
r26 48 49 8.86121 $w=1.3e-08 $l=3.8e-08 $layer=M1 $thickness=3.6e-08 $X=0.772
+ $Y=0.072 $X2=0.81 $Y2=0.072
r27 47 48 6.8791 $w=1.3e-08 $l=2.95e-08 $layer=M1 $thickness=3.6e-08 $X=0.7425
+ $Y=0.072 $X2=0.772 $Y2=0.072
r28 46 47 2.09871 $w=1.3e-08 $l=9e-09 $layer=M1 $thickness=3.6e-08 $X=0.7335
+ $Y=0.072 $X2=0.7425 $Y2=0.072
r29 45 46 3.61444 $w=1.3e-08 $l=1.55e-08 $layer=M1 $thickness=3.6e-08 $X=0.718
+ $Y=0.072 $X2=0.7335 $Y2=0.072
r30 44 45 3.73104 $w=1.3e-08 $l=1.6e-08 $layer=M1 $thickness=3.6e-08 $X=0.702
+ $Y=0.072 $X2=0.718 $Y2=0.072
r31 43 44 5.71315 $w=1.3e-08 $l=2.45e-08 $layer=M1 $thickness=3.6e-08 $X=0.6775
+ $Y=0.072 $X2=0.702 $Y2=0.072
r32 42 43 10.4935 $w=1.3e-08 $l=4.5e-08 $layer=M1 $thickness=3.6e-08 $X=0.6325
+ $Y=0.072 $X2=0.6775 $Y2=0.072
r33 41 42 8.97781 $w=1.3e-08 $l=3.85e-08 $layer=M1 $thickness=3.6e-08 $X=0.594
+ $Y=0.072 $X2=0.6325 $Y2=0.072
r34 40 41 4.43061 $w=1.3e-08 $l=1.9e-08 $layer=M1 $thickness=3.6e-08 $X=0.575
+ $Y=0.072 $X2=0.594 $Y2=0.072
r35 38 39 8.97781 $w=1.3e-08 $l=3.85e-08 $layer=M1 $thickness=3.6e-08 $X=0.27
+ $Y=0.072 $X2=0.3085 $Y2=0.072
r36 36 39 8.97781 $w=1.3e-08 $l=3.85e-08 $layer=M1 $thickness=3.6e-08 $X=0.347
+ $Y=0.072 $X2=0.3085 $Y2=0.072
r37 34 35 5.71315 $w=1.3e-08 $l=2.45e-08 $layer=M1 $thickness=3.6e-08 $X=0.378
+ $Y=0.072 $X2=0.4025 $Y2=0.072
r38 33 34 3.61444 $w=1.3e-08 $l=1.55e-08 $layer=M1 $thickness=3.6e-08 $X=0.3625
+ $Y=0.072 $X2=0.378 $Y2=0.072
r39 33 36 3.61444 $w=1.3e-08 $l=1.55e-08 $layer=M1 $thickness=3.6e-08 $X=0.3625
+ $Y=0.072 $X2=0.347 $Y2=0.072
r40 31 32 8.16164 $w=1.3e-08 $l=3.5e-08 $layer=M1 $thickness=3.6e-08 $X=0.486
+ $Y=0.072 $X2=0.521 $Y2=0.072
r41 30 31 8.97781 $w=1.3e-08 $l=3.85e-08 $layer=M1 $thickness=3.6e-08 $X=0.4475
+ $Y=0.072 $X2=0.486 $Y2=0.072
r42 30 35 10.4935 $w=1.3e-08 $l=4.5e-08 $layer=M1 $thickness=3.6e-08 $X=0.4475
+ $Y=0.072 $X2=0.4025 $Y2=0.072
r43 25 32 8.16164 $w=1.3e-08 $l=3.5e-08 $layer=M1 $thickness=3.6e-08 $X=0.556
+ $Y=0.072 $X2=0.521 $Y2=0.072
r44 25 40 4.43061 $w=1.3e-08 $l=1.9e-08 $layer=M1 $thickness=3.6e-08 $X=0.556
+ $Y=0.072 $X2=0.575 $Y2=0.072
r45 4 41 19.3796 $a=3.24e-16 $layer=V0LISD $X=0.594 $Y=0.0675 $X2=0.594
+ $Y2=0.072
r46 28 27 0.0308642 $w=8.1e-08 $l=2.5e-09 $layer=N_src_drn $thickness=1e-09
+ $X=0.6113 $Y=0.0675 $X2=0.6085 $Y2=0.0675
r47 4 27 0.179012 $w=8.1e-08 $l=1.45e-08 $layer=N_src_drn $thickness=1e-09
+ $X=0.594 $Y=0.0675 $X2=0.6085 $Y2=0.0675
r48 22 4 0.179012 $w=8.1e-08 $l=1.45e-08 $layer=N_src_drn $thickness=1e-09
+ $X=0.5795 $Y=0.0675 $X2=0.594 $Y2=0.0675
r49 29 22 0.0308642 $w=8.1e-08 $l=2.5e-09 $layer=N_src_drn $thickness=1e-09
+ $X=0.5766 $Y=0.0675 $X2=0.5795 $Y2=0.0675
.ends

.subckt PM_NAND3x2_ASAP7_75t_R%C vss 33 10 30 36 40 44 47 50 53 9 1 3 8 5 6 7 4
c1 1 vss 0.0325808f $X=0.621 $Y=0.135
c2 3 vss 0.0874749f $X=0.405 $Y=0.135
c3 4 vss 0.0903938f $X=0.459 $Y=0.135
c4 5 vss 0.0504581f $X=0.513 $Y=0.135
c5 6 vss 0.0504536f $X=0.567 $Y=0.135
c6 7 vss 0.0904078f $X=0.621 $Y=0.0245
c7 8 vss 0.0876443f $X=0.675 $Y=0.135
c8 9 vss 0.00728857f $X=0.556 $Y=0.116
r1 53 52 16.6668 $w=2.1e-08 $l=4.9e-08 $layer=Gate_1 $thickness=5.6e-08
+ $X=0.675 $Y=0.2025 $X2=0.675 $Y2=0.1535
r2 50 51 16.6668 $w=2.1e-08 $l=4.9e-08 $layer=Gate_1 $thickness=5.6e-08
+ $X=0.675 $Y=0.0675 $X2=0.675 $Y2=0.1165
r3 8 27 6.74717 $w=2e-08 $layer=Gate_1 $thickness=5.2e-08 $X=0.675 $Y=0.135
+ $X2=0.675 $Y2=0.135
r4 8 51 6.46262 $w=2.04595e-08 $l=1.85e-08 $layer=Gate_1 $thickness=5.6e-08
+ $X=0.675 $Y=0.135 $X2=0.675 $Y2=0.1165
r5 8 52 6.46262 $w=2.04595e-08 $l=1.85e-08 $layer=Gate_1 $thickness=5.6e-08
+ $X=0.675 $Y=0.135 $X2=0.675 $Y2=0.1535
r6 47 46 16.6668 $w=2.1e-08 $l=4.9e-08 $layer=Gate_1 $thickness=5.6e-08
+ $X=0.405 $Y=0.2025 $X2=0.405 $Y2=0.1535
r7 44 45 16.6668 $w=2.1e-08 $l=4.9e-08 $layer=Gate_1 $thickness=5.6e-08
+ $X=0.405 $Y=0.0675 $X2=0.405 $Y2=0.1165
r8 3 24 6.74717 $w=2e-08 $layer=Gate_1 $thickness=5.2e-08 $X=0.405 $Y=0.135
+ $X2=0.405 $Y2=0.135
r9 3 45 6.46262 $w=2.04595e-08 $l=1.85e-08 $layer=Gate_1 $thickness=5.6e-08
+ $X=0.405 $Y=0.135 $X2=0.405 $Y2=0.1165
r10 3 46 6.46262 $w=2.04595e-08 $l=1.85e-08 $layer=Gate_1 $thickness=5.6e-08
+ $X=0.405 $Y=0.135 $X2=0.405 $Y2=0.1535
r11 40 41 16.6668 $w=2.1e-08 $l=4.9e-08 $layer=Gate_1 $thickness=5.6e-08
+ $X=0.459 $Y=0.0675 $X2=0.459 $Y2=0.1165
r12 4 22 6.74717 $w=2e-08 $layer=Gate_1 $thickness=5.2e-08 $X=0.459 $Y=0.135
+ $X2=0.459 $Y2=0.135
r13 4 41 6.46262 $w=2.04595e-08 $l=1.85e-08 $layer=Gate_1 $thickness=5.6e-08
+ $X=0.459 $Y=0.135 $X2=0.459 $Y2=0.1165
r14 36 37 16.6668 $w=2.1e-08 $l=4.9e-08 $layer=Gate_1 $thickness=5.6e-08
+ $X=0.513 $Y=0.0675 $X2=0.513 $Y2=0.1165
r15 5 20 6.74717 $w=2e-08 $layer=Gate_1 $thickness=5.2e-08 $X=0.513 $Y=0.135
+ $X2=0.513 $Y2=0.135
r16 5 37 6.46262 $w=2.04595e-08 $l=1.85e-08 $layer=Gate_1 $thickness=5.6e-08
+ $X=0.513 $Y=0.135 $X2=0.513 $Y2=0.1165
r17 33 9 4.43061 $w=1.3e-08 $l=1.9e-08 $layer=M1 $thickness=3.6e-08 $X=0.555
+ $Y=0.137 $X2=0.556 $Y2=0.116
r18 30 31 16.6668 $w=2.1e-08 $l=4.9e-08 $layer=Gate_1 $thickness=5.6e-08
+ $X=0.567 $Y=0.0675 $X2=0.567 $Y2=0.1165
r19 6 17 3.57145 $w=2e-08 $layer=Gate_1 $thickness=5.6e-08 $X=0.567 $Y=0.135
+ $X2=0.567 $Y2=0.135
r20 6 31 6.46262 $w=2.04595e-08 $l=1.85e-08 $layer=Gate_1 $thickness=5.6e-08
+ $X=0.567 $Y=0.135 $X2=0.567 $Y2=0.1165
r21 26 27 20.114 $w=1.57815e-08 $l=2.7e-08 $layer=LIG $thickness=4.8e-08
+ $X=0.648 $Y=0.135 $X2=0.675 $Y2=0.135
r22 23 24 20.114 $w=1.57815e-08 $l=2.7e-08 $layer=LIG $thickness=4.8e-08
+ $X=0.432 $Y=0.135 $X2=0.405 $Y2=0.135
r23 22 23 20.114 $w=1.57815e-08 $l=2.7e-08 $layer=LIG $thickness=4.8e-08
+ $X=0.459 $Y=0.135 $X2=0.432 $Y2=0.135
r24 21 22 20.114 $w=1.57815e-08 $l=2.7e-08 $layer=LIG $thickness=4.8e-08
+ $X=0.486 $Y=0.135 $X2=0.459 $Y2=0.135
r25 20 21 20.114 $w=1.57815e-08 $l=2.7e-08 $layer=LIG $thickness=4.8e-08
+ $X=0.513 $Y=0.135 $X2=0.486 $Y2=0.135
r26 33 19 19.3796 $a=3.24e-16 $layer=V0LIG $X=0.555 $Y=0.137 $X2=0.552 $Y2=0.135
r27 18 19 16.9382 $w=1.33e-08 $l=1.7e-08 $layer=LIG $thickness=4.8e-08 $X=0.535
+ $Y=0.135 $X2=0.552 $Y2=0.135
r28 18 20 15.1321 $w=1.63455e-08 $l=2.2e-08 $layer=LIG $thickness=4.8e-08
+ $X=0.535 $Y=0.135 $X2=0.513 $Y2=0.135
r29 16 17 1.90543 $w=2e-08 $l=4e-09 $layer=LIG $thickness=4.8e-08 $X=0.571
+ $Y=0.135 $X2=0.567 $Y2=0.135
r30 15 16 3.17572 $w=2e-08 $l=1e-08 $layer=LIG $thickness=4.8e-08 $X=0.561
+ $Y=0.135 $X2=0.571 $Y2=0.135
r31 15 19 6.25213 $w=1.62778e-08 $l=9e-09 $layer=LIG $thickness=4.8e-08
+ $X=0.561 $Y=0.135 $X2=0.552 $Y2=0.135
r32 14 16 18.8437 $w=1.50478e-08 $l=2.3e-08 $layer=LIG $thickness=4.8e-08
+ $X=0.594 $Y=0.135 $X2=0.571 $Y2=0.135
r33 1 12 6.74717 $w=2e-08 $layer=Gate_1 $thickness=5.2e-08 $X=0.621 $Y=0.135
+ $X2=0.621 $Y2=0.135
r34 1 14 20.114 $w=1.57815e-08 $l=2.7e-08 $layer=LIG $thickness=4.8e-08
+ $X=0.621 $Y=0.135 $X2=0.594 $Y2=0.135
r35 1 26 20.114 $w=1.57815e-08 $l=2.7e-08 $layer=LIG $thickness=4.8e-08
+ $X=0.621 $Y=0.135 $X2=0.648 $Y2=0.135
r36 11 12 6.46262 $w=2.04595e-08 $l=1.85e-08 $layer=Gate_1 $thickness=5.6e-08
+ $X=0.621 $Y=0.1165 $X2=0.621 $Y2=0.135
r37 10 11 16.6668 $w=2.1e-08 $l=4.9e-08 $layer=Gate_1 $thickness=5.6e-08
+ $X=0.621 $Y=0.0675 $X2=0.621 $Y2=0.1165
r38 10 7 14.6259 $w=2.1e-08 $l=4.3e-08 $layer=Gate_1 $thickness=5.6e-08
+ $X=0.621 $Y=0.0675 $X2=0.621 $Y2=0.0245
.ends

.subckt PM_NAND3x2_ASAP7_75t_R%8 vss 16 17 31 32 35 36 12 2 3 11 10 1 13
c1 1 vss 0.00405865f $X=0.756 $Y=0.0675
c2 2 vss 0.00384409f $X=0.864 $Y=0.0675
c3 3 vss 0.00398736f $X=0.972 $Y=0.0675
c4 10 vss 0.00185779f $X=0.7415 $Y=0.0675
c5 11 vss 0.0018846f $X=0.8495 $Y=0.0675
c6 12 vss 0.00187135f $X=0.9575 $Y=0.0675
c7 13 vss 0.018159f $X=0.7445 $Y=0.036
r1 36 34 0.0308642 $w=8.1e-08 $l=2.5e-09 $layer=N_src_drn $thickness=1e-09
+ $X=0.9893 $Y=0.0675 $X2=0.9865 $Y2=0.0675
r2 3 34 0.179012 $w=8.1e-08 $l=1.45e-08 $layer=N_src_drn $thickness=1e-09
+ $X=0.972 $Y=0.0675 $X2=0.9865 $Y2=0.0675
r3 12 3 0.179012 $w=8.1e-08 $l=1.45e-08 $layer=N_src_drn $thickness=1e-09
+ $X=0.9575 $Y=0.0675 $X2=0.972 $Y2=0.0675
r4 35 12 0.0308642 $w=8.1e-08 $l=2.5e-09 $layer=N_src_drn $thickness=1e-09
+ $X=0.9546 $Y=0.0675 $X2=0.9575 $Y2=0.0675
r5 32 30 0.0308642 $w=8.1e-08 $l=2.5e-09 $layer=N_src_drn $thickness=1e-09
+ $X=0.8813 $Y=0.0675 $X2=0.8785 $Y2=0.0675
r6 2 30 0.179012 $w=8.1e-08 $l=1.45e-08 $layer=N_src_drn $thickness=1e-09
+ $X=0.864 $Y=0.0675 $X2=0.8785 $Y2=0.0675
r7 11 2 0.179012 $w=8.1e-08 $l=1.45e-08 $layer=N_src_drn $thickness=1e-09
+ $X=0.8495 $Y=0.0675 $X2=0.864 $Y2=0.0675
r8 31 11 0.0308642 $w=8.1e-08 $l=2.5e-09 $layer=N_src_drn $thickness=1e-09
+ $X=0.8466 $Y=0.0675 $X2=0.8495 $Y2=0.0675
r9 3 27 19.3796 $a=3.24e-16 $layer=V0LISD $X=0.972 $Y=0.0675 $X2=0.972 $Y2=0.036
r10 2 21 19.3796 $a=3.24e-16 $layer=V0LISD $X=0.864 $Y=0.0675 $X2=0.8605
+ $Y2=0.036
r11 26 27 8.97781 $w=1.3e-08 $l=3.85e-08 $layer=M1 $thickness=3.6e-08 $X=0.9335
+ $Y=0.036 $X2=0.972 $Y2=0.036
r12 25 26 6.99569 $w=1.3e-08 $l=3e-08 $layer=M1 $thickness=3.6e-08 $X=0.9035
+ $Y=0.036 $X2=0.9335 $Y2=0.036
r13 24 25 2.2153 $w=1.3e-08 $l=9.5e-09 $layer=M1 $thickness=3.6e-08 $X=0.894
+ $Y=0.036 $X2=0.9035 $Y2=0.036
r14 23 24 3.49785 $w=1.3e-08 $l=1.5e-08 $layer=M1 $thickness=3.6e-08 $X=0.879
+ $Y=0.036 $X2=0.894 $Y2=0.036
r15 22 23 2.2153 $w=1.3e-08 $l=9.5e-09 $layer=M1 $thickness=3.6e-08 $X=0.8695
+ $Y=0.036 $X2=0.879 $Y2=0.036
r16 21 22 2.09871 $w=1.3e-08 $l=9e-09 $layer=M1 $thickness=3.6e-08 $X=0.8605
+ $Y=0.036 $X2=0.8695 $Y2=0.036
r17 20 21 4.89699 $w=1.3e-08 $l=2.1e-08 $layer=M1 $thickness=3.6e-08 $X=0.8395
+ $Y=0.036 $X2=0.8605 $Y2=0.036
r18 19 20 10.4935 $w=1.3e-08 $l=4.5e-08 $layer=M1 $thickness=3.6e-08 $X=0.7945
+ $Y=0.036 $X2=0.8395 $Y2=0.036
r19 18 19 8.97781 $w=1.3e-08 $l=3.85e-08 $layer=M1 $thickness=3.6e-08 $X=0.756
+ $Y=0.036 $X2=0.7945 $Y2=0.036
r20 13 18 2.68168 $w=1.3e-08 $l=1.15e-08 $layer=M1 $thickness=3.6e-08 $X=0.7445
+ $Y=0.036 $X2=0.756 $Y2=0.036
r21 1 18 19.3796 $a=3.24e-16 $layer=V0LISD $X=0.756 $Y=0.0675 $X2=0.756
+ $Y2=0.036
r22 17 15 0.0308642 $w=8.1e-08 $l=2.5e-09 $layer=N_src_drn $thickness=1e-09
+ $X=0.7733 $Y=0.0675 $X2=0.7705 $Y2=0.0675
r23 1 15 0.179012 $w=8.1e-08 $l=1.45e-08 $layer=N_src_drn $thickness=1e-09
+ $X=0.756 $Y=0.0675 $X2=0.7705 $Y2=0.0675
r24 10 1 0.179012 $w=8.1e-08 $l=1.45e-08 $layer=N_src_drn $thickness=1e-09
+ $X=0.7415 $Y=0.0675 $X2=0.756 $Y2=0.0675
r25 16 10 0.0308642 $w=8.1e-08 $l=2.5e-09 $layer=N_src_drn $thickness=1e-09
+ $X=0.7386 $Y=0.0675 $X2=0.7415 $Y2=0.0675
.ends

.subckt PM_NAND3x2_ASAP7_75t_R%A vss 49 18 34 38 41 65 68 71 76 1 2 13 14 15 7
+ 8 5 6 9 10 12 11
c1 1 vss 0.00466166f $X=0.081 $Y=0.135
c2 2 vss 0.00457487f $X=0.883 $Y=0.135
c3 5 vss 0.017581f $X=0.081 $Y=0.0245
c4 6 vss 0.0112681f $X=0.135 $Y=0.135
c5 7 vss 0.0444835f $X=0.189 $Y=0.135
c6 8 vss 0.0444835f $X=0.891 $Y=0.135
c7 9 vss 0.0112678f $X=0.945 $Y=0.135
c8 10 vss 0.017581f $X=0.999 $Y=0.135
c9 11 vss 0.00322897f $X=0.183 $Y=0.198
c10 12 vss 0.00320151f $X=0.894 $Y=0.198
c11 13 vss 0.00405252f $X=0.183 $Y=0.116
c12 14 vss 0.00354965f $X=0.894 $Y=0.117
c13 15 vss 0.0935768f $X=0.1715 $Y=0.189
r1 76 77 14.6259 $w=2.1e-08 $l=4.3e-08 $layer=Gate_1 $thickness=5.6e-08
+ $X=0.999 $Y=0.0675 $X2=0.999 $Y2=0.1105
r2 74 77 2.89117 $w=2.1e-08 $l=8.5e-09 $layer=Gate_1 $thickness=5.6e-08
+ $X=0.999 $Y=0.119 $X2=0.999 $Y2=0.1105
r3 10 62 6.74717 $w=2e-08 $layer=Gate_1 $thickness=5.2e-08 $X=0.999 $Y=0.135
+ $X2=0.999 $Y2=0.135
r4 10 74 5.61228 $w=2.0375e-08 $l=1.6e-08 $layer=Gate_1 $thickness=5.6e-08
+ $X=0.999 $Y=0.135 $X2=0.999 $Y2=0.119
r5 71 72 16.6668 $w=2.1e-08 $l=4.9e-08 $layer=Gate_1 $thickness=5.6e-08
+ $X=0.945 $Y=0.0675 $X2=0.945 $Y2=0.1165
r6 9 60 6.74717 $w=2e-08 $layer=Gate_1 $thickness=5.2e-08 $X=0.945 $Y=0.135
+ $X2=0.945 $Y2=0.135
r7 9 72 6.46262 $w=2.04595e-08 $l=1.85e-08 $layer=Gate_1 $thickness=5.6e-08
+ $X=0.945 $Y=0.135 $X2=0.945 $Y2=0.1165
r8 68 67 16.6668 $w=2.1e-08 $l=4.9e-08 $layer=Gate_1 $thickness=5.6e-08
+ $X=0.891 $Y=0.2025 $X2=0.891 $Y2=0.1535
r9 65 66 16.6668 $w=2.1e-08 $l=4.9e-08 $layer=Gate_1 $thickness=5.6e-08
+ $X=0.891 $Y=0.0675 $X2=0.891 $Y2=0.1165
r10 8 56 3.57145 $w=2e-08 $layer=Gate_1 $thickness=5.6e-08 $X=0.891 $Y=0.135
+ $X2=0.891 $Y2=0.135
r11 8 66 6.46262 $w=2.04595e-08 $l=1.85e-08 $layer=Gate_1 $thickness=5.6e-08
+ $X=0.891 $Y=0.135 $X2=0.891 $Y2=0.1165
r12 8 67 6.46262 $w=2.04595e-08 $l=1.85e-08 $layer=Gate_1 $thickness=5.6e-08
+ $X=0.891 $Y=0.135 $X2=0.891 $Y2=0.1535
r13 61 62 20.114 $w=1.57815e-08 $l=2.7e-08 $layer=LIG $thickness=4.8e-08
+ $X=0.972 $Y=0.135 $X2=0.999 $Y2=0.135
r14 60 61 20.114 $w=1.57815e-08 $l=2.7e-08 $layer=LIG $thickness=4.8e-08
+ $X=0.945 $Y=0.135 $X2=0.972 $Y2=0.135
r15 59 60 19.1176 $w=1.58769e-08 $l=2.6e-08 $layer=LIG $thickness=4.8e-08
+ $X=0.919 $Y=0.135 $X2=0.945 $Y2=0.135
r16 58 59 16.9382 $w=1.33e-08 $l=1.7e-08 $layer=LIG $thickness=4.8e-08 $X=0.902
+ $Y=0.135 $X2=0.919 $Y2=0.135
r17 55 56 2.54058 $w=2e-08 $l=2e-09 $layer=LIG $thickness=4.8e-08 $X=0.893
+ $Y=0.135 $X2=0.891 $Y2=0.135
r18 55 58 3.53695 $w=1.92556e-08 $l=9e-09 $layer=LIG $thickness=4.8e-08
+ $X=0.893 $Y=0.135 $X2=0.902 $Y2=0.135
r19 2 55 3.17572 $w=2e-08 $l=1e-08 $layer=LIG $thickness=4.8e-08 $X=0.883
+ $Y=0.135 $X2=0.893 $Y2=0.135
r20 53 54 5.24677 $w=1.3e-08 $l=2.25e-08 $layer=M1 $thickness=3.6e-08 $X=0.894
+ $Y=0.162 $X2=0.894 $Y2=0.1845
r21 52 53 6.29612 $w=1.3e-08 $l=2.7e-08 $layer=M1 $thickness=3.6e-08 $X=0.894
+ $Y=0.135 $X2=0.894 $Y2=0.162
r22 52 55 19.3796 $a=3.24e-16 $layer=V0LIG $X=0.894 $Y=0.135 $X2=0.893 $Y2=0.135
r23 14 52 4.19742 $w=1.3e-08 $l=1.8e-08 $layer=M1 $thickness=3.6e-08 $X=0.894
+ $Y=0.117 $X2=0.894 $Y2=0.135
r24 49 12 39.0693 $a=1.62e-16 $layer=V1 $X=0.894 $Y=0.192 $X2=0.894 $Y2=0.198
r25 12 54 1.96775 $w=1.63333e-08 $l=1.35e-08 $layer=M1 $thickness=3.6e-08
+ $X=0.894 $Y=0.198 $X2=0.894 $Y2=0.1845
r26 49 54 39.0693 $a=1.62e-16 $layer=V1 $X=0.894 $Y=0.192 $X2=0.894 $Y2=0.1845
r27 49 48 82.899 $w=1.3e-08 $l=3.555e-07 $layer=M2 $thickness=3.6e-08 $X=0.894
+ $Y=0.192 $X2=0.5385 $Y2=0.189
r28 47 48 82.899 $w=1.3e-08 $l=3.555e-07 $layer=M2 $thickness=3.6e-08 $X=0.183
+ $Y=0.189 $X2=0.5385 $Y2=0.189
r29 15 47 2.68168 $w=1.3e-08 $l=1.15e-08 $layer=M2 $thickness=3.6e-08 $X=0.1715
+ $Y=0.189 $X2=0.183 $Y2=0.189
r30 11 45 1.96775 $w=1.63333e-08 $l=1.35e-08 $layer=M1 $thickness=3.6e-08
+ $X=0.183 $Y=0.198 $X2=0.183 $Y2=0.1845
r31 11 47 39.0693 $a=1.62e-16 $layer=V1 $X=0.183 $Y=0.198 $X2=0.183 $Y2=0.189
r32 45 47 39.0693 $a=1.62e-16 $layer=V1 $X=0.183 $Y=0.1845 $X2=0.183 $Y2=0.189
r33 44 45 5.24677 $w=1.3e-08 $l=2.25e-08 $layer=M1 $thickness=3.6e-08 $X=0.183
+ $Y=0.162 $X2=0.183 $Y2=0.1845
r34 43 44 6.29612 $w=1.3e-08 $l=2.7e-08 $layer=M1 $thickness=3.6e-08 $X=0.183
+ $Y=0.135 $X2=0.183 $Y2=0.162
r35 13 43 4.43061 $w=1.3e-08 $l=1.9e-08 $layer=M1 $thickness=3.6e-08 $X=0.183
+ $Y=0.116 $X2=0.183 $Y2=0.135
r36 41 40 16.6668 $w=2.1e-08 $l=4.9e-08 $layer=Gate_1 $thickness=5.6e-08
+ $X=0.189 $Y=0.2025 $X2=0.189 $Y2=0.1535
r37 38 39 16.6668 $w=2.1e-08 $l=4.9e-08 $layer=Gate_1 $thickness=5.6e-08
+ $X=0.189 $Y=0.0675 $X2=0.189 $Y2=0.1165
r38 7 31 3.57145 $w=2e-08 $layer=Gate_1 $thickness=5.6e-08 $X=0.189 $Y=0.135
+ $X2=0.189 $Y2=0.135
r39 7 39 6.46262 $w=2.04595e-08 $l=1.85e-08 $layer=Gate_1 $thickness=5.6e-08
+ $X=0.189 $Y=0.135 $X2=0.189 $Y2=0.1165
r40 7 40 6.46262 $w=2.04595e-08 $l=1.85e-08 $layer=Gate_1 $thickness=5.6e-08
+ $X=0.189 $Y=0.135 $X2=0.189 $Y2=0.1535
r41 34 35 16.6668 $w=2.1e-08 $l=4.9e-08 $layer=Gate_1 $thickness=5.6e-08
+ $X=0.135 $Y=0.0675 $X2=0.135 $Y2=0.1165
r42 6 26 6.74717 $w=2e-08 $layer=Gate_1 $thickness=5.2e-08 $X=0.135 $Y=0.135
+ $X2=0.135 $Y2=0.135
r43 6 35 6.46262 $w=2.04595e-08 $l=1.85e-08 $layer=Gate_1 $thickness=5.6e-08
+ $X=0.135 $Y=0.135 $X2=0.135 $Y2=0.1165
r44 29 31 2.06422 $w=2e-08 $l=3.5e-09 $layer=LIG $thickness=4.8e-08 $X=0.1855
+ $Y=0.135 $X2=0.189 $Y2=0.135
r45 29 43 19.3796 $a=3.24e-16 $layer=V0LIG $X=0.1855 $Y=0.135 $X2=0.183
+ $Y2=0.135
r46 28 29 4.55514 $w=1.81389e-08 $l=9e-09 $layer=LIG $thickness=4.8e-08
+ $X=0.1765 $Y=0.135 $X2=0.1855 $Y2=0.135
r47 27 28 16.9382 $w=1.33e-08 $l=1.7e-08 $layer=LIG $thickness=4.8e-08
+ $X=0.1595 $Y=0.135 $X2=0.1765 $Y2=0.135
r48 26 27 17.6231 $w=1.60347e-08 $l=2.45e-08 $layer=LIG $thickness=4.8e-08
+ $X=0.135 $Y=0.135 $X2=0.1595 $Y2=0.135
r49 25 26 20.114 $w=1.57815e-08 $l=2.7e-08 $layer=LIG $thickness=4.8e-08
+ $X=0.108 $Y=0.135 $X2=0.135 $Y2=0.135
r50 1 21 6.74717 $w=2e-08 $layer=Gate_1 $thickness=5.2e-08 $X=0.081 $Y=0.135
+ $X2=0.081 $Y2=0.135
r51 1 25 20.114 $w=1.57815e-08 $l=2.7e-08 $layer=LIG $thickness=4.8e-08
+ $X=0.081 $Y=0.135 $X2=0.108 $Y2=0.135
r52 20 21 5.61228 $w=2.0375e-08 $l=1.6e-08 $layer=Gate_1 $thickness=5.6e-08
+ $X=0.081 $Y=0.119 $X2=0.081 $Y2=0.135
r53 19 20 2.89117 $w=2.1e-08 $l=8.5e-09 $layer=Gate_1 $thickness=5.6e-08
+ $X=0.081 $Y=0.1105 $X2=0.081 $Y2=0.119
r54 18 19 14.6259 $w=2.1e-08 $l=4.3e-08 $layer=Gate_1 $thickness=5.6e-08
+ $X=0.081 $Y=0.0675 $X2=0.081 $Y2=0.1105
r55 18 5 14.6259 $w=2.1e-08 $l=4.3e-08 $layer=Gate_1 $thickness=5.6e-08
+ $X=0.081 $Y=0.0675 $X2=0.081 $Y2=0.0245
.ends

.subckt PM_NAND3x2_ASAP7_75t_R%Y vss 86 43 55 56 75 78 79 82 83 90 97 100 101
+ 27 7 3 39 25 28 6 2 1 8 26 37 41 29 32 40 38 30 31 4 5
c1 1 vss 0.00507566f $X=0.054 $Y=0.0675
c2 2 vss 0.00288914f $X=0.162 $Y=0.0675
c3 3 vss 0.00667792f $X=0.162 $Y=0.2025
c4 4 vss 0.0089518f $X=0.378 $Y=0.2025
c5 5 vss 0.0089559f $X=0.702 $Y=0.2025
c6 6 vss 0.00289478f $X=0.918 $Y=0.0675
c7 7 vss 0.00668156f $X=0.918 $Y=0.2025
c8 8 vss 0.00507618f $X=1.026 $Y=0.0675
c9 25 vss 0.0359215f $X=0.056 $Y=0.0675
c10 26 vss 0.00206917f $X=0.1475 $Y=0.0675
c11 27 vss 0.00207199f $X=0.9035 $Y=0.0675
c12 28 vss 0.0359215f $X=1.0115 $Y=0.0675
c13 29 vss 0.00339844f $X=0.164 $Y=0.2025
c14 30 vss 0.00452832f $X=0.3635 $Y=0.2025
c15 31 vss 0.00452831f $X=0.6875 $Y=0.2025
c16 32 vss 0.00332814f $X=0.9035 $Y=0.2025
c17 33 vss 0.00134912f $X=0.027 $Y=0.072
c18 34 vss 0.0028023f $X=0.027 $Y=0.234
c19 35 vss 0.0013486f $X=1.053 $Y=0.072
c20 36 vss 0.00277923f $X=1.053 $Y=0.234
c21 37 vss 0.00440005f $X=0.027 $Y=0.0935
c22 38 vss 0.00190423f $X=0.0405 $Y=0.072
c23 39 vss 0.0851769f $X=0.0945 $Y=0.234
c24 40 vss 0.00227482f $X=1.0015 $Y=0.072
c25 41 vss 0.0043947f $X=1.053 $Y=0.216
r1 101 99 0.0308642 $w=8.1e-08 $l=2.5e-09 $layer=N_src_drn $thickness=1e-09
+ $X=0.9353 $Y=0.0675 $X2=0.9325 $Y2=0.0675
r2 6 99 0.179012 $w=8.1e-08 $l=1.45e-08 $layer=N_src_drn $thickness=1e-09
+ $X=0.918 $Y=0.0675 $X2=0.9325 $Y2=0.0675
r3 27 6 0.179012 $w=8.1e-08 $l=1.45e-08 $layer=N_src_drn $thickness=1e-09
+ $X=0.9035 $Y=0.0675 $X2=0.918 $Y2=0.0675
r4 100 27 0.0308642 $w=8.1e-08 $l=2.5e-09 $layer=N_src_drn $thickness=1e-09
+ $X=0.9006 $Y=0.0675 $X2=0.9035 $Y2=0.0675
r5 28 8 0.154321 $w=8.1e-08 $l=1.25e-08 $layer=N_src_drn $thickness=1e-09
+ $X=1.0115 $Y=0.0675 $X2=1.026 $Y2=0.0675
r6 97 28 0.0308642 $w=8.1e-08 $l=2.5e-09 $layer=N_src_drn $thickness=1e-09
+ $X=1.0086 $Y=0.0675 $X2=1.0115 $Y2=0.0675
r7 6 94 19.3796 $a=3.24e-16 $layer=V0LISD $X=0.918 $Y=0.0675 $X2=0.918 $Y2=0.072
r8 8 91 19.3796 $a=3.24e-16 $layer=V0LISD $X=1.026 $Y=0.0675 $X2=1.026 $Y2=0.072
r9 94 95 8.97781 $w=1.3e-08 $l=3.85e-08 $layer=M1 $thickness=3.6e-08 $X=0.918
+ $Y=0.072 $X2=0.9565 $Y2=0.072
r10 91 92 3.14806 $w=1.3e-08 $l=1.35e-08 $layer=M1 $thickness=3.6e-08 $X=1.026
+ $Y=0.072 $X2=1.0395 $Y2=0.072
r11 40 91 5.71315 $w=1.3e-08 $l=2.45e-08 $layer=M1 $thickness=3.6e-08 $X=1.0015
+ $Y=0.072 $X2=1.026 $Y2=0.072
r12 40 95 10.4935 $w=1.3e-08 $l=4.5e-08 $layer=M1 $thickness=3.6e-08 $X=1.0015
+ $Y=0.072 $X2=0.9565 $Y2=0.072
r13 35 88 3.59766 $w=1.692e-08 $l=2.25e-08 $layer=M1 $thickness=3.6e-08
+ $X=1.053 $Y=0.072 $X2=1.053 $Y2=0.0945
r14 35 92 1.49895 $w=1.63333e-08 $l=1.35e-08 $layer=M1 $thickness=3.6e-08
+ $X=1.053 $Y=0.072 $X2=1.0395 $Y2=0.072
r15 32 7 0.154321 $w=8.1e-08 $l=1.25e-08 $layer=P_src_drn $thickness=1e-09
+ $X=0.9035 $Y=0.2025 $X2=0.918 $Y2=0.2025
r16 90 32 0.0308642 $w=8.1e-08 $l=2.5e-09 $layer=P_src_drn $thickness=1e-09
+ $X=0.9006 $Y=0.2025 $X2=0.9035 $Y2=0.2025
r17 86 87 5.42166 $w=1.3e-08 $l=2.32e-08 $layer=M1 $thickness=3.6e-08 $X=1.052
+ $Y=0.143 $X2=1.053 $Y2=0.1662
r18 86 85 4.13912 $w=1.3e-08 $l=1.78e-08 $layer=M1 $thickness=3.6e-08 $X=1.052
+ $Y=0.143 $X2=1.053 $Y2=0.1252
r19 85 88 7.17059 $w=1.3e-08 $l=3.07e-08 $layer=M1 $thickness=3.6e-08 $X=1.053
+ $Y=0.1252 $X2=1.053 $Y2=0.0945
r20 84 87 7.40378 $w=1.3e-08 $l=3.18e-08 $layer=M1 $thickness=3.6e-08 $X=1.053
+ $Y=0.198 $X2=1.053 $Y2=0.1662
r21 41 84 4.19742 $w=1.3e-08 $l=1.8e-08 $layer=M1 $thickness=3.6e-08 $X=1.053
+ $Y=0.216 $X2=1.053 $Y2=0.198
r22 83 81 0.0308642 $w=8.1e-08 $l=2.5e-09 $layer=P_src_drn $thickness=1e-09
+ $X=0.7193 $Y=0.2025 $X2=0.7165 $Y2=0.2025
r23 5 81 0.179012 $w=8.1e-08 $l=1.45e-08 $layer=P_src_drn $thickness=1e-09
+ $X=0.702 $Y=0.2025 $X2=0.7165 $Y2=0.2025
r24 31 5 0.179012 $w=8.1e-08 $l=1.45e-08 $layer=P_src_drn $thickness=1e-09
+ $X=0.6875 $Y=0.2025 $X2=0.702 $Y2=0.2025
r25 82 31 0.0308642 $w=8.1e-08 $l=2.5e-09 $layer=P_src_drn $thickness=1e-09
+ $X=0.6846 $Y=0.2025 $X2=0.6875 $Y2=0.2025
r26 79 77 0.0308642 $w=8.1e-08 $l=2.5e-09 $layer=P_src_drn $thickness=1e-09
+ $X=0.3953 $Y=0.2025 $X2=0.3925 $Y2=0.2025
r27 4 77 0.179012 $w=8.1e-08 $l=1.45e-08 $layer=P_src_drn $thickness=1e-09
+ $X=0.378 $Y=0.2025 $X2=0.3925 $Y2=0.2025
r28 30 4 0.179012 $w=8.1e-08 $l=1.45e-08 $layer=P_src_drn $thickness=1e-09
+ $X=0.3635 $Y=0.2025 $X2=0.378 $Y2=0.2025
r29 78 30 0.0308642 $w=8.1e-08 $l=2.5e-09 $layer=P_src_drn $thickness=1e-09
+ $X=0.3606 $Y=0.2025 $X2=0.3635 $Y2=0.2025
r30 75 74 0.0308642 $w=8.1e-08 $l=2.5e-09 $layer=P_src_drn $thickness=1e-09
+ $X=0.1793 $Y=0.2025 $X2=0.1765 $Y2=0.2025
r31 29 74 0.154321 $w=8.1e-08 $l=1.25e-08 $layer=P_src_drn $thickness=1e-09
+ $X=0.164 $Y=0.2025 $X2=0.1765 $Y2=0.2025
r32 7 72 19.3796 $a=3.24e-16 $layer=V0LISD $X=0.918 $Y=0.2025 $X2=0.918
+ $Y2=0.234
r33 36 73 14.0912 $w=1.36667e-08 $l=6.75e-08 $layer=M1 $thickness=3.6e-08
+ $X=1.053 $Y=0.234 $X2=0.9855 $Y2=0.234
r34 36 41 2.5483 $w=1.79e-08 $l=1.8e-08 $layer=M1 $thickness=3.6e-08 $X=1.053
+ $Y=0.234 $X2=1.053 $Y2=0.216
r35 5 65 19.3796 $a=3.24e-16 $layer=V0LISD $X=0.702 $Y=0.2025 $X2=0.702
+ $Y2=0.234
r36 4 63 19.3796 $a=3.24e-16 $layer=V0LISD $X=0.378 $Y=0.2025 $X2=0.378
+ $Y2=0.234
r37 3 57 19.3796 $a=3.24e-16 $layer=V0LISD $X=0.162 $Y=0.2025 $X2=0.162
+ $Y2=0.234
r38 72 73 15.7403 $w=1.3e-08 $l=6.75e-08 $layer=M1 $thickness=3.6e-08 $X=0.918
+ $Y=0.234 $X2=0.9855 $Y2=0.234
r39 71 72 2.68168 $w=1.3e-08 $l=1.15e-08 $layer=M1 $thickness=3.6e-08 $X=0.9065
+ $Y=0.234 $X2=0.918 $Y2=0.234
r40 70 71 0.699569 $w=1.3e-08 $l=3e-09 $layer=M1 $thickness=3.6e-08 $X=0.9035
+ $Y=0.234 $X2=0.9065 $Y2=0.234
r41 69 70 4.43061 $w=1.3e-08 $l=1.9e-08 $layer=M1 $thickness=3.6e-08 $X=0.8845
+ $Y=0.234 $X2=0.9035 $Y2=0.234
r42 68 69 9.211 $w=1.3e-08 $l=3.95e-08 $layer=M1 $thickness=3.6e-08 $X=0.845
+ $Y=0.234 $X2=0.8845 $Y2=0.234
r43 67 68 14.3412 $w=1.3e-08 $l=6.15e-08 $layer=M1 $thickness=3.6e-08 $X=0.7835
+ $Y=0.234 $X2=0.845 $Y2=0.234
r44 66 67 13.1752 $w=1.3e-08 $l=5.65e-08 $layer=M1 $thickness=3.6e-08 $X=0.727
+ $Y=0.234 $X2=0.7835 $Y2=0.234
r45 65 66 5.82974 $w=1.3e-08 $l=2.5e-08 $layer=M1 $thickness=3.6e-08 $X=0.702
+ $Y=0.234 $X2=0.727 $Y2=0.234
r46 64 65 37.7767 $w=1.3e-08 $l=1.62e-07 $layer=M1 $thickness=3.6e-08 $X=0.54
+ $Y=0.234 $X2=0.702 $Y2=0.234
r47 63 64 37.7767 $w=1.3e-08 $l=1.62e-07 $layer=M1 $thickness=3.6e-08 $X=0.378
+ $Y=0.234 $X2=0.54 $Y2=0.234
r48 62 63 5.71315 $w=1.3e-08 $l=2.45e-08 $layer=M1 $thickness=3.6e-08 $X=0.3535
+ $Y=0.234 $X2=0.378 $Y2=0.234
r49 61 62 13.1752 $w=1.3e-08 $l=5.65e-08 $layer=M1 $thickness=3.6e-08 $X=0.297
+ $Y=0.234 $X2=0.3535 $Y2=0.234
r50 60 61 14.8076 $w=1.3e-08 $l=6.35e-08 $layer=M1 $thickness=3.6e-08 $X=0.2335
+ $Y=0.234 $X2=0.297 $Y2=0.234
r51 59 60 9.56078 $w=1.3e-08 $l=4.1e-08 $layer=M1 $thickness=3.6e-08 $X=0.1925
+ $Y=0.234 $X2=0.2335 $Y2=0.234
r52 58 59 4.6638 $w=1.3e-08 $l=2e-08 $layer=M1 $thickness=3.6e-08 $X=0.1725
+ $Y=0.234 $X2=0.1925 $Y2=0.234
r53 57 58 2.44849 $w=1.3e-08 $l=1.05e-08 $layer=M1 $thickness=3.6e-08 $X=0.162
+ $Y=0.234 $X2=0.1725 $Y2=0.234
r54 39 57 15.7403 $w=1.3e-08 $l=6.75e-08 $layer=M1 $thickness=3.6e-08 $X=0.0945
+ $Y=0.234 $X2=0.162 $Y2=0.234
r55 34 52 2.5483 $w=1.79e-08 $l=1.8e-08 $layer=M1 $thickness=3.6e-08 $X=0.027
+ $Y=0.234 $X2=0.027 $Y2=0.216
r56 34 39 14.0912 $w=1.36667e-08 $l=6.75e-08 $layer=M1 $thickness=3.6e-08
+ $X=0.027 $Y=0.234 $X2=0.0945 $Y2=0.234
r57 56 54 0.0308642 $w=8.1e-08 $l=2.5e-09 $layer=N_src_drn $thickness=1e-09
+ $X=0.1793 $Y=0.0675 $X2=0.1765 $Y2=0.0675
r58 2 54 0.179012 $w=8.1e-08 $l=1.45e-08 $layer=N_src_drn $thickness=1e-09
+ $X=0.162 $Y=0.0675 $X2=0.1765 $Y2=0.0675
r59 26 2 0.179012 $w=8.1e-08 $l=1.45e-08 $layer=N_src_drn $thickness=1e-09
+ $X=0.1475 $Y=0.0675 $X2=0.162 $Y2=0.0675
r60 55 26 0.0308642 $w=8.1e-08 $l=2.5e-09 $layer=N_src_drn $thickness=1e-09
+ $X=0.1446 $Y=0.0675 $X2=0.1475 $Y2=0.0675
r61 51 52 4.19742 $w=1.3e-08 $l=1.8e-08 $layer=M1 $thickness=3.6e-08 $X=0.027
+ $Y=0.198 $X2=0.027 $Y2=0.216
r62 50 51 11.7761 $w=1.3e-08 $l=5.05e-08 $layer=M1 $thickness=3.6e-08 $X=0.027
+ $Y=0.1475 $X2=0.027 $Y2=0.198
r63 37 50 12.5922 $w=1.3e-08 $l=5.4e-08 $layer=M1 $thickness=3.6e-08 $X=0.027
+ $Y=0.0935 $X2=0.027 $Y2=0.1475
r64 2 47 19.3796 $a=3.24e-16 $layer=V0LISD $X=0.162 $Y=0.0675 $X2=0.162
+ $Y2=0.072
r65 33 38 1.49895 $w=1.63333e-08 $l=1.35e-08 $layer=M1 $thickness=3.6e-08
+ $X=0.027 $Y=0.072 $X2=0.0405 $Y2=0.072
r66 33 37 3.36447 $w=1.71023e-08 $l=2.15e-08 $layer=M1 $thickness=3.6e-08
+ $X=0.027 $Y=0.072 $X2=0.027 $Y2=0.0935
r67 46 47 8.97781 $w=1.3e-08 $l=3.85e-08 $layer=M1 $thickness=3.6e-08 $X=0.1235
+ $Y=0.072 $X2=0.162 $Y2=0.072
r68 45 46 10.4935 $w=1.3e-08 $l=4.5e-08 $layer=M1 $thickness=3.6e-08 $X=0.0785
+ $Y=0.072 $X2=0.1235 $Y2=0.072
r69 44 45 5.71315 $w=1.3e-08 $l=2.45e-08 $layer=M1 $thickness=3.6e-08 $X=0.054
+ $Y=0.072 $X2=0.0785 $Y2=0.072
r70 38 44 3.14806 $w=1.3e-08 $l=1.35e-08 $layer=M1 $thickness=3.6e-08 $X=0.0405
+ $Y=0.072 $X2=0.054 $Y2=0.072
r71 1 44 19.3796 $a=3.24e-16 $layer=V0LISD $X=0.054 $Y=0.0675 $X2=0.054
+ $Y2=0.072
r72 43 42 0.0308642 $w=8.1e-08 $l=2.5e-09 $layer=N_src_drn $thickness=1e-09
+ $X=0.0713 $Y=0.0675 $X2=0.0685 $Y2=0.0675
r73 25 42 0.154321 $w=8.1e-08 $l=1.25e-08 $layer=N_src_drn $thickness=1e-09
+ $X=0.056 $Y=0.0675 $X2=0.0685 $Y2=0.0675
r74 3 29 1e-05 $l=2e-09 $X=0.162 $Y=0.2025 $X2=0.164 $Y2=0.2025
r75 1 25 1e-05 $l=2e-09 $X=0.054 $Y=0.0675 $X2=0.056 $Y2=0.0675
.ends

.subckt PM_NAND3x2_ASAP7_75t_R%B vss 45 16 20 35 39 57 61 65 68 1 2 11 12 15 5
+ 10 13 14 7 8 6 9
c1 1 vss 0.0197046f $X=0.3225 $Y=0.135
c2 2 vss 0.0196611f $X=0.722 $Y=0.135
c3 5 vss 0.0528609f $X=0.243 $Y=0.135
c4 6 vss 0.0528628f $X=0.297 $Y=0.135
c5 7 vss 0.0499213f $X=0.351 $Y=0.135
c6 8 vss 0.0499213f $X=0.729 $Y=0.0245
c7 9 vss 0.0528683f $X=0.783 $Y=0.135
c8 10 vss 0.0528599f $X=0.837 $Y=0.135
c9 11 vss 0.00687118f $X=0.347 $Y=0.198
c10 12 vss 0.00688f $X=0.734 $Y=0.198
c11 13 vss 0.00760695f $X=0.347 $Y=0.1765
c12 14 vss 0.0134721f $X=0.645 $Y=0.198
c13 15 vss 0.00773518f $X=0.734 $Y=0.107
r1 68 67 16.6668 $w=2.1e-08 $l=4.9e-08 $layer=Gate_1 $thickness=5.6e-08
+ $X=0.351 $Y=0.2025 $X2=0.351 $Y2=0.1535
r2 65 66 16.6668 $w=2.1e-08 $l=4.9e-08 $layer=Gate_1 $thickness=5.6e-08
+ $X=0.351 $Y=0.0675 $X2=0.351 $Y2=0.1165
r3 7 54 3.57145 $w=2e-08 $layer=Gate_1 $thickness=5.6e-08 $X=0.351 $Y=0.135
+ $X2=0.351 $Y2=0.135
r4 7 66 6.46262 $w=2.04595e-08 $l=1.85e-08 $layer=Gate_1 $thickness=5.6e-08
+ $X=0.351 $Y=0.135 $X2=0.351 $Y2=0.1165
r5 7 67 6.46262 $w=2.04595e-08 $l=1.85e-08 $layer=Gate_1 $thickness=5.6e-08
+ $X=0.351 $Y=0.135 $X2=0.351 $Y2=0.1535
r6 61 62 16.6668 $w=2.1e-08 $l=4.9e-08 $layer=Gate_1 $thickness=5.6e-08
+ $X=0.243 $Y=0.0675 $X2=0.243 $Y2=0.1165
r7 5 50 6.74717 $w=2e-08 $layer=Gate_1 $thickness=5.2e-08 $X=0.243 $Y=0.135
+ $X2=0.243 $Y2=0.135
r8 5 62 6.46262 $w=2.04595e-08 $l=1.85e-08 $layer=Gate_1 $thickness=5.6e-08
+ $X=0.243 $Y=0.135 $X2=0.243 $Y2=0.1165
r9 57 58 16.6668 $w=2.1e-08 $l=4.9e-08 $layer=Gate_1 $thickness=5.6e-08
+ $X=0.297 $Y=0.0675 $X2=0.297 $Y2=0.1165
r10 6 48 6.74717 $w=2e-08 $layer=Gate_1 $thickness=5.2e-08 $X=0.297 $Y=0.135
+ $X2=0.297 $Y2=0.135
r11 6 58 6.46262 $w=2.04595e-08 $l=1.85e-08 $layer=Gate_1 $thickness=5.6e-08
+ $X=0.297 $Y=0.135 $X2=0.297 $Y2=0.1165
r12 52 54 2.38179 $w=2e-08 $l=2.5e-09 $layer=LIG $thickness=4.8e-08 $X=0.3485
+ $Y=0.135 $X2=0.351 $Y2=0.135
r13 49 50 20.114 $w=1.57815e-08 $l=2.7e-08 $layer=LIG $thickness=4.8e-08
+ $X=0.27 $Y=0.135 $X2=0.243 $Y2=0.135
r14 48 49 20.114 $w=1.57815e-08 $l=2.7e-08 $layer=LIG $thickness=4.8e-08
+ $X=0.297 $Y=0.135 $X2=0.27 $Y2=0.135
r15 47 52 3.87634 $w=1.88833e-08 $l=9e-09 $layer=LIG $thickness=4.8e-08
+ $X=0.3395 $Y=0.135 $X2=0.3485 $Y2=0.135
r16 1 47 16.9382 $w=1.33e-08 $l=1.7e-08 $layer=LIG $thickness=4.8e-08 $X=0.3225
+ $Y=0.135 $X2=0.3395 $Y2=0.135
r17 1 48 18.6194 $w=1.59275e-08 $l=2.55e-08 $layer=LIG $thickness=4.8e-08
+ $X=0.3225 $Y=0.135 $X2=0.297 $Y2=0.135
r18 45 46 4.43061 $w=1.3e-08 $l=1.9e-08 $layer=M1 $thickness=3.6e-08 $X=0.348
+ $Y=0.137 $X2=0.347 $Y2=0.154
r19 45 52 19.3796 $a=3.24e-16 $layer=V0LIG $X=0.348 $Y=0.137 $X2=0.3485
+ $Y2=0.135
r20 13 46 5.24677 $w=1.3e-08 $l=2.25e-08 $layer=M1 $thickness=3.6e-08 $X=0.347
+ $Y=0.1765 $X2=0.347 $Y2=0.154
r21 11 43 22.7192 $w=1.34306e-08 $l=1.045e-07 $layer=M1 $thickness=3.6e-08
+ $X=0.347 $Y=0.198 $X2=0.4515 $Y2=0.198
r22 11 13 3.36447 $w=1.71023e-08 $l=2.15e-08 $layer=M1 $thickness=3.6e-08
+ $X=0.347 $Y=0.198 $X2=0.347 $Y2=0.1765
r23 42 43 24.3683 $w=1.3e-08 $l=1.045e-07 $layer=M1 $thickness=3.6e-08 $X=0.556
+ $Y=0.198 $X2=0.4515 $Y2=0.198
r24 14 42 20.7539 $w=1.3e-08 $l=8.9e-08 $layer=M1 $thickness=3.6e-08 $X=0.645
+ $Y=0.198 $X2=0.556 $Y2=0.198
r25 12 33 3.36447 $w=1.71023e-08 $l=2.15e-08 $layer=M1 $thickness=3.6e-08
+ $X=0.734 $Y=0.198 $X2=0.734 $Y2=0.1765
r26 12 14 19.1048 $w=1.35056e-08 $l=8.9e-08 $layer=M1 $thickness=3.6e-08
+ $X=0.734 $Y=0.198 $X2=0.645 $Y2=0.198
r27 39 40 16.6668 $w=2.1e-08 $l=4.9e-08 $layer=Gate_1 $thickness=5.6e-08
+ $X=0.837 $Y=0.0675 $X2=0.837 $Y2=0.1165
r28 10 28 6.74717 $w=2e-08 $layer=Gate_1 $thickness=5.2e-08 $X=0.837 $Y=0.135
+ $X2=0.837 $Y2=0.135
r29 10 40 6.46262 $w=2.04595e-08 $l=1.85e-08 $layer=Gate_1 $thickness=5.6e-08
+ $X=0.837 $Y=0.135 $X2=0.837 $Y2=0.1165
r30 35 36 16.6668 $w=2.1e-08 $l=4.9e-08 $layer=Gate_1 $thickness=5.6e-08
+ $X=0.783 $Y=0.0675 $X2=0.783 $Y2=0.1165
r31 9 26 6.74717 $w=2e-08 $layer=Gate_1 $thickness=5.2e-08 $X=0.783 $Y=0.135
+ $X2=0.783 $Y2=0.135
r32 9 36 6.46262 $w=2.04595e-08 $l=1.85e-08 $layer=Gate_1 $thickness=5.6e-08
+ $X=0.783 $Y=0.135 $X2=0.783 $Y2=0.1165
r33 32 33 5.24677 $w=1.3e-08 $l=2.25e-08 $layer=M1 $thickness=3.6e-08 $X=0.734
+ $Y=0.154 $X2=0.734 $Y2=0.1765
r34 31 32 4.43061 $w=1.3e-08 $l=1.9e-08 $layer=M1 $thickness=3.6e-08 $X=0.734
+ $Y=0.135 $X2=0.734 $Y2=0.154
r35 30 31 4.19742 $w=1.3e-08 $l=1.8e-08 $layer=M1 $thickness=3.6e-08 $X=0.734
+ $Y=0.117 $X2=0.734 $Y2=0.135
r36 15 30 2.3319 $w=1.3e-08 $l=1e-08 $layer=M1 $thickness=3.6e-08 $X=0.734
+ $Y=0.107 $X2=0.734 $Y2=0.117
r37 27 28 20.114 $w=1.57815e-08 $l=2.7e-08 $layer=LIG $thickness=4.8e-08
+ $X=0.81 $Y=0.135 $X2=0.837 $Y2=0.135
r38 26 27 20.114 $w=1.57815e-08 $l=2.7e-08 $layer=LIG $thickness=4.8e-08
+ $X=0.783 $Y=0.135 $X2=0.81 $Y2=0.135
r39 25 26 18.1212 $w=1.598e-08 $l=2.5e-08 $layer=LIG $thickness=4.8e-08
+ $X=0.758 $Y=0.135 $X2=0.783 $Y2=0.135
r40 24 25 16.9382 $w=1.33e-08 $l=1.7e-08 $layer=LIG $thickness=4.8e-08 $X=0.741
+ $Y=0.135 $X2=0.758 $Y2=0.135
r41 22 24 4.21574 $w=1.85111e-08 $l=9e-09 $layer=LIG $thickness=4.8e-08
+ $X=0.732 $Y=0.135 $X2=0.741 $Y2=0.135
r42 22 31 19.3796 $a=3.24e-16 $layer=V0LIG $X=0.732 $Y=0.135 $X2=0.734 $Y2=0.135
r43 2 22 3.17572 $w=2e-08 $l=1e-08 $layer=LIG $thickness=4.8e-08 $X=0.722
+ $Y=0.135 $X2=0.732 $Y2=0.135
r44 20 19 16.6668 $w=2.1e-08 $l=4.9e-08 $layer=Gate_1 $thickness=5.6e-08
+ $X=0.729 $Y=0.2025 $X2=0.729 $Y2=0.1535
r45 18 19 6.46262 $w=2.04595e-08 $l=1.85e-08 $layer=Gate_1 $thickness=5.6e-08
+ $X=0.729 $Y=0.135 $X2=0.729 $Y2=0.1535
r46 18 22 5.79446 $w=2e-08 $l=3e-09 $layer=Gate_1 $thickness=5.27059e-08
+ $X=0.729 $Y=0.135 $X2=0.732 $Y2=0.135
r47 17 18 6.46262 $w=2.04595e-08 $l=1.85e-08 $layer=Gate_1 $thickness=5.6e-08
+ $X=0.729 $Y=0.1165 $X2=0.729 $Y2=0.135
r48 16 17 16.6668 $w=2.1e-08 $l=4.9e-08 $layer=Gate_1 $thickness=5.6e-08
+ $X=0.729 $Y=0.0675 $X2=0.729 $Y2=0.1165
r49 16 8 14.6259 $w=2.1e-08 $l=4.3e-08 $layer=Gate_1 $thickness=5.6e-08
+ $X=0.729 $Y=0.0675 $X2=0.729 $Y2=0.0245
.ends

.subckt PM_NAND3x2_ASAP7_75t_R%6__2 vss 16 17 30 31 34 35 10 2 1 11 12 3 13
c1 1 vss 0.00398699f $X=0.108 $Y=0.0675
c2 2 vss 0.00383839f $X=0.216 $Y=0.0675
c3 3 vss 0.00406227f $X=0.324 $Y=0.0675
c4 10 vss 0.00187075f $X=0.0935 $Y=0.0675
c5 11 vss 0.00188395f $X=0.2015 $Y=0.0675
c6 12 vss 0.00185713f $X=0.3095 $Y=0.0675
c7 13 vss 0.0181489f $X=0.0965 $Y=0.036
r1 35 33 0.0308642 $w=8.1e-08 $l=2.5e-09 $layer=N_src_drn $thickness=1e-09
+ $X=0.3413 $Y=0.0675 $X2=0.3385 $Y2=0.0675
r2 3 33 0.179012 $w=8.1e-08 $l=1.45e-08 $layer=N_src_drn $thickness=1e-09
+ $X=0.324 $Y=0.0675 $X2=0.3385 $Y2=0.0675
r3 12 3 0.179012 $w=8.1e-08 $l=1.45e-08 $layer=N_src_drn $thickness=1e-09
+ $X=0.3095 $Y=0.0675 $X2=0.324 $Y2=0.0675
r4 34 12 0.0308642 $w=8.1e-08 $l=2.5e-09 $layer=N_src_drn $thickness=1e-09
+ $X=0.3066 $Y=0.0675 $X2=0.3095 $Y2=0.0675
r5 31 29 0.0308642 $w=8.1e-08 $l=2.5e-09 $layer=N_src_drn $thickness=1e-09
+ $X=0.2333 $Y=0.0675 $X2=0.2305 $Y2=0.0675
r6 2 29 0.179012 $w=8.1e-08 $l=1.45e-08 $layer=N_src_drn $thickness=1e-09
+ $X=0.216 $Y=0.0675 $X2=0.2305 $Y2=0.0675
r7 11 2 0.179012 $w=8.1e-08 $l=1.45e-08 $layer=N_src_drn $thickness=1e-09
+ $X=0.2015 $Y=0.0675 $X2=0.216 $Y2=0.0675
r8 30 11 0.0308642 $w=8.1e-08 $l=2.5e-09 $layer=N_src_drn $thickness=1e-09
+ $X=0.1986 $Y=0.0675 $X2=0.2015 $Y2=0.0675
r9 3 26 19.3796 $a=3.24e-16 $layer=V0LISD $X=0.324 $Y=0.0675 $X2=0.324 $Y2=0.036
r10 2 23 19.3796 $a=3.24e-16 $layer=V0LISD $X=0.216 $Y=0.0675 $X2=0.218
+ $Y2=0.036
r11 25 26 8.97781 $w=1.3e-08 $l=3.85e-08 $layer=M1 $thickness=3.6e-08 $X=0.2855
+ $Y=0.036 $X2=0.324 $Y2=0.036
r12 24 25 10.4935 $w=1.3e-08 $l=4.5e-08 $layer=M1 $thickness=3.6e-08 $X=0.2405
+ $Y=0.036 $X2=0.2855 $Y2=0.036
r13 23 24 5.24677 $w=1.3e-08 $l=2.25e-08 $layer=M1 $thickness=3.6e-08 $X=0.218
+ $Y=0.036 $X2=0.2405 $Y2=0.036
r14 22 23 2.09871 $w=1.3e-08 $l=9e-09 $layer=M1 $thickness=3.6e-08 $X=0.209
+ $Y=0.036 $X2=0.218 $Y2=0.036
r15 21 22 2.2153 $w=1.3e-08 $l=9.5e-09 $layer=M1 $thickness=3.6e-08 $X=0.1995
+ $Y=0.036 $X2=0.209 $Y2=0.036
r16 20 21 3.61444 $w=1.3e-08 $l=1.55e-08 $layer=M1 $thickness=3.6e-08 $X=0.184
+ $Y=0.036 $X2=0.1995 $Y2=0.036
r17 19 20 8.74462 $w=1.3e-08 $l=3.75e-08 $layer=M1 $thickness=3.6e-08 $X=0.1465
+ $Y=0.036 $X2=0.184 $Y2=0.036
r18 18 19 8.97781 $w=1.3e-08 $l=3.85e-08 $layer=M1 $thickness=3.6e-08 $X=0.108
+ $Y=0.036 $X2=0.1465 $Y2=0.036
r19 13 18 2.68168 $w=1.3e-08 $l=1.15e-08 $layer=M1 $thickness=3.6e-08 $X=0.0965
+ $Y=0.036 $X2=0.108 $Y2=0.036
r20 1 18 19.3796 $a=3.24e-16 $layer=V0LISD $X=0.108 $Y=0.0675 $X2=0.108
+ $Y2=0.036
r21 17 15 0.0308642 $w=8.1e-08 $l=2.5e-09 $layer=N_src_drn $thickness=1e-09
+ $X=0.1253 $Y=0.0675 $X2=0.1225 $Y2=0.0675
r22 1 15 0.179012 $w=8.1e-08 $l=1.45e-08 $layer=N_src_drn $thickness=1e-09
+ $X=0.108 $Y=0.0675 $X2=0.1225 $Y2=0.0675
r23 10 1 0.179012 $w=8.1e-08 $l=1.45e-08 $layer=N_src_drn $thickness=1e-09
+ $X=0.0935 $Y=0.0675 $X2=0.108 $Y2=0.0675
r24 16 10 0.0308642 $w=8.1e-08 $l=2.5e-09 $layer=N_src_drn $thickness=1e-09
+ $X=0.0906 $Y=0.0675 $X2=0.0935 $Y2=0.0675
.ends

* End of included file NAND3x2_ASAP7_75t_R.pex.sp.pex

*
.subckt NAND3x2_ASAP7_75t_CUSTOM_4_25_0_7 VSS VDD A B C Y
*
* VSS VSS
* VDD VDD
* A A
* B B
* C C
* Y Y
*
*

M0 N_M0_d N_M0_g N_M0_s VSS nmos_rvt L=2e-08 W=8.1e-08 nfin=3 $X=0.071 $Y=0.027
M1 N_M1_d N_M1_g N_M1_s VSS nmos_rvt L=2e-08 W=8.1e-08 nfin=3 $X=0.125 $Y=0.027
M2 N_M2_d N_M2_g N_M2_s VSS nmos_rvt L=2e-08 W=8.1e-08 nfin=3 $X=0.179 $Y=0.027
M3 N_M3_d N_M3_g N_M3_s VSS nmos_rvt L=2e-08 W=8.1e-08 nfin=3 $X=0.233 $Y=0.027
M4 N_M4_d N_M4_g N_M4_s VSS nmos_rvt L=2e-08 W=8.1e-08 nfin=3 $X=0.287 $Y=0.027
M5 N_M5_d N_M5_g N_M5_s VSS nmos_rvt L=2e-08 W=8.1e-08 nfin=3 $X=0.341 $Y=0.027
M6 VSS N_M6_g N_M6_s VSS nmos_rvt L=2e-08 W=8.1e-08 nfin=3 $X=0.395 $Y=0.027
M7 VSS N_M7_g N_M7_s VSS nmos_rvt L=2e-08 W=8.1e-08 nfin=3 $X=0.449 $Y=0.027
M8 VSS N_M8_g N_M8_s VSS nmos_rvt L=2e-08 W=8.1e-08 nfin=3 $X=0.503 $Y=0.027
M9 VSS N_M9_g N_M9_s VSS nmos_rvt L=2e-08 W=8.1e-08 nfin=3 $X=0.557 $Y=0.027
M10 VSS N_M10_g N_M10_s VSS nmos_rvt L=2e-08 W=8.1e-08 nfin=3 $X=0.611 $Y=0.027
M11 VSS N_M11_g N_M11_s VSS nmos_rvt L=2e-08 W=8.1e-08 nfin=3 $X=0.665 $Y=0.027
M12 N_M12_d N_M12_g N_M12_s VSS nmos_rvt L=2e-08 W=8.1e-08 nfin=3 $X=0.719
+ $Y=0.027
M13 N_M13_d N_M13_g N_M13_s VSS nmos_rvt L=2e-08 W=8.1e-08 nfin=3 $X=0.773
+ $Y=0.027
M14 N_M14_d N_M14_g N_M14_s VSS nmos_rvt L=2e-08 W=8.1e-08 nfin=3 $X=0.827
+ $Y=0.027
M15 N_M15_d N_M15_g N_M15_s VSS nmos_rvt L=2e-08 W=8.1e-08 nfin=3 $X=0.881
+ $Y=0.027
M16 N_M16_d N_M16_g N_M16_s VSS nmos_rvt L=2e-08 W=8.1e-08 nfin=3 $X=0.935
+ $Y=0.027
M17 N_M17_d N_M17_g N_M17_s VSS nmos_rvt L=2e-08 W=8.1e-08 nfin=3 $X=0.989
+ $Y=0.027
M18 VDD N_M18_g N_M18_s VDD pmos_rvt L=2e-08 W=8.1e-08 nfin=3 $X=0.179 $Y=0.162
M19 N_M19_d N_M19_g VDD VDD pmos_rvt L=2e-08 W=8.1e-08 nfin=3 $X=0.341 $Y=0.162
M20 VDD N_M20_g N_M20_s VDD pmos_rvt L=2e-08 W=8.1e-08 nfin=3 $X=0.395 $Y=0.162
M21 VDD N_M21_g N_M21_s VDD pmos_rvt L=2e-08 W=8.1e-08 nfin=3 $X=0.665 $Y=0.162
M22 N_M22_d N_M22_g VDD VDD pmos_rvt L=2e-08 W=8.1e-08 nfin=3 $X=0.719 $Y=0.162
M23 VDD N_M23_g N_M23_s VDD pmos_rvt L=2e-08 W=8.1e-08 nfin=3 $X=0.881 $Y=0.162

* .include "NAND3x2_ASAP7_75t_R.pex.sp.pxi"

* Start of included file NAND3x2_ASAP7_75t_R.pex.sp.pxi
x_PM_NAND3x2_ASAP7_75t_R%7 vss N_M10_s N_M9_s N_M7_s N_M8_s N_M5_s N_M6_s
+ N_M3_s N_M4_s N_M11_s N_M12_s N_M13_s N_M14_s N_7_25 N_7_19 N_7_2 N_7_5
+ N_7_23 N_7_20 N_7_4 N_7_24 N_7_6 N_7_1 N_7_21 N_7_22 N_7_3
+ PM_NAND3x2_ASAP7_75t_R%7
cc_1 N_7_25 N_A_14 0.000313569f $X=0.556 $Y=0.072
cc_2 N_7_25 N_A_2 0.000120362f $X=0.556 $Y=0.072
cc_3 N_7_25 N_A_8 0.000151017f $X=0.556 $Y=0.072
cc_4 N_7_25 N_A_7 0.000153794f $X=0.556 $Y=0.072
cc_5 N_7_25 N_A_13 0.000166069f $X=0.556 $Y=0.072
cc_6 N_7_25 N_A_15 0.00475574f $X=0.556 $Y=0.072
cc_7 N_7_19 N_B_2 0.000202968f $X=0.2555 $Y=0.0675
cc_8 N_7_19 N_B_1 0.0031231f $X=0.2555 $Y=0.0675
cc_9 N_7_19 N_B_15 0.000276948f $X=0.2555 $Y=0.0675
cc_10 N_7_19 N_B_13 0.000280842f $X=0.2555 $Y=0.0675
cc_11 N_7_2 N_B_1 0.000385431f $X=0.378 $Y=0.0675
cc_12 N_7_5 N_B_2 0.000388132f $X=0.702 $Y=0.0675
cc_13 N_7_23 N_B_8 0.0326623f $X=0.6875 $Y=0.0675
cc_14 N_7_20 N_B_7 0.0326784f $X=0.3635 $Y=0.0675
cc_15 N_7_4 N_B_14 0.000661463f $X=0.594 $Y=0.0675
cc_16 N_7_5 N_B_8 0.000785112f $X=0.702 $Y=0.0675
cc_17 N_7_2 N_B_7 0.000785864f $X=0.378 $Y=0.0675
cc_18 N_7_24 N_B_10 0.0463601f $X=0.7955 $Y=0.0675
cc_19 N_7_6 N_B_9 0.00141218f $X=0.81 $Y=0.0675
cc_20 N_7_1 N_B_6 0.00141227f $X=0.27 $Y=0.0675
cc_21 N_7_24 N_B_2 0.00290376f $X=0.7955 $Y=0.0675
cc_22 N_7_25 N_B_15 0.00345696f $X=0.556 $Y=0.072
cc_23 N_7_25 N_B_13 0.00348666f $X=0.556 $Y=0.072
cc_24 N_7_19 N_B_6 0.017918f $X=0.2555 $Y=0.0675
cc_25 N_7_24 N_B_9 0.0179208f $X=0.7955 $Y=0.0675
cc_26 N_7_19 N_B_5 0.0467625f $X=0.2555 $Y=0.0675
cc_27 N_7_21 N_C_1 0.00559684f $X=0.4715 $Y=0.0675
cc_28 N_7_21 N_C_3 0.000418094f $X=0.4715 $Y=0.0675
cc_29 N_7_23 N_C_8 0.0326435f $X=0.6875 $Y=0.0675
cc_30 N_7_5 N_C_8 0.000654086f $X=0.702 $Y=0.0675
cc_31 N_7_2 N_C_3 0.000655443f $X=0.378 $Y=0.0675
cc_32 N_7_21 N_C_5 0.0363837f $X=0.4715 $Y=0.0675
cc_33 N_7_22 N_C_6 0.0187178f $X=0.5795 $Y=0.0675
cc_34 N_7_3 N_C_5 0.00136341f $X=0.486 $Y=0.0675
cc_35 N_7_4 N_C_7 0.00145137f $X=0.594 $Y=0.0675
cc_36 N_7_25 N_C_9 0.00153941f $X=0.556 $Y=0.072
cc_37 N_7_25 N_C_1 0.00230205f $X=0.556 $Y=0.072
cc_38 N_7_20 N_C_3 0.032211f $X=0.3635 $Y=0.0675
cc_39 N_7_22 N_C_7 0.0454341f $X=0.5795 $Y=0.0675
cc_40 N_7_21 N_C_4 0.028495f $X=0.4715 $Y=0.0675
cc_41 N_7_19 N_6__2_13 0.000565142f $X=0.2555 $Y=0.0675
cc_42 N_7_1 N_6__2_13 0.000749048f $X=0.27 $Y=0.0675
cc_43 N_7_19 N_6__2_11 0.0010642f $X=0.2555 $Y=0.0675
cc_44 N_7_19 N_6__2_12 0.0010774f $X=0.2555 $Y=0.0675
cc_45 N_7_2 N_6__2_3 0.00109553f $X=0.378 $Y=0.0675
cc_46 N_7_1 N_6__2_3 0.00280334f $X=0.27 $Y=0.0675
cc_47 N_7_1 N_6__2_2 0.00378444f $X=0.27 $Y=0.0675
cc_48 N_7_25 N_6__2_13 0.00995864f $X=0.556 $Y=0.072
x_PM_NAND3x2_ASAP7_75t_R%C vss C N_M10_g N_M9_g N_M8_g N_M7_g N_M6_g N_M20_g
+ N_M11_g N_M21_g N_C_9 N_C_1 N_C_3 N_C_8 N_C_5 N_C_6 N_C_7 N_C_4
+ PM_NAND3x2_ASAP7_75t_R%C
cc_49 N_C_9 N_B_15 0.000200973f $X=0.556 $Y=0.116
cc_50 N_C_9 N_B_13 0.00021955f $X=0.556 $Y=0.116
cc_51 N_C_1 N_B_1 0.000698041f $X=0.621 $Y=0.135
cc_52 N_C_1 N_B_2 0.000703049f $X=0.621 $Y=0.135
cc_53 N_C_1 N_B_14 0.00265841f $X=0.621 $Y=0.135
cc_54 N_C_3 N_B_7 0.00343225f $X=0.405 $Y=0.135
cc_55 N_C_8 N_B_8 0.00343357f $X=0.675 $Y=0.135
cc_56 N_C_9 N_B_14 0.00542897f $X=0.556 $Y=0.116
x_PM_NAND3x2_ASAP7_75t_R%8 vss N_M12_d N_M13_d N_M14_d N_M15_s N_M16_s N_M17_s
+ N_8_12 N_8_2 N_8_3 N_8_11 N_8_10 N_8_1 N_8_13 PM_NAND3x2_ASAP7_75t_R%8
cc_57 N_8_12 N_A_15 0.000236875f $X=0.9575 $Y=0.0675
cc_58 N_8_12 N_A_8 0.000436909f $X=0.9575 $Y=0.0675
cc_59 N_8_12 N_A_14 0.00110625f $X=0.9575 $Y=0.0675
cc_60 N_8_2 N_A_8 0.000898473f $X=0.864 $Y=0.0675
cc_61 N_8_3 N_A_9 0.00146935f $X=0.972 $Y=0.0675
cc_62 N_8_12 N_A_2 0.00276234f $X=0.9575 $Y=0.0675
cc_63 N_8_11 N_A_8 0.0323072f $X=0.8495 $Y=0.0675
cc_64 N_8_12 N_A_10 0.0357087f $X=0.9575 $Y=0.0675
cc_65 N_8_12 N_A_9 0.0291429f $X=0.9575 $Y=0.0675
cc_66 N_8_10 N_B_15 0.000265498f $X=0.7415 $Y=0.0675
cc_67 N_8_10 N_B_10 0.00105735f $X=0.7415 $Y=0.0675
cc_68 N_8_10 N_B_8 0.0189514f $X=0.7415 $Y=0.0675
cc_69 N_8_1 N_B_9 0.00157635f $X=0.756 $Y=0.0675
cc_70 N_8_10 N_B_2 0.00281449f $X=0.7415 $Y=0.0675
cc_71 N_8_11 N_B_10 0.0318828f $X=0.8495 $Y=0.0675
cc_72 N_8_10 N_B_9 0.0457887f $X=0.7415 $Y=0.0675
cc_73 N_8_13 N_7_24 0.000560136f $X=0.7445 $Y=0.036
cc_74 N_8_13 N_7_6 0.000749116f $X=0.7445 $Y=0.036
cc_75 N_8_11 N_7_24 0.0010642f $X=0.8495 $Y=0.0675
cc_76 N_8_10 N_7_24 0.00107716f $X=0.7415 $Y=0.0675
cc_77 N_8_2 N_7_6 0.00124883f $X=0.864 $Y=0.0675
cc_78 N_8_1 N_7_6 0.00252746f $X=0.756 $Y=0.0675
cc_79 N_8_1 N_7_5 0.00389124f $X=0.756 $Y=0.0675
cc_80 N_8_13 N_7_25 0.00991849f $X=0.7445 $Y=0.036
x_PM_NAND3x2_ASAP7_75t_R%A vss A N_M0_g N_M1_g N_M2_g N_M18_g N_M15_g N_M23_g
+ N_M16_g N_M17_g N_A_1 N_A_2 N_A_13 N_A_14 N_A_15 N_A_7 N_A_8 N_A_5 N_A_6
+ N_A_9 N_A_10 N_A_12 N_A_11 PM_NAND3x2_ASAP7_75t_R%A
x_PM_NAND3x2_ASAP7_75t_R%Y vss Y N_M0_d N_M1_d N_M2_d N_M18_s N_M19_d N_M20_s
+ N_M21_s N_M22_d N_M23_s N_M17_d N_M15_d N_M16_d N_Y_27 N_Y_7 N_Y_3 N_Y_39
+ N_Y_25 N_Y_28 N_Y_6 N_Y_2 N_Y_1 N_Y_8 N_Y_26 N_Y_37 N_Y_41 N_Y_29 N_Y_32
+ N_Y_40 N_Y_38 N_Y_30 N_Y_31 N_Y_4 N_Y_5 PM_NAND3x2_ASAP7_75t_R%Y
cc_81 N_Y_27 N_A_1 0.000100821f $X=0.9035 $Y=0.0675
cc_82 N_Y_27 N_A_2 0.00671323f $X=0.9035 $Y=0.0675
cc_83 N_Y_7 N_A_12 0.000365995f $X=0.918 $Y=0.2025
cc_84 N_Y_3 N_A_11 0.000382214f $X=0.162 $Y=0.2025
cc_85 N_Y_39 N_A_11 0.00276774f $X=0.0945 $Y=0.234
cc_86 N_Y_39 N_A_12 0.00269111f $X=0.0945 $Y=0.234
cc_87 N_Y_25 N_A_5 0.0345915f $X=0.056 $Y=0.0675
cc_88 N_Y_28 N_A_10 0.0345915f $X=1.0115 $Y=0.0675
cc_89 N_Y_6 N_A_14 0.000489769f $X=0.918 $Y=0.0675
cc_90 N_Y_2 N_A_13 0.000539613f $X=0.162 $Y=0.0675
cc_91 N_Y_6 N_A_2 0.000579814f $X=0.918 $Y=0.0675
cc_92 N_Y_3 N_A_1 0.000612329f $X=0.162 $Y=0.2025
cc_93 N_Y_1 N_A_5 0.000729367f $X=0.054 $Y=0.0675
cc_94 N_Y_8 N_A_10 0.000729367f $X=1.026 $Y=0.0675
cc_95 N_Y_26 N_A_6 0.0673603f $X=0.1475 $Y=0.0675
cc_96 N_Y_37 N_A_1 0.00100325f $X=0.027 $Y=0.0935
cc_97 N_Y_41 N_A_2 0.00103816f $X=1.053 $Y=0.216
cc_98 N_Y_29 N_A_7 0.0322267f $X=0.164 $Y=0.2025
cc_99 N_Y_32 N_A_8 0.0113989f $X=0.9035 $Y=0.2025
cc_100 N_Y_40 N_A_2 0.00132631f $X=1.0015 $Y=0.072
cc_101 N_Y_38 N_A_1 0.00139831f $X=0.0405 $Y=0.072
cc_102 N_Y_2 N_A_6 0.0015916f $X=0.162 $Y=0.0675
cc_103 N_Y_6 N_A_9 0.00166211f $X=0.918 $Y=0.0675
cc_104 N_Y_7 N_A_14 0.00172338f $X=0.918 $Y=0.2025
cc_105 N_Y_3 N_A_13 0.0018985f $X=0.162 $Y=0.2025
cc_106 N_Y_7 N_A_9 0.00267537f $X=0.918 $Y=0.2025
cc_107 N_Y_3 N_A_6 0.00272082f $X=0.162 $Y=0.2025
cc_108 N_Y_26 N_A_1 0.0063521f $X=0.1475 $Y=0.0675
cc_109 N_Y_39 N_A_15 0.0163792f $X=0.0945 $Y=0.234
cc_110 N_Y_27 N_A_8 0.0559997f $X=0.9035 $Y=0.0675
cc_111 N_Y_32 N_A_9 0.0208249f $X=0.9035 $Y=0.2025
cc_112 N_Y_26 N_A_7 0.0375479f $X=0.1475 $Y=0.0675
cc_113 N_Y_27 N_A_9 0.0492977f $X=0.9035 $Y=0.0675
cc_114 N_Y_30 N_B_1 0.00100583f $X=0.3635 $Y=0.2025
cc_115 N_Y_31 N_B_8 0.0336033f $X=0.6875 $Y=0.2025
cc_116 N_Y_4 N_B_14 0.000468705f $X=0.378 $Y=0.2025
cc_117 N_Y_5 N_B_14 0.000485429f $X=0.702 $Y=0.2025
cc_118 N_Y_5 N_B_15 0.000550871f $X=0.702 $Y=0.2025
cc_119 N_Y_4 N_B_13 0.000551601f $X=0.378 $Y=0.2025
cc_120 N_Y_31 N_B_2 0.000775466f $X=0.6875 $Y=0.2025
cc_121 N_Y_4 N_B_7 0.00158188f $X=0.378 $Y=0.2025
cc_122 N_Y_5 N_B_8 0.00158203f $X=0.702 $Y=0.2025
cc_123 N_Y_39 N_B_12 0.00792565f $X=0.0945 $Y=0.234
cc_124 N_Y_39 N_B_11 0.00807751f $X=0.0945 $Y=0.234
cc_125 N_Y_39 N_B_14 0.0129178f $X=0.0945 $Y=0.234
cc_126 N_Y_30 N_B_7 0.033871f $X=0.3635 $Y=0.2025
cc_127 N_Y_5 N_C_8 0.000698626f $X=0.702 $Y=0.2025
cc_128 N_Y_4 N_C_3 0.000698688f $X=0.378 $Y=0.2025
cc_129 N_Y_39 N_C_1 0.00123543f $X=0.0945 $Y=0.234
cc_130 N_Y_30 N_C_3 0.0330781f $X=0.3635 $Y=0.2025
cc_131 N_Y_31 N_C_8 0.034141f $X=0.6875 $Y=0.2025
cc_132 N_Y_1 N_6__2_13 0.000235238f $X=0.054 $Y=0.0675
cc_133 N_Y_25 N_6__2_13 0.000550747f $X=0.056 $Y=0.0675
cc_134 N_Y_26 N_6__2_13 0.000552546f $X=0.1475 $Y=0.0675
cc_135 N_Y_2 N_6__2_13 0.000699839f $X=0.162 $Y=0.0675
cc_136 N_Y_26 N_6__2_10 0.00215435f $X=0.1475 $Y=0.0675
cc_137 N_Y_1 N_6__2_1 0.00117448f $X=0.054 $Y=0.0675
cc_138 N_Y_2 N_6__2_1 0.00303044f $X=0.162 $Y=0.0675
cc_139 N_Y_2 N_6__2_2 0.00368313f $X=0.162 $Y=0.0675
cc_140 N_Y_38 N_6__2_13 0.00955343f $X=0.0405 $Y=0.072
cc_141 N_Y_8 N_8_13 0.000235319f $X=1.026 $Y=0.0675
cc_142 N_Y_28 N_8_13 0.000550799f $X=1.0115 $Y=0.0675
cc_143 N_Y_27 N_8_13 0.000558106f $X=0.9035 $Y=0.0675
cc_144 N_Y_6 N_8_13 0.000702988f $X=0.918 $Y=0.0675
cc_145 N_Y_27 N_8_12 0.00215448f $X=0.9035 $Y=0.0675
cc_146 N_Y_6 N_8_2 0.00368978f $X=0.918 $Y=0.0675
cc_147 N_Y_8 N_8_3 0.00420721f $X=1.026 $Y=0.0675
cc_148 N_Y_40 N_8_13 0.00959585f $X=1.0015 $Y=0.072
x_PM_NAND3x2_ASAP7_75t_R%B vss B N_M12_g N_M22_g N_M13_g N_M14_g N_M4_g N_M3_g
+ N_M5_g N_M19_g N_B_1 N_B_2 N_B_11 N_B_12 N_B_15 N_B_5 N_B_10 N_B_13 N_B_14
+ N_B_7 N_B_8 N_B_6 N_B_9 PM_NAND3x2_ASAP7_75t_R%B
cc_149 N_B_1 N_A_1 0.00202969f $X=0.3225 $Y=0.135
cc_150 N_B_2 N_A_2 0.00203819f $X=0.722 $Y=0.135
cc_151 N_B_1 N_A_13 0.000217792f $X=0.3225 $Y=0.135
cc_152 N_B_2 N_A_14 0.00022962f $X=0.722 $Y=0.135
cc_153 N_B_11 N_A_15 0.000372538f $X=0.347 $Y=0.198
cc_154 N_B_12 N_A_15 0.000373155f $X=0.734 $Y=0.198
cc_155 N_B_15 N_A_15 0.00108214f $X=0.734 $Y=0.107
cc_156 N_B_5 N_A_7 0.00343133f $X=0.243 $Y=0.135
cc_157 N_B_10 N_A_8 0.00343525f $X=0.837 $Y=0.135
cc_158 N_B_13 N_A_15 0.00452397f $X=0.347 $Y=0.1765
cc_159 N_B_14 N_A_15 0.00821133f $X=0.645 $Y=0.198
x_PM_NAND3x2_ASAP7_75t_R%6__2 vss N_M0_s N_M1_s N_M2_s N_M3_d N_M4_d N_M5_d
+ N_6__2_10 N_6__2_2 N_6__2_1 N_6__2_11 N_6__2_12 N_6__2_3 N_6__2_13
+ PM_NAND3x2_ASAP7_75t_R%6__2
cc_160 N_6__2_10 N_A_15 0.000257581f $X=0.0935 $Y=0.0675
cc_161 N_6__2_10 N_A_7 0.000436868f $X=0.0935 $Y=0.0675
cc_162 N_6__2_10 N_A_13 0.00116489f $X=0.0935 $Y=0.0675
cc_163 N_6__2_2 N_A_7 0.000869904f $X=0.216 $Y=0.0675
cc_164 N_6__2_1 N_A_5 0.00147199f $X=0.108 $Y=0.0675
cc_165 N_6__2_10 N_A_1 0.00277453f $X=0.0935 $Y=0.0675
cc_166 N_6__2_11 N_A_7 0.0323177f $X=0.2015 $Y=0.0675
cc_167 N_6__2_10 N_A_5 0.0357054f $X=0.0935 $Y=0.0675
cc_168 N_6__2_10 N_A_6 0.0291133f $X=0.0935 $Y=0.0675
cc_169 N_6__2_12 N_B_13 0.000279384f $X=0.3095 $Y=0.0675
cc_170 N_6__2_12 N_B_5 0.00106761f $X=0.3095 $Y=0.0675
cc_171 N_6__2_12 N_B_7 0.0366328f $X=0.3095 $Y=0.0675
cc_172 N_6__2_3 N_B_7 0.00158389f $X=0.324 $Y=0.0675
cc_173 N_6__2_12 N_B_1 0.00283308f $X=0.3095 $Y=0.0675
cc_174 N_6__2_11 N_B_5 0.0318618f $X=0.2015 $Y=0.0675
cc_175 N_6__2_12 N_B_6 0.0281418f $X=0.3095 $Y=0.0675

* End of included file NAND3x2_ASAP7_75t_R.pex.sp.pxi
.ends

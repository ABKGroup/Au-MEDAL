.subckt PM_AND3x4_ASAP7_75t_R%C vss 27 6 10 20 3 5 1 4
c1 1 vss 0.00821895f $X=0.297 $Y=0.135
c2 3 vss 0.0846986f $X=0.297 $Y=0.0245
c3 4 vss 0.0645525f $X=0.351 $Y=0.135
c4 5 vss 0.0111158f $X=0.351 $Y=0.108
r1 27 26 3.14806 $w=1.3e-08 $l=1.35e-08 $layer=M1 $thickness=3.6e-08 $X=0.35
+ $Y=0.137 $X2=0.351 $Y2=0.1215
r2 5 26 3.14806 $w=1.3e-08 $l=1.35e-08 $layer=M1 $thickness=3.6e-08 $X=0.351
+ $Y=0.108 $X2=0.351 $Y2=0.1215
r3 20 21 14.6259 $w=2.1e-08 $l=4.3e-08 $layer=Gate_1 $thickness=5.6e-08
+ $X=0.351 $Y=0.0675 $X2=0.351 $Y2=0.1105
r4 18 21 2.89117 $w=2.1e-08 $l=8.5e-09 $layer=Gate_1 $thickness=5.6e-08
+ $X=0.351 $Y=0.119 $X2=0.351 $Y2=0.1105
r5 4 15 6.4296 $w=2e-08 $layer=Gate_1 $thickness=5.22105e-08 $X=0.351 $Y=0.135
+ $X2=0.351 $Y2=0.135
r6 4 18 5.61228 $w=2.0375e-08 $l=1.6e-08 $layer=Gate_1 $thickness=5.6e-08
+ $X=0.351 $Y=0.135 $X2=0.351 $Y2=0.119
r7 27 15 19.3796 $a=3.24e-16 $layer=V0LIG $X=0.35 $Y=0.137 $X2=0.351 $Y2=0.135
r8 14 15 3.01694 $w=2e-08 $l=9.5e-09 $layer=LIG $thickness=4.8e-08 $X=0.3415
+ $Y=0.135 $X2=0.351 $Y2=0.135
r9 13 14 17.097 $w=1.34914e-08 $l=1.75e-08 $layer=LIG $thickness=4.8e-08
+ $X=0.324 $Y=0.135 $X2=0.3415 $Y2=0.135
r10 1 8 6.74717 $w=2e-08 $layer=Gate_1 $thickness=5.2e-08 $X=0.297 $Y=0.135
+ $X2=0.297 $Y2=0.135
r11 1 13 20.114 $w=1.57815e-08 $l=2.7e-08 $layer=LIG $thickness=4.8e-08
+ $X=0.297 $Y=0.135 $X2=0.324 $Y2=0.135
r12 10 9 16.6668 $w=2.1e-08 $l=4.9e-08 $layer=Gate_1 $thickness=5.6e-08
+ $X=0.297 $Y=0.2025 $X2=0.297 $Y2=0.1535
r13 8 9 6.46262 $w=2.04595e-08 $l=1.85e-08 $layer=Gate_1 $thickness=5.6e-08
+ $X=0.297 $Y=0.135 $X2=0.297 $Y2=0.1535
r14 7 8 6.46262 $w=2.04595e-08 $l=1.85e-08 $layer=Gate_1 $thickness=5.6e-08
+ $X=0.297 $Y=0.1165 $X2=0.297 $Y2=0.135
r15 6 7 16.6668 $w=2.1e-08 $l=4.9e-08 $layer=Gate_1 $thickness=5.6e-08 $X=0.297
+ $Y=0.0675 $X2=0.297 $Y2=0.1165
r16 6 3 14.6259 $w=2.1e-08 $l=4.3e-08 $layer=Gate_1 $thickness=5.6e-08 $X=0.297
+ $Y=0.0675 $X2=0.297 $Y2=0.0245
.ends

.subckt PM_AND3x4_ASAP7_75t_R%Y vss 33 24 25 37 38 46 47 50 51 15 20 21 2 1 4 3
+ 13 14 16
c1 1 vss 0.00853966f $X=0.108 $Y=0.0675
c2 2 vss 0.00853966f $X=0.108 $Y=0.2025
c3 3 vss 0.0087308f $X=0.216 $Y=0.0675
c4 4 vss 0.00853837f $X=0.216 $Y=0.2025
c5 13 vss 0.00431589f $X=0.0935 $Y=0.0675
c6 14 vss 0.00444889f $X=0.2015 $Y=0.0675
c7 15 vss 0.00432547f $X=0.0935 $Y=0.2025
c8 16 vss 0.00435915f $X=0.2015 $Y=0.2025
c9 17 vss 0.00290189f $X=0.027 $Y=0.036
c10 18 vss 0.00290189f $X=0.027 $Y=0.234
c11 19 vss 0.00853211f $X=0.027 $Y=0.0855
c12 20 vss 0.0177587f $X=0.0675 $Y=0.036
c13 21 vss 0.017681f $X=0.0675 $Y=0.234
r1 51 49 0.0308642 $w=8.1e-08 $l=2.5e-09 $layer=P_src_drn $thickness=1e-09
+ $X=0.2333 $Y=0.2025 $X2=0.2305 $Y2=0.2025
r2 4 49 0.179012 $w=8.1e-08 $l=1.45e-08 $layer=P_src_drn $thickness=1e-09
+ $X=0.216 $Y=0.2025 $X2=0.2305 $Y2=0.2025
r3 16 4 0.179012 $w=8.1e-08 $l=1.45e-08 $layer=P_src_drn $thickness=1e-09
+ $X=0.2015 $Y=0.2025 $X2=0.216 $Y2=0.2025
r4 50 16 0.0308642 $w=8.1e-08 $l=2.5e-09 $layer=P_src_drn $thickness=1e-09
+ $X=0.1986 $Y=0.2025 $X2=0.2015 $Y2=0.2025
r5 47 45 0.0308642 $w=8.1e-08 $l=2.5e-09 $layer=P_src_drn $thickness=1e-09
+ $X=0.1253 $Y=0.2025 $X2=0.1225 $Y2=0.2025
r6 2 45 0.179012 $w=8.1e-08 $l=1.45e-08 $layer=P_src_drn $thickness=1e-09
+ $X=0.108 $Y=0.2025 $X2=0.1225 $Y2=0.2025
r7 15 2 0.179012 $w=8.1e-08 $l=1.45e-08 $layer=P_src_drn $thickness=1e-09
+ $X=0.0935 $Y=0.2025 $X2=0.108 $Y2=0.2025
r8 46 15 0.0308642 $w=8.1e-08 $l=2.5e-09 $layer=P_src_drn $thickness=1e-09
+ $X=0.0906 $Y=0.2025 $X2=0.0935 $Y2=0.2025
r9 4 41 19.3796 $a=3.24e-16 $layer=V0LISD $X=0.216 $Y=0.2025 $X2=0.2125
+ $Y2=0.234
r10 2 39 19.3796 $a=3.24e-16 $layer=V0LISD $X=0.108 $Y=0.2025 $X2=0.108
+ $Y2=0.234
r11 40 41 11.7761 $w=1.3e-08 $l=5.05e-08 $layer=M1 $thickness=3.6e-08 $X=0.162
+ $Y=0.234 $X2=0.2125 $Y2=0.234
r12 39 40 12.5922 $w=1.3e-08 $l=5.4e-08 $layer=M1 $thickness=3.6e-08 $X=0.108
+ $Y=0.234 $X2=0.162 $Y2=0.234
r13 21 39 9.44419 $w=1.3e-08 $l=4.05e-08 $layer=M1 $thickness=3.6e-08 $X=0.0675
+ $Y=0.234 $X2=0.108 $Y2=0.234
r14 18 34 9.544 $w=1.48375e-08 $l=4.8e-08 $layer=M1 $thickness=3.6e-08 $X=0.027
+ $Y=0.234 $X2=0.027 $Y2=0.186
r15 18 21 7.79507 $w=1.41111e-08 $l=4.05e-08 $layer=M1 $thickness=3.6e-08
+ $X=0.027 $Y=0.234 $X2=0.0675 $Y2=0.234
r16 38 36 0.0308642 $w=8.1e-08 $l=2.5e-09 $layer=N_src_drn $thickness=1e-09
+ $X=0.2333 $Y=0.0675 $X2=0.2305 $Y2=0.0675
r17 3 36 0.179012 $w=8.1e-08 $l=1.45e-08 $layer=N_src_drn $thickness=1e-09
+ $X=0.216 $Y=0.0675 $X2=0.2305 $Y2=0.0675
r18 14 3 0.179012 $w=8.1e-08 $l=1.45e-08 $layer=N_src_drn $thickness=1e-09
+ $X=0.2015 $Y=0.0675 $X2=0.216 $Y2=0.0675
r19 37 14 0.0308642 $w=8.1e-08 $l=2.5e-09 $layer=N_src_drn $thickness=1e-09
+ $X=0.1986 $Y=0.0675 $X2=0.2015 $Y2=0.0675
r20 33 34 9.211 $w=1.3e-08 $l=3.95e-08 $layer=M1 $thickness=3.6e-08 $X=0.0285
+ $Y=0.1465 $X2=0.027 $Y2=0.186
r21 33 32 0.349785 $w=1.3e-08 $l=1.5e-09 $layer=M1 $thickness=3.6e-08 $X=0.0285
+ $Y=0.1465 $X2=0.027 $Y2=0.145
r22 31 32 2.3319 $w=1.3e-08 $l=1e-08 $layer=M1 $thickness=3.6e-08 $X=0.027
+ $Y=0.135 $X2=0.027 $Y2=0.145
r23 19 31 11.5429 $w=1.3e-08 $l=4.95e-08 $layer=M1 $thickness=3.6e-08 $X=0.027
+ $Y=0.0855 $X2=0.027 $Y2=0.135
r24 3 28 19.3796 $a=3.24e-16 $layer=V0LISD $X=0.216 $Y=0.0675 $X2=0.2125
+ $Y2=0.036
r25 17 20 7.79507 $w=1.41111e-08 $l=4.05e-08 $layer=M1 $thickness=3.6e-08
+ $X=0.027 $Y=0.036 $X2=0.0675 $Y2=0.036
r26 17 19 9.89378 $w=1.47818e-08 $l=4.95e-08 $layer=M1 $thickness=3.6e-08
+ $X=0.027 $Y=0.036 $X2=0.027 $Y2=0.0855
r27 27 28 11.7761 $w=1.3e-08 $l=5.05e-08 $layer=M1 $thickness=3.6e-08 $X=0.162
+ $Y=0.036 $X2=0.2125 $Y2=0.036
r28 26 27 12.5922 $w=1.3e-08 $l=5.4e-08 $layer=M1 $thickness=3.6e-08 $X=0.108
+ $Y=0.036 $X2=0.162 $Y2=0.036
r29 20 26 9.44419 $w=1.3e-08 $l=4.05e-08 $layer=M1 $thickness=3.6e-08 $X=0.0675
+ $Y=0.036 $X2=0.108 $Y2=0.036
r30 1 26 19.3796 $a=3.24e-16 $layer=V0LISD $X=0.108 $Y=0.0675 $X2=0.108
+ $Y2=0.036
r31 25 23 0.0308642 $w=8.1e-08 $l=2.5e-09 $layer=N_src_drn $thickness=1e-09
+ $X=0.1253 $Y=0.0675 $X2=0.1225 $Y2=0.0675
r32 1 23 0.179012 $w=8.1e-08 $l=1.45e-08 $layer=N_src_drn $thickness=1e-09
+ $X=0.108 $Y=0.0675 $X2=0.1225 $Y2=0.0675
r33 13 1 0.179012 $w=8.1e-08 $l=1.45e-08 $layer=N_src_drn $thickness=1e-09
+ $X=0.0935 $Y=0.0675 $X2=0.108 $Y2=0.0675
r34 24 13 0.0308642 $w=8.1e-08 $l=2.5e-09 $layer=N_src_drn $thickness=1e-09
+ $X=0.0906 $Y=0.0675 $X2=0.0935 $Y2=0.0675
.ends

.subckt PM_AND3x4_ASAP7_75t_R%8 vss 12 13 23 24 9 1 7 2 8
c1 1 vss 0.00845036f $X=0.324 $Y=0.0675
c2 2 vss 0.00396781f $X=0.54 $Y=0.0675
c3 7 vss 0.00430858f $X=0.3095 $Y=0.0675
c4 8 vss 0.00190647f $X=0.5255 $Y=0.0675
c5 9 vss 0.0218251f $X=0.3125 $Y=0.036
r1 24 22 0.0308642 $w=8.1e-08 $l=2.5e-09 $layer=N_src_drn $thickness=1e-09
+ $X=0.5573 $Y=0.0675 $X2=0.5545 $Y2=0.0675
r2 2 22 0.179012 $w=8.1e-08 $l=1.45e-08 $layer=N_src_drn $thickness=1e-09
+ $X=0.54 $Y=0.0675 $X2=0.5545 $Y2=0.0675
r3 8 2 0.179012 $w=8.1e-08 $l=1.45e-08 $layer=N_src_drn $thickness=1e-09
+ $X=0.5255 $Y=0.0675 $X2=0.54 $Y2=0.0675
r4 23 8 0.0308642 $w=8.1e-08 $l=2.5e-09 $layer=N_src_drn $thickness=1e-09
+ $X=0.5226 $Y=0.0675 $X2=0.5255 $Y2=0.0675
r5 2 19 19.3796 $a=3.24e-16 $layer=V0LISD $X=0.54 $Y=0.0675 $X2=0.54 $Y2=0.036
r6 18 19 8.97781 $w=1.3e-08 $l=3.85e-08 $layer=M1 $thickness=3.6e-08 $X=0.5015
+ $Y=0.036 $X2=0.54 $Y2=0.036
r7 17 18 19.9377 $w=1.3e-08 $l=8.55e-08 $layer=M1 $thickness=3.6e-08 $X=0.416
+ $Y=0.036 $X2=0.5015 $Y2=0.036
r8 16 17 15.1573 $w=1.3e-08 $l=6.5e-08 $layer=M1 $thickness=3.6e-08 $X=0.351
+ $Y=0.036 $X2=0.416 $Y2=0.036
r9 15 16 3.14806 $w=1.3e-08 $l=1.35e-08 $layer=M1 $thickness=3.6e-08 $X=0.3375
+ $Y=0.036 $X2=0.351 $Y2=0.036
r10 14 15 3.14806 $w=1.3e-08 $l=1.35e-08 $layer=M1 $thickness=3.6e-08 $X=0.324
+ $Y=0.036 $X2=0.3375 $Y2=0.036
r11 9 14 2.68168 $w=1.3e-08 $l=1.15e-08 $layer=M1 $thickness=3.6e-08 $X=0.3125
+ $Y=0.036 $X2=0.324 $Y2=0.036
r12 1 14 19.3796 $a=3.24e-16 $layer=V0LISD $X=0.324 $Y=0.0675 $X2=0.324
+ $Y2=0.036
r13 13 11 0.0308642 $w=8.1e-08 $l=2.5e-09 $layer=N_src_drn $thickness=1e-09
+ $X=0.3413 $Y=0.0675 $X2=0.3385 $Y2=0.0675
r14 1 11 0.179012 $w=8.1e-08 $l=1.45e-08 $layer=N_src_drn $thickness=1e-09
+ $X=0.324 $Y=0.0675 $X2=0.3385 $Y2=0.0675
r15 7 1 0.179012 $w=8.1e-08 $l=1.45e-08 $layer=N_src_drn $thickness=1e-09
+ $X=0.3095 $Y=0.0675 $X2=0.324 $Y2=0.0675
r16 12 7 0.0308642 $w=8.1e-08 $l=2.5e-09 $layer=N_src_drn $thickness=1e-09
+ $X=0.3066 $Y=0.0675 $X2=0.3095 $Y2=0.0675
.ends

.subckt PM_AND3x4_ASAP7_75t_R%9 vss 15 29 30 32 13 3 2 11 1 10 12
c1 1 vss 0.00464879f $X=0.486 $Y=0.0675
c2 2 vss 0.00333234f $X=0.594 $Y=0.0675
c3 3 vss 0.00532938f $X=0.696 $Y=0.0675
c4 10 vss 0.0359476f $X=0.488 $Y=0.0675
c5 11 vss 0.00203335f $X=0.5795 $Y=0.0675
c6 12 vss 0.0357107f $X=0.6875 $Y=0.0675
c7 13 vss 0.00276915f $X=0.4745 $Y=0.072
r1 12 3 0.154321 $w=8.1e-08 $l=1.25e-08 $layer=N_src_drn $thickness=1e-09
+ $X=0.6875 $Y=0.0675 $X2=0.696 $Y2=0.0675
r2 32 12 0.0308642 $w=8.1e-08 $l=2.5e-09 $layer=N_src_drn $thickness=1e-09
+ $X=0.6846 $Y=0.0675 $X2=0.6875 $Y2=0.0675
r3 30 28 0.0308642 $w=8.1e-08 $l=2.5e-09 $layer=N_src_drn $thickness=1e-09
+ $X=0.6113 $Y=0.0675 $X2=0.6085 $Y2=0.0675
r4 2 28 0.179012 $w=8.1e-08 $l=1.45e-08 $layer=N_src_drn $thickness=1e-09
+ $X=0.594 $Y=0.0675 $X2=0.6085 $Y2=0.0675
r5 11 2 0.179012 $w=8.1e-08 $l=1.45e-08 $layer=N_src_drn $thickness=1e-09
+ $X=0.5795 $Y=0.0675 $X2=0.594 $Y2=0.0675
r6 29 11 0.0308642 $w=8.1e-08 $l=2.5e-09 $layer=N_src_drn $thickness=1e-09
+ $X=0.5766 $Y=0.0675 $X2=0.5795 $Y2=0.0675
r7 3 26 19.3796 $a=3.24e-16 $layer=V0LISD $X=0.696 $Y=0.0675 $X2=0.692 $Y2=0.072
r8 2 21 19.3796 $a=3.24e-16 $layer=V0LISD $X=0.594 $Y=0.0675 $X2=0.594 $Y2=0.072
r9 25 26 6.06293 $w=1.3e-08 $l=2.6e-08 $layer=M1 $thickness=3.6e-08 $X=0.666
+ $Y=0.072 $X2=0.692 $Y2=0.072
r10 24 25 5.71315 $w=1.3e-08 $l=2.45e-08 $layer=M1 $thickness=3.6e-08 $X=0.6415
+ $Y=0.072 $X2=0.666 $Y2=0.072
r11 23 24 4.31401 $w=1.3e-08 $l=1.85e-08 $layer=M1 $thickness=3.6e-08 $X=0.623
+ $Y=0.072 $X2=0.6415 $Y2=0.072
r12 22 23 3.61444 $w=1.3e-08 $l=1.55e-08 $layer=M1 $thickness=3.6e-08 $X=0.6075
+ $Y=0.072 $X2=0.623 $Y2=0.072
r13 21 22 3.14806 $w=1.3e-08 $l=1.35e-08 $layer=M1 $thickness=3.6e-08 $X=0.594
+ $Y=0.072 $X2=0.6075 $Y2=0.072
r14 20 21 5.71315 $w=1.3e-08 $l=2.45e-08 $layer=M1 $thickness=3.6e-08 $X=0.5695
+ $Y=0.072 $X2=0.594 $Y2=0.072
r15 19 20 5.13017 $w=1.3e-08 $l=2.2e-08 $layer=M1 $thickness=3.6e-08 $X=0.5475
+ $Y=0.072 $X2=0.5695 $Y2=0.072
r16 18 19 5.82974 $w=1.3e-08 $l=2.5e-08 $layer=M1 $thickness=3.6e-08 $X=0.5225
+ $Y=0.072 $X2=0.5475 $Y2=0.072
r17 17 18 5.36336 $w=1.3e-08 $l=2.3e-08 $layer=M1 $thickness=3.6e-08 $X=0.4995
+ $Y=0.072 $X2=0.5225 $Y2=0.072
r18 16 17 3.14806 $w=1.3e-08 $l=1.35e-08 $layer=M1 $thickness=3.6e-08 $X=0.486
+ $Y=0.072 $X2=0.4995 $Y2=0.072
r19 13 16 2.68168 $w=1.3e-08 $l=1.15e-08 $layer=M1 $thickness=3.6e-08 $X=0.4745
+ $Y=0.072 $X2=0.486 $Y2=0.072
r20 1 16 19.3796 $a=3.24e-16 $layer=V0LISD $X=0.486 $Y=0.0675 $X2=0.486
+ $Y2=0.072
r21 15 14 0.0308642 $w=8.1e-08 $l=2.5e-09 $layer=N_src_drn $thickness=1e-09
+ $X=0.5033 $Y=0.0675 $X2=0.5005 $Y2=0.0675
r22 10 14 0.154321 $w=8.1e-08 $l=1.25e-08 $layer=N_src_drn $thickness=1e-09
+ $X=0.488 $Y=0.0675 $X2=0.5005 $Y2=0.0675
r23 1 10 1e-05 $l=2e-09 $X=0.486 $Y=0.0675 $X2=0.488 $Y2=0.0675
.ends

.subckt PM_AND3x4_ASAP7_75t_R%3 vss 33 39 52 55 58 61 64 67 93 95 97 109 110 23
+ 3 4 1 29 28 18 30 20 6 21 5 32 22 19 24 27 16 15 17 31
c1 1 vss 0.017577f $X=0.081 $Y=0.135
c2 3 vss 0.00740078f $X=0.324 $Y=0.2025
c3 4 vss 0.00870214f $X=0.486 $Y=0.2025
c4 5 vss 0.00427958f $X=0.648 $Y=0.0675
c5 6 vss 0.00714628f $X=0.648 $Y=0.2025
c6 15 vss 0.0856741f $X=0.081 $Y=0.0245
c7 16 vss 0.0809989f $X=0.135 $Y=0.135
c8 17 vss 0.0804726f $X=0.189 $Y=0.135
c9 18 vss 0.0805643f $X=0.243 $Y=0.135
c10 19 vss 0.00513083f $X=0.6335 $Y=0.0675
c11 20 vss 0.00683668f $X=0.3095 $Y=0.2025
c12 21 vss 0.0426072f $X=0.488 $Y=0.2025
c13 22 vss 0.00686004f $X=0.65 $Y=0.2025
c14 23 vss 0.00021882f $X=0.269 $Y=0.135
c15 24 vss 0.00293044f $X=0.269 $Y=0.234
c16 25 vss 0.00365433f $X=0.737 $Y=0.036
c17 26 vss 0.00382034f $X=0.737 $Y=0.234
c18 27 vss 0.00155101f $X=0.224 $Y=0.135
c19 28 vss 0.00551811f $X=0.269 $Y=0.098
c20 29 vss 0.00370557f $X=0.269 $Y=0.172
c21 30 vss 0.0461736f $X=0.294 $Y=0.234
c22 31 vss 0.00950983f $X=0.7145 $Y=0.036
c23 32 vss 0.0140726f $X=0.737 $Y=0.216
r1 110 108 0.0308642 $w=8.1e-08 $l=2.5e-09 $layer=N_src_drn $thickness=1e-09
+ $X=0.6653 $Y=0.0675 $X2=0.6625 $Y2=0.0675
r2 5 108 0.179012 $w=8.1e-08 $l=1.45e-08 $layer=N_src_drn $thickness=1e-09
+ $X=0.648 $Y=0.0675 $X2=0.6625 $Y2=0.0675
r3 19 5 0.179012 $w=8.1e-08 $l=1.45e-08 $layer=N_src_drn $thickness=1e-09
+ $X=0.6335 $Y=0.0675 $X2=0.648 $Y2=0.0675
r4 109 19 0.0308642 $w=8.1e-08 $l=2.5e-09 $layer=N_src_drn $thickness=1e-09
+ $X=0.6306 $Y=0.0675 $X2=0.6335 $Y2=0.0675
r5 5 105 19.3796 $a=3.24e-16 $layer=V0LISD $X=0.648 $Y=0.0675 $X2=0.648
+ $Y2=0.036
r6 105 106 7.22888 $w=1.3e-08 $l=3.1e-08 $layer=M1 $thickness=3.6e-08 $X=0.648
+ $Y=0.036 $X2=0.679 $Y2=0.036
r7 31 106 8.27824 $w=1.3e-08 $l=3.55e-08 $layer=M1 $thickness=3.6e-08 $X=0.7145
+ $Y=0.036 $X2=0.679 $Y2=0.036
r8 25 103 2.5483 $w=1.79e-08 $l=1.8e-08 $layer=M1 $thickness=3.6e-08 $X=0.737
+ $Y=0.036 $X2=0.737 $Y2=0.054
r9 25 31 3.59766 $w=1.5e-08 $l=2.25e-08 $layer=M1 $thickness=3.6e-08 $X=0.737
+ $Y=0.036 $X2=0.7145 $Y2=0.036
r10 102 103 4.19742 $w=1.3e-08 $l=1.8e-08 $layer=M1 $thickness=3.6e-08 $X=0.737
+ $Y=0.072 $X2=0.737 $Y2=0.054
r11 101 102 4.19742 $w=1.3e-08 $l=1.8e-08 $layer=M1 $thickness=3.6e-08 $X=0.737
+ $Y=0.09 $X2=0.737 $Y2=0.072
r12 100 101 4.19742 $w=1.3e-08 $l=1.8e-08 $layer=M1 $thickness=3.6e-08 $X=0.737
+ $Y=0.108 $X2=0.737 $Y2=0.09
r13 99 100 10.4935 $w=1.3e-08 $l=4.5e-08 $layer=M1 $thickness=3.6e-08 $X=0.737
+ $Y=0.153 $X2=0.737 $Y2=0.108
r14 98 99 10.4935 $w=1.3e-08 $l=4.5e-08 $layer=M1 $thickness=3.6e-08 $X=0.737
+ $Y=0.198 $X2=0.737 $Y2=0.153
r15 32 98 4.19742 $w=1.3e-08 $l=1.8e-08 $layer=M1 $thickness=3.6e-08 $X=0.737
+ $Y=0.216 $X2=0.737 $Y2=0.198
r16 97 96 0.0308642 $w=8.1e-08 $l=2.5e-09 $layer=P_src_drn $thickness=1e-09
+ $X=0.6653 $Y=0.2025 $X2=0.6625 $Y2=0.2025
r17 22 96 0.154321 $w=8.1e-08 $l=1.25e-08 $layer=P_src_drn $thickness=1e-09
+ $X=0.65 $Y=0.2025 $X2=0.6625 $Y2=0.2025
r18 95 94 0.0308642 $w=8.1e-08 $l=2.5e-09 $layer=P_src_drn $thickness=1e-09
+ $X=0.5033 $Y=0.2025 $X2=0.5005 $Y2=0.2025
r19 21 94 0.154321 $w=8.1e-08 $l=1.25e-08 $layer=P_src_drn $thickness=1e-09
+ $X=0.488 $Y=0.2025 $X2=0.5005 $Y2=0.2025
r20 20 3 0.154321 $w=8.1e-08 $l=1.25e-08 $layer=P_src_drn $thickness=1e-09
+ $X=0.3095 $Y=0.2025 $X2=0.324 $Y2=0.2025
r21 93 20 0.0308642 $w=8.1e-08 $l=2.5e-09 $layer=P_src_drn $thickness=1e-09
+ $X=0.3066 $Y=0.2025 $X2=0.3095 $Y2=0.2025
r22 26 91 3.59766 $w=1.5e-08 $l=2.25e-08 $layer=M1 $thickness=3.6e-08 $X=0.737
+ $Y=0.234 $X2=0.7145 $Y2=0.234
r23 26 32 2.5483 $w=1.79e-08 $l=1.8e-08 $layer=M1 $thickness=3.6e-08 $X=0.737
+ $Y=0.234 $X2=0.737 $Y2=0.216
r24 6 88 19.3796 $a=3.24e-16 $layer=V0LISD $X=0.648 $Y=0.2025 $X2=0.644
+ $Y2=0.234
r25 4 83 19.3796 $a=3.24e-16 $layer=V0LISD $X=0.486 $Y=0.2025 $X2=0.486
+ $Y2=0.234
r26 3 78 19.3796 $a=3.24e-16 $layer=V0LISD $X=0.324 $Y=0.2025 $X2=0.324
+ $Y2=0.234
r27 90 91 8.27824 $w=1.3e-08 $l=3.55e-08 $layer=M1 $thickness=3.6e-08 $X=0.679
+ $Y=0.234 $X2=0.7145 $Y2=0.234
r28 89 90 6.06293 $w=1.3e-08 $l=2.6e-08 $layer=M1 $thickness=3.6e-08 $X=0.653
+ $Y=0.234 $X2=0.679 $Y2=0.234
r29 88 89 2.09871 $w=1.3e-08 $l=9e-09 $layer=M1 $thickness=3.6e-08 $X=0.644
+ $Y=0.234 $X2=0.653 $Y2=0.234
r30 87 88 4.31401 $w=1.3e-08 $l=1.85e-08 $layer=M1 $thickness=3.6e-08 $X=0.6255
+ $Y=0.234 $X2=0.644 $Y2=0.234
r31 86 87 11.4263 $w=1.3e-08 $l=4.9e-08 $layer=M1 $thickness=3.6e-08 $X=0.5765
+ $Y=0.234 $X2=0.6255 $Y2=0.234
r32 85 86 12.5922 $w=1.3e-08 $l=5.4e-08 $layer=M1 $thickness=3.6e-08 $X=0.5225
+ $Y=0.234 $X2=0.5765 $Y2=0.234
r33 84 85 5.36336 $w=1.3e-08 $l=2.3e-08 $layer=M1 $thickness=3.6e-08 $X=0.4995
+ $Y=0.234 $X2=0.5225 $Y2=0.234
r34 83 84 3.14806 $w=1.3e-08 $l=1.35e-08 $layer=M1 $thickness=3.6e-08 $X=0.486
+ $Y=0.234 $X2=0.4995 $Y2=0.234
r35 82 83 2.68168 $w=1.3e-08 $l=1.15e-08 $layer=M1 $thickness=3.6e-08 $X=0.4745
+ $Y=0.234 $X2=0.486 $Y2=0.234
r36 81 82 13.6416 $w=1.3e-08 $l=5.85e-08 $layer=M1 $thickness=3.6e-08 $X=0.416
+ $Y=0.234 $X2=0.4745 $Y2=0.234
r37 80 81 15.1573 $w=1.3e-08 $l=6.5e-08 $layer=M1 $thickness=3.6e-08 $X=0.351
+ $Y=0.234 $X2=0.416 $Y2=0.234
r38 79 80 3.14806 $w=1.3e-08 $l=1.35e-08 $layer=M1 $thickness=3.6e-08 $X=0.3375
+ $Y=0.234 $X2=0.351 $Y2=0.234
r39 78 79 3.14806 $w=1.3e-08 $l=1.35e-08 $layer=M1 $thickness=3.6e-08 $X=0.324
+ $Y=0.234 $X2=0.3375 $Y2=0.234
r40 77 78 2.68168 $w=1.3e-08 $l=1.15e-08 $layer=M1 $thickness=3.6e-08 $X=0.3125
+ $Y=0.234 $X2=0.324 $Y2=0.234
r41 30 77 4.31401 $w=1.3e-08 $l=1.85e-08 $layer=M1 $thickness=3.6e-08 $X=0.294
+ $Y=0.234 $X2=0.3125 $Y2=0.234
r42 24 76 2.5483 $w=1.79e-08 $l=1.8e-08 $layer=M1 $thickness=3.6e-08 $X=0.269
+ $Y=0.234 $X2=0.269 $Y2=0.216
r43 24 30 4.18063 $w=1.48e-08 $l=2.5e-08 $layer=M1 $thickness=3.6e-08 $X=0.269
+ $Y=0.234 $X2=0.294 $Y2=0.234
r44 75 76 2.91487 $w=1.3e-08 $l=1.25e-08 $layer=M1 $thickness=3.6e-08 $X=0.269
+ $Y=0.2035 $X2=0.269 $Y2=0.216
r45 29 75 7.34548 $w=1.3e-08 $l=3.15e-08 $layer=M1 $thickness=3.6e-08 $X=0.269
+ $Y=0.172 $X2=0.269 $Y2=0.2035
r46 23 71 1.85116 $w=1.64615e-08 $l=1.3e-08 $layer=M1 $thickness=3.6e-08
+ $X=0.269 $Y=0.135 $X2=0.256 $Y2=0.135
r47 23 28 7.44771 $w=1.42162e-08 $l=3.7e-08 $layer=M1 $thickness=3.6e-08
+ $X=0.269 $Y=0.135 $X2=0.269 $Y2=0.098
r48 23 29 7.44771 $w=1.42162e-08 $l=3.7e-08 $layer=M1 $thickness=3.6e-08
+ $X=0.269 $Y=0.135 $X2=0.269 $Y2=0.172
r49 70 71 3.03147 $w=1.3e-08 $l=1.3e-08 $layer=M1 $thickness=3.6e-08 $X=0.243
+ $Y=0.135 $X2=0.256 $Y2=0.135
r50 69 70 2.56509 $w=1.3e-08 $l=1.1e-08 $layer=M1 $thickness=3.6e-08 $X=0.232
+ $Y=0.135 $X2=0.243 $Y2=0.135
r51 27 69 1.86552 $w=1.3e-08 $l=8e-09 $layer=M1 $thickness=3.6e-08 $X=0.224
+ $Y=0.135 $X2=0.232 $Y2=0.135
r52 67 66 16.4967 $w=2.1e-08 $l=4.85e-08 $layer=Gate_1 $thickness=5.6e-08
+ $X=0.243 $Y=0.2025 $X2=0.243 $Y2=0.154
r53 64 65 16.4967 $w=2.1e-08 $l=4.85e-08 $layer=Gate_1 $thickness=5.6e-08
+ $X=0.243 $Y=0.0675 $X2=0.243 $Y2=0.116
r54 18 48 6.27904 $w=2.09e-08 $layer=Gate_1 $thickness=5.24e-08 $X=0.243
+ $Y=0.135 $X2=0.243 $Y2=0.135
r55 18 65 6.6497 $w=2.04211e-08 $l=1.9e-08 $layer=Gate_1 $thickness=5.6e-08
+ $X=0.243 $Y=0.135 $X2=0.243 $Y2=0.116
r56 18 66 6.6497 $w=2.04211e-08 $l=1.9e-08 $layer=Gate_1 $thickness=5.6e-08
+ $X=0.243 $Y=0.135 $X2=0.243 $Y2=0.154
r57 61 60 16.4967 $w=2.1e-08 $l=4.85e-08 $layer=Gate_1 $thickness=5.6e-08
+ $X=0.189 $Y=0.2025 $X2=0.189 $Y2=0.154
r58 58 59 16.4967 $w=2.1e-08 $l=4.85e-08 $layer=Gate_1 $thickness=5.6e-08
+ $X=0.189 $Y=0.0675 $X2=0.189 $Y2=0.116
r59 17 45 6.54019 $w=2.09524e-08 $layer=Gate_1 $thickness=5.21905e-08 $X=0.189
+ $Y=0.135 $X2=0.189 $Y2=0.135
r60 17 59 6.6497 $w=2.04211e-08 $l=1.9e-08 $layer=Gate_1 $thickness=5.6e-08
+ $X=0.189 $Y=0.135 $X2=0.189 $Y2=0.116
r61 17 60 6.6497 $w=2.04211e-08 $l=1.9e-08 $layer=Gate_1 $thickness=5.6e-08
+ $X=0.189 $Y=0.135 $X2=0.189 $Y2=0.154
r62 55 54 16.4967 $w=2.1e-08 $l=4.85e-08 $layer=Gate_1 $thickness=5.6e-08
+ $X=0.135 $Y=0.2025 $X2=0.135 $Y2=0.154
r63 52 53 16.4967 $w=2.1e-08 $l=4.85e-08 $layer=Gate_1 $thickness=5.6e-08
+ $X=0.135 $Y=0.0675 $X2=0.135 $Y2=0.116
r64 16 43 6.54019 $w=2.09524e-08 $layer=Gate_1 $thickness=5.21905e-08 $X=0.135
+ $Y=0.135 $X2=0.135 $Y2=0.135
r65 16 53 6.6497 $w=2.04211e-08 $l=1.9e-08 $layer=Gate_1 $thickness=5.6e-08
+ $X=0.135 $Y=0.135 $X2=0.135 $Y2=0.116
r66 16 54 6.6497 $w=2.04211e-08 $l=1.9e-08 $layer=Gate_1 $thickness=5.6e-08
+ $X=0.135 $Y=0.135 $X2=0.135 $Y2=0.154
r67 48 70 19.3796 $a=3.24e-16 $layer=V0LIG $X=0.243 $Y=0.135 $X2=0.243 $Y2=0.135
r68 47 48 2.48102 $w=2.2e-08 $l=9.5e-09 $layer=LIG $thickness=4.8e-08 $X=0.2335
+ $Y=0.135 $X2=0.243 $Y2=0.135
r69 46 47 10.1729 $w=1.54914e-08 $l=1.75e-08 $layer=LIG $thickness=4.8e-08
+ $X=0.216 $Y=0.135 $X2=0.2335 $Y2=0.135
r70 45 46 12.6539 $w=1.77815e-08 $l=2.7e-08 $layer=LIG $thickness=4.8e-08
+ $X=0.189 $Y=0.135 $X2=0.216 $Y2=0.135
r71 44 45 12.6539 $w=1.77815e-08 $l=2.7e-08 $layer=LIG $thickness=4.8e-08
+ $X=0.162 $Y=0.135 $X2=0.189 $Y2=0.135
r72 43 44 12.6539 $w=1.77815e-08 $l=2.7e-08 $layer=LIG $thickness=4.8e-08
+ $X=0.135 $Y=0.135 $X2=0.162 $Y2=0.135
r73 42 43 12.6539 $w=1.77815e-08 $l=2.7e-08 $layer=LIG $thickness=4.8e-08
+ $X=0.108 $Y=0.135 $X2=0.135 $Y2=0.135
r74 1 36 6.54019 $w=2.09524e-08 $layer=Gate_1 $thickness=5.21905e-08 $X=0.081
+ $Y=0.135 $X2=0.081 $Y2=0.135
r75 1 42 12.6539 $w=1.77815e-08 $l=2.7e-08 $layer=LIG $thickness=4.8e-08
+ $X=0.081 $Y=0.135 $X2=0.108 $Y2=0.135
r76 39 38 14.6259 $w=2.1e-08 $l=4.3e-08 $layer=Gate_1 $thickness=5.6e-08
+ $X=0.081 $Y=0.2025 $X2=0.081 $Y2=0.1595
r77 37 38 2.7211 $w=2.1e-08 $l=8e-09 $layer=Gate_1 $thickness=5.6e-08 $X=0.081
+ $Y=0.1515 $X2=0.081 $Y2=0.1595
r78 36 37 5.79936 $w=2.03333e-08 $l=1.65e-08 $layer=Gate_1 $thickness=5.6e-08
+ $X=0.081 $Y=0.135 $X2=0.081 $Y2=0.1515
r79 35 36 5.79936 $w=2.03333e-08 $l=1.65e-08 $layer=Gate_1 $thickness=5.6e-08
+ $X=0.081 $Y=0.1185 $X2=0.081 $Y2=0.135
r80 34 35 2.7211 $w=2.1e-08 $l=8e-09 $layer=Gate_1 $thickness=5.6e-08 $X=0.081
+ $Y=0.1105 $X2=0.081 $Y2=0.1185
r81 33 34 14.6259 $w=2.1e-08 $l=4.3e-08 $layer=Gate_1 $thickness=5.6e-08
+ $X=0.081 $Y=0.0675 $X2=0.081 $Y2=0.1105
r82 33 15 14.6259 $w=2.1e-08 $l=4.3e-08 $layer=Gate_1 $thickness=5.6e-08
+ $X=0.081 $Y=0.0675 $X2=0.081 $Y2=0.0245
r83 6 22 1e-05 $l=2e-09 $X=0.648 $Y=0.2025 $X2=0.65 $Y2=0.2025
r84 4 21 1e-05 $l=2e-09 $X=0.486 $Y=0.2025 $X2=0.488 $Y2=0.2025
.ends

.subckt PM_AND3x4_ASAP7_75t_R%B vss 22 8 14 25 3 1 7 6 4 5
c1 1 vss 0.00739927f $X=0.5035 $Y=0.135
c2 3 vss 0.0627172f $X=0.513 $Y=0.0245
c3 4 vss 0.051554f $X=0.567 $Y=0.135
c4 5 vss 0.00153674f $X=0.513 $Y=0.108
c5 6 vss 0.00284871f $X=0.513 $Y=0.198
c6 7 vss 0.0046601f $X=0.513 $Y=0.1215
r1 6 23 6.16517 $w=1.44286e-08 $l=3.15e-08 $layer=M1 $thickness=3.6e-08
+ $X=0.513 $Y=0.198 $X2=0.513 $Y2=0.1665
r2 5 7 1.96775 $w=1.63333e-08 $l=1.35e-08 $layer=M1 $thickness=3.6e-08 $X=0.513
+ $Y=0.108 $X2=0.513 $Y2=0.1215
r3 25 26 16.6668 $w=2.1e-08 $l=4.9e-08 $layer=Gate_1 $thickness=5.6e-08
+ $X=0.567 $Y=0.0675 $X2=0.567 $Y2=0.1165
r4 4 20 6.74717 $w=2e-08 $layer=Gate_1 $thickness=5.2e-08 $X=0.567 $Y=0.135
+ $X2=0.567 $Y2=0.135
r5 4 26 6.46262 $w=2.04595e-08 $l=1.85e-08 $layer=Gate_1 $thickness=5.6e-08
+ $X=0.567 $Y=0.135 $X2=0.567 $Y2=0.1165
r6 22 23 7.34548 $w=1.3e-08 $l=3.15e-08 $layer=M1 $thickness=3.6e-08 $X=0.512
+ $Y=0.137 $X2=0.513 $Y2=0.1665
r7 22 7 3.14806 $w=1.3e-08 $l=1.35e-08 $layer=M1 $thickness=3.6e-08 $X=0.512
+ $Y=0.137 $X2=0.513 $Y2=0.1215
r8 19 20 20.114 $w=1.57815e-08 $l=2.7e-08 $layer=LIG $thickness=4.8e-08 $X=0.54
+ $Y=0.135 $X2=0.567 $Y2=0.135
r9 17 19 17.097 $w=1.34914e-08 $l=1.75e-08 $layer=LIG $thickness=4.8e-08
+ $X=0.5225 $Y=0.135 $X2=0.54 $Y2=0.135
r10 16 17 3.01694 $w=2e-08 $l=9.5e-09 $layer=LIG $thickness=4.8e-08 $X=0.513
+ $Y=0.135 $X2=0.5225 $Y2=0.135
r11 22 16 19.3796 $a=3.24e-16 $layer=V0LIG $X=0.512 $Y=0.137 $X2=0.513 $Y2=0.135
r12 1 16 3.01694 $w=2e-08 $l=9.5e-09 $layer=LIG $thickness=4.8e-08 $X=0.5035
+ $Y=0.135 $X2=0.513 $Y2=0.135
r13 14 13 14.6259 $w=2.1e-08 $l=4.3e-08 $layer=Gate_1 $thickness=5.6e-08
+ $X=0.513 $Y=0.2025 $X2=0.513 $Y2=0.1595
r14 12 13 2.89117 $w=2.1e-08 $l=8.5e-09 $layer=Gate_1 $thickness=5.6e-08
+ $X=0.513 $Y=0.151 $X2=0.513 $Y2=0.1595
r15 11 12 5.61228 $w=2.0375e-08 $l=1.6e-08 $layer=Gate_1 $thickness=5.6e-08
+ $X=0.513 $Y=0.135 $X2=0.513 $Y2=0.151
r16 11 17 3.73024 $w=2e-08 $l=9.5e-09 $layer=Gate_1 $thickness=5.5619e-08
+ $X=0.513 $Y=0.135 $X2=0.5225 $Y2=0.135
r17 11 16 6.4296 $w=2e-08 $layer=Gate_1 $thickness=5.22105e-08 $X=0.513
+ $Y=0.135 $X2=0.513 $Y2=0.135
r18 10 11 5.61228 $w=2.0375e-08 $l=1.6e-08 $layer=Gate_1 $thickness=5.6e-08
+ $X=0.513 $Y=0.119 $X2=0.513 $Y2=0.135
r19 9 10 2.89117 $w=2.1e-08 $l=8.5e-09 $layer=Gate_1 $thickness=5.6e-08
+ $X=0.513 $Y=0.1105 $X2=0.513 $Y2=0.119
r20 8 9 14.6259 $w=2.1e-08 $l=4.3e-08 $layer=Gate_1 $thickness=5.6e-08 $X=0.513
+ $Y=0.0675 $X2=0.513 $Y2=0.1105
r21 8 3 14.6259 $w=2.1e-08 $l=4.3e-08 $layer=Gate_1 $thickness=5.6e-08 $X=0.513
+ $Y=0.0675 $X2=0.513 $Y2=0.0245
.ends

.subckt PM_AND3x4_ASAP7_75t_R%A vss 26 8 14 23 3 1 7 4 6 5
c1 1 vss 0.00394153f $X=0.675 $Y=0.135
c2 3 vss 0.00899933f $X=0.621 $Y=0.135
c3 4 vss 0.060985f $X=0.675 $Y=0.0245
c4 5 vss 0.00231041f $X=0.621 $Y=0.108
c5 6 vss 0.00271f $X=0.621 $Y=0.198
c6 7 vss 0.00482628f $X=0.621 $Y=0.1215
r1 6 27 6.16517 $w=1.44286e-08 $l=3.15e-08 $layer=M1 $thickness=3.6e-08
+ $X=0.621 $Y=0.198 $X2=0.621 $Y2=0.1665
r2 5 7 1.96775 $w=1.63333e-08 $l=1.35e-08 $layer=M1 $thickness=3.6e-08 $X=0.621
+ $Y=0.108 $X2=0.621 $Y2=0.1215
r3 26 27 7.34548 $w=1.3e-08 $l=3.15e-08 $layer=M1 $thickness=3.6e-08 $X=0.62
+ $Y=0.137 $X2=0.621 $Y2=0.1665
r4 26 7 3.14806 $w=1.3e-08 $l=1.35e-08 $layer=M1 $thickness=3.6e-08 $X=0.62
+ $Y=0.137 $X2=0.621 $Y2=0.1215
r5 23 24 16.6668 $w=2.1e-08 $l=4.9e-08 $layer=Gate_1 $thickness=5.6e-08
+ $X=0.621 $Y=0.0675 $X2=0.621 $Y2=0.1165
r6 3 18 6.4296 $w=2e-08 $layer=Gate_1 $thickness=5.22105e-08 $X=0.621 $Y=0.135
+ $X2=0.621 $Y2=0.135
r7 3 24 6.46262 $w=2.04595e-08 $l=1.85e-08 $layer=Gate_1 $thickness=5.6e-08
+ $X=0.621 $Y=0.135 $X2=0.621 $Y2=0.1165
r8 18 19 3.01694 $w=2e-08 $l=9.5e-09 $layer=LIG $thickness=4.8e-08 $X=0.621
+ $Y=0.135 $X2=0.6305 $Y2=0.135
r9 26 18 19.3796 $a=3.24e-16 $layer=V0LIG $X=0.62 $Y=0.137 $X2=0.621 $Y2=0.135
r10 16 19 17.097 $w=1.34914e-08 $l=1.75e-08 $layer=LIG $thickness=4.8e-08
+ $X=0.648 $Y=0.135 $X2=0.6305 $Y2=0.135
r11 1 11 6.74717 $w=2e-08 $layer=Gate_1 $thickness=5.2e-08 $X=0.675 $Y=0.135
+ $X2=0.675 $Y2=0.135
r12 1 16 20.114 $w=1.57815e-08 $l=2.7e-08 $layer=LIG $thickness=4.8e-08
+ $X=0.675 $Y=0.135 $X2=0.648 $Y2=0.135
r13 14 13 14.6259 $w=2.1e-08 $l=4.3e-08 $layer=Gate_1 $thickness=5.6e-08
+ $X=0.675 $Y=0.2025 $X2=0.675 $Y2=0.1595
r14 12 13 2.89117 $w=2.1e-08 $l=8.5e-09 $layer=Gate_1 $thickness=5.6e-08
+ $X=0.675 $Y=0.151 $X2=0.675 $Y2=0.1595
r15 11 12 5.61228 $w=2.0375e-08 $l=1.6e-08 $layer=Gate_1 $thickness=5.6e-08
+ $X=0.675 $Y=0.135 $X2=0.675 $Y2=0.151
r16 10 11 5.61228 $w=2.0375e-08 $l=1.6e-08 $layer=Gate_1 $thickness=5.6e-08
+ $X=0.675 $Y=0.119 $X2=0.675 $Y2=0.135
r17 9 10 2.89117 $w=2.1e-08 $l=8.5e-09 $layer=Gate_1 $thickness=5.6e-08
+ $X=0.675 $Y=0.1105 $X2=0.675 $Y2=0.119
r18 8 9 14.6259 $w=2.1e-08 $l=4.3e-08 $layer=Gate_1 $thickness=5.6e-08 $X=0.675
+ $Y=0.0675 $X2=0.675 $Y2=0.1105
r19 8 4 14.6259 $w=2.1e-08 $l=4.3e-08 $layer=Gate_1 $thickness=5.6e-08 $X=0.675
+ $Y=0.0675 $X2=0.675 $Y2=0.0245
.ends

* End of included file AND3x4_ASAP7_75t_R.pex.sp.pex

*
.subckt AND3x4_ASAP7_75t_CUSTOM_4_25_0_7 VSS VDD C B A Y
*
* VSS VSS
* VDD VDD
* C C
* B B
* A A
* Y Y
*
*

M0 N_M0_d N_M0_g VSS VSS nmos_rvt L=2e-08 W=8.1e-08 nfin=3 $X=0.071 $Y=0.027
M1 N_M1_d N_M1_g VSS VSS nmos_rvt L=2e-08 W=8.1e-08 nfin=3 $X=0.125 $Y=0.027
M2 N_M2_d N_M2_g VSS VSS nmos_rvt L=2e-08 W=8.1e-08 nfin=3 $X=0.179 $Y=0.027
M3 N_M3_d N_M3_g VSS VSS nmos_rvt L=2e-08 W=8.1e-08 nfin=3 $X=0.233 $Y=0.027
M4 N_M4_d N_M4_g VSS VSS nmos_rvt L=2e-08 W=8.1e-08 nfin=3 $X=0.287 $Y=0.027
M5 N_M5_d N_M5_g VSS VSS nmos_rvt L=2e-08 W=8.1e-08 nfin=3 $X=0.341 $Y=0.027
M6 N_M6_d N_M6_g N_M6_s VSS nmos_rvt L=2e-08 W=8.1e-08 nfin=3 $X=0.503 $Y=0.027
M7 N_M7_d N_M7_g N_M7_s VSS nmos_rvt L=2e-08 W=8.1e-08 nfin=3 $X=0.557 $Y=0.027
M8 N_M8_d N_M8_g N_M8_s VSS nmos_rvt L=2e-08 W=8.1e-08 nfin=3 $X=0.611 $Y=0.027
M9 N_M9_d N_M9_g N_M9_s VSS nmos_rvt L=2e-08 W=8.1e-08 nfin=3 $X=0.665 $Y=0.027
M10 N_M10_d N_M10_g VDD VDD pmos_rvt L=2e-08 W=8.1e-08 nfin=3 $X=0.071 $Y=0.162
M11 N_M11_d N_M11_g VDD VDD pmos_rvt L=2e-08 W=8.1e-08 nfin=3 $X=0.125 $Y=0.162
M12 N_M12_d N_M12_g VDD VDD pmos_rvt L=2e-08 W=8.1e-08 nfin=3 $X=0.179 $Y=0.162
M13 N_M13_d N_M13_g VDD VDD pmos_rvt L=2e-08 W=8.1e-08 nfin=3 $X=0.233 $Y=0.162
M14 N_M14_d N_M14_g VDD VDD pmos_rvt L=2e-08 W=8.1e-08 nfin=3 $X=0.287 $Y=0.162
M15 VDD N_M15_g N_M15_s VDD pmos_rvt L=2e-08 W=8.1e-08 nfin=3 $X=0.503 $Y=0.162
M16 VDD N_M16_g N_M16_s VDD pmos_rvt L=2e-08 W=8.1e-08 nfin=3 $X=0.665 $Y=0.162

* .include "AND3x4_ASAP7_75t_R.pex.sp.pxi"

* Start of included file AND3x4_ASAP7_75t_R.pex.sp.pxi
x_PM_AND3x4_ASAP7_75t_R%C vss C N_M4_g N_M14_g N_M5_g N_C_3 N_C_5 N_C_1 N_C_4
+ PM_AND3x4_ASAP7_75t_R%C
cc_1 N_C_3 N_3_23 0.000214835f $X=0.297 $Y=0.0245
cc_2 N_C_3 N_3_3 0.00335146f $X=0.297 $Y=0.0245
cc_3 N_C_3 N_3_4 0.000283597f $X=0.297 $Y=0.0245
cc_4 N_C_3 N_3_1 0.000321269f $X=0.297 $Y=0.0245
cc_5 N_C_3 N_3_29 0.00055704f $X=0.297 $Y=0.0245
cc_6 N_C_3 N_3_28 0.000613942f $X=0.297 $Y=0.0245
cc_7 N_C_3 N_3_18 0.00174576f $X=0.297 $Y=0.0245
cc_8 N_C_5 N_3_30 0.00179094f $X=0.351 $Y=0.108
cc_9 N_C_1 N_3_20 0.0032608f $X=0.297 $Y=0.135
cc_10 N_C_5 N_3_3 0.00358445f $X=0.351 $Y=0.108
cc_11 N_C_4 N_3_20 0.0197675f $X=0.351 $Y=0.135
cc_12 N_C_3 N_3_20 0.0546336f $X=0.297 $Y=0.0245
x_PM_AND3x4_ASAP7_75t_R%Y vss Y N_M0_d N_M1_d N_M2_d N_M3_d N_M10_d N_M11_d
+ N_M12_d N_M13_d N_Y_15 N_Y_20 N_Y_21 N_Y_2 N_Y_1 N_Y_4 N_Y_3 N_Y_13 N_Y_14
+ N_Y_16 PM_AND3x4_ASAP7_75t_R%Y
cc_13 N_Y_15 N_3_28 0.00139246f $X=0.0935 $Y=0.2025
cc_14 N_Y_15 N_3_24 0.000775983f $X=0.0935 $Y=0.2025
cc_15 N_Y_15 N_3_1 0.0010521f $X=0.0935 $Y=0.2025
cc_16 N_Y_15 N_3_27 0.000777052f $X=0.0935 $Y=0.2025
cc_17 N_Y_15 N_3_18 0.00162771f $X=0.0935 $Y=0.2025
cc_18 N_Y_15 N_3_16 0.0381953f $X=0.0935 $Y=0.2025
cc_19 N_Y_15 N_3_29 0.000914813f $X=0.0935 $Y=0.2025
cc_20 N_Y_20 N_3_16 0.00113032f $X=0.0675 $Y=0.036
cc_21 N_Y_21 N_3_16 0.00128033f $X=0.0675 $Y=0.234
cc_22 N_Y_2 N_3_15 0.00162314f $X=0.108 $Y=0.2025
cc_23 N_Y_1 N_3_15 0.00162374f $X=0.108 $Y=0.0675
cc_24 N_Y_4 N_3_17 0.0020289f $X=0.216 $Y=0.2025
cc_25 N_Y_3 N_3_17 0.00203101f $X=0.216 $Y=0.0675
cc_26 N_Y_13 N_3_1 0.00937074f $X=0.0935 $Y=0.0675
cc_27 N_Y_13 N_3_15 0.0284787f $X=0.0935 $Y=0.0675
cc_28 N_Y_14 N_3_18 0.0645377f $X=0.2015 $Y=0.0675
cc_29 N_Y_16 N_3_17 0.0645138f $X=0.2015 $Y=0.2025
cc_30 N_Y_15 N_3_15 0.0650867f $X=0.0935 $Y=0.2025
x_PM_AND3x4_ASAP7_75t_R%8 vss N_M4_d N_M5_d N_M6_d N_M7_d N_8_9 N_8_1 N_8_7
+ N_8_2 N_8_8 PM_AND3x4_ASAP7_75t_R%8
cc_31 N_8_9 N_3_19 0.000134752f $X=0.3125 $Y=0.036
cc_32 N_8_9 N_3_4 0.000721729f $X=0.3125 $Y=0.036
cc_33 N_8_9 N_3_28 0.00171654f $X=0.3125 $Y=0.036
cc_34 N_8_9 N_C_3 0.00137691f $X=0.3125 $Y=0.036
cc_35 N_8_1 N_C_3 0.0018531f $X=0.324 $Y=0.0675
cc_36 N_8_1 N_C_5 0.0018939f $X=0.324 $Y=0.0675
cc_37 N_8_7 N_C_1 0.00204031f $X=0.3095 $Y=0.0675
cc_38 N_8_7 N_C_4 0.0177965f $X=0.3095 $Y=0.0675
cc_39 N_8_7 N_C_3 0.0472235f $X=0.3095 $Y=0.0675
cc_40 N_8_2 N_B_4 0.00164948f $X=0.54 $Y=0.0675
cc_41 N_8_8 N_B_1 0.00196137f $X=0.5255 $Y=0.0675
cc_42 N_8_8 N_B_3 0.0358383f $X=0.5255 $Y=0.0675
cc_43 N_8_8 N_B_4 0.0297428f $X=0.5255 $Y=0.0675
x_PM_AND3x4_ASAP7_75t_R%9 vss N_M6_s N_M7_s N_M8_s N_M9_s N_9_13 N_9_3 N_9_2
+ N_9_11 N_9_1 N_9_10 N_9_12 PM_AND3x4_ASAP7_75t_R%9
cc_44 N_9_13 N_3_6 0.000146956f $X=0.4745 $Y=0.072
cc_45 N_9_13 N_3_4 0.000156164f $X=0.4745 $Y=0.072
cc_46 N_9_13 N_3_5 0.00104469f $X=0.4745 $Y=0.072
cc_47 N_9_13 N_3_21 0.000200457f $X=0.4745 $Y=0.072
cc_48 N_9_13 N_3_19 0.000875987f $X=0.4745 $Y=0.072
cc_49 N_9_3 N_3_31 0.00102184f $X=0.696 $Y=0.0675
cc_50 N_9_2 N_3_5 0.00115916f $X=0.594 $Y=0.0675
cc_51 N_9_3 N_3_19 0.00141072f $X=0.696 $Y=0.0675
cc_52 N_9_3 N_3_32 0.00187948f $X=0.696 $Y=0.0675
cc_53 N_9_3 N_3_5 0.00752229f $X=0.696 $Y=0.0675
cc_54 N_9_13 N_3_31 0.00813266f $X=0.4745 $Y=0.072
cc_55 N_9_11 N_B_1 0.000478593f $X=0.5795 $Y=0.0675
cc_56 N_9_1 N_B_3 0.00100316f $X=0.486 $Y=0.0675
cc_57 N_9_10 N_B_1 0.00164976f $X=0.488 $Y=0.0675
cc_58 N_9_13 N_B_5 0.00466068f $X=0.4745 $Y=0.072
cc_59 N_9_10 N_B_3 0.0332078f $X=0.488 $Y=0.0675
cc_60 N_9_11 N_B_4 0.0357225f $X=0.5795 $Y=0.0675
cc_61 N_9_12 N_A_3 0.000917452f $X=0.6875 $Y=0.0675
cc_62 N_9_3 N_A_4 0.00150342f $X=0.696 $Y=0.0675
cc_63 N_9_3 N_A_1 0.00183796f $X=0.696 $Y=0.0675
cc_64 N_9_13 N_A_5 0.00470751f $X=0.4745 $Y=0.072
cc_65 N_9_11 N_A_3 0.0330786f $X=0.5795 $Y=0.0675
cc_66 N_9_12 N_A_4 0.0353537f $X=0.6875 $Y=0.0675
cc_67 N_9_13 N_8_2 0.000802983f $X=0.4745 $Y=0.072
cc_68 N_9_11 N_8_8 0.00113405f $X=0.5795 $Y=0.0675
cc_69 N_9_1 N_8_2 0.00166773f $X=0.486 $Y=0.0675
cc_70 N_9_2 N_8_2 0.00383953f $X=0.594 $Y=0.0675
cc_71 N_9_13 N_8_9 0.0104846f $X=0.4745 $Y=0.072
x_PM_AND3x4_ASAP7_75t_R%3 vss N_M0_g N_M10_g N_M1_g N_M11_g N_M2_g N_M12_g
+ N_M3_g N_M13_g N_M14_d N_M15_s N_M16_s N_M8_d N_M9_d N_3_23 N_3_3 N_3_4 N_3_1
+ N_3_29 N_3_28 N_3_18 N_3_30 N_3_20 N_3_6 N_3_21 N_3_5 N_3_32 N_3_22 N_3_19
+ N_3_24 N_3_27 N_3_16 N_3_15 N_3_17 N_3_31 PM_AND3x4_ASAP7_75t_R%3
x_PM_AND3x4_ASAP7_75t_R%B vss B N_M6_g N_M15_g N_M7_g N_B_3 N_B_1 N_B_7 N_B_6
+ N_B_4 N_B_5 PM_AND3x4_ASAP7_75t_R%B
cc_72 N_B_3 N_3_6 0.000207433f $X=0.513 $Y=0.0245
cc_73 N_B_3 N_3_4 0.00211691f $X=0.513 $Y=0.0245
cc_74 N_B_1 N_3_21 0.001002f $X=0.5035 $Y=0.135
cc_75 N_B_7 N_3_4 0.00104241f $X=0.513 $Y=0.1215
cc_76 N_B_6 N_3_30 0.00521198f $X=0.513 $Y=0.198
cc_77 N_B_3 N_3_21 0.0349182f $X=0.513 $Y=0.0245
x_PM_AND3x4_ASAP7_75t_R%A vss A N_M9_g N_M16_g N_M8_g N_A_3 N_A_1 N_A_7 N_A_4
+ N_A_6 N_A_5 PM_AND3x4_ASAP7_75t_R%A
cc_78 N_A_3 N_3_6 0.000394872f $X=0.621 $Y=0.135
cc_79 N_A_3 N_3_5 0.00260834f $X=0.621 $Y=0.135
cc_80 N_A_1 N_3_32 0.000906587f $X=0.675 $Y=0.135
cc_81 N_A_7 N_3_6 0.00109677f $X=0.621 $Y=0.1215
cc_82 N_A_4 N_3_22 0.0119706f $X=0.675 $Y=0.0245
cc_83 N_A_4 N_3_6 0.00248718f $X=0.675 $Y=0.0245
cc_84 N_A_1 N_3_22 0.00458702f $X=0.675 $Y=0.135
cc_85 N_A_6 N_3_30 0.00535502f $X=0.621 $Y=0.198
cc_86 N_A_3 N_3_22 0.021275f $X=0.621 $Y=0.135
cc_87 N_A_4 N_3_19 0.0376854f $X=0.675 $Y=0.0245
cc_88 N_A_3 N_3_19 0.0690301f $X=0.621 $Y=0.135
cc_89 N_A_1 N_B_1 0.00157992f $X=0.675 $Y=0.135
cc_90 N_A_3 N_B_4 0.0125599f $X=0.621 $Y=0.135

* End of included file AND3x4_ASAP7_75t_R.pex.sp.pxi
.ends

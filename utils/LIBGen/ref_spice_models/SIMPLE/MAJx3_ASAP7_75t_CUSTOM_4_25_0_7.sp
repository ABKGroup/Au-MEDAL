.subckt PM_MAJx3_ASAP7_75t_R%10 vss 2 3 1
c1 1 vss 0.000752488f $X=0.162 $Y=0.0675
r1 2 1 0.209877 $w=8.1e-08 $l=1.7e-08 $layer=N_src_drn $thickness=1e-09
+ $X=0.1446 $Y=0.0675 $X2=0.162 $Y2=0.0675
r2 3 1 0.209877 $w=8.1e-08 $l=1.7e-08 $layer=N_src_drn $thickness=1e-09
+ $X=0.1793 $Y=0.0675 $X2=0.162 $Y2=0.0675
.ends

.subckt PM_MAJx3_ASAP7_75t_R%11 vss 2 3 1
c1 1 vss 0.000759513f $X=0.162 $Y=0.2025
r1 2 1 0.209877 $w=8.1e-08 $l=1.7e-08 $layer=P_src_drn $thickness=1e-09
+ $X=0.1793 $Y=0.2025 $X2=0.162 $Y2=0.2025
r2 3 1 0.209877 $w=8.1e-08 $l=1.7e-08 $layer=P_src_drn $thickness=1e-09
+ $X=0.1446 $Y=0.2025 $X2=0.162 $Y2=0.2025
.ends

.subckt PM_MAJx3_ASAP7_75t_R%A vss 14 5 11 3 4 1
c1 1 vss 0.00065611f $X=0.081 $Y=0.135
c2 3 vss 0.0218102f $X=0.081 $Y=0.0245
c3 4 vss 0.0040061f $X=0.081 $Y=0.135
r1 14 15 1.22425 $w=1.3e-08 $l=5.2e-09 $layer=M1 $thickness=3.6e-08 $X=0.082
+ $Y=0.116 $X2=0.081 $Y2=0.1212
r2 4 15 3.20636 $w=1.3e-08 $l=1.38e-08 $layer=M1 $thickness=3.6e-08 $X=0.081
+ $Y=0.135 $X2=0.081 $Y2=0.1212
r3 1 8 10.4265 $w=1.765e-08 $layer=LIG $thickness=5.2e-08 $X=0.081 $Y=0.135
+ $X2=0.081 $Y2=0.135
r4 1 4 19.3796 $a=3.24e-16 $layer=V0LIG $X=0.081 $Y=0.135 $X2=0.081 $Y2=0.135
r5 11 10 14.6259 $w=2.1e-08 $l=4.3e-08 $layer=Gate_1 $thickness=5.6e-08
+ $X=0.081 $Y=0.2025 $X2=0.081 $Y2=0.1595
r6 9 10 2.7211 $w=2.1e-08 $l=8e-09 $layer=Gate_1 $thickness=5.6e-08 $X=0.081
+ $Y=0.1515 $X2=0.081 $Y2=0.1595
r7 8 9 5.79936 $w=2.03333e-08 $l=1.65e-08 $layer=Gate_1 $thickness=5.6e-08
+ $X=0.081 $Y=0.135 $X2=0.081 $Y2=0.1515
r8 7 8 5.79936 $w=2.03333e-08 $l=1.65e-08 $layer=Gate_1 $thickness=5.6e-08
+ $X=0.081 $Y=0.1185 $X2=0.081 $Y2=0.135
r9 6 7 2.7211 $w=2.1e-08 $l=8e-09 $layer=Gate_1 $thickness=5.6e-08 $X=0.081
+ $Y=0.1105 $X2=0.081 $Y2=0.1185
r10 5 6 14.6259 $w=2.1e-08 $l=4.3e-08 $layer=Gate_1 $thickness=5.6e-08 $X=0.081
+ $Y=0.0675 $X2=0.081 $Y2=0.1105
r11 5 3 14.6259 $w=2.1e-08 $l=4.3e-08 $layer=Gate_1 $thickness=5.6e-08 $X=0.081
+ $Y=0.0675 $X2=0.081 $Y2=0.0245
.ends

.subckt PM_MAJx3_ASAP7_75t_R%8 vss 12 13 21 7 8 2 9 1
c1 1 vss 0.00603512f $X=0.054 $Y=0.2025
c2 2 vss 0.00871466f $X=0.27 $Y=0.2025
c3 7 vss 0.0358341f $X=0.056 $Y=0.2025
c4 8 vss 0.00452215f $X=0.2555 $Y=0.2025
c5 9 vss 0.0208652f $X=0.2205 $Y=0.234
r1 21 20 0.0308642 $w=8.1e-08 $l=2.5e-09 $layer=P_src_drn $thickness=1e-09
+ $X=0.0713 $Y=0.2025 $X2=0.0685 $Y2=0.2025
r2 7 20 0.154321 $w=8.1e-08 $l=1.25e-08 $layer=P_src_drn $thickness=1e-09
+ $X=0.056 $Y=0.2025 $X2=0.0685 $Y2=0.2025
r3 1 18 19.3796 $a=3.24e-16 $layer=V0LISD $X=0.054 $Y=0.2025 $X2=0.054 $Y2=0.234
r4 18 19 9.0944 $w=1.3e-08 $l=3.9e-08 $layer=M1 $thickness=3.6e-08 $X=0.054
+ $Y=0.234 $X2=0.093 $Y2=0.234
r5 16 19 13.6416 $w=1.3e-08 $l=5.85e-08 $layer=M1 $thickness=3.6e-08 $X=0.1515
+ $Y=0.234 $X2=0.093 $Y2=0.234
r6 9 14 11.5429 $w=1.3e-08 $l=4.95e-08 $layer=M1 $thickness=3.6e-08 $X=0.2205
+ $Y=0.234 $X2=0.27 $Y2=0.234
r7 9 16 16.0901 $w=1.3e-08 $l=6.9e-08 $layer=M1 $thickness=3.6e-08 $X=0.2205
+ $Y=0.234 $X2=0.1515 $Y2=0.234
r8 2 14 19.3796 $a=3.24e-16 $layer=V0LISD $X=0.27 $Y=0.2025 $X2=0.27 $Y2=0.234
r9 13 11 0.0308642 $w=8.1e-08 $l=2.5e-09 $layer=P_src_drn $thickness=1e-09
+ $X=0.2873 $Y=0.2025 $X2=0.2845 $Y2=0.2025
r10 2 11 0.179012 $w=8.1e-08 $l=1.45e-08 $layer=P_src_drn $thickness=1e-09
+ $X=0.27 $Y=0.2025 $X2=0.2845 $Y2=0.2025
r11 8 2 0.179012 $w=8.1e-08 $l=1.45e-08 $layer=P_src_drn $thickness=1e-09
+ $X=0.2555 $Y=0.2025 $X2=0.27 $Y2=0.2025
r12 12 8 0.0308642 $w=8.1e-08 $l=2.5e-09 $layer=P_src_drn $thickness=1e-09
+ $X=0.2526 $Y=0.2025 $X2=0.2555 $Y2=0.2025
r13 1 7 1e-05 $l=2e-09 $X=0.054 $Y=0.2025 $X2=0.056 $Y2=0.2025
.ends

.subckt PM_MAJx3_ASAP7_75t_R%Y vss 32 26 27 41 44 45 47 15 2 1 19 16 13 14
c1 1 vss 0.00893579f $X=0.378 $Y=0.0675
c2 2 vss 0.0097728f $X=0.378 $Y=0.2025
c3 3 vss 0.00847976f $X=0.486 $Y=0.0675
c4 4 vss 0.00847976f $X=0.486 $Y=0.2025
c5 13 vss 0.00445354f $X=0.3635 $Y=0.0675
c6 14 vss 0.0369651f $X=0.4715 $Y=0.0675
c7 15 vss 0.00446229f $X=0.3635 $Y=0.2025
c8 16 vss 0.0369632f $X=0.4715 $Y=0.2025
c9 17 vss 0.00208016f $X=0.459 $Y=0.036
c10 18 vss 0.00208469f $X=0.459 $Y=0.234
c11 19 vss 0.008124f $X=0.3665 $Y=0.036
c12 20 vss 0.00963605f $X=0.3865 $Y=0.234
c13 21 vss 0.00504282f $X=0.459 $Y=0.054
c14 22 vss 0.00364507f $X=0.486 $Y=0.036
c15 23 vss 0.0037128f $X=0.486 $Y=0.234
r1 16 4 0.154321 $w=8.1e-08 $l=1.25e-08 $layer=P_src_drn $thickness=1e-09
+ $X=0.4715 $Y=0.2025 $X2=0.486 $Y2=0.2025
r2 47 16 0.0308642 $w=8.1e-08 $l=2.5e-09 $layer=P_src_drn $thickness=1e-09
+ $X=0.4686 $Y=0.2025 $X2=0.4715 $Y2=0.2025
r3 45 43 0.0308642 $w=8.1e-08 $l=2.5e-09 $layer=P_src_drn $thickness=1e-09
+ $X=0.3953 $Y=0.2025 $X2=0.3925 $Y2=0.2025
r4 2 43 0.179012 $w=8.1e-08 $l=1.45e-08 $layer=P_src_drn $thickness=1e-09
+ $X=0.378 $Y=0.2025 $X2=0.3925 $Y2=0.2025
r5 15 2 0.179012 $w=8.1e-08 $l=1.45e-08 $layer=P_src_drn $thickness=1e-09
+ $X=0.3635 $Y=0.2025 $X2=0.378 $Y2=0.2025
r6 44 15 0.0308642 $w=8.1e-08 $l=2.5e-09 $layer=P_src_drn $thickness=1e-09
+ $X=0.3606 $Y=0.2025 $X2=0.3635 $Y2=0.2025
r7 4 23 19.3796 $a=3.24e-16 $layer=V0LISD $X=0.486 $Y=0.2025 $X2=0.486 $Y2=0.234
r8 2 38 19.3796 $a=3.24e-16 $layer=V0LISD $X=0.378 $Y=0.2025 $X2=0.3775
+ $Y2=0.234
r9 14 3 0.154321 $w=8.1e-08 $l=1.25e-08 $layer=N_src_drn $thickness=1e-09
+ $X=0.4715 $Y=0.0675 $X2=0.486 $Y2=0.0675
r10 41 14 0.0308642 $w=8.1e-08 $l=2.5e-09 $layer=N_src_drn $thickness=1e-09
+ $X=0.4686 $Y=0.0675 $X2=0.4715 $Y2=0.0675
r11 20 36 7.46207 $w=1.3e-08 $l=3.2e-08 $layer=M1 $thickness=3.6e-08 $X=0.3865
+ $Y=0.234 $X2=0.4185 $Y2=0.234
r12 20 38 2.09871 $w=1.3e-08 $l=9e-09 $layer=M1 $thickness=3.6e-08 $X=0.3865
+ $Y=0.234 $X2=0.3775 $Y2=0.234
r13 3 22 19.3796 $a=3.24e-16 $layer=V0LISD $X=0.486 $Y=0.0675 $X2=0.486
+ $Y2=0.036
r14 18 35 3.01711 $w=1.55e-08 $l=1.8e-08 $layer=M1 $thickness=3.6e-08 $X=0.459
+ $Y=0.234 $X2=0.459 $Y2=0.216
r15 18 36 8.26388 $w=1.41111e-08 $l=4.05e-08 $layer=M1 $thickness=3.6e-08
+ $X=0.459 $Y=0.234 $X2=0.4185 $Y2=0.234
r16 18 23 5.11582 $w=1.46667e-08 $l=2.7e-08 $layer=M1 $thickness=3.6e-08
+ $X=0.459 $Y=0.234 $X2=0.486 $Y2=0.234
r17 34 35 8.86121 $w=1.3e-08 $l=3.8e-08 $layer=M1 $thickness=3.6e-08 $X=0.459
+ $Y=0.178 $X2=0.459 $Y2=0.216
r18 33 34 6.8791 $w=1.3e-08 $l=2.95e-08 $layer=M1 $thickness=3.6e-08 $X=0.459
+ $Y=0.1485 $X2=0.459 $Y2=0.178
r19 32 33 0.23319 $w=1.3e-08 $l=1e-09 $layer=M1 $thickness=3.6e-08 $X=0.459
+ $Y=0.1475 $X2=0.459 $Y2=0.1485
r20 32 31 9.91056 $w=1.3e-08 $l=4.25e-08 $layer=M1 $thickness=3.6e-08 $X=0.459
+ $Y=0.1475 $X2=0.459 $Y2=0.105
r21 21 31 11.8927 $w=1.3e-08 $l=5.1e-08 $layer=M1 $thickness=3.6e-08 $X=0.459
+ $Y=0.054 $X2=0.459 $Y2=0.105
r22 17 30 8.26388 $w=1.41111e-08 $l=4.05e-08 $layer=M1 $thickness=3.6e-08
+ $X=0.459 $Y=0.036 $X2=0.4185 $Y2=0.036
r23 17 21 3.01711 $w=1.55e-08 $l=1.8e-08 $layer=M1 $thickness=3.6e-08 $X=0.459
+ $Y=0.036 $X2=0.459 $Y2=0.054
r24 17 22 5.11582 $w=1.46667e-08 $l=2.7e-08 $layer=M1 $thickness=3.6e-08
+ $X=0.459 $Y=0.036 $X2=0.486 $Y2=0.036
r25 29 30 7.46207 $w=1.3e-08 $l=3.2e-08 $layer=M1 $thickness=3.6e-08 $X=0.3865
+ $Y=0.036 $X2=0.4185 $Y2=0.036
r26 28 29 2.09871 $w=1.3e-08 $l=9e-09 $layer=M1 $thickness=3.6e-08 $X=0.3775
+ $Y=0.036 $X2=0.3865 $Y2=0.036
r27 19 28 2.56509 $w=1.3e-08 $l=1.1e-08 $layer=M1 $thickness=3.6e-08 $X=0.3665
+ $Y=0.036 $X2=0.3775 $Y2=0.036
r28 1 28 19.3796 $a=3.24e-16 $layer=V0LISD $X=0.378 $Y=0.0675 $X2=0.3775
+ $Y2=0.036
r29 27 25 0.0308642 $w=8.1e-08 $l=2.5e-09 $layer=N_src_drn $thickness=1e-09
+ $X=0.3953 $Y=0.0675 $X2=0.3925 $Y2=0.0675
r30 1 25 0.179012 $w=8.1e-08 $l=1.45e-08 $layer=N_src_drn $thickness=1e-09
+ $X=0.378 $Y=0.0675 $X2=0.3925 $Y2=0.0675
r31 13 1 0.179012 $w=8.1e-08 $l=1.45e-08 $layer=N_src_drn $thickness=1e-09
+ $X=0.3635 $Y=0.0675 $X2=0.378 $Y2=0.0675
r32 26 13 0.0308642 $w=8.1e-08 $l=2.5e-09 $layer=N_src_drn $thickness=1e-09
+ $X=0.3606 $Y=0.0675 $X2=0.3635 $Y2=0.0675
.ends

.subckt PM_MAJx3_ASAP7_75t_R%B vss 27 16 20 38 41 1 12 5 2 9 13 7 14 6 10 15 8
c1 1 vss 0.00415032f $X=0.135 $Y=0.135
c2 2 vss 0.00681989f $X=0.297 $Y=0.135
c3 5 vss 0.0080293f $X=0.135 $Y=0.135
c4 6 vss 0.0827072f $X=0.297 $Y=0.0245
c5 7 vss 0.00212043f $X=0.189 $Y=0.135
c6 8 vss 0.00230128f $X=0.189 $Y=0.198
c7 9 vss 0.00217325f $X=0.2855 $Y=0.135
c8 10 vss 0.00289881f $X=0.324 $Y=0.135
c9 11 vss 0.00448454f $X=0.324 $Y=0.198
c10 12 vss 0.00232903f $X=0.1245 $Y=0.135
c11 13 vss 0.00267781f $X=0.189 $Y=0.1765
c12 14 vss 0.00497454f $X=0.2862 $Y=0.198
c13 15 vss 0.00333685f $X=0.324 $Y=0.1465
r1 41 40 16.4967 $w=2.1e-08 $l=4.85e-08 $layer=Gate_1 $thickness=5.6e-08
+ $X=0.135 $Y=0.2025 $X2=0.135 $Y2=0.154
r2 38 39 16.4967 $w=2.1e-08 $l=4.85e-08 $layer=Gate_1 $thickness=5.6e-08
+ $X=0.135 $Y=0.0675 $X2=0.135 $Y2=0.116
r3 5 39 6.6497 $w=2.04211e-08 $l=1.9e-08 $layer=Gate_1 $thickness=5.6e-08
+ $X=0.135 $Y=0.135 $X2=0.135 $Y2=0.116
r4 5 40 6.6497 $w=2.04211e-08 $l=1.9e-08 $layer=Gate_1 $thickness=5.6e-08
+ $X=0.135 $Y=0.135 $X2=0.135 $Y2=0.154
r5 1 34 19.3796 $a=3.24e-16 $layer=V0LIG $X=0.135 $Y=0.135 $X2=0.135 $Y2=0.135
r6 1 5 10.4265 $w=1.765e-08 $layer=LIG $thickness=5.2e-08 $X=0.135 $Y=0.135
+ $X2=0.135 $Y2=0.135
r7 34 35 6.29612 $w=1.3e-08 $l=2.7e-08 $layer=M1 $thickness=3.6e-08 $X=0.135
+ $Y=0.135 $X2=0.162 $Y2=0.135
r8 12 34 2.44849 $w=1.3e-08 $l=1.05e-08 $layer=M1 $thickness=3.6e-08 $X=0.1245
+ $Y=0.135 $X2=0.135 $Y2=0.135
r9 7 33 2.78149 $w=1.76421e-08 $l=1.9e-08 $layer=M1 $thickness=3.6e-08 $X=0.189
+ $Y=0.135 $X2=0.189 $Y2=0.154
r10 7 35 4.64701 $w=1.46667e-08 $l=2.7e-08 $layer=M1 $thickness=3.6e-08
+ $X=0.189 $Y=0.135 $X2=0.162 $Y2=0.135
r11 13 33 5.24677 $w=1.3e-08 $l=2.25e-08 $layer=M1 $thickness=3.6e-08 $X=0.189
+ $Y=0.1765 $X2=0.189 $Y2=0.154
r12 8 32 4.64701 $w=1.46667e-08 $l=2.7e-08 $layer=M1 $thickness=3.6e-08
+ $X=0.189 $Y=0.198 $X2=0.216 $Y2=0.198
r13 8 13 3.36447 $w=1.71023e-08 $l=2.15e-08 $layer=M1 $thickness=3.6e-08
+ $X=0.189 $Y=0.198 $X2=0.189 $Y2=0.1765
r14 31 32 6.29612 $w=1.3e-08 $l=2.7e-08 $layer=M1 $thickness=3.6e-08 $X=0.243
+ $Y=0.198 $X2=0.216 $Y2=0.198
r15 30 31 5.71315 $w=1.3e-08 $l=2.45e-08 $layer=M1 $thickness=3.6e-08 $X=0.2675
+ $Y=0.198 $X2=0.243 $Y2=0.198
r16 29 30 3.73104 $w=1.3e-08 $l=1.6e-08 $layer=M1 $thickness=3.6e-08 $X=0.2835
+ $Y=0.198 $X2=0.2675 $Y2=0.198
r17 27 28 3.08976 $w=1.3e-08 $l=1.32e-08 $layer=M1 $thickness=3.6e-08 $X=0.289
+ $Y=0.199 $X2=0.3022 $Y2=0.198
r18 27 14 0.641272 $w=1.3e-08 $l=2.8e-09 $layer=M1 $thickness=3.6e-08 $X=0.289
+ $Y=0.199 $X2=0.2862 $Y2=0.198
r19 14 29 0.641272 $w=1.3e-08 $l=2.7e-09 $layer=M1 $thickness=3.6e-08 $X=0.2862
+ $Y=0.198 $X2=0.2835 $Y2=0.198
r20 11 26 3.36447 $w=1.71023e-08 $l=2.15e-08 $layer=M1 $thickness=3.6e-08
+ $X=0.324 $Y=0.198 $X2=0.324 $Y2=0.1765
r21 11 28 3.42276 $w=1.5069e-08 $l=2.18e-08 $layer=M1 $thickness=3.6e-08
+ $X=0.324 $Y=0.198 $X2=0.3022 $Y2=0.198
r22 25 26 4.6638 $w=1.3e-08 $l=2e-08 $layer=M1 $thickness=3.6e-08 $X=0.324
+ $Y=0.1565 $X2=0.324 $Y2=0.1765
r23 15 25 2.3319 $w=1.3e-08 $l=1e-08 $layer=M1 $thickness=3.6e-08 $X=0.324
+ $Y=0.1465 $X2=0.324 $Y2=0.1565
r24 10 23 1.96775 $w=1.63333e-08 $l=1.35e-08 $layer=M1 $thickness=3.6e-08
+ $X=0.324 $Y=0.135 $X2=0.3105 $Y2=0.135
r25 10 15 1.50137 $w=1.6913e-08 $l=1.15e-08 $layer=M1 $thickness=3.6e-08
+ $X=0.324 $Y=0.135 $X2=0.324 $Y2=0.1465
r26 22 23 3.14806 $w=1.3e-08 $l=1.35e-08 $layer=M1 $thickness=3.6e-08 $X=0.297
+ $Y=0.135 $X2=0.3105 $Y2=0.135
r27 9 22 2.68168 $w=1.3e-08 $l=1.15e-08 $layer=M1 $thickness=3.6e-08 $X=0.2855
+ $Y=0.135 $X2=0.297 $Y2=0.135
r28 2 18 10.4265 $w=1.765e-08 $layer=LIG $thickness=5.2e-08 $X=0.297 $Y=0.135
+ $X2=0.297 $Y2=0.135
r29 2 22 19.3796 $a=3.24e-16 $layer=V0LIG $X=0.297 $Y=0.135 $X2=0.297 $Y2=0.135
r30 20 19 16.4967 $w=2.1e-08 $l=4.85e-08 $layer=Gate_1 $thickness=5.6e-08
+ $X=0.297 $Y=0.2025 $X2=0.297 $Y2=0.154
r31 18 19 6.6497 $w=2.04211e-08 $l=1.9e-08 $layer=Gate_1 $thickness=5.6e-08
+ $X=0.297 $Y=0.135 $X2=0.297 $Y2=0.154
r32 17 18 6.6497 $w=2.04211e-08 $l=1.9e-08 $layer=Gate_1 $thickness=5.6e-08
+ $X=0.297 $Y=0.116 $X2=0.297 $Y2=0.135
r33 16 17 16.4967 $w=2.1e-08 $l=4.85e-08 $layer=Gate_1 $thickness=5.6e-08
+ $X=0.297 $Y=0.0675 $X2=0.297 $Y2=0.116
r34 16 6 14.6259 $w=2.1e-08 $l=4.3e-08 $layer=Gate_1 $thickness=5.6e-08
+ $X=0.297 $Y=0.0675 $X2=0.297 $Y2=0.0245
.ends

.subckt PM_MAJx3_ASAP7_75t_R%6 vss 21 25 39 42 46 50 68 69 80 81 12 3 4 19 18
+ 17 13 1 20 9 14 15 11 16 10
c1 1 vss 0.0138332f $X=0.351 $Y=0.135
c2 3 vss 0.00368015f $X=0.108 $Y=0.0675
c3 4 vss 0.00368016f $X=0.108 $Y=0.2025
c4 9 vss 0.0808586f $X=0.351 $Y=0.0245
c5 10 vss 0.0810707f $X=0.405 $Y=0.135
c6 11 vss 0.0850547f $X=0.459 $Y=0.135
c7 12 vss 0.00609215f $X=0.0935 $Y=0.0675
c8 13 vss 0.00615743f $X=0.0935 $Y=0.2025
c9 14 vss 0.00222625f $X=0.027 $Y=0.072
c10 15 vss 0.00221451f $X=0.027 $Y=0.198
c11 16 vss 0.000768467f $X=0.377 $Y=0.072
c12 17 vss 0.00681106f $X=0.027 $Y=0.0935
c13 18 vss 0.0113625f $X=0.366 $Y=0.072
c14 19 vss 0.00259471f $X=0.038 $Y=0.198
c15 20 vss 0.00234837f $X=0.377 $Y=0.116
r1 81 79 0.0308642 $w=8.1e-08 $l=2.5e-09 $layer=P_src_drn $thickness=1e-09
+ $X=0.1253 $Y=0.2025 $X2=0.1225 $Y2=0.2025
r2 4 79 0.179012 $w=8.1e-08 $l=1.45e-08 $layer=P_src_drn $thickness=1e-09
+ $X=0.108 $Y=0.2025 $X2=0.1225 $Y2=0.2025
r3 13 4 0.179012 $w=8.1e-08 $l=1.45e-08 $layer=P_src_drn $thickness=1e-09
+ $X=0.0935 $Y=0.2025 $X2=0.108 $Y2=0.2025
r4 80 13 0.0308642 $w=8.1e-08 $l=2.5e-09 $layer=P_src_drn $thickness=1e-09
+ $X=0.0906 $Y=0.2025 $X2=0.0935 $Y2=0.2025
r5 4 75 19.3796 $a=3.24e-16 $layer=V0LISD $X=0.108 $Y=0.2025 $X2=0.109 $Y2=0.198
r6 74 75 3.26466 $w=1.3e-08 $l=1.4e-08 $layer=M1 $thickness=3.6e-08 $X=0.095
+ $Y=0.198 $X2=0.109 $Y2=0.198
r7 73 74 3.26466 $w=1.3e-08 $l=1.4e-08 $layer=M1 $thickness=3.6e-08 $X=0.081
+ $Y=0.198 $X2=0.095 $Y2=0.198
r8 72 73 5.82974 $w=1.3e-08 $l=2.5e-08 $layer=M1 $thickness=3.6e-08 $X=0.056
+ $Y=0.198 $X2=0.081 $Y2=0.198
r9 19 72 4.19742 $w=1.3e-08 $l=1.8e-08 $layer=M1 $thickness=3.6e-08 $X=0.038
+ $Y=0.198 $X2=0.056 $Y2=0.198
r10 15 71 3.36447 $w=1.71023e-08 $l=2.15e-08 $layer=M1 $thickness=3.6e-08
+ $X=0.027 $Y=0.198 $X2=0.027 $Y2=0.1765
r11 15 19 0.915974 $w=1.70909e-08 $l=1.1e-08 $layer=M1 $thickness=3.6e-08
+ $X=0.027 $Y=0.198 $X2=0.038 $Y2=0.198
r12 70 71 9.67737 $w=1.3e-08 $l=4.15e-08 $layer=M1 $thickness=3.6e-08 $X=0.027
+ $Y=0.135 $X2=0.027 $Y2=0.1765
r13 17 70 9.67737 $w=1.3e-08 $l=4.15e-08 $layer=M1 $thickness=3.6e-08 $X=0.027
+ $Y=0.0935 $X2=0.027 $Y2=0.135
r14 69 67 0.0308642 $w=8.1e-08 $l=2.5e-09 $layer=N_src_drn $thickness=1e-09
+ $X=0.1253 $Y=0.0675 $X2=0.1225 $Y2=0.0675
r15 3 67 0.179012 $w=8.1e-08 $l=1.45e-08 $layer=N_src_drn $thickness=1e-09
+ $X=0.108 $Y=0.0675 $X2=0.1225 $Y2=0.0675
r16 12 3 0.179012 $w=8.1e-08 $l=1.45e-08 $layer=N_src_drn $thickness=1e-09
+ $X=0.0935 $Y=0.0675 $X2=0.108 $Y2=0.0675
r17 68 12 0.0308642 $w=8.1e-08 $l=2.5e-09 $layer=N_src_drn $thickness=1e-09
+ $X=0.0906 $Y=0.0675 $X2=0.0935 $Y2=0.0675
r18 14 65 0.915974 $w=1.70909e-08 $l=1.1e-08 $layer=M1 $thickness=3.6e-08
+ $X=0.027 $Y=0.072 $X2=0.038 $Y2=0.072
r19 14 17 3.36447 $w=1.71023e-08 $l=2.15e-08 $layer=M1 $thickness=3.6e-08
+ $X=0.027 $Y=0.072 $X2=0.027 $Y2=0.0935
r20 3 61 19.3796 $a=3.24e-16 $layer=V0LISD $X=0.108 $Y=0.0675 $X2=0.109
+ $Y2=0.072
r21 64 65 4.19742 $w=1.3e-08 $l=1.8e-08 $layer=M1 $thickness=3.6e-08 $X=0.056
+ $Y=0.072 $X2=0.038 $Y2=0.072
r22 63 64 5.82974 $w=1.3e-08 $l=2.5e-08 $layer=M1 $thickness=3.6e-08 $X=0.081
+ $Y=0.072 $X2=0.056 $Y2=0.072
r23 61 62 2.44849 $w=1.3e-08 $l=1.05e-08 $layer=M1 $thickness=3.6e-08 $X=0.109
+ $Y=0.072 $X2=0.1195 $Y2=0.072
r24 60 61 3.26466 $w=1.3e-08 $l=1.4e-08 $layer=M1 $thickness=3.6e-08 $X=0.095
+ $Y=0.072 $X2=0.109 $Y2=0.072
r25 60 63 3.26466 $w=1.3e-08 $l=1.4e-08 $layer=M1 $thickness=3.6e-08 $X=0.095
+ $Y=0.072 $X2=0.081 $Y2=0.072
r26 59 62 9.32759 $w=1.3e-08 $l=4e-08 $layer=M1 $thickness=3.6e-08 $X=0.1595
+ $Y=0.072 $X2=0.1195 $Y2=0.072
r27 58 59 13.1752 $w=1.3e-08 $l=5.65e-08 $layer=M1 $thickness=3.6e-08 $X=0.216
+ $Y=0.072 $X2=0.1595 $Y2=0.072
r28 57 58 6.29612 $w=1.3e-08 $l=2.7e-08 $layer=M1 $thickness=3.6e-08 $X=0.243
+ $Y=0.072 $X2=0.216 $Y2=0.072
r29 56 57 5.71315 $w=1.3e-08 $l=2.45e-08 $layer=M1 $thickness=3.6e-08 $X=0.2675
+ $Y=0.072 $X2=0.243 $Y2=0.072
r30 55 56 3.73104 $w=1.3e-08 $l=1.6e-08 $layer=M1 $thickness=3.6e-08 $X=0.2835
+ $Y=0.072 $X2=0.2675 $Y2=0.072
r31 54 55 3.73104 $w=1.3e-08 $l=1.6e-08 $layer=M1 $thickness=3.6e-08 $X=0.2995
+ $Y=0.072 $X2=0.2835 $Y2=0.072
r32 53 54 5.71315 $w=1.3e-08 $l=2.45e-08 $layer=M1 $thickness=3.6e-08 $X=0.324
+ $Y=0.072 $X2=0.2995 $Y2=0.072
r33 52 53 5.71315 $w=1.3e-08 $l=2.45e-08 $layer=M1 $thickness=3.6e-08 $X=0.3485
+ $Y=0.072 $X2=0.324 $Y2=0.072
r34 18 52 4.08082 $w=1.3e-08 $l=1.75e-08 $layer=M1 $thickness=3.6e-08 $X=0.366
+ $Y=0.072 $X2=0.3485 $Y2=0.072
r35 16 37 3.36447 $w=1.71023e-08 $l=2.15e-08 $layer=M1 $thickness=3.6e-08
+ $X=0.377 $Y=0.072 $X2=0.377 $Y2=0.0935
r36 16 18 0.915974 $w=1.70909e-08 $l=1.1e-08 $layer=M1 $thickness=3.6e-08
+ $X=0.377 $Y=0.072 $X2=0.366 $Y2=0.072
r37 50 49 14.6259 $w=2.1e-08 $l=4.3e-08 $layer=Gate_1 $thickness=5.6e-08
+ $X=0.459 $Y=0.2025 $X2=0.459 $Y2=0.1595
r38 48 49 2.7211 $w=2.1e-08 $l=8e-09 $layer=Gate_1 $thickness=5.6e-08 $X=0.459
+ $Y=0.1515 $X2=0.459 $Y2=0.1595
r39 46 47 14.6259 $w=2.1e-08 $l=4.3e-08 $layer=Gate_1 $thickness=5.6e-08
+ $X=0.459 $Y=0.0675 $X2=0.459 $Y2=0.1105
r40 44 47 2.7211 $w=2.1e-08 $l=8e-09 $layer=Gate_1 $thickness=5.6e-08 $X=0.459
+ $Y=0.1185 $X2=0.459 $Y2=0.1105
r41 11 33 6.54019 $w=2.09524e-08 $layer=Gate_1 $thickness=5.21905e-08 $X=0.459
+ $Y=0.135 $X2=0.459 $Y2=0.135
r42 11 44 5.79936 $w=2.03333e-08 $l=1.65e-08 $layer=Gate_1 $thickness=5.6e-08
+ $X=0.459 $Y=0.135 $X2=0.459 $Y2=0.1185
r43 11 48 5.79936 $w=2.03333e-08 $l=1.65e-08 $layer=Gate_1 $thickness=5.6e-08
+ $X=0.459 $Y=0.135 $X2=0.459 $Y2=0.1515
r44 42 41 16.4967 $w=2.1e-08 $l=4.85e-08 $layer=Gate_1 $thickness=5.6e-08
+ $X=0.405 $Y=0.2025 $X2=0.405 $Y2=0.154
r45 39 40 16.4967 $w=2.1e-08 $l=4.85e-08 $layer=Gate_1 $thickness=5.6e-08
+ $X=0.405 $Y=0.0675 $X2=0.405 $Y2=0.116
r46 10 31 6.54019 $w=2.09524e-08 $layer=Gate_1 $thickness=5.21905e-08 $X=0.405
+ $Y=0.135 $X2=0.405 $Y2=0.135
r47 10 40 6.6497 $w=2.04211e-08 $l=1.9e-08 $layer=Gate_1 $thickness=5.6e-08
+ $X=0.405 $Y=0.135 $X2=0.405 $Y2=0.116
r48 10 41 6.6497 $w=2.04211e-08 $l=1.9e-08 $layer=Gate_1 $thickness=5.6e-08
+ $X=0.405 $Y=0.135 $X2=0.405 $Y2=0.154
r49 20 35 4.43061 $w=1.3e-08 $l=1.9e-08 $layer=M1 $thickness=3.6e-08 $X=0.377
+ $Y=0.116 $X2=0.377 $Y2=0.135
r50 20 37 5.24677 $w=1.3e-08 $l=2.25e-08 $layer=M1 $thickness=3.6e-08 $X=0.377
+ $Y=0.116 $X2=0.377 $Y2=0.0935
r51 32 33 12.6539 $w=1.77815e-08 $l=2.7e-08 $layer=LIG $thickness=4.8e-08
+ $X=0.432 $Y=0.135 $X2=0.459 $Y2=0.135
r52 31 32 12.6539 $w=1.77815e-08 $l=2.7e-08 $layer=LIG $thickness=4.8e-08
+ $X=0.405 $Y=0.135 $X2=0.432 $Y2=0.135
r53 30 31 5.26985 $w=1.99207e-08 $l=1.45e-08 $layer=LIG $thickness=4.8e-08
+ $X=0.3905 $Y=0.135 $X2=0.405 $Y2=0.135
r54 29 30 7.97476 $w=1.53e-08 $l=1.35e-08 $layer=LIG $thickness=4.8e-08
+ $X=0.377 $Y=0.135 $X2=0.3905 $Y2=0.135
r55 29 35 19.3796 $a=3.24e-16 $layer=V0LIG $X=0.377 $Y=0.135 $X2=0.377 $Y2=0.135
r56 28 29 7.38404 $w=1.53e-08 $l=1.25e-08 $layer=LIG $thickness=4.8e-08
+ $X=0.3645 $Y=0.135 $X2=0.377 $Y2=0.135
r57 1 23 6.54019 $w=2.09524e-08 $layer=Gate_1 $thickness=5.21905e-08 $X=0.351
+ $Y=0.135 $X2=0.351 $Y2=0.135
r58 1 28 4.67913 $w=2.0263e-08 $l=1.35e-08 $layer=LIG $thickness=4.8e-08
+ $X=0.351 $Y=0.135 $X2=0.3645 $Y2=0.135
r59 25 24 16.4967 $w=2.1e-08 $l=4.85e-08 $layer=Gate_1 $thickness=5.6e-08
+ $X=0.351 $Y=0.2025 $X2=0.351 $Y2=0.154
r60 23 24 6.6497 $w=2.04211e-08 $l=1.9e-08 $layer=Gate_1 $thickness=5.6e-08
+ $X=0.351 $Y=0.135 $X2=0.351 $Y2=0.154
r61 22 23 6.6497 $w=2.04211e-08 $l=1.9e-08 $layer=Gate_1 $thickness=5.6e-08
+ $X=0.351 $Y=0.116 $X2=0.351 $Y2=0.135
r62 21 22 16.4967 $w=2.1e-08 $l=4.85e-08 $layer=Gate_1 $thickness=5.6e-08
+ $X=0.351 $Y=0.0675 $X2=0.351 $Y2=0.116
r63 21 9 14.6259 $w=2.1e-08 $l=4.3e-08 $layer=Gate_1 $thickness=5.6e-08
+ $X=0.351 $Y=0.0675 $X2=0.351 $Y2=0.0245
.ends

.subckt PM_MAJx3_ASAP7_75t_R%C vss 25 6 10 19 22 3 1 5 4
c1 1 vss 0.0165054f $X=0.189 $Y=0.135
c2 3 vss 0.0860675f $X=0.189 $Y=0.0245
c3 4 vss 0.0832937f $X=0.243 $Y=0.135
c4 5 vss 0.00441475f $X=0.243 $Y=0.135
r1 25 26 1.22425 $w=1.3e-08 $l=5.2e-09 $layer=M1 $thickness=3.6e-08 $X=0.24
+ $Y=0.116 $X2=0.243 $Y2=0.1212
r2 5 15 19.3796 $a=3.24e-16 $layer=V0LIG $X=0.243 $Y=0.135 $X2=0.243 $Y2=0.135
r3 5 26 3.20636 $w=1.3e-08 $l=1.38e-08 $layer=M1 $thickness=3.6e-08 $X=0.243
+ $Y=0.135 $X2=0.243 $Y2=0.1212
r4 22 21 16.4967 $w=2.1e-08 $l=4.85e-08 $layer=Gate_1 $thickness=5.6e-08
+ $X=0.243 $Y=0.2025 $X2=0.243 $Y2=0.154
r5 19 20 16.4967 $w=2.1e-08 $l=4.85e-08 $layer=Gate_1 $thickness=5.6e-08
+ $X=0.243 $Y=0.0675 $X2=0.243 $Y2=0.116
r6 4 15 6.27904 $w=2.09e-08 $layer=Gate_1 $thickness=5.24e-08 $X=0.243 $Y=0.135
+ $X2=0.243 $Y2=0.135
r7 4 20 6.6497 $w=2.04211e-08 $l=1.9e-08 $layer=Gate_1 $thickness=5.6e-08
+ $X=0.243 $Y=0.135 $X2=0.243 $Y2=0.116
r8 4 21 6.6497 $w=2.04211e-08 $l=1.9e-08 $layer=Gate_1 $thickness=5.6e-08
+ $X=0.243 $Y=0.135 $X2=0.243 $Y2=0.154
r9 14 15 2.48102 $w=2.2e-08 $l=9.5e-09 $layer=LIG $thickness=4.8e-08 $X=0.2335
+ $Y=0.135 $X2=0.243 $Y2=0.135
r10 13 14 10.1729 $w=1.54914e-08 $l=1.75e-08 $layer=LIG $thickness=4.8e-08
+ $X=0.216 $Y=0.135 $X2=0.2335 $Y2=0.135
r11 1 8 6.54019 $w=2.09524e-08 $layer=Gate_1 $thickness=5.21905e-08 $X=0.189
+ $Y=0.135 $X2=0.189 $Y2=0.135
r12 1 13 12.6539 $w=1.77815e-08 $l=2.7e-08 $layer=LIG $thickness=4.8e-08
+ $X=0.189 $Y=0.135 $X2=0.216 $Y2=0.135
r13 10 9 16.4967 $w=2.1e-08 $l=4.85e-08 $layer=Gate_1 $thickness=5.6e-08
+ $X=0.189 $Y=0.2025 $X2=0.189 $Y2=0.154
r14 8 9 6.6497 $w=2.04211e-08 $l=1.9e-08 $layer=Gate_1 $thickness=5.6e-08
+ $X=0.189 $Y=0.135 $X2=0.189 $Y2=0.154
r15 7 8 6.6497 $w=2.04211e-08 $l=1.9e-08 $layer=Gate_1 $thickness=5.6e-08
+ $X=0.189 $Y=0.116 $X2=0.189 $Y2=0.135
r16 6 7 16.4967 $w=2.1e-08 $l=4.85e-08 $layer=Gate_1 $thickness=5.6e-08
+ $X=0.189 $Y=0.0675 $X2=0.189 $Y2=0.116
r17 6 3 14.6259 $w=2.1e-08 $l=4.3e-08 $layer=Gate_1 $thickness=5.6e-08 $X=0.189
+ $Y=0.0675 $X2=0.189 $Y2=0.0245
.ends

.subckt PM_MAJx3_ASAP7_75t_R%7 vss 11 18 19 7 8 2 9 1
c1 1 vss 0.00603001f $X=0.054 $Y=0.0675
c2 2 vss 0.00870725f $X=0.27 $Y=0.0675
c3 7 vss 0.0360148f $X=0.056 $Y=0.0675
c4 8 vss 0.00449786f $X=0.2555 $Y=0.0675
c5 9 vss 0.0207522f $X=0.0425 $Y=0.036
r1 19 17 0.0308642 $w=8.1e-08 $l=2.5e-09 $layer=N_src_drn $thickness=1e-09
+ $X=0.2873 $Y=0.0675 $X2=0.2845 $Y2=0.0675
r2 2 17 0.179012 $w=8.1e-08 $l=1.45e-08 $layer=N_src_drn $thickness=1e-09
+ $X=0.27 $Y=0.0675 $X2=0.2845 $Y2=0.0675
r3 8 2 0.179012 $w=8.1e-08 $l=1.45e-08 $layer=N_src_drn $thickness=1e-09
+ $X=0.2555 $Y=0.0675 $X2=0.27 $Y2=0.0675
r4 18 8 0.0308642 $w=8.1e-08 $l=2.5e-09 $layer=N_src_drn $thickness=1e-09
+ $X=0.2526 $Y=0.0675 $X2=0.2555 $Y2=0.0675
r5 2 14 19.3796 $a=3.24e-16 $layer=V0LISD $X=0.27 $Y=0.0675 $X2=0.27 $Y2=0.036
r6 13 14 25.1845 $w=1.3e-08 $l=1.08e-07 $layer=M1 $thickness=3.6e-08 $X=0.162
+ $Y=0.036 $X2=0.27 $Y2=0.036
r7 12 13 25.1845 $w=1.3e-08 $l=1.08e-07 $layer=M1 $thickness=3.6e-08 $X=0.054
+ $Y=0.036 $X2=0.162 $Y2=0.036
r8 9 12 2.68168 $w=1.3e-08 $l=1.15e-08 $layer=M1 $thickness=3.6e-08 $X=0.0425
+ $Y=0.036 $X2=0.054 $Y2=0.036
r9 1 12 19.3796 $a=3.24e-16 $layer=V0LISD $X=0.054 $Y=0.0675 $X2=0.054 $Y2=0.036
r10 11 10 0.0308642 $w=8.1e-08 $l=2.5e-09 $layer=N_src_drn $thickness=1e-09
+ $X=0.0713 $Y=0.0675 $X2=0.0685 $Y2=0.0675
r11 7 10 0.154321 $w=8.1e-08 $l=1.25e-08 $layer=N_src_drn $thickness=1e-09
+ $X=0.056 $Y=0.0675 $X2=0.0685 $Y2=0.0675
r12 1 7 1e-05 $l=2e-09 $X=0.054 $Y=0.0675 $X2=0.056 $Y2=0.0675
.ends

* End of included file MAJx3_ASAP7_75t_R.pex.sp.pex

*
.subckt MAJx3_ASAP7_75t_CUSTOM_4_25_0_7 VSS VDD A B C Y
*
* VSS VSS
* VDD VDD
* A A
* B B
* C C
* Y Y
*
*

M0 N_M0_d N_M0_g N_M0_s VSS nmos_rvt L=2e-08 W=8.1e-08 nfin=3 $X=0.071 $Y=0.027
M1 N_M1_d N_M1_g N_M1_s VSS nmos_rvt L=2e-08 W=8.1e-08 nfin=3 $X=0.125 $Y=0.027
M2 VSS N_M2_g N_M2_s VSS nmos_rvt L=2e-08 W=8.1e-08 nfin=3 $X=0.179 $Y=0.027
M3 N_M3_d N_M3_g VSS VSS nmos_rvt L=2e-08 W=8.1e-08 nfin=3 $X=0.233 $Y=0.027
M4 VSS N_M4_g N_M4_s VSS nmos_rvt L=2e-08 W=8.1e-08 nfin=3 $X=0.287 $Y=0.027
M5 N_M5_d N_M5_g VSS VSS nmos_rvt L=2e-08 W=8.1e-08 nfin=3 $X=0.341 $Y=0.027
M6 N_M6_d N_M6_g VSS VSS nmos_rvt L=2e-08 W=8.1e-08 nfin=3 $X=0.395 $Y=0.027
M7 N_M7_d N_M7_g VSS VSS nmos_rvt L=2e-08 W=8.1e-08 nfin=3 $X=0.449 $Y=0.027
M8 N_M8_d N_M8_g N_M8_s VDD pmos_rvt L=2e-08 W=8.1e-08 nfin=3 $X=0.071 $Y=0.162
M9 N_M9_d N_M9_g N_M9_s VDD pmos_rvt L=2e-08 W=8.1e-08 nfin=3 $X=0.125 $Y=0.162
M10 VDD N_M10_g N_M10_s VDD pmos_rvt L=2e-08 W=8.1e-08 nfin=3 $X=0.179 $Y=0.162
M11 N_M11_d N_M11_g VDD VDD pmos_rvt L=2e-08 W=8.1e-08 nfin=3 $X=0.233 $Y=0.162
M12 VDD N_M12_g N_M12_s VDD pmos_rvt L=2e-08 W=8.1e-08 nfin=3 $X=0.287 $Y=0.162
M13 N_M13_d N_M13_g VDD VDD pmos_rvt L=2e-08 W=8.1e-08 nfin=3 $X=0.341 $Y=0.162
M14 N_M14_d N_M14_g VDD VDD pmos_rvt L=2e-08 W=8.1e-08 nfin=3 $X=0.395 $Y=0.162
M15 N_M15_d N_M15_g VDD VDD pmos_rvt L=2e-08 W=8.1e-08 nfin=3 $X=0.449 $Y=0.162

* .include "MAJx3_ASAP7_75t_R.pex.sp.pxi"

* Start of included file MAJx3_ASAP7_75t_R.pex.sp.pxi
x_PM_MAJx3_ASAP7_75t_R%10 vss N_M1_d N_M2_s N_10_1 PM_MAJx3_ASAP7_75t_R%10
cc_1 N_10_1 N_B_5 0.0167126f $X=0.162 $Y=0.0675
cc_2 N_10_1 N_C_3 0.0168147f $X=0.162 $Y=0.0675
x_PM_MAJx3_ASAP7_75t_R%11 vss N_M10_s N_M9_d N_11_1 PM_MAJx3_ASAP7_75t_R%11
cc_3 N_11_1 N_B_5 0.0167786f $X=0.162 $Y=0.2025
cc_4 N_11_1 N_C_3 0.0168595f $X=0.162 $Y=0.2025
x_PM_MAJx3_ASAP7_75t_R%A vss A N_M0_g N_M8_g N_A_3 N_A_4 N_A_1
+ PM_MAJx3_ASAP7_75t_R%A
x_PM_MAJx3_ASAP7_75t_R%8 vss N_M11_d N_M12_s N_M8_s N_8_7 N_8_8 N_8_2 N_8_9
+ N_8_1 PM_MAJx3_ASAP7_75t_R%8
cc_5 N_8_7 N_A_3 0.0357424f $X=0.056 $Y=0.2025
cc_6 N_8_8 N_B_13 0.000241512f $X=0.2555 $Y=0.2025
cc_7 N_8_8 N_B_14 0.000478407f $X=0.2555 $Y=0.2025
cc_8 N_8_8 N_B_2 0.00066013f $X=0.2555 $Y=0.2025
cc_9 N_8_2 N_B_6 0.00153854f $X=0.27 $Y=0.2025
cc_10 N_8_9 N_B_14 0.00389474f $X=0.2205 $Y=0.234
cc_11 N_8_9 N_B_8 0.00552916f $X=0.2205 $Y=0.234
cc_12 N_8_8 N_B_6 0.0343184f $X=0.2555 $Y=0.2025
cc_13 N_8_8 N_C_1 0.000801343f $X=0.2555 $Y=0.2025
cc_14 N_8_8 N_C_4 0.0346975f $X=0.2555 $Y=0.2025
cc_15 N_8_9 N_6_4 0.000491237f $X=0.2205 $Y=0.234
cc_16 N_8_9 N_6_17 0.000602149f $X=0.2205 $Y=0.234
cc_17 N_8_9 N_6_13 0.0006126f $X=0.2205 $Y=0.234
cc_18 N_8_9 N_6_15 0.000644512f $X=0.2205 $Y=0.234
cc_19 N_8_1 N_6_19 0.000685279f $X=0.054 $Y=0.2025
cc_20 N_8_7 N_6_13 0.000750538f $X=0.056 $Y=0.2025
cc_21 N_8_1 N_6_4 0.00393416f $X=0.054 $Y=0.2025
cc_22 N_8_9 N_6_19 0.0080139f $X=0.2205 $Y=0.234
x_PM_MAJx3_ASAP7_75t_R%Y vss Y N_M5_d N_M6_d N_M7_d N_M13_d N_M14_d N_M15_d
+ N_Y_15 N_Y_2 N_Y_1 N_Y_19 N_Y_16 N_Y_13 N_Y_14 PM_MAJx3_ASAP7_75t_R%Y
cc_23 N_Y_15 N_6_11 0.00232158f $X=0.3635 $Y=0.2025
cc_24 N_Y_15 N_6_16 0.000470413f $X=0.3635 $Y=0.2025
cc_25 N_Y_15 N_6_1 0.00239631f $X=0.3635 $Y=0.2025
cc_26 N_Y_15 N_6_18 0.00116491f $X=0.3635 $Y=0.2025
cc_27 N_Y_15 N_6_20 0.00161911f $X=0.3635 $Y=0.2025
cc_28 N_Y_2 N_6_10 0.00173132f $X=0.378 $Y=0.2025
cc_29 N_Y_1 N_6_10 0.00230241f $X=0.378 $Y=0.0675
cc_30 N_Y_19 N_6_16 0.00295855f $X=0.3665 $Y=0.036
cc_31 N_Y_16 N_6_11 0.0144785f $X=0.4715 $Y=0.2025
cc_32 N_Y_13 N_6_1 0.00674027f $X=0.3635 $Y=0.0675
cc_33 N_Y_14 N_6_11 0.0518508f $X=0.4715 $Y=0.0675
cc_34 N_Y_13 N_6_10 0.0288248f $X=0.3635 $Y=0.0675
cc_35 N_Y_13 N_6_9 0.0365454f $X=0.3635 $Y=0.0675
cc_36 N_Y_15 N_6_10 0.0681695f $X=0.3635 $Y=0.2025
x_PM_MAJx3_ASAP7_75t_R%B vss B N_M4_g N_M12_g N_M1_g N_M9_g N_B_1 N_B_12 N_B_5
+ N_B_2 N_B_9 N_B_13 N_B_7 N_B_14 N_B_6 N_B_10 N_B_15 N_B_8
+ PM_MAJx3_ASAP7_75t_R%B
cc_37 N_B_1 N_A_3 0.000972199f $X=0.135 $Y=0.135
cc_38 N_B_12 N_A_4 0.00159101f $X=0.1245 $Y=0.135
cc_39 N_B_5 N_A_3 0.00408478f $X=0.135 $Y=0.135
x_PM_MAJx3_ASAP7_75t_R%6 vss N_M5_g N_M13_g N_M6_g N_M14_g N_M7_g N_M15_g
+ N_M0_d N_M1_s N_M8_d N_M9_s N_6_12 N_6_3 N_6_4 N_6_19 N_6_18 N_6_17 N_6_13
+ N_6_1 N_6_20 N_6_9 N_6_14 N_6_15 N_6_11 N_6_16 N_6_10 PM_MAJx3_ASAP7_75t_R%6
cc_40 N_6_12 N_A_3 0.0151179f $X=0.0935 $Y=0.0675
cc_41 N_6_3 N_A_3 0.000780896f $X=0.108 $Y=0.0675
cc_42 N_6_4 N_A_3 0.000780896f $X=0.108 $Y=0.2025
cc_43 N_6_3 N_A_1 0.000883064f $X=0.108 $Y=0.0675
cc_44 N_6_19 N_A_4 0.000969342f $X=0.038 $Y=0.198
cc_45 N_6_18 N_A_4 0.00110529f $X=0.366 $Y=0.072
cc_46 N_6_12 N_A_1 0.00149617f $X=0.0935 $Y=0.0675
cc_47 N_6_17 N_A_4 0.0047537f $X=0.027 $Y=0.0935
cc_48 N_6_13 N_A_3 0.0535862f $X=0.0935 $Y=0.2025
cc_49 N_6_19 N_B_5 0.000200434f $X=0.038 $Y=0.198
cc_50 N_6_3 N_B_1 0.000303442f $X=0.108 $Y=0.0675
cc_51 N_6_4 N_B_1 0.00113009f $X=0.108 $Y=0.2025
cc_52 N_6_1 N_B_10 0.00105494f $X=0.351 $Y=0.135
cc_53 N_6_19 N_B_13 0.000324504f $X=0.038 $Y=0.198
cc_54 N_6_18 N_B_9 0.000378524f $X=0.366 $Y=0.072
cc_55 N_6_1 N_B_2 0.000894951f $X=0.351 $Y=0.135
cc_56 N_6_13 N_B_5 0.0152164f $X=0.0935 $Y=0.2025
cc_57 N_6_20 N_B_15 0.000592933f $X=0.377 $Y=0.116
cc_58 N_6_19 N_B_12 0.000594105f $X=0.038 $Y=0.198
cc_59 N_6_3 N_B_5 0.00102029f $X=0.108 $Y=0.0675
cc_60 N_6_4 N_B_5 0.00102029f $X=0.108 $Y=0.2025
cc_61 N_6_18 N_B_12 0.00150893f $X=0.366 $Y=0.072
cc_62 N_6_18 N_B_10 0.00154587f $X=0.366 $Y=0.072
cc_63 N_6_20 N_B_10 0.0016164f $X=0.377 $Y=0.116
cc_64 N_6_12 N_B_1 0.00168518f $X=0.0935 $Y=0.0675
cc_65 N_6_9 N_B_6 0.00334108f $X=0.351 $Y=0.0245
cc_66 N_6_18 N_B_7 0.00351163f $X=0.366 $Y=0.072
cc_67 N_6_12 N_B_5 0.0548399f $X=0.0935 $Y=0.0675
cc_68 N_6_18 N_C_5 0.00372025f $X=0.366 $Y=0.072
x_PM_MAJx3_ASAP7_75t_R%C vss C N_M2_g N_M10_g N_M3_g N_M11_g N_C_3 N_C_1 N_C_5
+ N_C_4 PM_MAJx3_ASAP7_75t_R%C
cc_69 N_C_3 N_B_2 0.000333336f $X=0.189 $Y=0.0245
cc_70 N_C_1 N_B_2 0.000567872f $X=0.189 $Y=0.135
cc_71 N_C_1 N_B_9 0.000632759f $X=0.189 $Y=0.135
cc_72 N_C_1 N_B_1 0.000688191f $X=0.189 $Y=0.135
cc_73 N_C_5 N_B_13 0.000697095f $X=0.243 $Y=0.135
cc_74 N_C_5 N_B_7 0.000718821f $X=0.243 $Y=0.135
cc_75 N_C_5 N_B_14 0.00113277f $X=0.243 $Y=0.135
cc_76 N_C_1 N_B_7 0.0022189f $X=0.189 $Y=0.135
cc_77 N_C_5 N_B_9 0.00328221f $X=0.243 $Y=0.135
cc_78 N_C_4 N_B_6 0.00343974f $X=0.243 $Y=0.135
cc_79 N_C_3 N_B_5 0.00746961f $X=0.189 $Y=0.0245
x_PM_MAJx3_ASAP7_75t_R%7 vss N_M0_s N_M3_d N_M4_s N_7_7 N_7_8 N_7_2 N_7_9 N_7_1
+ PM_MAJx3_ASAP7_75t_R%7
cc_80 N_7_7 N_A_3 0.0357702f $X=0.056 $Y=0.0675
cc_81 N_7_8 N_B_12 0.00030946f $X=0.2555 $Y=0.0675
cc_82 N_7_8 N_B_2 0.000659966f $X=0.2555 $Y=0.0675
cc_83 N_7_2 N_B_6 0.00153721f $X=0.27 $Y=0.0675
cc_84 N_7_8 N_B_6 0.0341638f $X=0.2555 $Y=0.0675
cc_85 N_7_8 N_C_1 0.000751759f $X=0.2555 $Y=0.0675
cc_86 N_7_8 N_C_4 0.0346416f $X=0.2555 $Y=0.0675
cc_87 N_7_9 N_6_3 0.000490812f $X=0.0425 $Y=0.036
cc_88 N_7_9 N_6_12 0.00059524f $X=0.0425 $Y=0.036
cc_89 N_7_9 N_6_17 0.000600698f $X=0.0425 $Y=0.036
cc_90 N_7_9 N_6_14 0.000641012f $X=0.0425 $Y=0.036
cc_91 N_7_1 N_6_18 0.000684686f $X=0.054 $Y=0.0675
cc_92 N_7_7 N_6_12 0.000749754f $X=0.056 $Y=0.0675
cc_93 N_7_1 N_6_3 0.00393075f $X=0.054 $Y=0.0675
cc_94 N_7_9 N_6_18 0.0193208f $X=0.0425 $Y=0.036

* End of included file MAJx3_ASAP7_75t_R.pex.sp.pxi
.ends

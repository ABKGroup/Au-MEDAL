.subckt PM_MAJx2_ASAP7_75t_R%10 vss 2 3 1
c1 1 vss 0.000752488f $X=0.162 $Y=0.0675
r1 2 1 0.209877 $w=8.1e-08 $l=1.7e-08 $layer=N_src_drn $thickness=1e-09
+ $X=0.1446 $Y=0.0675 $X2=0.162 $Y2=0.0675
r2 3 1 0.209877 $w=8.1e-08 $l=1.7e-08 $layer=N_src_drn $thickness=1e-09
+ $X=0.1793 $Y=0.0675 $X2=0.162 $Y2=0.0675
.ends

.subckt PM_MAJx2_ASAP7_75t_R%11 vss 2 3 1
c1 1 vss 0.000748121f $X=0.162 $Y=0.2025
r1 2 1 0.209877 $w=8.1e-08 $l=1.7e-08 $layer=P_src_drn $thickness=1e-09
+ $X=0.1446 $Y=0.2025 $X2=0.162 $Y2=0.2025
r2 3 1 0.209877 $w=8.1e-08 $l=1.7e-08 $layer=P_src_drn $thickness=1e-09
+ $X=0.1793 $Y=0.2025 $X2=0.162 $Y2=0.2025
.ends

.subckt PM_MAJx2_ASAP7_75t_R%C vss 19 6 10 23 26 3 1 5 4
c1 1 vss 0.0166834f $X=0.2335 $Y=0.135
c2 3 vss 0.0860812f $X=0.189 $Y=0.135
c3 4 vss 0.0833073f $X=0.243 $Y=0.0245
c4 5 vss 0.00441491f $X=0.243 $Y=0.135
r1 26 25 16.4967 $w=2.1e-08 $l=4.85e-08 $layer=Gate_1 $thickness=5.6e-08
+ $X=0.189 $Y=0.2025 $X2=0.189 $Y2=0.154
r2 23 24 16.4967 $w=2.1e-08 $l=4.85e-08 $layer=Gate_1 $thickness=5.6e-08
+ $X=0.189 $Y=0.0675 $X2=0.189 $Y2=0.116
r3 3 15 6.54019 $w=2.09524e-08 $layer=Gate_1 $thickness=5.21905e-08 $X=0.189
+ $Y=0.135 $X2=0.189 $Y2=0.135
r4 3 24 6.6497 $w=2.04211e-08 $l=1.9e-08 $layer=Gate_1 $thickness=5.6e-08
+ $X=0.189 $Y=0.135 $X2=0.189 $Y2=0.116
r5 3 25 6.6497 $w=2.04211e-08 $l=1.9e-08 $layer=Gate_1 $thickness=5.6e-08
+ $X=0.189 $Y=0.135 $X2=0.189 $Y2=0.154
r6 19 20 1.22425 $w=1.3e-08 $l=5.2e-09 $layer=M1 $thickness=3.6e-08 $X=0.24
+ $Y=0.116 $X2=0.243 $Y2=0.1212
r7 5 12 19.3796 $a=3.24e-16 $layer=V0LIG $X=0.243 $Y=0.135 $X2=0.243 $Y2=0.135
r8 5 20 3.20636 $w=1.3e-08 $l=1.38e-08 $layer=M1 $thickness=3.6e-08 $X=0.243
+ $Y=0.135 $X2=0.243 $Y2=0.1212
r9 14 15 12.6539 $w=1.77815e-08 $l=2.7e-08 $layer=LIG $thickness=4.8e-08
+ $X=0.216 $Y=0.135 $X2=0.189 $Y2=0.135
r10 12 13 2.48102 $w=2.2e-08 $l=9.5e-09 $layer=LIG $thickness=4.8e-08 $X=0.243
+ $Y=0.135 $X2=0.2525 $Y2=0.135
r11 1 12 2.48102 $w=2.2e-08 $l=9.5e-09 $layer=LIG $thickness=4.8e-08 $X=0.2335
+ $Y=0.135 $X2=0.243 $Y2=0.135
r12 1 14 10.1729 $w=1.54914e-08 $l=1.75e-08 $layer=LIG $thickness=4.8e-08
+ $X=0.2335 $Y=0.135 $X2=0.216 $Y2=0.135
r13 10 9 16.4967 $w=2.1e-08 $l=4.85e-08 $layer=Gate_1 $thickness=5.6e-08
+ $X=0.243 $Y=0.2025 $X2=0.243 $Y2=0.154
r14 8 9 6.6497 $w=2.04211e-08 $l=1.9e-08 $layer=Gate_1 $thickness=5.6e-08
+ $X=0.243 $Y=0.135 $X2=0.243 $Y2=0.154
r15 8 13 4.05918 $w=2.0087e-08 $l=9.5e-09 $layer=Gate_1 $thickness=5.56522e-08
+ $X=0.243 $Y=0.135 $X2=0.2525 $Y2=0.135
r16 8 12 6.27904 $w=2.09e-08 $layer=Gate_1 $thickness=5.24e-08 $X=0.243
+ $Y=0.135 $X2=0.243 $Y2=0.135
r17 7 8 6.6497 $w=2.04211e-08 $l=1.9e-08 $layer=Gate_1 $thickness=5.6e-08
+ $X=0.243 $Y=0.116 $X2=0.243 $Y2=0.135
r18 6 7 16.4967 $w=2.1e-08 $l=4.85e-08 $layer=Gate_1 $thickness=5.6e-08
+ $X=0.243 $Y=0.0675 $X2=0.243 $Y2=0.116
r19 6 4 14.6259 $w=2.1e-08 $l=4.3e-08 $layer=Gate_1 $thickness=5.6e-08 $X=0.243
+ $Y=0.0675 $X2=0.243 $Y2=0.0245
.ends

.subckt PM_MAJx2_ASAP7_75t_R%8 vss 12 13 21 7 8 2 9 1
c1 1 vss 0.00598284f $X=0.054 $Y=0.2025
c2 2 vss 0.00879974f $X=0.27 $Y=0.2025
c3 7 vss 0.0360069f $X=0.056 $Y=0.2025
c4 8 vss 0.00449693f $X=0.2555 $Y=0.2025
c5 9 vss 0.0208602f $X=0.2205 $Y=0.234
r1 21 20 0.0308642 $w=8.1e-08 $l=2.5e-09 $layer=P_src_drn $thickness=1e-09
+ $X=0.0713 $Y=0.2025 $X2=0.0685 $Y2=0.2025
r2 7 20 0.154321 $w=8.1e-08 $l=1.25e-08 $layer=P_src_drn $thickness=1e-09
+ $X=0.056 $Y=0.2025 $X2=0.0685 $Y2=0.2025
r3 1 18 19.3796 $a=3.24e-16 $layer=V0LISD $X=0.054 $Y=0.2025 $X2=0.054 $Y2=0.234
r4 18 19 9.0944 $w=1.3e-08 $l=3.9e-08 $layer=M1 $thickness=3.6e-08 $X=0.054
+ $Y=0.234 $X2=0.093 $Y2=0.234
r5 16 19 13.6416 $w=1.3e-08 $l=5.85e-08 $layer=M1 $thickness=3.6e-08 $X=0.1515
+ $Y=0.234 $X2=0.093 $Y2=0.234
r6 9 14 11.5429 $w=1.3e-08 $l=4.95e-08 $layer=M1 $thickness=3.6e-08 $X=0.2205
+ $Y=0.234 $X2=0.27 $Y2=0.234
r7 9 16 16.0901 $w=1.3e-08 $l=6.9e-08 $layer=M1 $thickness=3.6e-08 $X=0.2205
+ $Y=0.234 $X2=0.1515 $Y2=0.234
r8 2 14 19.3796 $a=3.24e-16 $layer=V0LISD $X=0.27 $Y=0.2025 $X2=0.27 $Y2=0.234
r9 13 11 0.0308642 $w=8.1e-08 $l=2.5e-09 $layer=P_src_drn $thickness=1e-09
+ $X=0.2873 $Y=0.2025 $X2=0.2845 $Y2=0.2025
r10 2 11 0.179012 $w=8.1e-08 $l=1.45e-08 $layer=P_src_drn $thickness=1e-09
+ $X=0.27 $Y=0.2025 $X2=0.2845 $Y2=0.2025
r11 8 2 0.179012 $w=8.1e-08 $l=1.45e-08 $layer=P_src_drn $thickness=1e-09
+ $X=0.2555 $Y=0.2025 $X2=0.27 $Y2=0.2025
r12 12 8 0.0308642 $w=8.1e-08 $l=2.5e-09 $layer=P_src_drn $thickness=1e-09
+ $X=0.2526 $Y=0.2025 $X2=0.2555 $Y2=0.2025
r13 1 7 1e-05 $l=2e-09 $X=0.054 $Y=0.2025 $X2=0.056 $Y2=0.2025
.ends

.subckt PM_MAJx2_ASAP7_75t_R%Y vss 22 16 17 32 33 12 8 13 1 2 11 7
c1 1 vss 0.00871439f $X=0.378 $Y=0.0675
c2 2 vss 0.00888142f $X=0.378 $Y=0.2025
c3 7 vss 0.00448646f $X=0.3635 $Y=0.0675
c4 8 vss 0.00449093f $X=0.3635 $Y=0.2025
c5 9 vss 0.00290549f $X=0.459 $Y=0.036
c6 10 vss 0.00290971f $X=0.459 $Y=0.234
c7 11 vss 0.00816011f $X=0.3665 $Y=0.036
c8 12 vss 0.00867055f $X=0.3865 $Y=0.234
c9 13 vss 0.00823126f $X=0.459 $Y=0.054
r1 33 31 0.0308642 $w=8.1e-08 $l=2.5e-09 $layer=P_src_drn $thickness=1e-09
+ $X=0.3953 $Y=0.2025 $X2=0.3925 $Y2=0.2025
r2 2 31 0.179012 $w=8.1e-08 $l=1.45e-08 $layer=P_src_drn $thickness=1e-09
+ $X=0.378 $Y=0.2025 $X2=0.3925 $Y2=0.2025
r3 8 2 0.179012 $w=8.1e-08 $l=1.45e-08 $layer=P_src_drn $thickness=1e-09
+ $X=0.3635 $Y=0.2025 $X2=0.378 $Y2=0.2025
r4 32 8 0.0308642 $w=8.1e-08 $l=2.5e-09 $layer=P_src_drn $thickness=1e-09
+ $X=0.3606 $Y=0.2025 $X2=0.3635 $Y2=0.2025
r5 2 28 19.3796 $a=3.24e-16 $layer=V0LISD $X=0.378 $Y=0.2025 $X2=0.3775
+ $Y2=0.234
r6 12 26 7.46207 $w=1.3e-08 $l=3.2e-08 $layer=M1 $thickness=3.6e-08 $X=0.3865
+ $Y=0.234 $X2=0.4185 $Y2=0.234
r7 12 28 2.09871 $w=1.3e-08 $l=9e-09 $layer=M1 $thickness=3.6e-08 $X=0.3865
+ $Y=0.234 $X2=0.3775 $Y2=0.234
r8 10 25 2.5483 $w=1.79e-08 $l=1.8e-08 $layer=M1 $thickness=3.6e-08 $X=0.459
+ $Y=0.234 $X2=0.459 $Y2=0.216
r9 10 26 7.79507 $w=1.41111e-08 $l=4.05e-08 $layer=M1 $thickness=3.6e-08
+ $X=0.459 $Y=0.234 $X2=0.4185 $Y2=0.234
r10 24 25 8.86121 $w=1.3e-08 $l=3.8e-08 $layer=M1 $thickness=3.6e-08 $X=0.459
+ $Y=0.178 $X2=0.459 $Y2=0.216
r11 23 24 6.8791 $w=1.3e-08 $l=2.95e-08 $layer=M1 $thickness=3.6e-08 $X=0.459
+ $Y=0.1485 $X2=0.459 $Y2=0.178
r12 22 23 0.23319 $w=1.3e-08 $l=1e-09 $layer=M1 $thickness=3.6e-08 $X=0.459
+ $Y=0.1475 $X2=0.459 $Y2=0.1485
r13 22 21 9.91056 $w=1.3e-08 $l=4.25e-08 $layer=M1 $thickness=3.6e-08 $X=0.459
+ $Y=0.1475 $X2=0.459 $Y2=0.105
r14 13 21 11.8927 $w=1.3e-08 $l=5.1e-08 $layer=M1 $thickness=3.6e-08 $X=0.459
+ $Y=0.054 $X2=0.459 $Y2=0.105
r15 9 20 7.79507 $w=1.41111e-08 $l=4.05e-08 $layer=M1 $thickness=3.6e-08
+ $X=0.459 $Y=0.036 $X2=0.4185 $Y2=0.036
r16 9 13 2.5483 $w=1.79e-08 $l=1.8e-08 $layer=M1 $thickness=3.6e-08 $X=0.459
+ $Y=0.036 $X2=0.459 $Y2=0.054
r17 19 20 7.46207 $w=1.3e-08 $l=3.2e-08 $layer=M1 $thickness=3.6e-08 $X=0.3865
+ $Y=0.036 $X2=0.4185 $Y2=0.036
r18 18 19 2.09871 $w=1.3e-08 $l=9e-09 $layer=M1 $thickness=3.6e-08 $X=0.3775
+ $Y=0.036 $X2=0.3865 $Y2=0.036
r19 11 18 2.56509 $w=1.3e-08 $l=1.1e-08 $layer=M1 $thickness=3.6e-08 $X=0.3665
+ $Y=0.036 $X2=0.3775 $Y2=0.036
r20 1 18 19.3796 $a=3.24e-16 $layer=V0LISD $X=0.378 $Y=0.0675 $X2=0.3775
+ $Y2=0.036
r21 17 15 0.0308642 $w=8.1e-08 $l=2.5e-09 $layer=N_src_drn $thickness=1e-09
+ $X=0.3953 $Y=0.0675 $X2=0.3925 $Y2=0.0675
r22 1 15 0.179012 $w=8.1e-08 $l=1.45e-08 $layer=N_src_drn $thickness=1e-09
+ $X=0.378 $Y=0.0675 $X2=0.3925 $Y2=0.0675
r23 7 1 0.179012 $w=8.1e-08 $l=1.45e-08 $layer=N_src_drn $thickness=1e-09
+ $X=0.3635 $Y=0.0675 $X2=0.378 $Y2=0.0675
r24 16 7 0.0308642 $w=8.1e-08 $l=2.5e-09 $layer=N_src_drn $thickness=1e-09
+ $X=0.3606 $Y=0.0675 $X2=0.3635 $Y2=0.0675
.ends

.subckt PM_MAJx2_ASAP7_75t_R%B vss 27 16 20 38 41 1 12 5 2 9 13 7 14 6 10 15 8
+ 11
c1 1 vss 0.00406036f $X=0.135 $Y=0.135
c2 2 vss 0.00667456f $X=0.297 $Y=0.135
c3 5 vss 0.00798432f $X=0.135 $Y=0.135
c4 6 vss 0.0824975f $X=0.297 $Y=0.0245
c5 7 vss 0.00207545f $X=0.189 $Y=0.135
c6 8 vss 0.0022563f $X=0.189 $Y=0.198
c7 9 vss 0.00212827f $X=0.2855 $Y=0.135
c8 10 vss 0.00235071f $X=0.324 $Y=0.135
c9 11 vss 0.00306625f $X=0.324 $Y=0.198
c10 12 vss 0.00227763f $X=0.1245 $Y=0.135
c11 13 vss 0.00263283f $X=0.189 $Y=0.1765
c12 14 vss 0.00479639f $X=0.2862 $Y=0.198
c13 15 vss 0.00307347f $X=0.324 $Y=0.1465
r1 41 40 16.4967 $w=2.1e-08 $l=4.85e-08 $layer=Gate_1 $thickness=5.6e-08
+ $X=0.135 $Y=0.2025 $X2=0.135 $Y2=0.154
r2 38 39 16.4967 $w=2.1e-08 $l=4.85e-08 $layer=Gate_1 $thickness=5.6e-08
+ $X=0.135 $Y=0.0675 $X2=0.135 $Y2=0.116
r3 5 39 6.6497 $w=2.04211e-08 $l=1.9e-08 $layer=Gate_1 $thickness=5.6e-08
+ $X=0.135 $Y=0.135 $X2=0.135 $Y2=0.116
r4 5 40 6.6497 $w=2.04211e-08 $l=1.9e-08 $layer=Gate_1 $thickness=5.6e-08
+ $X=0.135 $Y=0.135 $X2=0.135 $Y2=0.154
r5 1 34 19.3796 $a=3.24e-16 $layer=V0LIG $X=0.135 $Y=0.135 $X2=0.135 $Y2=0.135
r6 1 5 10.4265 $w=1.765e-08 $layer=LIG $thickness=5.2e-08 $X=0.135 $Y=0.135
+ $X2=0.135 $Y2=0.135
r7 34 35 6.29612 $w=1.3e-08 $l=2.7e-08 $layer=M1 $thickness=3.6e-08 $X=0.135
+ $Y=0.135 $X2=0.162 $Y2=0.135
r8 12 34 2.44849 $w=1.3e-08 $l=1.05e-08 $layer=M1 $thickness=3.6e-08 $X=0.1245
+ $Y=0.135 $X2=0.135 $Y2=0.135
r9 7 33 2.78149 $w=1.76421e-08 $l=1.9e-08 $layer=M1 $thickness=3.6e-08 $X=0.189
+ $Y=0.135 $X2=0.189 $Y2=0.154
r10 7 35 4.64701 $w=1.46667e-08 $l=2.7e-08 $layer=M1 $thickness=3.6e-08
+ $X=0.189 $Y=0.135 $X2=0.162 $Y2=0.135
r11 13 33 5.24677 $w=1.3e-08 $l=2.25e-08 $layer=M1 $thickness=3.6e-08 $X=0.189
+ $Y=0.1765 $X2=0.189 $Y2=0.154
r12 8 32 4.64701 $w=1.46667e-08 $l=2.7e-08 $layer=M1 $thickness=3.6e-08
+ $X=0.189 $Y=0.198 $X2=0.216 $Y2=0.198
r13 8 13 3.36447 $w=1.71023e-08 $l=2.15e-08 $layer=M1 $thickness=3.6e-08
+ $X=0.189 $Y=0.198 $X2=0.189 $Y2=0.1765
r14 31 32 6.29612 $w=1.3e-08 $l=2.7e-08 $layer=M1 $thickness=3.6e-08 $X=0.243
+ $Y=0.198 $X2=0.216 $Y2=0.198
r15 30 31 5.71315 $w=1.3e-08 $l=2.45e-08 $layer=M1 $thickness=3.6e-08 $X=0.2675
+ $Y=0.198 $X2=0.243 $Y2=0.198
r16 29 30 3.73104 $w=1.3e-08 $l=1.6e-08 $layer=M1 $thickness=3.6e-08 $X=0.2835
+ $Y=0.198 $X2=0.2675 $Y2=0.198
r17 27 28 3.08976 $w=1.3e-08 $l=1.32e-08 $layer=M1 $thickness=3.6e-08 $X=0.289
+ $Y=0.199 $X2=0.3022 $Y2=0.198
r18 27 14 0.641272 $w=1.3e-08 $l=2.8e-09 $layer=M1 $thickness=3.6e-08 $X=0.289
+ $Y=0.199 $X2=0.2862 $Y2=0.198
r19 14 29 0.641272 $w=1.3e-08 $l=2.7e-09 $layer=M1 $thickness=3.6e-08 $X=0.2862
+ $Y=0.198 $X2=0.2835 $Y2=0.198
r20 11 26 3.36447 $w=1.71023e-08 $l=2.15e-08 $layer=M1 $thickness=3.6e-08
+ $X=0.324 $Y=0.198 $X2=0.324 $Y2=0.1765
r21 11 28 3.42276 $w=1.5069e-08 $l=2.18e-08 $layer=M1 $thickness=3.6e-08
+ $X=0.324 $Y=0.198 $X2=0.3022 $Y2=0.198
r22 25 26 4.6638 $w=1.3e-08 $l=2e-08 $layer=M1 $thickness=3.6e-08 $X=0.324
+ $Y=0.1565 $X2=0.324 $Y2=0.1765
r23 15 25 2.3319 $w=1.3e-08 $l=1e-08 $layer=M1 $thickness=3.6e-08 $X=0.324
+ $Y=0.1465 $X2=0.324 $Y2=0.1565
r24 10 23 1.96775 $w=1.63333e-08 $l=1.35e-08 $layer=M1 $thickness=3.6e-08
+ $X=0.324 $Y=0.135 $X2=0.3105 $Y2=0.135
r25 10 15 1.50137 $w=1.6913e-08 $l=1.15e-08 $layer=M1 $thickness=3.6e-08
+ $X=0.324 $Y=0.135 $X2=0.324 $Y2=0.1465
r26 22 23 3.14806 $w=1.3e-08 $l=1.35e-08 $layer=M1 $thickness=3.6e-08 $X=0.297
+ $Y=0.135 $X2=0.3105 $Y2=0.135
r27 9 22 2.68168 $w=1.3e-08 $l=1.15e-08 $layer=M1 $thickness=3.6e-08 $X=0.2855
+ $Y=0.135 $X2=0.297 $Y2=0.135
r28 2 18 10.4265 $w=1.765e-08 $layer=LIG $thickness=5.2e-08 $X=0.297 $Y=0.135
+ $X2=0.297 $Y2=0.135
r29 2 22 19.3796 $a=3.24e-16 $layer=V0LIG $X=0.297 $Y=0.135 $X2=0.297 $Y2=0.135
r30 20 19 16.4967 $w=2.1e-08 $l=4.85e-08 $layer=Gate_1 $thickness=5.6e-08
+ $X=0.297 $Y=0.2025 $X2=0.297 $Y2=0.154
r31 18 19 6.6497 $w=2.04211e-08 $l=1.9e-08 $layer=Gate_1 $thickness=5.6e-08
+ $X=0.297 $Y=0.135 $X2=0.297 $Y2=0.154
r32 17 18 6.6497 $w=2.04211e-08 $l=1.9e-08 $layer=Gate_1 $thickness=5.6e-08
+ $X=0.297 $Y=0.116 $X2=0.297 $Y2=0.135
r33 16 17 16.4967 $w=2.1e-08 $l=4.85e-08 $layer=Gate_1 $thickness=5.6e-08
+ $X=0.297 $Y=0.0675 $X2=0.297 $Y2=0.116
r34 16 6 14.6259 $w=2.1e-08 $l=4.3e-08 $layer=Gate_1 $thickness=5.6e-08
+ $X=0.297 $Y=0.0675 $X2=0.297 $Y2=0.0245
.ends

.subckt PM_MAJx2_ASAP7_75t_R%6 vss 20 24 37 41 59 60 71 72 12 3 4 18 17 16 11 1
+ 19 9 13 14 15 10
c1 1 vss 0.00737654f $X=0.351 $Y=0.135
c2 3 vss 0.00361445f $X=0.108 $Y=0.0675
c3 4 vss 0.00361448f $X=0.108 $Y=0.2025
c4 9 vss 0.0810386f $X=0.351 $Y=0.0245
c5 10 vss 0.0845009f $X=0.405 $Y=0.135
c6 11 vss 0.00491958f $X=0.0935 $Y=0.0675
c7 12 vss 0.00495801f $X=0.0935 $Y=0.2025
c8 13 vss 0.00185929f $X=0.027 $Y=0.072
c9 14 vss 0.00185208f $X=0.027 $Y=0.198
c10 15 vss 0.000771832f $X=0.377 $Y=0.072
c11 16 vss 0.00542181f $X=0.027 $Y=0.0935
c12 17 vss 0.00987826f $X=0.366 $Y=0.072
c13 18 vss 0.00202368f $X=0.038 $Y=0.198
c14 19 vss 0.00214476f $X=0.377 $Y=0.116
r1 72 70 0.0308642 $w=8.1e-08 $l=2.5e-09 $layer=P_src_drn $thickness=1e-09
+ $X=0.1253 $Y=0.2025 $X2=0.1225 $Y2=0.2025
r2 4 70 0.179012 $w=8.1e-08 $l=1.45e-08 $layer=P_src_drn $thickness=1e-09
+ $X=0.108 $Y=0.2025 $X2=0.1225 $Y2=0.2025
r3 12 4 0.179012 $w=8.1e-08 $l=1.45e-08 $layer=P_src_drn $thickness=1e-09
+ $X=0.0935 $Y=0.2025 $X2=0.108 $Y2=0.2025
r4 71 12 0.0308642 $w=8.1e-08 $l=2.5e-09 $layer=P_src_drn $thickness=1e-09
+ $X=0.0906 $Y=0.2025 $X2=0.0935 $Y2=0.2025
r5 4 66 19.3796 $a=3.24e-16 $layer=V0LISD $X=0.108 $Y=0.2025 $X2=0.109 $Y2=0.198
r6 65 66 3.26466 $w=1.3e-08 $l=1.4e-08 $layer=M1 $thickness=3.6e-08 $X=0.095
+ $Y=0.198 $X2=0.109 $Y2=0.198
r7 64 65 3.26466 $w=1.3e-08 $l=1.4e-08 $layer=M1 $thickness=3.6e-08 $X=0.081
+ $Y=0.198 $X2=0.095 $Y2=0.198
r8 63 64 5.82974 $w=1.3e-08 $l=2.5e-08 $layer=M1 $thickness=3.6e-08 $X=0.056
+ $Y=0.198 $X2=0.081 $Y2=0.198
r9 18 63 4.19742 $w=1.3e-08 $l=1.8e-08 $layer=M1 $thickness=3.6e-08 $X=0.038
+ $Y=0.198 $X2=0.056 $Y2=0.198
r10 14 62 3.36447 $w=1.71023e-08 $l=2.15e-08 $layer=M1 $thickness=3.6e-08
+ $X=0.027 $Y=0.198 $X2=0.027 $Y2=0.1765
r11 14 18 0.915974 $w=1.70909e-08 $l=1.1e-08 $layer=M1 $thickness=3.6e-08
+ $X=0.027 $Y=0.198 $X2=0.038 $Y2=0.198
r12 61 62 9.67737 $w=1.3e-08 $l=4.15e-08 $layer=M1 $thickness=3.6e-08 $X=0.027
+ $Y=0.135 $X2=0.027 $Y2=0.1765
r13 16 61 9.67737 $w=1.3e-08 $l=4.15e-08 $layer=M1 $thickness=3.6e-08 $X=0.027
+ $Y=0.0935 $X2=0.027 $Y2=0.135
r14 60 58 0.0308642 $w=8.1e-08 $l=2.5e-09 $layer=N_src_drn $thickness=1e-09
+ $X=0.1253 $Y=0.0675 $X2=0.1225 $Y2=0.0675
r15 3 58 0.179012 $w=8.1e-08 $l=1.45e-08 $layer=N_src_drn $thickness=1e-09
+ $X=0.108 $Y=0.0675 $X2=0.1225 $Y2=0.0675
r16 11 3 0.179012 $w=8.1e-08 $l=1.45e-08 $layer=N_src_drn $thickness=1e-09
+ $X=0.0935 $Y=0.0675 $X2=0.108 $Y2=0.0675
r17 59 11 0.0308642 $w=8.1e-08 $l=2.5e-09 $layer=N_src_drn $thickness=1e-09
+ $X=0.0906 $Y=0.0675 $X2=0.0935 $Y2=0.0675
r18 13 56 0.915974 $w=1.70909e-08 $l=1.1e-08 $layer=M1 $thickness=3.6e-08
+ $X=0.027 $Y=0.072 $X2=0.038 $Y2=0.072
r19 13 16 3.36447 $w=1.71023e-08 $l=2.15e-08 $layer=M1 $thickness=3.6e-08
+ $X=0.027 $Y=0.072 $X2=0.027 $Y2=0.0935
r20 3 52 19.3796 $a=3.24e-16 $layer=V0LISD $X=0.108 $Y=0.0675 $X2=0.109
+ $Y2=0.072
r21 55 56 4.19742 $w=1.3e-08 $l=1.8e-08 $layer=M1 $thickness=3.6e-08 $X=0.056
+ $Y=0.072 $X2=0.038 $Y2=0.072
r22 54 55 5.82974 $w=1.3e-08 $l=2.5e-08 $layer=M1 $thickness=3.6e-08 $X=0.081
+ $Y=0.072 $X2=0.056 $Y2=0.072
r23 52 53 2.44849 $w=1.3e-08 $l=1.05e-08 $layer=M1 $thickness=3.6e-08 $X=0.109
+ $Y=0.072 $X2=0.1195 $Y2=0.072
r24 51 52 3.26466 $w=1.3e-08 $l=1.4e-08 $layer=M1 $thickness=3.6e-08 $X=0.095
+ $Y=0.072 $X2=0.109 $Y2=0.072
r25 51 54 3.26466 $w=1.3e-08 $l=1.4e-08 $layer=M1 $thickness=3.6e-08 $X=0.095
+ $Y=0.072 $X2=0.081 $Y2=0.072
r26 50 53 9.32759 $w=1.3e-08 $l=4e-08 $layer=M1 $thickness=3.6e-08 $X=0.1595
+ $Y=0.072 $X2=0.1195 $Y2=0.072
r27 49 50 13.1752 $w=1.3e-08 $l=5.65e-08 $layer=M1 $thickness=3.6e-08 $X=0.216
+ $Y=0.072 $X2=0.1595 $Y2=0.072
r28 48 49 6.29612 $w=1.3e-08 $l=2.7e-08 $layer=M1 $thickness=3.6e-08 $X=0.243
+ $Y=0.072 $X2=0.216 $Y2=0.072
r29 47 48 5.71315 $w=1.3e-08 $l=2.45e-08 $layer=M1 $thickness=3.6e-08 $X=0.2675
+ $Y=0.072 $X2=0.243 $Y2=0.072
r30 46 47 3.73104 $w=1.3e-08 $l=1.6e-08 $layer=M1 $thickness=3.6e-08 $X=0.2835
+ $Y=0.072 $X2=0.2675 $Y2=0.072
r31 45 46 3.73104 $w=1.3e-08 $l=1.6e-08 $layer=M1 $thickness=3.6e-08 $X=0.2995
+ $Y=0.072 $X2=0.2835 $Y2=0.072
r32 44 45 5.71315 $w=1.3e-08 $l=2.45e-08 $layer=M1 $thickness=3.6e-08 $X=0.324
+ $Y=0.072 $X2=0.2995 $Y2=0.072
r33 43 44 5.71315 $w=1.3e-08 $l=2.45e-08 $layer=M1 $thickness=3.6e-08 $X=0.3485
+ $Y=0.072 $X2=0.324 $Y2=0.072
r34 17 43 4.08082 $w=1.3e-08 $l=1.75e-08 $layer=M1 $thickness=3.6e-08 $X=0.366
+ $Y=0.072 $X2=0.3485 $Y2=0.072
r35 15 34 3.36447 $w=1.71023e-08 $l=2.15e-08 $layer=M1 $thickness=3.6e-08
+ $X=0.377 $Y=0.072 $X2=0.377 $Y2=0.0935
r36 15 17 0.915974 $w=1.70909e-08 $l=1.1e-08 $layer=M1 $thickness=3.6e-08
+ $X=0.377 $Y=0.072 $X2=0.366 $Y2=0.072
r37 41 40 14.6259 $w=2.1e-08 $l=4.3e-08 $layer=Gate_1 $thickness=5.6e-08
+ $X=0.405 $Y=0.2025 $X2=0.405 $Y2=0.1595
r38 39 40 2.7211 $w=2.1e-08 $l=8e-09 $layer=Gate_1 $thickness=5.6e-08 $X=0.405
+ $Y=0.1515 $X2=0.405 $Y2=0.1595
r39 37 38 14.6259 $w=2.1e-08 $l=4.3e-08 $layer=Gate_1 $thickness=5.6e-08
+ $X=0.405 $Y=0.0675 $X2=0.405 $Y2=0.1105
r40 35 38 2.7211 $w=2.1e-08 $l=8e-09 $layer=Gate_1 $thickness=5.6e-08 $X=0.405
+ $Y=0.1185 $X2=0.405 $Y2=0.1105
r41 10 30 6.54019 $w=2.09524e-08 $layer=Gate_1 $thickness=5.21905e-08 $X=0.405
+ $Y=0.135 $X2=0.405 $Y2=0.135
r42 10 35 5.79936 $w=2.03333e-08 $l=1.65e-08 $layer=Gate_1 $thickness=5.6e-08
+ $X=0.405 $Y=0.135 $X2=0.405 $Y2=0.1185
r43 10 39 5.79936 $w=2.03333e-08 $l=1.65e-08 $layer=Gate_1 $thickness=5.6e-08
+ $X=0.405 $Y=0.135 $X2=0.405 $Y2=0.1515
r44 19 32 4.43061 $w=1.3e-08 $l=1.9e-08 $layer=M1 $thickness=3.6e-08 $X=0.377
+ $Y=0.116 $X2=0.377 $Y2=0.135
r45 19 34 5.24677 $w=1.3e-08 $l=2.25e-08 $layer=M1 $thickness=3.6e-08 $X=0.377
+ $Y=0.116 $X2=0.377 $Y2=0.0935
r46 29 30 5.26985 $w=1.99207e-08 $l=1.45e-08 $layer=LIG $thickness=4.8e-08
+ $X=0.3905 $Y=0.135 $X2=0.405 $Y2=0.135
r47 28 29 7.97476 $w=1.53e-08 $l=1.35e-08 $layer=LIG $thickness=4.8e-08
+ $X=0.377 $Y=0.135 $X2=0.3905 $Y2=0.135
r48 28 32 19.3796 $a=3.24e-16 $layer=V0LIG $X=0.377 $Y=0.135 $X2=0.377 $Y2=0.135
r49 27 28 7.38404 $w=1.53e-08 $l=1.25e-08 $layer=LIG $thickness=4.8e-08
+ $X=0.3645 $Y=0.135 $X2=0.377 $Y2=0.135
r50 1 22 6.54019 $w=2.09524e-08 $layer=Gate_1 $thickness=5.21905e-08 $X=0.351
+ $Y=0.135 $X2=0.351 $Y2=0.135
r51 1 27 4.67913 $w=2.0263e-08 $l=1.35e-08 $layer=LIG $thickness=4.8e-08
+ $X=0.351 $Y=0.135 $X2=0.3645 $Y2=0.135
r52 24 23 16.4967 $w=2.1e-08 $l=4.85e-08 $layer=Gate_1 $thickness=5.6e-08
+ $X=0.351 $Y=0.2025 $X2=0.351 $Y2=0.154
r53 22 23 6.6497 $w=2.04211e-08 $l=1.9e-08 $layer=Gate_1 $thickness=5.6e-08
+ $X=0.351 $Y=0.135 $X2=0.351 $Y2=0.154
r54 21 22 6.6497 $w=2.04211e-08 $l=1.9e-08 $layer=Gate_1 $thickness=5.6e-08
+ $X=0.351 $Y=0.116 $X2=0.351 $Y2=0.135
r55 20 21 16.4967 $w=2.1e-08 $l=4.85e-08 $layer=Gate_1 $thickness=5.6e-08
+ $X=0.351 $Y=0.0675 $X2=0.351 $Y2=0.116
r56 20 9 14.6259 $w=2.1e-08 $l=4.3e-08 $layer=Gate_1 $thickness=5.6e-08
+ $X=0.351 $Y=0.0675 $X2=0.351 $Y2=0.0245
.ends

.subckt PM_MAJx2_ASAP7_75t_R%7 vss 11 18 19 7 8 2 9 1
c1 1 vss 0.00598876f $X=0.054 $Y=0.0675
c2 2 vss 0.00880848f $X=0.27 $Y=0.0675
c3 7 vss 0.0358322f $X=0.056 $Y=0.0675
c4 8 vss 0.00448353f $X=0.2555 $Y=0.0675
c5 9 vss 0.0207552f $X=0.0425 $Y=0.036
r1 19 17 0.0308642 $w=8.1e-08 $l=2.5e-09 $layer=N_src_drn $thickness=1e-09
+ $X=0.2873 $Y=0.0675 $X2=0.2845 $Y2=0.0675
r2 2 17 0.179012 $w=8.1e-08 $l=1.45e-08 $layer=N_src_drn $thickness=1e-09
+ $X=0.27 $Y=0.0675 $X2=0.2845 $Y2=0.0675
r3 8 2 0.179012 $w=8.1e-08 $l=1.45e-08 $layer=N_src_drn $thickness=1e-09
+ $X=0.2555 $Y=0.0675 $X2=0.27 $Y2=0.0675
r4 18 8 0.0308642 $w=8.1e-08 $l=2.5e-09 $layer=N_src_drn $thickness=1e-09
+ $X=0.2526 $Y=0.0675 $X2=0.2555 $Y2=0.0675
r5 2 14 19.3796 $a=3.24e-16 $layer=V0LISD $X=0.27 $Y=0.0675 $X2=0.27 $Y2=0.036
r6 13 14 25.1845 $w=1.3e-08 $l=1.08e-07 $layer=M1 $thickness=3.6e-08 $X=0.162
+ $Y=0.036 $X2=0.27 $Y2=0.036
r7 12 13 25.1845 $w=1.3e-08 $l=1.08e-07 $layer=M1 $thickness=3.6e-08 $X=0.054
+ $Y=0.036 $X2=0.162 $Y2=0.036
r8 9 12 2.68168 $w=1.3e-08 $l=1.15e-08 $layer=M1 $thickness=3.6e-08 $X=0.0425
+ $Y=0.036 $X2=0.054 $Y2=0.036
r9 1 12 19.3796 $a=3.24e-16 $layer=V0LISD $X=0.054 $Y=0.0675 $X2=0.054 $Y2=0.036
r10 11 10 0.0308642 $w=8.1e-08 $l=2.5e-09 $layer=N_src_drn $thickness=1e-09
+ $X=0.0713 $Y=0.0675 $X2=0.0685 $Y2=0.0675
r11 7 10 0.154321 $w=8.1e-08 $l=1.25e-08 $layer=N_src_drn $thickness=1e-09
+ $X=0.056 $Y=0.0675 $X2=0.0685 $Y2=0.0675
r12 1 7 1e-05 $l=2e-09 $X=0.054 $Y=0.0675 $X2=0.056 $Y2=0.0675
.ends

.subckt PM_MAJx2_ASAP7_75t_R%A vss 14 5 11 3 4 1
c1 1 vss 0.000656513f $X=0.081 $Y=0.135
c2 3 vss 0.0218284f $X=0.081 $Y=0.0245
c3 4 vss 0.0040099f $X=0.081 $Y=0.135
r1 14 15 1.22425 $w=1.3e-08 $l=5.2e-09 $layer=M1 $thickness=3.6e-08 $X=0.082
+ $Y=0.116 $X2=0.081 $Y2=0.1212
r2 4 15 3.20636 $w=1.3e-08 $l=1.38e-08 $layer=M1 $thickness=3.6e-08 $X=0.081
+ $Y=0.135 $X2=0.081 $Y2=0.1212
r3 1 8 10.4265 $w=1.765e-08 $layer=LIG $thickness=5.2e-08 $X=0.081 $Y=0.135
+ $X2=0.081 $Y2=0.135
r4 1 4 19.3796 $a=3.24e-16 $layer=V0LIG $X=0.081 $Y=0.135 $X2=0.081 $Y2=0.135
r5 11 10 14.6259 $w=2.1e-08 $l=4.3e-08 $layer=Gate_1 $thickness=5.6e-08
+ $X=0.081 $Y=0.2025 $X2=0.081 $Y2=0.1595
r6 9 10 2.7211 $w=2.1e-08 $l=8e-09 $layer=Gate_1 $thickness=5.6e-08 $X=0.081
+ $Y=0.1515 $X2=0.081 $Y2=0.1595
r7 8 9 5.79936 $w=2.03333e-08 $l=1.65e-08 $layer=Gate_1 $thickness=5.6e-08
+ $X=0.081 $Y=0.135 $X2=0.081 $Y2=0.1515
r8 7 8 5.79936 $w=2.03333e-08 $l=1.65e-08 $layer=Gate_1 $thickness=5.6e-08
+ $X=0.081 $Y=0.1185 $X2=0.081 $Y2=0.135
r9 6 7 2.7211 $w=2.1e-08 $l=8e-09 $layer=Gate_1 $thickness=5.6e-08 $X=0.081
+ $Y=0.1105 $X2=0.081 $Y2=0.1185
r10 5 6 14.6259 $w=2.1e-08 $l=4.3e-08 $layer=Gate_1 $thickness=5.6e-08 $X=0.081
+ $Y=0.0675 $X2=0.081 $Y2=0.1105
r11 5 3 14.6259 $w=2.1e-08 $l=4.3e-08 $layer=Gate_1 $thickness=5.6e-08 $X=0.081
+ $Y=0.0675 $X2=0.081 $Y2=0.0245
.ends

* End of included file MAJx2_ASAP7_75t_R.pex.sp.pex

*
.subckt MAJx2_ASAP7_75t_CUSTOM_4_25_0_7 VSS VDD A B C Y
*
* VSS VSS
* VDD VDD
* A A
* B B
* C C
* Y Y
*
*

M0 N_M0_d N_M0_g N_M0_s VSS nmos_rvt L=2e-08 W=8.1e-08 nfin=3 $X=0.071 $Y=0.027
M1 N_M1_d N_M1_g N_M1_s VSS nmos_rvt L=2e-08 W=8.1e-08 nfin=3 $X=0.125 $Y=0.027
M2 VSS N_M2_g N_M2_s VSS nmos_rvt L=2e-08 W=8.1e-08 nfin=3 $X=0.179 $Y=0.027
M3 N_M3_d N_M3_g VSS VSS nmos_rvt L=2e-08 W=8.1e-08 nfin=3 $X=0.233 $Y=0.027
M4 VSS N_M4_g N_M4_s VSS nmos_rvt L=2e-08 W=8.1e-08 nfin=3 $X=0.287 $Y=0.027
M5 N_M5_d N_M5_g VSS VSS nmos_rvt L=2e-08 W=8.1e-08 nfin=3 $X=0.341 $Y=0.027
M6 N_M6_d N_M6_g VSS VSS nmos_rvt L=2e-08 W=8.1e-08 nfin=3 $X=0.395 $Y=0.027
M7 N_M7_d N_M7_g N_M7_s VDD pmos_rvt L=2e-08 W=8.1e-08 nfin=3 $X=0.071 $Y=0.162
M8 N_M8_d N_M8_g N_M8_s VDD pmos_rvt L=2e-08 W=8.1e-08 nfin=3 $X=0.125 $Y=0.162
M9 VDD N_M9_g N_M9_s VDD pmos_rvt L=2e-08 W=8.1e-08 nfin=3 $X=0.179 $Y=0.162
M10 N_M10_d N_M10_g VDD VDD pmos_rvt L=2e-08 W=8.1e-08 nfin=3 $X=0.233 $Y=0.162
M11 VDD N_M11_g N_M11_s VDD pmos_rvt L=2e-08 W=8.1e-08 nfin=3 $X=0.287 $Y=0.162
M12 N_M12_d N_M12_g VDD VDD pmos_rvt L=2e-08 W=8.1e-08 nfin=3 $X=0.341 $Y=0.162
M13 N_M13_d N_M13_g VDD VDD pmos_rvt L=2e-08 W=8.1e-08 nfin=3 $X=0.395 $Y=0.162

* .include "MAJx2_ASAP7_75t_R.pex.sp.pxi"

* Start of included file MAJx2_ASAP7_75t_R.pex.sp.pxi
x_PM_MAJx2_ASAP7_75t_R%10 vss N_M1_d N_M2_s N_10_1 PM_MAJx2_ASAP7_75t_R%10
cc_1 N_10_1 N_B_5 0.0167126f $X=0.162 $Y=0.0675
cc_2 N_10_1 N_C_3 0.0168147f $X=0.162 $Y=0.0675
x_PM_MAJx2_ASAP7_75t_R%11 vss N_M8_d N_M9_s N_11_1 PM_MAJx2_ASAP7_75t_R%11
cc_3 N_11_1 N_B_5 0.0168223f $X=0.162 $Y=0.2025
cc_4 N_11_1 N_C_3 0.0169021f $X=0.162 $Y=0.2025
x_PM_MAJx2_ASAP7_75t_R%C vss C N_M3_g N_M10_g N_M2_g N_M9_g N_C_3 N_C_1 N_C_5
+ N_C_4 PM_MAJx2_ASAP7_75t_R%C
cc_5 N_C_3 N_B_12 0.000320879f $X=0.189 $Y=0.135
cc_6 N_C_3 N_B_2 0.000333336f $X=0.189 $Y=0.135
cc_7 N_C_1 N_B_2 0.000567852f $X=0.2335 $Y=0.135
cc_8 N_C_1 N_B_9 0.000632759f $X=0.2335 $Y=0.135
cc_9 N_C_1 N_B_1 0.000688191f $X=0.2335 $Y=0.135
cc_10 N_C_5 N_B_13 0.000697096f $X=0.243 $Y=0.135
cc_11 N_C_5 N_B_7 0.000718821f $X=0.243 $Y=0.135
cc_12 N_C_5 N_B_14 0.00115124f $X=0.243 $Y=0.135
cc_13 N_C_1 N_B_7 0.00221816f $X=0.2335 $Y=0.135
cc_14 N_C_5 N_B_9 0.00333658f $X=0.243 $Y=0.135
cc_15 N_C_4 N_B_6 0.00342889f $X=0.243 $Y=0.0245
cc_16 N_C_3 N_B_5 0.00715053f $X=0.189 $Y=0.135
x_PM_MAJx2_ASAP7_75t_R%8 vss N_M10_d N_M11_s N_M7_s N_8_7 N_8_8 N_8_2 N_8_9
+ N_8_1 PM_MAJx2_ASAP7_75t_R%8
cc_17 N_8_7 N_A_3 0.0356915f $X=0.056 $Y=0.2025
cc_18 N_8_8 N_B_13 0.000241254f $X=0.2555 $Y=0.2025
cc_19 N_8_8 N_B_14 0.000477003f $X=0.2555 $Y=0.2025
cc_20 N_8_8 N_B_2 0.000659426f $X=0.2555 $Y=0.2025
cc_21 N_8_2 N_B_6 0.00154192f $X=0.27 $Y=0.2025
cc_22 N_8_9 N_B_14 0.00388318f $X=0.2205 $Y=0.234
cc_23 N_8_9 N_B_8 0.00553248f $X=0.2205 $Y=0.234
cc_24 N_8_8 N_B_6 0.0341506f $X=0.2555 $Y=0.2025
cc_25 N_8_8 N_C_1 0.000808824f $X=0.2555 $Y=0.2025
cc_26 N_8_8 N_C_4 0.0346097f $X=0.2555 $Y=0.2025
cc_27 N_8_9 N_6_4 0.000490714f $X=0.2205 $Y=0.234
cc_28 N_8_9 N_6_16 0.000601472f $X=0.2205 $Y=0.234
cc_29 N_8_9 N_6_12 0.000611948f $X=0.2205 $Y=0.234
cc_30 N_8_9 N_6_14 0.000643549f $X=0.2205 $Y=0.234
cc_31 N_8_1 N_6_18 0.00068455f $X=0.054 $Y=0.2025
cc_32 N_8_7 N_6_12 0.00074974f $X=0.056 $Y=0.2025
cc_33 N_8_1 N_6_4 0.00394494f $X=0.054 $Y=0.2025
cc_34 N_8_9 N_6_18 0.00808988f $X=0.2205 $Y=0.234
x_PM_MAJx2_ASAP7_75t_R%Y vss Y N_M5_d N_M6_d N_M12_d N_M13_d N_Y_12 N_Y_8
+ N_Y_13 N_Y_1 N_Y_2 N_Y_11 N_Y_7 PM_MAJx2_ASAP7_75t_R%Y
cc_35 N_Y_12 N_B_10 0.000268207f $X=0.3865 $Y=0.234
cc_36 N_Y_12 N_B_15 0.000361809f $X=0.3865 $Y=0.234
cc_37 N_Y_12 N_B_11 0.00198889f $X=0.3865 $Y=0.234
cc_38 N_Y_8 N_6_15 0.000469217f $X=0.3635 $Y=0.2025
cc_39 N_Y_8 N_6_1 0.000709565f $X=0.3635 $Y=0.2025
cc_40 N_Y_8 N_6_9 0.0374323f $X=0.3635 $Y=0.2025
cc_41 N_Y_8 N_6_17 0.00114059f $X=0.3635 $Y=0.2025
cc_42 N_Y_13 N_6_1 0.00119397f $X=0.459 $Y=0.054
cc_43 N_Y_1 N_6_19 0.00159758f $X=0.378 $Y=0.0675
cc_44 N_Y_2 N_6_9 0.00169837f $X=0.378 $Y=0.2025
cc_45 N_Y_1 N_6_10 0.00227277f $X=0.378 $Y=0.0675
cc_46 N_Y_11 N_6_15 0.0029955f $X=0.3665 $Y=0.036
cc_47 N_Y_7 N_6_1 0.0046704f $X=0.3635 $Y=0.0675
cc_48 N_Y_7 N_6_10 0.0103118f $X=0.3635 $Y=0.0675
cc_49 N_Y_7 N_6_9 0.0184324f $X=0.3635 $Y=0.0675
cc_50 N_Y_8 N_6_10 0.0669007f $X=0.3635 $Y=0.2025
x_PM_MAJx2_ASAP7_75t_R%B vss B N_M4_g N_M11_g N_M1_g N_M8_g N_B_1 N_B_12 N_B_5
+ N_B_2 N_B_9 N_B_13 N_B_7 N_B_14 N_B_6 N_B_10 N_B_15 N_B_8 N_B_11
+ PM_MAJx2_ASAP7_75t_R%B
cc_51 N_B_1 N_A_3 0.000972199f $X=0.135 $Y=0.135
cc_52 N_B_12 N_A_4 0.00159104f $X=0.1245 $Y=0.135
cc_53 N_B_5 N_A_3 0.00408478f $X=0.135 $Y=0.135
x_PM_MAJx2_ASAP7_75t_R%6 vss N_M5_g N_M12_g N_M6_g N_M13_g N_M0_d N_M1_s N_M7_d
+ N_M8_s N_6_12 N_6_3 N_6_4 N_6_18 N_6_17 N_6_16 N_6_11 N_6_1 N_6_19 N_6_9
+ N_6_13 N_6_14 N_6_15 N_6_10 PM_MAJx2_ASAP7_75t_R%6
cc_54 N_6_12 N_A_3 0.0150555f $X=0.0935 $Y=0.2025
cc_55 N_6_3 N_A_3 0.000780896f $X=0.108 $Y=0.0675
cc_56 N_6_4 N_A_3 0.000780896f $X=0.108 $Y=0.2025
cc_57 N_6_4 N_A_1 0.000883064f $X=0.108 $Y=0.2025
cc_58 N_6_18 N_A_4 0.00096937f $X=0.038 $Y=0.198
cc_59 N_6_17 N_A_4 0.00110394f $X=0.366 $Y=0.072
cc_60 N_6_12 N_A_1 0.00149617f $X=0.0935 $Y=0.2025
cc_61 N_6_16 N_A_4 0.0047534f $X=0.027 $Y=0.0935
cc_62 N_6_11 N_A_3 0.05364f $X=0.0935 $Y=0.0675
cc_63 N_6_3 N_B_1 0.000303442f $X=0.108 $Y=0.0675
cc_64 N_6_4 N_B_1 0.00113009f $X=0.108 $Y=0.2025
cc_65 N_6_1 N_B_10 0.00031776f $X=0.351 $Y=0.135
cc_66 N_6_18 N_B_13 0.000324504f $X=0.038 $Y=0.198
cc_67 N_6_17 N_B_9 0.000378524f $X=0.366 $Y=0.072
cc_68 N_6_12 N_B_5 0.0152649f $X=0.0935 $Y=0.2025
cc_69 N_6_1 N_B_2 0.00201029f $X=0.351 $Y=0.135
cc_70 N_6_19 N_B_15 0.00059213f $X=0.377 $Y=0.116
cc_71 N_6_18 N_B_12 0.000593233f $X=0.038 $Y=0.198
cc_72 N_6_3 N_B_5 0.00102029f $X=0.108 $Y=0.0675
cc_73 N_6_4 N_B_5 0.00102029f $X=0.108 $Y=0.2025
cc_74 N_6_17 N_B_10 0.00148369f $X=0.366 $Y=0.072
cc_75 N_6_17 N_B_12 0.0015085f $X=0.366 $Y=0.072
cc_76 N_6_19 N_B_10 0.00164537f $X=0.377 $Y=0.116
cc_77 N_6_11 N_B_1 0.00168518f $X=0.0935 $Y=0.0675
cc_78 N_6_9 N_B_6 0.00332478f $X=0.351 $Y=0.0245
cc_79 N_6_17 N_B_7 0.00349936f $X=0.366 $Y=0.072
cc_80 N_6_11 N_B_5 0.0549964f $X=0.0935 $Y=0.0675
cc_81 N_6_17 N_C_5 0.00367713f $X=0.366 $Y=0.072
x_PM_MAJx2_ASAP7_75t_R%7 vss N_M0_s N_M3_d N_M4_s N_7_7 N_7_8 N_7_2 N_7_9 N_7_1
+ PM_MAJx2_ASAP7_75t_R%7
cc_82 N_7_7 N_A_3 0.0358088f $X=0.056 $Y=0.0675
cc_83 N_7_8 N_B_12 0.000345511f $X=0.2555 $Y=0.0675
cc_84 N_7_8 N_B_2 0.000660496f $X=0.2555 $Y=0.0675
cc_85 N_7_2 N_B_6 0.00154347f $X=0.27 $Y=0.0675
cc_86 N_7_8 N_B_6 0.034037f $X=0.2555 $Y=0.0675
cc_87 N_7_8 N_C_1 0.000755766f $X=0.2555 $Y=0.0675
cc_88 N_7_8 N_C_4 0.0346117f $X=0.2555 $Y=0.0675
cc_89 N_7_9 N_6_3 0.00049121f $X=0.0425 $Y=0.036
cc_90 N_7_9 N_6_11 0.000595723f $X=0.0425 $Y=0.036
cc_91 N_7_9 N_6_16 0.000601174f $X=0.0425 $Y=0.036
cc_92 N_7_9 N_6_13 0.000641561f $X=0.0425 $Y=0.036
cc_93 N_7_1 N_6_17 0.000685242f $X=0.054 $Y=0.0675
cc_94 N_7_7 N_6_11 0.000750362f $X=0.056 $Y=0.0675
cc_95 N_7_1 N_6_3 0.00394893f $X=0.054 $Y=0.0675
cc_96 N_7_9 N_6_17 0.0193466f $X=0.0425 $Y=0.036
x_PM_MAJx2_ASAP7_75t_R%A vss A N_M0_g N_M7_g N_A_3 N_A_4 N_A_1
+ PM_MAJx2_ASAP7_75t_R%A

* End of included file MAJx2_ASAP7_75t_R.pex.sp.pxi
.ends

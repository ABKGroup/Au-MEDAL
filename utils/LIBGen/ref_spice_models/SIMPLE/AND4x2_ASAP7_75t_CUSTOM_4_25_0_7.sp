.subckt PM_AND4x2_ASAP7_75t_R%9 vss 2 3 1
c1 1 vss 0.000786528f $X=0.216 $Y=0.0675
r1 2 1 0.209877 $w=8.1e-08 $l=1.7e-08 $layer=N_src_drn $thickness=1e-09
+ $X=0.1986 $Y=0.0675 $X2=0.216 $Y2=0.0675
r2 3 1 0.209877 $w=8.1e-08 $l=1.7e-08 $layer=N_src_drn $thickness=1e-09
+ $X=0.2333 $Y=0.0675 $X2=0.216 $Y2=0.0675
.ends

.subckt PM_AND4x2_ASAP7_75t_R%11 vss 2 3 1
c1 1 vss 0.000727731f $X=0.324 $Y=0.0675
r1 2 1 0.209877 $w=8.1e-08 $l=1.7e-08 $layer=N_src_drn $thickness=1e-09
+ $X=0.3066 $Y=0.0675 $X2=0.324 $Y2=0.0675
r2 3 1 0.209877 $w=8.1e-08 $l=1.7e-08 $layer=N_src_drn $thickness=1e-09
+ $X=0.3413 $Y=0.0675 $X2=0.324 $Y2=0.0675
.ends

.subckt PM_AND4x2_ASAP7_75t_R%D vss 15 5 9 3 1 4
c1 1 vss 0.0040856f $X=0.189 $Y=0.135
c2 3 vss 0.0852384f $X=0.189 $Y=0.0245
c3 4 vss 0.0134885f $X=0.189 $Y=0.082
r1 15 14 2.91487 $w=1.3e-08 $l=1.25e-08 $layer=M1 $thickness=3.6e-08 $X=0.189
+ $Y=0.132 $X2=0.189 $Y2=0.1225
r2 4 14 9.44419 $w=1.3e-08 $l=4.05e-08 $layer=M1 $thickness=3.6e-08 $X=0.189
+ $Y=0.082 $X2=0.189 $Y2=0.1225
r3 1 7 7.07951 $w=1.89474e-08 $layer=LIG $thickness=5.17895e-08 $X=0.189
+ $Y=0.135 $X2=0.189 $Y2=0.135
r4 15 1 19.3796 $a=3.24e-16 $layer=V0LIG $X=0.189 $Y=0.132 $X2=0.189 $Y2=0.135
r5 9 8 16.8368 $w=2.1e-08 $l=4.95e-08 $layer=Gate_1 $thickness=5.6e-08 $X=0.189
+ $Y=0.2025 $X2=0.189 $Y2=0.153
r6 7 8 6.27555 $w=2.05e-08 $l=1.8e-08 $layer=Gate_1 $thickness=5.6e-08 $X=0.189
+ $Y=0.135 $X2=0.189 $Y2=0.153
r7 6 7 6.27555 $w=2.05e-08 $l=1.8e-08 $layer=Gate_1 $thickness=5.6e-08 $X=0.189
+ $Y=0.117 $X2=0.189 $Y2=0.135
r8 5 6 16.8368 $w=2.1e-08 $l=4.95e-08 $layer=Gate_1 $thickness=5.6e-08 $X=0.189
+ $Y=0.0675 $X2=0.189 $Y2=0.117
r9 5 3 14.6259 $w=2.1e-08 $l=4.3e-08 $layer=Gate_1 $thickness=5.6e-08 $X=0.189
+ $Y=0.0675 $X2=0.189 $Y2=0.0245
.ends

.subckt PM_AND4x2_ASAP7_75t_R%A vss 15 5 11 3 4 1
c1 1 vss 0.00266079f $X=0.351 $Y=0.135
c2 3 vss 0.0533054f $X=0.351 $Y=0.0245
c3 4 vss 0.00708509f $X=0.351 $Y=0.098
r1 15 4 8.62802 $w=1.3e-08 $l=3.7e-08 $layer=M1 $thickness=3.6e-08 $X=0.351
+ $Y=0.132 $X2=0.351 $Y2=0.098
r2 1 8 7.07951 $w=1.89474e-08 $layer=LIG $thickness=5.17895e-08 $X=0.351
+ $Y=0.135 $X2=0.351 $Y2=0.135
r3 15 1 19.3796 $a=3.24e-16 $layer=V0LIG $X=0.351 $Y=0.132 $X2=0.351 $Y2=0.135
r4 11 10 14.6259 $w=2.1e-08 $l=4.3e-08 $layer=Gate_1 $thickness=5.6e-08
+ $X=0.351 $Y=0.2025 $X2=0.351 $Y2=0.1595
r5 9 10 3.06124 $w=2.1e-08 $l=9e-09 $layer=Gate_1 $thickness=5.6e-08 $X=0.351
+ $Y=0.1505 $X2=0.351 $Y2=0.1595
r6 8 9 5.4252 $w=2.04194e-08 $l=1.55e-08 $layer=Gate_1 $thickness=5.6e-08
+ $X=0.351 $Y=0.135 $X2=0.351 $Y2=0.1505
r7 7 8 5.4252 $w=2.04194e-08 $l=1.55e-08 $layer=Gate_1 $thickness=5.6e-08
+ $X=0.351 $Y=0.1195 $X2=0.351 $Y2=0.135
r8 6 7 3.06124 $w=2.1e-08 $l=9e-09 $layer=Gate_1 $thickness=5.6e-08 $X=0.351
+ $Y=0.1105 $X2=0.351 $Y2=0.1195
r9 5 6 14.6259 $w=2.1e-08 $l=4.3e-08 $layer=Gate_1 $thickness=5.6e-08 $X=0.351
+ $Y=0.0675 $X2=0.351 $Y2=0.1105
r10 5 3 14.6259 $w=2.1e-08 $l=4.3e-08 $layer=Gate_1 $thickness=5.6e-08 $X=0.351
+ $Y=0.0675 $X2=0.351 $Y2=0.0245
.ends

.subckt PM_AND4x2_ASAP7_75t_R%B vss 13 5 9 3 1 4
c1 1 vss 0.00251121f $X=0.297 $Y=0.135
c2 3 vss 0.0475556f $X=0.297 $Y=0.0245
c3 4 vss 0.0120777f $X=0.297 $Y=0.098
r1 13 4 8.62802 $w=1.3e-08 $l=3.7e-08 $layer=M1 $thickness=3.6e-08 $X=0.297
+ $Y=0.132 $X2=0.297 $Y2=0.098
r2 1 7 6.74717 $w=2e-08 $layer=Gate_1 $thickness=5.2e-08 $X=0.297 $Y=0.135
+ $X2=0.297 $Y2=0.135
r3 13 1 19.3796 $a=3.24e-16 $layer=V0LIG $X=0.297 $Y=0.132 $X2=0.297 $Y2=0.135
r4 9 8 16.6668 $w=2.1e-08 $l=4.9e-08 $layer=Gate_1 $thickness=5.6e-08 $X=0.297
+ $Y=0.2025 $X2=0.297 $Y2=0.1535
r5 7 8 6.46262 $w=2.04595e-08 $l=1.85e-08 $layer=Gate_1 $thickness=5.6e-08
+ $X=0.297 $Y=0.135 $X2=0.297 $Y2=0.1535
r6 6 7 6.46262 $w=2.04595e-08 $l=1.85e-08 $layer=Gate_1 $thickness=5.6e-08
+ $X=0.297 $Y=0.1165 $X2=0.297 $Y2=0.135
r7 5 6 16.6668 $w=2.1e-08 $l=4.9e-08 $layer=Gate_1 $thickness=5.6e-08 $X=0.297
+ $Y=0.0675 $X2=0.297 $Y2=0.1165
r8 5 3 14.6259 $w=2.1e-08 $l=4.3e-08 $layer=Gate_1 $thickness=5.6e-08 $X=0.297
+ $Y=0.0675 $X2=0.297 $Y2=0.0245
.ends

.subckt PM_AND4x2_ASAP7_75t_R%Y vss 21 16 17 28 29 8 2 13 7
c1 1 vss 0.0102625f $X=0.108 $Y=0.0675
c2 2 vss 0.00863183f $X=0.108 $Y=0.2025
c3 7 vss 0.00453548f $X=0.0935 $Y=0.0675
c4 8 vss 0.0045358f $X=0.0935 $Y=0.2025
c5 9 vss 0.0029147f $X=0.027 $Y=0.036
c6 10 vss 0.00291091f $X=0.027 $Y=0.234
c7 11 vss 0.00850503f $X=0.027 $Y=0.082
c8 12 vss 0.00895486f $X=0.108 $Y=0.036
c9 13 vss 0.00785324f $X=0.0675 $Y=0.234
r1 29 27 0.0308642 $w=8.1e-08 $l=2.5e-09 $layer=P_src_drn $thickness=1e-09
+ $X=0.1253 $Y=0.2025 $X2=0.1225 $Y2=0.2025
r2 2 27 0.179012 $w=8.1e-08 $l=1.45e-08 $layer=P_src_drn $thickness=1e-09
+ $X=0.108 $Y=0.2025 $X2=0.1225 $Y2=0.2025
r3 8 2 0.179012 $w=8.1e-08 $l=1.45e-08 $layer=P_src_drn $thickness=1e-09
+ $X=0.0935 $Y=0.2025 $X2=0.108 $Y2=0.2025
r4 28 8 0.0308642 $w=8.1e-08 $l=2.5e-09 $layer=P_src_drn $thickness=1e-09
+ $X=0.0906 $Y=0.2025 $X2=0.0935 $Y2=0.2025
r5 2 24 19.3796 $a=3.24e-16 $layer=V0LISD $X=0.108 $Y=0.2025 $X2=0.108 $Y2=0.234
r6 13 24 9.44419 $w=1.3e-08 $l=4.05e-08 $layer=M1 $thickness=3.6e-08 $X=0.0675
+ $Y=0.234 $X2=0.108 $Y2=0.234
r7 10 23 2.5483 $w=1.79e-08 $l=1.8e-08 $layer=M1 $thickness=3.6e-08 $X=0.027
+ $Y=0.234 $X2=0.027 $Y2=0.216
r8 10 13 7.79507 $w=1.41111e-08 $l=4.05e-08 $layer=M1 $thickness=3.6e-08
+ $X=0.027 $Y=0.234 $X2=0.0675 $Y2=0.234
r9 22 23 10.785 $w=1.3e-08 $l=4.63e-08 $layer=M1 $thickness=3.6e-08 $X=0.027
+ $Y=0.1697 $X2=0.027 $Y2=0.216
r10 21 22 8.80291 $w=1.3e-08 $l=3.77e-08 $layer=M1 $thickness=3.6e-08 $X=0.026
+ $Y=0.132 $X2=0.027 $Y2=0.1697
r11 21 20 1.57403 $w=1.3e-08 $l=6.8e-09 $layer=M1 $thickness=3.6e-08 $X=0.026
+ $Y=0.132 $X2=0.027 $Y2=0.1252
r12 11 20 10.0855 $w=1.3e-08 $l=4.32e-08 $layer=M1 $thickness=3.6e-08 $X=0.027
+ $Y=0.082 $X2=0.027 $Y2=0.1252
r13 9 18 7.79507 $w=1.41111e-08 $l=4.05e-08 $layer=M1 $thickness=3.6e-08
+ $X=0.027 $Y=0.036 $X2=0.0675 $Y2=0.036
r14 9 11 9.07762 $w=1.49174e-08 $l=4.6e-08 $layer=M1 $thickness=3.6e-08
+ $X=0.027 $Y=0.036 $X2=0.027 $Y2=0.082
r15 12 18 9.44419 $w=1.3e-08 $l=4.05e-08 $layer=M1 $thickness=3.6e-08 $X=0.108
+ $Y=0.036 $X2=0.0675 $Y2=0.036
r16 1 12 19.3796 $a=3.24e-16 $layer=V0LISD $X=0.108 $Y=0.0675 $X2=0.108
+ $Y2=0.036
r17 17 15 0.0308642 $w=8.1e-08 $l=2.5e-09 $layer=N_src_drn $thickness=1e-09
+ $X=0.1253 $Y=0.0675 $X2=0.1225 $Y2=0.0675
r18 1 15 0.179012 $w=8.1e-08 $l=1.45e-08 $layer=N_src_drn $thickness=1e-09
+ $X=0.108 $Y=0.0675 $X2=0.1225 $Y2=0.0675
r19 7 1 0.179012 $w=8.1e-08 $l=1.45e-08 $layer=N_src_drn $thickness=1e-09
+ $X=0.0935 $Y=0.0675 $X2=0.108 $Y2=0.0675
r20 16 7 0.0308642 $w=8.1e-08 $l=2.5e-09 $layer=N_src_drn $thickness=1e-09
+ $X=0.0906 $Y=0.0675 $X2=0.0935 $Y2=0.0675
.ends

.subckt PM_AND4x2_ASAP7_75t_R%3 vss 27 33 43 46 65 66 69 70 77 1 22 18 3 15 13
+ 25 5 4 16 20 26 14 19 17 23 12
c1 1 vss 0.0070911f $X=0.081 $Y=0.135
c2 3 vss 0.00862059f $X=0.216 $Y=0.2025
c3 4 vss 0.00874835f $X=0.324 $Y=0.2025
c4 5 vss 0.00706939f $X=0.378 $Y=0.0675
c5 12 vss 0.0831947f $X=0.081 $Y=0.0245
c6 13 vss 0.0809914f $X=0.135 $Y=0.135
c7 14 vss 0.0396908f $X=0.3635 $Y=0.0675
c8 15 vss 0.00620039f $X=0.2015 $Y=0.2025
c9 16 vss 0.00630647f $X=0.3095 $Y=0.2025
c10 17 vss 0.000717615f $X=0.108 $Y=0.198
c11 18 vss 0.000690287f $X=0.162 $Y=0.1945
c12 19 vss 0.00284719f $X=0.162 $Y=0.234
c13 20 vss 0.00655095f $X=0.405 $Y=0.036
c14 21 vss 0.00344211f $X=0.405 $Y=0.234
c15 22 vss 0.00214421f $X=0.108 $Y=0.1225
c16 23 vss 0.00115955f $X=0.1195 $Y=0.198
c17 24 vss 0.000680334f $X=0.162 $Y=0.216
c18 25 vss 0.0206459f $X=0.1755 $Y=0.234
c19 26 vss 0.00959114f $X=0.405 $Y=0.2125
r1 14 5 0.154321 $w=8.1e-08 $l=1.25e-08 $layer=N_src_drn $thickness=1e-09
+ $X=0.3635 $Y=0.0675 $X2=0.378 $Y2=0.0675
r2 77 14 0.0308642 $w=8.1e-08 $l=2.5e-09 $layer=N_src_drn $thickness=1e-09
+ $X=0.3606 $Y=0.0675 $X2=0.3635 $Y2=0.0675
r3 5 74 19.3796 $a=3.24e-16 $layer=V0LISD $X=0.378 $Y=0.0675 $X2=0.378 $Y2=0.036
r4 74 75 3.14806 $w=1.3e-08 $l=1.35e-08 $layer=M1 $thickness=3.6e-08 $X=0.378
+ $Y=0.036 $X2=0.3915 $Y2=0.036
r5 20 72 3.83327 $w=1.5093e-08 $l=2.15e-08 $layer=M1 $thickness=3.6e-08
+ $X=0.405 $Y=0.036 $X2=0.405 $Y2=0.0575
r6 20 75 1.96775 $w=1.63333e-08 $l=1.35e-08 $layer=M1 $thickness=3.6e-08
+ $X=0.405 $Y=0.036 $X2=0.3915 $Y2=0.036
r7 71 72 18.0722 $w=1.3e-08 $l=7.75e-08 $layer=M1 $thickness=3.6e-08 $X=0.405
+ $Y=0.135 $X2=0.405 $Y2=0.0575
r8 26 71 18.0722 $w=1.3e-08 $l=7.75e-08 $layer=M1 $thickness=3.6e-08 $X=0.405
+ $Y=0.2125 $X2=0.405 $Y2=0.135
r9 70 68 0.0308642 $w=8.1e-08 $l=2.5e-09 $layer=P_src_drn $thickness=1e-09
+ $X=0.3413 $Y=0.2025 $X2=0.3385 $Y2=0.2025
r10 4 68 0.179012 $w=8.1e-08 $l=1.45e-08 $layer=P_src_drn $thickness=1e-09
+ $X=0.324 $Y=0.2025 $X2=0.3385 $Y2=0.2025
r11 16 4 0.179012 $w=8.1e-08 $l=1.45e-08 $layer=P_src_drn $thickness=1e-09
+ $X=0.3095 $Y=0.2025 $X2=0.324 $Y2=0.2025
r12 69 16 0.0308642 $w=8.1e-08 $l=2.5e-09 $layer=P_src_drn $thickness=1e-09
+ $X=0.3066 $Y=0.2025 $X2=0.3095 $Y2=0.2025
r13 66 64 0.0308642 $w=8.1e-08 $l=2.5e-09 $layer=P_src_drn $thickness=1e-09
+ $X=0.2333 $Y=0.2025 $X2=0.2305 $Y2=0.2025
r14 3 64 0.179012 $w=8.1e-08 $l=1.45e-08 $layer=P_src_drn $thickness=1e-09
+ $X=0.216 $Y=0.2025 $X2=0.2305 $Y2=0.2025
r15 15 3 0.179012 $w=8.1e-08 $l=1.45e-08 $layer=P_src_drn $thickness=1e-09
+ $X=0.2015 $Y=0.2025 $X2=0.216 $Y2=0.2025
r16 65 15 0.0308642 $w=8.1e-08 $l=2.5e-09 $layer=P_src_drn $thickness=1e-09
+ $X=0.1986 $Y=0.2025 $X2=0.2015 $Y2=0.2025
r17 21 62 4.18063 $w=1.48e-08 $l=2.5e-08 $layer=M1 $thickness=3.6e-08 $X=0.405
+ $Y=0.234 $X2=0.38 $Y2=0.234
r18 21 26 3.36447 $w=1.71023e-08 $l=2.15e-08 $layer=M1 $thickness=3.6e-08
+ $X=0.405 $Y=0.234 $X2=0.405 $Y2=0.2125
r19 4 58 19.3796 $a=3.24e-16 $layer=V0LISD $X=0.324 $Y=0.2025 $X2=0.324
+ $Y2=0.234
r20 3 52 19.3796 $a=3.24e-16 $layer=V0LISD $X=0.216 $Y=0.2025 $X2=0.216
+ $Y2=0.234
r21 61 62 4.19742 $w=1.3e-08 $l=1.8e-08 $layer=M1 $thickness=3.6e-08 $X=0.362
+ $Y=0.234 $X2=0.38 $Y2=0.234
r22 60 61 2.56509 $w=1.3e-08 $l=1.1e-08 $layer=M1 $thickness=3.6e-08 $X=0.351
+ $Y=0.234 $X2=0.362 $Y2=0.234
r23 59 60 3.14806 $w=1.3e-08 $l=1.35e-08 $layer=M1 $thickness=3.6e-08 $X=0.3375
+ $Y=0.234 $X2=0.351 $Y2=0.234
r24 58 59 3.14806 $w=1.3e-08 $l=1.35e-08 $layer=M1 $thickness=3.6e-08 $X=0.324
+ $Y=0.234 $X2=0.3375 $Y2=0.234
r25 57 58 3.14806 $w=1.3e-08 $l=1.35e-08 $layer=M1 $thickness=3.6e-08 $X=0.3105
+ $Y=0.234 $X2=0.324 $Y2=0.234
r26 56 57 3.14806 $w=1.3e-08 $l=1.35e-08 $layer=M1 $thickness=3.6e-08 $X=0.297
+ $Y=0.234 $X2=0.3105 $Y2=0.234
r27 55 56 6.29612 $w=1.3e-08 $l=2.7e-08 $layer=M1 $thickness=3.6e-08 $X=0.27
+ $Y=0.234 $X2=0.297 $Y2=0.234
r28 54 55 6.29612 $w=1.3e-08 $l=2.7e-08 $layer=M1 $thickness=3.6e-08 $X=0.243
+ $Y=0.234 $X2=0.27 $Y2=0.234
r29 53 54 3.14806 $w=1.3e-08 $l=1.35e-08 $layer=M1 $thickness=3.6e-08 $X=0.2295
+ $Y=0.234 $X2=0.243 $Y2=0.234
r30 52 53 3.14806 $w=1.3e-08 $l=1.35e-08 $layer=M1 $thickness=3.6e-08 $X=0.216
+ $Y=0.234 $X2=0.2295 $Y2=0.234
r31 51 52 3.14806 $w=1.3e-08 $l=1.35e-08 $layer=M1 $thickness=3.6e-08 $X=0.2025
+ $Y=0.234 $X2=0.216 $Y2=0.234
r32 50 51 3.14806 $w=1.3e-08 $l=1.35e-08 $layer=M1 $thickness=3.6e-08 $X=0.189
+ $Y=0.234 $X2=0.2025 $Y2=0.234
r33 25 50 3.14806 $w=1.3e-08 $l=1.35e-08 $layer=M1 $thickness=3.6e-08 $X=0.1755
+ $Y=0.234 $X2=0.189 $Y2=0.234
r34 19 24 2.5483 $w=1.79e-08 $l=1.8e-08 $layer=M1 $thickness=3.6e-08 $X=0.162
+ $Y=0.234 $X2=0.162 $Y2=0.216
r35 19 25 1.49895 $w=1.63333e-08 $l=1.35e-08 $layer=M1 $thickness=3.6e-08
+ $X=0.162 $Y=0.234 $X2=0.1755 $Y2=0.234
r36 24 49 2.45586 $w=1.44e-08 $l=1.25e-08 $layer=M1 $thickness=3.6e-08 $X=0.162
+ $Y=0.216 $X2=0.162 $Y2=0.2035
r37 18 49 0.9184 $w=1.8e-08 $l=9e-09 $layer=M1 $thickness=3.6e-08 $X=0.162
+ $Y=0.1945 $X2=0.162 $Y2=0.2035
r38 48 49 3.9716 $w=1.39211e-08 $l=2.51098e-08 $layer=M1 $thickness=3.6e-08
+ $X=0.1375 $Y=0.198 $X2=0.162 $Y2=0.2035
r39 23 48 4.19742 $w=1.3e-08 $l=1.8e-08 $layer=M1 $thickness=3.6e-08 $X=0.1195
+ $Y=0.198 $X2=0.1375 $Y2=0.198
r40 17 41 3.36447 $w=1.71023e-08 $l=2.15e-08 $layer=M1 $thickness=3.6e-08
+ $X=0.108 $Y=0.198 $X2=0.108 $Y2=0.1765
r41 17 23 1.03257 $w=1.6913e-08 $l=1.15e-08 $layer=M1 $thickness=3.6e-08
+ $X=0.108 $Y=0.198 $X2=0.1195 $Y2=0.198
r42 46 45 16.8368 $w=2.1e-08 $l=4.95e-08 $layer=Gate_1 $thickness=5.6e-08
+ $X=0.135 $Y=0.2025 $X2=0.135 $Y2=0.153
r43 43 44 16.8368 $w=2.1e-08 $l=4.95e-08 $layer=Gate_1 $thickness=5.6e-08
+ $X=0.135 $Y=0.0675 $X2=0.135 $Y2=0.117
r44 13 37 7.07951 $w=1.89474e-08 $layer=LIG $thickness=5.17895e-08 $X=0.135
+ $Y=0.135 $X2=0.135 $Y2=0.135
r45 13 44 6.27555 $w=2.05e-08 $l=1.8e-08 $layer=Gate_1 $thickness=5.6e-08
+ $X=0.135 $Y=0.135 $X2=0.135 $Y2=0.117
r46 13 45 6.27555 $w=2.05e-08 $l=1.8e-08 $layer=Gate_1 $thickness=5.6e-08
+ $X=0.135 $Y=0.135 $X2=0.135 $Y2=0.153
r47 40 41 5.24677 $w=1.3e-08 $l=2.25e-08 $layer=M1 $thickness=3.6e-08 $X=0.108
+ $Y=0.154 $X2=0.108 $Y2=0.1765
r48 39 40 4.43061 $w=1.3e-08 $l=1.9e-08 $layer=M1 $thickness=3.6e-08 $X=0.108
+ $Y=0.135 $X2=0.108 $Y2=0.154
r49 22 39 2.91487 $w=1.3e-08 $l=1.25e-08 $layer=M1 $thickness=3.6e-08 $X=0.108
+ $Y=0.1225 $X2=0.108 $Y2=0.135
r50 36 37 30.1405 $w=1.37815e-08 $l=2.7e-08 $layer=LIG $thickness=4.8e-08
+ $X=0.108 $Y=0.135 $X2=0.135 $Y2=0.135
r51 36 39 19.3796 $a=3.24e-16 $layer=V0LIG $X=0.108 $Y=0.135 $X2=0.108 $Y2=0.135
r52 1 30 7.07951 $w=1.89474e-08 $layer=LIG $thickness=5.17895e-08 $X=0.081
+ $Y=0.135 $X2=0.081 $Y2=0.135
r53 1 36 30.1405 $w=1.37815e-08 $l=2.7e-08 $layer=LIG $thickness=4.8e-08
+ $X=0.081 $Y=0.135 $X2=0.108 $Y2=0.135
r54 33 32 14.6259 $w=2.1e-08 $l=4.3e-08 $layer=Gate_1 $thickness=5.6e-08
+ $X=0.081 $Y=0.2025 $X2=0.081 $Y2=0.1595
r55 31 32 3.06124 $w=2.1e-08 $l=9e-09 $layer=Gate_1 $thickness=5.6e-08 $X=0.081
+ $Y=0.1505 $X2=0.081 $Y2=0.1595
r56 30 31 5.4252 $w=2.04194e-08 $l=1.55e-08 $layer=Gate_1 $thickness=5.6e-08
+ $X=0.081 $Y=0.135 $X2=0.081 $Y2=0.1505
r57 29 30 5.4252 $w=2.04194e-08 $l=1.55e-08 $layer=Gate_1 $thickness=5.6e-08
+ $X=0.081 $Y=0.1195 $X2=0.081 $Y2=0.135
r58 28 29 3.06124 $w=2.1e-08 $l=9e-09 $layer=Gate_1 $thickness=5.6e-08 $X=0.081
+ $Y=0.1105 $X2=0.081 $Y2=0.1195
r59 27 28 14.6259 $w=2.1e-08 $l=4.3e-08 $layer=Gate_1 $thickness=5.6e-08
+ $X=0.081 $Y=0.0675 $X2=0.081 $Y2=0.1105
r60 27 12 14.6259 $w=2.1e-08 $l=4.3e-08 $layer=Gate_1 $thickness=5.6e-08
+ $X=0.081 $Y=0.0675 $X2=0.081 $Y2=0.0245
.ends

.subckt PM_AND4x2_ASAP7_75t_R%10 vss 2 3 1
c1 1 vss 0.000698757f $X=0.27 $Y=0.0675
r1 2 1 0.209877 $w=8.1e-08 $l=1.7e-08 $layer=N_src_drn $thickness=1e-09
+ $X=0.2526 $Y=0.0675 $X2=0.27 $Y2=0.0675
r2 3 1 0.209877 $w=8.1e-08 $l=1.7e-08 $layer=N_src_drn $thickness=1e-09
+ $X=0.2873 $Y=0.0675 $X2=0.27 $Y2=0.0675
.ends

.subckt PM_AND4x2_ASAP7_75t_R%C vss 13 5 9 3 1 4
c1 1 vss 0.00284048f $X=0.243 $Y=0.135
c2 3 vss 0.0474952f $X=0.243 $Y=0.0245
c3 4 vss 0.0119384f $X=0.243 $Y=0.08
r1 13 4 12.8254 $w=1.3e-08 $l=5.5e-08 $layer=M1 $thickness=3.6e-08 $X=0.243
+ $Y=0.132 $X2=0.243 $Y2=0.08
r2 1 7 7.07951 $w=1.89474e-08 $layer=LIG $thickness=5.17895e-08 $X=0.243
+ $Y=0.135 $X2=0.243 $Y2=0.135
r3 13 1 19.3796 $a=3.24e-16 $layer=V0LIG $X=0.243 $Y=0.132 $X2=0.243 $Y2=0.135
r4 9 8 16.8368 $w=2.1e-08 $l=4.95e-08 $layer=Gate_1 $thickness=5.6e-08 $X=0.243
+ $Y=0.2025 $X2=0.243 $Y2=0.153
r5 7 8 6.27555 $w=2.05e-08 $l=1.8e-08 $layer=Gate_1 $thickness=5.6e-08 $X=0.243
+ $Y=0.135 $X2=0.243 $Y2=0.153
r6 6 7 6.27555 $w=2.05e-08 $l=1.8e-08 $layer=Gate_1 $thickness=5.6e-08 $X=0.243
+ $Y=0.117 $X2=0.243 $Y2=0.135
r7 5 6 16.8368 $w=2.1e-08 $l=4.95e-08 $layer=Gate_1 $thickness=5.6e-08 $X=0.243
+ $Y=0.0675 $X2=0.243 $Y2=0.117
r8 5 3 14.6259 $w=2.1e-08 $l=4.3e-08 $layer=Gate_1 $thickness=5.6e-08 $X=0.243
+ $Y=0.0675 $X2=0.243 $Y2=0.0245
.ends

* End of included file AND4x2_ASAP7_75t_R.pex.sp.pex

*
.subckt AND4x2_ASAP7_75t_CUSTOM_4_25_0_7 VSS VDD D C B A Y
*
* VSS VSS
* VDD VDD
* D D
* C C
* B B
* A A
* Y Y
*
*

M0 N_M0_d N_M0_g VSS VSS nmos_rvt L=2e-08 W=8.1e-08 nfin=3 $X=0.071 $Y=0.027
M1 N_M1_d N_M1_g VSS VSS nmos_rvt L=2e-08 W=8.1e-08 nfin=3 $X=0.125 $Y=0.027
M2 N_M2_d N_M2_g VSS VSS nmos_rvt L=2e-08 W=8.1e-08 nfin=3 $X=0.179 $Y=0.027
M3 N_M3_d N_M3_g N_M3_s VSS nmos_rvt L=2e-08 W=8.1e-08 nfin=3 $X=0.233 $Y=0.027
M4 N_M4_d N_M4_g N_M4_s VSS nmos_rvt L=2e-08 W=8.1e-08 nfin=3 $X=0.287 $Y=0.027
M5 N_M5_d N_M5_g N_M5_s VSS nmos_rvt L=2e-08 W=8.1e-08 nfin=3 $X=0.341 $Y=0.027
M6 N_M6_d N_M6_g VDD VDD pmos_rvt L=2e-08 W=8.1e-08 nfin=3 $X=0.071 $Y=0.162
M7 N_M7_d N_M7_g VDD VDD pmos_rvt L=2e-08 W=8.1e-08 nfin=3 $X=0.125 $Y=0.162
M8 N_M8_d N_M8_g VDD VDD pmos_rvt L=2e-08 W=8.1e-08 nfin=3 $X=0.179 $Y=0.162
M9 VDD N_M9_g N_M9_s VDD pmos_rvt L=2e-08 W=8.1e-08 nfin=3 $X=0.233 $Y=0.162
M10 N_M10_d N_M10_g VDD VDD pmos_rvt L=2e-08 W=8.1e-08 nfin=3 $X=0.287 $Y=0.162
M11 VDD N_M11_g N_M11_s VDD pmos_rvt L=2e-08 W=8.1e-08 nfin=3 $X=0.341 $Y=0.162

* .include "AND4x2_ASAP7_75t_R.pex.sp.pxi"

* Start of included file AND4x2_ASAP7_75t_R.pex.sp.pxi
x_PM_AND4x2_ASAP7_75t_R%9 vss N_M2_d N_M3_s N_9_1 PM_AND4x2_ASAP7_75t_R%9
cc_1 N_9_1 N_D_3 0.0167915f $X=0.216 $Y=0.0675
cc_2 N_9_1 N_C_3 0.0168972f $X=0.216 $Y=0.0675
x_PM_AND4x2_ASAP7_75t_R%11 vss N_M4_d N_M5_s N_11_1 PM_AND4x2_ASAP7_75t_R%11
cc_3 N_11_1 N_B_3 0.0169415f $X=0.324 $Y=0.0675
cc_4 N_11_1 N_A_3 0.01679f $X=0.324 $Y=0.0675
x_PM_AND4x2_ASAP7_75t_R%D vss D N_M2_g N_M8_g N_D_3 N_D_1 N_D_4
+ PM_AND4x2_ASAP7_75t_R%D
cc_5 N_D_3 N_3_1 0.000480243f $X=0.189 $Y=0.0245
cc_6 N_D_3 N_3_22 0.000543068f $X=0.189 $Y=0.0245
cc_7 N_D_3 N_3_18 0.000574836f $X=0.189 $Y=0.0245
cc_8 N_D_3 N_3_3 0.000835045f $X=0.189 $Y=0.0245
cc_9 N_D_1 N_3_3 0.000850322f $X=0.189 $Y=0.135
cc_10 N_D_1 N_3_15 0.00115087f $X=0.189 $Y=0.135
cc_11 N_D_3 N_3_13 0.00165625f $X=0.189 $Y=0.0245
cc_12 N_D_4 N_3_1 0.00178376f $X=0.189 $Y=0.082
cc_13 N_D_3 N_3_15 0.0366003f $X=0.189 $Y=0.0245
x_PM_AND4x2_ASAP7_75t_R%A vss A N_M5_g N_M11_g N_A_3 N_A_4 N_A_1
+ PM_AND4x2_ASAP7_75t_R%A
cc_14 N_A_3 N_3_16 0.0151446f $X=0.351 $Y=0.0245
cc_15 N_A_3 N_3_20 0.000472518f $X=0.351 $Y=0.0245
cc_16 N_A_3 N_3_5 0.00240073f $X=0.351 $Y=0.0245
cc_17 N_A_4 N_3_25 0.00103886f $X=0.351 $Y=0.098
cc_18 N_A_3 N_3_4 0.00112118f $X=0.351 $Y=0.0245
cc_19 N_A_1 N_3_16 0.00154953f $X=0.351 $Y=0.135
cc_20 N_A_4 N_3_26 0.00774113f $X=0.351 $Y=0.098
cc_21 N_A_3 N_3_14 0.0544927f $X=0.351 $Y=0.0245
cc_22 N_A_4 N_B_1 0.00138338f $X=0.351 $Y=0.098
cc_23 N_A_3 N_B_3 0.00505771f $X=0.351 $Y=0.0245
cc_24 N_A_4 N_B_4 0.00603223f $X=0.351 $Y=0.098
x_PM_AND4x2_ASAP7_75t_R%B vss B N_M4_g N_M10_g N_B_3 N_B_1 N_B_4
+ PM_AND4x2_ASAP7_75t_R%B
cc_25 N_B_3 N_3_5 0.000354799f $X=0.297 $Y=0.0245
cc_26 N_B_3 N_3_4 0.00142423f $X=0.297 $Y=0.0245
cc_27 N_B_1 N_3_16 0.000768297f $X=0.297 $Y=0.135
cc_28 N_B_4 N_3_25 0.00111345f $X=0.297 $Y=0.098
cc_29 N_B_4 N_3_4 0.00237052f $X=0.297 $Y=0.098
cc_30 N_B_3 N_3_16 0.0351155f $X=0.297 $Y=0.0245
cc_31 N_B_1 N_C_1 0.00125205f $X=0.297 $Y=0.135
cc_32 N_B_3 N_C_3 0.00525932f $X=0.297 $Y=0.0245
cc_33 N_B_4 N_C_4 0.00714105f $X=0.297 $Y=0.098
x_PM_AND4x2_ASAP7_75t_R%Y vss Y N_M0_d N_M1_d N_M6_d N_M7_d N_Y_8 N_Y_2 N_Y_13
+ N_Y_7 PM_AND4x2_ASAP7_75t_R%Y
cc_34 N_Y_8 N_3_19 0.00033912f $X=0.0935 $Y=0.2025
cc_35 N_Y_8 N_3_22 0.00204906f $X=0.0935 $Y=0.2025
cc_36 N_Y_8 N_3_17 0.000584589f $X=0.0935 $Y=0.2025
cc_37 N_Y_8 N_3_1 0.00205164f $X=0.0935 $Y=0.2025
cc_38 N_Y_8 N_3_23 0.000829569f $X=0.0935 $Y=0.2025
cc_39 N_Y_8 N_3_13 0.0392863f $X=0.0935 $Y=0.2025
cc_40 N_Y_2 N_3_13 0.00235382f $X=0.108 $Y=0.2025
cc_41 N_Y_13 N_3_17 0.00322373f $X=0.0675 $Y=0.234
cc_42 N_Y_7 N_3_1 0.00415162f $X=0.0935 $Y=0.0675
cc_43 N_Y_7 N_3_13 0.0288217f $X=0.0935 $Y=0.0675
cc_44 N_Y_8 N_3_12 0.0670857f $X=0.0935 $Y=0.2025
x_PM_AND4x2_ASAP7_75t_R%3 vss N_M0_g N_M6_g N_M1_g N_M7_g N_M8_d N_M9_s N_M10_d
+ N_M11_s N_M5_d N_3_1 N_3_22 N_3_18 N_3_3 N_3_15 N_3_13 N_3_25 N_3_5 N_3_4
+ N_3_16 N_3_20 N_3_26 N_3_14 N_3_19 N_3_17 N_3_23 N_3_12
+ PM_AND4x2_ASAP7_75t_R%3
x_PM_AND4x2_ASAP7_75t_R%10 vss N_M3_d N_M4_s N_10_1 PM_AND4x2_ASAP7_75t_R%10
cc_45 N_10_1 N_C_3 0.0168383f $X=0.27 $Y=0.0675
cc_46 N_10_1 N_B_3 0.0168626f $X=0.27 $Y=0.0675
x_PM_AND4x2_ASAP7_75t_R%C vss C N_M3_g N_M9_g N_C_3 N_C_1 N_C_4
+ PM_AND4x2_ASAP7_75t_R%C
cc_47 N_C_3 N_3_3 0.00144005f $X=0.243 $Y=0.0245
cc_48 N_C_1 N_3_15 0.000664395f $X=0.243 $Y=0.135
cc_49 N_C_4 N_3_25 0.0011758f $X=0.243 $Y=0.08
cc_50 N_C_4 N_3_3 0.0022437f $X=0.243 $Y=0.08
cc_51 N_C_3 N_3_15 0.0349532f $X=0.243 $Y=0.0245
cc_52 N_C_1 N_D_4 0.00121069f $X=0.243 $Y=0.135
cc_53 N_C_3 N_D_3 0.00503007f $X=0.243 $Y=0.0245
cc_54 N_C_4 N_D_4 0.00611268f $X=0.243 $Y=0.08

* End of included file AND4x2_ASAP7_75t_R.pex.sp.pxi
.ends

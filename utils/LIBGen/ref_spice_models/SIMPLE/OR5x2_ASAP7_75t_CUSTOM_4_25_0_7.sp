.subckt PM_OR5x2_ASAP7_75t_R%10 vss 2 3 1
c1 1 vss 0.00071211f $X=0.108 $Y=0.2025
r1 2 1 0.209877 $w=8.1e-08 $l=1.7e-08 $layer=P_src_drn $thickness=1e-09
+ $X=0.0906 $Y=0.2025 $X2=0.108 $Y2=0.2025
r2 3 1 0.209877 $w=8.1e-08 $l=1.7e-08 $layer=P_src_drn $thickness=1e-09
+ $X=0.1253 $Y=0.2025 $X2=0.108 $Y2=0.2025
.ends

.subckt PM_OR5x2_ASAP7_75t_R%12 vss 2 3 1
c1 1 vss 0.000689816f $X=0.216 $Y=0.2025
r1 2 1 0.209877 $w=8.1e-08 $l=1.7e-08 $layer=P_src_drn $thickness=1e-09
+ $X=0.2333 $Y=0.2025 $X2=0.216 $Y2=0.2025
r2 3 1 0.209877 $w=8.1e-08 $l=1.7e-08 $layer=P_src_drn $thickness=1e-09
+ $X=0.1986 $Y=0.2025 $X2=0.216 $Y2=0.2025
.ends

.subckt PM_OR5x2_ASAP7_75t_R%13 vss 2 3 1
c1 1 vss 0.000778944f $X=0.27 $Y=0.2025
r1 2 1 0.209877 $w=8.1e-08 $l=1.7e-08 $layer=P_src_drn $thickness=1e-09
+ $X=0.2526 $Y=0.2025 $X2=0.27 $Y2=0.2025
r2 3 1 0.209877 $w=8.1e-08 $l=1.7e-08 $layer=P_src_drn $thickness=1e-09
+ $X=0.2873 $Y=0.2025 $X2=0.27 $Y2=0.2025
.ends

.subckt PM_OR5x2_ASAP7_75t_R%A vss 17 5 11 3 4 1
c1 1 vss 0.00253262f $X=0.0715 $Y=0.136
c2 3 vss 0.0416594f $X=0.081 $Y=0.0245
c3 4 vss 0.00963502f $X=0.081 $Y=0.0985
r1 17 4 8.74462 $w=1.3e-08 $l=3.75e-08 $layer=M1 $thickness=3.6e-08 $X=0.081
+ $Y=0.135 $X2=0.081 $Y2=0.0985
r2 13 14 3.67195 $w=1.8e-08 $l=9.5e-09 $layer=LIG $thickness=4.8e-08 $X=0.081
+ $Y=0.136 $X2=0.0905 $Y2=0.136
r3 17 13 19.3796 $a=3.24e-16 $layer=V0LIG $X=0.081 $Y=0.135 $X2=0.081 $Y2=0.136
r4 1 13 3.67195 $w=1.8e-08 $l=9.5e-09 $layer=LIG $thickness=4.8e-08 $X=0.0715
+ $Y=0.136 $X2=0.081 $Y2=0.136
r5 11 10 14.6259 $w=2.1e-08 $l=4.3e-08 $layer=Gate_1 $thickness=5.6e-08
+ $X=0.081 $Y=0.2025 $X2=0.081 $Y2=0.1595
r6 9 10 2.89117 $w=2.1e-08 $l=8.5e-09 $layer=Gate_1 $thickness=5.6e-08 $X=0.081
+ $Y=0.151 $X2=0.081 $Y2=0.1595
r7 8 9 5.25513 $w=2.04e-08 $l=1.5e-08 $layer=Gate_1 $thickness=5.6e-08 $X=0.081
+ $Y=0.136 $X2=0.081 $Y2=0.151
r8 8 14 3.40757 $w=1.98947e-08 $l=9.5e-09 $layer=Gate_1 $thickness=5.55789e-08
+ $X=0.081 $Y=0.136 $X2=0.0905 $Y2=0.136
r9 8 13 6.69299 $w=1.9e-08 $layer=LIG $thickness=5.2e-08 $X=0.081 $Y=0.136
+ $X2=0.081 $Y2=0.136
r10 7 8 5.59527 $w=2.04375e-08 $l=1.6e-08 $layer=Gate_1 $thickness=5.6e-08
+ $X=0.081 $Y=0.12 $X2=0.081 $Y2=0.136
r11 6 7 7.82318 $w=2.1e-08 $l=2.3e-08 $layer=Gate_1 $thickness=5.6e-08 $X=0.081
+ $Y=0.097 $X2=0.081 $Y2=0.12
r12 5 6 14.6259 $w=2.1e-08 $l=4.3e-08 $layer=Gate_1 $thickness=5.6e-08 $X=0.081
+ $Y=0.054 $X2=0.081 $Y2=0.097
r13 5 3 10.0341 $w=2.1e-08 $l=2.95e-08 $layer=Gate_1 $thickness=5.6e-08
+ $X=0.081 $Y=0.054 $X2=0.081 $Y2=0.0245
.ends

.subckt PM_OR5x2_ASAP7_75t_R%B vss 13 5 9 1 4 3
c1 1 vss 0.00120042f $X=0.135 $Y=0.1355
c2 3 vss 0.0386174f $X=0.135 $Y=0.0245
c3 4 vss 0.0122643f $X=0.135 $Y=0.0985
r1 13 4 8.74462 $w=1.3e-08 $l=3.75e-08 $layer=M1 $thickness=3.6e-08 $X=0.135
+ $Y=0.135 $X2=0.135 $Y2=0.0985
r2 1 7 6.8952 $w=1.94872e-08 $layer=LIG $thickness=5.18974e-08 $X=0.135
+ $Y=0.1355 $X2=0.135 $Y2=0.1355
r3 13 1 19.3796 $a=3.24e-16 $layer=V0LIG $X=0.135 $Y=0.135 $X2=0.135 $Y2=0.1355
r4 9 8 16.6668 $w=2.1e-08 $l=4.9e-08 $layer=Gate_1 $thickness=5.6e-08 $X=0.135
+ $Y=0.2025 $X2=0.135 $Y2=0.1535
r5 7 8 6.28405 $w=2.04722e-08 $l=1.8e-08 $layer=Gate_1 $thickness=5.6e-08
+ $X=0.135 $Y=0.1355 $X2=0.135 $Y2=0.1535
r6 6 7 11.046 $w=2.07031e-08 $l=3.2e-08 $layer=Gate_1 $thickness=5.6e-08
+ $X=0.135 $Y=0.1035 $X2=0.135 $Y2=0.1355
r7 5 6 16.8368 $w=2.1e-08 $l=4.95e-08 $layer=Gate_1 $thickness=5.6e-08 $X=0.135
+ $Y=0.054 $X2=0.135 $Y2=0.1035
r8 5 3 10.0341 $w=2.1e-08 $l=2.95e-08 $layer=Gate_1 $thickness=5.6e-08 $X=0.135
+ $Y=0.054 $X2=0.135 $Y2=0.0245
.ends

.subckt PM_OR5x2_ASAP7_75t_R%D vss 15 5 9 1 4 3
c1 1 vss 0.00120029f $X=0.243 $Y=0.1355
c2 3 vss 0.0383496f $X=0.243 $Y=0.0245
c3 4 vss 0.0122667f $X=0.243 $Y=0.0935
r1 15 14 4.5472 $w=1.3e-08 $l=1.95e-08 $layer=M1 $thickness=3.6e-08 $X=0.243
+ $Y=0.135 $X2=0.243 $Y2=0.1165
r2 4 14 5.36336 $w=1.3e-08 $l=2.3e-08 $layer=M1 $thickness=3.6e-08 $X=0.243
+ $Y=0.0935 $X2=0.243 $Y2=0.1165
r3 1 7 6.8952 $w=1.94872e-08 $layer=LIG $thickness=5.18974e-08 $X=0.243
+ $Y=0.1355 $X2=0.243 $Y2=0.1355
r4 15 1 19.3796 $a=3.24e-16 $layer=V0LIG $X=0.243 $Y=0.135 $X2=0.243 $Y2=0.1355
r5 9 8 16.6668 $w=2.1e-08 $l=4.9e-08 $layer=Gate_1 $thickness=5.6e-08 $X=0.243
+ $Y=0.2025 $X2=0.243 $Y2=0.1535
r6 7 8 6.28405 $w=2.04722e-08 $l=1.8e-08 $layer=Gate_1 $thickness=5.6e-08
+ $X=0.243 $Y=0.1355 $X2=0.243 $Y2=0.1535
r7 6 7 11.046 $w=2.07031e-08 $l=3.2e-08 $layer=Gate_1 $thickness=5.6e-08
+ $X=0.243 $Y=0.1035 $X2=0.243 $Y2=0.1355
r8 5 6 16.8368 $w=2.1e-08 $l=4.95e-08 $layer=Gate_1 $thickness=5.6e-08 $X=0.243
+ $Y=0.054 $X2=0.243 $Y2=0.1035
r9 5 3 10.0341 $w=2.1e-08 $l=2.95e-08 $layer=Gate_1 $thickness=5.6e-08 $X=0.243
+ $Y=0.054 $X2=0.243 $Y2=0.0245
.ends

.subckt PM_OR5x2_ASAP7_75t_R%E vss 13 5 9 3 4 1
c1 1 vss 0.00770426f $X=0.297 $Y=0.1355
c2 3 vss 0.0988364f $X=0.297 $Y=0.0245
c3 4 vss 0.00955999f $X=0.297 $Y=0.1165
r1 13 4 4.5472 $w=1.3e-08 $l=1.95e-08 $layer=M1 $thickness=3.6e-08 $X=0.297
+ $Y=0.135 $X2=0.297 $Y2=0.1165
r2 1 7 6.8952 $w=1.94872e-08 $layer=LIG $thickness=5.18974e-08 $X=0.297
+ $Y=0.1355 $X2=0.297 $Y2=0.1355
r3 13 1 19.3796 $a=3.24e-16 $layer=V0LIG $X=0.297 $Y=0.135 $X2=0.297 $Y2=0.1355
r4 9 8 16.6668 $w=2.1e-08 $l=4.9e-08 $layer=Gate_1 $thickness=5.6e-08 $X=0.297
+ $Y=0.2025 $X2=0.297 $Y2=0.1535
r5 7 8 6.28405 $w=2.04722e-08 $l=1.8e-08 $layer=Gate_1 $thickness=5.6e-08
+ $X=0.297 $Y=0.1355 $X2=0.297 $Y2=0.1535
r6 6 7 11.046 $w=2.07031e-08 $l=3.2e-08 $layer=Gate_1 $thickness=5.6e-08
+ $X=0.297 $Y=0.1035 $X2=0.297 $Y2=0.1355
r7 5 6 16.8368 $w=2.1e-08 $l=4.95e-08 $layer=Gate_1 $thickness=5.6e-08 $X=0.297
+ $Y=0.054 $X2=0.297 $Y2=0.1035
r8 5 3 10.0341 $w=2.1e-08 $l=2.95e-08 $layer=Gate_1 $thickness=5.6e-08 $X=0.297
+ $Y=0.054 $X2=0.297 $Y2=0.0245
.ends

.subckt PM_OR5x2_ASAP7_75t_R%Y vss 23 16 17 30 31 7 11 8
c1 1 vss 0.00848342f $X=0.378 $Y=0.0675
c2 2 vss 0.0101535f $X=0.378 $Y=0.2025
c3 7 vss 0.00438579f $X=0.3635 $Y=0.0675
c4 8 vss 0.00438842f $X=0.3635 $Y=0.2025
c5 9 vss 0.00290686f $X=0.459 $Y=0.036
c6 10 vss 0.00290587f $X=0.459 $Y=0.234
c7 11 vss 0.0099333f $X=0.362 $Y=0.036
c8 12 vss 0.0087393f $X=0.3665 $Y=0.234
c9 13 vss 0.00862207f $X=0.459 $Y=0.054
r1 31 29 0.0308642 $w=8.1e-08 $l=2.5e-09 $layer=P_src_drn $thickness=1e-09
+ $X=0.3953 $Y=0.2025 $X2=0.3925 $Y2=0.2025
r2 2 29 0.179012 $w=8.1e-08 $l=1.45e-08 $layer=P_src_drn $thickness=1e-09
+ $X=0.378 $Y=0.2025 $X2=0.3925 $Y2=0.2025
r3 8 2 0.179012 $w=8.1e-08 $l=1.45e-08 $layer=P_src_drn $thickness=1e-09
+ $X=0.3635 $Y=0.2025 $X2=0.378 $Y2=0.2025
r4 30 8 0.0308642 $w=8.1e-08 $l=2.5e-09 $layer=P_src_drn $thickness=1e-09
+ $X=0.3606 $Y=0.2025 $X2=0.3635 $Y2=0.2025
r5 2 26 19.3796 $a=3.24e-16 $layer=V0LISD $X=0.378 $Y=0.2025 $X2=0.378 $Y2=0.234
r6 26 27 9.44419 $w=1.3e-08 $l=4.05e-08 $layer=M1 $thickness=3.6e-08 $X=0.378
+ $Y=0.234 $X2=0.4185 $Y2=0.234
r7 12 26 2.68168 $w=1.3e-08 $l=1.15e-08 $layer=M1 $thickness=3.6e-08 $X=0.3665
+ $Y=0.234 $X2=0.378 $Y2=0.234
r8 10 25 8.72783 $w=1.4982e-08 $l=4.45e-08 $layer=M1 $thickness=3.6e-08
+ $X=0.459 $Y=0.234 $X2=0.459 $Y2=0.1895
r9 10 27 7.79507 $w=1.41111e-08 $l=4.05e-08 $layer=M1 $thickness=3.6e-08
+ $X=0.459 $Y=0.234 $X2=0.4185 $Y2=0.234
r10 24 25 8.97781 $w=1.3e-08 $l=3.85e-08 $layer=M1 $thickness=3.6e-08 $X=0.459
+ $Y=0.151 $X2=0.459 $Y2=0.1895
r11 23 24 0.816164 $w=1.3e-08 $l=3.5e-09 $layer=M1 $thickness=3.6e-08 $X=0.459
+ $Y=0.1475 $X2=0.459 $Y2=0.151
r12 23 22 9.91056 $w=1.3e-08 $l=4.25e-08 $layer=M1 $thickness=3.6e-08 $X=0.459
+ $Y=0.1475 $X2=0.459 $Y2=0.105
r13 13 22 11.8927 $w=1.3e-08 $l=5.1e-08 $layer=M1 $thickness=3.6e-08 $X=0.459
+ $Y=0.054 $X2=0.459 $Y2=0.105
r14 9 21 7.79507 $w=1.41111e-08 $l=4.05e-08 $layer=M1 $thickness=3.6e-08
+ $X=0.459 $Y=0.036 $X2=0.4185 $Y2=0.036
r15 9 13 2.5483 $w=1.79e-08 $l=1.8e-08 $layer=M1 $thickness=3.6e-08 $X=0.459
+ $Y=0.036 $X2=0.459 $Y2=0.054
r16 20 21 9.44419 $w=1.3e-08 $l=4.05e-08 $layer=M1 $thickness=3.6e-08 $X=0.378
+ $Y=0.036 $X2=0.4185 $Y2=0.036
r17 19 20 2.68168 $w=1.3e-08 $l=1.15e-08 $layer=M1 $thickness=3.6e-08 $X=0.3665
+ $Y=0.036 $X2=0.378 $Y2=0.036
r18 11 19 1.04935 $w=1.3e-08 $l=4.5e-09 $layer=M1 $thickness=3.6e-08 $X=0.362
+ $Y=0.036 $X2=0.3665 $Y2=0.036
r19 1 20 19.3796 $a=3.24e-16 $layer=V0LISD $X=0.378 $Y=0.0675 $X2=0.378
+ $Y2=0.036
r20 17 15 0.0308642 $w=8.1e-08 $l=2.5e-09 $layer=N_src_drn $thickness=1e-09
+ $X=0.3953 $Y=0.0675 $X2=0.3925 $Y2=0.0675
r21 1 15 0.179012 $w=8.1e-08 $l=1.45e-08 $layer=N_src_drn $thickness=1e-09
+ $X=0.378 $Y=0.0675 $X2=0.3925 $Y2=0.0675
r22 7 1 0.179012 $w=8.1e-08 $l=1.45e-08 $layer=N_src_drn $thickness=1e-09
+ $X=0.3635 $Y=0.0675 $X2=0.378 $Y2=0.0675
r23 16 7 0.0308642 $w=8.1e-08 $l=2.5e-09 $layer=N_src_drn $thickness=1e-09
+ $X=0.3606 $Y=0.0675 $X2=0.3635 $Y2=0.0675
.ends

.subckt PM_OR5x2_ASAP7_75t_R%8 vss 31 35 48 52 72 73 76 77 81 86 17 22 3 4 27
+ 20 26 5 18 6 19 24 29 1 30 15 23 25 16
c1 1 vss 0.00793224f $X=0.3415 $Y=0.135
c2 3 vss 0.007464f $X=0.054 $Y=0.054
c3 4 vss 0.00679401f $X=0.054 $Y=0.2025
c4 5 vss 0.00750212f $X=0.162 $Y=0.054
c5 6 vss 0.00747059f $X=0.27 $Y=0.054
c6 15 vss 0.0836792f $X=0.351 $Y=0.0245
c7 16 vss 0.0837187f $X=0.405 $Y=0.135
c8 17 vss 0.0298727f $X=0.056 $Y=0.054
c9 18 vss 0.00515336f $X=0.1475 $Y=0.054
c10 19 vss 0.00525603f $X=0.2555 $Y=0.054
c11 20 vss 0.039812f $X=0.056 $Y=0.2025
c12 21 vss 0.00317307f $X=0.027 $Y=0.036
c13 22 vss 0.00682864f $X=0.027 $Y=0.234
c14 23 vss 0.00282134f $X=0.297 $Y=0.036
c15 24 vss 0.00051885f $X=0.297 $Y=0.0665
c16 25 vss 0.000790956f $X=0.351 $Y=0.072
c17 26 vss 0.00836283f $X=0.027 $Y=0.0575
c18 27 vss 0.0228335f $X=0.2565 $Y=0.036
c19 28 vss 0.000553926f $X=0.297 $Y=0.054
c20 29 vss 0.00145171f $X=0.324 $Y=0.072
c21 30 vss 0.00249017f $X=0.351 $Y=0.1165
r1 86 85 0.0308642 $w=8.1e-08 $l=2.5e-09 $layer=P_src_drn $thickness=1e-09
+ $X=0.0713 $Y=0.2025 $X2=0.0685 $Y2=0.2025
r2 20 85 0.154321 $w=8.1e-08 $l=1.25e-08 $layer=P_src_drn $thickness=1e-09
+ $X=0.056 $Y=0.2025 $X2=0.0685 $Y2=0.2025
r3 4 83 19.3796 $a=3.24e-16 $layer=V0LISD $X=0.054 $Y=0.2025 $X2=0.054 $Y2=0.234
r4 82 83 3.14806 $w=1.3e-08 $l=1.35e-08 $layer=M1 $thickness=3.6e-08 $X=0.0405
+ $Y=0.234 $X2=0.054 $Y2=0.234
r5 22 79 3.83327 $w=1.5093e-08 $l=2.15e-08 $layer=M1 $thickness=3.6e-08
+ $X=0.027 $Y=0.234 $X2=0.027 $Y2=0.2125
r6 22 82 1.96775 $w=1.63333e-08 $l=1.35e-08 $layer=M1 $thickness=3.6e-08
+ $X=0.027 $Y=0.234 $X2=0.0405 $Y2=0.234
r7 81 80 0.0462963 $w=5.4e-08 $l=2.5e-09 $layer=N_src_drn $thickness=1e-09
+ $X=0.0713 $Y=0.054 $X2=0.0685 $Y2=0.054
r8 17 80 0.231482 $w=5.4e-08 $l=1.25e-08 $layer=N_src_drn $thickness=1e-09
+ $X=0.056 $Y=0.054 $X2=0.0685 $Y2=0.054
r9 78 79 18.0722 $w=1.3e-08 $l=7.75e-08 $layer=M1 $thickness=3.6e-08 $X=0.027
+ $Y=0.135 $X2=0.027 $Y2=0.2125
r10 26 78 18.0722 $w=1.3e-08 $l=7.75e-08 $layer=M1 $thickness=3.6e-08 $X=0.027
+ $Y=0.0575 $X2=0.027 $Y2=0.135
r11 77 75 0.0462963 $w=5.4e-08 $l=2.5e-09 $layer=N_src_drn $thickness=1e-09
+ $X=0.1793 $Y=0.054 $X2=0.1765 $Y2=0.054
r12 5 75 0.268519 $w=5.4e-08 $l=1.45e-08 $layer=N_src_drn $thickness=1e-09
+ $X=0.162 $Y=0.054 $X2=0.1765 $Y2=0.054
r13 18 5 0.268519 $w=5.4e-08 $l=1.45e-08 $layer=N_src_drn $thickness=1e-09
+ $X=0.1475 $Y=0.054 $X2=0.162 $Y2=0.054
r14 76 18 0.0462963 $w=5.4e-08 $l=2.5e-09 $layer=N_src_drn $thickness=1e-09
+ $X=0.1446 $Y=0.054 $X2=0.1475 $Y2=0.054
r15 73 71 0.0462963 $w=5.4e-08 $l=2.5e-09 $layer=N_src_drn $thickness=1e-09
+ $X=0.2873 $Y=0.054 $X2=0.2845 $Y2=0.054
r16 6 71 0.268519 $w=5.4e-08 $l=1.45e-08 $layer=N_src_drn $thickness=1e-09
+ $X=0.27 $Y=0.054 $X2=0.2845 $Y2=0.054
r17 19 6 0.268519 $w=5.4e-08 $l=1.45e-08 $layer=N_src_drn $thickness=1e-09
+ $X=0.2555 $Y=0.054 $X2=0.27 $Y2=0.054
r18 72 19 0.0462963 $w=5.4e-08 $l=2.5e-09 $layer=N_src_drn $thickness=1e-09
+ $X=0.2526 $Y=0.054 $X2=0.2555 $Y2=0.054
r19 3 68 19.3796 $a=3.24e-16 $layer=V0LISD $X=0.054 $Y=0.054 $X2=0.054 $Y2=0.036
r20 21 67 1.49895 $w=1.63333e-08 $l=1.35e-08 $layer=M1 $thickness=3.6e-08
+ $X=0.027 $Y=0.036 $X2=0.0405 $Y2=0.036
r21 21 26 3.36447 $w=1.71023e-08 $l=2.15e-08 $layer=M1 $thickness=3.6e-08
+ $X=0.027 $Y=0.036 $X2=0.027 $Y2=0.0575
r22 5 61 19.3796 $a=3.24e-16 $layer=V0LISD $X=0.162 $Y=0.054 $X2=0.162 $Y2=0.036
r23 6 55 19.3796 $a=3.24e-16 $layer=V0LISD $X=0.27 $Y=0.054 $X2=0.27 $Y2=0.036
r24 68 69 2.91487 $w=1.3e-08 $l=1.25e-08 $layer=M1 $thickness=3.6e-08 $X=0.054
+ $Y=0.036 $X2=0.0665 $Y2=0.036
r25 67 68 3.14806 $w=1.3e-08 $l=1.35e-08 $layer=M1 $thickness=3.6e-08 $X=0.0405
+ $Y=0.036 $X2=0.054 $Y2=0.036
r26 66 69 1.04935 $w=1.3e-08 $l=4.5e-09 $layer=M1 $thickness=3.6e-08 $X=0.071
+ $Y=0.036 $X2=0.0665 $Y2=0.036
r27 65 66 2.3319 $w=1.3e-08 $l=1e-08 $layer=M1 $thickness=3.6e-08 $X=0.081
+ $Y=0.036 $X2=0.071 $Y2=0.036
r28 64 65 6.29612 $w=1.3e-08 $l=2.7e-08 $layer=M1 $thickness=3.6e-08 $X=0.108
+ $Y=0.036 $X2=0.081 $Y2=0.036
r29 63 64 6.29612 $w=1.3e-08 $l=2.7e-08 $layer=M1 $thickness=3.6e-08 $X=0.135
+ $Y=0.036 $X2=0.108 $Y2=0.036
r30 61 62 3.14806 $w=1.3e-08 $l=1.35e-08 $layer=M1 $thickness=3.6e-08 $X=0.162
+ $Y=0.036 $X2=0.1755 $Y2=0.036
r31 60 61 3.14806 $w=1.3e-08 $l=1.35e-08 $layer=M1 $thickness=3.6e-08 $X=0.1485
+ $Y=0.036 $X2=0.162 $Y2=0.036
r32 60 63 3.14806 $w=1.3e-08 $l=1.35e-08 $layer=M1 $thickness=3.6e-08 $X=0.1485
+ $Y=0.036 $X2=0.135 $Y2=0.036
r33 59 62 3.14806 $w=1.3e-08 $l=1.35e-08 $layer=M1 $thickness=3.6e-08 $X=0.189
+ $Y=0.036 $X2=0.1755 $Y2=0.036
r34 58 59 6.29612 $w=1.3e-08 $l=2.7e-08 $layer=M1 $thickness=3.6e-08 $X=0.216
+ $Y=0.036 $X2=0.189 $Y2=0.036
r35 57 58 6.29612 $w=1.3e-08 $l=2.7e-08 $layer=M1 $thickness=3.6e-08 $X=0.243
+ $Y=0.036 $X2=0.216 $Y2=0.036
r36 55 56 3.14806 $w=1.3e-08 $l=1.35e-08 $layer=M1 $thickness=3.6e-08 $X=0.27
+ $Y=0.036 $X2=0.2835 $Y2=0.036
r37 27 55 3.14806 $w=1.3e-08 $l=1.35e-08 $layer=M1 $thickness=3.6e-08 $X=0.2565
+ $Y=0.036 $X2=0.27 $Y2=0.036
r38 27 57 3.14806 $w=1.3e-08 $l=1.35e-08 $layer=M1 $thickness=3.6e-08 $X=0.2565
+ $Y=0.036 $X2=0.243 $Y2=0.036
r39 23 28 2.5483 $w=1.79e-08 $l=1.8e-08 $layer=M1 $thickness=3.6e-08 $X=0.297
+ $Y=0.036 $X2=0.297 $Y2=0.054
r40 23 56 1.49895 $w=1.63333e-08 $l=1.35e-08 $layer=M1 $thickness=3.6e-08
+ $X=0.297 $Y=0.036 $X2=0.2835 $Y2=0.036
r41 24 29 4.55457 $w=1.3814e-08 $l=2.75545e-08 $layer=M1 $thickness=3.6e-08
+ $X=0.297 $Y=0.0665 $X2=0.324 $Y2=0.072
r42 24 28 2.45586 $w=1.44e-08 $l=1.25e-08 $layer=M1 $thickness=3.6e-08 $X=0.297
+ $Y=0.0665 $X2=0.297 $Y2=0.054
r43 25 45 3.36447 $w=1.71023e-08 $l=2.15e-08 $layer=M1 $thickness=3.6e-08
+ $X=0.351 $Y=0.072 $X2=0.351 $Y2=0.0935
r44 25 29 4.64701 $w=1.46667e-08 $l=2.7e-08 $layer=M1 $thickness=3.6e-08
+ $X=0.351 $Y=0.072 $X2=0.324 $Y2=0.072
r45 52 51 14.6259 $w=2.1e-08 $l=4.3e-08 $layer=Gate_1 $thickness=5.6e-08
+ $X=0.405 $Y=0.2025 $X2=0.405 $Y2=0.1595
r46 50 51 2.7211 $w=2.1e-08 $l=8e-09 $layer=Gate_1 $thickness=5.6e-08 $X=0.405
+ $Y=0.1515 $X2=0.405 $Y2=0.1595
r47 48 49 14.6259 $w=2.1e-08 $l=4.3e-08 $layer=Gate_1 $thickness=5.6e-08
+ $X=0.405 $Y=0.0675 $X2=0.405 $Y2=0.1105
r48 46 49 2.7211 $w=2.1e-08 $l=8e-09 $layer=Gate_1 $thickness=5.6e-08 $X=0.405
+ $Y=0.1185 $X2=0.405 $Y2=0.1105
r49 16 41 6.54019 $w=2.09524e-08 $layer=Gate_1 $thickness=5.21905e-08 $X=0.405
+ $Y=0.135 $X2=0.405 $Y2=0.135
r50 16 46 5.79936 $w=2.03333e-08 $l=1.65e-08 $layer=Gate_1 $thickness=5.6e-08
+ $X=0.405 $Y=0.135 $X2=0.405 $Y2=0.1185
r51 16 50 5.79936 $w=2.03333e-08 $l=1.65e-08 $layer=Gate_1 $thickness=5.6e-08
+ $X=0.405 $Y=0.135 $X2=0.405 $Y2=0.1515
r52 30 43 4.5472 $w=1.3e-08 $l=1.95e-08 $layer=M1 $thickness=3.6e-08 $X=0.351
+ $Y=0.1165 $X2=0.351 $Y2=0.136
r53 30 45 5.36336 $w=1.3e-08 $l=2.3e-08 $layer=M1 $thickness=3.6e-08 $X=0.351
+ $Y=0.1165 $X2=0.351 $Y2=0.0935
r54 40 41 12.6539 $w=1.77815e-08 $l=2.7e-08 $layer=LIG $thickness=4.8e-08
+ $X=0.378 $Y=0.135 $X2=0.405 $Y2=0.135
r55 38 40 10.1729 $w=1.54914e-08 $l=1.75e-08 $layer=LIG $thickness=4.8e-08
+ $X=0.3605 $Y=0.135 $X2=0.378 $Y2=0.135
r56 37 38 2.48102 $w=2.2e-08 $l=9.5e-09 $layer=LIG $thickness=4.8e-08 $X=0.351
+ $Y=0.135 $X2=0.3605 $Y2=0.135
r57 37 43 19.3796 $a=3.24e-16 $layer=V0LIG $X=0.351 $Y=0.135 $X2=0.351 $Y2=0.136
r58 1 37 2.48102 $w=2.2e-08 $l=9.5e-09 $layer=LIG $thickness=4.8e-08 $X=0.3415
+ $Y=0.135 $X2=0.351 $Y2=0.135
r59 35 34 16.4967 $w=2.1e-08 $l=4.85e-08 $layer=Gate_1 $thickness=5.6e-08
+ $X=0.351 $Y=0.2025 $X2=0.351 $Y2=0.154
r60 33 34 6.6497 $w=2.04211e-08 $l=1.9e-08 $layer=Gate_1 $thickness=5.6e-08
+ $X=0.351 $Y=0.135 $X2=0.351 $Y2=0.154
r61 33 38 4.05918 $w=2.0087e-08 $l=9.5e-09 $layer=Gate_1 $thickness=5.56522e-08
+ $X=0.351 $Y=0.135 $X2=0.3605 $Y2=0.135
r62 33 37 6.27904 $w=2.09e-08 $layer=Gate_1 $thickness=5.24e-08 $X=0.351
+ $Y=0.135 $X2=0.351 $Y2=0.135
r63 32 33 6.6497 $w=2.04211e-08 $l=1.9e-08 $layer=Gate_1 $thickness=5.6e-08
+ $X=0.351 $Y=0.116 $X2=0.351 $Y2=0.135
r64 31 32 16.4967 $w=2.1e-08 $l=4.85e-08 $layer=Gate_1 $thickness=5.6e-08
+ $X=0.351 $Y=0.0675 $X2=0.351 $Y2=0.116
r65 31 15 14.6259 $w=2.1e-08 $l=4.3e-08 $layer=Gate_1 $thickness=5.6e-08
+ $X=0.351 $Y=0.0675 $X2=0.351 $Y2=0.0245
r66 4 20 1e-05 $l=2e-09 $X=0.054 $Y=0.2025 $X2=0.056 $Y2=0.2025
r67 3 17 1e-05 $l=2e-09 $X=0.054 $Y=0.054 $X2=0.056 $Y2=0.054
.ends

.subckt PM_OR5x2_ASAP7_75t_R%11 vss 2 3 1
c1 1 vss 0.000692454f $X=0.162 $Y=0.2025
r1 2 1 0.209877 $w=8.1e-08 $l=1.7e-08 $layer=P_src_drn $thickness=1e-09
+ $X=0.1446 $Y=0.2025 $X2=0.162 $Y2=0.2025
r2 3 1 0.209877 $w=8.1e-08 $l=1.7e-08 $layer=P_src_drn $thickness=1e-09
+ $X=0.1793 $Y=0.2025 $X2=0.162 $Y2=0.2025
.ends

.subckt PM_OR5x2_ASAP7_75t_R%C vss 13 5 9 1 4 3
c1 1 vss 0.00152403f $X=0.189 $Y=0.1355
c2 3 vss 0.0384596f $X=0.189 $Y=0.0245
c3 4 vss 0.0120958f $X=0.189 $Y=0.0985
r1 13 4 8.74462 $w=1.3e-08 $l=3.75e-08 $layer=M1 $thickness=3.6e-08 $X=0.189
+ $Y=0.135 $X2=0.189 $Y2=0.0985
r2 1 7 6.8952 $w=1.94872e-08 $layer=LIG $thickness=5.18974e-08 $X=0.189
+ $Y=0.1355 $X2=0.189 $Y2=0.1355
r3 13 1 19.3796 $a=3.24e-16 $layer=V0LIG $X=0.189 $Y=0.135 $X2=0.189 $Y2=0.1355
r4 9 8 16.6668 $w=2.1e-08 $l=4.9e-08 $layer=Gate_1 $thickness=5.6e-08 $X=0.189
+ $Y=0.2025 $X2=0.189 $Y2=0.1535
r5 7 8 6.28405 $w=2.04722e-08 $l=1.8e-08 $layer=Gate_1 $thickness=5.6e-08
+ $X=0.189 $Y=0.1355 $X2=0.189 $Y2=0.1535
r6 6 7 11.046 $w=2.07031e-08 $l=3.2e-08 $layer=Gate_1 $thickness=5.6e-08
+ $X=0.189 $Y=0.1035 $X2=0.189 $Y2=0.1355
r7 5 6 16.8368 $w=2.1e-08 $l=4.95e-08 $layer=Gate_1 $thickness=5.6e-08 $X=0.189
+ $Y=0.054 $X2=0.189 $Y2=0.1035
r8 5 3 10.0341 $w=2.1e-08 $l=2.95e-08 $layer=Gate_1 $thickness=5.6e-08 $X=0.189
+ $Y=0.054 $X2=0.189 $Y2=0.0245
.ends

* End of included file OR5x2_ASAP7_75t_R.pex.sp.pex

*
.subckt OR5x2_ASAP7_75t_CUSTOM_4_25_0_7 VSS VDD A B C D E Y
*
* VSS VSS
* VDD VDD
* A A
* B B
* C C
* D D
* E E
* Y Y
*
*

M0 VSS N_M0_g N_M0_s VSS nmos_rvt L=2e-08 W=5.4e-08 nfin=2 $X=0.071 $Y=0.027
M1 N_M1_d N_M1_g VSS VSS nmos_rvt L=2e-08 W=5.4e-08 nfin=2 $X=0.125 $Y=0.027
M2 VSS N_M2_g N_M2_s VSS nmos_rvt L=2e-08 W=5.4e-08 nfin=2 $X=0.179 $Y=0.027
M3 N_M3_d N_M3_g VSS VSS nmos_rvt L=2e-08 W=5.4e-08 nfin=2 $X=0.233 $Y=0.027
M4 VSS N_M4_g N_M4_s VSS nmos_rvt L=2e-08 W=5.4e-08 nfin=2 $X=0.287 $Y=0.027
M5 N_M5_d N_M5_g VSS VSS nmos_rvt L=2e-08 W=8.1e-08 nfin=3 $X=0.341 $Y=0.027
M6 N_M6_d N_M6_g VSS VSS nmos_rvt L=2e-08 W=8.1e-08 nfin=3 $X=0.395 $Y=0.027
M7 N_M7_d N_M7_g N_M7_s VDD pmos_rvt L=2e-08 W=8.1e-08 nfin=3 $X=0.071 $Y=0.162
M8 N_M8_d N_M8_g N_M8_s VDD pmos_rvt L=2e-08 W=8.1e-08 nfin=3 $X=0.125 $Y=0.162
M9 N_M9_d N_M9_g N_M9_s VDD pmos_rvt L=2e-08 W=8.1e-08 nfin=3 $X=0.179 $Y=0.162
M10 N_M10_d N_M10_g N_M10_s VDD pmos_rvt L=2e-08 W=8.1e-08 nfin=3 $X=0.233
+ $Y=0.162
M11 VDD N_M11_g N_M11_s VDD pmos_rvt L=2e-08 W=8.1e-08 nfin=3 $X=0.287 $Y=0.162
M12 N_M12_d N_M12_g VDD VDD pmos_rvt L=2e-08 W=8.1e-08 nfin=3 $X=0.341 $Y=0.162
M13 N_M13_d N_M13_g VDD VDD pmos_rvt L=2e-08 W=8.1e-08 nfin=3 $X=0.395 $Y=0.162

* .include "OR5x2_ASAP7_75t_R.pex.sp.pxi"

* Start of included file OR5x2_ASAP7_75t_R.pex.sp.pxi
x_PM_OR5x2_ASAP7_75t_R%10 vss N_M7_d N_M8_s N_10_1 PM_OR5x2_ASAP7_75t_R%10
cc_1 N_10_1 N_A_3 0.0169804f $X=0.108 $Y=0.2025
cc_2 N_10_1 N_B_3 0.0169628f $X=0.108 $Y=0.2025
x_PM_OR5x2_ASAP7_75t_R%12 vss N_M10_s N_M9_d N_12_1 PM_OR5x2_ASAP7_75t_R%12
cc_3 N_12_1 N_C_3 0.016976f $X=0.216 $Y=0.2025
cc_4 N_12_1 N_D_3 0.0169803f $X=0.216 $Y=0.2025
x_PM_OR5x2_ASAP7_75t_R%13 vss N_M10_d N_M11_s N_13_1 PM_OR5x2_ASAP7_75t_R%13
cc_5 N_13_1 N_D_3 0.0168489f $X=0.27 $Y=0.2025
cc_6 N_13_1 N_E_3 0.0168441f $X=0.27 $Y=0.2025
x_PM_OR5x2_ASAP7_75t_R%A vss A N_M0_g N_M7_g N_A_3 N_A_4 N_A_1
+ PM_OR5x2_ASAP7_75t_R%A
x_PM_OR5x2_ASAP7_75t_R%B vss B N_M1_g N_M8_g N_B_1 N_B_4 N_B_3
+ PM_OR5x2_ASAP7_75t_R%B
cc_7 N_B_1 N_A_3 0.00144646f $X=0.135 $Y=0.1355
cc_8 N_B_4 N_A_4 0.00535191f $X=0.135 $Y=0.0985
cc_9 N_B_3 N_A_3 0.00799524f $X=0.135 $Y=0.0245
x_PM_OR5x2_ASAP7_75t_R%D vss D N_M3_g N_M10_g N_D_1 N_D_4 N_D_3
+ PM_OR5x2_ASAP7_75t_R%D
cc_10 N_D_1 N_C_1 0.00157712f $X=0.243 $Y=0.1355
cc_11 N_D_4 N_C_4 0.00638539f $X=0.243 $Y=0.0935
cc_12 N_D_3 N_C_3 0.00805905f $X=0.243 $Y=0.0245
x_PM_OR5x2_ASAP7_75t_R%E vss E N_M4_g N_M11_g N_E_3 N_E_4 N_E_1
+ PM_OR5x2_ASAP7_75t_R%E
cc_13 N_E_3 N_D_1 0.00152173f $X=0.297 $Y=0.0245
cc_14 N_E_4 N_D_4 0.0053224f $X=0.297 $Y=0.1165
cc_15 N_E_3 N_D_3 0.00789727f $X=0.297 $Y=0.0245
x_PM_OR5x2_ASAP7_75t_R%Y vss Y N_M5_d N_M6_d N_M12_d N_M13_d N_Y_7 N_Y_11 N_Y_8
+ PM_OR5x2_ASAP7_75t_R%Y
cc_16 N_Y_7 N_8_23 0.000227051f $X=0.3635 $Y=0.0675
cc_17 N_Y_7 N_8_25 0.000300589f $X=0.3635 $Y=0.0675
cc_18 N_Y_7 N_8_30 0.00168418f $X=0.3635 $Y=0.0675
cc_19 N_Y_7 N_8_1 0.00625054f $X=0.3635 $Y=0.0675
cc_20 N_Y_7 N_8_29 0.000520283f $X=0.3635 $Y=0.0675
cc_21 N_Y_7 N_8_16 0.0192774f $X=0.3635 $Y=0.0675
cc_22 N_Y_11 N_8_25 0.00310013f $X=0.362 $Y=0.036
cc_23 N_Y_8 N_8_15 0.0104326f $X=0.3635 $Y=0.2025
cc_24 N_Y_8 N_8_16 0.0553284f $X=0.3635 $Y=0.2025
cc_25 N_Y_7 N_8_15 0.0528022f $X=0.3635 $Y=0.0675
x_PM_OR5x2_ASAP7_75t_R%8 vss N_M5_g N_M12_g N_M6_g N_M13_g N_M3_d N_M4_s N_M1_d
+ N_M2_s N_M0_s N_M7_s N_8_17 N_8_22 N_8_3 N_8_4 N_8_27 N_8_20 N_8_26 N_8_5
+ N_8_18 N_8_6 N_8_19 N_8_24 N_8_29 N_8_1 N_8_30 N_8_15 N_8_23 N_8_25 N_8_16
+ PM_OR5x2_ASAP7_75t_R%8
cc_26 N_8_17 N_A_3 0.0110628f $X=0.056 $Y=0.054
cc_27 N_8_22 N_A_3 0.000510946f $X=0.027 $Y=0.234
cc_28 N_8_3 N_A_3 0.000709397f $X=0.054 $Y=0.054
cc_29 N_8_4 N_A_1 0.000715961f $X=0.054 $Y=0.2025
cc_30 N_8_27 N_A_4 0.00103168f $X=0.2565 $Y=0.036
cc_31 N_8_4 N_A_3 0.00172745f $X=0.054 $Y=0.2025
cc_32 N_8_20 N_A_1 0.00200286f $X=0.056 $Y=0.2025
cc_33 N_8_26 N_A_4 0.00785425f $X=0.027 $Y=0.0575
cc_34 N_8_20 N_A_3 0.0495685f $X=0.056 $Y=0.2025
cc_35 N_8_5 N_B_3 0.000851535f $X=0.162 $Y=0.054
cc_36 N_8_18 N_B_1 0.000351445f $X=0.1475 $Y=0.054
cc_37 N_8_4 N_B_3 0.000423024f $X=0.054 $Y=0.2025
cc_38 N_8_27 N_B_4 0.00113251f $X=0.2565 $Y=0.036
cc_39 N_8_4 N_B_4 0.00220403f $X=0.054 $Y=0.2025
cc_40 N_8_18 N_B_3 0.0259422f $X=0.1475 $Y=0.054
cc_41 N_8_5 N_C_3 0.000615589f $X=0.162 $Y=0.054
cc_42 N_8_27 N_C_4 0.0011318f $X=0.2565 $Y=0.036
cc_43 N_8_5 N_C_4 0.00181267f $X=0.162 $Y=0.054
cc_44 N_8_18 N_C_3 0.0261261f $X=0.1475 $Y=0.054
cc_45 N_8_6 N_D_3 0.000944782f $X=0.27 $Y=0.054
cc_46 N_8_19 N_D_1 0.000424777f $X=0.2555 $Y=0.054
cc_47 N_8_27 N_D_4 0.00102687f $X=0.2565 $Y=0.036
cc_48 N_8_24 N_D_4 0.00258824f $X=0.297 $Y=0.0665
cc_49 N_8_19 N_D_3 0.0255835f $X=0.2555 $Y=0.054
cc_50 N_8_29 N_E_3 0.000392571f $X=0.324 $Y=0.072
cc_51 N_8_6 N_E_3 0.000445713f $X=0.27 $Y=0.054
cc_52 N_8_24 N_E_3 0.000544214f $X=0.297 $Y=0.0665
cc_53 N_8_1 N_E_3 0.00091735f $X=0.3415 $Y=0.135
cc_54 N_8_1 N_E_1 0.00156721f $X=0.3415 $Y=0.135
cc_55 N_8_30 N_E_4 0.00352039f $X=0.351 $Y=0.1165
cc_56 N_8_19 N_E_3 0.0105785f $X=0.2555 $Y=0.054
cc_57 N_8_15 N_E_3 0.017993f $X=0.351 $Y=0.0245
x_PM_OR5x2_ASAP7_75t_R%11 vss N_M8_d N_M9_s N_11_1 PM_OR5x2_ASAP7_75t_R%11
cc_58 N_11_1 N_B_3 0.0168852f $X=0.162 $Y=0.2025
cc_59 N_11_1 N_C_3 0.0168939f $X=0.162 $Y=0.2025
x_PM_OR5x2_ASAP7_75t_R%C vss C N_M2_g N_M9_g N_C_1 N_C_4 N_C_3
+ PM_OR5x2_ASAP7_75t_R%C
cc_60 N_C_1 N_B_1 0.00155536f $X=0.189 $Y=0.1355
cc_61 N_C_4 N_B_4 0.006405f $X=0.189 $Y=0.0985
cc_62 N_C_3 N_B_3 0.00808404f $X=0.189 $Y=0.0245

* End of included file OR5x2_ASAP7_75t_R.pex.sp.pxi
.ends

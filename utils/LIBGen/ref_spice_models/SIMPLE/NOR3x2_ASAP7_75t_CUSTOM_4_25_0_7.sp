.subckt PM_NOR3x2_ASAP7_75t_R%7 vss 28 29 53 54 57 58 61 62 65 66 69 70 25 19 2
+ 5 23 20 4 24 6 1 21 22 3
c1 1 vss 0.00277218f $X=0.27 $Y=0.2025
c2 2 vss 0.00584209f $X=0.378 $Y=0.2025
c3 3 vss 0.00886178f $X=0.486 $Y=0.2025
c4 4 vss 0.00883073f $X=0.594 $Y=0.2025
c5 5 vss 0.00583297f $X=0.702 $Y=0.2025
c6 6 vss 0.00277499f $X=0.81 $Y=0.2025
c7 19 vss 0.00191937f $X=0.2555 $Y=0.2025
c8 20 vss 0.00316944f $X=0.3635 $Y=0.2025
c9 21 vss 0.00410762f $X=0.4715 $Y=0.2025
c10 22 vss 0.00410795f $X=0.5795 $Y=0.2025
c11 23 vss 0.00314278f $X=0.6875 $Y=0.2025
c12 24 vss 0.00192253f $X=0.7955 $Y=0.2025
c13 25 vss 0.027379f $X=0.2585 $Y=0.198
r1 70 68 0.0308642 $w=8.1e-08 $l=2.5e-09 $layer=P_src_drn $thickness=1e-09
+ $X=0.8273 $Y=0.2025 $X2=0.8245 $Y2=0.2025
r2 6 68 0.179012 $w=8.1e-08 $l=1.45e-08 $layer=P_src_drn $thickness=1e-09
+ $X=0.81 $Y=0.2025 $X2=0.8245 $Y2=0.2025
r3 24 6 0.179012 $w=8.1e-08 $l=1.45e-08 $layer=P_src_drn $thickness=1e-09
+ $X=0.7955 $Y=0.2025 $X2=0.81 $Y2=0.2025
r4 69 24 0.0308642 $w=8.1e-08 $l=2.5e-09 $layer=P_src_drn $thickness=1e-09
+ $X=0.7926 $Y=0.2025 $X2=0.7955 $Y2=0.2025
r5 66 64 0.0308642 $w=8.1e-08 $l=2.5e-09 $layer=P_src_drn $thickness=1e-09
+ $X=0.7193 $Y=0.2025 $X2=0.7165 $Y2=0.2025
r6 5 64 0.179012 $w=8.1e-08 $l=1.45e-08 $layer=P_src_drn $thickness=1e-09
+ $X=0.702 $Y=0.2025 $X2=0.7165 $Y2=0.2025
r7 23 5 0.179012 $w=8.1e-08 $l=1.45e-08 $layer=P_src_drn $thickness=1e-09
+ $X=0.6875 $Y=0.2025 $X2=0.702 $Y2=0.2025
r8 65 23 0.0308642 $w=8.1e-08 $l=2.5e-09 $layer=P_src_drn $thickness=1e-09
+ $X=0.6846 $Y=0.2025 $X2=0.6875 $Y2=0.2025
r9 62 60 0.0308642 $w=8.1e-08 $l=2.5e-09 $layer=P_src_drn $thickness=1e-09
+ $X=0.6113 $Y=0.2025 $X2=0.6085 $Y2=0.2025
r10 4 60 0.179012 $w=8.1e-08 $l=1.45e-08 $layer=P_src_drn $thickness=1e-09
+ $X=0.594 $Y=0.2025 $X2=0.6085 $Y2=0.2025
r11 22 4 0.179012 $w=8.1e-08 $l=1.45e-08 $layer=P_src_drn $thickness=1e-09
+ $X=0.5795 $Y=0.2025 $X2=0.594 $Y2=0.2025
r12 61 22 0.0308642 $w=8.1e-08 $l=2.5e-09 $layer=P_src_drn $thickness=1e-09
+ $X=0.5766 $Y=0.2025 $X2=0.5795 $Y2=0.2025
r13 58 56 0.0308642 $w=8.1e-08 $l=2.5e-09 $layer=P_src_drn $thickness=1e-09
+ $X=0.5033 $Y=0.2025 $X2=0.5005 $Y2=0.2025
r14 3 56 0.179012 $w=8.1e-08 $l=1.45e-08 $layer=P_src_drn $thickness=1e-09
+ $X=0.486 $Y=0.2025 $X2=0.5005 $Y2=0.2025
r15 21 3 0.179012 $w=8.1e-08 $l=1.45e-08 $layer=P_src_drn $thickness=1e-09
+ $X=0.4715 $Y=0.2025 $X2=0.486 $Y2=0.2025
r16 57 21 0.0308642 $w=8.1e-08 $l=2.5e-09 $layer=P_src_drn $thickness=1e-09
+ $X=0.4686 $Y=0.2025 $X2=0.4715 $Y2=0.2025
r17 54 52 0.0308642 $w=8.1e-08 $l=2.5e-09 $layer=P_src_drn $thickness=1e-09
+ $X=0.3953 $Y=0.2025 $X2=0.3925 $Y2=0.2025
r18 2 52 0.179012 $w=8.1e-08 $l=1.45e-08 $layer=P_src_drn $thickness=1e-09
+ $X=0.378 $Y=0.2025 $X2=0.3925 $Y2=0.2025
r19 20 2 0.179012 $w=8.1e-08 $l=1.45e-08 $layer=P_src_drn $thickness=1e-09
+ $X=0.3635 $Y=0.2025 $X2=0.378 $Y2=0.2025
r20 53 20 0.0308642 $w=8.1e-08 $l=2.5e-09 $layer=P_src_drn $thickness=1e-09
+ $X=0.3606 $Y=0.2025 $X2=0.3635 $Y2=0.2025
r21 6 49 19.3796 $a=3.24e-16 $layer=V0LISD $X=0.81 $Y=0.2025 $X2=0.81 $Y2=0.198
r22 5 44 19.3796 $a=3.24e-16 $layer=V0LISD $X=0.702 $Y=0.2025 $X2=0.702
+ $Y2=0.198
r23 4 41 19.3796 $a=3.24e-16 $layer=V0LISD $X=0.594 $Y=0.2025 $X2=0.594
+ $Y2=0.198
r24 3 37 19.3796 $a=3.24e-16 $layer=V0LISD $X=0.486 $Y=0.2025 $X2=0.486
+ $Y2=0.198
r25 2 34 19.3796 $a=3.24e-16 $layer=V0LISD $X=0.378 $Y=0.2025 $X2=0.378
+ $Y2=0.198
r26 48 49 8.86121 $w=1.3e-08 $l=3.8e-08 $layer=M1 $thickness=3.6e-08 $X=0.772
+ $Y=0.198 $X2=0.81 $Y2=0.198
r27 47 48 6.8791 $w=1.3e-08 $l=2.95e-08 $layer=M1 $thickness=3.6e-08 $X=0.7425
+ $Y=0.198 $X2=0.772 $Y2=0.198
r28 46 47 2.09871 $w=1.3e-08 $l=9e-09 $layer=M1 $thickness=3.6e-08 $X=0.7335
+ $Y=0.198 $X2=0.7425 $Y2=0.198
r29 45 46 3.61444 $w=1.3e-08 $l=1.55e-08 $layer=M1 $thickness=3.6e-08 $X=0.718
+ $Y=0.198 $X2=0.7335 $Y2=0.198
r30 44 45 3.73104 $w=1.3e-08 $l=1.6e-08 $layer=M1 $thickness=3.6e-08 $X=0.702
+ $Y=0.198 $X2=0.718 $Y2=0.198
r31 43 44 5.71315 $w=1.3e-08 $l=2.45e-08 $layer=M1 $thickness=3.6e-08 $X=0.6775
+ $Y=0.198 $X2=0.702 $Y2=0.198
r32 42 43 10.4935 $w=1.3e-08 $l=4.5e-08 $layer=M1 $thickness=3.6e-08 $X=0.6325
+ $Y=0.198 $X2=0.6775 $Y2=0.198
r33 41 42 8.97781 $w=1.3e-08 $l=3.85e-08 $layer=M1 $thickness=3.6e-08 $X=0.594
+ $Y=0.198 $X2=0.6325 $Y2=0.198
r34 40 41 4.43061 $w=1.3e-08 $l=1.9e-08 $layer=M1 $thickness=3.6e-08 $X=0.575
+ $Y=0.198 $X2=0.594 $Y2=0.198
r35 39 40 4.43061 $w=1.3e-08 $l=1.9e-08 $layer=M1 $thickness=3.6e-08 $X=0.556
+ $Y=0.198 $X2=0.575 $Y2=0.198
r36 38 39 8.16164 $w=1.3e-08 $l=3.5e-08 $layer=M1 $thickness=3.6e-08 $X=0.521
+ $Y=0.198 $X2=0.556 $Y2=0.198
r37 37 38 8.16164 $w=1.3e-08 $l=3.5e-08 $layer=M1 $thickness=3.6e-08 $X=0.486
+ $Y=0.198 $X2=0.521 $Y2=0.198
r38 36 37 8.97781 $w=1.3e-08 $l=3.85e-08 $layer=M1 $thickness=3.6e-08 $X=0.4475
+ $Y=0.198 $X2=0.486 $Y2=0.198
r39 35 36 10.4935 $w=1.3e-08 $l=4.5e-08 $layer=M1 $thickness=3.6e-08 $X=0.4025
+ $Y=0.198 $X2=0.4475 $Y2=0.198
r40 34 35 5.71315 $w=1.3e-08 $l=2.45e-08 $layer=M1 $thickness=3.6e-08 $X=0.378
+ $Y=0.198 $X2=0.4025 $Y2=0.198
r41 33 34 3.61444 $w=1.3e-08 $l=1.55e-08 $layer=M1 $thickness=3.6e-08 $X=0.3625
+ $Y=0.198 $X2=0.378 $Y2=0.198
r42 32 33 3.61444 $w=1.3e-08 $l=1.55e-08 $layer=M1 $thickness=3.6e-08 $X=0.347
+ $Y=0.198 $X2=0.3625 $Y2=0.198
r43 31 32 8.97781 $w=1.3e-08 $l=3.85e-08 $layer=M1 $thickness=3.6e-08 $X=0.3085
+ $Y=0.198 $X2=0.347 $Y2=0.198
r44 30 31 8.97781 $w=1.3e-08 $l=3.85e-08 $layer=M1 $thickness=3.6e-08 $X=0.27
+ $Y=0.198 $X2=0.3085 $Y2=0.198
r45 25 30 2.68168 $w=1.3e-08 $l=1.15e-08 $layer=M1 $thickness=3.6e-08 $X=0.2585
+ $Y=0.198 $X2=0.27 $Y2=0.198
r46 1 30 19.3796 $a=3.24e-16 $layer=V0LISD $X=0.27 $Y=0.2025 $X2=0.27 $Y2=0.198
r47 28 27 0.0308642 $w=8.1e-08 $l=2.5e-09 $layer=P_src_drn $thickness=1e-09
+ $X=0.2873 $Y=0.2025 $X2=0.2845 $Y2=0.2025
r48 1 27 0.179012 $w=8.1e-08 $l=1.45e-08 $layer=P_src_drn $thickness=1e-09
+ $X=0.27 $Y=0.2025 $X2=0.2845 $Y2=0.2025
r49 19 1 0.179012 $w=8.1e-08 $l=1.45e-08 $layer=P_src_drn $thickness=1e-09
+ $X=0.2555 $Y=0.2025 $X2=0.27 $Y2=0.2025
r50 29 19 0.0308642 $w=8.1e-08 $l=2.5e-09 $layer=P_src_drn $thickness=1e-09
+ $X=0.2526 $Y=0.2025 $X2=0.2555 $Y2=0.2025
.ends

.subckt PM_NOR3x2_ASAP7_75t_R%C vss 39 10 14 33 37 43 47 50 53 9 1 3 8 5 6 7 4
c1 1 vss 0.0326217f $X=0.405 $Y=0.135
c2 3 vss 0.0875043f $X=0.405 $Y=0.0245
c3 4 vss 0.0904233f $X=0.459 $Y=0.135
c4 5 vss 0.0504875f $X=0.513 $Y=0.135
c5 6 vss 0.0504831f $X=0.567 $Y=0.135
c6 7 vss 0.0904372f $X=0.621 $Y=0.135
c7 8 vss 0.0876737f $X=0.675 $Y=0.135
c8 9 vss 0.00731803f $X=0.556 $Y=0.116
r1 53 52 16.6668 $w=2.1e-08 $l=4.9e-08 $layer=Gate_1 $thickness=5.6e-08
+ $X=0.675 $Y=0.2025 $X2=0.675 $Y2=0.1535
r2 50 51 16.6668 $w=2.1e-08 $l=4.9e-08 $layer=Gate_1 $thickness=5.6e-08
+ $X=0.675 $Y=0.0675 $X2=0.675 $Y2=0.1165
r3 8 29 6.74717 $w=2e-08 $layer=Gate_1 $thickness=5.2e-08 $X=0.675 $Y=0.135
+ $X2=0.675 $Y2=0.135
r4 8 51 6.46262 $w=2.04595e-08 $l=1.85e-08 $layer=Gate_1 $thickness=5.6e-08
+ $X=0.675 $Y=0.135 $X2=0.675 $Y2=0.1165
r5 8 52 6.46262 $w=2.04595e-08 $l=1.85e-08 $layer=Gate_1 $thickness=5.6e-08
+ $X=0.675 $Y=0.135 $X2=0.675 $Y2=0.1535
r6 47 46 16.6668 $w=2.1e-08 $l=4.9e-08 $layer=Gate_1 $thickness=5.6e-08
+ $X=0.621 $Y=0.2025 $X2=0.621 $Y2=0.1535
r7 7 27 6.74717 $w=2e-08 $layer=Gate_1 $thickness=5.2e-08 $X=0.621 $Y=0.135
+ $X2=0.621 $Y2=0.135
r8 7 46 6.46262 $w=2.04595e-08 $l=1.85e-08 $layer=Gate_1 $thickness=5.6e-08
+ $X=0.621 $Y=0.135 $X2=0.621 $Y2=0.1535
r9 43 42 16.6668 $w=2.1e-08 $l=4.9e-08 $layer=Gate_1 $thickness=5.6e-08
+ $X=0.567 $Y=0.2025 $X2=0.567 $Y2=0.1535
r10 6 25 3.57145 $w=2e-08 $layer=Gate_1 $thickness=5.6e-08 $X=0.567 $Y=0.135
+ $X2=0.567 $Y2=0.135
r11 6 42 6.46262 $w=2.04595e-08 $l=1.85e-08 $layer=Gate_1 $thickness=5.6e-08
+ $X=0.567 $Y=0.135 $X2=0.567 $Y2=0.1535
r12 39 9 4.43061 $w=1.3e-08 $l=1.9e-08 $layer=M1 $thickness=3.6e-08 $X=0.555
+ $Y=0.133 $X2=0.556 $Y2=0.116
r13 37 36 16.6668 $w=2.1e-08 $l=4.9e-08 $layer=Gate_1 $thickness=5.6e-08
+ $X=0.513 $Y=0.2025 $X2=0.513 $Y2=0.1535
r14 5 20 6.74717 $w=2e-08 $layer=Gate_1 $thickness=5.2e-08 $X=0.513 $Y=0.135
+ $X2=0.513 $Y2=0.135
r15 5 36 6.46262 $w=2.04595e-08 $l=1.85e-08 $layer=Gate_1 $thickness=5.6e-08
+ $X=0.513 $Y=0.135 $X2=0.513 $Y2=0.1535
r16 33 32 16.6668 $w=2.1e-08 $l=4.9e-08 $layer=Gate_1 $thickness=5.6e-08
+ $X=0.459 $Y=0.2025 $X2=0.459 $Y2=0.1535
r17 4 18 6.74717 $w=2e-08 $layer=Gate_1 $thickness=5.2e-08 $X=0.459 $Y=0.135
+ $X2=0.459 $Y2=0.135
r18 4 32 6.46262 $w=2.04595e-08 $l=1.85e-08 $layer=Gate_1 $thickness=5.6e-08
+ $X=0.459 $Y=0.135 $X2=0.459 $Y2=0.1535
r19 28 29 20.114 $w=1.57815e-08 $l=2.7e-08 $layer=LIG $thickness=4.8e-08
+ $X=0.648 $Y=0.135 $X2=0.675 $Y2=0.135
r20 27 28 20.114 $w=1.57815e-08 $l=2.7e-08 $layer=LIG $thickness=4.8e-08
+ $X=0.621 $Y=0.135 $X2=0.648 $Y2=0.135
r21 26 27 20.114 $w=1.57815e-08 $l=2.7e-08 $layer=LIG $thickness=4.8e-08
+ $X=0.594 $Y=0.135 $X2=0.621 $Y2=0.135
r22 24 25 1.90543 $w=2e-08 $l=4e-09 $layer=LIG $thickness=4.8e-08 $X=0.571
+ $Y=0.135 $X2=0.567 $Y2=0.135
r23 24 26 18.8437 $w=1.50478e-08 $l=2.3e-08 $layer=LIG $thickness=4.8e-08
+ $X=0.571 $Y=0.135 $X2=0.594 $Y2=0.135
r24 23 24 3.17572 $w=2e-08 $l=1e-08 $layer=LIG $thickness=4.8e-08 $X=0.561
+ $Y=0.135 $X2=0.571 $Y2=0.135
r25 22 23 6.25213 $w=1.62778e-08 $l=9e-09 $layer=LIG $thickness=4.8e-08
+ $X=0.552 $Y=0.135 $X2=0.561 $Y2=0.135
r26 39 22 19.3796 $a=3.24e-16 $layer=V0LIG $X=0.555 $Y=0.133 $X2=0.552 $Y2=0.135
r27 21 22 16.9382 $w=1.33e-08 $l=1.7e-08 $layer=LIG $thickness=4.8e-08 $X=0.535
+ $Y=0.135 $X2=0.552 $Y2=0.135
r28 20 21 15.1321 $w=1.63455e-08 $l=2.2e-08 $layer=LIG $thickness=4.8e-08
+ $X=0.513 $Y=0.135 $X2=0.535 $Y2=0.135
r29 19 20 20.114 $w=1.57815e-08 $l=2.7e-08 $layer=LIG $thickness=4.8e-08
+ $X=0.486 $Y=0.135 $X2=0.513 $Y2=0.135
r30 18 19 20.114 $w=1.57815e-08 $l=2.7e-08 $layer=LIG $thickness=4.8e-08
+ $X=0.459 $Y=0.135 $X2=0.486 $Y2=0.135
r31 17 18 20.114 $w=1.57815e-08 $l=2.7e-08 $layer=LIG $thickness=4.8e-08
+ $X=0.432 $Y=0.135 $X2=0.459 $Y2=0.135
r32 1 12 6.74717 $w=2e-08 $layer=Gate_1 $thickness=5.2e-08 $X=0.405 $Y=0.135
+ $X2=0.405 $Y2=0.135
r33 1 17 20.114 $w=1.57815e-08 $l=2.7e-08 $layer=LIG $thickness=4.8e-08
+ $X=0.405 $Y=0.135 $X2=0.432 $Y2=0.135
r34 14 13 16.6668 $w=2.1e-08 $l=4.9e-08 $layer=Gate_1 $thickness=5.6e-08
+ $X=0.405 $Y=0.2025 $X2=0.405 $Y2=0.1535
r35 12 13 6.46262 $w=2.04595e-08 $l=1.85e-08 $layer=Gate_1 $thickness=5.6e-08
+ $X=0.405 $Y=0.135 $X2=0.405 $Y2=0.1535
r36 11 12 6.46262 $w=2.04595e-08 $l=1.85e-08 $layer=Gate_1 $thickness=5.6e-08
+ $X=0.405 $Y=0.1165 $X2=0.405 $Y2=0.135
r37 10 11 16.6668 $w=2.1e-08 $l=4.9e-08 $layer=Gate_1 $thickness=5.6e-08
+ $X=0.405 $Y=0.0675 $X2=0.405 $Y2=0.1165
r38 10 3 14.6259 $w=2.1e-08 $l=4.3e-08 $layer=Gate_1 $thickness=5.6e-08
+ $X=0.405 $Y=0.0675 $X2=0.405 $Y2=0.0245
.ends

.subckt PM_NOR3x2_ASAP7_75t_R%8 vss 16 17 31 32 35 36 12 2 3 11 10 1 13
c1 1 vss 0.00405871f $X=0.756 $Y=0.2025
c2 2 vss 0.00384391f $X=0.864 $Y=0.2025
c3 3 vss 0.00398722f $X=0.972 $Y=0.2025
c4 10 vss 0.00186048f $X=0.7415 $Y=0.2025
c5 11 vss 0.0018873f $X=0.8495 $Y=0.2025
c6 12 vss 0.00187392f $X=0.9575 $Y=0.2025
c7 13 vss 0.0181605f $X=0.7445 $Y=0.234
r1 36 34 0.0308642 $w=8.1e-08 $l=2.5e-09 $layer=P_src_drn $thickness=1e-09
+ $X=0.9893 $Y=0.2025 $X2=0.9865 $Y2=0.2025
r2 3 34 0.179012 $w=8.1e-08 $l=1.45e-08 $layer=P_src_drn $thickness=1e-09
+ $X=0.972 $Y=0.2025 $X2=0.9865 $Y2=0.2025
r3 12 3 0.179012 $w=8.1e-08 $l=1.45e-08 $layer=P_src_drn $thickness=1e-09
+ $X=0.9575 $Y=0.2025 $X2=0.972 $Y2=0.2025
r4 35 12 0.0308642 $w=8.1e-08 $l=2.5e-09 $layer=P_src_drn $thickness=1e-09
+ $X=0.9546 $Y=0.2025 $X2=0.9575 $Y2=0.2025
r5 32 30 0.0308642 $w=8.1e-08 $l=2.5e-09 $layer=P_src_drn $thickness=1e-09
+ $X=0.8813 $Y=0.2025 $X2=0.8785 $Y2=0.2025
r6 2 30 0.179012 $w=8.1e-08 $l=1.45e-08 $layer=P_src_drn $thickness=1e-09
+ $X=0.864 $Y=0.2025 $X2=0.8785 $Y2=0.2025
r7 11 2 0.179012 $w=8.1e-08 $l=1.45e-08 $layer=P_src_drn $thickness=1e-09
+ $X=0.8495 $Y=0.2025 $X2=0.864 $Y2=0.2025
r8 31 11 0.0308642 $w=8.1e-08 $l=2.5e-09 $layer=P_src_drn $thickness=1e-09
+ $X=0.8466 $Y=0.2025 $X2=0.8495 $Y2=0.2025
r9 3 27 19.3796 $a=3.24e-16 $layer=V0LISD $X=0.972 $Y=0.2025 $X2=0.972 $Y2=0.234
r10 2 21 19.3796 $a=3.24e-16 $layer=V0LISD $X=0.864 $Y=0.2025 $X2=0.8605
+ $Y2=0.234
r11 26 27 8.97781 $w=1.3e-08 $l=3.85e-08 $layer=M1 $thickness=3.6e-08 $X=0.9335
+ $Y=0.234 $X2=0.972 $Y2=0.234
r12 25 26 6.99569 $w=1.3e-08 $l=3e-08 $layer=M1 $thickness=3.6e-08 $X=0.9035
+ $Y=0.234 $X2=0.9335 $Y2=0.234
r13 24 25 2.2153 $w=1.3e-08 $l=9.5e-09 $layer=M1 $thickness=3.6e-08 $X=0.894
+ $Y=0.234 $X2=0.9035 $Y2=0.234
r14 23 24 3.49785 $w=1.3e-08 $l=1.5e-08 $layer=M1 $thickness=3.6e-08 $X=0.879
+ $Y=0.234 $X2=0.894 $Y2=0.234
r15 22 23 2.2153 $w=1.3e-08 $l=9.5e-09 $layer=M1 $thickness=3.6e-08 $X=0.8695
+ $Y=0.234 $X2=0.879 $Y2=0.234
r16 21 22 2.09871 $w=1.3e-08 $l=9e-09 $layer=M1 $thickness=3.6e-08 $X=0.8605
+ $Y=0.234 $X2=0.8695 $Y2=0.234
r17 20 21 4.89699 $w=1.3e-08 $l=2.1e-08 $layer=M1 $thickness=3.6e-08 $X=0.8395
+ $Y=0.234 $X2=0.8605 $Y2=0.234
r18 19 20 10.4935 $w=1.3e-08 $l=4.5e-08 $layer=M1 $thickness=3.6e-08 $X=0.7945
+ $Y=0.234 $X2=0.8395 $Y2=0.234
r19 18 19 8.97781 $w=1.3e-08 $l=3.85e-08 $layer=M1 $thickness=3.6e-08 $X=0.756
+ $Y=0.234 $X2=0.7945 $Y2=0.234
r20 13 18 2.68168 $w=1.3e-08 $l=1.15e-08 $layer=M1 $thickness=3.6e-08 $X=0.7445
+ $Y=0.234 $X2=0.756 $Y2=0.234
r21 1 18 19.3796 $a=3.24e-16 $layer=V0LISD $X=0.756 $Y=0.2025 $X2=0.756
+ $Y2=0.234
r22 17 15 0.0308642 $w=8.1e-08 $l=2.5e-09 $layer=P_src_drn $thickness=1e-09
+ $X=0.7733 $Y=0.2025 $X2=0.7705 $Y2=0.2025
r23 1 15 0.179012 $w=8.1e-08 $l=1.45e-08 $layer=P_src_drn $thickness=1e-09
+ $X=0.756 $Y=0.2025 $X2=0.7705 $Y2=0.2025
r24 10 1 0.179012 $w=8.1e-08 $l=1.45e-08 $layer=P_src_drn $thickness=1e-09
+ $X=0.7415 $Y=0.2025 $X2=0.756 $Y2=0.2025
r25 16 10 0.0308642 $w=8.1e-08 $l=2.5e-09 $layer=P_src_drn $thickness=1e-09
+ $X=0.7386 $Y=0.2025 $X2=0.7415 $Y2=0.2025
.ends

.subckt PM_NOR3x2_ASAP7_75t_R%A vss 48 18 22 37 43 64 67 71 77 1 2 13 14 15 7 8
+ 6 5 9 10 12 11
c1 1 vss 0.0047785f $X=0.1855 $Y=0.135
c2 2 vss 0.00468814f $X=0.883 $Y=0.135
c3 5 vss 0.017581f $X=0.081 $Y=0.135
c4 6 vss 0.0115013f $X=0.135 $Y=0.135
c5 7 vss 0.0445173f $X=0.189 $Y=0.0245
c6 8 vss 0.0445173f $X=0.891 $Y=0.135
c7 9 vss 0.011501f $X=0.945 $Y=0.135
c8 10 vss 0.017581f $X=0.999 $Y=0.135
c9 11 vss 0.00332936f $X=0.183 $Y=0.072
c10 12 vss 0.00330022f $X=0.894 $Y=0.072
c11 13 vss 0.00421778f $X=0.183 $Y=0.0855
c12 14 vss 0.00369537f $X=0.894 $Y=0.0855
c13 15 vss 0.0920433f $X=0.1715 $Y=0.081
r1 77 76 14.6259 $w=2.1e-08 $l=4.3e-08 $layer=Gate_1 $thickness=5.6e-08
+ $X=0.999 $Y=0.2025 $X2=0.999 $Y2=0.1595
r2 75 76 2.89117 $w=2.1e-08 $l=8.5e-09 $layer=Gate_1 $thickness=5.6e-08
+ $X=0.999 $Y=0.151 $X2=0.999 $Y2=0.1595
r3 10 61 6.74717 $w=2e-08 $layer=Gate_1 $thickness=5.2e-08 $X=0.999 $Y=0.135
+ $X2=0.999 $Y2=0.135
r4 10 75 5.61228 $w=2.0375e-08 $l=1.6e-08 $layer=Gate_1 $thickness=5.6e-08
+ $X=0.999 $Y=0.135 $X2=0.999 $Y2=0.151
r5 71 70 16.6668 $w=2.1e-08 $l=4.9e-08 $layer=Gate_1 $thickness=5.6e-08
+ $X=0.945 $Y=0.2025 $X2=0.945 $Y2=0.1535
r6 9 59 6.74717 $w=2e-08 $layer=Gate_1 $thickness=5.2e-08 $X=0.945 $Y=0.135
+ $X2=0.945 $Y2=0.135
r7 9 70 6.46262 $w=2.04595e-08 $l=1.85e-08 $layer=Gate_1 $thickness=5.6e-08
+ $X=0.945 $Y=0.135 $X2=0.945 $Y2=0.1535
r8 67 66 16.6668 $w=2.1e-08 $l=4.9e-08 $layer=Gate_1 $thickness=5.6e-08
+ $X=0.891 $Y=0.2025 $X2=0.891 $Y2=0.1535
r9 64 65 16.6668 $w=2.1e-08 $l=4.9e-08 $layer=Gate_1 $thickness=5.6e-08
+ $X=0.891 $Y=0.0675 $X2=0.891 $Y2=0.1165
r10 8 55 3.57145 $w=2e-08 $layer=Gate_1 $thickness=5.6e-08 $X=0.891 $Y=0.135
+ $X2=0.891 $Y2=0.135
r11 8 65 6.46262 $w=2.04595e-08 $l=1.85e-08 $layer=Gate_1 $thickness=5.6e-08
+ $X=0.891 $Y=0.135 $X2=0.891 $Y2=0.1165
r12 8 66 6.46262 $w=2.04595e-08 $l=1.85e-08 $layer=Gate_1 $thickness=5.6e-08
+ $X=0.891 $Y=0.135 $X2=0.891 $Y2=0.1535
r13 60 61 20.114 $w=1.57815e-08 $l=2.7e-08 $layer=LIG $thickness=4.8e-08
+ $X=0.972 $Y=0.135 $X2=0.999 $Y2=0.135
r14 59 60 20.114 $w=1.57815e-08 $l=2.7e-08 $layer=LIG $thickness=4.8e-08
+ $X=0.945 $Y=0.135 $X2=0.972 $Y2=0.135
r15 58 59 19.1176 $w=1.58769e-08 $l=2.6e-08 $layer=LIG $thickness=4.8e-08
+ $X=0.919 $Y=0.135 $X2=0.945 $Y2=0.135
r16 57 58 16.9382 $w=1.33e-08 $l=1.7e-08 $layer=LIG $thickness=4.8e-08 $X=0.902
+ $Y=0.135 $X2=0.919 $Y2=0.135
r17 54 55 2.54058 $w=2e-08 $l=2e-09 $layer=LIG $thickness=4.8e-08 $X=0.893
+ $Y=0.135 $X2=0.891 $Y2=0.135
r18 54 57 3.53695 $w=1.92556e-08 $l=9e-09 $layer=LIG $thickness=4.8e-08
+ $X=0.893 $Y=0.135 $X2=0.902 $Y2=0.135
r19 2 54 3.17572 $w=2e-08 $l=1e-08 $layer=LIG $thickness=4.8e-08 $X=0.883
+ $Y=0.135 $X2=0.893 $Y2=0.135
r20 52 54 19.3796 $a=3.24e-16 $layer=V0LIG $X=0.894 $Y=0.135 $X2=0.893 $Y2=0.135
r21 51 52 6.29612 $w=1.3e-08 $l=2.7e-08 $layer=M1 $thickness=3.6e-08 $X=0.894
+ $Y=0.108 $X2=0.894 $Y2=0.135
r22 14 51 5.24677 $w=1.3e-08 $l=2.25e-08 $layer=M1 $thickness=3.6e-08 $X=0.894
+ $Y=0.0855 $X2=0.894 $Y2=0.108
r23 48 14 39.0693 $a=1.62e-16 $layer=V1 $X=0.894 $Y=0.078 $X2=0.894 $Y2=0.0855
r24 48 12 39.0693 $a=1.62e-16 $layer=V1 $X=0.894 $Y=0.078 $X2=0.894 $Y2=0.072
r25 12 14 1.96775 $w=1.63333e-08 $l=1.35e-08 $layer=M1 $thickness=3.6e-08
+ $X=0.894 $Y=0.072 $X2=0.894 $Y2=0.0855
r26 48 47 82.899 $w=1.3e-08 $l=3.555e-07 $layer=M2 $thickness=3.6e-08 $X=0.894
+ $Y=0.078 $X2=0.5385 $Y2=0.081
r27 46 47 82.899 $w=1.3e-08 $l=3.555e-07 $layer=M2 $thickness=3.6e-08 $X=0.183
+ $Y=0.081 $X2=0.5385 $Y2=0.081
r28 15 46 2.68168 $w=1.3e-08 $l=1.15e-08 $layer=M2 $thickness=3.6e-08 $X=0.1715
+ $Y=0.081 $X2=0.183 $Y2=0.081
r29 11 13 1.96775 $w=1.63333e-08 $l=1.35e-08 $layer=M1 $thickness=3.6e-08
+ $X=0.183 $Y=0.072 $X2=0.183 $Y2=0.0855
r30 11 46 39.0693 $a=1.62e-16 $layer=V1 $X=0.183 $Y=0.072 $X2=0.183 $Y2=0.081
r31 43 42 14.6259 $w=2.1e-08 $l=4.3e-08 $layer=Gate_1 $thickness=5.6e-08
+ $X=0.081 $Y=0.2025 $X2=0.081 $Y2=0.1595
r32 41 42 2.89117 $w=2.1e-08 $l=8.5e-09 $layer=Gate_1 $thickness=5.6e-08
+ $X=0.081 $Y=0.151 $X2=0.081 $Y2=0.1595
r33 5 29 6.74717 $w=2e-08 $layer=Gate_1 $thickness=5.2e-08 $X=0.081 $Y=0.135
+ $X2=0.081 $Y2=0.135
r34 5 41 5.61228 $w=2.0375e-08 $l=1.6e-08 $layer=Gate_1 $thickness=5.6e-08
+ $X=0.081 $Y=0.135 $X2=0.081 $Y2=0.151
r35 37 36 16.6668 $w=2.1e-08 $l=4.9e-08 $layer=Gate_1 $thickness=5.6e-08
+ $X=0.135 $Y=0.2025 $X2=0.135 $Y2=0.1535
r36 6 27 6.74717 $w=2e-08 $layer=Gate_1 $thickness=5.2e-08 $X=0.135 $Y=0.135
+ $X2=0.135 $Y2=0.135
r37 6 36 6.46262 $w=2.04595e-08 $l=1.85e-08 $layer=Gate_1 $thickness=5.6e-08
+ $X=0.135 $Y=0.135 $X2=0.135 $Y2=0.1535
r38 32 33 6.29612 $w=1.3e-08 $l=2.7e-08 $layer=M1 $thickness=3.6e-08 $X=0.183
+ $Y=0.108 $X2=0.183 $Y2=0.135
r39 13 32 5.24677 $w=1.3e-08 $l=2.25e-08 $layer=M1 $thickness=3.6e-08 $X=0.183
+ $Y=0.0855 $X2=0.183 $Y2=0.108
r40 13 46 39.0693 $a=1.62e-16 $layer=V1 $X=0.183 $Y=0.0855 $X2=0.183 $Y2=0.081
r41 28 29 20.114 $w=1.57815e-08 $l=2.7e-08 $layer=LIG $thickness=4.8e-08
+ $X=0.108 $Y=0.135 $X2=0.081 $Y2=0.135
r42 27 28 20.114 $w=1.57815e-08 $l=2.7e-08 $layer=LIG $thickness=4.8e-08
+ $X=0.135 $Y=0.135 $X2=0.108 $Y2=0.135
r43 25 26 16.9382 $w=1.33e-08 $l=1.7e-08 $layer=LIG $thickness=4.8e-08
+ $X=0.1595 $Y=0.135 $X2=0.1765 $Y2=0.135
r44 25 27 17.6231 $w=1.60347e-08 $l=2.45e-08 $layer=LIG $thickness=4.8e-08
+ $X=0.1595 $Y=0.135 $X2=0.135 $Y2=0.135
r45 1 24 3.17572 $w=2e-08 $l=1e-08 $layer=LIG $thickness=4.8e-08 $X=0.1855
+ $Y=0.135 $X2=0.1955 $Y2=0.135
r46 1 20 5.63567 $w=2e-08 $l=3.5e-09 $layer=Gate_1 $thickness=5.28485e-08
+ $X=0.1855 $Y=0.135 $X2=0.189 $Y2=0.135
r47 1 26 4.55514 $w=1.81389e-08 $l=9e-09 $layer=LIG $thickness=4.8e-08
+ $X=0.1855 $Y=0.135 $X2=0.1765 $Y2=0.135
r48 1 33 19.3796 $a=3.24e-16 $layer=V0LIG $X=0.1855 $Y=0.135 $X2=0.183 $Y2=0.135
r49 22 21 16.6668 $w=2.1e-08 $l=4.9e-08 $layer=Gate_1 $thickness=5.6e-08
+ $X=0.189 $Y=0.2025 $X2=0.189 $Y2=0.1535
r50 20 21 6.46262 $w=2.04595e-08 $l=1.85e-08 $layer=Gate_1 $thickness=5.6e-08
+ $X=0.189 $Y=0.135 $X2=0.189 $Y2=0.1535
r51 20 24 4.68295 $w=2e-08 $l=6.5e-09 $layer=Gate_1 $thickness=5.39259e-08
+ $X=0.189 $Y=0.135 $X2=0.1955 $Y2=0.135
r52 19 20 6.46262 $w=2.04595e-08 $l=1.85e-08 $layer=Gate_1 $thickness=5.6e-08
+ $X=0.189 $Y=0.1165 $X2=0.189 $Y2=0.135
r53 18 19 16.6668 $w=2.1e-08 $l=4.9e-08 $layer=Gate_1 $thickness=5.6e-08
+ $X=0.189 $Y=0.0675 $X2=0.189 $Y2=0.1165
r54 18 7 14.6259 $w=2.1e-08 $l=4.3e-08 $layer=Gate_1 $thickness=5.6e-08
+ $X=0.189 $Y=0.0675 $X2=0.189 $Y2=0.0245
.ends

.subckt PM_NOR3x2_ASAP7_75t_R%Y vss 74 43 66 67 70 71 78 91 94 95 97 100 101 31
+ 6 2 38 29 32 7 3 1 8 30 37 41 25 28 40 39 26 27 4 5
c1 1 vss 0.00507566f $X=0.054 $Y=0.2025
c2 2 vss 0.00667789f $X=0.162 $Y=0.0675
c3 3 vss 0.00288905f $X=0.162 $Y=0.2025
c4 4 vss 0.00895151f $X=0.378 $Y=0.0675
c5 5 vss 0.00895561f $X=0.702 $Y=0.0675
c6 6 vss 0.00668153f $X=0.918 $Y=0.0675
c7 7 vss 0.00289469f $X=0.918 $Y=0.2025
c8 8 vss 0.00507617f $X=1.026 $Y=0.2025
c9 25 vss 0.00339851f $X=0.164 $Y=0.0675
c10 26 vss 0.00452837f $X=0.3635 $Y=0.0675
c11 27 vss 0.00452836f $X=0.6875 $Y=0.0675
c12 28 vss 0.00332822f $X=0.9035 $Y=0.0675
c13 29 vss 0.0359214f $X=0.056 $Y=0.2025
c14 30 vss 0.0020692f $X=0.1475 $Y=0.2025
c15 31 vss 0.00207202f $X=0.9035 $Y=0.2025
c16 32 vss 0.0359214f $X=1.0115 $Y=0.2025
c17 33 vss 0.00280231f $X=0.027 $Y=0.036
c18 34 vss 0.00134915f $X=0.027 $Y=0.198
c19 35 vss 0.00277925f $X=1.053 $Y=0.036
c20 36 vss 0.00134862f $X=1.053 $Y=0.198
c21 37 vss 0.0044002f $X=0.027 $Y=0.054
c22 38 vss 0.0851769f $X=0.0945 $Y=0.036
c23 39 vss 0.00190426f $X=0.0405 $Y=0.198
c24 40 vss 0.00227477f $X=1.0015 $Y=0.198
c25 41 vss 0.00439484f $X=1.053 $Y=0.054
r1 101 99 0.0308642 $w=8.1e-08 $l=2.5e-09 $layer=P_src_drn $thickness=1e-09
+ $X=0.9353 $Y=0.2025 $X2=0.9325 $Y2=0.2025
r2 7 99 0.179012 $w=8.1e-08 $l=1.45e-08 $layer=P_src_drn $thickness=1e-09
+ $X=0.918 $Y=0.2025 $X2=0.9325 $Y2=0.2025
r3 31 7 0.179012 $w=8.1e-08 $l=1.45e-08 $layer=P_src_drn $thickness=1e-09
+ $X=0.9035 $Y=0.2025 $X2=0.918 $Y2=0.2025
r4 100 31 0.0308642 $w=8.1e-08 $l=2.5e-09 $layer=P_src_drn $thickness=1e-09
+ $X=0.9006 $Y=0.2025 $X2=0.9035 $Y2=0.2025
r5 32 8 0.154321 $w=8.1e-08 $l=1.25e-08 $layer=P_src_drn $thickness=1e-09
+ $X=1.0115 $Y=0.2025 $X2=1.026 $Y2=0.2025
r6 97 32 0.0308642 $w=8.1e-08 $l=2.5e-09 $layer=P_src_drn $thickness=1e-09
+ $X=1.0086 $Y=0.2025 $X2=1.0115 $Y2=0.2025
r7 95 93 0.0308642 $w=8.1e-08 $l=2.5e-09 $layer=P_src_drn $thickness=1e-09
+ $X=0.1793 $Y=0.2025 $X2=0.1765 $Y2=0.2025
r8 3 93 0.179012 $w=8.1e-08 $l=1.45e-08 $layer=P_src_drn $thickness=1e-09
+ $X=0.162 $Y=0.2025 $X2=0.1765 $Y2=0.2025
r9 30 3 0.179012 $w=8.1e-08 $l=1.45e-08 $layer=P_src_drn $thickness=1e-09
+ $X=0.1475 $Y=0.2025 $X2=0.162 $Y2=0.2025
r10 94 30 0.0308642 $w=8.1e-08 $l=2.5e-09 $layer=P_src_drn $thickness=1e-09
+ $X=0.1446 $Y=0.2025 $X2=0.1475 $Y2=0.2025
r11 91 90 0.0308642 $w=8.1e-08 $l=2.5e-09 $layer=P_src_drn $thickness=1e-09
+ $X=0.0713 $Y=0.2025 $X2=0.0685 $Y2=0.2025
r12 29 90 0.154321 $w=8.1e-08 $l=1.25e-08 $layer=P_src_drn $thickness=1e-09
+ $X=0.056 $Y=0.2025 $X2=0.0685 $Y2=0.2025
r13 7 88 19.3796 $a=3.24e-16 $layer=V0LISD $X=0.918 $Y=0.2025 $X2=0.918
+ $Y2=0.198
r14 8 85 19.3796 $a=3.24e-16 $layer=V0LISD $X=1.026 $Y=0.2025 $X2=1.026
+ $Y2=0.198
r15 3 82 19.3796 $a=3.24e-16 $layer=V0LISD $X=0.162 $Y=0.2025 $X2=0.162
+ $Y2=0.198
r16 1 79 19.3796 $a=3.24e-16 $layer=V0LISD $X=0.054 $Y=0.2025 $X2=0.054
+ $Y2=0.198
r17 88 89 8.97781 $w=1.3e-08 $l=3.85e-08 $layer=M1 $thickness=3.6e-08 $X=0.918
+ $Y=0.198 $X2=0.9565 $Y2=0.198
r18 85 86 3.14806 $w=1.3e-08 $l=1.35e-08 $layer=M1 $thickness=3.6e-08 $X=1.026
+ $Y=0.198 $X2=1.0395 $Y2=0.198
r19 40 85 5.71315 $w=1.3e-08 $l=2.45e-08 $layer=M1 $thickness=3.6e-08 $X=1.0015
+ $Y=0.198 $X2=1.026 $Y2=0.198
r20 40 89 10.4935 $w=1.3e-08 $l=4.5e-08 $layer=M1 $thickness=3.6e-08 $X=1.0015
+ $Y=0.198 $X2=0.9565 $Y2=0.198
r21 81 82 8.97781 $w=1.3e-08 $l=3.85e-08 $layer=M1 $thickness=3.6e-08 $X=0.1235
+ $Y=0.198 $X2=0.162 $Y2=0.198
r22 80 81 10.4935 $w=1.3e-08 $l=4.5e-08 $layer=M1 $thickness=3.6e-08 $X=0.0785
+ $Y=0.198 $X2=0.1235 $Y2=0.198
r23 79 80 5.71315 $w=1.3e-08 $l=2.45e-08 $layer=M1 $thickness=3.6e-08 $X=0.054
+ $Y=0.198 $X2=0.0785 $Y2=0.198
r24 39 79 3.14806 $w=1.3e-08 $l=1.35e-08 $layer=M1 $thickness=3.6e-08 $X=0.0405
+ $Y=0.198 $X2=0.054 $Y2=0.198
r25 36 76 3.59766 $w=1.692e-08 $l=2.25e-08 $layer=M1 $thickness=3.6e-08
+ $X=1.053 $Y=0.198 $X2=1.053 $Y2=0.1755
r26 36 86 1.49895 $w=1.63333e-08 $l=1.35e-08 $layer=M1 $thickness=3.6e-08
+ $X=1.053 $Y=0.198 $X2=1.0395 $Y2=0.198
r27 34 63 3.36447 $w=1.71023e-08 $l=2.15e-08 $layer=M1 $thickness=3.6e-08
+ $X=0.027 $Y=0.198 $X2=0.027 $Y2=0.1765
r28 34 39 1.49895 $w=1.63333e-08 $l=1.35e-08 $layer=M1 $thickness=3.6e-08
+ $X=0.027 $Y=0.198 $X2=0.0405 $Y2=0.198
r29 28 6 0.154321 $w=8.1e-08 $l=1.25e-08 $layer=N_src_drn $thickness=1e-09
+ $X=0.9035 $Y=0.0675 $X2=0.918 $Y2=0.0675
r30 78 28 0.0308642 $w=8.1e-08 $l=2.5e-09 $layer=N_src_drn $thickness=1e-09
+ $X=0.9006 $Y=0.0675 $X2=0.9035 $Y2=0.0675
r31 75 76 7.17059 $w=1.3e-08 $l=3.08e-08 $layer=M1 $thickness=3.6e-08 $X=1.053
+ $Y=0.1447 $X2=1.053 $Y2=0.1755
r32 74 75 4.13912 $w=1.3e-08 $l=1.77e-08 $layer=M1 $thickness=3.6e-08 $X=1.052
+ $Y=0.127 $X2=1.053 $Y2=0.1447
r33 74 73 5.42166 $w=1.3e-08 $l=2.33e-08 $layer=M1 $thickness=3.6e-08 $X=1.052
+ $Y=0.127 $X2=1.053 $Y2=0.1037
r34 72 73 7.40378 $w=1.3e-08 $l=3.17e-08 $layer=M1 $thickness=3.6e-08 $X=1.053
+ $Y=0.072 $X2=1.053 $Y2=0.1037
r35 41 72 4.19742 $w=1.3e-08 $l=1.8e-08 $layer=M1 $thickness=3.6e-08 $X=1.053
+ $Y=0.054 $X2=1.053 $Y2=0.072
r36 71 69 0.0308642 $w=8.1e-08 $l=2.5e-09 $layer=N_src_drn $thickness=1e-09
+ $X=0.7193 $Y=0.0675 $X2=0.7165 $Y2=0.0675
r37 5 69 0.179012 $w=8.1e-08 $l=1.45e-08 $layer=N_src_drn $thickness=1e-09
+ $X=0.702 $Y=0.0675 $X2=0.7165 $Y2=0.0675
r38 27 5 0.179012 $w=8.1e-08 $l=1.45e-08 $layer=N_src_drn $thickness=1e-09
+ $X=0.6875 $Y=0.0675 $X2=0.702 $Y2=0.0675
r39 70 27 0.0308642 $w=8.1e-08 $l=2.5e-09 $layer=N_src_drn $thickness=1e-09
+ $X=0.6846 $Y=0.0675 $X2=0.6875 $Y2=0.0675
r40 67 65 0.0308642 $w=8.1e-08 $l=2.5e-09 $layer=N_src_drn $thickness=1e-09
+ $X=0.3953 $Y=0.0675 $X2=0.3925 $Y2=0.0675
r41 4 65 0.179012 $w=8.1e-08 $l=1.45e-08 $layer=N_src_drn $thickness=1e-09
+ $X=0.378 $Y=0.0675 $X2=0.3925 $Y2=0.0675
r42 26 4 0.179012 $w=8.1e-08 $l=1.45e-08 $layer=N_src_drn $thickness=1e-09
+ $X=0.3635 $Y=0.0675 $X2=0.378 $Y2=0.0675
r43 66 26 0.0308642 $w=8.1e-08 $l=2.5e-09 $layer=N_src_drn $thickness=1e-09
+ $X=0.3606 $Y=0.0675 $X2=0.3635 $Y2=0.0675
r44 62 63 12.5922 $w=1.3e-08 $l=5.4e-08 $layer=M1 $thickness=3.6e-08 $X=0.027
+ $Y=0.1225 $X2=0.027 $Y2=0.1765
r45 61 62 11.7761 $w=1.3e-08 $l=5.05e-08 $layer=M1 $thickness=3.6e-08 $X=0.027
+ $Y=0.072 $X2=0.027 $Y2=0.1225
r46 37 61 4.19742 $w=1.3e-08 $l=1.8e-08 $layer=M1 $thickness=3.6e-08 $X=0.027
+ $Y=0.054 $X2=0.027 $Y2=0.072
r47 6 59 19.3796 $a=3.24e-16 $layer=V0LISD $X=0.918 $Y=0.0675 $X2=0.918
+ $Y2=0.036
r48 35 60 14.0912 $w=1.36667e-08 $l=6.75e-08 $layer=M1 $thickness=3.6e-08
+ $X=1.053 $Y=0.036 $X2=0.9855 $Y2=0.036
r49 35 41 2.5483 $w=1.79e-08 $l=1.8e-08 $layer=M1 $thickness=3.6e-08 $X=1.053
+ $Y=0.036 $X2=1.053 $Y2=0.054
r50 5 52 19.3796 $a=3.24e-16 $layer=V0LISD $X=0.702 $Y=0.0675 $X2=0.702
+ $Y2=0.036
r51 4 50 19.3796 $a=3.24e-16 $layer=V0LISD $X=0.378 $Y=0.0675 $X2=0.378
+ $Y2=0.036
r52 33 38 14.0912 $w=1.36667e-08 $l=6.75e-08 $layer=M1 $thickness=3.6e-08
+ $X=0.027 $Y=0.036 $X2=0.0945 $Y2=0.036
r53 33 37 2.5483 $w=1.79e-08 $l=1.8e-08 $layer=M1 $thickness=3.6e-08 $X=0.027
+ $Y=0.036 $X2=0.027 $Y2=0.054
r54 59 60 15.7403 $w=1.3e-08 $l=6.75e-08 $layer=M1 $thickness=3.6e-08 $X=0.918
+ $Y=0.036 $X2=0.9855 $Y2=0.036
r55 58 59 2.68168 $w=1.3e-08 $l=1.15e-08 $layer=M1 $thickness=3.6e-08 $X=0.9065
+ $Y=0.036 $X2=0.918 $Y2=0.036
r56 57 58 0.699569 $w=1.3e-08 $l=3e-09 $layer=M1 $thickness=3.6e-08 $X=0.9035
+ $Y=0.036 $X2=0.9065 $Y2=0.036
r57 56 57 4.43061 $w=1.3e-08 $l=1.9e-08 $layer=M1 $thickness=3.6e-08 $X=0.8845
+ $Y=0.036 $X2=0.9035 $Y2=0.036
r58 55 56 9.211 $w=1.3e-08 $l=3.95e-08 $layer=M1 $thickness=3.6e-08 $X=0.845
+ $Y=0.036 $X2=0.8845 $Y2=0.036
r59 54 55 14.3412 $w=1.3e-08 $l=6.15e-08 $layer=M1 $thickness=3.6e-08 $X=0.7835
+ $Y=0.036 $X2=0.845 $Y2=0.036
r60 53 54 13.1752 $w=1.3e-08 $l=5.65e-08 $layer=M1 $thickness=3.6e-08 $X=0.727
+ $Y=0.036 $X2=0.7835 $Y2=0.036
r61 52 53 5.82974 $w=1.3e-08 $l=2.5e-08 $layer=M1 $thickness=3.6e-08 $X=0.702
+ $Y=0.036 $X2=0.727 $Y2=0.036
r62 51 52 37.7767 $w=1.3e-08 $l=1.62e-07 $layer=M1 $thickness=3.6e-08 $X=0.54
+ $Y=0.036 $X2=0.702 $Y2=0.036
r63 50 51 37.7767 $w=1.3e-08 $l=1.62e-07 $layer=M1 $thickness=3.6e-08 $X=0.378
+ $Y=0.036 $X2=0.54 $Y2=0.036
r64 49 50 5.71315 $w=1.3e-08 $l=2.45e-08 $layer=M1 $thickness=3.6e-08 $X=0.3535
+ $Y=0.036 $X2=0.378 $Y2=0.036
r65 48 49 13.1752 $w=1.3e-08 $l=5.65e-08 $layer=M1 $thickness=3.6e-08 $X=0.297
+ $Y=0.036 $X2=0.3535 $Y2=0.036
r66 47 48 14.8076 $w=1.3e-08 $l=6.35e-08 $layer=M1 $thickness=3.6e-08 $X=0.2335
+ $Y=0.036 $X2=0.297 $Y2=0.036
r67 46 47 9.56078 $w=1.3e-08 $l=4.1e-08 $layer=M1 $thickness=3.6e-08 $X=0.1925
+ $Y=0.036 $X2=0.2335 $Y2=0.036
r68 45 46 4.6638 $w=1.3e-08 $l=2e-08 $layer=M1 $thickness=3.6e-08 $X=0.1725
+ $Y=0.036 $X2=0.1925 $Y2=0.036
r69 44 45 2.44849 $w=1.3e-08 $l=1.05e-08 $layer=M1 $thickness=3.6e-08 $X=0.162
+ $Y=0.036 $X2=0.1725 $Y2=0.036
r70 38 44 15.7403 $w=1.3e-08 $l=6.75e-08 $layer=M1 $thickness=3.6e-08 $X=0.0945
+ $Y=0.036 $X2=0.162 $Y2=0.036
r71 2 44 19.3796 $a=3.24e-16 $layer=V0LISD $X=0.162 $Y=0.0675 $X2=0.162
+ $Y2=0.036
r72 43 42 0.0308642 $w=8.1e-08 $l=2.5e-09 $layer=N_src_drn $thickness=1e-09
+ $X=0.1793 $Y=0.0675 $X2=0.1765 $Y2=0.0675
r73 25 42 0.154321 $w=8.1e-08 $l=1.25e-08 $layer=N_src_drn $thickness=1e-09
+ $X=0.164 $Y=0.0675 $X2=0.1765 $Y2=0.0675
r74 1 29 1e-05 $l=2e-09 $X=0.054 $Y=0.2025 $X2=0.056 $Y2=0.2025
r75 2 25 1e-05 $l=2e-09 $X=0.162 $Y=0.0675 $X2=0.164 $Y2=0.0675
.ends

.subckt PM_NOR3x2_ASAP7_75t_R%B vss 39 18 31 34 37 58 61 65 69 1 2 11 12 15 5
+ 10 13 14 7 8 6 9
c1 1 vss 0.0197299f $X=0.297 $Y=0.135
c2 2 vss 0.0196864f $X=0.722 $Y=0.135
c3 5 vss 0.0528735f $X=0.243 $Y=0.135
c4 6 vss 0.0528755f $X=0.297 $Y=0.0735
c5 7 vss 0.0499339f $X=0.351 $Y=0.135
c6 8 vss 0.0499339f $X=0.729 $Y=0.135
c7 9 vss 0.052881f $X=0.783 $Y=0.135
c8 10 vss 0.0528725f $X=0.837 $Y=0.135
c9 11 vss 0.00688384f $X=0.347 $Y=0.072
c10 12 vss 0.00689266f $X=0.734 $Y=0.072
c11 13 vss 0.00761961f $X=0.347 $Y=0.116
c12 14 vss 0.0134847f $X=0.4515 $Y=0.072
c13 15 vss 0.00774784f $X=0.734 $Y=0.0935
r1 69 68 16.6668 $w=2.1e-08 $l=4.9e-08 $layer=Gate_1 $thickness=5.6e-08
+ $X=0.837 $Y=0.2025 $X2=0.837 $Y2=0.1535
r2 10 55 6.74717 $w=2e-08 $layer=Gate_1 $thickness=5.2e-08 $X=0.837 $Y=0.135
+ $X2=0.837 $Y2=0.135
r3 10 68 6.46262 $w=2.04595e-08 $l=1.85e-08 $layer=Gate_1 $thickness=5.6e-08
+ $X=0.837 $Y=0.135 $X2=0.837 $Y2=0.1535
r4 65 64 16.6668 $w=2.1e-08 $l=4.9e-08 $layer=Gate_1 $thickness=5.6e-08
+ $X=0.783 $Y=0.2025 $X2=0.783 $Y2=0.1535
r5 9 53 6.74717 $w=2e-08 $layer=Gate_1 $thickness=5.2e-08 $X=0.783 $Y=0.135
+ $X2=0.783 $Y2=0.135
r6 9 64 6.46262 $w=2.04595e-08 $l=1.85e-08 $layer=Gate_1 $thickness=5.6e-08
+ $X=0.783 $Y=0.135 $X2=0.783 $Y2=0.1535
r7 61 60 16.6668 $w=2.1e-08 $l=4.9e-08 $layer=Gate_1 $thickness=5.6e-08
+ $X=0.729 $Y=0.2025 $X2=0.729 $Y2=0.1535
r8 58 59 16.6668 $w=2.1e-08 $l=4.9e-08 $layer=Gate_1 $thickness=5.6e-08
+ $X=0.729 $Y=0.0675 $X2=0.729 $Y2=0.1165
r9 8 49 3.57145 $w=2e-08 $layer=Gate_1 $thickness=5.6e-08 $X=0.729 $Y=0.135
+ $X2=0.729 $Y2=0.135
r10 8 59 6.46262 $w=2.04595e-08 $l=1.85e-08 $layer=Gate_1 $thickness=5.6e-08
+ $X=0.729 $Y=0.135 $X2=0.729 $Y2=0.1165
r11 8 60 6.46262 $w=2.04595e-08 $l=1.85e-08 $layer=Gate_1 $thickness=5.6e-08
+ $X=0.729 $Y=0.135 $X2=0.729 $Y2=0.1535
r12 54 55 20.114 $w=1.57815e-08 $l=2.7e-08 $layer=LIG $thickness=4.8e-08
+ $X=0.81 $Y=0.135 $X2=0.837 $Y2=0.135
r13 53 54 20.114 $w=1.57815e-08 $l=2.7e-08 $layer=LIG $thickness=4.8e-08
+ $X=0.783 $Y=0.135 $X2=0.81 $Y2=0.135
r14 52 53 18.1212 $w=1.598e-08 $l=2.5e-08 $layer=LIG $thickness=4.8e-08
+ $X=0.758 $Y=0.135 $X2=0.783 $Y2=0.135
r15 51 52 16.9382 $w=1.33e-08 $l=1.7e-08 $layer=LIG $thickness=4.8e-08 $X=0.741
+ $Y=0.135 $X2=0.758 $Y2=0.135
r16 48 49 2.22301 $w=2e-08 $l=3e-09 $layer=LIG $thickness=4.8e-08 $X=0.732
+ $Y=0.135 $X2=0.729 $Y2=0.135
r17 48 51 4.21574 $w=1.85111e-08 $l=9e-09 $layer=LIG $thickness=4.8e-08
+ $X=0.732 $Y=0.135 $X2=0.741 $Y2=0.135
r18 2 48 3.17572 $w=2e-08 $l=1e-08 $layer=LIG $thickness=4.8e-08 $X=0.722
+ $Y=0.135 $X2=0.732 $Y2=0.135
r19 45 48 19.3796 $a=3.24e-16 $layer=V0LIG $X=0.734 $Y=0.135 $X2=0.732 $Y2=0.135
r20 44 45 4.43061 $w=1.3e-08 $l=1.9e-08 $layer=M1 $thickness=3.6e-08 $X=0.734
+ $Y=0.116 $X2=0.734 $Y2=0.135
r21 15 44 5.24677 $w=1.3e-08 $l=2.25e-08 $layer=M1 $thickness=3.6e-08 $X=0.734
+ $Y=0.0935 $X2=0.734 $Y2=0.116
r22 12 43 19.1048 $w=1.35056e-08 $l=8.9e-08 $layer=M1 $thickness=3.6e-08
+ $X=0.734 $Y=0.072 $X2=0.645 $Y2=0.072
r23 12 15 3.36447 $w=1.71023e-08 $l=2.15e-08 $layer=M1 $thickness=3.6e-08
+ $X=0.734 $Y=0.072 $X2=0.734 $Y2=0.0935
r24 42 43 20.7539 $w=1.3e-08 $l=8.9e-08 $layer=M1 $thickness=3.6e-08 $X=0.556
+ $Y=0.072 $X2=0.645 $Y2=0.072
r25 14 42 24.3683 $w=1.3e-08 $l=1.045e-07 $layer=M1 $thickness=3.6e-08
+ $X=0.4515 $Y=0.072 $X2=0.556 $Y2=0.072
r26 11 41 3.36447 $w=1.71023e-08 $l=2.15e-08 $layer=M1 $thickness=3.6e-08
+ $X=0.347 $Y=0.072 $X2=0.347 $Y2=0.0935
r27 11 14 22.7192 $w=1.34306e-08 $l=1.045e-07 $layer=M1 $thickness=3.6e-08
+ $X=0.347 $Y=0.072 $X2=0.4515 $Y2=0.072
r28 39 13 4.43061 $w=1.3e-08 $l=1.9e-08 $layer=M1 $thickness=3.6e-08 $X=0.348
+ $Y=0.133 $X2=0.347 $Y2=0.116
r29 13 41 5.24677 $w=1.3e-08 $l=2.25e-08 $layer=M1 $thickness=3.6e-08 $X=0.347
+ $Y=0.116 $X2=0.347 $Y2=0.0935
r30 37 36 16.6668 $w=2.1e-08 $l=4.9e-08 $layer=Gate_1 $thickness=5.6e-08
+ $X=0.351 $Y=0.2025 $X2=0.351 $Y2=0.1535
r31 34 35 16.6668 $w=2.1e-08 $l=4.9e-08 $layer=Gate_1 $thickness=5.6e-08
+ $X=0.351 $Y=0.0675 $X2=0.351 $Y2=0.1165
r32 7 27 3.57145 $w=2e-08 $layer=Gate_1 $thickness=5.6e-08 $X=0.351 $Y=0.135
+ $X2=0.351 $Y2=0.135
r33 7 35 6.46262 $w=2.04595e-08 $l=1.85e-08 $layer=Gate_1 $thickness=5.6e-08
+ $X=0.351 $Y=0.135 $X2=0.351 $Y2=0.1165
r34 7 36 6.46262 $w=2.04595e-08 $l=1.85e-08 $layer=Gate_1 $thickness=5.6e-08
+ $X=0.351 $Y=0.135 $X2=0.351 $Y2=0.1535
r35 31 30 16.6668 $w=2.1e-08 $l=4.9e-08 $layer=Gate_1 $thickness=5.6e-08
+ $X=0.243 $Y=0.2025 $X2=0.243 $Y2=0.1535
r36 5 21 6.74717 $w=2e-08 $layer=Gate_1 $thickness=5.2e-08 $X=0.243 $Y=0.135
+ $X2=0.243 $Y2=0.135
r37 5 30 6.46262 $w=2.04595e-08 $l=1.85e-08 $layer=Gate_1 $thickness=5.6e-08
+ $X=0.243 $Y=0.135 $X2=0.243 $Y2=0.1535
r38 25 27 2.38179 $w=2e-08 $l=2.5e-09 $layer=LIG $thickness=4.8e-08 $X=0.3485
+ $Y=0.135 $X2=0.351 $Y2=0.135
r39 39 25 19.3796 $a=3.24e-16 $layer=V0LIG $X=0.348 $Y=0.133 $X2=0.3485
+ $Y2=0.135
r40 24 25 3.87634 $w=1.88833e-08 $l=9e-09 $layer=LIG $thickness=4.8e-08
+ $X=0.3395 $Y=0.135 $X2=0.3485 $Y2=0.135
r41 23 24 16.9382 $w=1.33e-08 $l=1.7e-08 $layer=LIG $thickness=4.8e-08
+ $X=0.3225 $Y=0.135 $X2=0.3395 $Y2=0.135
r42 20 21 20.114 $w=1.57815e-08 $l=2.7e-08 $layer=LIG $thickness=4.8e-08
+ $X=0.27 $Y=0.135 $X2=0.243 $Y2=0.135
r43 1 16 6.74717 $w=2e-08 $layer=Gate_1 $thickness=5.2e-08 $X=0.297 $Y=0.135
+ $X2=0.297 $Y2=0.135
r44 1 20 20.114 $w=1.57815e-08 $l=2.7e-08 $layer=LIG $thickness=4.8e-08
+ $X=0.297 $Y=0.135 $X2=0.27 $Y2=0.135
r45 1 23 18.6194 $w=1.59275e-08 $l=2.55e-08 $layer=LIG $thickness=4.8e-08
+ $X=0.297 $Y=0.135 $X2=0.3225 $Y2=0.135
r46 18 17 16.6668 $w=2.1e-08 $l=4.9e-08 $layer=Gate_1 $thickness=5.6e-08
+ $X=0.297 $Y=0.2025 $X2=0.297 $Y2=0.1535
r47 16 17 6.46262 $w=2.04595e-08 $l=1.85e-08 $layer=Gate_1 $thickness=5.6e-08
+ $X=0.297 $Y=0.135 $X2=0.297 $Y2=0.1535
r48 6 16 21.0886 $w=2.08374e-08 $l=6.15e-08 $layer=Gate_1 $thickness=5.6e-08
+ $X=0.297 $Y=0.0735 $X2=0.297 $Y2=0.135
.ends

.subckt PM_NOR3x2_ASAP7_75t_R%6__2 vss 16 17 30 31 34 35 10 2 1 11 12 3 13
c1 1 vss 0.00398705f $X=0.108 $Y=0.2025
c2 2 vss 0.0038384f $X=0.216 $Y=0.2025
c3 3 vss 0.00406247f $X=0.324 $Y=0.2025
c4 10 vss 0.00187368f $X=0.0935 $Y=0.2025
c5 11 vss 0.00188701f $X=0.2015 $Y=0.2025
c6 12 vss 0.00186019f $X=0.3095 $Y=0.2025
c7 13 vss 0.0181515f $X=0.2855 $Y=0.234
r1 35 33 0.0308642 $w=8.1e-08 $l=2.5e-09 $layer=P_src_drn $thickness=1e-09
+ $X=0.1253 $Y=0.2025 $X2=0.1225 $Y2=0.2025
r2 1 33 0.179012 $w=8.1e-08 $l=1.45e-08 $layer=P_src_drn $thickness=1e-09
+ $X=0.108 $Y=0.2025 $X2=0.1225 $Y2=0.2025
r3 10 1 0.179012 $w=8.1e-08 $l=1.45e-08 $layer=P_src_drn $thickness=1e-09
+ $X=0.0935 $Y=0.2025 $X2=0.108 $Y2=0.2025
r4 34 10 0.0308642 $w=8.1e-08 $l=2.5e-09 $layer=P_src_drn $thickness=1e-09
+ $X=0.0906 $Y=0.2025 $X2=0.0935 $Y2=0.2025
r5 31 29 0.0308642 $w=8.1e-08 $l=2.5e-09 $layer=P_src_drn $thickness=1e-09
+ $X=0.2333 $Y=0.2025 $X2=0.2305 $Y2=0.2025
r6 2 29 0.179012 $w=8.1e-08 $l=1.45e-08 $layer=P_src_drn $thickness=1e-09
+ $X=0.216 $Y=0.2025 $X2=0.2305 $Y2=0.2025
r7 11 2 0.179012 $w=8.1e-08 $l=1.45e-08 $layer=P_src_drn $thickness=1e-09
+ $X=0.2015 $Y=0.2025 $X2=0.216 $Y2=0.2025
r8 30 11 0.0308642 $w=8.1e-08 $l=2.5e-09 $layer=P_src_drn $thickness=1e-09
+ $X=0.1986 $Y=0.2025 $X2=0.2015 $Y2=0.2025
r9 1 26 19.3796 $a=3.24e-16 $layer=V0LISD $X=0.108 $Y=0.2025 $X2=0.108 $Y2=0.234
r10 2 20 19.3796 $a=3.24e-16 $layer=V0LISD $X=0.216 $Y=0.2025 $X2=0.218
+ $Y2=0.234
r11 26 27 8.97781 $w=1.3e-08 $l=3.85e-08 $layer=M1 $thickness=3.6e-08 $X=0.108
+ $Y=0.234 $X2=0.1465 $Y2=0.234
r12 24 27 8.74462 $w=1.3e-08 $l=3.75e-08 $layer=M1 $thickness=3.6e-08 $X=0.184
+ $Y=0.234 $X2=0.1465 $Y2=0.234
r13 22 23 2.2153 $w=1.3e-08 $l=9.5e-09 $layer=M1 $thickness=3.6e-08 $X=0.1995
+ $Y=0.234 $X2=0.209 $Y2=0.234
r14 22 24 3.61444 $w=1.3e-08 $l=1.55e-08 $layer=M1 $thickness=3.6e-08 $X=0.1995
+ $Y=0.234 $X2=0.184 $Y2=0.234
r15 20 21 5.24677 $w=1.3e-08 $l=2.25e-08 $layer=M1 $thickness=3.6e-08 $X=0.218
+ $Y=0.234 $X2=0.2405 $Y2=0.234
r16 20 23 2.09871 $w=1.3e-08 $l=9e-09 $layer=M1 $thickness=3.6e-08 $X=0.218
+ $Y=0.234 $X2=0.209 $Y2=0.234
r17 13 18 8.97781 $w=1.3e-08 $l=3.85e-08 $layer=M1 $thickness=3.6e-08 $X=0.2855
+ $Y=0.234 $X2=0.324 $Y2=0.234
r18 13 21 10.4935 $w=1.3e-08 $l=4.5e-08 $layer=M1 $thickness=3.6e-08 $X=0.2855
+ $Y=0.234 $X2=0.2405 $Y2=0.234
r19 3 18 19.3796 $a=3.24e-16 $layer=V0LISD $X=0.324 $Y=0.2025 $X2=0.324
+ $Y2=0.234
r20 17 15 0.0308642 $w=8.1e-08 $l=2.5e-09 $layer=P_src_drn $thickness=1e-09
+ $X=0.3413 $Y=0.2025 $X2=0.3385 $Y2=0.2025
r21 3 15 0.179012 $w=8.1e-08 $l=1.45e-08 $layer=P_src_drn $thickness=1e-09
+ $X=0.324 $Y=0.2025 $X2=0.3385 $Y2=0.2025
r22 12 3 0.179012 $w=8.1e-08 $l=1.45e-08 $layer=P_src_drn $thickness=1e-09
+ $X=0.3095 $Y=0.2025 $X2=0.324 $Y2=0.2025
r23 16 12 0.0308642 $w=8.1e-08 $l=2.5e-09 $layer=P_src_drn $thickness=1e-09
+ $X=0.3066 $Y=0.2025 $X2=0.3095 $Y2=0.2025
.ends

* End of included file NOR3x2_ASAP7_75t_R.pex.sp.pex

*
.subckt NOR3x2_ASAP7_75t_CUSTOM_4_25_0_7 VSS VDD A B C Y
*
* VSS VSS
* VDD VDD
* A A
* B B
* C C
* Y Y
*
*

M0 VSS N_M0_g N_M0_s VSS nmos_rvt L=2e-08 W=8.1e-08 nfin=3 $X=0.179 $Y=0.027
M1 N_M1_d N_M1_g VSS VSS nmos_rvt L=2e-08 W=8.1e-08 nfin=3 $X=0.341 $Y=0.027
M2 VSS N_M2_g N_M2_s VSS nmos_rvt L=2e-08 W=8.1e-08 nfin=3 $X=0.395 $Y=0.027
M3 VSS N_M3_g N_M3_s VSS nmos_rvt L=2e-08 W=8.1e-08 nfin=3 $X=0.665 $Y=0.027
M4 N_M4_d N_M4_g VSS VSS nmos_rvt L=2e-08 W=8.1e-08 nfin=3 $X=0.719 $Y=0.027
M5 VSS N_M5_g N_M5_s VSS nmos_rvt L=2e-08 W=8.1e-08 nfin=3 $X=0.881 $Y=0.027
M6 N_M6_d N_M6_g N_M6_s VDD pmos_rvt L=2e-08 W=8.1e-08 nfin=3 $X=0.071 $Y=0.162
M7 N_M7_d N_M7_g N_M7_s VDD pmos_rvt L=2e-08 W=8.1e-08 nfin=3 $X=0.125 $Y=0.162
M8 N_M8_d N_M8_g N_M8_s VDD pmos_rvt L=2e-08 W=8.1e-08 nfin=3 $X=0.179 $Y=0.162
M9 N_M9_d N_M9_g N_M9_s VDD pmos_rvt L=2e-08 W=8.1e-08 nfin=3 $X=0.233 $Y=0.162
M10 N_M10_d N_M10_g N_M10_s VDD pmos_rvt L=2e-08 W=8.1e-08 nfin=3 $X=0.287
+ $Y=0.162
M11 N_M11_d N_M11_g N_M11_s VDD pmos_rvt L=2e-08 W=8.1e-08 nfin=3 $X=0.341
+ $Y=0.162
M12 VDD N_M12_g N_M12_s VDD pmos_rvt L=2e-08 W=8.1e-08 nfin=3 $X=0.395 $Y=0.162
M13 VDD N_M13_g N_M13_s VDD pmos_rvt L=2e-08 W=8.1e-08 nfin=3 $X=0.449 $Y=0.162
M14 VDD N_M14_g N_M14_s VDD pmos_rvt L=2e-08 W=8.1e-08 nfin=3 $X=0.503 $Y=0.162
M15 VDD N_M15_g N_M15_s VDD pmos_rvt L=2e-08 W=8.1e-08 nfin=3 $X=0.557 $Y=0.162
M16 VDD N_M16_g N_M16_s VDD pmos_rvt L=2e-08 W=8.1e-08 nfin=3 $X=0.611 $Y=0.162
M17 VDD N_M17_g N_M17_s VDD pmos_rvt L=2e-08 W=8.1e-08 nfin=3 $X=0.665 $Y=0.162
M18 N_M18_d N_M18_g N_M18_s VDD pmos_rvt L=2e-08 W=8.1e-08 nfin=3 $X=0.719
+ $Y=0.162
M19 N_M19_d N_M19_g N_M19_s VDD pmos_rvt L=2e-08 W=8.1e-08 nfin=3 $X=0.773
+ $Y=0.162
M20 N_M20_d N_M20_g N_M20_s VDD pmos_rvt L=2e-08 W=8.1e-08 nfin=3 $X=0.827
+ $Y=0.162
M21 N_M21_d N_M21_g N_M21_s VDD pmos_rvt L=2e-08 W=8.1e-08 nfin=3 $X=0.881
+ $Y=0.162
M22 N_M22_d N_M22_g N_M22_s VDD pmos_rvt L=2e-08 W=8.1e-08 nfin=3 $X=0.935
+ $Y=0.162
M23 N_M23_d N_M23_g N_M23_s VDD pmos_rvt L=2e-08 W=8.1e-08 nfin=3 $X=0.989
+ $Y=0.162

* .include "NOR3x2_ASAP7_75t_R.pex.sp.pxi"

* Start of included file NOR3x2_ASAP7_75t_R.pex.sp.pxi
x_PM_NOR3x2_ASAP7_75t_R%7 vss N_M10_s N_M9_s N_M11_s N_M12_s N_M13_s N_M14_s
+ N_M15_s N_M16_s N_M17_s N_M18_s N_M19_s N_M20_s N_7_25 N_7_19 N_7_2 N_7_5
+ N_7_23 N_7_20 N_7_4 N_7_24 N_7_6 N_7_1 N_7_21 N_7_22 N_7_3
+ PM_NOR3x2_ASAP7_75t_R%7
cc_1 N_7_25 N_A_14 0.000313391f $X=0.2585 $Y=0.198
cc_2 N_7_25 N_A_2 0.000120294f $X=0.2585 $Y=0.198
cc_3 N_7_25 N_A_8 0.000150931f $X=0.2585 $Y=0.198
cc_4 N_7_25 N_A_7 0.000153707f $X=0.2585 $Y=0.198
cc_5 N_7_25 N_A_13 0.000165975f $X=0.2585 $Y=0.198
cc_6 N_7_25 N_A_15 0.0047914f $X=0.2585 $Y=0.198
cc_7 N_7_19 N_B_2 0.000202853f $X=0.2555 $Y=0.2025
cc_8 N_7_19 N_B_1 0.00312134f $X=0.2555 $Y=0.2025
cc_9 N_7_19 N_B_15 0.000276791f $X=0.2555 $Y=0.2025
cc_10 N_7_19 N_B_13 0.000280683f $X=0.2555 $Y=0.2025
cc_11 N_7_2 N_B_1 0.000385213f $X=0.378 $Y=0.2025
cc_12 N_7_5 N_B_2 0.000387913f $X=0.702 $Y=0.2025
cc_13 N_7_23 N_B_8 0.0325791f $X=0.6875 $Y=0.2025
cc_14 N_7_20 N_B_7 0.0325949f $X=0.3635 $Y=0.2025
cc_15 N_7_4 N_B_14 0.000661089f $X=0.594 $Y=0.2025
cc_16 N_7_5 N_B_8 0.000784668f $X=0.702 $Y=0.2025
cc_17 N_7_2 N_B_7 0.00078542f $X=0.378 $Y=0.2025
cc_18 N_7_24 N_B_10 0.0463339f $X=0.7955 $Y=0.2025
cc_19 N_7_6 N_B_9 0.00141138f $X=0.81 $Y=0.2025
cc_20 N_7_1 N_B_6 0.00141147f $X=0.27 $Y=0.2025
cc_21 N_7_24 N_B_2 0.00290212f $X=0.7955 $Y=0.2025
cc_22 N_7_25 N_B_15 0.003455f $X=0.2585 $Y=0.198
cc_23 N_7_25 N_B_13 0.00348468f $X=0.2585 $Y=0.198
cc_24 N_7_19 N_B_6 0.0179079f $X=0.2555 $Y=0.2025
cc_25 N_7_24 N_B_9 0.0179107f $X=0.7955 $Y=0.2025
cc_26 N_7_19 N_B_5 0.046736f $X=0.2555 $Y=0.2025
cc_27 N_7_21 N_C_1 0.00559367f $X=0.4715 $Y=0.2025
cc_28 N_7_21 N_C_3 0.000417858f $X=0.4715 $Y=0.2025
cc_29 N_7_23 N_C_8 0.0325602f $X=0.6875 $Y=0.2025
cc_30 N_7_5 N_C_8 0.000653716f $X=0.702 $Y=0.2025
cc_31 N_7_2 N_C_3 0.000655072f $X=0.378 $Y=0.2025
cc_32 N_7_21 N_C_5 0.0363631f $X=0.4715 $Y=0.2025
cc_33 N_7_22 N_C_6 0.0187072f $X=0.5795 $Y=0.2025
cc_34 N_7_3 N_C_5 0.00136264f $X=0.486 $Y=0.2025
cc_35 N_7_4 N_C_7 0.00145055f $X=0.594 $Y=0.2025
cc_36 N_7_25 N_C_9 0.00153854f $X=0.2585 $Y=0.198
cc_37 N_7_25 N_C_1 0.00230075f $X=0.2585 $Y=0.198
cc_38 N_7_20 N_C_3 0.0321283f $X=0.3635 $Y=0.2025
cc_39 N_7_22 N_C_7 0.0454085f $X=0.5795 $Y=0.2025
cc_40 N_7_21 N_C_4 0.0284789f $X=0.4715 $Y=0.2025
cc_41 N_7_19 N_6__2_13 0.000564822f $X=0.2555 $Y=0.2025
cc_42 N_7_1 N_6__2_13 0.000748624f $X=0.27 $Y=0.2025
cc_43 N_7_19 N_6__2_11 0.0010636f $X=0.2555 $Y=0.2025
cc_44 N_7_19 N_6__2_12 0.00107679f $X=0.2555 $Y=0.2025
cc_45 N_7_2 N_6__2_3 0.00109491f $X=0.378 $Y=0.2025
cc_46 N_7_1 N_6__2_3 0.00280175f $X=0.27 $Y=0.2025
cc_47 N_7_1 N_6__2_2 0.00378229f $X=0.27 $Y=0.2025
cc_48 N_7_25 N_6__2_13 0.00995301f $X=0.2585 $Y=0.198
x_PM_NOR3x2_ASAP7_75t_R%C vss C N_M2_g N_M12_g N_M13_g N_M14_g N_M15_g N_M16_g
+ N_M3_g N_M17_g N_C_9 N_C_1 N_C_3 N_C_8 N_C_5 N_C_6 N_C_7 N_C_4
+ PM_NOR3x2_ASAP7_75t_R%C
cc_49 N_C_9 N_B_15 0.000200973f $X=0.556 $Y=0.116
cc_50 N_C_9 N_B_13 0.00021955f $X=0.556 $Y=0.116
cc_51 N_C_1 N_B_1 0.000698041f $X=0.405 $Y=0.135
cc_52 N_C_1 N_B_2 0.000703049f $X=0.405 $Y=0.135
cc_53 N_C_1 N_B_14 0.00265841f $X=0.405 $Y=0.135
cc_54 N_C_3 N_B_7 0.00343225f $X=0.405 $Y=0.0245
cc_55 N_C_8 N_B_8 0.00343357f $X=0.675 $Y=0.135
cc_56 N_C_9 N_B_14 0.00542897f $X=0.556 $Y=0.116
x_PM_NOR3x2_ASAP7_75t_R%8 vss N_M18_d N_M19_d N_M20_d N_M21_s N_M22_s N_M23_s
+ N_8_12 N_8_2 N_8_3 N_8_11 N_8_10 N_8_1 N_8_13 PM_NOR3x2_ASAP7_75t_R%8
cc_57 N_8_12 N_A_15 0.000250361f $X=0.9575 $Y=0.2025
cc_58 N_8_12 N_A_8 0.000436888f $X=0.9575 $Y=0.2025
cc_59 N_8_12 N_A_14 0.0011062f $X=0.9575 $Y=0.2025
cc_60 N_8_12 N_A_9 0.0189016f $X=0.9575 $Y=0.2025
cc_61 N_8_2 N_A_8 0.00089843f $X=0.864 $Y=0.2025
cc_62 N_8_3 N_A_9 0.00146928f $X=0.972 $Y=0.2025
cc_63 N_8_12 N_A_2 0.00276221f $X=0.9575 $Y=0.2025
cc_64 N_8_11 N_A_8 0.0323057f $X=0.8495 $Y=0.2025
cc_65 N_8_12 N_A_10 0.045947f $X=0.9575 $Y=0.2025
cc_66 N_8_10 N_B_15 0.000265485f $X=0.7415 $Y=0.2025
cc_67 N_8_10 N_B_10 0.0010573f $X=0.7415 $Y=0.2025
cc_68 N_8_10 N_B_8 0.0189505f $X=0.7415 $Y=0.2025
cc_69 N_8_1 N_B_9 0.00157627f $X=0.756 $Y=0.2025
cc_70 N_8_10 N_B_2 0.00281436f $X=0.7415 $Y=0.2025
cc_71 N_8_11 N_B_10 0.0318813f $X=0.8495 $Y=0.2025
cc_72 N_8_10 N_B_9 0.0457866f $X=0.7415 $Y=0.2025
cc_73 N_8_13 N_7_24 0.000559819f $X=0.7445 $Y=0.234
cc_74 N_8_13 N_7_6 0.000748692f $X=0.7445 $Y=0.234
cc_75 N_8_11 N_7_24 0.0010636f $X=0.8495 $Y=0.2025
cc_76 N_8_10 N_7_24 0.00107655f $X=0.7415 $Y=0.2025
cc_77 N_8_2 N_7_6 0.00124813f $X=0.864 $Y=0.2025
cc_78 N_8_1 N_7_6 0.00252603f $X=0.756 $Y=0.2025
cc_79 N_8_1 N_7_5 0.00388904f $X=0.756 $Y=0.2025
cc_80 N_8_13 N_7_25 0.00991288f $X=0.7445 $Y=0.234
x_PM_NOR3x2_ASAP7_75t_R%A vss A N_M0_g N_M8_g N_M7_g N_M6_g N_M5_g N_M21_g
+ N_M22_g N_M23_g N_A_1 N_A_2 N_A_13 N_A_14 N_A_15 N_A_7 N_A_8 N_A_6 N_A_5
+ N_A_9 N_A_10 N_A_12 N_A_11 PM_NOR3x2_ASAP7_75t_R%A
x_PM_NOR3x2_ASAP7_75t_R%Y vss Y N_M0_s N_M1_d N_M2_s N_M3_s N_M4_d N_M5_s
+ N_M6_d N_M7_d N_M8_d N_M23_d N_M21_d N_M22_d N_Y_31 N_Y_6 N_Y_2 N_Y_38 N_Y_29
+ N_Y_32 N_Y_7 N_Y_3 N_Y_1 N_Y_8 N_Y_30 N_Y_37 N_Y_41 N_Y_25 N_Y_28 N_Y_40
+ N_Y_39 N_Y_26 N_Y_27 N_Y_4 N_Y_5 PM_NOR3x2_ASAP7_75t_R%Y
cc_81 N_Y_31 N_A_1 0.00010082f $X=0.9035 $Y=0.2025
cc_82 N_Y_31 N_A_2 0.0067132f $X=0.9035 $Y=0.2025
cc_83 N_Y_6 N_A_12 0.000365994f $X=0.918 $Y=0.0675
cc_84 N_Y_2 N_A_11 0.000382212f $X=0.162 $Y=0.0675
cc_85 N_Y_38 N_A_11 0.00276772f $X=0.0945 $Y=0.036
cc_86 N_Y_38 N_A_12 0.00269302f $X=0.0945 $Y=0.036
cc_87 N_Y_29 N_A_5 0.0345913f $X=0.056 $Y=0.2025
cc_88 N_Y_32 N_A_10 0.0345913f $X=1.0115 $Y=0.2025
cc_89 N_Y_7 N_A_14 0.000489767f $X=0.918 $Y=0.2025
cc_90 N_Y_3 N_A_13 0.000539611f $X=0.162 $Y=0.2025
cc_91 N_Y_7 N_A_2 0.000579812f $X=0.918 $Y=0.2025
cc_92 N_Y_2 N_A_1 0.000612326f $X=0.162 $Y=0.0675
cc_93 N_Y_1 N_A_5 0.000729364f $X=0.054 $Y=0.2025
cc_94 N_Y_8 N_A_10 0.000729364f $X=1.026 $Y=0.2025
cc_95 N_Y_30 N_A_6 0.06736f $X=0.1475 $Y=0.2025
cc_96 N_Y_37 N_A_1 0.00100324f $X=0.027 $Y=0.054
cc_97 N_Y_41 N_A_2 0.00103816f $X=1.053 $Y=0.054
cc_98 N_Y_25 N_A_7 0.0322265f $X=0.164 $Y=0.0675
cc_99 N_Y_28 N_A_8 0.0113989f $X=0.9035 $Y=0.0675
cc_100 N_Y_40 N_A_2 0.0013263f $X=1.0015 $Y=0.198
cc_101 N_Y_39 N_A_1 0.0013983f $X=0.0405 $Y=0.198
cc_102 N_Y_3 N_A_6 0.0015916f $X=0.162 $Y=0.2025
cc_103 N_Y_7 N_A_9 0.00166211f $X=0.918 $Y=0.2025
cc_104 N_Y_6 N_A_14 0.00172337f $X=0.918 $Y=0.0675
cc_105 N_Y_2 N_A_13 0.00189849f $X=0.162 $Y=0.0675
cc_106 N_Y_6 N_A_9 0.00267535f $X=0.918 $Y=0.0675
cc_107 N_Y_2 N_A_6 0.00272081f $X=0.162 $Y=0.0675
cc_108 N_Y_30 N_A_1 0.00635207f $X=0.1475 $Y=0.2025
cc_109 N_Y_38 N_A_15 0.0163812f $X=0.0945 $Y=0.036
cc_110 N_Y_31 N_A_8 0.0559994f $X=0.9035 $Y=0.2025
cc_111 N_Y_28 N_A_9 0.0208248f $X=0.9035 $Y=0.0675
cc_112 N_Y_30 N_A_7 0.0375477f $X=0.1475 $Y=0.2025
cc_113 N_Y_31 N_A_9 0.0492974f $X=0.9035 $Y=0.2025
cc_114 N_Y_26 N_B_1 0.00100583f $X=0.3635 $Y=0.0675
cc_115 N_Y_27 N_B_8 0.0336031f $X=0.6875 $Y=0.0675
cc_116 N_Y_4 N_B_14 0.000468703f $X=0.378 $Y=0.0675
cc_117 N_Y_5 N_B_14 0.000485427f $X=0.702 $Y=0.0675
cc_118 N_Y_5 N_B_15 0.000550868f $X=0.702 $Y=0.0675
cc_119 N_Y_4 N_B_13 0.000551598f $X=0.378 $Y=0.0675
cc_120 N_Y_27 N_B_2 0.000775462f $X=0.6875 $Y=0.0675
cc_121 N_Y_4 N_B_7 0.00158188f $X=0.378 $Y=0.0675
cc_122 N_Y_5 N_B_8 0.00158203f $X=0.702 $Y=0.0675
cc_123 N_Y_38 N_B_12 0.00792562f $X=0.0945 $Y=0.036
cc_124 N_Y_38 N_B_11 0.00807747f $X=0.0945 $Y=0.036
cc_125 N_Y_38 N_B_14 0.0129178f $X=0.0945 $Y=0.036
cc_126 N_Y_26 N_B_7 0.0338709f $X=0.3635 $Y=0.0675
cc_127 N_Y_5 N_C_8 0.000698623f $X=0.702 $Y=0.0675
cc_128 N_Y_4 N_C_3 0.000698685f $X=0.378 $Y=0.0675
cc_129 N_Y_38 N_C_1 0.00123542f $X=0.0945 $Y=0.036
cc_130 N_Y_26 N_C_3 0.0330779f $X=0.3635 $Y=0.0675
cc_131 N_Y_27 N_C_8 0.0341409f $X=0.6875 $Y=0.0675
cc_132 N_Y_1 N_6__2_13 0.000235238f $X=0.054 $Y=0.2025
cc_133 N_Y_29 N_6__2_13 0.000550747f $X=0.056 $Y=0.2025
cc_134 N_Y_30 N_6__2_13 0.000552546f $X=0.1475 $Y=0.2025
cc_135 N_Y_3 N_6__2_13 0.000699839f $X=0.162 $Y=0.2025
cc_136 N_Y_30 N_6__2_11 0.00106447f $X=0.1475 $Y=0.2025
cc_137 N_Y_30 N_6__2_10 0.00108988f $X=0.1475 $Y=0.2025
cc_138 N_Y_1 N_6__2_1 0.00117448f $X=0.054 $Y=0.2025
cc_139 N_Y_3 N_6__2_2 0.00120422f $X=0.162 $Y=0.2025
cc_140 N_Y_3 N_6__2_1 0.00550934f $X=0.162 $Y=0.2025
cc_141 N_Y_39 N_6__2_13 0.00955343f $X=0.0405 $Y=0.198
cc_142 N_Y_8 N_8_13 0.000235308f $X=1.026 $Y=0.2025
cc_143 N_Y_32 N_8_13 0.000550773f $X=1.0115 $Y=0.2025
cc_144 N_Y_31 N_8_13 0.000558079f $X=0.9035 $Y=0.2025
cc_145 N_Y_7 N_8_13 0.000702954f $X=0.918 $Y=0.2025
cc_146 N_Y_31 N_8_12 0.00215438f $X=0.9035 $Y=0.2025
cc_147 N_Y_7 N_8_2 0.00368961f $X=0.918 $Y=0.2025
cc_148 N_Y_8 N_8_3 0.00420701f $X=1.026 $Y=0.2025
cc_149 N_Y_40 N_8_13 0.0095954f $X=1.0015 $Y=0.198
x_PM_NOR3x2_ASAP7_75t_R%B vss B N_M10_g N_M9_g N_M1_g N_M11_g N_M4_g N_M18_g
+ N_M19_g N_M20_g N_B_1 N_B_2 N_B_11 N_B_12 N_B_15 N_B_5 N_B_10 N_B_13 N_B_14
+ N_B_7 N_B_8 N_B_6 N_B_9 PM_NOR3x2_ASAP7_75t_R%B
cc_150 N_B_1 N_A_1 0.00202969f $X=0.297 $Y=0.135
cc_151 N_B_2 N_A_2 0.00203819f $X=0.722 $Y=0.135
cc_152 N_B_1 N_A_13 0.000217792f $X=0.297 $Y=0.135
cc_153 N_B_2 N_A_14 0.00022962f $X=0.722 $Y=0.135
cc_154 N_B_11 N_A_15 0.000372538f $X=0.347 $Y=0.072
cc_155 N_B_12 N_A_15 0.000373155f $X=0.734 $Y=0.072
cc_156 N_B_15 N_A_15 0.00108214f $X=0.734 $Y=0.0935
cc_157 N_B_5 N_A_7 0.00343133f $X=0.243 $Y=0.135
cc_158 N_B_10 N_A_8 0.00343525f $X=0.837 $Y=0.135
cc_159 N_B_13 N_A_15 0.00452397f $X=0.347 $Y=0.116
cc_160 N_B_14 N_A_15 0.00827748f $X=0.4515 $Y=0.072
x_PM_NOR3x2_ASAP7_75t_R%6__2 vss N_M10_d N_M11_d N_M8_s N_M9_d N_M6_s N_M7_s
+ N_6__2_10 N_6__2_2 N_6__2_1 N_6__2_11 N_6__2_12 N_6__2_3 N_6__2_13
+ PM_NOR3x2_ASAP7_75t_R%6__2
cc_161 N_6__2_10 N_A_15 0.000257581f $X=0.0935 $Y=0.2025
cc_162 N_6__2_10 N_A_7 0.000436868f $X=0.0935 $Y=0.2025
cc_163 N_6__2_10 N_A_13 0.00116489f $X=0.0935 $Y=0.2025
cc_164 N_6__2_10 N_A_6 0.0188989f $X=0.0935 $Y=0.2025
cc_165 N_6__2_2 N_A_7 0.000869904f $X=0.216 $Y=0.2025
cc_166 N_6__2_1 N_A_5 0.00147199f $X=0.108 $Y=0.2025
cc_167 N_6__2_10 N_A_1 0.00277453f $X=0.0935 $Y=0.2025
cc_168 N_6__2_11 N_A_7 0.0323177f $X=0.2015 $Y=0.2025
cc_169 N_6__2_10 N_A_5 0.0459198f $X=0.0935 $Y=0.2025
cc_170 N_6__2_12 N_B_13 0.000279384f $X=0.3095 $Y=0.2025
cc_171 N_6__2_12 N_B_5 0.00106761f $X=0.3095 $Y=0.2025
cc_172 N_6__2_12 N_B_7 0.0366328f $X=0.3095 $Y=0.2025
cc_173 N_6__2_3 N_B_7 0.00158389f $X=0.324 $Y=0.2025
cc_174 N_6__2_12 N_B_1 0.00283308f $X=0.3095 $Y=0.2025
cc_175 N_6__2_11 N_B_5 0.0318618f $X=0.2015 $Y=0.2025
cc_176 N_6__2_12 N_B_6 0.0281418f $X=0.3095 $Y=0.2025

* End of included file NOR3x2_ASAP7_75t_R.pex.sp.pxi
.ends

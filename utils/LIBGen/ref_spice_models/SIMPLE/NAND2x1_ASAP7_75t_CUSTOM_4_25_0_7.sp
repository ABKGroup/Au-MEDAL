.subckt PM_NAND2x1_ASAP7_75t_R%A vss 21 9 25 28 4 6 3 1 7
c1 1 vss 0.00797913f $X=0.075 $Y=0.1345
c2 3 vss 0.0554308f $X=0.081 $Y=0.0245
c3 4 vss 0.0826721f $X=0.135 $Y=0.1345
c4 5 vss 0.00195327f $X=0.027 $Y=0.135
c5 6 vss 0.00948209f $X=0.027 $Y=0.116
c6 7 vss 0.0156995f $X=0.027 $Y=0.172
c7 8 vss 0.00404937f $X=0.0505 $Y=0.135
r1 5 23 1.38478 $w=1.70909e-08 $l=1.1e-08 $layer=M1 $thickness=3.6e-08 $X=0.027
+ $Y=0.135 $X2=0.038 $Y2=0.135
r2 5 6 3.2503 $w=1.53684e-08 $l=1.9e-08 $layer=M1 $thickness=3.6e-08 $X=0.027
+ $Y=0.135 $X2=0.027 $Y2=0.116
r3 5 7 7.44771 $w=1.42162e-08 $l=3.7e-08 $layer=M1 $thickness=3.6e-08 $X=0.027
+ $Y=0.135 $X2=0.027 $Y2=0.172
r4 28 27 16.4967 $w=2.1e-08 $l=4.85e-08 $layer=Gate_1 $thickness=5.6e-08
+ $X=0.135 $Y=0.2025 $X2=0.135 $Y2=0.154
r5 25 26 16.3266 $w=2.1e-08 $l=4.8e-08 $layer=Gate_1 $thickness=5.6e-08
+ $X=0.135 $Y=0.0675 $X2=0.135 $Y2=0.1155
r6 4 19 6.4735 $w=2.13953e-08 $layer=Gate_1 $thickness=5.22791e-08 $X=0.135
+ $Y=0.1345 $X2=0.135 $Y2=0.1345
r7 4 26 6.6582 $w=2.03947e-08 $l=1.9e-08 $layer=Gate_1 $thickness=5.6e-08
+ $X=0.135 $Y=0.1345 $X2=0.135 $Y2=0.1155
r8 4 27 6.82827 $w=2.04103e-08 $l=1.95e-08 $layer=Gate_1 $thickness=5.6e-08
+ $X=0.135 $Y=0.1345 $X2=0.135 $Y2=0.154
r9 21 8 4.5472 $w=1.3e-08 $l=1.95e-08 $layer=M1 $thickness=3.6e-08 $X=0.07
+ $Y=0.136 $X2=0.0505 $Y2=0.135
r10 8 23 2.91487 $w=1.3e-08 $l=1.25e-08 $layer=M1 $thickness=3.6e-08 $X=0.0505
+ $Y=0.135 $X2=0.038 $Y2=0.135
r11 18 19 10.1596 $w=1.87815e-08 $l=2.7e-08 $layer=LIG $thickness=4.8e-08
+ $X=0.108 $Y=0.1345 $X2=0.135 $Y2=0.1345
r12 21 17 19.3796 $a=3.24e-16 $layer=V0LIG $X=0.07 $Y=0.136 $X2=0.066 $Y2=0.1345
r13 15 18 9.21311 $w=1.80478e-08 $l=2.3e-08 $layer=LIG $thickness=4.8e-08
+ $X=0.085 $Y=0.1345 $X2=0.108 $Y2=0.1345
r14 1 15 2.36633 $w=2.3e-08 $l=1e-08 $layer=LIG $thickness=4.8e-08 $X=0.075
+ $Y=0.1345 $X2=0.085 $Y2=0.1345
r15 1 17 3.23868 $w=1.92778e-08 $l=9e-09 $layer=LIG $thickness=4.8e-08 $X=0.075
+ $Y=0.1345 $X2=0.066 $Y2=0.1345
r16 12 15 5.52696 $w=2.10286e-08 $l=4e-09 $layer=Gate_1 $thickness=5.32571e-08
+ $X=0.081 $Y=0.1345 $X2=0.085 $Y2=0.1345
r17 11 12 5.80786 $w=2.0303e-08 $l=1.65e-08 $layer=Gate_1 $thickness=5.6e-08
+ $X=0.081 $Y=0.118 $X2=0.081 $Y2=0.1345
r18 10 11 2.55104 $w=2.1e-08 $l=7.5e-09 $layer=Gate_1 $thickness=5.6e-08
+ $X=0.081 $Y=0.1105 $X2=0.081 $Y2=0.118
r19 9 10 14.6259 $w=2.1e-08 $l=4.3e-08 $layer=Gate_1 $thickness=5.6e-08
+ $X=0.081 $Y=0.0675 $X2=0.081 $Y2=0.1105
r20 9 3 14.6259 $w=2.1e-08 $l=4.3e-08 $layer=Gate_1 $thickness=5.6e-08 $X=0.081
+ $Y=0.0675 $X2=0.081 $Y2=0.0245
.ends

.subckt PM_NAND2x1_ASAP7_75t_R%5 vss 15 27 28 30 13 1 10 11 12 3 2
c1 1 vss 0.00836002f $X=0.054 $Y=0.0675
c2 2 vss 0.0066111f $X=0.162 $Y=0.0675
c3 3 vss 0.00605762f $X=0.27 $Y=0.0675
c4 10 vss 0.0370375f $X=0.056 $Y=0.0675
c5 11 vss 0.00317659f $X=0.1475 $Y=0.0675
c6 12 vss 0.0358396f $X=0.2555 $Y=0.0675
c7 13 vss 0.0212857f $X=0.0425 $Y=0.036
r1 12 3 0.154321 $w=8.1e-08 $l=1.25e-08 $layer=N_src_drn $thickness=1e-09
+ $X=0.2555 $Y=0.0675 $X2=0.27 $Y2=0.0675
r2 30 12 0.0308642 $w=8.1e-08 $l=2.5e-09 $layer=N_src_drn $thickness=1e-09
+ $X=0.2526 $Y=0.0675 $X2=0.2555 $Y2=0.0675
r3 28 26 0.0308642 $w=8.1e-08 $l=2.5e-09 $layer=N_src_drn $thickness=1e-09
+ $X=0.1793 $Y=0.0675 $X2=0.1765 $Y2=0.0675
r4 2 26 0.179012 $w=8.1e-08 $l=1.45e-08 $layer=N_src_drn $thickness=1e-09
+ $X=0.162 $Y=0.0675 $X2=0.1765 $Y2=0.0675
r5 11 2 0.179012 $w=8.1e-08 $l=1.45e-08 $layer=N_src_drn $thickness=1e-09
+ $X=0.1475 $Y=0.0675 $X2=0.162 $Y2=0.0675
r6 27 11 0.0308642 $w=8.1e-08 $l=2.5e-09 $layer=N_src_drn $thickness=1e-09
+ $X=0.1446 $Y=0.0675 $X2=0.1475 $Y2=0.0675
r7 3 23 19.3796 $a=3.24e-16 $layer=V0LISD $X=0.27 $Y=0.0675 $X2=0.27 $Y2=0.036
r8 2 20 19.3796 $a=3.24e-16 $layer=V0LISD $X=0.162 $Y=0.0675 $X2=0.162 $Y2=0.036
r9 22 23 8.97781 $w=1.3e-08 $l=3.85e-08 $layer=M1 $thickness=3.6e-08 $X=0.2315
+ $Y=0.036 $X2=0.27 $Y2=0.036
r10 21 22 10.4935 $w=1.3e-08 $l=4.5e-08 $layer=M1 $thickness=3.6e-08 $X=0.1865
+ $Y=0.036 $X2=0.2315 $Y2=0.036
r11 20 21 5.71315 $w=1.3e-08 $l=2.45e-08 $layer=M1 $thickness=3.6e-08 $X=0.162
+ $Y=0.036 $X2=0.1865 $Y2=0.036
r12 19 20 8.97781 $w=1.3e-08 $l=3.85e-08 $layer=M1 $thickness=3.6e-08 $X=0.1235
+ $Y=0.036 $X2=0.162 $Y2=0.036
r13 18 19 8.04505 $w=1.3e-08 $l=3.45e-08 $layer=M1 $thickness=3.6e-08 $X=0.089
+ $Y=0.036 $X2=0.1235 $Y2=0.036
r14 17 18 3.61444 $w=1.3e-08 $l=1.55e-08 $layer=M1 $thickness=3.6e-08 $X=0.0735
+ $Y=0.036 $X2=0.089 $Y2=0.036
r15 16 17 4.5472 $w=1.3e-08 $l=1.95e-08 $layer=M1 $thickness=3.6e-08 $X=0.054
+ $Y=0.036 $X2=0.0735 $Y2=0.036
r16 13 16 2.68168 $w=1.3e-08 $l=1.15e-08 $layer=M1 $thickness=3.6e-08 $X=0.0425
+ $Y=0.036 $X2=0.054 $Y2=0.036
r17 1 16 19.3796 $a=3.24e-16 $layer=V0LISD $X=0.054 $Y=0.0675 $X2=0.054
+ $Y2=0.036
r18 15 14 0.0308642 $w=8.1e-08 $l=2.5e-09 $layer=N_src_drn $thickness=1e-09
+ $X=0.0713 $Y=0.0675 $X2=0.0685 $Y2=0.0675
r19 10 14 0.154321 $w=8.1e-08 $l=1.25e-08 $layer=N_src_drn $thickness=1e-09
+ $X=0.056 $Y=0.0675 $X2=0.0685 $Y2=0.0675
r20 1 10 1e-05 $l=2e-09 $X=0.054 $Y=0.0675 $X2=0.056 $Y2=0.0675
.ends

.subckt PM_NAND2x1_ASAP7_75t_R%Y vss 28 20 21 39 41 11 1 10 12 15 2 3 17 16
c1 1 vss 0.00740316f $X=0.108 $Y=0.2025
c2 2 vss 0.00289832f $X=0.216 $Y=0.0675
c3 3 vss 0.0070915f $X=0.216 $Y=0.2025
c4 10 vss 0.00192888f $X=0.2015 $Y=0.0675
c5 11 vss 0.00327609f $X=0.11 $Y=0.2025
c6 12 vss 0.00333239f $X=0.2015 $Y=0.2025
c7 13 vss 0.00104782f $X=0.297 $Y=0.072
c8 14 vss 0.00277197f $X=0.297 $Y=0.234
c9 15 vss 0.0167414f $X=0.27 $Y=0.234
c10 16 vss 0.000986729f $X=0.2045 $Y=0.072
c11 17 vss 0.00375609f $X=0.297 $Y=0.0935
r1 41 40 0.0308642 $w=8.1e-08 $l=2.5e-09 $layer=P_src_drn $thickness=1e-09
+ $X=0.1253 $Y=0.2025 $X2=0.1225 $Y2=0.2025
r2 11 40 0.154321 $w=8.1e-08 $l=1.25e-08 $layer=P_src_drn $thickness=1e-09
+ $X=0.11 $Y=0.2025 $X2=0.1225 $Y2=0.2025
r3 12 3 0.154321 $w=8.1e-08 $l=1.25e-08 $layer=P_src_drn $thickness=1e-09
+ $X=0.2015 $Y=0.2025 $X2=0.216 $Y2=0.2025
r4 39 12 0.0308642 $w=8.1e-08 $l=2.5e-09 $layer=P_src_drn $thickness=1e-09
+ $X=0.1986 $Y=0.2025 $X2=0.2015 $Y2=0.2025
r5 1 36 19.3796 $a=3.24e-16 $layer=V0LISD $X=0.108 $Y=0.2025 $X2=0.108 $Y2=0.234
r6 3 33 19.3796 $a=3.24e-16 $layer=V0LISD $X=0.216 $Y=0.2025 $X2=0.216 $Y2=0.234
r7 36 37 12.0093 $w=1.3e-08 $l=5.15e-08 $layer=M1 $thickness=3.6e-08 $X=0.108
+ $Y=0.234 $X2=0.1595 $Y2=0.234
r8 33 34 3.14806 $w=1.3e-08 $l=1.35e-08 $layer=M1 $thickness=3.6e-08 $X=0.216
+ $Y=0.234 $X2=0.2295 $Y2=0.234
r9 32 33 2.68168 $w=1.3e-08 $l=1.15e-08 $layer=M1 $thickness=3.6e-08 $X=0.2045
+ $Y=0.234 $X2=0.216 $Y2=0.234
r10 32 37 10.4935 $w=1.3e-08 $l=4.5e-08 $layer=M1 $thickness=3.6e-08 $X=0.2045
+ $Y=0.234 $X2=0.1595 $Y2=0.234
r11 31 34 3.14806 $w=1.3e-08 $l=1.35e-08 $layer=M1 $thickness=3.6e-08 $X=0.243
+ $Y=0.234 $X2=0.2295 $Y2=0.234
r12 15 31 6.29612 $w=1.3e-08 $l=2.7e-08 $layer=M1 $thickness=3.6e-08 $X=0.27
+ $Y=0.234 $X2=0.243 $Y2=0.234
r13 14 30 3.36447 $w=1.71023e-08 $l=2.15e-08 $layer=M1 $thickness=3.6e-08
+ $X=0.297 $Y=0.234 $X2=0.297 $Y2=0.2125
r14 14 15 4.64701 $w=1.46667e-08 $l=2.7e-08 $layer=M1 $thickness=3.6e-08
+ $X=0.297 $Y=0.234 $X2=0.27 $Y2=0.234
r15 29 30 9.26929 $w=1.3e-08 $l=3.98e-08 $layer=M1 $thickness=3.6e-08 $X=0.297
+ $Y=0.1727 $X2=0.297 $Y2=0.2125
r16 28 29 6.47102 $w=1.3e-08 $l=2.77e-08 $layer=M1 $thickness=3.6e-08 $X=0.298
+ $Y=0.145 $X2=0.297 $Y2=0.1727
r17 28 27 4.6055 $w=1.3e-08 $l=1.98e-08 $layer=M1 $thickness=3.6e-08 $X=0.298
+ $Y=0.145 $X2=0.297 $Y2=0.1252
r18 17 27 7.40377 $w=1.3e-08 $l=3.17e-08 $layer=M1 $thickness=3.6e-08 $X=0.297
+ $Y=0.0935 $X2=0.297 $Y2=0.1252
r19 13 26 0.915974 $w=1.70909e-08 $l=1.1e-08 $layer=M1 $thickness=3.6e-08
+ $X=0.297 $Y=0.072 $X2=0.286 $Y2=0.072
r20 13 17 3.36447 $w=1.71023e-08 $l=2.15e-08 $layer=M1 $thickness=3.6e-08
+ $X=0.297 $Y=0.072 $X2=0.297 $Y2=0.0935
r21 25 26 4.19742 $w=1.3e-08 $l=1.8e-08 $layer=M1 $thickness=3.6e-08 $X=0.268
+ $Y=0.072 $X2=0.286 $Y2=0.072
r22 24 25 5.82974 $w=1.3e-08 $l=2.5e-08 $layer=M1 $thickness=3.6e-08 $X=0.243
+ $Y=0.072 $X2=0.268 $Y2=0.072
r23 23 24 3.14806 $w=1.3e-08 $l=1.35e-08 $layer=M1 $thickness=3.6e-08 $X=0.2295
+ $Y=0.072 $X2=0.243 $Y2=0.072
r24 22 23 3.14806 $w=1.3e-08 $l=1.35e-08 $layer=M1 $thickness=3.6e-08 $X=0.216
+ $Y=0.072 $X2=0.2295 $Y2=0.072
r25 16 22 2.68168 $w=1.3e-08 $l=1.15e-08 $layer=M1 $thickness=3.6e-08 $X=0.2045
+ $Y=0.072 $X2=0.216 $Y2=0.072
r26 2 22 19.3796 $a=3.24e-16 $layer=V0LISD $X=0.216 $Y=0.0675 $X2=0.216
+ $Y2=0.072
r27 21 19 0.0308642 $w=8.1e-08 $l=2.5e-09 $layer=N_src_drn $thickness=1e-09
+ $X=0.2333 $Y=0.0675 $X2=0.2305 $Y2=0.0675
r28 2 19 0.179012 $w=8.1e-08 $l=1.45e-08 $layer=N_src_drn $thickness=1e-09
+ $X=0.216 $Y=0.0675 $X2=0.2305 $Y2=0.0675
r29 10 2 0.179012 $w=8.1e-08 $l=1.45e-08 $layer=N_src_drn $thickness=1e-09
+ $X=0.2015 $Y=0.0675 $X2=0.216 $Y2=0.0675
r30 20 10 0.0308642 $w=8.1e-08 $l=2.5e-09 $layer=N_src_drn $thickness=1e-09
+ $X=0.1986 $Y=0.0675 $X2=0.2015 $Y2=0.0675
r31 1 11 1e-05 $l=2e-09 $X=0.108 $Y=0.2025 $X2=0.11 $Y2=0.2025
.ends

.subckt PM_NAND2x1_ASAP7_75t_R%B vss 26 6 10 20 3 1 4 5
c1 1 vss 0.0142986f $X=0.189 $Y=0.135
c2 3 vss 0.0495998f $X=0.189 $Y=0.0245
c3 4 vss 0.0231402f $X=0.243 $Y=0.135
c4 5 vss 0.00719193f $X=0.243 $Y=0.135
r1 26 25 0.991056 $w=1.3e-08 $l=4.3e-09 $layer=M1 $thickness=3.6e-08 $X=0.24
+ $Y=0.152 $X2=0.243 $Y2=0.1477
r2 5 15 19.3796 $a=3.24e-16 $layer=V0LIG $X=0.243 $Y=0.135 $X2=0.243 $Y2=0.135
r3 5 25 2.97317 $w=1.3e-08 $l=1.27e-08 $layer=M1 $thickness=3.6e-08 $X=0.243
+ $Y=0.135 $X2=0.243 $Y2=0.1477
r4 20 21 14.6259 $w=2.1e-08 $l=4.3e-08 $layer=Gate_1 $thickness=5.6e-08
+ $X=0.243 $Y=0.0675 $X2=0.243 $Y2=0.1105
r5 18 21 2.7211 $w=2.1e-08 $l=8e-09 $layer=Gate_1 $thickness=5.6e-08 $X=0.243
+ $Y=0.1185 $X2=0.243 $Y2=0.1105
r6 4 15 6.27904 $w=2.09e-08 $layer=Gate_1 $thickness=5.24e-08 $X=0.243 $Y=0.135
+ $X2=0.243 $Y2=0.135
r7 4 18 5.79936 $w=2.03333e-08 $l=1.65e-08 $layer=Gate_1 $thickness=5.6e-08
+ $X=0.243 $Y=0.135 $X2=0.243 $Y2=0.1185
r8 14 15 2.48102 $w=2.2e-08 $l=9.5e-09 $layer=LIG $thickness=4.8e-08 $X=0.2335
+ $Y=0.135 $X2=0.243 $Y2=0.135
r9 13 14 10.1729 $w=1.54914e-08 $l=1.75e-08 $layer=LIG $thickness=4.8e-08
+ $X=0.216 $Y=0.135 $X2=0.2335 $Y2=0.135
r10 1 8 6.54019 $w=2.09524e-08 $layer=Gate_1 $thickness=5.21905e-08 $X=0.189
+ $Y=0.135 $X2=0.189 $Y2=0.135
r11 1 13 12.6539 $w=1.77815e-08 $l=2.7e-08 $layer=LIG $thickness=4.8e-08
+ $X=0.189 $Y=0.135 $X2=0.216 $Y2=0.135
r12 10 9 16.4967 $w=2.1e-08 $l=4.85e-08 $layer=Gate_1 $thickness=5.6e-08
+ $X=0.189 $Y=0.2025 $X2=0.189 $Y2=0.154
r13 8 9 6.6497 $w=2.04211e-08 $l=1.9e-08 $layer=Gate_1 $thickness=5.6e-08
+ $X=0.189 $Y=0.135 $X2=0.189 $Y2=0.154
r14 7 8 6.6497 $w=2.04211e-08 $l=1.9e-08 $layer=Gate_1 $thickness=5.6e-08
+ $X=0.189 $Y=0.116 $X2=0.189 $Y2=0.135
r15 6 7 16.4967 $w=2.1e-08 $l=4.85e-08 $layer=Gate_1 $thickness=5.6e-08
+ $X=0.189 $Y=0.0675 $X2=0.189 $Y2=0.116
r16 6 3 14.6259 $w=2.1e-08 $l=4.3e-08 $layer=Gate_1 $thickness=5.6e-08 $X=0.189
+ $Y=0.0675 $X2=0.189 $Y2=0.0245
.ends

* End of included file NAND2x1_ASAP7_75t_R.pex.sp.pex

*
.subckt NAND2x1_ASAP7_75t_CUSTOM_4_25_0_7 VSS VDD A B Y
*
* VSS VSS
* VDD VDD
* A A
* B B
* Y Y
*
*

M0 VSS N_M0_g N_M0_s VSS nmos_rvt L=2e-08 W=8.1e-08 nfin=3 $X=0.071 $Y=0.027
M1 VSS N_M1_g N_M1_s VSS nmos_rvt L=2e-08 W=8.1e-08 nfin=3 $X=0.125 $Y=0.027
M2 N_M2_d N_M2_g N_M2_s VSS nmos_rvt L=2e-08 W=8.1e-08 nfin=3 $X=0.179 $Y=0.027
M3 N_M3_d N_M3_g N_M3_s VSS nmos_rvt L=2e-08 W=8.1e-08 nfin=3 $X=0.233 $Y=0.027
M4 VDD N_M4_g N_M4_s VDD pmos_rvt L=2e-08 W=8.1e-08 nfin=3 $X=0.125 $Y=0.162
M5 N_M5_d N_M5_g VDD VDD pmos_rvt L=2e-08 W=8.1e-08 nfin=3 $X=0.179 $Y=0.162

* .include "NAND2x1_ASAP7_75t_R.pex.sp.pxi"

* Start of included file NAND2x1_ASAP7_75t_R.pex.sp.pxi
x_PM_NAND2x1_ASAP7_75t_R%A vss A N_M0_g N_M1_g N_M4_g N_A_4 N_A_6 N_A_3 N_A_1
+ N_A_7 PM_NAND2x1_ASAP7_75t_R%A
x_PM_NAND2x1_ASAP7_75t_R%5 vss N_M0_s N_M1_s N_M2_s N_M3_s N_5_13 N_5_1 N_5_10
+ N_5_11 N_5_12 N_5_3 N_5_2 PM_NAND2x1_ASAP7_75t_R%5
cc_1 N_5_13 N_A_6 0.00158138f $X=0.0425 $Y=0.036
cc_2 N_5_1 N_A_3 0.00196846f $X=0.054 $Y=0.0675
cc_3 N_5_10 N_A_1 0.00227523f $X=0.056 $Y=0.0675
cc_4 N_5_10 N_A_3 0.0335579f $X=0.056 $Y=0.0675
cc_5 N_5_11 N_A_4 0.0376505f $X=0.1475 $Y=0.0675
cc_6 N_5_12 N_B_1 0.00186721f $X=0.2555 $Y=0.0675
cc_7 N_5_11 N_B_3 0.0330593f $X=0.1475 $Y=0.0675
cc_8 N_5_12 N_B_4 0.036966f $X=0.2555 $Y=0.0675
x_PM_NAND2x1_ASAP7_75t_R%Y vss Y N_M2_d N_M3_d N_M5_d N_M4_s N_Y_11 N_Y_1
+ N_Y_10 N_Y_12 N_Y_15 N_Y_2 N_Y_3 N_Y_17 N_Y_16 PM_NAND2x1_ASAP7_75t_R%Y
cc_9 N_Y_11 N_A_7 0.000734705f $X=0.11 $Y=0.2025
cc_10 N_Y_11 N_A_4 0.0305065f $X=0.11 $Y=0.2025
cc_11 N_Y_1 N_A_4 0.00236262f $X=0.108 $Y=0.2025
cc_12 N_Y_11 N_A_1 0.00268991f $X=0.11 $Y=0.2025
cc_13 N_Y_11 N_A_3 0.0418504f $X=0.11 $Y=0.2025
cc_14 N_Y_10 N_B_5 0.0010972f $X=0.2015 $Y=0.0675
cc_15 N_Y_12 N_B_3 0.0321232f $X=0.2015 $Y=0.2025
cc_16 N_Y_15 N_B_5 0.00130453f $X=0.27 $Y=0.234
cc_17 N_Y_2 N_B_4 0.00164456f $X=0.216 $Y=0.0675
cc_18 N_Y_3 N_B_4 0.00234629f $X=0.216 $Y=0.2025
cc_19 N_Y_10 N_B_1 0.00500398f $X=0.2015 $Y=0.0675
cc_20 N_Y_17 N_B_5 0.00713862f $X=0.297 $Y=0.0935
cc_21 N_Y_10 N_B_4 0.0373951f $X=0.2015 $Y=0.0675
cc_22 N_Y_10 N_B_3 0.0688816f $X=0.2015 $Y=0.0675
cc_23 N_Y_10 N_5_13 0.000797545f $X=0.2015 $Y=0.0675
cc_24 N_Y_10 N_5_12 0.00110041f $X=0.2015 $Y=0.0675
cc_25 N_Y_2 N_5_3 0.00225501f $X=0.216 $Y=0.0675
cc_26 N_Y_2 N_5_2 0.00402159f $X=0.216 $Y=0.0675
cc_27 N_Y_16 N_5_13 0.0117273f $X=0.2045 $Y=0.072
x_PM_NAND2x1_ASAP7_75t_R%B vss B N_M2_g N_M5_g N_M3_g N_B_3 N_B_1 N_B_4 N_B_5
+ PM_NAND2x1_ASAP7_75t_R%B
cc_28 N_B_3 N_A_4 0.00507455f $X=0.189 $Y=0.0245

* End of included file NAND2x1_ASAP7_75t_R.pex.sp.pxi
.ends

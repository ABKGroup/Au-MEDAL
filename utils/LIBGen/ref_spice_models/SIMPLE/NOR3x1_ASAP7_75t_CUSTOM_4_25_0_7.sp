.subckt PM_NOR3x1_ASAP7_75t_R%6 vss 16 17 31 32 35 36 10 13 1 11 12 3 2
c1 1 vss 0.00921756f $X=0.108 $Y=0.2025
c2 2 vss 0.00586496f $X=0.216 $Y=0.2025
c3 3 vss 0.00298625f $X=0.324 $Y=0.2025
c4 10 vss 0.00412692f $X=0.0935 $Y=0.2025
c5 11 vss 0.00318614f $X=0.2015 $Y=0.2025
c6 12 vss 0.00188819f $X=0.3095 $Y=0.2025
c7 13 vss 0.0118315f $X=0.0965 $Y=0.198
r1 36 34 0.0308642 $w=8.1e-08 $l=2.5e-09 $layer=P_src_drn $thickness=1e-09
+ $X=0.3413 $Y=0.2025 $X2=0.3385 $Y2=0.2025
r2 3 34 0.179012 $w=8.1e-08 $l=1.45e-08 $layer=P_src_drn $thickness=1e-09
+ $X=0.324 $Y=0.2025 $X2=0.3385 $Y2=0.2025
r3 12 3 0.179012 $w=8.1e-08 $l=1.45e-08 $layer=P_src_drn $thickness=1e-09
+ $X=0.3095 $Y=0.2025 $X2=0.324 $Y2=0.2025
r4 35 12 0.0308642 $w=8.1e-08 $l=2.5e-09 $layer=P_src_drn $thickness=1e-09
+ $X=0.3066 $Y=0.2025 $X2=0.3095 $Y2=0.2025
r5 32 30 0.0308642 $w=8.1e-08 $l=2.5e-09 $layer=P_src_drn $thickness=1e-09
+ $X=0.2333 $Y=0.2025 $X2=0.2305 $Y2=0.2025
r6 2 30 0.179012 $w=8.1e-08 $l=1.45e-08 $layer=P_src_drn $thickness=1e-09
+ $X=0.216 $Y=0.2025 $X2=0.2305 $Y2=0.2025
r7 11 2 0.179012 $w=8.1e-08 $l=1.45e-08 $layer=P_src_drn $thickness=1e-09
+ $X=0.2015 $Y=0.2025 $X2=0.216 $Y2=0.2025
r8 31 11 0.0308642 $w=8.1e-08 $l=2.5e-09 $layer=P_src_drn $thickness=1e-09
+ $X=0.1986 $Y=0.2025 $X2=0.2015 $Y2=0.2025
r9 3 27 19.3796 $a=3.24e-16 $layer=V0LISD $X=0.324 $Y=0.2025 $X2=0.324 $Y2=0.198
r10 2 22 19.3796 $a=3.24e-16 $layer=V0LISD $X=0.216 $Y=0.2025 $X2=0.216
+ $Y2=0.198
r11 26 27 3.14806 $w=1.3e-08 $l=1.35e-08 $layer=M1 $thickness=3.6e-08 $X=0.3105
+ $Y=0.198 $X2=0.324 $Y2=0.198
r12 25 26 6.8791 $w=1.3e-08 $l=2.95e-08 $layer=M1 $thickness=3.6e-08 $X=0.281
+ $Y=0.198 $X2=0.3105 $Y2=0.198
r13 24 25 8.39483 $w=1.3e-08 $l=3.6e-08 $layer=M1 $thickness=3.6e-08 $X=0.245
+ $Y=0.198 $X2=0.281 $Y2=0.198
r14 23 24 3.61444 $w=1.3e-08 $l=1.55e-08 $layer=M1 $thickness=3.6e-08 $X=0.2295
+ $Y=0.198 $X2=0.245 $Y2=0.198
r15 22 23 3.14806 $w=1.3e-08 $l=1.35e-08 $layer=M1 $thickness=3.6e-08 $X=0.216
+ $Y=0.198 $X2=0.2295 $Y2=0.198
r16 21 22 2.68168 $w=1.3e-08 $l=1.15e-08 $layer=M1 $thickness=3.6e-08 $X=0.2045
+ $Y=0.198 $X2=0.216 $Y2=0.198
r17 20 21 3.61444 $w=1.3e-08 $l=1.55e-08 $layer=M1 $thickness=3.6e-08 $X=0.189
+ $Y=0.198 $X2=0.2045 $Y2=0.198
r18 19 20 9.91056 $w=1.3e-08 $l=4.25e-08 $layer=M1 $thickness=3.6e-08 $X=0.1465
+ $Y=0.198 $X2=0.189 $Y2=0.198
r19 18 19 8.97781 $w=1.3e-08 $l=3.85e-08 $layer=M1 $thickness=3.6e-08 $X=0.108
+ $Y=0.198 $X2=0.1465 $Y2=0.198
r20 13 18 2.68168 $w=1.3e-08 $l=1.15e-08 $layer=M1 $thickness=3.6e-08 $X=0.0965
+ $Y=0.198 $X2=0.108 $Y2=0.198
r21 1 18 19.3796 $a=3.24e-16 $layer=V0LISD $X=0.108 $Y=0.2025 $X2=0.108
+ $Y2=0.198
r22 17 15 0.0308642 $w=8.1e-08 $l=2.5e-09 $layer=P_src_drn $thickness=1e-09
+ $X=0.1253 $Y=0.2025 $X2=0.1225 $Y2=0.2025
r23 1 15 0.179012 $w=8.1e-08 $l=1.45e-08 $layer=P_src_drn $thickness=1e-09
+ $X=0.108 $Y=0.2025 $X2=0.1225 $Y2=0.2025
r24 10 1 0.179012 $w=8.1e-08 $l=1.45e-08 $layer=P_src_drn $thickness=1e-09
+ $X=0.0935 $Y=0.2025 $X2=0.108 $Y2=0.2025
r25 16 10 0.0308642 $w=8.1e-08 $l=2.5e-09 $layer=P_src_drn $thickness=1e-09
+ $X=0.0906 $Y=0.2025 $X2=0.0935 $Y2=0.2025
.ends

.subckt PM_NOR3x1_ASAP7_75t_R%C vss 38 12 16 29 35 1 5 11 3 4
c1 1 vss 0.0159335f $X=0.189 $Y=0.135
c2 3 vss 0.0568994f $X=0.081 $Y=0.135
c3 4 vss 0.0886321f $X=0.135 $Y=0.135
c4 5 vss 0.0821542f $X=0.189 $Y=0.0245
c5 6 vss 0.00993003f $X=0.027 $Y=0.036
c6 7 vss 0.00229482f $X=0.027 $Y=0.135
c7 8 vss 0.00917327f $X=0.027 $Y=0.198
c8 9 vss 0.0122151f $X=0.027 $Y=0.1035
c9 10 vss 0.00675239f $X=0.027 $Y=0.1485
c10 11 vss 0.00423136f $X=0.0455 $Y=0.135
r1 8 43 3.01711 $w=1.55e-08 $l=1.8e-08 $layer=M1 $thickness=3.6e-08 $X=0.027
+ $Y=0.198 $X2=0.027 $Y2=0.18
r2 6 41 3.01711 $w=1.55e-08 $l=1.8e-08 $layer=M1 $thickness=3.6e-08 $X=0.027
+ $Y=0.036 $X2=0.027 $Y2=0.054
r3 42 43 4.19742 $w=1.3e-08 $l=1.8e-08 $layer=M1 $thickness=3.6e-08 $X=0.027
+ $Y=0.162 $X2=0.027 $Y2=0.18
r4 10 42 3.14806 $w=1.3e-08 $l=1.35e-08 $layer=M1 $thickness=3.6e-08 $X=0.027
+ $Y=0.1485 $X2=0.027 $Y2=0.162
r5 40 41 4.19742 $w=1.3e-08 $l=1.8e-08 $layer=M1 $thickness=3.6e-08 $X=0.027
+ $Y=0.072 $X2=0.027 $Y2=0.054
r6 9 40 7.34548 $w=1.3e-08 $l=3.15e-08 $layer=M1 $thickness=3.6e-08 $X=0.027
+ $Y=0.1035 $X2=0.027 $Y2=0.072
r7 7 11 3.1337 $w=1.54324e-08 $l=1.85e-08 $layer=M1 $thickness=3.6e-08 $X=0.027
+ $Y=0.135 $X2=0.0455 $Y2=0.135
r8 7 9 6.16517 $w=1.44286e-08 $l=3.15e-08 $layer=M1 $thickness=3.6e-08 $X=0.027
+ $Y=0.135 $X2=0.027 $Y2=0.1035
r9 7 10 1.96775 $w=1.63333e-08 $l=1.35e-08 $layer=M1 $thickness=3.6e-08
+ $X=0.027 $Y=0.135 $X2=0.027 $Y2=0.1485
r10 38 37 2.79828 $w=1.3e-08 $l=1.2e-08 $layer=M1 $thickness=3.6e-08 $X=0.069
+ $Y=0.133 $X2=0.058 $Y2=0.135
r11 11 37 2.91487 $w=1.3e-08 $l=1.25e-08 $layer=M1 $thickness=3.6e-08 $X=0.0455
+ $Y=0.135 $X2=0.058 $Y2=0.135
r12 35 34 14.6259 $w=2.1e-08 $l=4.3e-08 $layer=Gate_1 $thickness=5.6e-08
+ $X=0.081 $Y=0.2025 $X2=0.081 $Y2=0.1595
r13 33 34 2.89117 $w=2.1e-08 $l=8.5e-09 $layer=Gate_1 $thickness=5.6e-08
+ $X=0.081 $Y=0.151 $X2=0.081 $Y2=0.1595
r14 3 23 3.57145 $w=2e-08 $layer=Gate_1 $thickness=5.6e-08 $X=0.081 $Y=0.135
+ $X2=0.081 $Y2=0.135
r15 3 33 5.61228 $w=2.0375e-08 $l=1.6e-08 $layer=Gate_1 $thickness=5.6e-08
+ $X=0.081 $Y=0.135 $X2=0.081 $Y2=0.151
r16 29 28 16.6668 $w=2.1e-08 $l=4.9e-08 $layer=Gate_1 $thickness=5.6e-08
+ $X=0.135 $Y=0.2025 $X2=0.135 $Y2=0.1535
r17 4 19 6.74717 $w=2e-08 $layer=Gate_1 $thickness=5.2e-08 $X=0.135 $Y=0.135
+ $X2=0.135 $Y2=0.135
r18 4 28 6.46262 $w=2.04595e-08 $l=1.85e-08 $layer=Gate_1 $thickness=5.6e-08
+ $X=0.135 $Y=0.135 $X2=0.135 $Y2=0.1535
r19 38 25 19.3796 $a=3.24e-16 $layer=V0LIG $X=0.069 $Y=0.133 $X2=0.066 $Y2=0.135
r20 22 23 1.90543 $w=2e-08 $l=4e-09 $layer=LIG $thickness=4.8e-08 $X=0.085
+ $Y=0.135 $X2=0.081 $Y2=0.135
r21 21 22 3.17572 $w=2e-08 $l=1e-08 $layer=LIG $thickness=4.8e-08 $X=0.075
+ $Y=0.135 $X2=0.085 $Y2=0.135
r22 21 25 6.25213 $w=1.62778e-08 $l=9e-09 $layer=LIG $thickness=4.8e-08
+ $X=0.075 $Y=0.135 $X2=0.066 $Y2=0.135
r23 20 22 18.8437 $w=1.50478e-08 $l=2.3e-08 $layer=LIG $thickness=4.8e-08
+ $X=0.108 $Y=0.135 $X2=0.085 $Y2=0.135
r24 19 20 20.114 $w=1.57815e-08 $l=2.7e-08 $layer=LIG $thickness=4.8e-08
+ $X=0.135 $Y=0.135 $X2=0.108 $Y2=0.135
r25 18 19 20.114 $w=1.57815e-08 $l=2.7e-08 $layer=LIG $thickness=4.8e-08
+ $X=0.162 $Y=0.135 $X2=0.135 $Y2=0.135
r26 1 14 6.74717 $w=2e-08 $layer=Gate_1 $thickness=5.2e-08 $X=0.189 $Y=0.135
+ $X2=0.189 $Y2=0.135
r27 1 18 20.114 $w=1.57815e-08 $l=2.7e-08 $layer=LIG $thickness=4.8e-08
+ $X=0.189 $Y=0.135 $X2=0.162 $Y2=0.135
r28 16 15 16.6668 $w=2.1e-08 $l=4.9e-08 $layer=Gate_1 $thickness=5.6e-08
+ $X=0.189 $Y=0.2025 $X2=0.189 $Y2=0.1535
r29 14 15 6.46262 $w=2.04595e-08 $l=1.85e-08 $layer=Gate_1 $thickness=5.6e-08
+ $X=0.189 $Y=0.135 $X2=0.189 $Y2=0.1535
r30 13 14 6.46262 $w=2.04595e-08 $l=1.85e-08 $layer=Gate_1 $thickness=5.6e-08
+ $X=0.189 $Y=0.1165 $X2=0.189 $Y2=0.135
r31 12 13 16.6668 $w=2.1e-08 $l=4.9e-08 $layer=Gate_1 $thickness=5.6e-08
+ $X=0.189 $Y=0.0675 $X2=0.189 $Y2=0.1165
r32 12 5 14.6259 $w=2.1e-08 $l=4.3e-08 $layer=Gate_1 $thickness=5.6e-08
+ $X=0.189 $Y=0.0675 $X2=0.189 $Y2=0.0245
.ends

.subckt PM_NOR3x1_ASAP7_75t_R%7 vss 16 17 29 30 33 34 10 1 11 12 2 3 13
c1 1 vss 0.00405435f $X=0.27 $Y=0.2025
c2 2 vss 0.00385229f $X=0.378 $Y=0.2025
c3 3 vss 0.00393058f $X=0.486 $Y=0.2025
c4 10 vss 0.00190575f $X=0.2555 $Y=0.2025
c5 11 vss 0.00192635f $X=0.3635 $Y=0.2025
c6 12 vss 0.00188317f $X=0.4715 $Y=0.2025
c7 13 vss 0.0190431f $X=0.4475 $Y=0.234
r1 34 32 0.0308642 $w=8.1e-08 $l=2.5e-09 $layer=P_src_drn $thickness=1e-09
+ $X=0.2873 $Y=0.2025 $X2=0.2845 $Y2=0.2025
r2 1 32 0.179012 $w=8.1e-08 $l=1.45e-08 $layer=P_src_drn $thickness=1e-09
+ $X=0.27 $Y=0.2025 $X2=0.2845 $Y2=0.2025
r3 10 1 0.179012 $w=8.1e-08 $l=1.45e-08 $layer=P_src_drn $thickness=1e-09
+ $X=0.2555 $Y=0.2025 $X2=0.27 $Y2=0.2025
r4 33 10 0.0308642 $w=8.1e-08 $l=2.5e-09 $layer=P_src_drn $thickness=1e-09
+ $X=0.2526 $Y=0.2025 $X2=0.2555 $Y2=0.2025
r5 30 28 0.0308642 $w=8.1e-08 $l=2.5e-09 $layer=P_src_drn $thickness=1e-09
+ $X=0.3953 $Y=0.2025 $X2=0.3925 $Y2=0.2025
r6 2 28 0.179012 $w=8.1e-08 $l=1.45e-08 $layer=P_src_drn $thickness=1e-09
+ $X=0.378 $Y=0.2025 $X2=0.3925 $Y2=0.2025
r7 11 2 0.179012 $w=8.1e-08 $l=1.45e-08 $layer=P_src_drn $thickness=1e-09
+ $X=0.3635 $Y=0.2025 $X2=0.378 $Y2=0.2025
r8 29 11 0.0308642 $w=8.1e-08 $l=2.5e-09 $layer=P_src_drn $thickness=1e-09
+ $X=0.3606 $Y=0.2025 $X2=0.3635 $Y2=0.2025
r9 1 25 19.3796 $a=3.24e-16 $layer=V0LISD $X=0.27 $Y=0.2025 $X2=0.27 $Y2=0.234
r10 2 22 19.3796 $a=3.24e-16 $layer=V0LISD $X=0.378 $Y=0.2025 $X2=0.378
+ $Y2=0.234
r11 25 26 8.97781 $w=1.3e-08 $l=3.85e-08 $layer=M1 $thickness=3.6e-08 $X=0.27
+ $Y=0.234 $X2=0.3085 $Y2=0.234
r12 22 23 3.14806 $w=1.3e-08 $l=1.35e-08 $layer=M1 $thickness=3.6e-08 $X=0.378
+ $Y=0.234 $X2=0.3915 $Y2=0.234
r13 21 22 5.71315 $w=1.3e-08 $l=2.45e-08 $layer=M1 $thickness=3.6e-08 $X=0.3535
+ $Y=0.234 $X2=0.378 $Y2=0.234
r14 21 26 10.4935 $w=1.3e-08 $l=4.5e-08 $layer=M1 $thickness=3.6e-08 $X=0.3535
+ $Y=0.234 $X2=0.3085 $Y2=0.234
r15 20 23 3.61444 $w=1.3e-08 $l=1.55e-08 $layer=M1 $thickness=3.6e-08 $X=0.407
+ $Y=0.234 $X2=0.3915 $Y2=0.234
r16 13 18 8.97781 $w=1.3e-08 $l=3.85e-08 $layer=M1 $thickness=3.6e-08 $X=0.4475
+ $Y=0.234 $X2=0.486 $Y2=0.234
r17 13 20 9.44419 $w=1.3e-08 $l=4.05e-08 $layer=M1 $thickness=3.6e-08 $X=0.4475
+ $Y=0.234 $X2=0.407 $Y2=0.234
r18 3 18 19.3796 $a=3.24e-16 $layer=V0LISD $X=0.486 $Y=0.2025 $X2=0.486
+ $Y2=0.234
r19 17 15 0.0308642 $w=8.1e-08 $l=2.5e-09 $layer=P_src_drn $thickness=1e-09
+ $X=0.5033 $Y=0.2025 $X2=0.5005 $Y2=0.2025
r20 3 15 0.179012 $w=8.1e-08 $l=1.45e-08 $layer=P_src_drn $thickness=1e-09
+ $X=0.486 $Y=0.2025 $X2=0.5005 $Y2=0.2025
r21 12 3 0.179012 $w=8.1e-08 $l=1.45e-08 $layer=P_src_drn $thickness=1e-09
+ $X=0.4715 $Y=0.2025 $X2=0.486 $Y2=0.2025
r22 16 12 0.0308642 $w=8.1e-08 $l=2.5e-09 $layer=P_src_drn $thickness=1e-09
+ $X=0.4686 $Y=0.2025 $X2=0.4715 $Y2=0.2025
.ends

.subckt PM_NOR3x1_ASAP7_75t_R%Y vss 38 24 25 36 48 51 52 13 1 19 3 4 21 14 2 20
+ 16 15
c1 1 vss 0.00992828f $X=0.216 $Y=0.0675
c2 2 vss 0.00660124f $X=0.432 $Y=0.0675
c3 3 vss 0.00282057f $X=0.432 $Y=0.2025
c4 4 vss 0.00505626f $X=0.54 $Y=0.2025
c5 13 vss 0.00453849f $X=0.2015 $Y=0.0675
c6 14 vss 0.00337857f $X=0.4175 $Y=0.0675
c7 15 vss 0.00215293f $X=0.4175 $Y=0.2025
c8 16 vss 0.0357698f $X=0.5255 $Y=0.2025
c9 17 vss 0.00280483f $X=0.567 $Y=0.036
c10 18 vss 0.00136194f $X=0.567 $Y=0.198
c11 19 vss 0.0318095f $X=0.2045 $Y=0.036
c12 20 vss 0.00229549f $X=0.5155 $Y=0.198
c13 21 vss 0.00412463f $X=0.567 $Y=0.054
r1 51 50 0.0308642 $w=8.1e-08 $l=2.5e-09 $layer=P_src_drn $thickness=1e-09
+ $X=0.4493 $Y=0.2025 $X2=0.4465 $Y2=0.2025
r2 3 50 0.179012 $w=8.1e-08 $l=1.45e-08 $layer=P_src_drn $thickness=1e-09
+ $X=0.432 $Y=0.2025 $X2=0.4465 $Y2=0.2025
r3 15 3 0.179012 $w=8.1e-08 $l=1.45e-08 $layer=P_src_drn $thickness=1e-09
+ $X=0.4175 $Y=0.2025 $X2=0.432 $Y2=0.2025
r4 52 15 0.0308642 $w=8.1e-08 $l=2.5e-09 $layer=P_src_drn $thickness=1e-09
+ $X=0.4146 $Y=0.2025 $X2=0.4175 $Y2=0.2025
r5 16 4 0.154321 $w=8.1e-08 $l=1.25e-08 $layer=P_src_drn $thickness=1e-09
+ $X=0.5255 $Y=0.2025 $X2=0.54 $Y2=0.2025
r6 48 16 0.0308642 $w=8.1e-08 $l=2.5e-09 $layer=P_src_drn $thickness=1e-09
+ $X=0.5226 $Y=0.2025 $X2=0.5255 $Y2=0.2025
r7 3 45 19.3796 $a=3.24e-16 $layer=V0LISD $X=0.432 $Y=0.2025 $X2=0.432 $Y2=0.198
r8 4 41 19.3796 $a=3.24e-16 $layer=V0LISD $X=0.54 $Y=0.2025 $X2=0.54 $Y2=0.198
r9 45 46 5.24677 $w=1.3e-08 $l=2.25e-08 $layer=M1 $thickness=3.6e-08 $X=0.432
+ $Y=0.198 $X2=0.4545 $Y2=0.198
r10 43 46 6.8791 $w=1.3e-08 $l=2.95e-08 $layer=M1 $thickness=3.6e-08 $X=0.484
+ $Y=0.198 $X2=0.4545 $Y2=0.198
r11 41 42 3.14806 $w=1.3e-08 $l=1.35e-08 $layer=M1 $thickness=3.6e-08 $X=0.54
+ $Y=0.198 $X2=0.5535 $Y2=0.198
r12 20 41 5.71315 $w=1.3e-08 $l=2.45e-08 $layer=M1 $thickness=3.6e-08 $X=0.5155
+ $Y=0.198 $X2=0.54 $Y2=0.198
r13 20 43 7.34548 $w=1.3e-08 $l=3.15e-08 $layer=M1 $thickness=3.6e-08 $X=0.5155
+ $Y=0.198 $X2=0.484 $Y2=0.198
r14 18 40 2.5483 $w=1.79e-08 $l=1.8e-08 $layer=M1 $thickness=3.6e-08 $X=0.567
+ $Y=0.198 $X2=0.567 $Y2=0.18
r15 18 42 1.49895 $w=1.63333e-08 $l=1.35e-08 $layer=M1 $thickness=3.6e-08
+ $X=0.567 $Y=0.198 $X2=0.5535 $Y2=0.198
r16 39 40 7.17059 $w=1.3e-08 $l=3.08e-08 $layer=M1 $thickness=3.6e-08 $X=0.567
+ $Y=0.1492 $X2=0.567 $Y2=0.18
r17 38 39 5.18847 $w=1.3e-08 $l=2.22e-08 $layer=M1 $thickness=3.6e-08 $X=0.566
+ $Y=0.127 $X2=0.567 $Y2=0.1492
r18 38 37 7.52037 $w=1.3e-08 $l=3.23e-08 $layer=M1 $thickness=3.6e-08 $X=0.566
+ $Y=0.127 $X2=0.567 $Y2=0.0947
r19 21 37 9.50248 $w=1.3e-08 $l=4.07e-08 $layer=M1 $thickness=3.6e-08 $X=0.567
+ $Y=0.054 $X2=0.567 $Y2=0.0947
r20 14 2 0.154321 $w=8.1e-08 $l=1.25e-08 $layer=N_src_drn $thickness=1e-09
+ $X=0.4175 $Y=0.0675 $X2=0.432 $Y2=0.0675
r21 36 14 0.0308642 $w=8.1e-08 $l=2.5e-09 $layer=N_src_drn $thickness=1e-09
+ $X=0.4146 $Y=0.0675 $X2=0.4175 $Y2=0.0675
r22 17 34 10.9431 $w=1.38333e-08 $l=5.4e-08 $layer=M1 $thickness=3.6e-08
+ $X=0.567 $Y=0.036 $X2=0.513 $Y2=0.036
r23 17 21 2.5483 $w=1.79e-08 $l=1.8e-08 $layer=M1 $thickness=3.6e-08 $X=0.567
+ $Y=0.036 $X2=0.567 $Y2=0.054
r24 2 32 19.3796 $a=3.24e-16 $layer=V0LISD $X=0.432 $Y=0.0675 $X2=0.432
+ $Y2=0.036
r25 33 34 13.6416 $w=1.3e-08 $l=5.85e-08 $layer=M1 $thickness=3.6e-08 $X=0.4545
+ $Y=0.036 $X2=0.513 $Y2=0.036
r26 32 33 5.24677 $w=1.3e-08 $l=2.25e-08 $layer=M1 $thickness=3.6e-08 $X=0.432
+ $Y=0.036 $X2=0.4545 $Y2=0.036
r27 31 32 5.24677 $w=1.3e-08 $l=2.25e-08 $layer=M1 $thickness=3.6e-08 $X=0.4095
+ $Y=0.036 $X2=0.432 $Y2=0.036
r28 30 31 9.91056 $w=1.3e-08 $l=4.25e-08 $layer=M1 $thickness=3.6e-08 $X=0.367
+ $Y=0.036 $X2=0.4095 $Y2=0.036
r29 29 30 10.4935 $w=1.3e-08 $l=4.5e-08 $layer=M1 $thickness=3.6e-08 $X=0.322
+ $Y=0.036 $X2=0.367 $Y2=0.036
r30 28 29 12.1259 $w=1.3e-08 $l=5.2e-08 $layer=M1 $thickness=3.6e-08 $X=0.27
+ $Y=0.036 $X2=0.322 $Y2=0.036
r31 27 28 9.44419 $w=1.3e-08 $l=4.05e-08 $layer=M1 $thickness=3.6e-08 $X=0.2295
+ $Y=0.036 $X2=0.27 $Y2=0.036
r32 26 27 3.14806 $w=1.3e-08 $l=1.35e-08 $layer=M1 $thickness=3.6e-08 $X=0.216
+ $Y=0.036 $X2=0.2295 $Y2=0.036
r33 19 26 2.68168 $w=1.3e-08 $l=1.15e-08 $layer=M1 $thickness=3.6e-08 $X=0.2045
+ $Y=0.036 $X2=0.216 $Y2=0.036
r34 1 26 19.3796 $a=3.24e-16 $layer=V0LISD $X=0.216 $Y=0.0675 $X2=0.216
+ $Y2=0.036
r35 25 23 0.0308642 $w=8.1e-08 $l=2.5e-09 $layer=N_src_drn $thickness=1e-09
+ $X=0.2333 $Y=0.0675 $X2=0.2305 $Y2=0.0675
r36 1 23 0.179012 $w=8.1e-08 $l=1.45e-08 $layer=N_src_drn $thickness=1e-09
+ $X=0.216 $Y=0.0675 $X2=0.2305 $Y2=0.0675
r37 13 1 0.179012 $w=8.1e-08 $l=1.45e-08 $layer=N_src_drn $thickness=1e-09
+ $X=0.2015 $Y=0.0675 $X2=0.216 $Y2=0.0675
r38 24 13 0.0308642 $w=8.1e-08 $l=2.5e-09 $layer=N_src_drn $thickness=1e-09
+ $X=0.1986 $Y=0.0675 $X2=0.2015 $Y2=0.0675
.ends

.subckt PM_NOR3x1_ASAP7_75t_R%A vss 21 13 24 27 33 3 1 9 4 5 10 6 7 8
c1 1 vss 0.0119783f $X=0.459 $Y=0.135
c2 3 vss 0.0487253f $X=0.405 $Y=0.135
c3 4 vss 0.0119502f $X=0.459 $Y=0.0735
c4 5 vss 0.0223669f $X=0.513 $Y=0.135
c5 6 vss 0.00534196f $X=0.459 $Y=0.072
c6 7 vss 0.00491801f $X=0.459 $Y=0.162
c7 8 vss 0.00631759f $X=0.423 $Y=0.072
c8 9 vss 0.00596001f $X=0.434 $Y=0.162
c9 10 vss 0.00532025f $X=0.459 $Y=0.1035
r1 7 22 1.49895 $w=1.95333e-08 $l=1.35e-08 $layer=M1 $thickness=3.6e-08
+ $X=0.459 $Y=0.162 $X2=0.459 $Y2=0.1485
r2 7 9 4.18063 $w=1.48e-08 $l=2.5e-08 $layer=M1 $thickness=3.6e-08 $X=0.459
+ $Y=0.162 $X2=0.434 $Y2=0.162
r3 6 10 5.69636 $w=1.58e-08 $l=3.15e-08 $layer=M1 $thickness=3.6e-08 $X=0.459
+ $Y=0.072 $X2=0.459 $Y2=0.1035
r4 6 8 6.74572 $w=1.425e-08 $l=3.6e-08 $layer=M1 $thickness=3.6e-08 $X=0.459
+ $Y=0.072 $X2=0.423 $Y2=0.072
r5 33 32 14.6259 $w=2.1e-08 $l=4.3e-08 $layer=Gate_1 $thickness=5.6e-08
+ $X=0.513 $Y=0.2025 $X2=0.513 $Y2=0.1595
r6 31 32 2.89117 $w=2.1e-08 $l=8.5e-09 $layer=Gate_1 $thickness=5.6e-08
+ $X=0.513 $Y=0.151 $X2=0.513 $Y2=0.1595
r7 5 19 6.74717 $w=2e-08 $layer=Gate_1 $thickness=5.2e-08 $X=0.513 $Y=0.135
+ $X2=0.513 $Y2=0.135
r8 5 31 5.61228 $w=2.0375e-08 $l=1.6e-08 $layer=Gate_1 $thickness=5.6e-08
+ $X=0.513 $Y=0.135 $X2=0.513 $Y2=0.151
r9 27 26 16.6668 $w=2.1e-08 $l=4.9e-08 $layer=Gate_1 $thickness=5.6e-08
+ $X=0.405 $Y=0.2025 $X2=0.405 $Y2=0.1535
r10 24 25 16.6668 $w=2.1e-08 $l=4.9e-08 $layer=Gate_1 $thickness=5.6e-08
+ $X=0.405 $Y=0.0675 $X2=0.405 $Y2=0.1165
r11 3 16 6.74717 $w=2e-08 $layer=Gate_1 $thickness=5.2e-08 $X=0.405 $Y=0.135
+ $X2=0.405 $Y2=0.135
r12 3 25 6.46262 $w=2.04595e-08 $l=1.85e-08 $layer=Gate_1 $thickness=5.6e-08
+ $X=0.405 $Y=0.135 $X2=0.405 $Y2=0.1165
r13 3 26 6.46262 $w=2.04595e-08 $l=1.85e-08 $layer=Gate_1 $thickness=5.6e-08
+ $X=0.405 $Y=0.135 $X2=0.405 $Y2=0.1535
r14 21 22 3.14806 $w=1.3e-08 $l=1.35e-08 $layer=M1 $thickness=3.6e-08 $X=0.459
+ $Y=0.133 $X2=0.459 $Y2=0.1485
r15 21 10 7.34548 $w=1.3e-08 $l=3.15e-08 $layer=M1 $thickness=3.6e-08 $X=0.459
+ $Y=0.133 $X2=0.459 $Y2=0.1035
r16 18 19 20.114 $w=1.57815e-08 $l=2.7e-08 $layer=LIG $thickness=4.8e-08
+ $X=0.486 $Y=0.135 $X2=0.513 $Y2=0.135
r17 15 16 20.114 $w=1.57815e-08 $l=2.7e-08 $layer=LIG $thickness=4.8e-08
+ $X=0.432 $Y=0.135 $X2=0.405 $Y2=0.135
r18 1 11 6.74717 $w=2e-08 $layer=Gate_1 $thickness=5.2e-08 $X=0.459 $Y=0.135
+ $X2=0.459 $Y2=0.135
r19 1 15 20.114 $w=1.57815e-08 $l=2.7e-08 $layer=LIG $thickness=4.8e-08
+ $X=0.459 $Y=0.135 $X2=0.432 $Y2=0.135
r20 1 18 20.114 $w=1.57815e-08 $l=2.7e-08 $layer=LIG $thickness=4.8e-08
+ $X=0.459 $Y=0.135 $X2=0.486 $Y2=0.135
r21 21 1 19.3796 $a=3.24e-16 $layer=V0LIG $X=0.459 $Y=0.133 $X2=0.459 $Y2=0.135
r22 13 12 16.6668 $w=2.1e-08 $l=4.9e-08 $layer=Gate_1 $thickness=5.6e-08
+ $X=0.459 $Y=0.2025 $X2=0.459 $Y2=0.1535
r23 11 12 6.46262 $w=2.04595e-08 $l=1.85e-08 $layer=Gate_1 $thickness=5.6e-08
+ $X=0.459 $Y=0.135 $X2=0.459 $Y2=0.1535
r24 4 11 21.0886 $w=2.08374e-08 $l=6.15e-08 $layer=Gate_1 $thickness=5.6e-08
+ $X=0.459 $Y=0.0735 $X2=0.459 $Y2=0.135
.ends

.subckt PM_NOR3x1_ASAP7_75t_R%B vss 10 11 15 25 31 1 3 5 7 4 9 8 6
c1 1 vss 0.0166829f $X=0.243 $Y=0.135
c2 3 vss 0.0484247f $X=0.243 $Y=0.0245
c3 4 vss 0.0513481f $X=0.297 $Y=0.135
c4 5 vss 0.0513574f $X=0.351 $Y=0.135
c5 6 vss 0.00542963f $X=0.297 $Y=0.072
c6 7 vss 0.0049319f $X=0.297 $Y=0.162
c7 8 vss 0.00687615f $X=0.261 $Y=0.072
c8 9 vss 0.00551796f $X=0.261 $Y=0.162
c9 10 vss 0.00607889f $X=0.296 $Y=0.133
r1 7 28 1.49895 $w=1.95333e-08 $l=1.35e-08 $layer=M1 $thickness=3.6e-08
+ $X=0.297 $Y=0.162 $X2=0.297 $Y2=0.1485
r2 7 9 6.74572 $w=1.425e-08 $l=3.6e-08 $layer=M1 $thickness=3.6e-08 $X=0.297
+ $Y=0.162 $X2=0.261 $Y2=0.162
r3 6 27 5.69636 $w=1.58e-08 $l=3.15e-08 $layer=M1 $thickness=3.6e-08 $X=0.297
+ $Y=0.072 $X2=0.297 $Y2=0.1035
r4 6 8 6.74572 $w=1.425e-08 $l=3.6e-08 $layer=M1 $thickness=3.6e-08 $X=0.297
+ $Y=0.072 $X2=0.261 $Y2=0.072
r5 31 30 16.6668 $w=2.1e-08 $l=4.9e-08 $layer=Gate_1 $thickness=5.6e-08
+ $X=0.351 $Y=0.2025 $X2=0.351 $Y2=0.1535
r6 5 21 6.74717 $w=2e-08 $layer=Gate_1 $thickness=5.2e-08 $X=0.351 $Y=0.135
+ $X2=0.351 $Y2=0.135
r7 5 30 6.46262 $w=2.04595e-08 $l=1.85e-08 $layer=Gate_1 $thickness=5.6e-08
+ $X=0.351 $Y=0.135 $X2=0.351 $Y2=0.1535
r8 10 19 19.3796 $a=3.24e-16 $layer=V0LIG $X=0.296 $Y=0.133 $X2=0.297 $Y2=0.135
r9 10 27 7.34548 $w=1.3e-08 $l=3.15e-08 $layer=M1 $thickness=3.6e-08 $X=0.296
+ $Y=0.133 $X2=0.297 $Y2=0.1035
r10 10 28 3.14806 $w=1.3e-08 $l=1.35e-08 $layer=M1 $thickness=3.6e-08 $X=0.296
+ $Y=0.133 $X2=0.297 $Y2=0.1485
r11 25 24 16.6668 $w=2.1e-08 $l=4.9e-08 $layer=Gate_1 $thickness=5.6e-08
+ $X=0.297 $Y=0.2025 $X2=0.297 $Y2=0.1535
r12 4 19 6.74717 $w=2e-08 $layer=Gate_1 $thickness=5.2e-08 $X=0.297 $Y=0.135
+ $X2=0.297 $Y2=0.135
r13 4 24 6.46262 $w=2.04595e-08 $l=1.85e-08 $layer=Gate_1 $thickness=5.6e-08
+ $X=0.297 $Y=0.135 $X2=0.297 $Y2=0.1535
r14 20 21 20.114 $w=1.57815e-08 $l=2.7e-08 $layer=LIG $thickness=4.8e-08
+ $X=0.324 $Y=0.135 $X2=0.351 $Y2=0.135
r15 19 20 20.114 $w=1.57815e-08 $l=2.7e-08 $layer=LIG $thickness=4.8e-08
+ $X=0.297 $Y=0.135 $X2=0.324 $Y2=0.135
r16 18 19 20.114 $w=1.57815e-08 $l=2.7e-08 $layer=LIG $thickness=4.8e-08
+ $X=0.27 $Y=0.135 $X2=0.297 $Y2=0.135
r17 1 13 6.74717 $w=2e-08 $layer=Gate_1 $thickness=5.2e-08 $X=0.243 $Y=0.135
+ $X2=0.243 $Y2=0.135
r18 1 18 20.114 $w=1.57815e-08 $l=2.7e-08 $layer=LIG $thickness=4.8e-08
+ $X=0.243 $Y=0.135 $X2=0.27 $Y2=0.135
r19 15 14 16.6668 $w=2.1e-08 $l=4.9e-08 $layer=Gate_1 $thickness=5.6e-08
+ $X=0.243 $Y=0.2025 $X2=0.243 $Y2=0.1535
r20 13 14 6.46262 $w=2.04595e-08 $l=1.85e-08 $layer=Gate_1 $thickness=5.6e-08
+ $X=0.243 $Y=0.135 $X2=0.243 $Y2=0.1535
r21 12 13 6.46262 $w=2.04595e-08 $l=1.85e-08 $layer=Gate_1 $thickness=5.6e-08
+ $X=0.243 $Y=0.1165 $X2=0.243 $Y2=0.135
r22 11 12 16.6668 $w=2.1e-08 $l=4.9e-08 $layer=Gate_1 $thickness=5.6e-08
+ $X=0.243 $Y=0.0675 $X2=0.243 $Y2=0.1165
r23 11 3 14.6259 $w=2.1e-08 $l=4.3e-08 $layer=Gate_1 $thickness=5.6e-08
+ $X=0.243 $Y=0.0675 $X2=0.243 $Y2=0.0245
.ends

* End of included file NOR3x1_ASAP7_75t_R.pex.sp.pex

*
.subckt NOR3x1_ASAP7_75t_CUSTOM_4_25_0_7 VSS VDD C B A Y
*
* VSS VSS
* VDD VDD
* C C
* B B
* A A
* Y Y
*
*

M0 N_M0_d N_M0_g VSS VSS nmos_rvt L=2e-08 W=8.1e-08 nfin=3 $X=0.179 $Y=0.027
M1 VSS N_M1_g N_M1_s VSS nmos_rvt L=2e-08 W=8.1e-08 nfin=3 $X=0.233 $Y=0.027
M2 N_M2_d N_M2_g VSS VSS nmos_rvt L=2e-08 W=8.1e-08 nfin=3 $X=0.395 $Y=0.027
M3 N_M3_d N_M3_g VDD VDD pmos_rvt L=2e-08 W=8.1e-08 nfin=3 $X=0.071 $Y=0.162
M4 N_M4_d N_M4_g VDD VDD pmos_rvt L=2e-08 W=8.1e-08 nfin=3 $X=0.125 $Y=0.162
M5 N_M5_d N_M5_g VDD VDD pmos_rvt L=2e-08 W=8.1e-08 nfin=3 $X=0.179 $Y=0.162
M6 N_M6_d N_M6_g N_M6_s VDD pmos_rvt L=2e-08 W=8.1e-08 nfin=3 $X=0.233 $Y=0.162
M7 N_M7_d N_M7_g N_M7_s VDD pmos_rvt L=2e-08 W=8.1e-08 nfin=3 $X=0.287 $Y=0.162
M8 N_M8_d N_M8_g N_M8_s VDD pmos_rvt L=2e-08 W=8.1e-08 nfin=3 $X=0.341 $Y=0.162
M9 N_M9_d N_M9_g N_M9_s VDD pmos_rvt L=2e-08 W=8.1e-08 nfin=3 $X=0.395 $Y=0.162
M10 N_M10_d N_M10_g N_M10_s VDD pmos_rvt L=2e-08 W=8.1e-08 nfin=3 $X=0.449
+ $Y=0.162
M11 N_M11_d N_M11_g N_M11_s VDD pmos_rvt L=2e-08 W=8.1e-08 nfin=3 $X=0.503
+ $Y=0.162

* .include "NOR3x1_ASAP7_75t_R.pex.sp.pxi"

* Start of included file NOR3x1_ASAP7_75t_R.pex.sp.pxi
x_PM_NOR3x1_ASAP7_75t_R%6 vss N_M3_d N_M4_d N_M5_d N_M6_s N_M7_s N_M8_s N_6_10
+ N_6_13 N_6_1 N_6_11 N_6_12 N_6_3 N_6_2 PM_NOR3x1_ASAP7_75t_R%6
cc_1 N_6_10 N_C_5 0.00105883f $X=0.0935 $Y=0.2025
cc_2 N_6_10 N_C_11 0.000520376f $X=0.0935 $Y=0.2025
cc_3 N_6_10 N_C_3 0.0186793f $X=0.0935 $Y=0.2025
cc_4 N_6_13 N_C_1 0.00132145f $X=0.0965 $Y=0.198
cc_5 N_6_1 N_C_4 0.00156738f $X=0.108 $Y=0.2025
cc_6 N_6_10 N_C_1 0.00303449f $X=0.0935 $Y=0.2025
cc_7 N_6_11 N_C_5 0.0319975f $X=0.2015 $Y=0.2025
cc_8 N_6_10 N_C_4 0.0473287f $X=0.0935 $Y=0.2025
cc_9 N_6_12 N_B_7 0.00153323f $X=0.3095 $Y=0.2025
cc_10 N_6_12 N_B_3 0.00122442f $X=0.3095 $Y=0.2025
cc_11 N_6_12 N_B_5 0.0363138f $X=0.3095 $Y=0.2025
cc_12 N_6_3 N_B_4 0.00151715f $X=0.324 $Y=0.2025
cc_13 N_6_12 N_B_1 0.00269009f $X=0.3095 $Y=0.2025
cc_14 N_6_13 N_B_9 0.00589807f $X=0.0965 $Y=0.198
cc_15 N_6_11 N_B_3 0.0321487f $X=0.2015 $Y=0.2025
cc_16 N_6_12 N_B_4 0.0287246f $X=0.3095 $Y=0.2025
x_PM_NOR3x1_ASAP7_75t_R%C vss C N_M0_g N_M5_g N_M4_g N_M3_g N_C_1 N_C_5 N_C_11
+ N_C_3 N_C_4 PM_NOR3x1_ASAP7_75t_R%C
x_PM_NOR3x1_ASAP7_75t_R%7 vss N_M10_s N_M11_s N_M8_d N_M9_s N_M6_d N_M7_d
+ N_7_10 N_7_1 N_7_11 N_7_12 N_7_2 N_7_3 N_7_13 PM_NOR3x1_ASAP7_75t_R%7
cc_17 N_7_10 N_B_9 0.000359409f $X=0.2555 $Y=0.2025
cc_18 N_7_10 N_B_5 0.00110623f $X=0.2555 $Y=0.2025
cc_19 N_7_1 N_B_4 0.00174572f $X=0.27 $Y=0.2025
cc_20 N_7_10 N_B_1 0.00267581f $X=0.2555 $Y=0.2025
cc_21 N_7_11 N_B_5 0.0317612f $X=0.3635 $Y=0.2025
cc_22 N_7_10 N_B_3 0.0357938f $X=0.2555 $Y=0.2025
cc_23 N_7_10 N_B_4 0.0293532f $X=0.2555 $Y=0.2025
cc_24 N_7_12 N_A_9 0.000611862f $X=0.4715 $Y=0.2025
cc_25 N_7_2 N_A_3 0.000939346f $X=0.378 $Y=0.2025
cc_26 N_7_3 N_A_4 0.00154868f $X=0.486 $Y=0.2025
cc_27 N_7_12 N_A_1 0.00268494f $X=0.4715 $Y=0.2025
cc_28 N_7_11 N_A_3 0.0322071f $X=0.3635 $Y=0.2025
cc_29 N_7_12 N_A_5 0.035669f $X=0.4715 $Y=0.2025
cc_30 N_7_12 N_A_4 0.0304444f $X=0.4715 $Y=0.2025
cc_31 N_7_11 N_6_13 0.00106251f $X=0.3635 $Y=0.2025
cc_32 N_7_10 N_6_11 0.00107088f $X=0.2555 $Y=0.2025
cc_33 N_7_1 N_6_2 0.00109694f $X=0.27 $Y=0.2025
cc_34 N_7_2 N_6_3 0.00123632f $X=0.378 $Y=0.2025
cc_35 N_7_1 N_6_3 0.00520093f $X=0.27 $Y=0.2025
cc_36 N_7_13 N_6_13 0.0110982f $X=0.4475 $Y=0.234
x_PM_NOR3x1_ASAP7_75t_R%Y vss Y N_M0_d N_M1_s N_M2_d N_M11_d N_M10_d N_M9_d
+ N_Y_13 N_Y_1 N_Y_19 N_Y_3 N_Y_4 N_Y_21 N_Y_14 N_Y_2 N_Y_20 N_Y_16 N_Y_15
+ PM_NOR3x1_ASAP7_75t_R%Y
cc_37 N_Y_13 N_C_1 0.000878412f $X=0.2015 $Y=0.0675
cc_38 N_Y_13 N_C_5 0.0343646f $X=0.2015 $Y=0.0675
cc_39 N_Y_13 B 0.00044413f $X=0.2015 $Y=0.0675
cc_40 N_Y_13 N_B_1 0.000787409f $X=0.2015 $Y=0.0675
cc_41 N_Y_1 N_B_3 0.00121334f $X=0.216 $Y=0.0675
cc_42 N_Y_19 N_B_8 0.00255522f $X=0.2045 $Y=0.036
cc_43 N_Y_19 N_B_6 0.00489922f $X=0.2045 $Y=0.036
cc_44 N_Y_13 N_B_3 0.033999f $X=0.2015 $Y=0.0675
cc_45 N_Y_3 N_A_9 0.000609086f $X=0.432 $Y=0.2025
cc_46 N_Y_4 N_A_5 0.000765066f $X=0.54 $Y=0.2025
cc_47 N_Y_21 N_A_1 0.00108905f $X=0.567 $Y=0.054
cc_48 N_Y_14 N_A_3 0.011353f $X=0.4175 $Y=0.0675
cc_49 N_Y_2 N_A_10 0.0013451f $X=0.432 $Y=0.0675
cc_50 N_Y_19 N_A_6 0.00142284f $X=0.2045 $Y=0.036
cc_51 N_Y_3 N_A_4 0.00179058f $X=0.432 $Y=0.2025
cc_52 N_Y_20 N_A_9 0.00201325f $X=0.5155 $Y=0.198
cc_53 N_Y_2 N_A_3 0.00297786f $X=0.432 $Y=0.0675
cc_54 N_Y_20 N_A_7 0.00392069f $X=0.5155 $Y=0.198
cc_55 N_Y_14 N_A_1 0.00601185f $X=0.4175 $Y=0.0675
cc_56 N_Y_19 N_A_8 0.00675898f $X=0.2045 $Y=0.036
cc_57 N_Y_16 N_A_5 0.0339874f $X=0.5255 $Y=0.2025
cc_58 N_Y_14 N_A_4 0.0207627f $X=0.4175 $Y=0.0675
cc_59 N_Y_15 N_A_3 0.0374144f $X=0.4175 $Y=0.2025
cc_60 N_Y_15 N_A_4 0.0694117f $X=0.4175 $Y=0.2025
cc_61 N_Y_3 N_7_13 0.000720544f $X=0.432 $Y=0.2025
cc_62 N_Y_15 N_7_11 0.00106265f $X=0.4175 $Y=0.2025
cc_63 N_Y_15 N_7_12 0.0010841f $X=0.4175 $Y=0.2025
cc_64 N_Y_4 N_7_3 0.00116733f $X=0.54 $Y=0.2025
cc_65 N_Y_3 N_7_2 0.00117905f $X=0.432 $Y=0.2025
cc_66 N_Y_3 N_7_3 0.00542718f $X=0.432 $Y=0.2025
cc_67 N_Y_20 N_7_13 0.0107591f $X=0.5155 $Y=0.198
x_PM_NOR3x1_ASAP7_75t_R%A vss A N_M10_g N_M2_g N_M9_g N_M11_g N_A_3 N_A_1 N_A_9
+ N_A_4 N_A_5 N_A_10 N_A_6 N_A_7 N_A_8 PM_NOR3x1_ASAP7_75t_R%A
cc_68 N_A_3 B 0.000310955f $X=0.405 $Y=0.135
cc_69 N_A_1 N_B_1 0.00175273f $X=0.459 $Y=0.135
cc_70 N_A_3 N_B_5 0.00447863f $X=0.405 $Y=0.135
x_PM_NOR3x1_ASAP7_75t_R%B vss B N_M1_g N_M6_g N_M7_g N_M8_g N_B_1 N_B_3 N_B_5
+ N_B_7 N_B_4 N_B_9 N_B_8 N_B_6 PM_NOR3x1_ASAP7_75t_R%B
cc_71 N_B_1 N_C_1 0.00166005f $X=0.243 $Y=0.135
cc_72 N_B_3 N_C_5 0.0039364f $X=0.243 $Y=0.0245

* End of included file NOR3x1_ASAP7_75t_R.pex.sp.pxi
.ends

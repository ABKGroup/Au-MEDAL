.subckt PM_AND5x2_ASAP7_75t_R%9 vss 12 13 23 24 1 7 2 8 9
c1 1 vss 0.00879745f $X=0.108 $Y=0.0675
c2 2 vss 0.00408314f $X=0.324 $Y=0.0675
c3 7 vss 0.00457691f $X=0.0935 $Y=0.0675
c4 8 vss 0.00196983f $X=0.3095 $Y=0.0675
c5 9 vss 0.0228187f $X=0.0945 $Y=0.036
r1 24 22 0.0308642 $w=8.1e-08 $l=2.5e-09 $layer=N_src_drn $thickness=1e-09
+ $X=0.3413 $Y=0.0675 $X2=0.3385 $Y2=0.0675
r2 2 22 0.179012 $w=8.1e-08 $l=1.45e-08 $layer=N_src_drn $thickness=1e-09
+ $X=0.324 $Y=0.0675 $X2=0.3385 $Y2=0.0675
r3 8 2 0.179012 $w=8.1e-08 $l=1.45e-08 $layer=N_src_drn $thickness=1e-09
+ $X=0.3095 $Y=0.0675 $X2=0.324 $Y2=0.0675
r4 23 8 0.0308642 $w=8.1e-08 $l=2.5e-09 $layer=N_src_drn $thickness=1e-09
+ $X=0.3066 $Y=0.0675 $X2=0.3095 $Y2=0.0675
r5 2 19 19.3796 $a=3.24e-16 $layer=V0LISD $X=0.324 $Y=0.0675 $X2=0.324 $Y2=0.036
r6 18 19 8.97781 $w=1.3e-08 $l=3.85e-08 $layer=M1 $thickness=3.6e-08 $X=0.2855
+ $Y=0.036 $X2=0.324 $Y2=0.036
r7 17 18 19.4713 $w=1.3e-08 $l=8.35e-08 $layer=M1 $thickness=3.6e-08 $X=0.202
+ $Y=0.036 $X2=0.2855 $Y2=0.036
r8 16 17 16.2067 $w=1.3e-08 $l=6.95e-08 $layer=M1 $thickness=3.6e-08 $X=0.1325
+ $Y=0.036 $X2=0.202 $Y2=0.036
r9 15 16 5.71315 $w=1.3e-08 $l=2.45e-08 $layer=M1 $thickness=3.6e-08 $X=0.108
+ $Y=0.036 $X2=0.1325 $Y2=0.036
r10 14 15 2.56509 $w=1.3e-08 $l=1.1e-08 $layer=M1 $thickness=3.6e-08 $X=0.097
+ $Y=0.036 $X2=0.108 $Y2=0.036
r11 9 14 0.582974 $w=1.3e-08 $l=2.5e-09 $layer=M1 $thickness=3.6e-08 $X=0.0945
+ $Y=0.036 $X2=0.097 $Y2=0.036
r12 1 15 19.3796 $a=3.24e-16 $layer=V0LISD $X=0.108 $Y=0.0675 $X2=0.108
+ $Y2=0.036
r13 13 11 0.0308642 $w=8.1e-08 $l=2.5e-09 $layer=N_src_drn $thickness=1e-09
+ $X=0.1253 $Y=0.0675 $X2=0.1225 $Y2=0.0675
r14 1 11 0.179012 $w=8.1e-08 $l=1.45e-08 $layer=N_src_drn $thickness=1e-09
+ $X=0.108 $Y=0.0675 $X2=0.1225 $Y2=0.0675
r15 7 1 0.179012 $w=8.1e-08 $l=1.45e-08 $layer=N_src_drn $thickness=1e-09
+ $X=0.0935 $Y=0.0675 $X2=0.108 $Y2=0.0675
r16 12 7 0.0308642 $w=8.1e-08 $l=2.5e-09 $layer=N_src_drn $thickness=1e-09
+ $X=0.0906 $Y=0.0675 $X2=0.0935 $Y2=0.0675
.ends

.subckt PM_AND5x2_ASAP7_75t_R%10 vss 15 30 31 33 11 1 10 13 3 12 2
c1 1 vss 0.00526942f $X=0.27 $Y=0.0675
c2 2 vss 0.00365387f $X=0.378 $Y=0.0675
c3 3 vss 0.00532325f $X=0.486 $Y=0.0675
c4 10 vss 0.0362905f $X=0.272 $Y=0.0675
c5 11 vss 0.00223065f $X=0.3635 $Y=0.0675
c6 12 vss 0.0360044f $X=0.4715 $Y=0.0675
c7 13 vss 0.00397971f $X=0.2585 $Y=0.072
r1 12 3 0.154321 $w=8.1e-08 $l=1.25e-08 $layer=N_src_drn $thickness=1e-09
+ $X=0.4715 $Y=0.0675 $X2=0.486 $Y2=0.0675
r2 33 12 0.0308642 $w=8.1e-08 $l=2.5e-09 $layer=N_src_drn $thickness=1e-09
+ $X=0.4686 $Y=0.0675 $X2=0.4715 $Y2=0.0675
r3 31 29 0.0308642 $w=8.1e-08 $l=2.5e-09 $layer=N_src_drn $thickness=1e-09
+ $X=0.3953 $Y=0.0675 $X2=0.3925 $Y2=0.0675
r4 2 29 0.179012 $w=8.1e-08 $l=1.45e-08 $layer=N_src_drn $thickness=1e-09
+ $X=0.378 $Y=0.0675 $X2=0.3925 $Y2=0.0675
r5 11 2 0.179012 $w=8.1e-08 $l=1.45e-08 $layer=N_src_drn $thickness=1e-09
+ $X=0.3635 $Y=0.0675 $X2=0.378 $Y2=0.0675
r6 30 11 0.0308642 $w=8.1e-08 $l=2.5e-09 $layer=N_src_drn $thickness=1e-09
+ $X=0.3606 $Y=0.0675 $X2=0.3635 $Y2=0.0675
r7 3 25 19.3796 $a=3.24e-16 $layer=V0LISD $X=0.486 $Y=0.0675 $X2=0.482 $Y2=0.072
r8 2 21 19.3796 $a=3.24e-16 $layer=V0LISD $X=0.378 $Y=0.0675 $X2=0.378 $Y2=0.072
r9 24 25 4.31401 $w=1.3e-08 $l=1.85e-08 $layer=M1 $thickness=3.6e-08 $X=0.4635
+ $Y=0.072 $X2=0.482 $Y2=0.072
r10 23 24 6.8791 $w=1.3e-08 $l=2.95e-08 $layer=M1 $thickness=3.6e-08 $X=0.434
+ $Y=0.072 $X2=0.4635 $Y2=0.072
r11 22 23 7.34548 $w=1.3e-08 $l=3.15e-08 $layer=M1 $thickness=3.6e-08 $X=0.4025
+ $Y=0.072 $X2=0.434 $Y2=0.072
r12 21 22 5.71315 $w=1.3e-08 $l=2.45e-08 $layer=M1 $thickness=3.6e-08 $X=0.378
+ $Y=0.072 $X2=0.4025 $Y2=0.072
r13 20 21 5.71315 $w=1.3e-08 $l=2.45e-08 $layer=M1 $thickness=3.6e-08 $X=0.3535
+ $Y=0.072 $X2=0.378 $Y2=0.072
r14 19 20 7.34548 $w=1.3e-08 $l=3.15e-08 $layer=M1 $thickness=3.6e-08 $X=0.322
+ $Y=0.072 $X2=0.3535 $Y2=0.072
r15 18 19 6.8791 $w=1.3e-08 $l=2.95e-08 $layer=M1 $thickness=3.6e-08 $X=0.2925
+ $Y=0.072 $X2=0.322 $Y2=0.072
r16 17 18 4.31401 $w=1.3e-08 $l=1.85e-08 $layer=M1 $thickness=3.6e-08 $X=0.274
+ $Y=0.072 $X2=0.2925 $Y2=0.072
r17 16 17 2.09871 $w=1.3e-08 $l=9e-09 $layer=M1 $thickness=3.6e-08 $X=0.265
+ $Y=0.072 $X2=0.274 $Y2=0.072
r18 13 16 1.51573 $w=1.3e-08 $l=6.5e-09 $layer=M1 $thickness=3.6e-08 $X=0.2585
+ $Y=0.072 $X2=0.265 $Y2=0.072
r19 1 17 19.3796 $a=3.24e-16 $layer=V0LISD $X=0.27 $Y=0.0675 $X2=0.274 $Y2=0.072
r20 15 14 0.0308642 $w=8.1e-08 $l=2.5e-09 $layer=N_src_drn $thickness=1e-09
+ $X=0.2873 $Y=0.0675 $X2=0.2845 $Y2=0.0675
r21 10 14 0.154321 $w=8.1e-08 $l=1.25e-08 $layer=N_src_drn $thickness=1e-09
+ $X=0.272 $Y=0.0675 $X2=0.2845 $Y2=0.0675
r22 1 10 1e-05 $l=2e-09 $X=0.27 $Y=0.0675 $X2=0.272 $Y2=0.0675
.ends

.subckt PM_AND5x2_ASAP7_75t_R%11 vss 12 13 22 23 1 7 2 8 9
c1 1 vss 0.00404726f $X=0.432 $Y=0.0675
c2 2 vss 0.00419704f $X=0.648 $Y=0.0675
c3 7 vss 0.00190329f $X=0.4175 $Y=0.0675
c4 8 vss 0.00192025f $X=0.6335 $Y=0.0675
c5 9 vss 0.0199133f $X=0.4205 $Y=0.036
r1 23 21 0.0308642 $w=8.1e-08 $l=2.5e-09 $layer=N_src_drn $thickness=1e-09
+ $X=0.6653 $Y=0.0675 $X2=0.6625 $Y2=0.0675
r2 2 21 0.179012 $w=8.1e-08 $l=1.45e-08 $layer=N_src_drn $thickness=1e-09
+ $X=0.648 $Y=0.0675 $X2=0.6625 $Y2=0.0675
r3 8 2 0.179012 $w=8.1e-08 $l=1.45e-08 $layer=N_src_drn $thickness=1e-09
+ $X=0.6335 $Y=0.0675 $X2=0.648 $Y2=0.0675
r4 22 8 0.0308642 $w=8.1e-08 $l=2.5e-09 $layer=N_src_drn $thickness=1e-09
+ $X=0.6306 $Y=0.0675 $X2=0.6335 $Y2=0.0675
r5 2 18 19.3796 $a=3.24e-16 $layer=V0LISD $X=0.648 $Y=0.0675 $X2=0.648 $Y2=0.036
r6 17 18 8.97781 $w=1.3e-08 $l=3.85e-08 $layer=M1 $thickness=3.6e-08 $X=0.6095
+ $Y=0.036 $X2=0.648 $Y2=0.036
r7 16 17 16.2067 $w=1.3e-08 $l=6.95e-08 $layer=M1 $thickness=3.6e-08 $X=0.54
+ $Y=0.036 $X2=0.6095 $Y2=0.036
r8 15 16 16.2067 $w=1.3e-08 $l=6.95e-08 $layer=M1 $thickness=3.6e-08 $X=0.4705
+ $Y=0.036 $X2=0.54 $Y2=0.036
r9 14 15 8.97781 $w=1.3e-08 $l=3.85e-08 $layer=M1 $thickness=3.6e-08 $X=0.432
+ $Y=0.036 $X2=0.4705 $Y2=0.036
r10 9 14 2.68168 $w=1.3e-08 $l=1.15e-08 $layer=M1 $thickness=3.6e-08 $X=0.4205
+ $Y=0.036 $X2=0.432 $Y2=0.036
r11 1 14 19.3796 $a=3.24e-16 $layer=V0LISD $X=0.432 $Y=0.0675 $X2=0.432
+ $Y2=0.036
r12 13 11 0.0308642 $w=8.1e-08 $l=2.5e-09 $layer=N_src_drn $thickness=1e-09
+ $X=0.4493 $Y=0.0675 $X2=0.4465 $Y2=0.0675
r13 1 11 0.179012 $w=8.1e-08 $l=1.45e-08 $layer=N_src_drn $thickness=1e-09
+ $X=0.432 $Y=0.0675 $X2=0.4465 $Y2=0.0675
r14 7 1 0.179012 $w=8.1e-08 $l=1.45e-08 $layer=N_src_drn $thickness=1e-09
+ $X=0.4175 $Y=0.0675 $X2=0.432 $Y2=0.0675
r15 12 7 0.0308642 $w=8.1e-08 $l=2.5e-09 $layer=N_src_drn $thickness=1e-09
+ $X=0.4146 $Y=0.0675 $X2=0.4175 $Y2=0.0675
.ends

.subckt PM_AND5x2_ASAP7_75t_R%D vss 7 8 14 25 4 3 1 6 5
c1 1 vss 0.00733063f $X=0.2875 $Y=0.135
c2 3 vss 0.0607756f $X=0.297 $Y=0.0245
c3 4 vss 0.0511133f $X=0.351 $Y=0.135
c4 5 vss 0.00317006f $X=0.297 $Y=0.108
c5 6 vss 0.00272435f $X=0.297 $Y=0.198
c6 7 vss 0.00461487f $X=0.296 $Y=0.137
r1 6 23 6.16517 $w=1.44286e-08 $l=3.15e-08 $layer=M1 $thickness=3.6e-08
+ $X=0.297 $Y=0.198 $X2=0.297 $Y2=0.1665
r2 5 22 1.96775 $w=1.63333e-08 $l=1.35e-08 $layer=M1 $thickness=3.6e-08
+ $X=0.297 $Y=0.108 $X2=0.297 $Y2=0.1215
r3 25 26 16.6668 $w=2.1e-08 $l=4.9e-08 $layer=Gate_1 $thickness=5.6e-08
+ $X=0.351 $Y=0.0675 $X2=0.351 $Y2=0.1165
r4 4 20 6.74717 $w=2e-08 $layer=Gate_1 $thickness=5.2e-08 $X=0.351 $Y=0.135
+ $X2=0.351 $Y2=0.135
r5 4 26 6.46262 $w=2.04595e-08 $l=1.85e-08 $layer=Gate_1 $thickness=5.6e-08
+ $X=0.351 $Y=0.135 $X2=0.351 $Y2=0.1165
r6 7 16 19.3796 $a=3.24e-16 $layer=V0LIG $X=0.296 $Y=0.137 $X2=0.297 $Y2=0.135
r7 7 22 3.14806 $w=1.3e-08 $l=1.35e-08 $layer=M1 $thickness=3.6e-08 $X=0.296
+ $Y=0.137 $X2=0.297 $Y2=0.1215
r8 7 23 7.34548 $w=1.3e-08 $l=3.15e-08 $layer=M1 $thickness=3.6e-08 $X=0.296
+ $Y=0.137 $X2=0.297 $Y2=0.1665
r9 19 20 20.114 $w=1.57815e-08 $l=2.7e-08 $layer=LIG $thickness=4.8e-08
+ $X=0.324 $Y=0.135 $X2=0.351 $Y2=0.135
r10 17 19 17.097 $w=1.34914e-08 $l=1.75e-08 $layer=LIG $thickness=4.8e-08
+ $X=0.3065 $Y=0.135 $X2=0.324 $Y2=0.135
r11 16 17 3.01694 $w=2e-08 $l=9.5e-09 $layer=LIG $thickness=4.8e-08 $X=0.297
+ $Y=0.135 $X2=0.3065 $Y2=0.135
r12 1 16 3.01694 $w=2e-08 $l=9.5e-09 $layer=LIG $thickness=4.8e-08 $X=0.2875
+ $Y=0.135 $X2=0.297 $Y2=0.135
r13 14 13 14.6259 $w=2.1e-08 $l=4.3e-08 $layer=Gate_1 $thickness=5.6e-08
+ $X=0.297 $Y=0.2025 $X2=0.297 $Y2=0.1595
r14 12 13 2.89117 $w=2.1e-08 $l=8.5e-09 $layer=Gate_1 $thickness=5.6e-08
+ $X=0.297 $Y=0.151 $X2=0.297 $Y2=0.1595
r15 11 12 5.61228 $w=2.0375e-08 $l=1.6e-08 $layer=Gate_1 $thickness=5.6e-08
+ $X=0.297 $Y=0.135 $X2=0.297 $Y2=0.151
r16 11 17 3.73024 $w=2e-08 $l=9.5e-09 $layer=Gate_1 $thickness=5.5619e-08
+ $X=0.297 $Y=0.135 $X2=0.3065 $Y2=0.135
r17 11 16 6.4296 $w=2e-08 $layer=Gate_1 $thickness=5.22105e-08 $X=0.297
+ $Y=0.135 $X2=0.297 $Y2=0.135
r18 10 11 5.61228 $w=2.0375e-08 $l=1.6e-08 $layer=Gate_1 $thickness=5.6e-08
+ $X=0.297 $Y=0.119 $X2=0.297 $Y2=0.135
r19 9 10 2.89117 $w=2.1e-08 $l=8.5e-09 $layer=Gate_1 $thickness=5.6e-08
+ $X=0.297 $Y=0.1105 $X2=0.297 $Y2=0.119
r20 8 9 14.6259 $w=2.1e-08 $l=4.3e-08 $layer=Gate_1 $thickness=5.6e-08 $X=0.297
+ $Y=0.0675 $X2=0.297 $Y2=0.1105
r21 8 3 14.6259 $w=2.1e-08 $l=4.3e-08 $layer=Gate_1 $thickness=5.6e-08 $X=0.297
+ $Y=0.0675 $X2=0.297 $Y2=0.0245
.ends

.subckt PM_AND5x2_ASAP7_75t_R%C vss 22 8 14 25 3 4 1 6 7 5
c1 1 vss 0.00530404f $X=0.4495 $Y=0.135
c2 3 vss 0.00926228f $X=0.405 $Y=0.135
c3 4 vss 0.065397f $X=0.459 $Y=0.0245
c4 5 vss 0.00328599f $X=0.459 $Y=0.108
c5 6 vss 0.00348122f $X=0.459 $Y=0.198
c6 7 vss 0.00475329f $X=0.459 $Y=0.1215
r1 6 23 6.16517 $w=1.44286e-08 $l=3.15e-08 $layer=M1 $thickness=3.6e-08
+ $X=0.459 $Y=0.198 $X2=0.459 $Y2=0.1665
r2 5 7 1.96775 $w=1.63333e-08 $l=1.35e-08 $layer=M1 $thickness=3.6e-08 $X=0.459
+ $Y=0.108 $X2=0.459 $Y2=0.1215
r3 25 26 16.6668 $w=2.1e-08 $l=4.9e-08 $layer=Gate_1 $thickness=5.6e-08
+ $X=0.405 $Y=0.0675 $X2=0.405 $Y2=0.1165
r4 3 19 6.74717 $w=2e-08 $layer=Gate_1 $thickness=5.2e-08 $X=0.405 $Y=0.135
+ $X2=0.405 $Y2=0.135
r5 3 26 6.46262 $w=2.04595e-08 $l=1.85e-08 $layer=Gate_1 $thickness=5.6e-08
+ $X=0.405 $Y=0.135 $X2=0.405 $Y2=0.1165
r6 22 23 7.34548 $w=1.3e-08 $l=3.15e-08 $layer=M1 $thickness=3.6e-08 $X=0.458
+ $Y=0.137 $X2=0.459 $Y2=0.1665
r7 22 7 3.14806 $w=1.3e-08 $l=1.35e-08 $layer=M1 $thickness=3.6e-08 $X=0.458
+ $Y=0.137 $X2=0.459 $Y2=0.1215
r8 18 19 20.114 $w=1.57815e-08 $l=2.7e-08 $layer=LIG $thickness=4.8e-08
+ $X=0.432 $Y=0.135 $X2=0.405 $Y2=0.135
r9 16 17 3.01694 $w=2e-08 $l=9.5e-09 $layer=LIG $thickness=4.8e-08 $X=0.459
+ $Y=0.135 $X2=0.4685 $Y2=0.135
r10 22 16 19.3796 $a=3.24e-16 $layer=V0LIG $X=0.458 $Y=0.137 $X2=0.459 $Y2=0.135
r11 1 16 3.01694 $w=2e-08 $l=9.5e-09 $layer=LIG $thickness=4.8e-08 $X=0.4495
+ $Y=0.135 $X2=0.459 $Y2=0.135
r12 1 18 17.097 $w=1.34914e-08 $l=1.75e-08 $layer=LIG $thickness=4.8e-08
+ $X=0.4495 $Y=0.135 $X2=0.432 $Y2=0.135
r13 14 13 14.6259 $w=2.1e-08 $l=4.3e-08 $layer=Gate_1 $thickness=5.6e-08
+ $X=0.459 $Y=0.2025 $X2=0.459 $Y2=0.1595
r14 12 13 2.89117 $w=2.1e-08 $l=8.5e-09 $layer=Gate_1 $thickness=5.6e-08
+ $X=0.459 $Y=0.151 $X2=0.459 $Y2=0.1595
r15 11 12 5.61228 $w=2.0375e-08 $l=1.6e-08 $layer=Gate_1 $thickness=5.6e-08
+ $X=0.459 $Y=0.135 $X2=0.459 $Y2=0.151
r16 11 17 3.73024 $w=2e-08 $l=9.5e-09 $layer=Gate_1 $thickness=5.5619e-08
+ $X=0.459 $Y=0.135 $X2=0.4685 $Y2=0.135
r17 11 16 6.4296 $w=2e-08 $layer=Gate_1 $thickness=5.22105e-08 $X=0.459
+ $Y=0.135 $X2=0.459 $Y2=0.135
r18 10 11 5.61228 $w=2.0375e-08 $l=1.6e-08 $layer=Gate_1 $thickness=5.6e-08
+ $X=0.459 $Y=0.119 $X2=0.459 $Y2=0.135
r19 9 10 2.89117 $w=2.1e-08 $l=8.5e-09 $layer=Gate_1 $thickness=5.6e-08
+ $X=0.459 $Y=0.1105 $X2=0.459 $Y2=0.119
r20 8 9 14.6259 $w=2.1e-08 $l=4.3e-08 $layer=Gate_1 $thickness=5.6e-08 $X=0.459
+ $Y=0.0675 $X2=0.459 $Y2=0.1105
r21 8 4 14.6259 $w=2.1e-08 $l=4.3e-08 $layer=Gate_1 $thickness=5.6e-08 $X=0.459
+ $Y=0.0675 $X2=0.459 $Y2=0.0245
.ends

.subckt PM_AND5x2_ASAP7_75t_R%A vss 26 8 14 23 1 3 4 7 6 5
c1 1 vss 0.00398288f $X=0.783 $Y=0.135
c2 3 vss 0.00890006f $X=0.729 $Y=0.135
c3 4 vss 0.0645478f $X=0.783 $Y=0.0245
c4 5 vss 0.00229736f $X=0.729 $Y=0.108
c5 6 vss 0.00285036f $X=0.729 $Y=0.198
c6 7 vss 0.00422581f $X=0.729 $Y=0.1215
r1 6 27 6.16517 $w=1.44286e-08 $l=3.15e-08 $layer=M1 $thickness=3.6e-08
+ $X=0.729 $Y=0.198 $X2=0.729 $Y2=0.1665
r2 5 7 1.96775 $w=1.63333e-08 $l=1.35e-08 $layer=M1 $thickness=3.6e-08 $X=0.729
+ $Y=0.108 $X2=0.729 $Y2=0.1215
r3 26 27 7.34548 $w=1.3e-08 $l=3.15e-08 $layer=M1 $thickness=3.6e-08 $X=0.728
+ $Y=0.137 $X2=0.729 $Y2=0.1665
r4 26 7 3.14806 $w=1.3e-08 $l=1.35e-08 $layer=M1 $thickness=3.6e-08 $X=0.728
+ $Y=0.137 $X2=0.729 $Y2=0.1215
r5 23 24 16.6668 $w=2.1e-08 $l=4.9e-08 $layer=Gate_1 $thickness=5.6e-08
+ $X=0.729 $Y=0.0675 $X2=0.729 $Y2=0.1165
r6 3 18 6.4296 $w=2e-08 $layer=Gate_1 $thickness=5.22105e-08 $X=0.729 $Y=0.135
+ $X2=0.729 $Y2=0.135
r7 3 24 6.46262 $w=2.04595e-08 $l=1.85e-08 $layer=Gate_1 $thickness=5.6e-08
+ $X=0.729 $Y=0.135 $X2=0.729 $Y2=0.1165
r8 18 19 3.01694 $w=2e-08 $l=9.5e-09 $layer=LIG $thickness=4.8e-08 $X=0.729
+ $Y=0.135 $X2=0.7385 $Y2=0.135
r9 26 18 19.3796 $a=3.24e-16 $layer=V0LIG $X=0.728 $Y=0.137 $X2=0.729 $Y2=0.135
r10 16 19 17.097 $w=1.34914e-08 $l=1.75e-08 $layer=LIG $thickness=4.8e-08
+ $X=0.756 $Y=0.135 $X2=0.7385 $Y2=0.135
r11 1 11 6.74717 $w=2e-08 $layer=Gate_1 $thickness=5.2e-08 $X=0.783 $Y=0.135
+ $X2=0.783 $Y2=0.135
r12 1 16 20.114 $w=1.57815e-08 $l=2.7e-08 $layer=LIG $thickness=4.8e-08
+ $X=0.783 $Y=0.135 $X2=0.756 $Y2=0.135
r13 14 13 14.6259 $w=2.1e-08 $l=4.3e-08 $layer=Gate_1 $thickness=5.6e-08
+ $X=0.783 $Y=0.2025 $X2=0.783 $Y2=0.1595
r14 12 13 2.89117 $w=2.1e-08 $l=8.5e-09 $layer=Gate_1 $thickness=5.6e-08
+ $X=0.783 $Y=0.151 $X2=0.783 $Y2=0.1595
r15 11 12 5.61228 $w=2.0375e-08 $l=1.6e-08 $layer=Gate_1 $thickness=5.6e-08
+ $X=0.783 $Y=0.135 $X2=0.783 $Y2=0.151
r16 10 11 5.61228 $w=2.0375e-08 $l=1.6e-08 $layer=Gate_1 $thickness=5.6e-08
+ $X=0.783 $Y=0.119 $X2=0.783 $Y2=0.135
r17 9 10 2.89117 $w=2.1e-08 $l=8.5e-09 $layer=Gate_1 $thickness=5.6e-08
+ $X=0.783 $Y=0.1105 $X2=0.783 $Y2=0.119
r18 8 9 14.6259 $w=2.1e-08 $l=4.3e-08 $layer=Gate_1 $thickness=5.6e-08 $X=0.783
+ $Y=0.0675 $X2=0.783 $Y2=0.1105
r19 8 4 14.6259 $w=2.1e-08 $l=4.3e-08 $layer=Gate_1 $thickness=5.6e-08 $X=0.783
+ $Y=0.0675 $X2=0.783 $Y2=0.0245
.ends

.subckt PM_AND5x2_ASAP7_75t_R%Y vss 22 16 17 28 29 8 2 7
c1 1 vss 0.00901746f $X=0.972 $Y=0.0675
c2 2 vss 0.00893608f $X=0.972 $Y=0.2025
c3 7 vss 0.00441937f $X=0.9575 $Y=0.0675
c4 8 vss 0.00441947f $X=0.9575 $Y=0.2025
c5 9 vss 0.00291615f $X=1.053 $Y=0.036
c6 10 vss 0.00291572f $X=1.053 $Y=0.234
c7 11 vss 0.00874769f $X=0.9605 $Y=0.036
c8 12 vss 0.00861728f $X=0.9605 $Y=0.234
c9 13 vss 0.00857736f $X=1.053 $Y=0.0855
r1 29 27 0.0308642 $w=8.1e-08 $l=2.5e-09 $layer=P_src_drn $thickness=1e-09
+ $X=0.9893 $Y=0.2025 $X2=0.9865 $Y2=0.2025
r2 2 27 0.179012 $w=8.1e-08 $l=1.45e-08 $layer=P_src_drn $thickness=1e-09
+ $X=0.972 $Y=0.2025 $X2=0.9865 $Y2=0.2025
r3 8 2 0.179012 $w=8.1e-08 $l=1.45e-08 $layer=P_src_drn $thickness=1e-09
+ $X=0.9575 $Y=0.2025 $X2=0.972 $Y2=0.2025
r4 28 8 0.0308642 $w=8.1e-08 $l=2.5e-09 $layer=P_src_drn $thickness=1e-09
+ $X=0.9546 $Y=0.2025 $X2=0.9575 $Y2=0.2025
r5 2 24 19.3796 $a=3.24e-16 $layer=V0LISD $X=0.972 $Y=0.2025 $X2=0.972 $Y2=0.234
r6 24 25 9.44419 $w=1.3e-08 $l=4.05e-08 $layer=M1 $thickness=3.6e-08 $X=0.972
+ $Y=0.234 $X2=1.0125 $Y2=0.234
r7 12 24 2.68168 $w=1.3e-08 $l=1.15e-08 $layer=M1 $thickness=3.6e-08 $X=0.9605
+ $Y=0.234 $X2=0.972 $Y2=0.234
r8 10 23 9.4274 $w=1.48568e-08 $l=4.75e-08 $layer=M1 $thickness=3.6e-08
+ $X=1.053 $Y=0.234 $X2=1.053 $Y2=0.1865
r9 10 25 7.79507 $w=1.41111e-08 $l=4.05e-08 $layer=M1 $thickness=3.6e-08
+ $X=1.053 $Y=0.234 $X2=1.0125 $Y2=0.234
r10 22 23 9.0944 $w=1.3e-08 $l=3.9e-08 $layer=M1 $thickness=3.6e-08 $X=1.053
+ $Y=0.1475 $X2=1.053 $Y2=0.1865
r11 22 21 0.46638 $w=1.3e-08 $l=2e-09 $layer=M1 $thickness=3.6e-08 $X=1.053
+ $Y=0.1475 $X2=1.053 $Y2=0.1455
r12 20 21 2.44849 $w=1.3e-08 $l=1.05e-08 $layer=M1 $thickness=3.6e-08 $X=1.053
+ $Y=0.135 $X2=1.053 $Y2=0.1455
r13 13 20 11.5429 $w=1.3e-08 $l=4.95e-08 $layer=M1 $thickness=3.6e-08 $X=1.053
+ $Y=0.0855 $X2=1.053 $Y2=0.135
r14 9 19 7.79507 $w=1.41111e-08 $l=4.05e-08 $layer=M1 $thickness=3.6e-08
+ $X=1.053 $Y=0.036 $X2=1.0125 $Y2=0.036
r15 9 13 9.89378 $w=1.47818e-08 $l=4.95e-08 $layer=M1 $thickness=3.6e-08
+ $X=1.053 $Y=0.036 $X2=1.053 $Y2=0.0855
r16 18 19 9.44419 $w=1.3e-08 $l=4.05e-08 $layer=M1 $thickness=3.6e-08 $X=0.972
+ $Y=0.036 $X2=1.0125 $Y2=0.036
r17 11 18 2.68168 $w=1.3e-08 $l=1.15e-08 $layer=M1 $thickness=3.6e-08 $X=0.9605
+ $Y=0.036 $X2=0.972 $Y2=0.036
r18 1 18 19.3796 $a=3.24e-16 $layer=V0LISD $X=0.972 $Y=0.0675 $X2=0.972
+ $Y2=0.036
r19 17 15 0.0308642 $w=8.1e-08 $l=2.5e-09 $layer=N_src_drn $thickness=1e-09
+ $X=0.9893 $Y=0.0675 $X2=0.9865 $Y2=0.0675
r20 1 15 0.179012 $w=8.1e-08 $l=1.45e-08 $layer=N_src_drn $thickness=1e-09
+ $X=0.972 $Y=0.0675 $X2=0.9865 $Y2=0.0675
r21 7 1 0.179012 $w=8.1e-08 $l=1.45e-08 $layer=N_src_drn $thickness=1e-09
+ $X=0.9575 $Y=0.0675 $X2=0.972 $Y2=0.0675
r22 16 7 0.0308642 $w=8.1e-08 $l=2.5e-09 $layer=N_src_drn $thickness=1e-09
+ $X=0.9546 $Y=0.0675 $X2=0.9575 $Y2=0.0675
.ends

.subckt PM_AND5x2_ASAP7_75t_R%12 vss 15 30 31 33 11 1 10 13 2 12 3
c1 1 vss 0.0050546f $X=0.594 $Y=0.0675
c2 2 vss 0.00333503f $X=0.702 $Y=0.0675
c3 3 vss 0.00517853f $X=0.81 $Y=0.0675
c4 10 vss 0.0357195f $X=0.596 $Y=0.0675
c5 11 vss 0.0020386f $X=0.6875 $Y=0.0675
c6 12 vss 0.0359397f $X=0.7955 $Y=0.0675
c7 13 vss 0.00359731f $X=0.5825 $Y=0.072
r1 12 3 0.154321 $w=8.1e-08 $l=1.25e-08 $layer=N_src_drn $thickness=1e-09
+ $X=0.7955 $Y=0.0675 $X2=0.81 $Y2=0.0675
r2 33 12 0.0308642 $w=8.1e-08 $l=2.5e-09 $layer=N_src_drn $thickness=1e-09
+ $X=0.7926 $Y=0.0675 $X2=0.7955 $Y2=0.0675
r3 31 29 0.0308642 $w=8.1e-08 $l=2.5e-09 $layer=N_src_drn $thickness=1e-09
+ $X=0.7193 $Y=0.0675 $X2=0.7165 $Y2=0.0675
r4 2 29 0.179012 $w=8.1e-08 $l=1.45e-08 $layer=N_src_drn $thickness=1e-09
+ $X=0.702 $Y=0.0675 $X2=0.7165 $Y2=0.0675
r5 11 2 0.179012 $w=8.1e-08 $l=1.45e-08 $layer=N_src_drn $thickness=1e-09
+ $X=0.6875 $Y=0.0675 $X2=0.702 $Y2=0.0675
r6 30 11 0.0308642 $w=8.1e-08 $l=2.5e-09 $layer=N_src_drn $thickness=1e-09
+ $X=0.6846 $Y=0.0675 $X2=0.6875 $Y2=0.0675
r7 3 26 19.3796 $a=3.24e-16 $layer=V0LISD $X=0.81 $Y=0.0675 $X2=0.81 $Y2=0.072
r8 2 21 19.3796 $a=3.24e-16 $layer=V0LISD $X=0.702 $Y=0.0675 $X2=0.702 $Y2=0.072
r9 25 26 7.22888 $w=1.3e-08 $l=3.1e-08 $layer=M1 $thickness=3.6e-08 $X=0.779
+ $Y=0.072 $X2=0.81 $Y2=0.072
r10 24 25 6.8791 $w=1.3e-08 $l=2.95e-08 $layer=M1 $thickness=3.6e-08 $X=0.7495
+ $Y=0.072 $X2=0.779 $Y2=0.072
r11 23 24 4.31401 $w=1.3e-08 $l=1.85e-08 $layer=M1 $thickness=3.6e-08 $X=0.731
+ $Y=0.072 $X2=0.7495 $Y2=0.072
r12 22 23 3.61444 $w=1.3e-08 $l=1.55e-08 $layer=M1 $thickness=3.6e-08 $X=0.7155
+ $Y=0.072 $X2=0.731 $Y2=0.072
r13 21 22 3.14806 $w=1.3e-08 $l=1.35e-08 $layer=M1 $thickness=3.6e-08 $X=0.702
+ $Y=0.072 $X2=0.7155 $Y2=0.072
r14 20 21 5.71315 $w=1.3e-08 $l=2.45e-08 $layer=M1 $thickness=3.6e-08 $X=0.6775
+ $Y=0.072 $X2=0.702 $Y2=0.072
r15 19 20 7.34548 $w=1.3e-08 $l=3.15e-08 $layer=M1 $thickness=3.6e-08 $X=0.646
+ $Y=0.072 $X2=0.6775 $Y2=0.072
r16 18 19 6.8791 $w=1.3e-08 $l=2.95e-08 $layer=M1 $thickness=3.6e-08 $X=0.6165
+ $Y=0.072 $X2=0.646 $Y2=0.072
r17 17 18 4.31401 $w=1.3e-08 $l=1.85e-08 $layer=M1 $thickness=3.6e-08 $X=0.598
+ $Y=0.072 $X2=0.6165 $Y2=0.072
r18 16 17 2.09871 $w=1.3e-08 $l=9e-09 $layer=M1 $thickness=3.6e-08 $X=0.589
+ $Y=0.072 $X2=0.598 $Y2=0.072
r19 13 16 1.51573 $w=1.3e-08 $l=6.5e-09 $layer=M1 $thickness=3.6e-08 $X=0.5825
+ $Y=0.072 $X2=0.589 $Y2=0.072
r20 1 17 19.3796 $a=3.24e-16 $layer=V0LISD $X=0.594 $Y=0.0675 $X2=0.598
+ $Y2=0.072
r21 15 14 0.0308642 $w=8.1e-08 $l=2.5e-09 $layer=N_src_drn $thickness=1e-09
+ $X=0.6113 $Y=0.0675 $X2=0.6085 $Y2=0.0675
r22 10 14 0.154321 $w=8.1e-08 $l=1.25e-08 $layer=N_src_drn $thickness=1e-09
+ $X=0.596 $Y=0.0675 $X2=0.6085 $Y2=0.0675
r23 1 10 1e-05 $l=2e-09 $X=0.594 $Y=0.0675 $X2=0.596 $Y2=0.0675
.ends

.subckt PM_AND5x2_ASAP7_75t_R%8 vss 37 43 55 59 94 95 97 99 101 103 105 3 32 24
+ 5 4 25 26 6 27 8 7 23 28 30 35 34 33 31 1 36 21 22
c1 1 vss 0.0130749f $X=0.936 $Y=0.135
c2 3 vss 0.00947572f $X=0.162 $Y=0.2025
c3 4 vss 0.00865348f $X=0.27 $Y=0.2025
c4 5 vss 0.00768349f $X=0.432 $Y=0.2025
c5 6 vss 0.00856313f $X=0.594 $Y=0.2025
c6 7 vss 0.00433702f $X=0.756 $Y=0.0675
c7 8 vss 0.00709798f $X=0.756 $Y=0.2025
c8 21 vss 0.0818219f $X=0.945 $Y=0.0245
c9 22 vss 0.0824847f $X=0.999 $Y=0.135
c10 23 vss 0.0031483f $X=0.7415 $Y=0.0675
c11 24 vss 0.0394398f $X=0.1475 $Y=0.2025
c12 25 vss 0.0395712f $X=0.272 $Y=0.2025
c13 26 vss 0.00481075f $X=0.434 $Y=0.2025
c14 27 vss 0.0395204f $X=0.596 $Y=0.2025
c15 28 vss 0.00463464f $X=0.758 $Y=0.2025
c16 29 vss 0.00321117f $X=0.891 $Y=0.036
c17 30 vss 0.00052982f $X=0.891 $Y=0.135
c18 31 vss 0.00333579f $X=0.891 $Y=0.234
c19 32 vss 0.0703997f $X=0.853 $Y=0.234
c20 33 vss 0.0127551f $X=0.853 $Y=0.036
c21 34 vss 0.00381331f $X=0.891 $Y=0.1215
c22 35 vss 0.00429038f $X=0.891 $Y=0.1665
c23 36 vss 0.00139062f $X=0.9095 $Y=0.135
r1 24 3 0.154321 $w=8.1e-08 $l=1.25e-08 $layer=P_src_drn $thickness=1e-09
+ $X=0.1475 $Y=0.2025 $X2=0.162 $Y2=0.2025
r2 105 24 0.0308642 $w=8.1e-08 $l=2.5e-09 $layer=P_src_drn $thickness=1e-09
+ $X=0.1446 $Y=0.2025 $X2=0.1475 $Y2=0.2025
r3 103 102 0.0308642 $w=8.1e-08 $l=2.5e-09 $layer=P_src_drn $thickness=1e-09
+ $X=0.2873 $Y=0.2025 $X2=0.2845 $Y2=0.2025
r4 25 102 0.154321 $w=8.1e-08 $l=1.25e-08 $layer=P_src_drn $thickness=1e-09
+ $X=0.272 $Y=0.2025 $X2=0.2845 $Y2=0.2025
r5 101 100 0.0308642 $w=8.1e-08 $l=2.5e-09 $layer=P_src_drn $thickness=1e-09
+ $X=0.4493 $Y=0.2025 $X2=0.4465 $Y2=0.2025
r6 26 100 0.154321 $w=8.1e-08 $l=1.25e-08 $layer=P_src_drn $thickness=1e-09
+ $X=0.434 $Y=0.2025 $X2=0.4465 $Y2=0.2025
r7 99 98 0.0308642 $w=8.1e-08 $l=2.5e-09 $layer=P_src_drn $thickness=1e-09
+ $X=0.6113 $Y=0.2025 $X2=0.6085 $Y2=0.2025
r8 27 98 0.154321 $w=8.1e-08 $l=1.25e-08 $layer=P_src_drn $thickness=1e-09
+ $X=0.596 $Y=0.2025 $X2=0.6085 $Y2=0.2025
r9 97 96 0.0308642 $w=8.1e-08 $l=2.5e-09 $layer=P_src_drn $thickness=1e-09
+ $X=0.7733 $Y=0.2025 $X2=0.7705 $Y2=0.2025
r10 28 96 0.154321 $w=8.1e-08 $l=1.25e-08 $layer=P_src_drn $thickness=1e-09
+ $X=0.758 $Y=0.2025 $X2=0.7705 $Y2=0.2025
r11 95 93 0.0308642 $w=8.1e-08 $l=2.5e-09 $layer=N_src_drn $thickness=1e-09
+ $X=0.7733 $Y=0.0675 $X2=0.7705 $Y2=0.0675
r12 7 93 0.179012 $w=8.1e-08 $l=1.45e-08 $layer=N_src_drn $thickness=1e-09
+ $X=0.756 $Y=0.0675 $X2=0.7705 $Y2=0.0675
r13 23 7 0.179012 $w=8.1e-08 $l=1.45e-08 $layer=N_src_drn $thickness=1e-09
+ $X=0.7415 $Y=0.0675 $X2=0.756 $Y2=0.0675
r14 94 23 0.0308642 $w=8.1e-08 $l=2.5e-09 $layer=N_src_drn $thickness=1e-09
+ $X=0.7386 $Y=0.0675 $X2=0.7415 $Y2=0.0675
r15 3 90 19.3796 $a=3.24e-16 $layer=V0LISD $X=0.162 $Y=0.2025 $X2=0.162
+ $Y2=0.234
r16 4 85 19.3796 $a=3.24e-16 $layer=V0LISD $X=0.27 $Y=0.2025 $X2=0.274 $Y2=0.234
r17 5 83 19.3796 $a=3.24e-16 $layer=V0LISD $X=0.432 $Y=0.2025 $X2=0.432
+ $Y2=0.234
r18 6 75 19.3796 $a=3.24e-16 $layer=V0LISD $X=0.594 $Y=0.2025 $X2=0.598
+ $Y2=0.234
r19 8 73 19.3796 $a=3.24e-16 $layer=V0LISD $X=0.756 $Y=0.2025 $X2=0.752
+ $Y2=0.234
r20 7 68 19.3796 $a=3.24e-16 $layer=V0LISD $X=0.756 $Y=0.0675 $X2=0.756
+ $Y2=0.036
r21 90 91 12.0093 $w=1.3e-08 $l=5.15e-08 $layer=M1 $thickness=3.6e-08 $X=0.162
+ $Y=0.234 $X2=0.2135 $Y2=0.234
r22 87 88 1.51573 $w=1.3e-08 $l=6.5e-09 $layer=M1 $thickness=3.6e-08 $X=0.2585
+ $Y=0.234 $X2=0.265 $Y2=0.234
r23 87 91 10.4935 $w=1.3e-08 $l=4.5e-08 $layer=M1 $thickness=3.6e-08 $X=0.2585
+ $Y=0.234 $X2=0.2135 $Y2=0.234
r24 85 86 4.31401 $w=1.3e-08 $l=1.85e-08 $layer=M1 $thickness=3.6e-08 $X=0.274
+ $Y=0.234 $X2=0.2925 $Y2=0.234
r25 85 88 2.09871 $w=1.3e-08 $l=9e-09 $layer=M1 $thickness=3.6e-08 $X=0.274
+ $Y=0.234 $X2=0.265 $Y2=0.234
r26 83 84 3.14806 $w=1.3e-08 $l=1.35e-08 $layer=M1 $thickness=3.6e-08 $X=0.432
+ $Y=0.234 $X2=0.4455 $Y2=0.234
r27 82 83 15.7403 $w=1.3e-08 $l=6.75e-08 $layer=M1 $thickness=3.6e-08 $X=0.3645
+ $Y=0.234 $X2=0.432 $Y2=0.234
r28 82 86 16.7897 $w=1.3e-08 $l=7.2e-08 $layer=M1 $thickness=3.6e-08 $X=0.3645
+ $Y=0.234 $X2=0.2925 $Y2=0.234
r29 81 84 5.36336 $w=1.3e-08 $l=2.3e-08 $layer=M1 $thickness=3.6e-08 $X=0.4685
+ $Y=0.234 $X2=0.4455 $Y2=0.234
r30 80 81 5.82974 $w=1.3e-08 $l=2.5e-08 $layer=M1 $thickness=3.6e-08 $X=0.4935
+ $Y=0.234 $X2=0.4685 $Y2=0.234
r31 79 80 10.8433 $w=1.3e-08 $l=4.65e-08 $layer=M1 $thickness=3.6e-08 $X=0.54
+ $Y=0.234 $X2=0.4935 $Y2=0.234
r32 77 78 1.51573 $w=1.3e-08 $l=6.5e-09 $layer=M1 $thickness=3.6e-08 $X=0.5825
+ $Y=0.234 $X2=0.589 $Y2=0.234
r33 77 79 9.91056 $w=1.3e-08 $l=4.25e-08 $layer=M1 $thickness=3.6e-08 $X=0.5825
+ $Y=0.234 $X2=0.54 $Y2=0.234
r34 75 76 4.31401 $w=1.3e-08 $l=1.85e-08 $layer=M1 $thickness=3.6e-08 $X=0.598
+ $Y=0.234 $X2=0.6165 $Y2=0.234
r35 75 78 2.09871 $w=1.3e-08 $l=9e-09 $layer=M1 $thickness=3.6e-08 $X=0.598
+ $Y=0.234 $X2=0.589 $Y2=0.234
r36 74 76 13.6416 $w=1.3e-08 $l=5.85e-08 $layer=M1 $thickness=3.6e-08 $X=0.675
+ $Y=0.234 $X2=0.6165 $Y2=0.234
r37 72 73 4.31401 $w=1.3e-08 $l=1.85e-08 $layer=M1 $thickness=3.6e-08 $X=0.7335
+ $Y=0.234 $X2=0.752 $Y2=0.234
r38 72 74 13.6416 $w=1.3e-08 $l=5.85e-08 $layer=M1 $thickness=3.6e-08 $X=0.7335
+ $Y=0.234 $X2=0.675 $Y2=0.234
r39 70 71 7.81186 $w=1.3e-08 $l=3.35e-08 $layer=M1 $thickness=3.6e-08 $X=0.761
+ $Y=0.234 $X2=0.7945 $Y2=0.234
r40 70 73 2.09871 $w=1.3e-08 $l=9e-09 $layer=M1 $thickness=3.6e-08 $X=0.761
+ $Y=0.234 $X2=0.752 $Y2=0.234
r41 32 71 13.6416 $w=1.3e-08 $l=5.85e-08 $layer=M1 $thickness=3.6e-08 $X=0.853
+ $Y=0.234 $X2=0.7945 $Y2=0.234
r42 68 69 8.97781 $w=1.3e-08 $l=3.85e-08 $layer=M1 $thickness=3.6e-08 $X=0.756
+ $Y=0.036 $X2=0.7945 $Y2=0.036
r43 33 69 13.6416 $w=1.3e-08 $l=5.85e-08 $layer=M1 $thickness=3.6e-08 $X=0.853
+ $Y=0.036 $X2=0.7945 $Y2=0.036
r44 31 66 2.5483 $w=1.79e-08 $l=1.8e-08 $layer=M1 $thickness=3.6e-08 $X=0.891
+ $Y=0.234 $X2=0.891 $Y2=0.216
r45 31 32 7.2121 $w=1.41842e-08 $l=3.8e-08 $layer=M1 $thickness=3.6e-08
+ $X=0.891 $Y=0.234 $X2=0.853 $Y2=0.234
r46 29 64 2.5483 $w=1.79e-08 $l=1.8e-08 $layer=M1 $thickness=3.6e-08 $X=0.891
+ $Y=0.036 $X2=0.891 $Y2=0.054
r47 29 33 7.2121 $w=1.41842e-08 $l=3.8e-08 $layer=M1 $thickness=3.6e-08
+ $X=0.891 $Y=0.036 $X2=0.853 $Y2=0.036
r48 65 66 4.19742 $w=1.3e-08 $l=1.8e-08 $layer=M1 $thickness=3.6e-08 $X=0.891
+ $Y=0.198 $X2=0.891 $Y2=0.216
r49 35 65 7.34548 $w=1.3e-08 $l=3.15e-08 $layer=M1 $thickness=3.6e-08 $X=0.891
+ $Y=0.1665 $X2=0.891 $Y2=0.198
r50 63 64 4.19742 $w=1.3e-08 $l=1.8e-08 $layer=M1 $thickness=3.6e-08 $X=0.891
+ $Y=0.072 $X2=0.891 $Y2=0.054
r51 62 63 4.19742 $w=1.3e-08 $l=1.8e-08 $layer=M1 $thickness=3.6e-08 $X=0.891
+ $Y=0.09 $X2=0.891 $Y2=0.072
r52 61 62 4.19742 $w=1.3e-08 $l=1.8e-08 $layer=M1 $thickness=3.6e-08 $X=0.891
+ $Y=0.108 $X2=0.891 $Y2=0.09
r53 34 61 3.14806 $w=1.3e-08 $l=1.35e-08 $layer=M1 $thickness=3.6e-08 $X=0.891
+ $Y=0.1215 $X2=0.891 $Y2=0.108
r54 30 36 3.1337 $w=1.54324e-08 $l=1.85e-08 $layer=M1 $thickness=3.6e-08
+ $X=0.891 $Y=0.135 $X2=0.9095 $Y2=0.135
r55 30 34 1.96775 $w=1.63333e-08 $l=1.35e-08 $layer=M1 $thickness=3.6e-08
+ $X=0.891 $Y=0.135 $X2=0.891 $Y2=0.1215
r56 30 35 6.16517 $w=1.44286e-08 $l=3.15e-08 $layer=M1 $thickness=3.6e-08
+ $X=0.891 $Y=0.135 $X2=0.891 $Y2=0.1665
r57 59 58 14.6259 $w=2.1e-08 $l=4.3e-08 $layer=Gate_1 $thickness=5.6e-08
+ $X=0.999 $Y=0.2025 $X2=0.999 $Y2=0.1595
r58 57 58 2.7211 $w=2.1e-08 $l=8e-09 $layer=Gate_1 $thickness=5.6e-08 $X=0.999
+ $Y=0.1515 $X2=0.999 $Y2=0.1595
r59 55 56 14.6259 $w=2.1e-08 $l=4.3e-08 $layer=Gate_1 $thickness=5.6e-08
+ $X=0.999 $Y=0.0675 $X2=0.999 $Y2=0.1105
r60 53 56 2.7211 $w=2.1e-08 $l=8e-09 $layer=Gate_1 $thickness=5.6e-08 $X=0.999
+ $Y=0.1185 $X2=0.999 $Y2=0.1105
r61 22 49 6.54019 $w=2.09524e-08 $layer=Gate_1 $thickness=5.21905e-08 $X=0.999
+ $Y=0.135 $X2=0.999 $Y2=0.135
r62 22 53 5.79936 $w=2.03333e-08 $l=1.65e-08 $layer=Gate_1 $thickness=5.6e-08
+ $X=0.999 $Y=0.135 $X2=0.999 $Y2=0.1185
r63 22 57 5.79936 $w=2.03333e-08 $l=1.65e-08 $layer=Gate_1 $thickness=5.6e-08
+ $X=0.999 $Y=0.135 $X2=0.999 $Y2=0.1515
r64 36 51 4.31401 $w=1.3e-08 $l=1.85e-08 $layer=M1 $thickness=3.6e-08 $X=0.9095
+ $Y=0.135 $X2=0.928 $Y2=0.135
r65 48 49 12.6539 $w=1.77815e-08 $l=2.7e-08 $layer=LIG $thickness=4.8e-08
+ $X=0.972 $Y=0.135 $X2=0.999 $Y2=0.135
r66 47 51 19.3796 $a=3.24e-16 $layer=V0LIG $X=0.927 $Y=0.135 $X2=0.928 $Y2=0.135
r67 45 48 12.3927 $w=1.76192e-08 $l=2.6e-08 $layer=LIG $thickness=4.8e-08
+ $X=0.946 $Y=0.135 $X2=0.972 $Y2=0.135
r68 1 45 2.6116 $w=2.2e-08 $l=1e-08 $layer=LIG $thickness=4.8e-08 $X=0.936
+ $Y=0.135 $X2=0.946 $Y2=0.135
r69 1 47 4.98695 $w=1.60444e-08 $l=9e-09 $layer=LIG $thickness=4.8e-08 $X=0.936
+ $Y=0.135 $X2=0.927 $Y2=0.135
r70 43 42 14.6259 $w=2.1e-08 $l=4.3e-08 $layer=Gate_1 $thickness=5.6e-08
+ $X=0.945 $Y=0.2025 $X2=0.945 $Y2=0.1595
r71 41 42 2.7211 $w=2.1e-08 $l=8e-09 $layer=Gate_1 $thickness=5.6e-08 $X=0.945
+ $Y=0.1515 $X2=0.945 $Y2=0.1595
r72 40 41 5.79936 $w=2.03333e-08 $l=1.65e-08 $layer=Gate_1 $thickness=5.6e-08
+ $X=0.945 $Y=0.135 $X2=0.945 $Y2=0.1515
r73 40 45 6.27904 $w=2.09e-08 $l=1e-09 $layer=Gate_1 $thickness=5.24e-08
+ $X=0.945 $Y=0.135 $X2=0.946 $Y2=0.135
r74 39 40 5.79936 $w=2.03333e-08 $l=1.65e-08 $layer=Gate_1 $thickness=5.6e-08
+ $X=0.945 $Y=0.1185 $X2=0.945 $Y2=0.135
r75 38 39 2.7211 $w=2.1e-08 $l=8e-09 $layer=Gate_1 $thickness=5.6e-08 $X=0.945
+ $Y=0.1105 $X2=0.945 $Y2=0.1185
r76 37 38 14.6259 $w=2.1e-08 $l=4.3e-08 $layer=Gate_1 $thickness=5.6e-08
+ $X=0.945 $Y=0.0675 $X2=0.945 $Y2=0.1105
r77 37 21 14.6259 $w=2.1e-08 $l=4.3e-08 $layer=Gate_1 $thickness=5.6e-08
+ $X=0.945 $Y=0.0675 $X2=0.945 $Y2=0.0245
r78 4 25 1e-05 $l=2e-09 $X=0.27 $Y=0.2025 $X2=0.272 $Y2=0.2025
r79 5 26 1e-05 $l=2e-09 $X=0.432 $Y=0.2025 $X2=0.434 $Y2=0.2025
r80 6 27 1e-05 $l=2e-09 $X=0.594 $Y=0.2025 $X2=0.596 $Y2=0.2025
r81 8 28 1e-05 $l=2e-09 $X=0.756 $Y=0.2025 $X2=0.758 $Y2=0.2025
.ends

.subckt PM_AND5x2_ASAP7_75t_R%B vss 22 8 14 25 1 4 3 7 6 5
c1 1 vss 0.00715495f $X=0.6115 $Y=0.135
c2 3 vss 0.0622357f $X=0.621 $Y=0.0245
c3 4 vss 0.0510398f $X=0.675 $Y=0.135
c4 5 vss 0.00305449f $X=0.621 $Y=0.108
c5 6 vss 0.00271763f $X=0.621 $Y=0.198
c6 7 vss 0.00410274f $X=0.621 $Y=0.1215
r1 6 23 6.16517 $w=1.44286e-08 $l=3.15e-08 $layer=M1 $thickness=3.6e-08
+ $X=0.621 $Y=0.198 $X2=0.621 $Y2=0.1665
r2 5 7 1.96775 $w=1.63333e-08 $l=1.35e-08 $layer=M1 $thickness=3.6e-08 $X=0.621
+ $Y=0.108 $X2=0.621 $Y2=0.1215
r3 25 26 16.6668 $w=2.1e-08 $l=4.9e-08 $layer=Gate_1 $thickness=5.6e-08
+ $X=0.675 $Y=0.0675 $X2=0.675 $Y2=0.1165
r4 4 20 6.74717 $w=2e-08 $layer=Gate_1 $thickness=5.2e-08 $X=0.675 $Y=0.135
+ $X2=0.675 $Y2=0.135
r5 4 26 6.46262 $w=2.04595e-08 $l=1.85e-08 $layer=Gate_1 $thickness=5.6e-08
+ $X=0.675 $Y=0.135 $X2=0.675 $Y2=0.1165
r6 22 23 7.34548 $w=1.3e-08 $l=3.15e-08 $layer=M1 $thickness=3.6e-08 $X=0.62
+ $Y=0.137 $X2=0.621 $Y2=0.1665
r7 22 7 3.14806 $w=1.3e-08 $l=1.35e-08 $layer=M1 $thickness=3.6e-08 $X=0.62
+ $Y=0.137 $X2=0.621 $Y2=0.1215
r8 19 20 20.114 $w=1.57815e-08 $l=2.7e-08 $layer=LIG $thickness=4.8e-08
+ $X=0.648 $Y=0.135 $X2=0.675 $Y2=0.135
r9 17 19 17.097 $w=1.34914e-08 $l=1.75e-08 $layer=LIG $thickness=4.8e-08
+ $X=0.6305 $Y=0.135 $X2=0.648 $Y2=0.135
r10 16 17 3.01694 $w=2e-08 $l=9.5e-09 $layer=LIG $thickness=4.8e-08 $X=0.621
+ $Y=0.135 $X2=0.6305 $Y2=0.135
r11 22 16 19.3796 $a=3.24e-16 $layer=V0LIG $X=0.62 $Y=0.137 $X2=0.621 $Y2=0.135
r12 1 16 3.01694 $w=2e-08 $l=9.5e-09 $layer=LIG $thickness=4.8e-08 $X=0.6115
+ $Y=0.135 $X2=0.621 $Y2=0.135
r13 14 13 14.6259 $w=2.1e-08 $l=4.3e-08 $layer=Gate_1 $thickness=5.6e-08
+ $X=0.621 $Y=0.2025 $X2=0.621 $Y2=0.1595
r14 12 13 2.89117 $w=2.1e-08 $l=8.5e-09 $layer=Gate_1 $thickness=5.6e-08
+ $X=0.621 $Y=0.151 $X2=0.621 $Y2=0.1595
r15 11 12 5.61228 $w=2.0375e-08 $l=1.6e-08 $layer=Gate_1 $thickness=5.6e-08
+ $X=0.621 $Y=0.135 $X2=0.621 $Y2=0.151
r16 11 17 3.73024 $w=2e-08 $l=9.5e-09 $layer=Gate_1 $thickness=5.5619e-08
+ $X=0.621 $Y=0.135 $X2=0.6305 $Y2=0.135
r17 11 16 6.4296 $w=2e-08 $layer=Gate_1 $thickness=5.22105e-08 $X=0.621
+ $Y=0.135 $X2=0.621 $Y2=0.135
r18 10 11 5.61228 $w=2.0375e-08 $l=1.6e-08 $layer=Gate_1 $thickness=5.6e-08
+ $X=0.621 $Y=0.119 $X2=0.621 $Y2=0.135
r19 9 10 2.89117 $w=2.1e-08 $l=8.5e-09 $layer=Gate_1 $thickness=5.6e-08
+ $X=0.621 $Y=0.1105 $X2=0.621 $Y2=0.119
r20 8 9 14.6259 $w=2.1e-08 $l=4.3e-08 $layer=Gate_1 $thickness=5.6e-08 $X=0.621
+ $Y=0.0675 $X2=0.621 $Y2=0.1105
r21 8 3 14.6259 $w=2.1e-08 $l=4.3e-08 $layer=Gate_1 $thickness=5.6e-08 $X=0.621
+ $Y=0.0675 $X2=0.621 $Y2=0.0245
.ends

.subckt PM_AND5x2_ASAP7_75t_R%E vss 21 9 26 30 4 1 3
c1 1 vss 0.0110222f $X=0.0715 $Y=0.135
c2 3 vss 0.0951581f $X=0.081 $Y=0.0245
c3 4 vss 0.0907635f $X=0.135 $Y=0.135
c4 5 vss 0.00156794f $X=0.027 $Y=0.135
c5 6 vss 0.0126955f $X=0.027 $Y=0.1215
c6 7 vss 0.0129205f $X=0.027 $Y=0.1665
c7 8 vss 0.004545f $X=0.054 $Y=0.135
r1 5 8 5.11582 $w=1.46667e-08 $l=2.7e-08 $layer=M1 $thickness=3.6e-08 $X=0.027
+ $Y=0.135 $X2=0.054 $Y2=0.135
r2 5 6 1.96775 $w=1.63333e-08 $l=1.35e-08 $layer=M1 $thickness=3.6e-08 $X=0.027
+ $Y=0.135 $X2=0.027 $Y2=0.1215
r3 5 7 6.16517 $w=1.44286e-08 $l=3.15e-08 $layer=M1 $thickness=3.6e-08 $X=0.027
+ $Y=0.135 $X2=0.027 $Y2=0.1665
r4 30 29 14.6259 $w=2.1e-08 $l=4.3e-08 $layer=Gate_1 $thickness=5.6e-08
+ $X=0.135 $Y=0.2025 $X2=0.135 $Y2=0.1595
r5 28 29 2.89117 $w=2.1e-08 $l=8.5e-09 $layer=Gate_1 $thickness=5.6e-08
+ $X=0.135 $Y=0.151 $X2=0.135 $Y2=0.1595
r6 26 27 14.6259 $w=2.1e-08 $l=4.3e-08 $layer=Gate_1 $thickness=5.6e-08
+ $X=0.135 $Y=0.0675 $X2=0.135 $Y2=0.1105
r7 24 27 2.89117 $w=2.1e-08 $l=8.5e-09 $layer=Gate_1 $thickness=5.6e-08
+ $X=0.135 $Y=0.119 $X2=0.135 $Y2=0.1105
r8 4 19 6.74717 $w=2e-08 $layer=Gate_1 $thickness=5.2e-08 $X=0.135 $Y=0.135
+ $X2=0.135 $Y2=0.135
r9 4 24 5.61228 $w=2.0375e-08 $l=1.6e-08 $layer=Gate_1 $thickness=5.6e-08
+ $X=0.135 $Y=0.135 $X2=0.135 $Y2=0.119
r10 4 28 5.61228 $w=2.0375e-08 $l=1.6e-08 $layer=Gate_1 $thickness=5.6e-08
+ $X=0.135 $Y=0.135 $X2=0.135 $Y2=0.151
r11 21 8 6.29612 $w=1.3e-08 $l=2.7e-08 $layer=M1 $thickness=3.6e-08 $X=0.08
+ $Y=0.137 $X2=0.054 $Y2=0.135
r12 18 19 20.114 $w=1.57815e-08 $l=2.7e-08 $layer=LIG $thickness=4.8e-08
+ $X=0.108 $Y=0.135 $X2=0.135 $Y2=0.135
r13 16 18 17.097 $w=1.34914e-08 $l=1.75e-08 $layer=LIG $thickness=4.8e-08
+ $X=0.0905 $Y=0.135 $X2=0.108 $Y2=0.135
r14 15 16 3.01694 $w=2e-08 $l=9.5e-09 $layer=LIG $thickness=4.8e-08 $X=0.081
+ $Y=0.135 $X2=0.0905 $Y2=0.135
r15 21 15 19.3796 $a=3.24e-16 $layer=V0LIG $X=0.08 $Y=0.137 $X2=0.081 $Y2=0.135
r16 1 15 3.01694 $w=2e-08 $l=9.5e-09 $layer=LIG $thickness=4.8e-08 $X=0.0715
+ $Y=0.135 $X2=0.081 $Y2=0.135
r17 12 16 3.73024 $w=2e-08 $l=9.5e-09 $layer=Gate_1 $thickness=5.5619e-08
+ $X=0.081 $Y=0.135 $X2=0.0905 $Y2=0.135
r18 12 15 6.4296 $w=2e-08 $layer=Gate_1 $thickness=5.22105e-08 $X=0.081
+ $Y=0.135 $X2=0.081 $Y2=0.135
r19 11 12 5.61228 $w=2.0375e-08 $l=1.6e-08 $layer=Gate_1 $thickness=5.6e-08
+ $X=0.081 $Y=0.119 $X2=0.081 $Y2=0.135
r20 10 11 2.89117 $w=2.1e-08 $l=8.5e-09 $layer=Gate_1 $thickness=5.6e-08
+ $X=0.081 $Y=0.1105 $X2=0.081 $Y2=0.119
r21 9 10 14.6259 $w=2.1e-08 $l=4.3e-08 $layer=Gate_1 $thickness=5.6e-08
+ $X=0.081 $Y=0.0675 $X2=0.081 $Y2=0.1105
r22 9 3 14.6259 $w=2.1e-08 $l=4.3e-08 $layer=Gate_1 $thickness=5.6e-08 $X=0.081
+ $Y=0.0675 $X2=0.081 $Y2=0.0245
.ends

* End of included file AND5x2_ASAP7_75t_R.pex.sp.pex

*
.subckt AND5x2_ASAP7_75t_CUSTOM_4_25_0_7 VSS VDD E D C B A Y
*
* VSS VSS
* VDD VDD
* E E
* D D
* C C
* B B
* A A
* Y Y
*
*

M0 N_M0_d N_M0_g VSS VSS nmos_rvt L=2e-08 W=8.1e-08 nfin=3 $X=0.071 $Y=0.027
M1 N_M1_d N_M1_g VSS VSS nmos_rvt L=2e-08 W=8.1e-08 nfin=3 $X=0.125 $Y=0.027
M2 N_M2_d N_M2_g N_M2_s VSS nmos_rvt L=2e-08 W=8.1e-08 nfin=3 $X=0.287 $Y=0.027
M3 N_M3_d N_M3_g N_M3_s VSS nmos_rvt L=2e-08 W=8.1e-08 nfin=3 $X=0.341 $Y=0.027
M4 N_M4_d N_M4_g N_M4_s VSS nmos_rvt L=2e-08 W=8.1e-08 nfin=3 $X=0.395 $Y=0.027
M5 N_M5_d N_M5_g N_M5_s VSS nmos_rvt L=2e-08 W=8.1e-08 nfin=3 $X=0.449 $Y=0.027
M6 N_M6_d N_M6_g N_M6_s VSS nmos_rvt L=2e-08 W=8.1e-08 nfin=3 $X=0.611 $Y=0.027
M7 N_M7_d N_M7_g N_M7_s VSS nmos_rvt L=2e-08 W=8.1e-08 nfin=3 $X=0.665 $Y=0.027
M8 N_M8_d N_M8_g N_M8_s VSS nmos_rvt L=2e-08 W=8.1e-08 nfin=3 $X=0.719 $Y=0.027
M9 N_M9_d N_M9_g N_M9_s VSS nmos_rvt L=2e-08 W=8.1e-08 nfin=3 $X=0.773 $Y=0.027
M10 N_M10_d N_M10_g VSS VSS nmos_rvt L=2e-08 W=8.1e-08 nfin=3 $X=0.935 $Y=0.027
M11 N_M11_d N_M11_g VSS VSS nmos_rvt L=2e-08 W=8.1e-08 nfin=3 $X=0.989 $Y=0.027
M12 N_M12_d N_M12_g VDD VDD pmos_rvt L=2e-08 W=8.1e-08 nfin=3 $X=0.125 $Y=0.162
M13 VDD N_M13_g N_M13_s VDD pmos_rvt L=2e-08 W=8.1e-08 nfin=3 $X=0.287 $Y=0.162
M14 VDD N_M14_g N_M14_s VDD pmos_rvt L=2e-08 W=8.1e-08 nfin=3 $X=0.449 $Y=0.162
M15 VDD N_M15_g N_M15_s VDD pmos_rvt L=2e-08 W=8.1e-08 nfin=3 $X=0.611 $Y=0.162
M16 VDD N_M16_g N_M16_s VDD pmos_rvt L=2e-08 W=8.1e-08 nfin=3 $X=0.773 $Y=0.162
M17 N_M17_d N_M17_g VDD VDD pmos_rvt L=2e-08 W=8.1e-08 nfin=3 $X=0.935 $Y=0.162
M18 N_M18_d N_M18_g VDD VDD pmos_rvt L=2e-08 W=8.1e-08 nfin=3 $X=0.989 $Y=0.162

* .include "AND5x2_ASAP7_75t_R.pex.sp.pxi"

* Start of included file AND5x2_ASAP7_75t_R.pex.sp.pxi
x_PM_AND5x2_ASAP7_75t_R%9 vss N_M0_d N_M1_d N_M2_d N_M3_d N_9_1 N_9_7 N_9_2
+ N_9_8 N_9_9 PM_AND5x2_ASAP7_75t_R%9
cc_1 N_9_1 N_E_4 0.00180822f $X=0.108 $Y=0.0675
cc_2 N_9_7 N_E_1 0.00219859f $X=0.0935 $Y=0.0675
cc_3 N_9_7 N_E_4 0.0180308f $X=0.0935 $Y=0.0675
cc_4 N_9_7 N_E_3 0.048722f $X=0.0935 $Y=0.0675
cc_5 N_9_2 N_D_3 0.00160353f $X=0.324 $Y=0.0675
cc_6 N_9_8 N_D_1 0.00197205f $X=0.3095 $Y=0.0675
cc_7 N_9_8 N_D_3 0.0359296f $X=0.3095 $Y=0.0675
cc_8 N_9_8 N_D_4 0.0300493f $X=0.3095 $Y=0.0675
x_PM_AND5x2_ASAP7_75t_R%10 vss N_M2_s N_M3_s N_M4_s N_M5_s N_10_11 N_10_1
+ N_10_10 N_10_13 N_10_3 N_10_12 N_10_2 PM_AND5x2_ASAP7_75t_R%10
cc_9 N_10_11 D 0.00050196f $X=0.3635 $Y=0.0675
cc_10 N_10_1 N_D_3 0.00107524f $X=0.27 $Y=0.0675
cc_11 N_10_10 N_D_1 0.00171933f $X=0.272 $Y=0.0675
cc_12 N_10_13 N_D_5 0.00477953f $X=0.2585 $Y=0.072
cc_13 N_10_10 N_D_3 0.0332648f $X=0.272 $Y=0.0675
cc_14 N_10_11 N_D_4 0.0360325f $X=0.3635 $Y=0.0675
cc_15 N_10_11 N_C_7 0.000517003f $X=0.3635 $Y=0.0675
cc_16 N_10_3 N_C_4 0.00107273f $X=0.486 $Y=0.0675
cc_17 N_10_11 N_C_1 0.00168547f $X=0.3635 $Y=0.0675
cc_18 N_10_13 N_C_5 0.0047273f $X=0.2585 $Y=0.072
cc_19 N_10_12 N_C_4 0.033264f $X=0.4715 $Y=0.0675
cc_20 N_10_11 N_C_3 0.0360553f $X=0.3635 $Y=0.0675
cc_21 N_10_10 N_9_8 0.00113992f $X=0.272 $Y=0.0675
cc_22 N_10_2 N_9_2 0.00116995f $X=0.378 $Y=0.0675
cc_23 N_10_1 N_9_2 0.0044505f $X=0.27 $Y=0.0675
cc_24 N_10_13 N_9_9 0.0112759f $X=0.2585 $Y=0.072
x_PM_AND5x2_ASAP7_75t_R%11 vss N_M4_d N_M5_d N_M6_d N_M7_d N_11_1 N_11_7 N_11_2
+ N_11_8 N_11_9 PM_AND5x2_ASAP7_75t_R%11
cc_25 N_11_1 N_C_4 0.00160053f $X=0.432 $Y=0.0675
cc_26 N_11_7 N_C_1 0.00199454f $X=0.4175 $Y=0.0675
cc_27 N_11_7 N_C_4 0.035941f $X=0.4175 $Y=0.0675
cc_28 N_11_7 N_C_3 0.0297642f $X=0.4175 $Y=0.0675
cc_29 N_11_2 N_B_3 0.00160057f $X=0.648 $Y=0.0675
cc_30 N_11_8 N_B_1 0.00196685f $X=0.6335 $Y=0.0675
cc_31 N_11_8 N_B_3 0.0359441f $X=0.6335 $Y=0.0675
cc_32 N_11_8 N_B_4 0.0297838f $X=0.6335 $Y=0.0675
cc_33 N_11_1 N_10_13 0.000807279f $X=0.432 $Y=0.0675
cc_34 N_11_7 N_10_11 0.00113879f $X=0.4175 $Y=0.0675
cc_35 N_11_1 N_10_2 0.00117052f $X=0.432 $Y=0.0675
cc_36 N_11_1 N_10_3 0.00442424f $X=0.432 $Y=0.0675
cc_37 N_11_9 N_10_13 0.0102721f $X=0.4205 $Y=0.036
x_PM_AND5x2_ASAP7_75t_R%D vss D N_M2_g N_M13_g N_M3_g N_D_4 N_D_3 N_D_1 N_D_6
+ N_D_5 PM_AND5x2_ASAP7_75t_R%D
x_PM_AND5x2_ASAP7_75t_R%C vss C N_M5_g N_M14_g N_M4_g N_C_3 N_C_4 N_C_1 N_C_6
+ N_C_7 N_C_5 PM_AND5x2_ASAP7_75t_R%C
cc_38 N_C_3 N_D_4 0.0122785f $X=0.405 $Y=0.135
x_PM_AND5x2_ASAP7_75t_R%A vss A N_M9_g N_M16_g N_M8_g N_A_1 N_A_3 N_A_4 N_A_7
+ N_A_6 N_A_5 PM_AND5x2_ASAP7_75t_R%A
cc_39 N_A_1 N_B_1 0.00148579f $X=0.783 $Y=0.135
cc_40 N_A_3 N_B_4 0.0122864f $X=0.729 $Y=0.135
x_PM_AND5x2_ASAP7_75t_R%Y vss Y N_M10_d N_M11_d N_M17_d N_M18_d N_Y_8 N_Y_2
+ N_Y_7 PM_AND5x2_ASAP7_75t_R%Y
cc_41 N_Y_8 N_8_31 0.000163806f $X=0.9575 $Y=0.2025
cc_42 N_Y_8 N_8_1 0.0011869f $X=0.9575 $Y=0.2025
cc_43 N_Y_8 N_8_35 0.000481157f $X=0.9575 $Y=0.2025
cc_44 N_Y_8 N_8_34 0.000510001f $X=0.9575 $Y=0.2025
cc_45 N_Y_8 N_8_36 0.000625291f $X=0.9575 $Y=0.2025
cc_46 N_Y_8 N_8_21 0.0210645f $X=0.9575 $Y=0.2025
cc_47 N_Y_2 N_8_21 0.00192881f $X=0.972 $Y=0.2025
cc_48 N_Y_7 N_8_1 0.00538632f $X=0.9575 $Y=0.0675
cc_49 N_Y_7 N_8_21 0.0652318f $X=0.9575 $Y=0.0675
cc_50 N_Y_8 N_8_22 0.0498393f $X=0.9575 $Y=0.2025
x_PM_AND5x2_ASAP7_75t_R%12 vss N_M6_s N_M7_s N_M8_s N_M9_s N_12_11 N_12_1
+ N_12_10 N_12_13 N_12_2 N_12_12 N_12_3 PM_AND5x2_ASAP7_75t_R%12
cc_51 N_12_11 N_B_5 0.000437271f $X=0.6875 $Y=0.0675
cc_52 N_12_1 N_B_3 0.00106965f $X=0.594 $Y=0.0675
cc_53 N_12_10 N_B_1 0.00166819f $X=0.596 $Y=0.0675
cc_54 N_12_13 N_B_5 0.0046071f $X=0.5825 $Y=0.072
cc_55 N_12_10 N_B_3 0.0331647f $X=0.596 $Y=0.0675
cc_56 N_12_11 N_B_4 0.0357868f $X=0.6875 $Y=0.0675
cc_57 N_12_11 N_A_4 0.000788574f $X=0.6875 $Y=0.0675
cc_58 N_12_2 N_A_3 0.000912223f $X=0.702 $Y=0.0675
cc_59 N_12_11 N_A_1 0.00160654f $X=0.6875 $Y=0.0675
cc_60 N_12_13 N_A_5 0.00490334f $X=0.5825 $Y=0.072
cc_61 N_12_12 N_A_4 0.0331738f $X=0.7955 $Y=0.0675
cc_62 N_12_11 N_A_3 0.0355467f $X=0.6875 $Y=0.0675
cc_63 N_12_13 N_8_23 0.00146635f $X=0.5825 $Y=0.072
cc_64 N_12_13 N_8_27 0.000149435f $X=0.5825 $Y=0.072
cc_65 N_12_13 N_8_30 0.000154576f $X=0.5825 $Y=0.072
cc_66 N_12_13 N_8_35 0.000166579f $X=0.5825 $Y=0.072
cc_67 N_12_13 N_8_7 0.00100462f $X=0.5825 $Y=0.072
cc_68 N_12_13 N_8_32 0.000301813f $X=0.5825 $Y=0.072
cc_69 N_12_13 N_8_34 0.000530565f $X=0.5825 $Y=0.072
cc_70 N_12_3 N_8_33 0.000760417f $X=0.81 $Y=0.0675
cc_71 N_12_12 N_8_23 0.00116943f $X=0.7955 $Y=0.0675
cc_72 N_12_3 N_8_7 0.00197106f $X=0.81 $Y=0.0675
cc_73 N_12_2 N_8_7 0.0039245f $X=0.702 $Y=0.0675
cc_74 N_12_13 N_8_33 0.00921506f $X=0.5825 $Y=0.072
cc_75 N_12_13 N_11_2 0.000807279f $X=0.5825 $Y=0.072
cc_76 N_12_10 N_11_8 0.00114039f $X=0.596 $Y=0.0675
cc_77 N_12_1 N_11_2 0.00167581f $X=0.594 $Y=0.0675
cc_78 N_12_2 N_11_2 0.00391385f $X=0.702 $Y=0.0675
cc_79 N_12_13 N_11_9 0.0101993f $X=0.5825 $Y=0.072
x_PM_AND5x2_ASAP7_75t_R%8 vss N_M10_g N_M17_g N_M11_g N_M18_g N_M8_d N_M9_d
+ N_M16_s N_M15_s N_M14_s N_M13_s N_M12_d N_8_3 N_8_32 N_8_24 N_8_5 N_8_4
+ N_8_25 N_8_26 N_8_6 N_8_27 N_8_8 N_8_7 N_8_23 N_8_28 N_8_30 N_8_35 N_8_34
+ N_8_33 N_8_31 N_8_1 N_8_36 N_8_21 N_8_22 PM_AND5x2_ASAP7_75t_R%8
cc_80 N_8_3 N_E_4 0.00136237f $X=0.162 $Y=0.2025
cc_81 N_8_32 N_E_4 0.000442511f $X=0.853 $Y=0.234
cc_82 N_8_24 N_E_1 0.00112497f $X=0.1475 $Y=0.2025
cc_83 N_8_24 N_E_4 0.0348083f $X=0.1475 $Y=0.2025
cc_84 N_8_5 N_D_3 0.000277683f $X=0.432 $Y=0.2025
cc_85 N_8_4 N_D_3 0.0023125f $X=0.27 $Y=0.2025
cc_86 N_8_4 D 0.000933098f $X=0.27 $Y=0.2025
cc_87 N_8_25 N_D_1 0.00123113f $X=0.272 $Y=0.2025
cc_88 N_8_32 N_D_6 0.00573128f $X=0.853 $Y=0.234
cc_89 N_8_25 N_D_3 0.0350283f $X=0.272 $Y=0.2025
cc_90 N_8_5 N_C_4 0.00150111f $X=0.432 $Y=0.2025
cc_91 N_8_5 N_C_3 0.0024753f $X=0.432 $Y=0.2025
cc_92 N_8_26 N_C_1 0.00248976f $X=0.434 $Y=0.2025
cc_93 N_8_32 N_C_3 0.00256041f $X=0.853 $Y=0.234
cc_94 N_8_32 N_C_6 0.00295405f $X=0.853 $Y=0.234
cc_95 N_8_26 N_C_3 0.0196445f $X=0.434 $Y=0.2025
cc_96 N_8_26 N_C_4 0.052622f $X=0.434 $Y=0.2025
cc_97 N_8_6 N_B_3 0.00231178f $X=0.594 $Y=0.2025
cc_98 N_8_6 N_B_7 0.000812374f $X=0.594 $Y=0.2025
cc_99 N_8_27 N_B_1 0.0011667f $X=0.596 $Y=0.2025
cc_100 N_8_32 N_B_6 0.00532397f $X=0.853 $Y=0.234
cc_101 N_8_27 N_B_3 0.0349407f $X=0.596 $Y=0.2025
cc_102 N_8_8 N_A_4 0.000766121f $X=0.756 $Y=0.2025
cc_103 N_8_7 N_A_4 0.00220299f $X=0.756 $Y=0.0675
cc_104 N_8_23 N_A_4 0.0196783f $X=0.7415 $Y=0.0675
cc_105 N_8_8 N_A_7 0.000973654f $X=0.756 $Y=0.2025
cc_106 N_8_8 N_A_3 0.00249735f $X=0.756 $Y=0.2025
cc_107 N_8_23 N_A_1 0.00455458f $X=0.7415 $Y=0.0675
cc_108 N_8_32 N_A_6 0.00547071f $X=0.853 $Y=0.234
cc_109 N_8_23 N_A_3 0.0490306f $X=0.7415 $Y=0.0675
cc_110 N_8_28 N_A_4 0.0718718f $X=0.758 $Y=0.2025
x_PM_AND5x2_ASAP7_75t_R%B vss B N_M6_g N_M15_g N_M7_g N_B_1 N_B_4 N_B_3 N_B_7
+ N_B_6 N_B_5 PM_AND5x2_ASAP7_75t_R%B
x_PM_AND5x2_ASAP7_75t_R%E vss E N_M0_g N_M1_g N_M12_g N_E_4 N_E_1 N_E_3
+ PM_AND5x2_ASAP7_75t_R%E

* End of included file AND5x2_ASAP7_75t_R.pex.sp.pxi
.ends

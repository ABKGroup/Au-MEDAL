.subckt PM_NAND2xp67_ASAP7_75t_R%B vss 29 7 11 21 3 1 4 6 5
c1 1 vss 0.00873838f $X=0.189 $Y=0.134
c2 3 vss 0.0361341f $X=0.189 $Y=0.0245
c3 4 vss 0.0505838f $X=0.243 $Y=0.134
c4 5 vss 0.00467221f $X=0.243 $Y=0.198
c5 6 vss 0.00416546f $X=0.243 $Y=0.1255
r1 5 30 4.70773 $w=1.47822e-08 $l=2.53e-08 $layer=M1 $thickness=3.6e-08
+ $X=0.243 $Y=0.198 $X2=0.243 $Y2=0.1727
r2 29 30 3.90593 $w=1.3e-08 $l=1.67e-08 $layer=M1 $thickness=3.6e-08 $X=0.243
+ $Y=0.156 $X2=0.243 $Y2=0.1727
r3 29 28 1.45744 $w=1.3e-08 $l=6.3e-09 $layer=M1 $thickness=3.6e-08 $X=0.243
+ $Y=0.156 $X2=0.243 $Y2=0.1497
r4 27 28 1.45744 $w=1.3e-08 $l=6.2e-09 $layer=M1 $thickness=3.6e-08 $X=0.243
+ $Y=0.1435 $X2=0.243 $Y2=0.1497
r5 25 27 2.09871 $w=1.3e-08 $l=9e-09 $layer=M1 $thickness=3.6e-08 $X=0.243
+ $Y=0.1345 $X2=0.243 $Y2=0.1435
r6 6 25 2.09871 $w=1.3e-08 $l=9e-09 $layer=M1 $thickness=3.6e-08 $X=0.243
+ $Y=0.1255 $X2=0.243 $Y2=0.1345
r7 21 22 14.6259 $w=2.1e-08 $l=4.3e-08 $layer=Gate_1 $thickness=5.6e-08
+ $X=0.243 $Y=0.054 $X2=0.243 $Y2=0.097
r8 19 22 7.1429 $w=2.1e-08 $l=2.1e-08 $layer=Gate_1 $thickness=5.6e-08 $X=0.243
+ $Y=0.118 $X2=0.243 $Y2=0.097
r9 4 16 6.27904 $w=2.09e-08 $layer=Gate_1 $thickness=5.24e-08 $X=0.243 $Y=0.134
+ $X2=0.243 $Y2=0.134
r10 4 19 5.62929 $w=2.03125e-08 $l=1.6e-08 $layer=Gate_1 $thickness=5.6e-08
+ $X=0.243 $Y=0.134 $X2=0.243 $Y2=0.118
r11 16 25 19.3796 $a=3.24e-16 $layer=V0LIG $X=0.243 $Y=0.134 $X2=0.243
+ $Y2=0.1345
r12 15 16 2.48102 $w=2.2e-08 $l=9.5e-09 $layer=LIG $thickness=4.8e-08 $X=0.2335
+ $Y=0.134 $X2=0.243 $Y2=0.134
r13 14 15 10.1729 $w=1.54914e-08 $l=1.75e-08 $layer=LIG $thickness=4.8e-08
+ $X=0.216 $Y=0.134 $X2=0.2335 $Y2=0.134
r14 1 9 6.54019 $w=2.09524e-08 $layer=Gate_1 $thickness=5.21905e-08 $X=0.189
+ $Y=0.134 $X2=0.189 $Y2=0.134
r15 1 14 12.6539 $w=1.77815e-08 $l=2.7e-08 $layer=LIG $thickness=4.8e-08
+ $X=0.189 $Y=0.134 $X2=0.216 $Y2=0.134
r16 11 10 16.6668 $w=2.1e-08 $l=4.9e-08 $layer=Gate_1 $thickness=5.6e-08
+ $X=0.189 $Y=0.216 $X2=0.189 $Y2=0.167
r17 9 10 11.4116 $w=2.06667e-08 $l=3.3e-08 $layer=Gate_1 $thickness=5.6e-08
+ $X=0.189 $Y=0.134 $X2=0.189 $Y2=0.167
r18 8 9 11.0715 $w=2.06563e-08 $l=3.2e-08 $layer=Gate_1 $thickness=5.6e-08
+ $X=0.189 $Y=0.102 $X2=0.189 $Y2=0.134
r19 7 8 16.3266 $w=2.1e-08 $l=4.8e-08 $layer=Gate_1 $thickness=5.6e-08 $X=0.189
+ $Y=0.054 $X2=0.189 $Y2=0.102
r20 7 3 10.0341 $w=2.1e-08 $l=2.95e-08 $layer=Gate_1 $thickness=5.6e-08
+ $X=0.189 $Y=0.054 $X2=0.189 $Y2=0.0245
.ends

.subckt PM_NAND2xp67_ASAP7_75t_R%Y vss 26 18 19 39 41 9 1 10 14 8 13 15 2
c1 1 vss 0.0114002f $X=0.162 $Y=0.216
c2 2 vss 0.00290639f $X=0.216 $Y=0.054
c3 8 vss 0.00201711f $X=0.2015 $Y=0.054
c4 9 vss 0.00268645f $X=0.0935 $Y=0.216
c5 10 vss 0.00265875f $X=0.164 $Y=0.216
c6 11 vss 0.00104402f $X=0.297 $Y=0.072
c7 12 vss 0.00281213f $X=0.297 $Y=0.234
c8 13 vss 0.0129108f $X=0.27 $Y=0.234
c9 14 vss 0.000754053f $X=0.2045 $Y=0.072
c10 15 vss 0.00428373f $X=0.297 $Y=0.0932
r1 9 37 0.231482 $w=5.4e-08 $l=1.25e-08 $layer=P_src_drn $thickness=1e-09
+ $X=0.0935 $Y=0.216 $X2=0.108 $Y2=0.216
r2 41 9 0.0462963 $w=5.4e-08 $l=2.5e-09 $layer=P_src_drn $thickness=1e-09
+ $X=0.0906 $Y=0.216 $X2=0.0935 $Y2=0.216
r3 39 38 0.0462963 $w=5.4e-08 $l=2.5e-09 $layer=P_src_drn $thickness=1e-09
+ $X=0.1793 $Y=0.216 $X2=0.1765 $Y2=0.216
r4 10 38 0.231482 $w=5.4e-08 $l=1.25e-08 $layer=P_src_drn $thickness=1e-09
+ $X=0.164 $Y=0.216 $X2=0.1765 $Y2=0.216
r5 36 37 4.04632 $w=5.02e-08 $l=2.7e-08 $layer=LISD $thickness=2.7e-08 $X=0.135
+ $Y=0.216 $X2=0.108 $Y2=0.216
r6 1 34 19.3796 $a=3.24e-16 $layer=V0LISD $X=0.162 $Y=0.216 $X2=0.162 $Y2=0.234
r7 1 36 4.04632 $w=5.02e-08 $l=2.7e-08 $layer=LISD $thickness=2.7e-08 $X=0.162
+ $Y=0.216 $X2=0.135 $Y2=0.216
r8 34 35 5.71315 $w=1.3e-08 $l=2.45e-08 $layer=M1 $thickness=3.6e-08 $X=0.162
+ $Y=0.234 $X2=0.1865 $Y2=0.234
r9 32 35 5.13018 $w=1.3e-08 $l=2.2e-08 $layer=M1 $thickness=3.6e-08 $X=0.2085
+ $Y=0.234 $X2=0.1865 $Y2=0.234
r10 31 32 5.82974 $w=1.3e-08 $l=2.5e-08 $layer=M1 $thickness=3.6e-08 $X=0.2335
+ $Y=0.234 $X2=0.2085 $Y2=0.234
r11 13 31 8.51143 $w=1.3e-08 $l=3.65e-08 $layer=M1 $thickness=3.6e-08 $X=0.27
+ $Y=0.234 $X2=0.2335 $Y2=0.234
r12 12 30 2.5483 $w=1.79e-08 $l=1.8e-08 $layer=M1 $thickness=3.6e-08 $X=0.297
+ $Y=0.234 $X2=0.297 $Y2=0.216
r13 12 13 4.64701 $w=1.46667e-08 $l=2.7e-08 $layer=M1 $thickness=3.6e-08
+ $X=0.297 $Y=0.234 $X2=0.27 $Y2=0.234
r14 29 30 4.19742 $w=1.3e-08 $l=1.8e-08 $layer=M1 $thickness=3.6e-08 $X=0.297
+ $Y=0.198 $X2=0.297 $Y2=0.216
r15 28 29 11.7178 $w=1.3e-08 $l=5.03e-08 $layer=M1 $thickness=3.6e-08 $X=0.297
+ $Y=0.1477 $X2=0.297 $Y2=0.198
r16 27 28 9.67738 $w=1.3e-08 $l=4.15e-08 $layer=M1 $thickness=3.6e-08 $X=0.297
+ $Y=0.1062 $X2=0.297 $Y2=0.1477
r17 26 27 0.116595 $w=1.3e-08 $l=5e-10 $layer=M1 $thickness=3.6e-08 $X=0.298
+ $Y=0.106 $X2=0.297 $Y2=0.1062
r18 26 15 2.91487 $w=1.3e-08 $l=1.25e-08 $layer=M1 $thickness=3.6e-08 $X=0.298
+ $Y=0.106 $X2=0.297 $Y2=0.0932
r19 11 25 0.915974 $w=1.70909e-08 $l=1.1e-08 $layer=M1 $thickness=3.6e-08
+ $X=0.297 $Y=0.072 $X2=0.286 $Y2=0.072
r20 11 15 3.30617 $w=1.71506e-08 $l=2.12e-08 $layer=M1 $thickness=3.6e-08
+ $X=0.297 $Y=0.072 $X2=0.297 $Y2=0.0932
r21 24 25 4.19742 $w=1.3e-08 $l=1.8e-08 $layer=M1 $thickness=3.6e-08 $X=0.268
+ $Y=0.072 $X2=0.286 $Y2=0.072
r22 23 24 5.82974 $w=1.3e-08 $l=2.5e-08 $layer=M1 $thickness=3.6e-08 $X=0.243
+ $Y=0.072 $X2=0.268 $Y2=0.072
r23 22 23 3.14806 $w=1.3e-08 $l=1.35e-08 $layer=M1 $thickness=3.6e-08 $X=0.2295
+ $Y=0.072 $X2=0.243 $Y2=0.072
r24 21 22 2.2153 $w=1.3e-08 $l=9.5e-09 $layer=M1 $thickness=3.6e-08 $X=0.22
+ $Y=0.072 $X2=0.2295 $Y2=0.072
r25 20 21 2.09871 $w=1.3e-08 $l=9e-09 $layer=M1 $thickness=3.6e-08 $X=0.211
+ $Y=0.072 $X2=0.22 $Y2=0.072
r26 14 20 1.51573 $w=1.3e-08 $l=6.5e-09 $layer=M1 $thickness=3.6e-08 $X=0.2045
+ $Y=0.072 $X2=0.211 $Y2=0.072
r27 2 21 19.3796 $a=3.24e-16 $layer=V0LISD $X=0.216 $Y=0.054 $X2=0.22 $Y2=0.072
r28 19 17 0.0462963 $w=5.4e-08 $l=2.5e-09 $layer=N_src_drn $thickness=1e-09
+ $X=0.2333 $Y=0.054 $X2=0.2305 $Y2=0.054
r29 2 17 0.268519 $w=5.4e-08 $l=1.45e-08 $layer=N_src_drn $thickness=1e-09
+ $X=0.216 $Y=0.054 $X2=0.2305 $Y2=0.054
r30 8 2 0.268519 $w=5.4e-08 $l=1.45e-08 $layer=N_src_drn $thickness=1e-09
+ $X=0.2015 $Y=0.054 $X2=0.216 $Y2=0.054
r31 18 8 0.0462963 $w=5.4e-08 $l=2.5e-09 $layer=N_src_drn $thickness=1e-09
+ $X=0.1986 $Y=0.054 $X2=0.2015 $Y2=0.054
r32 1 10 1e-05 $l=2e-09 $X=0.162 $Y=0.216 $X2=0.164 $Y2=0.216
.ends

.subckt PM_NAND2xp67_ASAP7_75t_R%5 vss 15 28 29 31 10 1 13 11 12 3 2
c1 1 vss 0.00741868f $X=0.054 $Y=0.054
c2 2 vss 0.0057711f $X=0.162 $Y=0.054
c3 3 vss 0.0056617f $X=0.27 $Y=0.054
c4 10 vss 0.027768f $X=0.056 $Y=0.054
c5 11 vss 0.00288996f $X=0.1475 $Y=0.054
c6 12 vss 0.0269734f $X=0.2555 $Y=0.054
c7 13 vss 0.0206826f $X=0.0425 $Y=0.036
r1 12 3 0.231482 $w=5.4e-08 $l=1.25e-08 $layer=N_src_drn $thickness=1e-09
+ $X=0.2555 $Y=0.054 $X2=0.27 $Y2=0.054
r2 31 12 0.0462963 $w=5.4e-08 $l=2.5e-09 $layer=N_src_drn $thickness=1e-09
+ $X=0.2526 $Y=0.054 $X2=0.2555 $Y2=0.054
r3 29 27 0.0462963 $w=5.4e-08 $l=2.5e-09 $layer=N_src_drn $thickness=1e-09
+ $X=0.1793 $Y=0.054 $X2=0.1765 $Y2=0.054
r4 2 27 0.268519 $w=5.4e-08 $l=1.45e-08 $layer=N_src_drn $thickness=1e-09
+ $X=0.162 $Y=0.054 $X2=0.1765 $Y2=0.054
r5 11 2 0.268519 $w=5.4e-08 $l=1.45e-08 $layer=N_src_drn $thickness=1e-09
+ $X=0.1475 $Y=0.054 $X2=0.162 $Y2=0.054
r6 28 11 0.0462963 $w=5.4e-08 $l=2.5e-09 $layer=N_src_drn $thickness=1e-09
+ $X=0.1446 $Y=0.054 $X2=0.1475 $Y2=0.054
r7 3 24 19.3796 $a=3.24e-16 $layer=V0LISD $X=0.27 $Y=0.054 $X2=0.27 $Y2=0.036
r8 2 21 19.3796 $a=3.24e-16 $layer=V0LISD $X=0.162 $Y=0.054 $X2=0.162 $Y2=0.036
r9 23 24 8.97781 $w=1.3e-08 $l=3.85e-08 $layer=M1 $thickness=3.6e-08 $X=0.2315
+ $Y=0.036 $X2=0.27 $Y2=0.036
r10 22 23 10.4935 $w=1.3e-08 $l=4.5e-08 $layer=M1 $thickness=3.6e-08 $X=0.1865
+ $Y=0.036 $X2=0.2315 $Y2=0.036
r11 21 22 5.71315 $w=1.3e-08 $l=2.45e-08 $layer=M1 $thickness=3.6e-08 $X=0.162
+ $Y=0.036 $X2=0.1865 $Y2=0.036
r12 20 21 2.68168 $w=1.3e-08 $l=1.15e-08 $layer=M1 $thickness=3.6e-08 $X=0.1505
+ $Y=0.036 $X2=0.162 $Y2=0.036
r13 19 20 6.7625 $w=1.3e-08 $l=2.9e-08 $layer=M1 $thickness=3.6e-08 $X=0.1215
+ $Y=0.036 $X2=0.1505 $Y2=0.036
r14 18 19 9.91056 $w=1.3e-08 $l=4.25e-08 $layer=M1 $thickness=3.6e-08 $X=0.079
+ $Y=0.036 $X2=0.1215 $Y2=0.036
r15 17 18 4.6638 $w=1.3e-08 $l=2e-08 $layer=M1 $thickness=3.6e-08 $X=0.059
+ $Y=0.036 $X2=0.079 $Y2=0.036
r16 16 17 2.09871 $w=1.3e-08 $l=9e-09 $layer=M1 $thickness=3.6e-08 $X=0.05
+ $Y=0.036 $X2=0.059 $Y2=0.036
r17 13 16 1.74892 $w=1.3e-08 $l=7.5e-09 $layer=M1 $thickness=3.6e-08 $X=0.0425
+ $Y=0.036 $X2=0.05 $Y2=0.036
r18 1 16 19.3796 $a=3.24e-16 $layer=V0LISD $X=0.054 $Y=0.054 $X2=0.05 $Y2=0.036
r19 15 14 0.0462963 $w=5.4e-08 $l=2.5e-09 $layer=N_src_drn $thickness=1e-09
+ $X=0.0713 $Y=0.054 $X2=0.0685 $Y2=0.054
r20 10 14 0.231482 $w=5.4e-08 $l=1.25e-08 $layer=N_src_drn $thickness=1e-09
+ $X=0.056 $Y=0.054 $X2=0.0685 $Y2=0.054
r21 1 10 1e-05 $l=2e-09 $X=0.054 $Y=0.054 $X2=0.056 $Y2=0.054
.ends

.subckt PM_NAND2xp67_ASAP7_75t_R%A vss 25 11 17 29 1 4 3 5
c1 1 vss 0.00495712f $X=0.0715 $Y=0.134
c2 3 vss 0.0683427f $X=0.081 $Y=0.0245
c3 4 vss 0.0345138f $X=0.135 $Y=0.134
c4 5 vss 0.00467241f $X=0.027 $Y=0.072
c5 6 vss 0.00160065f $X=0.027 $Y=0.134
c6 7 vss 0.00893262f $X=0.027 $Y=0.234
c7 8 vss 0.00453425f $X=0.027 $Y=0.1155
c8 9 vss 0.00991278f $X=0.027 $Y=0.166
c9 10 vss 0.00348102f $X=0.0635 $Y=0.134
r1 7 34 3.01711 $w=1.55e-08 $l=1.8e-08 $layer=M1 $thickness=3.6e-08 $X=0.027
+ $Y=0.234 $X2=0.027 $Y2=0.216
r2 5 32 3.83327 $w=1.5093e-08 $l=2.15e-08 $layer=M1 $thickness=3.6e-08 $X=0.027
+ $Y=0.072 $X2=0.027 $Y2=0.0935
r3 33 34 4.19742 $w=1.3e-08 $l=1.8e-08 $layer=M1 $thickness=3.6e-08 $X=0.027
+ $Y=0.198 $X2=0.027 $Y2=0.216
r4 9 33 7.46207 $w=1.3e-08 $l=3.2e-08 $layer=M1 $thickness=3.6e-08 $X=0.027
+ $Y=0.166 $X2=0.027 $Y2=0.198
r5 8 32 5.13017 $w=1.3e-08 $l=2.2e-08 $layer=M1 $thickness=3.6e-08 $X=0.027
+ $Y=0.1155 $X2=0.027 $Y2=0.0935
r6 6 27 3.1337 $w=1.54324e-08 $l=1.85e-08 $layer=M1 $thickness=3.6e-08 $X=0.027
+ $Y=0.134 $X2=0.0455 $Y2=0.134
r7 6 8 3.1337 $w=1.54324e-08 $l=1.85e-08 $layer=M1 $thickness=3.6e-08 $X=0.027
+ $Y=0.134 $X2=0.027 $Y2=0.1155
r8 6 9 6.28176 $w=1.44063e-08 $l=3.2e-08 $layer=M1 $thickness=3.6e-08 $X=0.027
+ $Y=0.134 $X2=0.027 $Y2=0.166
r9 29 30 16.3266 $w=2.1e-08 $l=4.8e-08 $layer=Gate_1 $thickness=5.6e-08
+ $X=0.135 $Y=0.054 $X2=0.135 $Y2=0.102
r10 4 23 6.54019 $w=2.09524e-08 $layer=Gate_1 $thickness=5.21905e-08 $X=0.135
+ $Y=0.134 $X2=0.135 $Y2=0.134
r11 4 30 11.0715 $w=2.06563e-08 $l=3.2e-08 $layer=Gate_1 $thickness=5.6e-08
+ $X=0.135 $Y=0.134 $X2=0.135 $Y2=0.102
r12 25 10 4.08082 $w=1.3e-08 $l=1.75e-08 $layer=M1 $thickness=3.6e-08 $X=0.081
+ $Y=0.135 $X2=0.0635 $Y2=0.134
r13 10 27 4.19742 $w=1.3e-08 $l=1.8e-08 $layer=M1 $thickness=3.6e-08 $X=0.0635
+ $Y=0.134 $X2=0.0455 $Y2=0.134
r14 22 23 12.6539 $w=1.77815e-08 $l=2.7e-08 $layer=LIG $thickness=4.8e-08
+ $X=0.108 $Y=0.134 $X2=0.135 $Y2=0.134
r15 20 22 10.1729 $w=1.54914e-08 $l=1.75e-08 $layer=LIG $thickness=4.8e-08
+ $X=0.0905 $Y=0.134 $X2=0.108 $Y2=0.134
r16 19 20 2.48102 $w=2.2e-08 $l=9.5e-09 $layer=LIG $thickness=4.8e-08 $X=0.081
+ $Y=0.134 $X2=0.0905 $Y2=0.134
r17 25 19 19.3796 $a=3.24e-16 $layer=V0LIG $X=0.081 $Y=0.135 $X2=0.081 $Y2=0.134
r18 1 19 2.48102 $w=2.2e-08 $l=9.5e-09 $layer=LIG $thickness=4.8e-08 $X=0.0715
+ $Y=0.134 $X2=0.081 $Y2=0.134
r19 17 16 14.6259 $w=2.1e-08 $l=4.3e-08 $layer=Gate_1 $thickness=5.6e-08
+ $X=0.081 $Y=0.216 $X2=0.081 $Y2=0.173
r20 15 16 7.48304 $w=2.1e-08 $l=2.2e-08 $layer=Gate_1 $thickness=5.6e-08
+ $X=0.081 $Y=0.151 $X2=0.081 $Y2=0.173
r21 14 15 5.96942 $w=2.03529e-08 $l=1.7e-08 $layer=Gate_1 $thickness=5.6e-08
+ $X=0.081 $Y=0.134 $X2=0.081 $Y2=0.151
r22 14 20 4.05918 $w=2.0087e-08 $l=9.5e-09 $layer=Gate_1 $thickness=5.56522e-08
+ $X=0.081 $Y=0.134 $X2=0.0905 $Y2=0.134
r23 14 19 6.27904 $w=2.09e-08 $layer=Gate_1 $thickness=5.24e-08 $X=0.081
+ $Y=0.134 $X2=0.081 $Y2=0.134
r24 13 14 5.62929 $w=2.03125e-08 $l=1.6e-08 $layer=Gate_1 $thickness=5.6e-08
+ $X=0.081 $Y=0.118 $X2=0.081 $Y2=0.134
r25 12 13 7.1429 $w=2.1e-08 $l=2.1e-08 $layer=Gate_1 $thickness=5.6e-08
+ $X=0.081 $Y=0.097 $X2=0.081 $Y2=0.118
r26 11 12 14.6259 $w=2.1e-08 $l=4.3e-08 $layer=Gate_1 $thickness=5.6e-08
+ $X=0.081 $Y=0.054 $X2=0.081 $Y2=0.097
r27 11 3 10.0341 $w=2.1e-08 $l=2.95e-08 $layer=Gate_1 $thickness=5.6e-08
+ $X=0.081 $Y=0.054 $X2=0.081 $Y2=0.0245
.ends

* End of included file NAND2xp67_ASAP7_75t_R.pex.sp.pex

*
.subckt NAND2xp67_ASAP7_75t_CUSTOM_4_25_0_7 VSS VDD A B Y
*
* VSS VSS
* VDD VDD
* A A
* B B
* Y Y
*
*

M0 VSS N_M0_g N_M0_s VSS nmos_rvt L=2e-08 W=5.4e-08 nfin=2 $X=0.071 $Y=0.027
M1 VSS N_M1_g N_M1_s VSS nmos_rvt L=2e-08 W=5.4e-08 nfin=2 $X=0.125 $Y=0.027
M2 N_M2_d N_M2_g N_M2_s VSS nmos_rvt L=2e-08 W=5.4e-08 nfin=2 $X=0.179 $Y=0.027
M3 N_M3_d N_M3_g N_M3_s VSS nmos_rvt L=2e-08 W=5.4e-08 nfin=2 $X=0.233 $Y=0.027
M4 N_M4_d N_M4_g VDD VDD pmos_rvt L=2e-08 W=5.4e-08 nfin=2 $X=0.071 $Y=0.189
M5 VDD N_M5_g N_M5_s VDD pmos_rvt L=2e-08 W=5.4e-08 nfin=2 $X=0.179 $Y=0.189

* .include "NAND2xp67_ASAP7_75t_R.pex.sp.pxi"

* Start of included file NAND2xp67_ASAP7_75t_R.pex.sp.pxi
x_PM_NAND2xp67_ASAP7_75t_R%B vss B N_M2_g N_M5_g N_M3_g N_B_3 N_B_1 N_B_4 N_B_6
+ N_B_5 PM_NAND2xp67_ASAP7_75t_R%B
cc_1 N_B_3 N_A_1 0.0019448f $X=0.189 $Y=0.0245
cc_2 N_B_3 N_A_4 0.0084247f $X=0.189 $Y=0.0245
x_PM_NAND2xp67_ASAP7_75t_R%Y vss Y N_M2_d N_M3_d N_M5_s N_M4_d N_Y_9 N_Y_1
+ N_Y_10 N_Y_14 N_Y_8 N_Y_13 N_Y_15 N_Y_2 PM_NAND2xp67_ASAP7_75t_R%Y
cc_3 N_Y_9 N_A_3 0.0364441f $X=0.0935 $Y=0.216
cc_4 N_Y_9 N_A_1 0.001253f $X=0.0935 $Y=0.216
cc_5 N_Y_1 N_A_4 0.0020992f $X=0.162 $Y=0.216
cc_6 N_Y_10 N_A_4 0.0115313f $X=0.164 $Y=0.216
cc_7 N_Y_9 N_A_4 0.030897f $X=0.0935 $Y=0.216
cc_8 N_Y_14 N_B_6 0.00125988f $X=0.2045 $Y=0.072
cc_9 N_Y_8 N_B_1 0.00170376f $X=0.2015 $Y=0.054
cc_10 N_Y_13 N_B_5 0.00486442f $X=0.27 $Y=0.234
cc_11 N_Y_15 N_B_6 0.00542525f $X=0.297 $Y=0.0932
cc_12 N_Y_8 N_B_4 0.0346477f $X=0.2015 $Y=0.054
cc_13 N_Y_10 N_B_3 0.0416623f $X=0.164 $Y=0.216
cc_14 N_Y_8 N_5_12 0.000848144f $X=0.2015 $Y=0.054
cc_15 N_Y_2 N_5_3 0.00155846f $X=0.216 $Y=0.054
cc_16 N_Y_2 N_5_2 0.00285571f $X=0.216 $Y=0.054
cc_17 N_Y_14 N_5_13 0.0115814f $X=0.2045 $Y=0.072
x_PM_NAND2xp67_ASAP7_75t_R%5 vss N_M0_s N_M1_s N_M2_s N_M3_s N_5_10 N_5_1
+ N_5_13 N_5_11 N_5_12 N_5_3 N_5_2 PM_NAND2xp67_ASAP7_75t_R%5
cc_18 N_5_10 N_A_1 0.00112195f $X=0.056 $Y=0.054
cc_19 N_5_1 N_A_3 0.00119096f $X=0.054 $Y=0.054
cc_20 N_5_13 N_A_5 0.00181214f $X=0.0425 $Y=0.036
cc_21 N_5_13 N_A_4 0.00194738f $X=0.0425 $Y=0.036
cc_22 N_5_10 N_A_3 0.0244684f $X=0.056 $Y=0.054
cc_23 N_5_11 N_A_4 0.0273295f $X=0.1475 $Y=0.054
cc_24 N_5_11 N_B_1 0.000731474f $X=0.1475 $Y=0.054
cc_25 N_5_12 N_B_4 0.0242285f $X=0.2555 $Y=0.054
cc_26 N_5_11 N_B_3 0.0268803f $X=0.1475 $Y=0.054
x_PM_NAND2xp67_ASAP7_75t_R%A vss A N_M0_g N_M4_g N_M1_g N_A_1 N_A_4 N_A_3 N_A_5
+ PM_NAND2xp67_ASAP7_75t_R%A

* End of included file NAND2xp67_ASAP7_75t_R.pex.sp.pxi
.ends

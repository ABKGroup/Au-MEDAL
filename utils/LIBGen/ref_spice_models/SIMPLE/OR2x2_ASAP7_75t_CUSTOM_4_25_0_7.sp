.subckt PM_OR2x2_ASAP7_75t_R%7 vss 2 3 1
c1 1 vss 0.00077469f $X=0.108 $Y=0.2025
r1 2 1 0.209877 $w=8.1e-08 $l=1.7e-08 $layer=P_src_drn $thickness=1e-09
+ $X=0.0906 $Y=0.2025 $X2=0.108 $Y2=0.2025
r2 3 1 0.209877 $w=8.1e-08 $l=1.7e-08 $layer=P_src_drn $thickness=1e-09
+ $X=0.1253 $Y=0.2025 $X2=0.108 $Y2=0.2025
.ends

.subckt PM_OR2x2_ASAP7_75t_R%A vss 6 7 11 1 3 4 5
c1 1 vss 0.00638313f $X=0.135 $Y=0.135
c2 3 vss 0.0862277f $X=0.135 $Y=0.0245
c3 4 vss 0.00265784f $X=0.135 $Y=0.072
c4 5 vss 0.00249331f $X=0.135 $Y=0.198
c5 6 vss 0.00325532f $X=0.137 $Y=0.134
r1 5 15 6.16517 $w=1.44286e-08 $l=3.15e-08 $layer=M1 $thickness=3.6e-08
+ $X=0.135 $Y=0.198 $X2=0.135 $Y2=0.1665
r2 4 14 6.16517 $w=1.44286e-08 $l=3.15e-08 $layer=M1 $thickness=3.6e-08
+ $X=0.135 $Y=0.072 $X2=0.135 $Y2=0.1035
r3 6 14 7.34548 $w=1.3e-08 $l=3.15e-08 $layer=M1 $thickness=3.6e-08 $X=0.137
+ $Y=0.134 $X2=0.135 $Y2=0.1035
r4 6 15 7.34548 $w=1.3e-08 $l=3.15e-08 $layer=M1 $thickness=3.6e-08 $X=0.137
+ $Y=0.134 $X2=0.135 $Y2=0.1665
r5 1 9 10.6051 $w=1.77022e-08 $l=5e-10 $layer=LIG $thickness=5.20889e-08
+ $X=0.135 $Y=0.135 $X2=0.135 $Y2=0.1355
r6 6 1 19.3796 $a=3.24e-16 $layer=V0LIG $X=0.137 $Y=0.134 $X2=0.135 $Y2=0.135
r7 11 10 16.3266 $w=2.1e-08 $l=4.8e-08 $layer=Gate_1 $thickness=5.6e-08
+ $X=0.135 $Y=0.2025 $X2=0.135 $Y2=0.1545
r8 9 10 6.6582 $w=2.03947e-08 $l=1.9e-08 $layer=Gate_1 $thickness=5.6e-08
+ $X=0.135 $Y=0.1355 $X2=0.135 $Y2=0.1545
r9 8 9 11.4201 $w=2.06515e-08 $l=3.3e-08 $layer=Gate_1 $thickness=5.6e-08
+ $X=0.135 $Y=0.1025 $X2=0.135 $Y2=0.1355
r10 7 8 16.4967 $w=2.1e-08 $l=4.85e-08 $layer=Gate_1 $thickness=5.6e-08
+ $X=0.135 $Y=0.054 $X2=0.135 $Y2=0.1025
r11 7 3 10.0341 $w=2.1e-08 $l=2.95e-08 $layer=Gate_1 $thickness=5.6e-08
+ $X=0.135 $Y=0.054 $X2=0.135 $Y2=0.0245
.ends

.subckt PM_OR2x2_ASAP7_75t_R%Y vss 28 20 21 36 37 8 1 2 13 14 7
c1 1 vss 0.00729107f $X=0.216 $Y=0.0675
c2 2 vss 0.00720968f $X=0.216 $Y=0.2025
c3 7 vss 0.004382f $X=0.2015 $Y=0.0675
c4 8 vss 0.0043724f $X=0.2015 $Y=0.2025
c5 9 vss 0.00244045f $X=0.216 $Y=0.036
c6 10 vss 0.00244045f $X=0.216 $Y=0.234
c7 11 vss 0.00290828f $X=0.297 $Y=0.036
c8 12 vss 0.00290828f $X=0.297 $Y=0.234
c9 13 vss 0.0012439f $X=0.216 $Y=0.054
c10 14 vss 0.000925322f $X=0.216 $Y=0.1865
c11 15 vss 0.00595006f $X=0.226 $Y=0.036
c12 16 vss 0.00594404f $X=0.2575 $Y=0.234
c13 17 vss 0.00835984f $X=0.297 $Y=0.0655
r1 37 35 0.0308642 $w=8.1e-08 $l=2.5e-09 $layer=P_src_drn $thickness=1e-09
+ $X=0.2333 $Y=0.2025 $X2=0.2305 $Y2=0.2025
r2 2 35 0.179012 $w=8.1e-08 $l=1.45e-08 $layer=P_src_drn $thickness=1e-09
+ $X=0.216 $Y=0.2025 $X2=0.2305 $Y2=0.2025
r3 8 2 0.179012 $w=8.1e-08 $l=1.45e-08 $layer=P_src_drn $thickness=1e-09
+ $X=0.2015 $Y=0.2025 $X2=0.216 $Y2=0.2025
r4 36 8 0.0308642 $w=8.1e-08 $l=2.5e-09 $layer=P_src_drn $thickness=1e-09
+ $X=0.1986 $Y=0.2025 $X2=0.2015 $Y2=0.2025
r5 2 32 19.3796 $a=3.24e-16 $layer=V0LISD $X=0.216 $Y=0.2025 $X2=0.216 $Y2=0.198
r6 32 33 4.19742 $w=1.3e-08 $l=1.8e-08 $layer=M1 $thickness=3.6e-08 $X=0.216
+ $Y=0.198 $X2=0.216 $Y2=0.216
r7 14 32 2.68168 $w=1.3e-08 $l=1.15e-08 $layer=M1 $thickness=3.6e-08 $X=0.216
+ $Y=0.1865 $X2=0.216 $Y2=0.198
r8 10 31 0.682785 $w=1.75e-08 $l=1e-08 $layer=M1 $thickness=3.6e-08 $X=0.216
+ $Y=0.234 $X2=0.226 $Y2=0.234
r9 10 33 2.5483 $w=1.79e-08 $l=1.8e-08 $layer=M1 $thickness=3.6e-08 $X=0.216
+ $Y=0.234 $X2=0.216 $Y2=0.216
r10 16 31 7.34548 $w=1.3e-08 $l=3.15e-08 $layer=M1 $thickness=3.6e-08 $X=0.2575
+ $Y=0.234 $X2=0.226 $Y2=0.234
r11 12 30 5.22999 $w=1.59898e-08 $l=2.95e-08 $layer=M1 $thickness=3.6e-08
+ $X=0.297 $Y=0.234 $X2=0.297 $Y2=0.2045
r12 12 16 7.56188 $w=1.41392e-08 $l=3.95e-08 $layer=M1 $thickness=3.6e-08
+ $X=0.297 $Y=0.234 $X2=0.2575 $Y2=0.234
r13 29 30 8.97781 $w=1.3e-08 $l=3.85e-08 $layer=M1 $thickness=3.6e-08 $X=0.297
+ $Y=0.166 $X2=0.297 $Y2=0.2045
r14 28 29 4.31401 $w=1.3e-08 $l=1.85e-08 $layer=M1 $thickness=3.6e-08 $X=0.297
+ $Y=0.1475 $X2=0.297 $Y2=0.166
r15 28 27 0.46638 $w=1.3e-08 $l=2e-09 $layer=M1 $thickness=3.6e-08 $X=0.297
+ $Y=0.1475 $X2=0.297 $Y2=0.1455
r16 26 27 2.44849 $w=1.3e-08 $l=1.05e-08 $layer=M1 $thickness=3.6e-08 $X=0.297
+ $Y=0.135 $X2=0.297 $Y2=0.1455
r17 25 26 6.7625 $w=1.3e-08 $l=2.9e-08 $layer=M1 $thickness=3.6e-08 $X=0.297
+ $Y=0.106 $X2=0.297 $Y2=0.135
r18 17 25 9.44419 $w=1.3e-08 $l=4.05e-08 $layer=M1 $thickness=3.6e-08 $X=0.297
+ $Y=0.0655 $X2=0.297 $Y2=0.106
r19 11 24 7.56188 $w=1.41392e-08 $l=3.95e-08 $layer=M1 $thickness=3.6e-08
+ $X=0.297 $Y=0.036 $X2=0.2575 $Y2=0.036
r20 11 17 5.22999 $w=1.59898e-08 $l=2.95e-08 $layer=M1 $thickness=3.6e-08
+ $X=0.297 $Y=0.036 $X2=0.297 $Y2=0.0655
r21 15 24 7.34548 $w=1.3e-08 $l=3.15e-08 $layer=M1 $thickness=3.6e-08 $X=0.226
+ $Y=0.036 $X2=0.2575 $Y2=0.036
r22 9 13 2.5483 $w=1.79e-08 $l=1.8e-08 $layer=M1 $thickness=3.6e-08 $X=0.216
+ $Y=0.036 $X2=0.216 $Y2=0.054
r23 9 15 0.682785 $w=1.75e-08 $l=1e-08 $layer=M1 $thickness=3.6e-08 $X=0.216
+ $Y=0.036 $X2=0.226 $Y2=0.036
r24 13 22 4.19742 $w=1.3e-08 $l=1.8e-08 $layer=M1 $thickness=3.6e-08 $X=0.216
+ $Y=0.054 $X2=0.216 $Y2=0.072
r25 1 22 19.3796 $a=3.24e-16 $layer=V0LISD $X=0.216 $Y=0.0675 $X2=0.216
+ $Y2=0.072
r26 21 19 0.0308642 $w=8.1e-08 $l=2.5e-09 $layer=N_src_drn $thickness=1e-09
+ $X=0.2333 $Y=0.0675 $X2=0.2305 $Y2=0.0675
r27 1 19 0.179012 $w=8.1e-08 $l=1.45e-08 $layer=N_src_drn $thickness=1e-09
+ $X=0.216 $Y=0.0675 $X2=0.2305 $Y2=0.0675
r28 7 1 0.179012 $w=8.1e-08 $l=1.45e-08 $layer=N_src_drn $thickness=1e-09
+ $X=0.2015 $Y=0.0675 $X2=0.216 $Y2=0.0675
r29 20 7 0.0308642 $w=8.1e-08 $l=2.5e-09 $layer=N_src_drn $thickness=1e-09
+ $X=0.1986 $Y=0.0675 $X2=0.2015 $Y2=0.0675
.ends

.subckt PM_OR2x2_ASAP7_75t_R%5 vss 21 25 39 43 63 64 66 17 3 4 16 12 11 14 1 18
+ 19 9 20 13 15 10
c1 1 vss 0.00717523f $X=0.189 $Y=0.135
c2 3 vss 0.00773919f $X=0.054 $Y=0.2025
c3 4 vss 0.00804901f $X=0.108 $Y=0.054
c4 9 vss 0.108617f $X=0.189 $Y=0.0245
c5 10 vss 0.0864865f $X=0.243 $Y=0.135
c6 11 vss 0.00642054f $X=0.0935 $Y=0.054
c7 12 vss 0.0421154f $X=0.056 $Y=0.2025
c8 13 vss 0.0026681f $X=0.177 $Y=0.036
c9 14 vss 0.000168969f $X=0.177 $Y=0.135
c10 15 vss 0.00266903f $X=0.177 $Y=0.234
c11 16 vss 0.0142711f $X=0.156 $Y=0.234
c12 17 vss 0.00802842f $X=0.156 $Y=0.036
c13 18 vss 0.0027824f $X=0.177 $Y=0.106
c14 19 vss 0.00279128f $X=0.177 $Y=0.164
c15 20 vss 0.00127568f $X=0.195 $Y=0.135
r1 66 65 0.0308642 $w=8.1e-08 $l=2.5e-09 $layer=P_src_drn $thickness=1e-09
+ $X=0.0713 $Y=0.2025 $X2=0.0685 $Y2=0.2025
r2 12 65 0.154321 $w=8.1e-08 $l=1.25e-08 $layer=P_src_drn $thickness=1e-09
+ $X=0.056 $Y=0.2025 $X2=0.0685 $Y2=0.2025
r3 64 62 0.0462963 $w=5.4e-08 $l=2.5e-09 $layer=N_src_drn $thickness=1e-09
+ $X=0.1253 $Y=0.054 $X2=0.1225 $Y2=0.054
r4 4 62 0.268519 $w=5.4e-08 $l=1.45e-08 $layer=N_src_drn $thickness=1e-09
+ $X=0.108 $Y=0.054 $X2=0.1225 $Y2=0.054
r5 11 4 0.268519 $w=5.4e-08 $l=1.45e-08 $layer=N_src_drn $thickness=1e-09
+ $X=0.0935 $Y=0.054 $X2=0.108 $Y2=0.054
r6 63 11 0.0462963 $w=5.4e-08 $l=2.5e-09 $layer=N_src_drn $thickness=1e-09
+ $X=0.0906 $Y=0.054 $X2=0.0935 $Y2=0.054
r7 3 59 19.3796 $a=3.24e-16 $layer=V0LISD $X=0.054 $Y=0.2025 $X2=0.054 $Y2=0.234
r8 4 51 19.3796 $a=3.24e-16 $layer=V0LISD $X=0.108 $Y=0.054 $X2=0.112 $Y2=0.036
r9 59 60 3.73104 $w=1.3e-08 $l=1.6e-08 $layer=M1 $thickness=3.6e-08 $X=0.054
+ $Y=0.234 $X2=0.07 $Y2=0.234
r10 57 60 3.61444 $w=1.3e-08 $l=1.55e-08 $layer=M1 $thickness=3.6e-08 $X=0.0855
+ $Y=0.234 $X2=0.07 $Y2=0.234
r11 56 57 3.49785 $w=1.3e-08 $l=1.5e-08 $layer=M1 $thickness=3.6e-08 $X=0.1005
+ $Y=0.234 $X2=0.0855 $Y2=0.234
r12 55 56 5.82974 $w=1.3e-08 $l=2.5e-08 $layer=M1 $thickness=3.6e-08 $X=0.1255
+ $Y=0.234 $X2=0.1005 $Y2=0.234
r13 16 55 7.11229 $w=1.3e-08 $l=3.05e-08 $layer=M1 $thickness=3.6e-08 $X=0.156
+ $Y=0.234 $X2=0.1255 $Y2=0.234
r14 51 52 4.31401 $w=1.3e-08 $l=1.85e-08 $layer=M1 $thickness=3.6e-08 $X=0.112
+ $Y=0.036 $X2=0.1305 $Y2=0.036
r15 17 52 5.94634 $w=1.3e-08 $l=2.55e-08 $layer=M1 $thickness=3.6e-08 $X=0.156
+ $Y=0.036 $X2=0.1305 $Y2=0.036
r16 15 50 2.5483 $w=1.79e-08 $l=1.8e-08 $layer=M1 $thickness=3.6e-08 $X=0.177
+ $Y=0.234 $X2=0.177 $Y2=0.216
r17 15 16 3.24787 $w=1.51429e-08 $l=2.1e-08 $layer=M1 $thickness=3.6e-08
+ $X=0.177 $Y=0.234 $X2=0.156 $Y2=0.234
r18 13 47 2.5483 $w=1.79e-08 $l=1.8e-08 $layer=M1 $thickness=3.6e-08 $X=0.177
+ $Y=0.036 $X2=0.177 $Y2=0.054
r19 13 17 3.24787 $w=1.51429e-08 $l=2.1e-08 $layer=M1 $thickness=3.6e-08
+ $X=0.177 $Y=0.036 $X2=0.156 $Y2=0.036
r20 49 50 4.19742 $w=1.3e-08 $l=1.8e-08 $layer=M1 $thickness=3.6e-08 $X=0.177
+ $Y=0.198 $X2=0.177 $Y2=0.216
r21 48 49 2.68168 $w=1.3e-08 $l=1.15e-08 $layer=M1 $thickness=3.6e-08 $X=0.177
+ $Y=0.1865 $X2=0.177 $Y2=0.198
r22 19 48 5.24677 $w=1.3e-08 $l=2.25e-08 $layer=M1 $thickness=3.6e-08 $X=0.177
+ $Y=0.164 $X2=0.177 $Y2=0.1865
r23 46 47 4.19742 $w=1.3e-08 $l=1.8e-08 $layer=M1 $thickness=3.6e-08 $X=0.177
+ $Y=0.072 $X2=0.177 $Y2=0.054
r24 45 46 2.68168 $w=1.3e-08 $l=1.15e-08 $layer=M1 $thickness=3.6e-08 $X=0.177
+ $Y=0.0835 $X2=0.177 $Y2=0.072
r25 18 45 5.24677 $w=1.3e-08 $l=2.25e-08 $layer=M1 $thickness=3.6e-08 $X=0.177
+ $Y=0.106 $X2=0.177 $Y2=0.0835
r26 14 20 3.01711 $w=1.55e-08 $l=1.8e-08 $layer=M1 $thickness=3.6e-08 $X=0.177
+ $Y=0.135 $X2=0.195 $Y2=0.135
r27 14 18 5.5822 $w=1.45517e-08 $l=2.9e-08 $layer=M1 $thickness=3.6e-08
+ $X=0.177 $Y=0.135 $X2=0.177 $Y2=0.106
r28 14 19 5.5822 $w=1.45517e-08 $l=2.9e-08 $layer=M1 $thickness=3.6e-08
+ $X=0.177 $Y=0.135 $X2=0.177 $Y2=0.164
r29 43 42 14.6259 $w=2.1e-08 $l=4.3e-08 $layer=Gate_1 $thickness=5.6e-08
+ $X=0.243 $Y=0.2025 $X2=0.243 $Y2=0.1595
r30 41 42 2.7211 $w=2.1e-08 $l=8e-09 $layer=Gate_1 $thickness=5.6e-08 $X=0.243
+ $Y=0.1515 $X2=0.243 $Y2=0.1595
r31 39 40 14.6259 $w=2.1e-08 $l=4.3e-08 $layer=Gate_1 $thickness=5.6e-08
+ $X=0.243 $Y=0.0675 $X2=0.243 $Y2=0.1105
r32 37 40 2.7211 $w=2.1e-08 $l=8e-09 $layer=Gate_1 $thickness=5.6e-08 $X=0.243
+ $Y=0.1185 $X2=0.243 $Y2=0.1105
r33 10 31 6.54019 $w=2.09524e-08 $layer=Gate_1 $thickness=5.21905e-08 $X=0.243
+ $Y=0.135 $X2=0.243 $Y2=0.135
r34 10 37 5.79936 $w=2.03333e-08 $l=1.65e-08 $layer=Gate_1 $thickness=5.6e-08
+ $X=0.243 $Y=0.135 $X2=0.243 $Y2=0.1185
r35 10 41 5.79936 $w=2.03333e-08 $l=1.65e-08 $layer=Gate_1 $thickness=5.6e-08
+ $X=0.243 $Y=0.135 $X2=0.243 $Y2=0.1515
r36 33 34 2.09871 $w=1.3e-08 $l=9e-09 $layer=M1 $thickness=3.6e-08 $X=0.2055
+ $Y=0.135 $X2=0.2145 $Y2=0.135
r37 20 33 2.44849 $w=1.3e-08 $l=1.05e-08 $layer=M1 $thickness=3.6e-08 $X=0.195
+ $Y=0.135 $X2=0.2055 $Y2=0.135
r38 30 31 5.86058 $w=1.96226e-08 $l=1.55e-08 $layer=LIG $thickness=4.8e-08
+ $X=0.2275 $Y=0.135 $X2=0.243 $Y2=0.135
r39 29 30 8.56549 $w=1.53e-08 $l=1.45e-08 $layer=LIG $thickness=4.8e-08
+ $X=0.213 $Y=0.135 $X2=0.2275 $Y2=0.135
r40 29 34 19.3796 $a=3.24e-16 $layer=V0LIG $X=0.213 $Y=0.135 $X2=0.2145
+ $Y2=0.135
r41 28 29 6.79332 $w=1.53e-08 $l=1.15e-08 $layer=LIG $thickness=4.8e-08
+ $X=0.2015 $Y=0.135 $X2=0.213 $Y2=0.135
r42 1 23 6.54019 $w=2.09524e-08 $layer=Gate_1 $thickness=5.21905e-08 $X=0.189
+ $Y=0.135 $X2=0.189 $Y2=0.135
r43 1 28 4.08841 $w=2.066e-08 $l=1.25e-08 $layer=LIG $thickness=4.8e-08
+ $X=0.189 $Y=0.135 $X2=0.2015 $Y2=0.135
r44 25 24 16.4967 $w=2.1e-08 $l=4.85e-08 $layer=Gate_1 $thickness=5.6e-08
+ $X=0.189 $Y=0.2025 $X2=0.189 $Y2=0.154
r45 23 24 6.6497 $w=2.04211e-08 $l=1.9e-08 $layer=Gate_1 $thickness=5.6e-08
+ $X=0.189 $Y=0.135 $X2=0.189 $Y2=0.154
r46 22 23 6.6497 $w=2.04211e-08 $l=1.9e-08 $layer=Gate_1 $thickness=5.6e-08
+ $X=0.189 $Y=0.116 $X2=0.189 $Y2=0.135
r47 21 22 16.4967 $w=2.1e-08 $l=4.85e-08 $layer=Gate_1 $thickness=5.6e-08
+ $X=0.189 $Y=0.0675 $X2=0.189 $Y2=0.116
r48 21 9 14.6259 $w=2.1e-08 $l=4.3e-08 $layer=Gate_1 $thickness=5.6e-08
+ $X=0.189 $Y=0.0675 $X2=0.189 $Y2=0.0245
r49 3 12 1e-05 $l=2e-09 $X=0.054 $Y=0.2025 $X2=0.056 $Y2=0.2025
.ends

.subckt PM_OR2x2_ASAP7_75t_R%B vss 24 9 15 1 8 3 4 7
c1 1 vss 0.00420392f $X=0.0715 $Y=0.1355
c2 3 vss 0.0391123f $X=0.081 $Y=0.0245
c3 4 vss 0.00800007f $X=0.027 $Y=0.036
c4 5 vss 0.00148085f $X=0.027 $Y=0.1297
c5 6 vss 0.00872391f $X=0.027 $Y=0.1035
c6 7 vss 0.00617163f $X=0.027 $Y=0.1665
c7 8 vss 0.00210749f $X=0.047 $Y=0.135
r1 4 27 3.01711 $w=1.55e-08 $l=1.8e-08 $layer=M1 $thickness=3.6e-08 $X=0.027
+ $Y=0.036 $X2=0.027 $Y2=0.054
r2 7 25 5.73148 $w=1.38716e-08 $l=2.73e-08 $layer=M1 $thickness=3.6e-08
+ $X=0.027 $Y=0.1665 $X2=0.027 $Y2=0.1392
r3 26 27 4.19742 $w=1.3e-08 $l=1.8e-08 $layer=M1 $thickness=3.6e-08 $X=0.027
+ $Y=0.072 $X2=0.027 $Y2=0.054
r4 6 26 7.34548 $w=1.3e-08 $l=3.15e-08 $layer=M1 $thickness=3.6e-08 $X=0.027
+ $Y=0.1035 $X2=0.027 $Y2=0.072
r5 24 25 0.535733 $w=1.8e-08 $l=5.2e-09 $layer=M1 $thickness=3.6e-08 $X=0.028
+ $Y=0.134 $X2=0.027 $Y2=0.1392
r6 24 5 0.433689 $w=1.8e-08 $l=4.3e-09 $layer=M1 $thickness=3.6e-08 $X=0.028
+ $Y=0.134 $X2=0.027 $Y2=0.1297
r7 5 6 5.62944 $w=1.37143e-08 $l=2.62e-08 $layer=M1 $thickness=3.6e-08 $X=0.027
+ $Y=0.1297 $X2=0.027 $Y2=0.1035
r8 24 21 0.517402 $w=3.18182e-09 $l=1.10454e-08 $layer=M1 $thickness=3.6e-08
+ $X=0.028 $Y=0.134 $X2=0.038 $Y2=0.135
r9 20 22 2.09871 $w=1.3e-08 $l=9e-09 $layer=M1 $thickness=3.6e-08 $X=0.0545
+ $Y=0.135 $X2=0.0635 $Y2=0.135
r10 8 20 1.74892 $w=1.3e-08 $l=7.5e-09 $layer=M1 $thickness=3.6e-08 $X=0.047
+ $Y=0.135 $X2=0.0545 $Y2=0.135
r11 8 21 2.09871 $w=1.3e-08 $l=9e-09 $layer=M1 $thickness=3.6e-08 $X=0.047
+ $Y=0.135 $X2=0.038 $Y2=0.135
r12 18 22 19.3796 $a=3.24e-16 $layer=V0LIG $X=0.0625 $Y=0.1355 $X2=0.0635
+ $Y2=0.135
r13 1 17 2.36633 $w=2.3e-08 $l=1e-08 $layer=LIG $thickness=4.8e-08 $X=0.0715
+ $Y=0.1355 $X2=0.0815 $Y2=0.1355
r14 1 18 4.01497 $w=1.66722e-08 $l=9e-09 $layer=LIG $thickness=4.8e-08
+ $X=0.0715 $Y=0.1355 $X2=0.0625 $Y2=0.1355
r15 15 14 14.6259 $w=2.1e-08 $l=4.3e-08 $layer=Gate_1 $thickness=5.6e-08
+ $X=0.081 $Y=0.2025 $X2=0.081 $Y2=0.1595
r16 13 14 2.55104 $w=2.1e-08 $l=7.5e-09 $layer=Gate_1 $thickness=5.6e-08
+ $X=0.081 $Y=0.152 $X2=0.081 $Y2=0.1595
r17 12 13 5.80786 $w=2.0303e-08 $l=1.65e-08 $layer=Gate_1 $thickness=5.6e-08
+ $X=0.081 $Y=0.1355 $X2=0.081 $Y2=0.152
r18 12 17 6.35518 $w=2.13571e-08 $l=5e-10 $layer=Gate_1 $thickness=5.2381e-08
+ $X=0.081 $Y=0.1355 $X2=0.0815 $Y2=0.1355
r19 11 12 5.97793 $w=2.03235e-08 $l=1.7e-08 $layer=Gate_1 $thickness=5.6e-08
+ $X=0.081 $Y=0.1185 $X2=0.081 $Y2=0.1355
r20 10 11 7.31297 $w=2.1e-08 $l=2.15e-08 $layer=Gate_1 $thickness=5.6e-08
+ $X=0.081 $Y=0.097 $X2=0.081 $Y2=0.1185
r21 9 10 14.6259 $w=2.1e-08 $l=4.3e-08 $layer=Gate_1 $thickness=5.6e-08
+ $X=0.081 $Y=0.054 $X2=0.081 $Y2=0.097
r22 9 3 10.0341 $w=2.1e-08 $l=2.95e-08 $layer=Gate_1 $thickness=5.6e-08
+ $X=0.081 $Y=0.054 $X2=0.081 $Y2=0.0245
.ends

* End of included file OR2x2_ASAP7_75t_R.pex.sp.pex

*
.subckt OR2x2_ASAP7_75t_CUSTOM_4_25_0_7 VSS VDD B A Y
*
* VSS VSS
* VDD VDD
* B B
* A A
* Y Y
*
*

M0 N_M0_d N_M0_g VSS VSS nmos_rvt L=2e-08 W=5.4e-08 nfin=2 $X=0.071 $Y=0.027
M1 VSS N_M1_g N_M1_s VSS nmos_rvt L=2e-08 W=5.4e-08 nfin=2 $X=0.125 $Y=0.027
M2 N_M2_d N_M2_g VSS VSS nmos_rvt L=2e-08 W=8.1e-08 nfin=3 $X=0.179 $Y=0.027
M3 N_M3_d N_M3_g VSS VSS nmos_rvt L=2e-08 W=8.1e-08 nfin=3 $X=0.233 $Y=0.027
M4 N_M4_d N_M4_g N_M4_s VDD pmos_rvt L=2e-08 W=8.1e-08 nfin=3 $X=0.071 $Y=0.162
M5 VDD N_M5_g N_M5_s VDD pmos_rvt L=2e-08 W=8.1e-08 nfin=3 $X=0.125 $Y=0.162
M6 N_M6_d N_M6_g VDD VDD pmos_rvt L=2e-08 W=8.1e-08 nfin=3 $X=0.179 $Y=0.162
M7 N_M7_d N_M7_g VDD VDD pmos_rvt L=2e-08 W=8.1e-08 nfin=3 $X=0.233 $Y=0.162

* .include "OR2x2_ASAP7_75t_R.pex.sp.pxi"

* Start of included file OR2x2_ASAP7_75t_R.pex.sp.pxi
x_PM_OR2x2_ASAP7_75t_R%7 vss N_M4_d N_M5_s N_7_1 PM_OR2x2_ASAP7_75t_R%7
cc_1 N_7_1 N_B_3 0.016896f $X=0.108 $Y=0.2025
cc_2 N_7_1 N_A_3 0.016974f $X=0.108 $Y=0.2025
x_PM_OR2x2_ASAP7_75t_R%A vss A N_M1_g N_M5_g N_A_1 N_A_3 N_A_4 N_A_5
+ PM_OR2x2_ASAP7_75t_R%A
cc_3 N_A_1 N_B_1 0.00155169f $X=0.135 $Y=0.135
cc_4 A N_B_8 0.0016332f $X=0.137 $Y=0.134
cc_5 N_A_3 N_B_3 0.00912478f $X=0.135 $Y=0.0245
x_PM_OR2x2_ASAP7_75t_R%Y vss Y N_M2_d N_M3_d N_M6_d N_M7_d N_Y_8 N_Y_1 N_Y_2
+ N_Y_13 N_Y_14 N_Y_7 PM_OR2x2_ASAP7_75t_R%Y
cc_6 N_Y_8 N_5_19 0.000682181f $X=0.2015 $Y=0.2025
cc_7 N_Y_8 N_5_9 0.0379482f $X=0.2015 $Y=0.2025
cc_8 N_Y_8 N_5_1 0.00187993f $X=0.2015 $Y=0.2025
cc_9 N_Y_8 N_5_20 0.00122657f $X=0.2015 $Y=0.2025
cc_10 N_Y_8 N_5_13 0.00141123f $X=0.2015 $Y=0.2025
cc_11 N_Y_8 N_5_15 0.00141138f $X=0.2015 $Y=0.2025
cc_12 N_Y_1 N_5_9 0.00191108f $X=0.216 $Y=0.0675
cc_13 N_Y_2 N_5_9 0.00192941f $X=0.216 $Y=0.2025
cc_14 N_Y_13 N_5_18 0.00352693f $X=0.216 $Y=0.054
cc_15 N_Y_14 N_5_19 0.003527f $X=0.216 $Y=0.1865
cc_16 N_Y_7 N_5_1 0.0046525f $X=0.2015 $Y=0.0675
cc_17 N_Y_7 N_5_10 0.0103049f $X=0.2015 $Y=0.0675
cc_18 N_Y_7 N_5_9 0.0184369f $X=0.2015 $Y=0.0675
cc_19 N_Y_8 N_5_10 0.0680167f $X=0.2015 $Y=0.2025
x_PM_OR2x2_ASAP7_75t_R%5 vss N_M2_g N_M6_g N_M3_g N_M7_g N_M0_d N_M1_s N_M4_s
+ N_5_17 N_5_3 N_5_4 N_5_16 N_5_12 N_5_11 N_5_14 N_5_1 N_5_18 N_5_19 N_5_9
+ N_5_20 N_5_13 N_5_15 N_5_10 PM_OR2x2_ASAP7_75t_R%5
cc_20 N_5_17 N_B_3 0.000408346f $X=0.156 $Y=0.036
cc_21 N_5_3 N_B_1 0.000491645f $X=0.054 $Y=0.2025
cc_22 N_5_4 N_B_3 0.000572352f $X=0.108 $Y=0.054
cc_23 N_5_17 N_B_4 0.000794716f $X=0.156 $Y=0.036
cc_24 N_5_16 N_B_7 0.000892068f $X=0.156 $Y=0.234
cc_25 N_5_3 N_B_7 0.00151378f $X=0.054 $Y=0.2025
cc_26 N_5_3 N_B_3 0.00225369f $X=0.054 $Y=0.2025
cc_27 N_5_12 N_B_1 0.00229836f $X=0.056 $Y=0.2025
cc_28 N_5_11 N_B_3 0.0105395f $X=0.0935 $Y=0.054
cc_29 N_5_12 N_B_3 0.0511645f $X=0.056 $Y=0.2025
cc_30 N_5_14 N_A_3 0.000651438f $X=0.177 $Y=0.135
cc_31 N_5_4 N_A_3 0.000774719f $X=0.108 $Y=0.054
cc_32 N_5_1 N_A_1 0.00156709f $X=0.189 $Y=0.135
cc_33 N_5_18 A 0.00180453f $X=0.177 $Y=0.106
cc_34 N_5_19 A 0.00180523f $X=0.177 $Y=0.164
cc_35 N_5_11 N_A_3 0.0105252f $X=0.0935 $Y=0.054
cc_36 N_5_14 A 0.00408978f $X=0.177 $Y=0.135
cc_37 N_5_17 N_A_4 0.00432596f $X=0.156 $Y=0.036
cc_38 N_5_16 N_A_5 0.00483114f $X=0.156 $Y=0.234
cc_39 N_5_9 N_A_3 0.0187959f $X=0.189 $Y=0.0245
x_PM_OR2x2_ASAP7_75t_R%B vss B N_M0_g N_M4_g N_B_1 N_B_8 N_B_3 N_B_4 N_B_7
+ PM_OR2x2_ASAP7_75t_R%B

* End of included file OR2x2_ASAP7_75t_R.pex.sp.pxi
.ends

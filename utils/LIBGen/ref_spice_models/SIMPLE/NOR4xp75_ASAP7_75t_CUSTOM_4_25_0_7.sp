.subckt PM_NOR4xp75_ASAP7_75t_R%7 vss 16 17 28 29 32 33 10 1 11 12 3 13 2
c1 1 vss 0.00861278f $X=0.108 $Y=0.2025
c2 2 vss 0.00597506f $X=0.216 $Y=0.2025
c3 3 vss 0.00388083f $X=0.324 $Y=0.2025
c4 10 vss 0.00451068f $X=0.0935 $Y=0.2025
c5 11 vss 0.00313378f $X=0.2015 $Y=0.2025
c6 12 vss 0.00189508f $X=0.3095 $Y=0.2025
c7 13 vss 0.0209801f $X=0.0935 $Y=0.234
r1 33 31 0.0308642 $w=8.1e-08 $l=2.5e-09 $layer=P_src_drn $thickness=1e-09
+ $X=0.3413 $Y=0.2025 $X2=0.3385 $Y2=0.2025
r2 3 31 0.179012 $w=8.1e-08 $l=1.45e-08 $layer=P_src_drn $thickness=1e-09
+ $X=0.324 $Y=0.2025 $X2=0.3385 $Y2=0.2025
r3 12 3 0.179012 $w=8.1e-08 $l=1.45e-08 $layer=P_src_drn $thickness=1e-09
+ $X=0.3095 $Y=0.2025 $X2=0.324 $Y2=0.2025
r4 32 12 0.0308642 $w=8.1e-08 $l=2.5e-09 $layer=P_src_drn $thickness=1e-09
+ $X=0.3066 $Y=0.2025 $X2=0.3095 $Y2=0.2025
r5 29 27 0.0308642 $w=8.1e-08 $l=2.5e-09 $layer=P_src_drn $thickness=1e-09
+ $X=0.2333 $Y=0.2025 $X2=0.2305 $Y2=0.2025
r6 2 27 0.179012 $w=8.1e-08 $l=1.45e-08 $layer=P_src_drn $thickness=1e-09
+ $X=0.216 $Y=0.2025 $X2=0.2305 $Y2=0.2025
r7 11 2 0.179012 $w=8.1e-08 $l=1.45e-08 $layer=P_src_drn $thickness=1e-09
+ $X=0.2015 $Y=0.2025 $X2=0.216 $Y2=0.2025
r8 28 11 0.0308642 $w=8.1e-08 $l=2.5e-09 $layer=P_src_drn $thickness=1e-09
+ $X=0.1986 $Y=0.2025 $X2=0.2015 $Y2=0.2025
r9 3 24 19.3796 $a=3.24e-16 $layer=V0LISD $X=0.324 $Y=0.2025 $X2=0.324 $Y2=0.234
r10 2 21 19.3796 $a=3.24e-16 $layer=V0LISD $X=0.216 $Y=0.2025 $X2=0.216
+ $Y2=0.234
r11 23 24 8.97781 $w=1.3e-08 $l=3.85e-08 $layer=M1 $thickness=3.6e-08 $X=0.2855
+ $Y=0.234 $X2=0.324 $Y2=0.234
r12 22 23 10.4935 $w=1.3e-08 $l=4.5e-08 $layer=M1 $thickness=3.6e-08 $X=0.2405
+ $Y=0.234 $X2=0.2855 $Y2=0.234
r13 21 22 5.71315 $w=1.3e-08 $l=2.45e-08 $layer=M1 $thickness=3.6e-08 $X=0.216
+ $Y=0.234 $X2=0.2405 $Y2=0.234
r14 20 21 12.5922 $w=1.3e-08 $l=5.4e-08 $layer=M1 $thickness=3.6e-08 $X=0.162
+ $Y=0.234 $X2=0.216 $Y2=0.234
r15 19 20 12.5922 $w=1.3e-08 $l=5.4e-08 $layer=M1 $thickness=3.6e-08 $X=0.108
+ $Y=0.234 $X2=0.162 $Y2=0.234
r16 18 19 2.56509 $w=1.3e-08 $l=1.1e-08 $layer=M1 $thickness=3.6e-08 $X=0.097
+ $Y=0.234 $X2=0.108 $Y2=0.234
r17 13 18 0.816164 $w=1.3e-08 $l=3.5e-09 $layer=M1 $thickness=3.6e-08 $X=0.0935
+ $Y=0.234 $X2=0.097 $Y2=0.234
r18 1 19 19.3796 $a=3.24e-16 $layer=V0LISD $X=0.108 $Y=0.2025 $X2=0.108
+ $Y2=0.234
r19 17 15 0.0308642 $w=8.1e-08 $l=2.5e-09 $layer=P_src_drn $thickness=1e-09
+ $X=0.1253 $Y=0.2025 $X2=0.1225 $Y2=0.2025
r20 1 15 0.179012 $w=8.1e-08 $l=1.45e-08 $layer=P_src_drn $thickness=1e-09
+ $X=0.108 $Y=0.2025 $X2=0.1225 $Y2=0.2025
r21 10 1 0.179012 $w=8.1e-08 $l=1.45e-08 $layer=P_src_drn $thickness=1e-09
+ $X=0.0935 $Y=0.2025 $X2=0.108 $Y2=0.2025
r22 16 10 0.0308642 $w=8.1e-08 $l=2.5e-09 $layer=P_src_drn $thickness=1e-09
+ $X=0.0906 $Y=0.2025 $X2=0.0935 $Y2=0.2025
.ends

.subckt PM_NOR4xp75_ASAP7_75t_R%D vss 28 12 18 34 37 40 43 5 1 8 3 4 11 6
c1 1 vss 0.0102645f $X=0.0715 $Y=0.135
c2 3 vss 0.0750431f $X=0.081 $Y=0.0245
c3 4 vss 0.0708274f $X=0.135 $Y=0.135
c4 5 vss 0.0737516f $X=0.189 $Y=0.135
c5 6 vss 0.0105031f $X=0.027 $Y=0.036
c6 7 vss 0.00240183f $X=0.027 $Y=0.135
c7 8 vss 0.0105536f $X=0.027 $Y=0.234
c8 9 vss 0.0128353f $X=0.027 $Y=0.098
c9 10 vss 0.0134779f $X=0.027 $Y=0.1475
c10 11 vss 0.00558892f $X=0.0645 $Y=0.135
r1 8 48 3.01711 $w=1.55e-08 $l=1.8e-08 $layer=M1 $thickness=3.6e-08 $X=0.027
+ $Y=0.234 $X2=0.027 $Y2=0.216
r2 6 45 3.83327 $w=1.5093e-08 $l=2.15e-08 $layer=M1 $thickness=3.6e-08 $X=0.027
+ $Y=0.036 $X2=0.027 $Y2=0.0575
r3 47 48 2.91487 $w=1.3e-08 $l=1.25e-08 $layer=M1 $thickness=3.6e-08 $X=0.027
+ $Y=0.2035 $X2=0.027 $Y2=0.216
r4 46 47 6.52931 $w=1.3e-08 $l=2.8e-08 $layer=M1 $thickness=3.6e-08 $X=0.027
+ $Y=0.1755 $X2=0.027 $Y2=0.2035
r5 10 46 6.52931 $w=1.3e-08 $l=2.8e-08 $layer=M1 $thickness=3.6e-08 $X=0.027
+ $Y=0.1475 $X2=0.027 $Y2=0.1755
r6 9 45 9.44419 $w=1.3e-08 $l=4.05e-08 $layer=M1 $thickness=3.6e-08 $X=0.027
+ $Y=0.098 $X2=0.027 $Y2=0.0575
r7 7 30 3.36689 $w=1.53077e-08 $l=1.95e-08 $layer=M1 $thickness=3.6e-08
+ $X=0.027 $Y=0.135 $X2=0.0465 $Y2=0.135
r8 7 9 7.44771 $w=1.42162e-08 $l=3.7e-08 $layer=M1 $thickness=3.6e-08 $X=0.027
+ $Y=0.135 $X2=0.027 $Y2=0.098
r9 7 10 1.73456 $w=1.66e-08 $l=1.25e-08 $layer=M1 $thickness=3.6e-08 $X=0.027
+ $Y=0.135 $X2=0.027 $Y2=0.1475
r10 43 42 16.8368 $w=2.1e-08 $l=4.95e-08 $layer=Gate_1 $thickness=5.6e-08
+ $X=0.189 $Y=0.2025 $X2=0.189 $Y2=0.153
r11 40 41 16.8368 $w=2.1e-08 $l=4.95e-08 $layer=Gate_1 $thickness=5.6e-08
+ $X=0.189 $Y=0.054 $X2=0.189 $Y2=0.1035
r12 5 26 7.07951 $w=1.89474e-08 $layer=LIG $thickness=5.17895e-08 $X=0.189
+ $Y=0.135 $X2=0.189 $Y2=0.135
r13 5 41 10.8674 $w=2.07143e-08 $l=3.15e-08 $layer=Gate_1 $thickness=5.6e-08
+ $X=0.189 $Y=0.135 $X2=0.189 $Y2=0.1035
r14 5 42 6.27555 $w=2.05e-08 $l=1.8e-08 $layer=Gate_1 $thickness=5.6e-08
+ $X=0.189 $Y=0.135 $X2=0.189 $Y2=0.153
r15 37 36 16.8368 $w=2.1e-08 $l=4.95e-08 $layer=Gate_1 $thickness=5.6e-08
+ $X=0.135 $Y=0.2025 $X2=0.135 $Y2=0.153
r16 34 35 16.8368 $w=2.1e-08 $l=4.95e-08 $layer=Gate_1 $thickness=5.6e-08
+ $X=0.135 $Y=0.054 $X2=0.135 $Y2=0.1035
r17 4 24 7.07951 $w=1.89474e-08 $layer=LIG $thickness=5.17895e-08 $X=0.135
+ $Y=0.135 $X2=0.135 $Y2=0.135
r18 4 35 10.8674 $w=2.07143e-08 $l=3.15e-08 $layer=Gate_1 $thickness=5.6e-08
+ $X=0.135 $Y=0.135 $X2=0.135 $Y2=0.1035
r19 4 36 6.27555 $w=2.05e-08 $l=1.8e-08 $layer=Gate_1 $thickness=5.6e-08
+ $X=0.135 $Y=0.135 $X2=0.135 $Y2=0.153
r20 28 11 3.84763 $w=1.3e-08 $l=1.65e-08 $layer=M1 $thickness=3.6e-08 $X=0.081
+ $Y=0.138 $X2=0.0645 $Y2=0.135
r21 11 30 4.19742 $w=1.3e-08 $l=1.8e-08 $layer=M1 $thickness=3.6e-08 $X=0.0645
+ $Y=0.135 $X2=0.0465 $Y2=0.135
r22 25 26 30.1405 $w=1.37815e-08 $l=2.7e-08 $layer=LIG $thickness=4.8e-08
+ $X=0.162 $Y=0.135 $X2=0.189 $Y2=0.135
r23 24 25 30.1405 $w=1.37815e-08 $l=2.7e-08 $layer=LIG $thickness=4.8e-08
+ $X=0.135 $Y=0.135 $X2=0.162 $Y2=0.135
r24 23 24 30.1405 $w=1.37815e-08 $l=2.7e-08 $layer=LIG $thickness=4.8e-08
+ $X=0.108 $Y=0.135 $X2=0.135 $Y2=0.135
r25 21 23 26.4685 $w=1.14914e-08 $l=1.75e-08 $layer=LIG $thickness=4.8e-08
+ $X=0.0905 $Y=0.135 $X2=0.108 $Y2=0.135
r26 20 21 3.67195 $w=1.8e-08 $l=9.5e-09 $layer=LIG $thickness=4.8e-08 $X=0.081
+ $Y=0.135 $X2=0.0905 $Y2=0.135
r27 28 20 19.3796 $a=3.24e-16 $layer=V0LIG $X=0.081 $Y=0.138 $X2=0.081 $Y2=0.135
r28 1 20 3.67195 $w=1.8e-08 $l=9.5e-09 $layer=LIG $thickness=4.8e-08 $X=0.0715
+ $Y=0.135 $X2=0.081 $Y2=0.135
r29 18 17 14.6259 $w=2.1e-08 $l=4.3e-08 $layer=Gate_1 $thickness=5.6e-08
+ $X=0.081 $Y=0.2025 $X2=0.081 $Y2=0.1595
r30 16 17 3.06124 $w=2.1e-08 $l=9e-09 $layer=Gate_1 $thickness=5.6e-08 $X=0.081
+ $Y=0.1505 $X2=0.081 $Y2=0.1595
r31 15 16 5.4252 $w=2.04194e-08 $l=1.55e-08 $layer=Gate_1 $thickness=5.6e-08
+ $X=0.081 $Y=0.135 $X2=0.081 $Y2=0.1505
r32 15 21 3.40757 $w=1.98947e-08 $l=9.5e-09 $layer=Gate_1
+ $thickness=5.55789e-08 $X=0.081 $Y=0.135 $X2=0.0905 $Y2=0.135
r33 15 20 6.69299 $w=1.9e-08 $layer=LIG $thickness=5.2e-08 $X=0.081 $Y=0.135
+ $X2=0.081 $Y2=0.135
r34 14 15 5.4252 $w=2.04194e-08 $l=1.55e-08 $layer=Gate_1 $thickness=5.6e-08
+ $X=0.081 $Y=0.1195 $X2=0.081 $Y2=0.135
r35 13 14 7.65311 $w=2.1e-08 $l=2.25e-08 $layer=Gate_1 $thickness=5.6e-08
+ $X=0.081 $Y=0.097 $X2=0.081 $Y2=0.1195
r36 12 13 14.6259 $w=2.1e-08 $l=4.3e-08 $layer=Gate_1 $thickness=5.6e-08
+ $X=0.081 $Y=0.054 $X2=0.081 $Y2=0.097
r37 12 3 10.0341 $w=2.1e-08 $l=2.95e-08 $layer=Gate_1 $thickness=5.6e-08
+ $X=0.081 $Y=0.054 $X2=0.081 $Y2=0.0245
.ends

.subckt PM_NOR4xp75_ASAP7_75t_R%B vss 35 9 13 24 27 30 33 1 3 7 5 6 4 8
c1 1 vss 0.0168784f $X=0.405 $Y=0.135
c2 3 vss 0.0397246f $X=0.405 $Y=0.0245
c3 4 vss 0.0393154f $X=0.459 $Y=0.135
c4 5 vss 0.0396029f $X=0.513 $Y=0.135
c5 6 vss 0.00732137f $X=0.513 $Y=0.16
c6 7 vss 0.00780448f $X=0.54 $Y=0.1575
c7 8 vss 0.00868183f $X=0.513 $Y=0.098
r1 7 38 0.9184 $w=1.8e-08 $l=9e-09 $layer=M1 $thickness=3.6e-08 $X=0.54
+ $Y=0.1575 $X2=0.54 $Y2=0.1665
r2 37 38 1.30447 $w=1.47857e-08 $l=1.49833e-08 $layer=M1 $thickness=3.6e-08
+ $X=0.5265 $Y=0.16 $X2=0.54 $Y2=0.1665
r3 6 36 1.73456 $w=1.66e-08 $l=1.25e-08 $layer=M1 $thickness=3.6e-08 $X=0.513
+ $Y=0.16 $X2=0.513 $Y2=0.1475
r4 6 37 1.96775 $w=1.63333e-08 $l=1.35e-08 $layer=M1 $thickness=3.6e-08
+ $X=0.513 $Y=0.16 $X2=0.5265 $Y2=0.16
r5 35 36 2.91487 $w=1.3e-08 $l=1.25e-08 $layer=M1 $thickness=3.6e-08 $X=0.521
+ $Y=0.138 $X2=0.513 $Y2=0.1475
r6 35 8 8.62802 $w=1.3e-08 $l=3.7e-08 $layer=M1 $thickness=3.6e-08 $X=0.521
+ $Y=0.138 $X2=0.513 $Y2=0.098
r7 33 32 16.6668 $w=2.1e-08 $l=4.9e-08 $layer=Gate_1 $thickness=5.6e-08
+ $X=0.513 $Y=0.2025 $X2=0.513 $Y2=0.1535
r8 30 31 16.6668 $w=2.1e-08 $l=4.9e-08 $layer=Gate_1 $thickness=5.6e-08
+ $X=0.513 $Y=0.054 $X2=0.513 $Y2=0.103
r9 5 20 6.4296 $w=2e-08 $layer=Gate_1 $thickness=5.22105e-08 $X=0.513 $Y=0.135
+ $X2=0.513 $Y2=0.135
r10 5 31 11.0545 $w=2.06875e-08 $l=3.2e-08 $layer=Gate_1 $thickness=5.6e-08
+ $X=0.513 $Y=0.135 $X2=0.513 $Y2=0.103
r11 5 32 6.46262 $w=2.04595e-08 $l=1.85e-08 $layer=Gate_1 $thickness=5.6e-08
+ $X=0.513 $Y=0.135 $X2=0.513 $Y2=0.1535
r12 27 26 16.6668 $w=2.1e-08 $l=4.9e-08 $layer=Gate_1 $thickness=5.6e-08
+ $X=0.459 $Y=0.2025 $X2=0.459 $Y2=0.1535
r13 24 25 16.6668 $w=2.1e-08 $l=4.9e-08 $layer=Gate_1 $thickness=5.6e-08
+ $X=0.459 $Y=0.054 $X2=0.459 $Y2=0.103
r14 4 17 6.74717 $w=2e-08 $layer=Gate_1 $thickness=5.2e-08 $X=0.459 $Y=0.135
+ $X2=0.459 $Y2=0.135
r15 4 25 11.0545 $w=2.06875e-08 $l=3.2e-08 $layer=Gate_1 $thickness=5.6e-08
+ $X=0.459 $Y=0.135 $X2=0.459 $Y2=0.103
r16 4 26 6.46262 $w=2.04595e-08 $l=1.85e-08 $layer=Gate_1 $thickness=5.6e-08
+ $X=0.459 $Y=0.135 $X2=0.459 $Y2=0.1535
r17 35 20 19.3796 $a=3.24e-16 $layer=V0LIG $X=0.521 $Y=0.138 $X2=0.513 $Y2=0.135
r18 19 20 3.01694 $w=2e-08 $l=9.5e-09 $layer=LIG $thickness=4.8e-08 $X=0.5035
+ $Y=0.135 $X2=0.513 $Y2=0.135
r19 18 19 17.097 $w=1.34914e-08 $l=1.75e-08 $layer=LIG $thickness=4.8e-08
+ $X=0.486 $Y=0.135 $X2=0.5035 $Y2=0.135
r20 17 18 20.114 $w=1.57815e-08 $l=2.7e-08 $layer=LIG $thickness=4.8e-08
+ $X=0.459 $Y=0.135 $X2=0.486 $Y2=0.135
r21 16 17 20.114 $w=1.57815e-08 $l=2.7e-08 $layer=LIG $thickness=4.8e-08
+ $X=0.432 $Y=0.135 $X2=0.459 $Y2=0.135
r22 1 11 6.74717 $w=2e-08 $layer=Gate_1 $thickness=5.2e-08 $X=0.405 $Y=0.135
+ $X2=0.405 $Y2=0.135
r23 1 16 20.114 $w=1.57815e-08 $l=2.7e-08 $layer=LIG $thickness=4.8e-08
+ $X=0.405 $Y=0.135 $X2=0.432 $Y2=0.135
r24 13 12 16.6668 $w=2.1e-08 $l=4.9e-08 $layer=Gate_1 $thickness=5.6e-08
+ $X=0.405 $Y=0.2025 $X2=0.405 $Y2=0.1535
r25 11 12 6.46262 $w=2.04595e-08 $l=1.85e-08 $layer=Gate_1 $thickness=5.6e-08
+ $X=0.405 $Y=0.135 $X2=0.405 $Y2=0.1535
r26 10 11 11.0545 $w=2.06875e-08 $l=3.2e-08 $layer=Gate_1 $thickness=5.6e-08
+ $X=0.405 $Y=0.103 $X2=0.405 $Y2=0.135
r27 9 10 16.6668 $w=2.1e-08 $l=4.9e-08 $layer=Gate_1 $thickness=5.6e-08
+ $X=0.405 $Y=0.054 $X2=0.405 $Y2=0.103
r28 9 3 10.0341 $w=2.1e-08 $l=2.95e-08 $layer=Gate_1 $thickness=5.6e-08
+ $X=0.405 $Y=0.054 $X2=0.405 $Y2=0.0245
.ends

.subckt PM_NOR4xp75_ASAP7_75t_R%A vss 19 7 11 23 26 30 34 3 6 1 5 4
c1 1 vss 0.0196095f $X=0.621 $Y=0.135
c2 3 vss 0.0414641f $X=0.567 $Y=0.135
c3 4 vss 0.0403065f $X=0.621 $Y=0.0245
c4 5 vss 0.043556f $X=0.675 $Y=0.135
c5 6 vss 0.010055f $X=0.621 $Y=0.098
r1 34 33 14.6259 $w=2.1e-08 $l=4.3e-08 $layer=Gate_1 $thickness=5.6e-08
+ $X=0.675 $Y=0.2025 $X2=0.675 $Y2=0.1595
r2 32 33 2.89117 $w=2.1e-08 $l=8.5e-09 $layer=Gate_1 $thickness=5.6e-08
+ $X=0.675 $Y=0.151 $X2=0.675 $Y2=0.1595
r3 30 31 14.6259 $w=2.1e-08 $l=4.3e-08 $layer=Gate_1 $thickness=5.6e-08
+ $X=0.675 $Y=0.054 $X2=0.675 $Y2=0.097
r4 28 31 7.48304 $w=2.1e-08 $l=2.2e-08 $layer=Gate_1 $thickness=5.6e-08
+ $X=0.675 $Y=0.119 $X2=0.675 $Y2=0.097
r5 5 17 6.74717 $w=2e-08 $layer=Gate_1 $thickness=5.2e-08 $X=0.675 $Y=0.135
+ $X2=0.675 $Y2=0.135
r6 5 28 5.61228 $w=2.0375e-08 $l=1.6e-08 $layer=Gate_1 $thickness=5.6e-08
+ $X=0.675 $Y=0.135 $X2=0.675 $Y2=0.119
r7 5 32 5.61228 $w=2.0375e-08 $l=1.6e-08 $layer=Gate_1 $thickness=5.6e-08
+ $X=0.675 $Y=0.135 $X2=0.675 $Y2=0.151
r8 26 25 16.6668 $w=2.1e-08 $l=4.9e-08 $layer=Gate_1 $thickness=5.6e-08
+ $X=0.567 $Y=0.2025 $X2=0.567 $Y2=0.1535
r9 23 24 16.6668 $w=2.1e-08 $l=4.9e-08 $layer=Gate_1 $thickness=5.6e-08
+ $X=0.567 $Y=0.054 $X2=0.567 $Y2=0.103
r10 3 14 6.74717 $w=2e-08 $layer=Gate_1 $thickness=5.2e-08 $X=0.567 $Y=0.135
+ $X2=0.567 $Y2=0.135
r11 3 24 11.0545 $w=2.06875e-08 $l=3.2e-08 $layer=Gate_1 $thickness=5.6e-08
+ $X=0.567 $Y=0.135 $X2=0.567 $Y2=0.103
r12 3 25 6.46262 $w=2.04595e-08 $l=1.85e-08 $layer=Gate_1 $thickness=5.6e-08
+ $X=0.567 $Y=0.135 $X2=0.567 $Y2=0.1535
r13 19 6 8.62802 $w=1.3e-08 $l=3.7e-08 $layer=M1 $thickness=3.6e-08 $X=0.621
+ $Y=0.138 $X2=0.621 $Y2=0.098
r14 16 17 20.114 $w=1.57815e-08 $l=2.7e-08 $layer=LIG $thickness=4.8e-08
+ $X=0.648 $Y=0.135 $X2=0.675 $Y2=0.135
r15 13 14 20.114 $w=1.57815e-08 $l=2.7e-08 $layer=LIG $thickness=4.8e-08
+ $X=0.594 $Y=0.135 $X2=0.567 $Y2=0.135
r16 1 9 6.74717 $w=2e-08 $layer=Gate_1 $thickness=5.2e-08 $X=0.621 $Y=0.135
+ $X2=0.621 $Y2=0.135
r17 1 13 20.114 $w=1.57815e-08 $l=2.7e-08 $layer=LIG $thickness=4.8e-08
+ $X=0.621 $Y=0.135 $X2=0.594 $Y2=0.135
r18 1 16 20.114 $w=1.57815e-08 $l=2.7e-08 $layer=LIG $thickness=4.8e-08
+ $X=0.621 $Y=0.135 $X2=0.648 $Y2=0.135
r19 19 1 19.3796 $a=3.24e-16 $layer=V0LIG $X=0.621 $Y=0.138 $X2=0.621 $Y2=0.135
r20 11 10 16.6668 $w=2.1e-08 $l=4.9e-08 $layer=Gate_1 $thickness=5.6e-08
+ $X=0.621 $Y=0.2025 $X2=0.621 $Y2=0.1535
r21 9 10 6.46262 $w=2.04595e-08 $l=1.85e-08 $layer=Gate_1 $thickness=5.6e-08
+ $X=0.621 $Y=0.135 $X2=0.621 $Y2=0.1535
r22 8 9 11.0545 $w=2.06875e-08 $l=3.2e-08 $layer=Gate_1 $thickness=5.6e-08
+ $X=0.621 $Y=0.103 $X2=0.621 $Y2=0.135
r23 7 8 16.6668 $w=2.1e-08 $l=4.9e-08 $layer=Gate_1 $thickness=5.6e-08 $X=0.621
+ $Y=0.054 $X2=0.621 $Y2=0.103
r24 7 4 10.0341 $w=2.1e-08 $l=2.95e-08 $layer=Gate_1 $thickness=5.6e-08
+ $X=0.621 $Y=0.054 $X2=0.621 $Y2=0.0245
.ends

.subckt PM_NOR4xp75_ASAP7_75t_R%9 vss 16 17 29 30 33 34 10 2 1 13 11 12 3
c1 1 vss 0.00397479f $X=0.432 $Y=0.2025
c2 2 vss 0.00364757f $X=0.54 $Y=0.2025
c3 3 vss 0.00383338f $X=0.648 $Y=0.2025
c4 10 vss 0.00186281f $X=0.4175 $Y=0.2025
c5 11 vss 0.00189726f $X=0.5255 $Y=0.2025
c6 12 vss 0.00188546f $X=0.6335 $Y=0.2025
c7 13 vss 0.0192506f $X=0.4175 $Y=0.234
r1 34 32 0.0308642 $w=8.1e-08 $l=2.5e-09 $layer=P_src_drn $thickness=1e-09
+ $X=0.6653 $Y=0.2025 $X2=0.6625 $Y2=0.2025
r2 3 32 0.179012 $w=8.1e-08 $l=1.45e-08 $layer=P_src_drn $thickness=1e-09
+ $X=0.648 $Y=0.2025 $X2=0.6625 $Y2=0.2025
r3 12 3 0.179012 $w=8.1e-08 $l=1.45e-08 $layer=P_src_drn $thickness=1e-09
+ $X=0.6335 $Y=0.2025 $X2=0.648 $Y2=0.2025
r4 33 12 0.0308642 $w=8.1e-08 $l=2.5e-09 $layer=P_src_drn $thickness=1e-09
+ $X=0.6306 $Y=0.2025 $X2=0.6335 $Y2=0.2025
r5 30 28 0.0308642 $w=8.1e-08 $l=2.5e-09 $layer=P_src_drn $thickness=1e-09
+ $X=0.5573 $Y=0.2025 $X2=0.5545 $Y2=0.2025
r6 2 28 0.179012 $w=8.1e-08 $l=1.45e-08 $layer=P_src_drn $thickness=1e-09
+ $X=0.54 $Y=0.2025 $X2=0.5545 $Y2=0.2025
r7 11 2 0.179012 $w=8.1e-08 $l=1.45e-08 $layer=P_src_drn $thickness=1e-09
+ $X=0.5255 $Y=0.2025 $X2=0.54 $Y2=0.2025
r8 29 11 0.0308642 $w=8.1e-08 $l=2.5e-09 $layer=P_src_drn $thickness=1e-09
+ $X=0.5226 $Y=0.2025 $X2=0.5255 $Y2=0.2025
r9 3 25 19.3796 $a=3.24e-16 $layer=V0LISD $X=0.648 $Y=0.2025 $X2=0.648 $Y2=0.234
r10 2 22 19.3796 $a=3.24e-16 $layer=V0LISD $X=0.54 $Y=0.2025 $X2=0.54 $Y2=0.234
r11 24 25 8.97781 $w=1.3e-08 $l=3.85e-08 $layer=M1 $thickness=3.6e-08 $X=0.6095
+ $Y=0.234 $X2=0.648 $Y2=0.234
r12 23 24 10.4935 $w=1.3e-08 $l=4.5e-08 $layer=M1 $thickness=3.6e-08 $X=0.5645
+ $Y=0.234 $X2=0.6095 $Y2=0.234
r13 22 23 5.71315 $w=1.3e-08 $l=2.45e-08 $layer=M1 $thickness=3.6e-08 $X=0.54
+ $Y=0.234 $X2=0.5645 $Y2=0.234
r14 21 22 5.24677 $w=1.3e-08 $l=2.25e-08 $layer=M1 $thickness=3.6e-08 $X=0.5175
+ $Y=0.234 $X2=0.54 $Y2=0.234
r15 20 21 3.73104 $w=1.3e-08 $l=1.6e-08 $layer=M1 $thickness=3.6e-08 $X=0.5015
+ $Y=0.234 $X2=0.5175 $Y2=0.234
r16 19 20 7.34548 $w=1.3e-08 $l=3.15e-08 $layer=M1 $thickness=3.6e-08 $X=0.47
+ $Y=0.234 $X2=0.5015 $Y2=0.234
r17 18 19 8.86121 $w=1.3e-08 $l=3.8e-08 $layer=M1 $thickness=3.6e-08 $X=0.432
+ $Y=0.234 $X2=0.47 $Y2=0.234
r18 13 18 3.38125 $w=1.3e-08 $l=1.45e-08 $layer=M1 $thickness=3.6e-08 $X=0.4175
+ $Y=0.234 $X2=0.432 $Y2=0.234
r19 1 18 19.3796 $a=3.24e-16 $layer=V0LISD $X=0.432 $Y=0.2025 $X2=0.432
+ $Y2=0.234
r20 17 15 0.0308642 $w=8.1e-08 $l=2.5e-09 $layer=P_src_drn $thickness=1e-09
+ $X=0.4493 $Y=0.2025 $X2=0.4465 $Y2=0.2025
r21 1 15 0.179012 $w=8.1e-08 $l=1.45e-08 $layer=P_src_drn $thickness=1e-09
+ $X=0.432 $Y=0.2025 $X2=0.4465 $Y2=0.2025
r22 10 1 0.179012 $w=8.1e-08 $l=1.45e-08 $layer=P_src_drn $thickness=1e-09
+ $X=0.4175 $Y=0.2025 $X2=0.432 $Y2=0.2025
r23 16 10 0.0308642 $w=8.1e-08 $l=2.5e-09 $layer=P_src_drn $thickness=1e-09
+ $X=0.4146 $Y=0.2025 $X2=0.4175 $Y2=0.2025
.ends

.subckt PM_NOR4xp75_ASAP7_75t_R%Y vss 80 40 41 65 66 69 70 73 74 77 78 85 86 95
+ 98 99 26 1 35 2 25 27 3 5 29 28 4 36 32 6 30 8 37 7 31
c1 1 vss 0.00743643f $X=0.108 $Y=0.054
c2 2 vss 0.00709659f $X=0.216 $Y=0.054
c3 3 vss 0.00761897f $X=0.324 $Y=0.054
c4 4 vss 0.0073148f $X=0.432 $Y=0.054
c5 5 vss 0.00708181f $X=0.54 $Y=0.054
c6 6 vss 0.00276048f $X=0.594 $Y=0.2025
c7 7 vss 0.00724618f $X=0.648 $Y=0.054
c8 8 vss 0.00496652f $X=0.702 $Y=0.2025
c9 25 vss 0.00374482f $X=0.0935 $Y=0.054
c10 26 vss 0.00356075f $X=0.2015 $Y=0.054
c11 27 vss 0.0036891f $X=0.3095 $Y=0.054
c12 28 vss 0.00367779f $X=0.4175 $Y=0.054
c13 29 vss 0.00355007f $X=0.5255 $Y=0.054
c14 30 vss 0.00372734f $X=0.6335 $Y=0.054
c15 31 vss 0.00211803f $X=0.5795 $Y=0.2025
c16 32 vss 0.035795f $X=0.6875 $Y=0.2025
c17 33 vss 0.00290568f $X=0.729 $Y=0.036
c18 34 vss 0.00134493f $X=0.729 $Y=0.198
c19 35 vss 0.0545307f $X=0.0945 $Y=0.036
c20 36 vss 0.00198107f $X=0.68 $Y=0.198
c21 37 vss 0.00495769f $X=0.729 $Y=0.0575
r1 99 97 0.0308642 $w=8.1e-08 $l=2.5e-09 $layer=P_src_drn $thickness=1e-09
+ $X=0.6113 $Y=0.2025 $X2=0.6085 $Y2=0.2025
r2 6 97 0.179012 $w=8.1e-08 $l=1.45e-08 $layer=P_src_drn $thickness=1e-09
+ $X=0.594 $Y=0.2025 $X2=0.6085 $Y2=0.2025
r3 31 6 0.179012 $w=8.1e-08 $l=1.45e-08 $layer=P_src_drn $thickness=1e-09
+ $X=0.5795 $Y=0.2025 $X2=0.594 $Y2=0.2025
r4 98 31 0.0308642 $w=8.1e-08 $l=2.5e-09 $layer=P_src_drn $thickness=1e-09
+ $X=0.5766 $Y=0.2025 $X2=0.5795 $Y2=0.2025
r5 32 8 0.154321 $w=8.1e-08 $l=1.25e-08 $layer=P_src_drn $thickness=1e-09
+ $X=0.6875 $Y=0.2025 $X2=0.702 $Y2=0.2025
r6 95 32 0.0308642 $w=8.1e-08 $l=2.5e-09 $layer=P_src_drn $thickness=1e-09
+ $X=0.6846 $Y=0.2025 $X2=0.6875 $Y2=0.2025
r7 6 92 19.3796 $a=3.24e-16 $layer=V0LISD $X=0.594 $Y=0.2025 $X2=0.594 $Y2=0.198
r8 8 87 19.3796 $a=3.24e-16 $layer=V0LISD $X=0.702 $Y=0.2025 $X2=0.703 $Y2=0.198
r9 92 93 3.14806 $w=1.3e-08 $l=1.35e-08 $layer=M1 $thickness=3.6e-08 $X=0.594
+ $Y=0.198 $X2=0.6075 $Y2=0.198
r10 90 93 3.14806 $w=1.3e-08 $l=1.35e-08 $layer=M1 $thickness=3.6e-08 $X=0.621
+ $Y=0.198 $X2=0.6075 $Y2=0.198
r11 89 90 6.29612 $w=1.3e-08 $l=2.7e-08 $layer=M1 $thickness=3.6e-08 $X=0.648
+ $Y=0.198 $X2=0.621 $Y2=0.198
r12 87 88 3.03147 $w=1.3e-08 $l=1.3e-08 $layer=M1 $thickness=3.6e-08 $X=0.703
+ $Y=0.198 $X2=0.716 $Y2=0.198
r13 36 87 5.36336 $w=1.3e-08 $l=2.3e-08 $layer=M1 $thickness=3.6e-08 $X=0.68
+ $Y=0.198 $X2=0.703 $Y2=0.198
r14 36 89 7.46207 $w=1.3e-08 $l=3.2e-08 $layer=M1 $thickness=3.6e-08 $X=0.68
+ $Y=0.198 $X2=0.648 $Y2=0.198
r15 34 82 3.36447 $w=1.71023e-08 $l=2.15e-08 $layer=M1 $thickness=3.6e-08
+ $X=0.729 $Y=0.198 $X2=0.729 $Y2=0.1765
r16 34 88 1.38235 $w=1.64615e-08 $l=1.3e-08 $layer=M1 $thickness=3.6e-08
+ $X=0.729 $Y=0.198 $X2=0.716 $Y2=0.198
r17 86 84 0.0462963 $w=5.4e-08 $l=2.5e-09 $layer=N_src_drn $thickness=1e-09
+ $X=0.6653 $Y=0.054 $X2=0.6625 $Y2=0.054
r18 7 84 0.268519 $w=5.4e-08 $l=1.45e-08 $layer=N_src_drn $thickness=1e-09
+ $X=0.648 $Y=0.054 $X2=0.6625 $Y2=0.054
r19 30 7 0.268519 $w=5.4e-08 $l=1.45e-08 $layer=N_src_drn $thickness=1e-09
+ $X=0.6335 $Y=0.054 $X2=0.648 $Y2=0.054
r20 85 30 0.0462963 $w=5.4e-08 $l=2.5e-09 $layer=N_src_drn $thickness=1e-09
+ $X=0.6306 $Y=0.054 $X2=0.6335 $Y2=0.054
r21 81 82 4.95528 $w=1.3e-08 $l=2.13e-08 $layer=M1 $thickness=3.6e-08 $X=0.729
+ $Y=0.1552 $X2=0.729 $Y2=0.1765
r22 80 81 2.15701 $w=1.3e-08 $l=9.2e-09 $layer=M1 $thickness=3.6e-08 $X=0.732
+ $Y=0.146 $X2=0.729 $Y2=0.1552
r23 80 79 8.91951 $w=1.3e-08 $l=3.83e-08 $layer=M1 $thickness=3.6e-08 $X=0.732
+ $Y=0.146 $X2=0.729 $Y2=0.1077
r24 37 79 11.7178 $w=1.3e-08 $l=5.02e-08 $layer=M1 $thickness=3.6e-08 $X=0.729
+ $Y=0.0575 $X2=0.729 $Y2=0.1077
r25 78 76 0.0462963 $w=5.4e-08 $l=2.5e-09 $layer=N_src_drn $thickness=1e-09
+ $X=0.5573 $Y=0.054 $X2=0.5545 $Y2=0.054
r26 5 76 0.268519 $w=5.4e-08 $l=1.45e-08 $layer=N_src_drn $thickness=1e-09
+ $X=0.54 $Y=0.054 $X2=0.5545 $Y2=0.054
r27 29 5 0.268519 $w=5.4e-08 $l=1.45e-08 $layer=N_src_drn $thickness=1e-09
+ $X=0.5255 $Y=0.054 $X2=0.54 $Y2=0.054
r28 77 29 0.0462963 $w=5.4e-08 $l=2.5e-09 $layer=N_src_drn $thickness=1e-09
+ $X=0.5226 $Y=0.054 $X2=0.5255 $Y2=0.054
r29 74 72 0.0462963 $w=5.4e-08 $l=2.5e-09 $layer=N_src_drn $thickness=1e-09
+ $X=0.4493 $Y=0.054 $X2=0.4465 $Y2=0.054
r30 4 72 0.268519 $w=5.4e-08 $l=1.45e-08 $layer=N_src_drn $thickness=1e-09
+ $X=0.432 $Y=0.054 $X2=0.4465 $Y2=0.054
r31 28 4 0.268519 $w=5.4e-08 $l=1.45e-08 $layer=N_src_drn $thickness=1e-09
+ $X=0.4175 $Y=0.054 $X2=0.432 $Y2=0.054
r32 73 28 0.0462963 $w=5.4e-08 $l=2.5e-09 $layer=N_src_drn $thickness=1e-09
+ $X=0.4146 $Y=0.054 $X2=0.4175 $Y2=0.054
r33 70 68 0.0462963 $w=5.4e-08 $l=2.5e-09 $layer=N_src_drn $thickness=1e-09
+ $X=0.3413 $Y=0.054 $X2=0.3385 $Y2=0.054
r34 3 68 0.268519 $w=5.4e-08 $l=1.45e-08 $layer=N_src_drn $thickness=1e-09
+ $X=0.324 $Y=0.054 $X2=0.3385 $Y2=0.054
r35 27 3 0.268519 $w=5.4e-08 $l=1.45e-08 $layer=N_src_drn $thickness=1e-09
+ $X=0.3095 $Y=0.054 $X2=0.324 $Y2=0.054
r36 69 27 0.0462963 $w=5.4e-08 $l=2.5e-09 $layer=N_src_drn $thickness=1e-09
+ $X=0.3066 $Y=0.054 $X2=0.3095 $Y2=0.054
r37 66 64 0.0462963 $w=5.4e-08 $l=2.5e-09 $layer=N_src_drn $thickness=1e-09
+ $X=0.2333 $Y=0.054 $X2=0.2305 $Y2=0.054
r38 2 64 0.268519 $w=5.4e-08 $l=1.45e-08 $layer=N_src_drn $thickness=1e-09
+ $X=0.216 $Y=0.054 $X2=0.2305 $Y2=0.054
r39 26 2 0.268519 $w=5.4e-08 $l=1.45e-08 $layer=N_src_drn $thickness=1e-09
+ $X=0.2015 $Y=0.054 $X2=0.216 $Y2=0.054
r40 65 26 0.0462963 $w=5.4e-08 $l=2.5e-09 $layer=N_src_drn $thickness=1e-09
+ $X=0.1986 $Y=0.054 $X2=0.2015 $Y2=0.054
r41 7 61 19.3796 $a=3.24e-16 $layer=V0LISD $X=0.648 $Y=0.054 $X2=0.648 $Y2=0.036
r42 33 62 7.79507 $w=1.41111e-08 $l=4.05e-08 $layer=M1 $thickness=3.6e-08
+ $X=0.729 $Y=0.036 $X2=0.6885 $Y2=0.036
r43 33 37 3.36447 $w=1.71023e-08 $l=2.15e-08 $layer=M1 $thickness=3.6e-08
+ $X=0.729 $Y=0.036 $X2=0.729 $Y2=0.0575
r44 5 56 19.3796 $a=3.24e-16 $layer=V0LISD $X=0.54 $Y=0.054 $X2=0.54 $Y2=0.036
r45 4 51 19.3796 $a=3.24e-16 $layer=V0LISD $X=0.432 $Y=0.054 $X2=0.432 $Y2=0.036
r46 3 49 19.3796 $a=3.24e-16 $layer=V0LISD $X=0.324 $Y=0.054 $X2=0.324 $Y2=0.036
r47 2 45 19.3796 $a=3.24e-16 $layer=V0LISD $X=0.216 $Y=0.054 $X2=0.216 $Y2=0.036
r48 61 62 9.44419 $w=1.3e-08 $l=4.05e-08 $layer=M1 $thickness=3.6e-08 $X=0.648
+ $Y=0.036 $X2=0.6885 $Y2=0.036
r49 60 61 3.14806 $w=1.3e-08 $l=1.35e-08 $layer=M1 $thickness=3.6e-08 $X=0.6345
+ $Y=0.036 $X2=0.648 $Y2=0.036
r50 59 60 3.14806 $w=1.3e-08 $l=1.35e-08 $layer=M1 $thickness=3.6e-08 $X=0.621
+ $Y=0.036 $X2=0.6345 $Y2=0.036
r51 58 59 5.82974 $w=1.3e-08 $l=2.5e-08 $layer=M1 $thickness=3.6e-08 $X=0.596
+ $Y=0.036 $X2=0.621 $Y2=0.036
r52 57 58 7.34548 $w=1.3e-08 $l=3.15e-08 $layer=M1 $thickness=3.6e-08 $X=0.5645
+ $Y=0.036 $X2=0.596 $Y2=0.036
r53 56 57 5.71315 $w=1.3e-08 $l=2.45e-08 $layer=M1 $thickness=3.6e-08 $X=0.54
+ $Y=0.036 $X2=0.5645 $Y2=0.036
r54 55 56 3.14806 $w=1.3e-08 $l=1.35e-08 $layer=M1 $thickness=3.6e-08 $X=0.5265
+ $Y=0.036 $X2=0.54 $Y2=0.036
r55 54 55 3.14806 $w=1.3e-08 $l=1.35e-08 $layer=M1 $thickness=3.6e-08 $X=0.513
+ $Y=0.036 $X2=0.5265 $Y2=0.036
r56 53 54 2.68168 $w=1.3e-08 $l=1.15e-08 $layer=M1 $thickness=3.6e-08 $X=0.5015
+ $Y=0.036 $X2=0.513 $Y2=0.036
r57 52 53 7.34548 $w=1.3e-08 $l=3.15e-08 $layer=M1 $thickness=3.6e-08 $X=0.47
+ $Y=0.036 $X2=0.5015 $Y2=0.036
r58 51 52 8.86121 $w=1.3e-08 $l=3.8e-08 $layer=M1 $thickness=3.6e-08 $X=0.432
+ $Y=0.036 $X2=0.47 $Y2=0.036
r59 50 51 12.5922 $w=1.3e-08 $l=5.4e-08 $layer=M1 $thickness=3.6e-08 $X=0.378
+ $Y=0.036 $X2=0.432 $Y2=0.036
r60 49 50 12.5922 $w=1.3e-08 $l=5.4e-08 $layer=M1 $thickness=3.6e-08 $X=0.324
+ $Y=0.036 $X2=0.378 $Y2=0.036
r61 48 49 3.14806 $w=1.3e-08 $l=1.35e-08 $layer=M1 $thickness=3.6e-08 $X=0.3105
+ $Y=0.036 $X2=0.324 $Y2=0.036
r62 47 48 3.14806 $w=1.3e-08 $l=1.35e-08 $layer=M1 $thickness=3.6e-08 $X=0.297
+ $Y=0.036 $X2=0.3105 $Y2=0.036
r63 46 47 9.44419 $w=1.3e-08 $l=4.05e-08 $layer=M1 $thickness=3.6e-08 $X=0.2565
+ $Y=0.036 $X2=0.297 $Y2=0.036
r64 45 46 9.44419 $w=1.3e-08 $l=4.05e-08 $layer=M1 $thickness=3.6e-08 $X=0.216
+ $Y=0.036 $X2=0.2565 $Y2=0.036
r65 44 45 12.5922 $w=1.3e-08 $l=5.4e-08 $layer=M1 $thickness=3.6e-08 $X=0.162
+ $Y=0.036 $X2=0.216 $Y2=0.036
r66 43 44 12.5922 $w=1.3e-08 $l=5.4e-08 $layer=M1 $thickness=3.6e-08 $X=0.108
+ $Y=0.036 $X2=0.162 $Y2=0.036
r67 42 43 2.56509 $w=1.3e-08 $l=1.1e-08 $layer=M1 $thickness=3.6e-08 $X=0.097
+ $Y=0.036 $X2=0.108 $Y2=0.036
r68 35 42 0.582974 $w=1.3e-08 $l=2.5e-09 $layer=M1 $thickness=3.6e-08 $X=0.0945
+ $Y=0.036 $X2=0.097 $Y2=0.036
r69 1 43 19.3796 $a=3.24e-16 $layer=V0LISD $X=0.108 $Y=0.054 $X2=0.108 $Y2=0.036
r70 41 39 0.0462963 $w=5.4e-08 $l=2.5e-09 $layer=N_src_drn $thickness=1e-09
+ $X=0.1253 $Y=0.054 $X2=0.1225 $Y2=0.054
r71 1 39 0.268519 $w=5.4e-08 $l=1.45e-08 $layer=N_src_drn $thickness=1e-09
+ $X=0.108 $Y=0.054 $X2=0.1225 $Y2=0.054
r72 25 1 0.268519 $w=5.4e-08 $l=1.45e-08 $layer=N_src_drn $thickness=1e-09
+ $X=0.0935 $Y=0.054 $X2=0.108 $Y2=0.054
r73 40 25 0.0462963 $w=5.4e-08 $l=2.5e-09 $layer=N_src_drn $thickness=1e-09
+ $X=0.0906 $Y=0.054 $X2=0.0935 $Y2=0.054
.ends

.subckt PM_NOR4xp75_ASAP7_75t_R%8 vss 16 17 29 30 33 34 10 13 1 11 12 3 2
c1 1 vss 0.0028861f $X=0.27 $Y=0.2025
c2 2 vss 0.00264816f $X=0.378 $Y=0.2025
c3 3 vss 0.0028043f $X=0.486 $Y=0.2025
c4 10 vss 0.00192719f $X=0.2555 $Y=0.2025
c5 11 vss 0.00198909f $X=0.3635 $Y=0.2025
c6 12 vss 0.00180947f $X=0.4715 $Y=0.2025
c7 13 vss 0.00352292f $X=0.2585 $Y=0.198
r1 34 32 0.0308642 $w=8.1e-08 $l=2.5e-09 $layer=P_src_drn $thickness=1e-09
+ $X=0.5033 $Y=0.2025 $X2=0.5005 $Y2=0.2025
r2 3 32 0.179012 $w=8.1e-08 $l=1.45e-08 $layer=P_src_drn $thickness=1e-09
+ $X=0.486 $Y=0.2025 $X2=0.5005 $Y2=0.2025
r3 12 3 0.179012 $w=8.1e-08 $l=1.45e-08 $layer=P_src_drn $thickness=1e-09
+ $X=0.4715 $Y=0.2025 $X2=0.486 $Y2=0.2025
r4 33 12 0.0308642 $w=8.1e-08 $l=2.5e-09 $layer=P_src_drn $thickness=1e-09
+ $X=0.4686 $Y=0.2025 $X2=0.4715 $Y2=0.2025
r5 30 28 0.0308642 $w=8.1e-08 $l=2.5e-09 $layer=P_src_drn $thickness=1e-09
+ $X=0.3953 $Y=0.2025 $X2=0.3925 $Y2=0.2025
r6 2 28 0.179012 $w=8.1e-08 $l=1.45e-08 $layer=P_src_drn $thickness=1e-09
+ $X=0.378 $Y=0.2025 $X2=0.3925 $Y2=0.2025
r7 11 2 0.179012 $w=8.1e-08 $l=1.45e-08 $layer=P_src_drn $thickness=1e-09
+ $X=0.3635 $Y=0.2025 $X2=0.378 $Y2=0.2025
r8 29 11 0.0308642 $w=8.1e-08 $l=2.5e-09 $layer=P_src_drn $thickness=1e-09
+ $X=0.3606 $Y=0.2025 $X2=0.3635 $Y2=0.2025
r9 3 25 19.3796 $a=3.24e-16 $layer=V0LISD $X=0.486 $Y=0.2025 $X2=0.485 $Y2=0.198
r10 2 22 19.3796 $a=3.24e-16 $layer=V0LISD $X=0.378 $Y=0.2025 $X2=0.378
+ $Y2=0.198
r11 24 25 9.56078 $w=1.3e-08 $l=4.1e-08 $layer=M1 $thickness=3.6e-08 $X=0.444
+ $Y=0.198 $X2=0.485 $Y2=0.198
r12 23 24 10.3769 $w=1.3e-08 $l=4.45e-08 $layer=M1 $thickness=3.6e-08 $X=0.3995
+ $Y=0.198 $X2=0.444 $Y2=0.198
r13 22 23 5.01358 $w=1.3e-08 $l=2.15e-08 $layer=M1 $thickness=3.6e-08 $X=0.378
+ $Y=0.198 $X2=0.3995 $Y2=0.198
r14 21 22 5.47996 $w=1.3e-08 $l=2.35e-08 $layer=M1 $thickness=3.6e-08 $X=0.3545
+ $Y=0.198 $X2=0.378 $Y2=0.198
r15 20 21 7.34548 $w=1.3e-08 $l=3.15e-08 $layer=M1 $thickness=3.6e-08 $X=0.323
+ $Y=0.198 $X2=0.3545 $Y2=0.198
r16 19 20 7.11229 $w=1.3e-08 $l=3.05e-08 $layer=M1 $thickness=3.6e-08 $X=0.2925
+ $Y=0.198 $X2=0.323 $Y2=0.198
r17 18 19 5.24677 $w=1.3e-08 $l=2.25e-08 $layer=M1 $thickness=3.6e-08 $X=0.27
+ $Y=0.198 $X2=0.2925 $Y2=0.198
r18 13 18 2.68168 $w=1.3e-08 $l=1.15e-08 $layer=M1 $thickness=3.6e-08 $X=0.2585
+ $Y=0.198 $X2=0.27 $Y2=0.198
r19 1 18 19.3796 $a=3.24e-16 $layer=V0LISD $X=0.27 $Y=0.2025 $X2=0.27 $Y2=0.198
r20 17 15 0.0308642 $w=8.1e-08 $l=2.5e-09 $layer=P_src_drn $thickness=1e-09
+ $X=0.2873 $Y=0.2025 $X2=0.2845 $Y2=0.2025
r21 1 15 0.179012 $w=8.1e-08 $l=1.45e-08 $layer=P_src_drn $thickness=1e-09
+ $X=0.27 $Y=0.2025 $X2=0.2845 $Y2=0.2025
r22 10 1 0.179012 $w=8.1e-08 $l=1.45e-08 $layer=P_src_drn $thickness=1e-09
+ $X=0.2555 $Y=0.2025 $X2=0.27 $Y2=0.2025
r23 16 10 0.0308642 $w=8.1e-08 $l=2.5e-09 $layer=P_src_drn $thickness=1e-09
+ $X=0.2526 $Y=0.2025 $X2=0.2555 $Y2=0.2025
.ends

.subckt PM_NOR4xp75_ASAP7_75t_R%C vss 9 10 14 23 26 31 34 1 6 3 5 8 4 7
c1 1 vss 0.0141615f $X=0.243 $Y=0.135
c2 3 vss 0.0385643f $X=0.243 $Y=0.0245
c3 4 vss 0.0382645f $X=0.297 $Y=0.135
c4 5 vss 0.0387405f $X=0.351 $Y=0.135
c5 6 vss 0.0073104f $X=0.216 $Y=0.16
c6 7 vss 0.00613079f $X=0.297 $Y=0.16
c7 8 vss 0.00648025f $X=0.272 $Y=0.16
c8 9 vss 0.00764877f $X=0.3 $Y=0.138
r1 6 36 4.53284 $w=1.48367e-08 $l=2.45e-08 $layer=M1 $thickness=3.6e-08
+ $X=0.216 $Y=0.16 $X2=0.2405 $Y2=0.16
r2 8 36 7.34548 $w=1.3e-08 $l=3.15e-08 $layer=M1 $thickness=3.6e-08 $X=0.272
+ $Y=0.16 $X2=0.2405 $Y2=0.16
r3 7 29 1.26576 $w=2.0056e-08 $l=1.25e-08 $layer=M1 $thickness=3.6e-08 $X=0.297
+ $Y=0.16 $X2=0.297 $Y2=0.1475
r4 7 8 4.18063 $w=1.48e-08 $l=2.5e-08 $layer=M1 $thickness=3.6e-08 $X=0.297
+ $Y=0.16 $X2=0.272 $Y2=0.16
r5 34 33 16.8368 $w=2.1e-08 $l=4.95e-08 $layer=Gate_1 $thickness=5.6e-08
+ $X=0.351 $Y=0.2025 $X2=0.351 $Y2=0.153
r6 31 32 16.8368 $w=2.1e-08 $l=4.95e-08 $layer=Gate_1 $thickness=5.6e-08
+ $X=0.351 $Y=0.054 $X2=0.351 $Y2=0.1035
r7 5 20 7.07951 $w=1.89474e-08 $layer=LIG $thickness=5.17895e-08 $X=0.351
+ $Y=0.135 $X2=0.351 $Y2=0.135
r8 5 32 10.8674 $w=2.07143e-08 $l=3.15e-08 $layer=Gate_1 $thickness=5.6e-08
+ $X=0.351 $Y=0.135 $X2=0.351 $Y2=0.1035
r9 5 33 6.27555 $w=2.05e-08 $l=1.8e-08 $layer=Gate_1 $thickness=5.6e-08
+ $X=0.351 $Y=0.135 $X2=0.351 $Y2=0.153
r10 9 18 19.3796 $a=3.24e-16 $layer=V0LIG $X=0.3 $Y=0.138 $X2=0.297 $Y2=0.135
r11 9 29 2.91487 $w=1.3e-08 $l=1.25e-08 $layer=M1 $thickness=3.6e-08 $X=0.3
+ $Y=0.138 $X2=0.297 $Y2=0.1475
r12 26 25 16.8368 $w=2.1e-08 $l=4.95e-08 $layer=Gate_1 $thickness=5.6e-08
+ $X=0.297 $Y=0.2025 $X2=0.297 $Y2=0.153
r13 23 24 16.8368 $w=2.1e-08 $l=4.95e-08 $layer=Gate_1 $thickness=5.6e-08
+ $X=0.297 $Y=0.054 $X2=0.297 $Y2=0.1035
r14 4 18 7.07951 $w=1.89474e-08 $layer=LIG $thickness=5.17895e-08 $X=0.297
+ $Y=0.135 $X2=0.297 $Y2=0.135
r15 4 24 10.8674 $w=2.07143e-08 $l=3.15e-08 $layer=Gate_1 $thickness=5.6e-08
+ $X=0.297 $Y=0.135 $X2=0.297 $Y2=0.1035
r16 4 25 6.27555 $w=2.05e-08 $l=1.8e-08 $layer=Gate_1 $thickness=5.6e-08
+ $X=0.297 $Y=0.135 $X2=0.297 $Y2=0.153
r17 19 20 30.1405 $w=1.37815e-08 $l=2.7e-08 $layer=LIG $thickness=4.8e-08
+ $X=0.324 $Y=0.135 $X2=0.351 $Y2=0.135
r18 18 19 30.1405 $w=1.37815e-08 $l=2.7e-08 $layer=LIG $thickness=4.8e-08
+ $X=0.297 $Y=0.135 $X2=0.324 $Y2=0.135
r19 17 18 30.1405 $w=1.37815e-08 $l=2.7e-08 $layer=LIG $thickness=4.8e-08
+ $X=0.27 $Y=0.135 $X2=0.297 $Y2=0.135
r20 1 12 7.07951 $w=1.89474e-08 $layer=LIG $thickness=5.17895e-08 $X=0.243
+ $Y=0.135 $X2=0.243 $Y2=0.135
r21 1 17 30.1405 $w=1.37815e-08 $l=2.7e-08 $layer=LIG $thickness=4.8e-08
+ $X=0.243 $Y=0.135 $X2=0.27 $Y2=0.135
r22 14 13 16.8368 $w=2.1e-08 $l=4.95e-08 $layer=Gate_1 $thickness=5.6e-08
+ $X=0.243 $Y=0.2025 $X2=0.243 $Y2=0.153
r23 12 13 6.27555 $w=2.05e-08 $l=1.8e-08 $layer=Gate_1 $thickness=5.6e-08
+ $X=0.243 $Y=0.135 $X2=0.243 $Y2=0.153
r24 11 12 10.8674 $w=2.07143e-08 $l=3.15e-08 $layer=Gate_1 $thickness=5.6e-08
+ $X=0.243 $Y=0.1035 $X2=0.243 $Y2=0.135
r25 10 11 16.8368 $w=2.1e-08 $l=4.95e-08 $layer=Gate_1 $thickness=5.6e-08
+ $X=0.243 $Y=0.054 $X2=0.243 $Y2=0.1035
r26 10 3 10.0341 $w=2.1e-08 $l=2.95e-08 $layer=Gate_1 $thickness=5.6e-08
+ $X=0.243 $Y=0.054 $X2=0.243 $Y2=0.0245
.ends

* End of included file NOR4xp75_ASAP7_75t_R.pex.sp.pex

*
.subckt NOR4xp75_ASAP7_75t_CUSTOM_4_25_0_7 VSS VDD D C B A Y
*
* VSS VSS
* VDD VDD
* D D
* C C
* B B
* A A
* Y Y
*
*

M0 N_M0_d N_M0_g VSS VSS nmos_rvt L=2e-08 W=5.4e-08 nfin=2 $X=0.071 $Y=0.027
M1 N_M1_d N_M1_g VSS VSS nmos_rvt L=2e-08 W=5.4e-08 nfin=2 $X=0.125 $Y=0.027
M2 N_M2_d N_M2_g VSS VSS nmos_rvt L=2e-08 W=5.4e-08 nfin=2 $X=0.179 $Y=0.027
M3 VSS N_M3_g N_M3_s VSS nmos_rvt L=2e-08 W=5.4e-08 nfin=2 $X=0.233 $Y=0.027
M4 VSS N_M4_g N_M4_s VSS nmos_rvt L=2e-08 W=5.4e-08 nfin=2 $X=0.287 $Y=0.027
M5 VSS N_M5_g N_M5_s VSS nmos_rvt L=2e-08 W=5.4e-08 nfin=2 $X=0.341 $Y=0.027
M6 N_M6_d N_M6_g VSS VSS nmos_rvt L=2e-08 W=5.4e-08 nfin=2 $X=0.395 $Y=0.027
M7 N_M7_d N_M7_g VSS VSS nmos_rvt L=2e-08 W=5.4e-08 nfin=2 $X=0.449 $Y=0.027
M8 N_M8_d N_M8_g VSS VSS nmos_rvt L=2e-08 W=5.4e-08 nfin=2 $X=0.503 $Y=0.027
M9 VSS N_M9_g N_M9_s VSS nmos_rvt L=2e-08 W=5.4e-08 nfin=2 $X=0.557 $Y=0.027
M10 VSS N_M10_g N_M10_s VSS nmos_rvt L=2e-08 W=5.4e-08 nfin=2 $X=0.611 $Y=0.027
M11 VSS N_M11_g N_M11_s VSS nmos_rvt L=2e-08 W=5.4e-08 nfin=2 $X=0.665 $Y=0.027
M12 N_M12_d N_M12_g VDD VDD pmos_rvt L=2e-08 W=8.1e-08 nfin=3 $X=0.071 $Y=0.162
M13 N_M13_d N_M13_g VDD VDD pmos_rvt L=2e-08 W=8.1e-08 nfin=3 $X=0.125 $Y=0.162
M14 N_M14_d N_M14_g VDD VDD pmos_rvt L=2e-08 W=8.1e-08 nfin=3 $X=0.179 $Y=0.162
M15 N_M15_d N_M15_g N_M15_s VDD pmos_rvt L=2e-08 W=8.1e-08 nfin=3 $X=0.233
+ $Y=0.162
M16 N_M16_d N_M16_g N_M16_s VDD pmos_rvt L=2e-08 W=8.1e-08 nfin=3 $X=0.287
+ $Y=0.162
M17 N_M17_d N_M17_g N_M17_s VDD pmos_rvt L=2e-08 W=8.1e-08 nfin=3 $X=0.341
+ $Y=0.162
M18 N_M18_d N_M18_g N_M18_s VDD pmos_rvt L=2e-08 W=8.1e-08 nfin=3 $X=0.395
+ $Y=0.162
M19 N_M19_d N_M19_g N_M19_s VDD pmos_rvt L=2e-08 W=8.1e-08 nfin=3 $X=0.449
+ $Y=0.162
M20 N_M20_d N_M20_g N_M20_s VDD pmos_rvt L=2e-08 W=8.1e-08 nfin=3 $X=0.503
+ $Y=0.162
M21 N_M21_d N_M21_g N_M21_s VDD pmos_rvt L=2e-08 W=8.1e-08 nfin=3 $X=0.557
+ $Y=0.162
M22 N_M22_d N_M22_g N_M22_s VDD pmos_rvt L=2e-08 W=8.1e-08 nfin=3 $X=0.611
+ $Y=0.162
M23 N_M23_d N_M23_g N_M23_s VDD pmos_rvt L=2e-08 W=8.1e-08 nfin=3 $X=0.665
+ $Y=0.162

* .include "NOR4xp75_ASAP7_75t_R.pex.sp.pxi"

* Start of included file NOR4xp75_ASAP7_75t_R.pex.sp.pxi
x_PM_NOR4xp75_ASAP7_75t_R%7 vss N_M12_d N_M13_d N_M14_d N_M15_s N_M16_s N_M17_s
+ N_7_10 N_7_1 N_7_11 N_7_12 N_7_3 N_7_13 N_7_2 PM_NOR4xp75_ASAP7_75t_R%7
cc_1 N_7_10 N_D_8 0.000393209f $X=0.0935 $Y=0.2025
cc_2 N_7_10 N_D_5 0.00197578f $X=0.0935 $Y=0.2025
cc_3 N_7_1 N_D_3 0.00181535f $X=0.108 $Y=0.2025
cc_4 N_7_10 N_D_1 0.00277538f $X=0.0935 $Y=0.2025
cc_5 N_7_11 N_D_5 0.0326216f $X=0.2015 $Y=0.2025
cc_6 N_7_10 N_D_3 0.0354938f $X=0.0935 $Y=0.2025
cc_7 N_7_10 N_D_4 0.0301853f $X=0.0935 $Y=0.2025
cc_8 N_7_12 N_C_6 0.000264823f $X=0.3095 $Y=0.2025
cc_9 N_7_12 N_C_8 0.00039749f $X=0.3095 $Y=0.2025
cc_10 N_7_12 N_C_3 0.00177279f $X=0.3095 $Y=0.2025
cc_11 N_7_12 N_C_5 0.0370019f $X=0.3095 $Y=0.2025
cc_12 N_7_3 N_C_4 0.00156498f $X=0.324 $Y=0.2025
cc_13 N_7_12 N_C_1 0.0024961f $X=0.3095 $Y=0.2025
cc_14 N_7_13 N_C_6 0.00285072f $X=0.0935 $Y=0.234
cc_15 N_7_11 N_C_3 0.0323333f $X=0.2015 $Y=0.2025
cc_16 N_7_12 N_C_4 0.0287743f $X=0.3095 $Y=0.2025
x_PM_NOR4xp75_ASAP7_75t_R%D vss D N_M0_g N_M12_g N_M1_g N_M13_g N_M2_g N_M14_g
+ N_D_5 N_D_1 N_D_8 N_D_3 N_D_4 N_D_11 N_D_6 PM_NOR4xp75_ASAP7_75t_R%D
x_PM_NOR4xp75_ASAP7_75t_R%B vss B N_M6_g N_M18_g N_M7_g N_M19_g N_M8_g N_M20_g
+ N_B_1 N_B_3 N_B_7 N_B_5 N_B_6 N_B_4 N_B_8 PM_NOR4xp75_ASAP7_75t_R%B
cc_17 N_B_1 N_C_1 0.00119628f $X=0.405 $Y=0.135
cc_18 N_B_3 N_C_5 0.00584388f $X=0.405 $Y=0.0245
x_PM_NOR4xp75_ASAP7_75t_R%A vss A N_M10_g N_M22_g N_M9_g N_M21_g N_M11_g
+ N_M23_g N_A_3 N_A_6 N_A_1 N_A_5 N_A_4 PM_NOR4xp75_ASAP7_75t_R%A
cc_19 N_A_3 N_B_1 0.000450442f $X=0.567 $Y=0.135
cc_20 N_A_6 N_B_7 0.000580905f $X=0.621 $Y=0.098
cc_21 N_A_1 N_B_7 0.0014248f $X=0.621 $Y=0.135
cc_22 N_A_3 N_B_5 0.00635734f $X=0.567 $Y=0.135
x_PM_NOR4xp75_ASAP7_75t_R%9 vss N_M18_d N_M19_d N_M20_d N_M21_s N_M22_s N_M23_s
+ N_9_10 N_9_2 N_9_1 N_9_13 N_9_11 N_9_12 N_9_3 PM_NOR4xp75_ASAP7_75t_R%9
cc_23 N_9_10 N_B_5 0.00041963f $X=0.4175 $Y=0.2025
cc_24 N_9_2 N_B_5 0.00134029f $X=0.54 $Y=0.2025
cc_25 N_9_1 N_B_3 0.0014667f $X=0.432 $Y=0.2025
cc_26 N_9_13 N_B_7 0.002279f $X=0.4175 $Y=0.234
cc_27 N_9_10 N_B_1 0.00266986f $X=0.4175 $Y=0.2025
cc_28 N_9_11 N_B_5 0.0324068f $X=0.5255 $Y=0.2025
cc_29 N_9_10 N_B_4 0.0179097f $X=0.4175 $Y=0.2025
cc_30 N_9_10 N_B_3 0.0478006f $X=0.4175 $Y=0.2025
cc_31 N_9_12 N_A_5 0.0186759f $X=0.6335 $Y=0.2025
cc_32 N_9_3 N_A_4 0.00157385f $X=0.648 $Y=0.2025
cc_33 N_9_12 N_A_1 0.00265556f $X=0.6335 $Y=0.2025
cc_34 N_9_11 N_A_3 0.0321975f $X=0.5255 $Y=0.2025
cc_35 N_9_12 N_A_4 0.047248f $X=0.6335 $Y=0.2025
cc_36 N_9_11 N_8_12 0.00105216f $X=0.5255 $Y=0.2025
cc_37 N_9_10 N_8_11 0.00106827f $X=0.4175 $Y=0.2025
cc_38 N_9_2 N_8_3 0.00107349f $X=0.54 $Y=0.2025
cc_39 N_9_1 N_8_2 0.00114839f $X=0.432 $Y=0.2025
cc_40 N_9_1 N_8_3 0.00530713f $X=0.432 $Y=0.2025
cc_41 N_9_13 N_8_13 0.011224f $X=0.4175 $Y=0.234
x_PM_NOR4xp75_ASAP7_75t_R%Y vss Y N_M0_d N_M1_d N_M2_d N_M3_s N_M4_s N_M5_s
+ N_M6_d N_M7_d N_M8_d N_M9_s N_M10_s N_M11_s N_M23_d N_M21_d N_M22_d N_Y_26
+ N_Y_1 N_Y_35 N_Y_2 N_Y_25 N_Y_27 N_Y_3 N_Y_5 N_Y_29 N_Y_28 N_Y_4 N_Y_36
+ N_Y_32 N_Y_6 N_Y_30 N_Y_8 N_Y_37 N_Y_7 N_Y_31 PM_NOR4xp75_ASAP7_75t_R%Y
cc_42 N_Y_26 N_D_3 0.000330147f $X=0.2015 $Y=0.054
cc_43 N_Y_1 N_D_11 0.000352837f $X=0.108 $Y=0.054
cc_44 N_Y_35 N_D_6 0.000424208f $X=0.0945 $Y=0.036
cc_45 N_Y_2 N_D_5 0.000563566f $X=0.216 $Y=0.054
cc_46 N_Y_25 N_D_1 0.000942045f $X=0.0935 $Y=0.054
cc_47 N_Y_35 N_D_5 0.001045f $X=0.0945 $Y=0.036
cc_48 N_Y_1 N_D_3 0.00116337f $X=0.108 $Y=0.054
cc_49 N_Y_26 N_D_5 0.024218f $X=0.2015 $Y=0.054
cc_50 N_Y_25 N_D_4 0.0263993f $X=0.0935 $Y=0.054
cc_51 N_Y_25 N_D_3 0.0226953f $X=0.0935 $Y=0.054
cc_52 N_Y_2 N_C_6 0.000245442f $X=0.216 $Y=0.054
cc_53 N_Y_26 N_C_3 0.0244202f $X=0.2015 $Y=0.054
cc_54 N_Y_2 N_C_3 0.00062932f $X=0.216 $Y=0.054
cc_55 N_Y_27 N_C_1 0.000994509f $X=0.3095 $Y=0.054
cc_56 N_Y_3 N_C_4 0.00103278f $X=0.324 $Y=0.054
cc_57 N_Y_35 C 0.00202782f $X=0.0945 $Y=0.036
cc_58 N_Y_3 C 0.00211523f $X=0.324 $Y=0.054
cc_59 N_Y_27 N_C_5 0.0267293f $X=0.3095 $Y=0.054
cc_60 N_Y_27 N_C_4 0.0223833f $X=0.3095 $Y=0.054
cc_61 N_Y_35 N_B_3 0.000217984f $X=0.0945 $Y=0.036
cc_62 N_Y_5 N_B_1 0.000227072f $X=0.54 $Y=0.054
cc_63 N_Y_29 N_B_5 0.0246454f $X=0.5255 $Y=0.054
cc_64 N_Y_28 N_B_4 0.0271248f $X=0.4175 $Y=0.054
cc_65 N_Y_5 N_B_5 0.000755597f $X=0.54 $Y=0.054
cc_66 N_Y_4 N_B_4 0.00083212f $X=0.432 $Y=0.054
cc_67 N_Y_28 N_B_1 0.00146454f $X=0.4175 $Y=0.054
cc_68 N_Y_36 N_B_7 0.00160552f $X=0.68 $Y=0.198
cc_69 N_Y_35 N_B_8 0.00169977f $X=0.0945 $Y=0.036
cc_70 N_Y_5 N_B_8 0.00216869f $X=0.54 $Y=0.054
cc_71 N_Y_28 N_B_3 0.0225097f $X=0.4175 $Y=0.054
cc_72 N_Y_32 N_A_4 0.000423638f $X=0.6875 $Y=0.2025
cc_73 N_Y_6 N_A_4 0.00207332f $X=0.594 $Y=0.2025
cc_74 N_Y_5 N_A_3 0.00049142f $X=0.54 $Y=0.054
cc_75 N_Y_30 N_A_5 0.00839536f $X=0.6335 $Y=0.054
cc_76 N_Y_6 N_A_1 0.000697957f $X=0.594 $Y=0.2025
cc_77 N_Y_8 N_A_5 0.000766853f $X=0.702 $Y=0.2025
cc_78 N_Y_37 N_A_1 0.000793149f $X=0.729 $Y=0.0575
cc_79 N_Y_7 N_A_5 0.00106633f $X=0.648 $Y=0.054
cc_80 N_Y_36 N_A_6 0.00143006f $X=0.68 $Y=0.198
cc_81 N_Y_35 N_A_6 0.00157949f $X=0.0945 $Y=0.036
cc_82 N_Y_29 N_A_3 0.0104594f $X=0.5255 $Y=0.054
cc_83 N_Y_7 N_A_6 0.00388655f $X=0.648 $Y=0.054
cc_84 N_Y_31 N_A_1 0.00466512f $X=0.5795 $Y=0.2025
cc_85 N_Y_32 N_A_5 0.0467903f $X=0.6875 $Y=0.2025
cc_86 N_Y_30 N_A_4 0.01314f $X=0.6335 $Y=0.054
cc_87 N_Y_31 N_A_3 0.0508199f $X=0.5795 $Y=0.2025
cc_88 N_Y_31 N_A_4 0.043548f $X=0.5795 $Y=0.2025
cc_89 N_Y_32 N_9_13 0.000535143f $X=0.6875 $Y=0.2025
cc_90 N_Y_31 N_9_13 0.000557912f $X=0.5795 $Y=0.2025
cc_91 N_Y_6 N_9_13 0.000670584f $X=0.594 $Y=0.2025
cc_92 N_Y_31 N_9_11 0.00105929f $X=0.5795 $Y=0.2025
cc_93 N_Y_31 N_9_12 0.00108621f $X=0.5795 $Y=0.2025
cc_94 N_Y_8 N_9_3 0.00120619f $X=0.702 $Y=0.2025
cc_95 N_Y_6 N_9_3 0.00291377f $X=0.594 $Y=0.2025
cc_96 N_Y_6 N_9_2 0.00360062f $X=0.594 $Y=0.2025
cc_97 N_Y_36 N_9_13 0.00961246f $X=0.68 $Y=0.198
x_PM_NOR4xp75_ASAP7_75t_R%8 vss N_M15_d N_M16_d N_M17_d N_M18_s N_M19_s N_M20_s
+ N_8_10 N_8_13 N_8_1 N_8_11 N_8_12 N_8_3 N_8_2 PM_NOR4xp75_ASAP7_75t_R%8
cc_98 N_8_10 N_C_5 0.0011316f $X=0.2555 $Y=0.2025
cc_99 N_8_10 N_C_6 0.000451518f $X=0.2555 $Y=0.2025
cc_100 N_8_10 N_C_8 0.000629179f $X=0.2555 $Y=0.2025
cc_101 N_8_13 N_C_8 0.00152032f $X=0.2585 $Y=0.198
cc_102 N_8_1 N_C_4 0.00173397f $X=0.27 $Y=0.2025
cc_103 N_8_10 N_C_1 0.00274787f $X=0.2555 $Y=0.2025
cc_104 N_8_13 N_C_7 0.00387282f $X=0.2585 $Y=0.198
cc_105 N_8_11 N_C_5 0.0318632f $X=0.3635 $Y=0.2025
cc_106 N_8_10 N_C_4 0.035339f $X=0.2555 $Y=0.2025
cc_107 N_8_10 N_C_3 0.0296836f $X=0.2555 $Y=0.2025
cc_108 N_8_12 N_B_3 0.00111518f $X=0.4715 $Y=0.2025
cc_109 N_8_12 N_B_6 0.000435185f $X=0.4715 $Y=0.2025
cc_110 N_8_12 N_B_7 0.000502061f $X=0.4715 $Y=0.2025
cc_111 N_8_13 N_B_6 0.000742077f $X=0.2585 $Y=0.198
cc_112 N_8_13 N_B_1 0.00147764f $X=0.2585 $Y=0.198
cc_113 N_8_3 N_B_4 0.00152444f $X=0.486 $Y=0.2025
cc_114 N_8_12 N_B_1 0.00310556f $X=0.4715 $Y=0.2025
cc_115 N_8_11 N_B_3 0.0321352f $X=0.3635 $Y=0.2025
cc_116 N_8_12 N_B_5 0.0357962f $X=0.4715 $Y=0.2025
cc_117 N_8_12 N_B_4 0.029157f $X=0.4715 $Y=0.2025
cc_118 N_8_10 N_7_13 0.00115259f $X=0.2555 $Y=0.2025
cc_119 N_8_11 N_7_12 0.00116268f $X=0.3635 $Y=0.2025
cc_120 N_8_1 N_7_2 0.00353214f $X=0.27 $Y=0.2025
cc_121 N_8_2 N_7_3 0.00389581f $X=0.378 $Y=0.2025
cc_122 N_8_13 N_7_13 0.010973f $X=0.2585 $Y=0.198
x_PM_NOR4xp75_ASAP7_75t_R%C vss C N_M3_g N_M15_g N_M4_g N_M16_g N_M5_g N_M17_g
+ N_C_1 N_C_6 N_C_3 N_C_5 N_C_8 N_C_4 N_C_7 PM_NOR4xp75_ASAP7_75t_R%C
cc_123 N_C_1 N_D_5 0.000476027f $X=0.243 $Y=0.135
cc_124 N_C_6 N_D_1 0.00146283f $X=0.216 $Y=0.16
cc_125 N_C_3 N_D_5 0.00611791f $X=0.243 $Y=0.0245

* End of included file NOR4xp75_ASAP7_75t_R.pex.sp.pxi
.ends

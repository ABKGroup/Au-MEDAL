.subckt PM_NAND2xp5_ASAP7_75t_R%6 vss 2 3 1
c1 1 vss 0.000800008f $X=0.108 $Y=0.0675
r1 2 1 0.209877 $w=8.1e-08 $l=1.7e-08 $layer=N_src_drn $thickness=1e-09
+ $X=0.0906 $Y=0.0675 $X2=0.108 $Y2=0.0675
r2 3 1 0.209877 $w=8.1e-08 $l=1.7e-08 $layer=N_src_drn $thickness=1e-09
+ $X=0.1253 $Y=0.0675 $X2=0.108 $Y2=0.0675
.ends

.subckt PM_NAND2xp5_ASAP7_75t_R%A vss 22 10 16 9 1 3 6
c1 1 vss 0.00696817f $X=0.072 $Y=0.135
c2 3 vss 0.0776269f $X=0.081 $Y=0.0245
c3 4 vss 0.00762235f $X=0.027 $Y=0.036
c4 5 vss 0.00126288f $X=0.027 $Y=0.135
c5 6 vss 0.00709349f $X=0.027 $Y=0.234
c6 7 vss 0.00731563f $X=0.027 $Y=0.1035
c7 8 vss 0.00697466f $X=0.027 $Y=0.1665
c8 9 vss 0.00169056f $X=0.0455 $Y=0.135
r1 6 27 3.01711 $w=1.55e-08 $l=1.8e-08 $layer=M1 $thickness=3.6e-08 $X=0.027
+ $Y=0.234 $X2=0.027 $Y2=0.216
r2 4 25 3.01711 $w=1.55e-08 $l=1.8e-08 $layer=M1 $thickness=3.6e-08 $X=0.027
+ $Y=0.036 $X2=0.027 $Y2=0.054
r3 26 27 4.19742 $w=1.3e-08 $l=1.8e-08 $layer=M1 $thickness=3.6e-08 $X=0.027
+ $Y=0.198 $X2=0.027 $Y2=0.216
r4 8 26 7.34548 $w=1.3e-08 $l=3.15e-08 $layer=M1 $thickness=3.6e-08 $X=0.027
+ $Y=0.1665 $X2=0.027 $Y2=0.198
r5 24 25 4.19742 $w=1.3e-08 $l=1.8e-08 $layer=M1 $thickness=3.6e-08 $X=0.027
+ $Y=0.072 $X2=0.027 $Y2=0.054
r6 7 24 7.34548 $w=1.3e-08 $l=3.15e-08 $layer=M1 $thickness=3.6e-08 $X=0.027
+ $Y=0.1035 $X2=0.027 $Y2=0.072
r7 5 9 3.1337 $w=1.54324e-08 $l=1.85e-08 $layer=M1 $thickness=3.6e-08 $X=0.027
+ $Y=0.135 $X2=0.0455 $Y2=0.135
r8 5 7 6.16517 $w=1.44286e-08 $l=3.15e-08 $layer=M1 $thickness=3.6e-08 $X=0.027
+ $Y=0.135 $X2=0.027 $Y2=0.1035
r9 5 8 6.16517 $w=1.44286e-08 $l=3.15e-08 $layer=M1 $thickness=3.6e-08 $X=0.027
+ $Y=0.135 $X2=0.027 $Y2=0.1665
r10 22 9 4.31401 $w=1.3e-08 $l=1.85e-08 $layer=M1 $thickness=3.6e-08 $X=0.06
+ $Y=0.135 $X2=0.0455 $Y2=0.135
r11 22 20 19.3796 $a=3.24e-16 $layer=V0LIG $X=0.06 $Y=0.135 $X2=0.063 $Y2=0.135
r12 1 18 3.86521 $w=1.8e-08 $l=1e-08 $layer=LIG $thickness=4.8e-08 $X=0.072
+ $Y=0.135 $X2=0.082 $Y2=0.135
r13 1 20 12.7513 $w=1.20444e-08 $l=9e-09 $layer=LIG $thickness=4.8e-08 $X=0.072
+ $Y=0.135 $X2=0.063 $Y2=0.135
r14 16 15 14.6259 $w=2.1e-08 $l=4.3e-08 $layer=Gate_1 $thickness=5.6e-08
+ $X=0.081 $Y=0.216 $X2=0.081 $Y2=0.173
r15 14 15 7.65311 $w=2.1e-08 $l=2.25e-08 $layer=Gate_1 $thickness=5.6e-08
+ $X=0.081 $Y=0.1505 $X2=0.081 $Y2=0.173
r16 13 14 5.4252 $w=2.04194e-08 $l=1.55e-08 $layer=Gate_1 $thickness=5.6e-08
+ $X=0.081 $Y=0.135 $X2=0.081 $Y2=0.1505
r17 13 18 6.69299 $w=1.9e-08 $l=1e-09 $layer=LIG $thickness=5.2e-08 $X=0.081
+ $Y=0.135 $X2=0.082 $Y2=0.135
r18 12 13 5.4252 $w=2.04194e-08 $l=1.55e-08 $layer=Gate_1 $thickness=5.6e-08
+ $X=0.081 $Y=0.1195 $X2=0.081 $Y2=0.135
r19 11 12 3.06124 $w=2.1e-08 $l=9e-09 $layer=Gate_1 $thickness=5.6e-08 $X=0.081
+ $Y=0.1105 $X2=0.081 $Y2=0.1195
r20 10 11 14.6259 $w=2.1e-08 $l=4.3e-08 $layer=Gate_1 $thickness=5.6e-08
+ $X=0.081 $Y=0.0675 $X2=0.081 $Y2=0.1105
r21 10 3 14.6259 $w=2.1e-08 $l=4.3e-08 $layer=Gate_1 $thickness=5.6e-08
+ $X=0.081 $Y=0.0675 $X2=0.081 $Y2=0.0245
.ends

.subckt PM_NAND2xp5_ASAP7_75t_R%B vss 19 7 13 4 1 6 3 5
c1 1 vss 0.00193893f $X=0.135 $Y=0.135
c2 3 vss 0.0407043f $X=0.135 $Y=0.0245
c3 4 vss 0.00497618f $X=0.1345 $Y=0.072
c4 5 vss 0.00263761f $X=0.135 $Y=0.198
c5 6 vss 0.00734698f $X=0.135 $Y=0.135
r1 5 20 5.17411 $w=1.46514e-08 $l=2.73e-08 $layer=M1 $thickness=3.6e-08
+ $X=0.135 $Y=0.198 $X2=0.135 $Y2=0.1707
r2 4 17 6.11415 $w=1.4371e-08 $l=3.1504e-08 $layer=M1 $thickness=3.6e-08
+ $X=0.1345 $Y=0.072 $X2=0.135 $Y2=0.1035
r3 19 20 4.37231 $w=1.3e-08 $l=1.87e-08 $layer=M1 $thickness=3.6e-08 $X=0.135
+ $Y=0.152 $X2=0.135 $Y2=0.1707
r4 19 18 0.991056 $w=1.3e-08 $l=4.3e-09 $layer=M1 $thickness=3.6e-08 $X=0.135
+ $Y=0.152 $X2=0.135 $Y2=0.1477
r5 6 17 7.34548 $w=1.3e-08 $l=3.15e-08 $layer=M1 $thickness=3.6e-08 $X=0.135
+ $Y=0.135 $X2=0.135 $Y2=0.1035
r6 6 18 2.97317 $w=1.3e-08 $l=1.27e-08 $layer=M1 $thickness=3.6e-08 $X=0.135
+ $Y=0.135 $X2=0.135 $Y2=0.1477
r7 1 10 7.07951 $w=1.89474e-08 $layer=LIG $thickness=5.17895e-08 $X=0.135
+ $Y=0.135 $X2=0.135 $Y2=0.135
r8 1 6 19.3796 $a=3.24e-16 $layer=V0LIG $X=0.135 $Y=0.135 $X2=0.135 $Y2=0.135
r9 13 12 14.6259 $w=2.1e-08 $l=4.3e-08 $layer=Gate_1 $thickness=5.6e-08
+ $X=0.135 $Y=0.216 $X2=0.135 $Y2=0.173
r10 11 12 7.65311 $w=2.1e-08 $l=2.25e-08 $layer=Gate_1 $thickness=5.6e-08
+ $X=0.135 $Y=0.1505 $X2=0.135 $Y2=0.173
r11 10 11 5.4252 $w=2.04194e-08 $l=1.55e-08 $layer=Gate_1 $thickness=5.6e-08
+ $X=0.135 $Y=0.135 $X2=0.135 $Y2=0.1505
r12 9 10 5.4252 $w=2.04194e-08 $l=1.55e-08 $layer=Gate_1 $thickness=5.6e-08
+ $X=0.135 $Y=0.1195 $X2=0.135 $Y2=0.135
r13 8 9 3.06124 $w=2.1e-08 $l=9e-09 $layer=Gate_1 $thickness=5.6e-08 $X=0.135
+ $Y=0.1105 $X2=0.135 $Y2=0.1195
r14 7 8 14.6259 $w=2.1e-08 $l=4.3e-08 $layer=Gate_1 $thickness=5.6e-08 $X=0.135
+ $Y=0.0675 $X2=0.135 $Y2=0.1105
r15 7 3 14.6259 $w=2.1e-08 $l=4.3e-08 $layer=Gate_1 $thickness=5.6e-08 $X=0.135
+ $Y=0.0675 $X2=0.135 $Y2=0.0245
.ends

.subckt PM_NAND2xp5_ASAP7_75t_R%Y vss 19 15 30 31 8 7 2 12 11 13
c1 1 vss 0.00777317f $X=0.108 $Y=0.216
c2 2 vss 0.00680282f $X=0.162 $Y=0.0675
c3 7 vss 0.0372545f $X=0.1475 $Y=0.0675
c4 8 vss 0.00381066f $X=0.0935 $Y=0.216
c5 9 vss 0.00269716f $X=0.189 $Y=0.036
c6 10 vss 0.00296115f $X=0.189 $Y=0.234
c7 11 vss 0.00810485f $X=0.162 $Y=0.234
c8 12 vss 0.00354213f $X=0.162 $Y=0.036
c9 13 vss 0.00557466f $X=0.189 $Y=0.054
r1 31 29 0.0462963 $w=5.4e-08 $l=2.5e-09 $layer=P_src_drn $thickness=1e-09
+ $X=0.1253 $Y=0.216 $X2=0.1225 $Y2=0.216
r2 1 29 0.268519 $w=5.4e-08 $l=1.45e-08 $layer=P_src_drn $thickness=1e-09
+ $X=0.108 $Y=0.216 $X2=0.1225 $Y2=0.216
r3 8 1 0.268519 $w=5.4e-08 $l=1.45e-08 $layer=P_src_drn $thickness=1e-09
+ $X=0.0935 $Y=0.216 $X2=0.108 $Y2=0.216
r4 30 8 0.0462963 $w=5.4e-08 $l=2.5e-09 $layer=P_src_drn $thickness=1e-09
+ $X=0.0906 $Y=0.216 $X2=0.0935 $Y2=0.216
r5 1 23 19.3796 $a=3.24e-16 $layer=V0LISD $X=0.108 $Y=0.216 $X2=0.112 $Y2=0.234
r6 23 24 4.31401 $w=1.3e-08 $l=1.85e-08 $layer=M1 $thickness=3.6e-08 $X=0.112
+ $Y=0.234 $X2=0.1305 $Y2=0.234
r7 11 24 7.34548 $w=1.3e-08 $l=3.15e-08 $layer=M1 $thickness=3.6e-08 $X=0.162
+ $Y=0.234 $X2=0.1305 $Y2=0.234
r8 10 22 2.5483 $w=1.79e-08 $l=1.8e-08 $layer=M1 $thickness=3.6e-08 $X=0.189
+ $Y=0.234 $X2=0.189 $Y2=0.216
r9 10 11 4.64701 $w=1.46667e-08 $l=2.7e-08 $layer=M1 $thickness=3.6e-08
+ $X=0.189 $Y=0.234 $X2=0.162 $Y2=0.234
r10 21 22 4.19742 $w=1.3e-08 $l=1.8e-08 $layer=M1 $thickness=3.6e-08 $X=0.189
+ $Y=0.198 $X2=0.189 $Y2=0.216
r11 20 21 14.3995 $w=1.3e-08 $l=6.18e-08 $layer=M1 $thickness=3.6e-08 $X=0.189
+ $Y=0.1362 $X2=0.189 $Y2=0.198
r12 19 20 12.4174 $w=1.3e-08 $l=5.32e-08 $layer=M1 $thickness=3.6e-08 $X=0.19
+ $Y=0.083 $X2=0.189 $Y2=0.1362
r13 19 18 0.291487 $w=1.3e-08 $l=1.3e-09 $layer=M1 $thickness=3.6e-08 $X=0.19
+ $Y=0.083 $X2=0.189 $Y2=0.0817
r14 17 18 2.2736 $w=1.3e-08 $l=9.7e-09 $layer=M1 $thickness=3.6e-08 $X=0.189
+ $Y=0.072 $X2=0.189 $Y2=0.0817
r15 13 17 4.19742 $w=1.3e-08 $l=1.8e-08 $layer=M1 $thickness=3.6e-08 $X=0.189
+ $Y=0.054 $X2=0.189 $Y2=0.072
r16 9 12 4.64701 $w=1.46667e-08 $l=2.7e-08 $layer=M1 $thickness=3.6e-08
+ $X=0.189 $Y=0.036 $X2=0.162 $Y2=0.036
r17 9 13 2.5483 $w=1.79e-08 $l=1.8e-08 $layer=M1 $thickness=3.6e-08 $X=0.189
+ $Y=0.036 $X2=0.189 $Y2=0.054
r18 2 12 19.3796 $a=3.24e-16 $layer=V0LISD $X=0.162 $Y=0.0675 $X2=0.162
+ $Y2=0.036
r19 7 2 0.154321 $w=8.1e-08 $l=1.25e-08 $layer=N_src_drn $thickness=1e-09
+ $X=0.1475 $Y=0.0675 $X2=0.162 $Y2=0.0675
r20 15 7 0.0308642 $w=8.1e-08 $l=2.5e-09 $layer=N_src_drn $thickness=1e-09
+ $X=0.1446 $Y=0.0675 $X2=0.1475 $Y2=0.0675
.ends

* End of included file NAND2xp5_ASAP7_75t_R.pex.sp.pex

*
.subckt NAND2xp5_ASAP7_75t_CUSTOM_4_25_0_7 VSS VDD A B Y
*
* VSS VSS
* VDD VDD
* A A
* B B
* Y Y
*
*

M0 N_M0_d N_M0_g VSS VSS nmos_rvt L=2e-08 W=8.1e-08 nfin=3 $X=0.071 $Y=0.027
M1 N_M1_d N_M1_g N_M1_s VSS nmos_rvt L=2e-08 W=8.1e-08 nfin=3 $X=0.125 $Y=0.027
M2 N_M2_d N_M2_g VDD VDD pmos_rvt L=2e-08 W=5.4e-08 nfin=2 $X=0.071 $Y=0.189
M3 VDD N_M3_g N_M3_s VDD pmos_rvt L=2e-08 W=5.4e-08 nfin=2 $X=0.125 $Y=0.189

* .include "NAND2xp5_ASAP7_75t_R.pex.sp.pxi"

* Start of included file NAND2xp5_ASAP7_75t_R.pex.sp.pxi
x_PM_NAND2xp5_ASAP7_75t_R%6 vss N_M0_d N_M1_s N_6_1 PM_NAND2xp5_ASAP7_75t_R%6
cc_1 N_6_1 N_A_3 0.016873f $X=0.108 $Y=0.0675
cc_2 N_6_1 N_B_3 0.0168888f $X=0.108 $Y=0.0675
x_PM_NAND2xp5_ASAP7_75t_R%A vss A N_M0_g N_M2_g N_A_9 N_A_1 N_A_3 N_A_6
+ PM_NAND2xp5_ASAP7_75t_R%A
x_PM_NAND2xp5_ASAP7_75t_R%B vss B N_M1_g N_M3_g N_B_4 N_B_1 N_B_6 N_B_3 N_B_5
+ PM_NAND2xp5_ASAP7_75t_R%B
cc_3 N_B_4 N_A_9 0.000603771f $X=0.1345 $Y=0.072
cc_4 N_B_1 N_A_1 0.00148057f $X=0.135 $Y=0.135
cc_5 N_B_6 N_A_9 0.0017741f $X=0.135 $Y=0.135
cc_6 N_B_3 N_A_3 0.00933327f $X=0.135 $Y=0.0245
x_PM_NAND2xp5_ASAP7_75t_R%Y vss Y N_M1_d N_M2_d N_M3_s N_Y_8 N_Y_7 N_Y_2 N_Y_12
+ N_Y_11 N_Y_13 PM_NAND2xp5_ASAP7_75t_R%Y
cc_7 N_Y_8 N_A_6 0.000822737f $X=0.0935 $Y=0.216
cc_8 N_Y_8 N_A_3 0.0279721f $X=0.0935 $Y=0.216
cc_9 N_Y_7 N_B_1 0.0012732f $X=0.1475 $Y=0.0675
cc_10 N_Y_2 N_B_3 0.00171992f $X=0.162 $Y=0.0675
cc_11 N_Y_12 N_B_4 0.00240026f $X=0.162 $Y=0.036
cc_12 N_Y_8 N_B_3 0.0108072f $X=0.0935 $Y=0.216
cc_13 N_Y_11 N_B_5 0.00448205f $X=0.162 $Y=0.234
cc_14 N_Y_13 N_B_6 0.00574089f $X=0.189 $Y=0.054
cc_15 N_Y_7 N_B_3 0.0521421f $X=0.1475 $Y=0.0675

* End of included file NAND2xp5_ASAP7_75t_R.pex.sp.pxi
.ends

.subckt PM_OR3x2_ASAP7_75t_R%8 vss 2 3 1
c1 1 vss 0.000697363f $X=0.108 $Y=0.2025
r1 2 1 0.209877 $w=8.1e-08 $l=1.7e-08 $layer=P_src_drn $thickness=1e-09
+ $X=0.0906 $Y=0.2025 $X2=0.108 $Y2=0.2025
r2 3 1 0.209877 $w=8.1e-08 $l=1.7e-08 $layer=P_src_drn $thickness=1e-09
+ $X=0.1253 $Y=0.2025 $X2=0.108 $Y2=0.2025
.ends

.subckt PM_OR3x2_ASAP7_75t_R%9 vss 2 3 1
c1 1 vss 0.000772277f $X=0.162 $Y=0.2025
r1 2 1 0.209877 $w=8.1e-08 $l=1.7e-08 $layer=P_src_drn $thickness=1e-09
+ $X=0.1446 $Y=0.2025 $X2=0.162 $Y2=0.2025
r2 3 1 0.209877 $w=8.1e-08 $l=1.7e-08 $layer=P_src_drn $thickness=1e-09
+ $X=0.1793 $Y=0.2025 $X2=0.162 $Y2=0.2025
.ends

.subckt PM_OR3x2_ASAP7_75t_R%C vss 12 5 9 3 4 1
c1 1 vss 0.00759357f $X=0.189 $Y=0.135
c2 3 vss 0.0841617f $X=0.189 $Y=0.0245
c3 4 vss 0.00500949f $X=0.189 $Y=0.098
r1 12 4 8.62802 $w=1.3e-08 $l=3.7e-08 $layer=M1 $thickness=3.6e-08 $X=0.187
+ $Y=0.134 $X2=0.189 $Y2=0.098
r2 1 7 10.6051 $w=1.77022e-08 $l=5e-10 $layer=LIG $thickness=5.20889e-08
+ $X=0.189 $Y=0.135 $X2=0.189 $Y2=0.1355
r3 12 1 19.3796 $a=3.24e-16 $layer=V0LIG $X=0.187 $Y=0.134 $X2=0.189 $Y2=0.135
r4 9 8 16.3266 $w=2.1e-08 $l=4.8e-08 $layer=Gate_1 $thickness=5.6e-08 $X=0.189
+ $Y=0.2025 $X2=0.189 $Y2=0.1545
r5 7 8 6.6582 $w=2.03947e-08 $l=1.9e-08 $layer=Gate_1 $thickness=5.6e-08
+ $X=0.189 $Y=0.1355 $X2=0.189 $Y2=0.1545
r6 6 7 6.82827 $w=2.04103e-08 $l=1.95e-08 $layer=Gate_1 $thickness=5.6e-08
+ $X=0.189 $Y=0.116 $X2=0.189 $Y2=0.1355
r7 5 6 16.4967 $w=2.1e-08 $l=4.85e-08 $layer=Gate_1 $thickness=5.6e-08 $X=0.189
+ $Y=0.0675 $X2=0.189 $Y2=0.116
r8 5 3 14.6259 $w=2.1e-08 $l=4.3e-08 $layer=Gate_1 $thickness=5.6e-08 $X=0.189
+ $Y=0.0675 $X2=0.189 $Y2=0.0245
.ends

.subckt PM_OR3x2_ASAP7_75t_R%Y vss 28 20 21 36 37 8 2 1 13 14 7
c1 1 vss 0.00730218f $X=0.27 $Y=0.0675
c2 2 vss 0.00723576f $X=0.27 $Y=0.2025
c3 7 vss 0.00440944f $X=0.2555 $Y=0.0675
c4 8 vss 0.00439539f $X=0.2555 $Y=0.2025
c5 9 vss 0.00245103f $X=0.27 $Y=0.036
c6 10 vss 0.00245103f $X=0.27 $Y=0.234
c7 11 vss 0.00291876f $X=0.351 $Y=0.036
c8 12 vss 0.00291876f $X=0.351 $Y=0.234
c9 13 vss 0.000819301f $X=0.27 $Y=0.054
c10 14 vss 0.00115774f $X=0.27 $Y=0.1865
c11 15 vss 0.00597948f $X=0.2815 $Y=0.036
c12 16 vss 0.00596472f $X=0.313 $Y=0.234
c13 17 vss 0.00833567f $X=0.351 $Y=0.0655
r1 37 35 0.0308642 $w=8.1e-08 $l=2.5e-09 $layer=P_src_drn $thickness=1e-09
+ $X=0.2873 $Y=0.2025 $X2=0.2845 $Y2=0.2025
r2 2 35 0.179012 $w=8.1e-08 $l=1.45e-08 $layer=P_src_drn $thickness=1e-09
+ $X=0.27 $Y=0.2025 $X2=0.2845 $Y2=0.2025
r3 8 2 0.179012 $w=8.1e-08 $l=1.45e-08 $layer=P_src_drn $thickness=1e-09
+ $X=0.2555 $Y=0.2025 $X2=0.27 $Y2=0.2025
r4 36 8 0.0308642 $w=8.1e-08 $l=2.5e-09 $layer=P_src_drn $thickness=1e-09
+ $X=0.2526 $Y=0.2025 $X2=0.2555 $Y2=0.2025
r5 2 32 19.3796 $a=3.24e-16 $layer=V0LISD $X=0.27 $Y=0.2025 $X2=0.27 $Y2=0.198
r6 32 33 4.19742 $w=1.3e-08 $l=1.8e-08 $layer=M1 $thickness=3.6e-08 $X=0.27
+ $Y=0.198 $X2=0.27 $Y2=0.216
r7 14 32 2.68168 $w=1.3e-08 $l=1.15e-08 $layer=M1 $thickness=3.6e-08 $X=0.27
+ $Y=0.1865 $X2=0.27 $Y2=0.198
r8 10 31 1.03257 $w=1.6913e-08 $l=1.15e-08 $layer=M1 $thickness=3.6e-08 $X=0.27
+ $Y=0.234 $X2=0.2815 $Y2=0.234
r9 10 33 2.5483 $w=1.79e-08 $l=1.8e-08 $layer=M1 $thickness=3.6e-08 $X=0.27
+ $Y=0.234 $X2=0.27 $Y2=0.216
r10 16 31 7.34548 $w=1.3e-08 $l=3.15e-08 $layer=M1 $thickness=3.6e-08 $X=0.313
+ $Y=0.234 $X2=0.2815 $Y2=0.234
r11 12 30 5.22999 $w=1.59898e-08 $l=2.95e-08 $layer=M1 $thickness=3.6e-08
+ $X=0.351 $Y=0.234 $X2=0.351 $Y2=0.2045
r12 12 16 7.2121 $w=1.41842e-08 $l=3.8e-08 $layer=M1 $thickness=3.6e-08
+ $X=0.351 $Y=0.234 $X2=0.313 $Y2=0.234
r13 29 30 8.97781 $w=1.3e-08 $l=3.85e-08 $layer=M1 $thickness=3.6e-08 $X=0.351
+ $Y=0.166 $X2=0.351 $Y2=0.2045
r14 28 29 4.31401 $w=1.3e-08 $l=1.85e-08 $layer=M1 $thickness=3.6e-08 $X=0.351
+ $Y=0.1475 $X2=0.351 $Y2=0.166
r15 28 27 0.46638 $w=1.3e-08 $l=2e-09 $layer=M1 $thickness=3.6e-08 $X=0.351
+ $Y=0.1475 $X2=0.351 $Y2=0.1455
r16 26 27 2.44849 $w=1.3e-08 $l=1.05e-08 $layer=M1 $thickness=3.6e-08 $X=0.351
+ $Y=0.135 $X2=0.351 $Y2=0.1455
r17 25 26 6.7625 $w=1.3e-08 $l=2.9e-08 $layer=M1 $thickness=3.6e-08 $X=0.351
+ $Y=0.106 $X2=0.351 $Y2=0.135
r18 17 25 9.44419 $w=1.3e-08 $l=4.05e-08 $layer=M1 $thickness=3.6e-08 $X=0.351
+ $Y=0.0655 $X2=0.351 $Y2=0.106
r19 11 24 7.2121 $w=1.41842e-08 $l=3.8e-08 $layer=M1 $thickness=3.6e-08
+ $X=0.351 $Y=0.036 $X2=0.313 $Y2=0.036
r20 11 17 5.22999 $w=1.59898e-08 $l=2.95e-08 $layer=M1 $thickness=3.6e-08
+ $X=0.351 $Y=0.036 $X2=0.351 $Y2=0.0655
r21 15 24 7.34548 $w=1.3e-08 $l=3.15e-08 $layer=M1 $thickness=3.6e-08 $X=0.2815
+ $Y=0.036 $X2=0.313 $Y2=0.036
r22 9 13 2.5483 $w=1.79e-08 $l=1.8e-08 $layer=M1 $thickness=3.6e-08 $X=0.27
+ $Y=0.036 $X2=0.27 $Y2=0.054
r23 9 15 1.03257 $w=1.6913e-08 $l=1.15e-08 $layer=M1 $thickness=3.6e-08 $X=0.27
+ $Y=0.036 $X2=0.2815 $Y2=0.036
r24 13 22 4.19742 $w=1.3e-08 $l=1.8e-08 $layer=M1 $thickness=3.6e-08 $X=0.27
+ $Y=0.054 $X2=0.27 $Y2=0.072
r25 1 22 19.3796 $a=3.24e-16 $layer=V0LISD $X=0.27 $Y=0.0675 $X2=0.27 $Y2=0.072
r26 21 19 0.0308642 $w=8.1e-08 $l=2.5e-09 $layer=N_src_drn $thickness=1e-09
+ $X=0.2873 $Y=0.0675 $X2=0.2845 $Y2=0.0675
r27 1 19 0.179012 $w=8.1e-08 $l=1.45e-08 $layer=N_src_drn $thickness=1e-09
+ $X=0.27 $Y=0.0675 $X2=0.2845 $Y2=0.0675
r28 7 1 0.179012 $w=8.1e-08 $l=1.45e-08 $layer=N_src_drn $thickness=1e-09
+ $X=0.2555 $Y=0.0675 $X2=0.27 $Y2=0.0675
r29 20 7 0.0308642 $w=8.1e-08 $l=2.5e-09 $layer=N_src_drn $thickness=1e-09
+ $X=0.2526 $Y=0.0675 $X2=0.2555 $Y2=0.0675
.ends

.subckt PM_OR3x2_ASAP7_75t_R%6 vss 25 29 39 43 69 70 72 74 16 4 20 21 3 14 15 5
+ 1 12 22 23 18 24 17 19 13
c1 1 vss 0.00703016f $X=0.243 $Y=0.135
c2 3 vss 0.00985127f $X=0.054 $Y=0.0675
c3 4 vss 0.00788088f $X=0.054 $Y=0.2025
c4 5 vss 0.00867334f $X=0.162 $Y=0.0675
c5 12 vss 0.0808633f $X=0.243 $Y=0.0245
c6 13 vss 0.0842113f $X=0.297 $Y=0.135
c7 14 vss 0.0405559f $X=0.056 $Y=0.0675
c8 15 vss 0.00663797f $X=0.1475 $Y=0.0675
c9 16 vss 0.0400577f $X=0.056 $Y=0.2025
c10 17 vss 0.00266319f $X=0.231 $Y=0.036
c11 18 vss 0.000163502f $X=0.231 $Y=0.135
c12 19 vss 0.00267718f $X=0.231 $Y=0.234
c13 20 vss 0.0183221f $X=0.21 $Y=0.036
c14 21 vss 0.0188369f $X=0.21 $Y=0.234
c15 22 vss 0.00269215f $X=0.231 $Y=0.106
c16 23 vss 0.00276715f $X=0.231 $Y=0.164
c17 24 vss 0.00103915f $X=0.27 $Y=0.135
r1 74 73 0.0308642 $w=8.1e-08 $l=2.5e-09 $layer=P_src_drn $thickness=1e-09
+ $X=0.0713 $Y=0.2025 $X2=0.0685 $Y2=0.2025
r2 16 73 0.154321 $w=8.1e-08 $l=1.25e-08 $layer=P_src_drn $thickness=1e-09
+ $X=0.056 $Y=0.2025 $X2=0.0685 $Y2=0.2025
r3 72 71 0.0308642 $w=8.1e-08 $l=2.5e-09 $layer=N_src_drn $thickness=1e-09
+ $X=0.0713 $Y=0.0675 $X2=0.0685 $Y2=0.0675
r4 14 71 0.154321 $w=8.1e-08 $l=1.25e-08 $layer=N_src_drn $thickness=1e-09
+ $X=0.056 $Y=0.0675 $X2=0.0685 $Y2=0.0675
r5 70 68 0.0308642 $w=8.1e-08 $l=2.5e-09 $layer=N_src_drn $thickness=1e-09
+ $X=0.1793 $Y=0.0675 $X2=0.1765 $Y2=0.0675
r6 5 68 0.179012 $w=8.1e-08 $l=1.45e-08 $layer=N_src_drn $thickness=1e-09
+ $X=0.162 $Y=0.0675 $X2=0.1765 $Y2=0.0675
r7 15 5 0.179012 $w=8.1e-08 $l=1.45e-08 $layer=N_src_drn $thickness=1e-09
+ $X=0.1475 $Y=0.0675 $X2=0.162 $Y2=0.0675
r8 69 15 0.0308642 $w=8.1e-08 $l=2.5e-09 $layer=N_src_drn $thickness=1e-09
+ $X=0.1446 $Y=0.0675 $X2=0.1475 $Y2=0.0675
r9 4 65 19.3796 $a=3.24e-16 $layer=V0LISD $X=0.054 $Y=0.2025 $X2=0.054 $Y2=0.234
r10 3 57 19.3796 $a=3.24e-16 $layer=V0LISD $X=0.054 $Y=0.0675 $X2=0.054
+ $Y2=0.036
r11 5 51 19.3796 $a=3.24e-16 $layer=V0LISD $X=0.162 $Y=0.0675 $X2=0.162
+ $Y2=0.036
r12 65 66 3.14806 $w=1.3e-08 $l=1.35e-08 $layer=M1 $thickness=3.6e-08 $X=0.054
+ $Y=0.234 $X2=0.0675 $Y2=0.234
r13 63 66 3.14806 $w=1.3e-08 $l=1.35e-08 $layer=M1 $thickness=3.6e-08 $X=0.081
+ $Y=0.234 $X2=0.0675 $Y2=0.234
r14 62 63 6.29612 $w=1.3e-08 $l=2.7e-08 $layer=M1 $thickness=3.6e-08 $X=0.108
+ $Y=0.234 $X2=0.081 $Y2=0.234
r15 61 62 6.29612 $w=1.3e-08 $l=2.7e-08 $layer=M1 $thickness=3.6e-08 $X=0.135
+ $Y=0.234 $X2=0.108 $Y2=0.234
r16 60 61 6.29612 $w=1.3e-08 $l=2.7e-08 $layer=M1 $thickness=3.6e-08 $X=0.162
+ $Y=0.234 $X2=0.135 $Y2=0.234
r17 59 60 6.29612 $w=1.3e-08 $l=2.7e-08 $layer=M1 $thickness=3.6e-08 $X=0.189
+ $Y=0.234 $X2=0.162 $Y2=0.234
r18 21 59 4.89699 $w=1.3e-08 $l=2.1e-08 $layer=M1 $thickness=3.6e-08 $X=0.21
+ $Y=0.234 $X2=0.189 $Y2=0.234
r19 57 58 3.14806 $w=1.3e-08 $l=1.35e-08 $layer=M1 $thickness=3.6e-08 $X=0.054
+ $Y=0.036 $X2=0.0675 $Y2=0.036
r20 55 58 3.14806 $w=1.3e-08 $l=1.35e-08 $layer=M1 $thickness=3.6e-08 $X=0.081
+ $Y=0.036 $X2=0.0675 $Y2=0.036
r21 54 55 6.29612 $w=1.3e-08 $l=2.7e-08 $layer=M1 $thickness=3.6e-08 $X=0.108
+ $Y=0.036 $X2=0.081 $Y2=0.036
r22 53 54 6.29612 $w=1.3e-08 $l=2.7e-08 $layer=M1 $thickness=3.6e-08 $X=0.135
+ $Y=0.036 $X2=0.108 $Y2=0.036
r23 51 52 3.14806 $w=1.3e-08 $l=1.35e-08 $layer=M1 $thickness=3.6e-08 $X=0.162
+ $Y=0.036 $X2=0.1755 $Y2=0.036
r24 50 51 3.14806 $w=1.3e-08 $l=1.35e-08 $layer=M1 $thickness=3.6e-08 $X=0.1485
+ $Y=0.036 $X2=0.162 $Y2=0.036
r25 50 53 3.14806 $w=1.3e-08 $l=1.35e-08 $layer=M1 $thickness=3.6e-08 $X=0.1485
+ $Y=0.036 $X2=0.135 $Y2=0.036
r26 49 52 3.14806 $w=1.3e-08 $l=1.35e-08 $layer=M1 $thickness=3.6e-08 $X=0.189
+ $Y=0.036 $X2=0.1755 $Y2=0.036
r27 20 49 4.89699 $w=1.3e-08 $l=2.1e-08 $layer=M1 $thickness=3.6e-08 $X=0.21
+ $Y=0.036 $X2=0.189 $Y2=0.036
r28 19 48 3.36447 $w=1.71023e-08 $l=2.15e-08 $layer=M1 $thickness=3.6e-08
+ $X=0.231 $Y=0.234 $X2=0.231 $Y2=0.2125
r29 19 21 3.24787 $w=1.51429e-08 $l=2.1e-08 $layer=M1 $thickness=3.6e-08
+ $X=0.231 $Y=0.234 $X2=0.21 $Y2=0.234
r30 17 46 3.36447 $w=1.71023e-08 $l=2.15e-08 $layer=M1 $thickness=3.6e-08
+ $X=0.231 $Y=0.036 $X2=0.231 $Y2=0.0575
r31 17 20 3.24787 $w=1.51429e-08 $l=2.1e-08 $layer=M1 $thickness=3.6e-08
+ $X=0.231 $Y=0.036 $X2=0.21 $Y2=0.036
r32 47 48 4.78039 $w=1.3e-08 $l=2.05e-08 $layer=M1 $thickness=3.6e-08 $X=0.231
+ $Y=0.192 $X2=0.231 $Y2=0.2125
r33 23 47 6.52931 $w=1.3e-08 $l=2.8e-08 $layer=M1 $thickness=3.6e-08 $X=0.231
+ $Y=0.164 $X2=0.231 $Y2=0.192
r34 45 46 4.78039 $w=1.3e-08 $l=2.05e-08 $layer=M1 $thickness=3.6e-08 $X=0.231
+ $Y=0.078 $X2=0.231 $Y2=0.0575
r35 22 45 6.52931 $w=1.3e-08 $l=2.8e-08 $layer=M1 $thickness=3.6e-08 $X=0.231
+ $Y=0.106 $X2=0.231 $Y2=0.078
r36 18 35 3.36689 $w=1.53077e-08 $l=1.95e-08 $layer=M1 $thickness=3.6e-08
+ $X=0.231 $Y=0.135 $X2=0.2505 $Y2=0.135
r37 18 22 5.5822 $w=1.45517e-08 $l=2.9e-08 $layer=M1 $thickness=3.6e-08
+ $X=0.231 $Y=0.135 $X2=0.231 $Y2=0.106
r38 18 23 5.5822 $w=1.45517e-08 $l=2.9e-08 $layer=M1 $thickness=3.6e-08
+ $X=0.231 $Y=0.135 $X2=0.231 $Y2=0.164
r39 43 42 14.6259 $w=2.1e-08 $l=4.3e-08 $layer=Gate_1 $thickness=5.6e-08
+ $X=0.297 $Y=0.2025 $X2=0.297 $Y2=0.1595
r40 41 42 2.7211 $w=2.1e-08 $l=8e-09 $layer=Gate_1 $thickness=5.6e-08 $X=0.297
+ $Y=0.1515 $X2=0.297 $Y2=0.1595
r41 39 40 14.6259 $w=2.1e-08 $l=4.3e-08 $layer=Gate_1 $thickness=5.6e-08
+ $X=0.297 $Y=0.0675 $X2=0.297 $Y2=0.1105
r42 37 40 2.7211 $w=2.1e-08 $l=8e-09 $layer=Gate_1 $thickness=5.6e-08 $X=0.297
+ $Y=0.1185 $X2=0.297 $Y2=0.1105
r43 13 33 6.54019 $w=2.09524e-08 $layer=Gate_1 $thickness=5.21905e-08 $X=0.297
+ $Y=0.135 $X2=0.297 $Y2=0.135
r44 13 37 5.79936 $w=2.03333e-08 $l=1.65e-08 $layer=Gate_1 $thickness=5.6e-08
+ $X=0.297 $Y=0.135 $X2=0.297 $Y2=0.1185
r45 13 41 5.79936 $w=2.03333e-08 $l=1.65e-08 $layer=Gate_1 $thickness=5.6e-08
+ $X=0.297 $Y=0.135 $X2=0.297 $Y2=0.1515
r46 24 32 19.3796 $a=3.24e-16 $layer=V0LIG $X=0.27 $Y=0.135 $X2=0.27 $Y2=0.135
r47 24 35 4.5472 $w=1.3e-08 $l=1.95e-08 $layer=M1 $thickness=3.6e-08 $X=0.27
+ $Y=0.135 $X2=0.2505 $Y2=0.135
r48 32 33 12.6539 $w=1.77815e-08 $l=2.7e-08 $layer=LIG $thickness=4.8e-08
+ $X=0.27 $Y=0.135 $X2=0.297 $Y2=0.135
r49 1 27 6.54019 $w=2.09524e-08 $layer=Gate_1 $thickness=5.21905e-08 $X=0.243
+ $Y=0.135 $X2=0.243 $Y2=0.135
r50 1 32 12.6539 $w=1.77815e-08 $l=2.7e-08 $layer=LIG $thickness=4.8e-08
+ $X=0.243 $Y=0.135 $X2=0.27 $Y2=0.135
r51 29 28 16.4967 $w=2.1e-08 $l=4.85e-08 $layer=Gate_1 $thickness=5.6e-08
+ $X=0.243 $Y=0.2025 $X2=0.243 $Y2=0.154
r52 27 28 6.6497 $w=2.04211e-08 $l=1.9e-08 $layer=Gate_1 $thickness=5.6e-08
+ $X=0.243 $Y=0.135 $X2=0.243 $Y2=0.154
r53 26 27 6.6497 $w=2.04211e-08 $l=1.9e-08 $layer=Gate_1 $thickness=5.6e-08
+ $X=0.243 $Y=0.116 $X2=0.243 $Y2=0.135
r54 25 26 16.4967 $w=2.1e-08 $l=4.85e-08 $layer=Gate_1 $thickness=5.6e-08
+ $X=0.243 $Y=0.0675 $X2=0.243 $Y2=0.116
r55 25 12 14.6259 $w=2.1e-08 $l=4.3e-08 $layer=Gate_1 $thickness=5.6e-08
+ $X=0.243 $Y=0.0675 $X2=0.243 $Y2=0.0245
r56 4 16 1e-05 $l=2e-09 $X=0.054 $Y=0.2025 $X2=0.056 $Y2=0.2025
r57 3 14 1e-05 $l=2e-09 $X=0.054 $Y=0.0675 $X2=0.056 $Y2=0.0675
.ends

.subckt PM_OR3x2_ASAP7_75t_R%A vss 13 5 11 3 4 1
c1 1 vss 0.00276452f $X=0.081 $Y=0.1355
c2 3 vss 0.052077f $X=0.081 $Y=0.0245
c3 4 vss 0.00918844f $X=0.081 $Y=0.098
r1 13 4 8.62802 $w=1.3e-08 $l=3.7e-08 $layer=M1 $thickness=3.6e-08 $X=0.081
+ $Y=0.134 $X2=0.081 $Y2=0.098
r2 1 8 10.9005 $w=1.765e-08 $layer=LIG $thickness=5.2e-08 $X=0.081 $Y=0.1355
+ $X2=0.081 $Y2=0.1355
r3 13 1 19.3796 $a=3.24e-16 $layer=V0LIG $X=0.081 $Y=0.134 $X2=0.081 $Y2=0.1355
r4 11 10 14.6259 $w=2.1e-08 $l=4.3e-08 $layer=Gate_1 $thickness=5.6e-08
+ $X=0.081 $Y=0.2025 $X2=0.081 $Y2=0.1595
r5 9 10 2.55104 $w=2.1e-08 $l=7.5e-09 $layer=Gate_1 $thickness=5.6e-08 $X=0.081
+ $Y=0.152 $X2=0.081 $Y2=0.1595
r6 8 9 5.80786 $w=2.0303e-08 $l=1.65e-08 $layer=Gate_1 $thickness=5.6e-08
+ $X=0.081 $Y=0.1355 $X2=0.081 $Y2=0.152
r7 7 8 5.97793 $w=2.03235e-08 $l=1.7e-08 $layer=Gate_1 $thickness=5.6e-08
+ $X=0.081 $Y=0.1185 $X2=0.081 $Y2=0.1355
r8 6 7 2.7211 $w=2.1e-08 $l=8e-09 $layer=Gate_1 $thickness=5.6e-08 $X=0.081
+ $Y=0.1105 $X2=0.081 $Y2=0.1185
r9 5 6 14.6259 $w=2.1e-08 $l=4.3e-08 $layer=Gate_1 $thickness=5.6e-08 $X=0.081
+ $Y=0.0675 $X2=0.081 $Y2=0.1105
r10 5 3 14.6259 $w=2.1e-08 $l=4.3e-08 $layer=Gate_1 $thickness=5.6e-08 $X=0.081
+ $Y=0.0675 $X2=0.081 $Y2=0.0245
.ends

.subckt PM_OR3x2_ASAP7_75t_R%B vss 11 5 9 1 4 3
c1 1 vss 0.00714889f $X=0.135 $Y=0.1355
c2 3 vss 0.0466546f $X=0.135 $Y=0.0245
c3 4 vss 0.00477944f $X=0.135 $Y=0.098
r1 11 4 8.62802 $w=1.3e-08 $l=3.7e-08 $layer=M1 $thickness=3.6e-08 $X=0.136
+ $Y=0.134 $X2=0.135 $Y2=0.098
r2 1 7 10.9005 $w=1.765e-08 $layer=LIG $thickness=5.2e-08 $X=0.135 $Y=0.1355
+ $X2=0.135 $Y2=0.1355
r3 11 1 19.3796 $a=3.24e-16 $layer=V0LIG $X=0.136 $Y=0.134 $X2=0.135 $Y2=0.1355
r4 9 8 16.3266 $w=2.1e-08 $l=4.8e-08 $layer=Gate_1 $thickness=5.6e-08 $X=0.135
+ $Y=0.2025 $X2=0.135 $Y2=0.1545
r5 7 8 6.6582 $w=2.03947e-08 $l=1.9e-08 $layer=Gate_1 $thickness=5.6e-08
+ $X=0.135 $Y=0.1355 $X2=0.135 $Y2=0.1545
r6 6 7 6.82827 $w=2.04103e-08 $l=1.95e-08 $layer=Gate_1 $thickness=5.6e-08
+ $X=0.135 $Y=0.116 $X2=0.135 $Y2=0.1355
r7 5 6 16.4967 $w=2.1e-08 $l=4.85e-08 $layer=Gate_1 $thickness=5.6e-08 $X=0.135
+ $Y=0.0675 $X2=0.135 $Y2=0.116
r8 5 3 14.6259 $w=2.1e-08 $l=4.3e-08 $layer=Gate_1 $thickness=5.6e-08 $X=0.135
+ $Y=0.0675 $X2=0.135 $Y2=0.0245
.ends

* End of included file OR3x2_ASAP7_75t_R.pex.sp.pex

*
.subckt OR3x2_ASAP7_75t_CUSTOM_4_25_0_7 VSS VDD A B C Y
*
* VSS VSS
* VDD VDD
* A A
* B B
* C C
* Y Y
*
*

M0 VSS N_M0_g N_M0_s VSS nmos_rvt L=2e-08 W=8.1e-08 nfin=3 $X=0.071 $Y=0.027
M1 N_M1_d N_M1_g VSS VSS nmos_rvt L=2e-08 W=8.1e-08 nfin=3 $X=0.125 $Y=0.027
M2 VSS N_M2_g N_M2_s VSS nmos_rvt L=2e-08 W=8.1e-08 nfin=3 $X=0.179 $Y=0.027
M3 N_M3_d N_M3_g VSS VSS nmos_rvt L=2e-08 W=8.1e-08 nfin=3 $X=0.233 $Y=0.027
M4 N_M4_d N_M4_g VSS VSS nmos_rvt L=2e-08 W=8.1e-08 nfin=3 $X=0.287 $Y=0.027
M5 N_M5_d N_M5_g N_M5_s VDD pmos_rvt L=2e-08 W=8.1e-08 nfin=3 $X=0.071 $Y=0.162
M6 N_M6_d N_M6_g N_M6_s VDD pmos_rvt L=2e-08 W=8.1e-08 nfin=3 $X=0.125 $Y=0.162
M7 VDD N_M7_g N_M7_s VDD pmos_rvt L=2e-08 W=8.1e-08 nfin=3 $X=0.179 $Y=0.162
M8 N_M8_d N_M8_g VDD VDD pmos_rvt L=2e-08 W=8.1e-08 nfin=3 $X=0.233 $Y=0.162
M9 N_M9_d N_M9_g VDD VDD pmos_rvt L=2e-08 W=8.1e-08 nfin=3 $X=0.287 $Y=0.162

* .include "OR3x2_ASAP7_75t_R.pex.sp.pxi"

* Start of included file OR3x2_ASAP7_75t_R.pex.sp.pxi
x_PM_OR3x2_ASAP7_75t_R%8 vss N_M5_d N_M6_s N_8_1 PM_OR3x2_ASAP7_75t_R%8
cc_1 N_8_1 N_A_3 0.0168068f $X=0.108 $Y=0.2025
cc_2 N_8_1 N_B_3 0.0168768f $X=0.108 $Y=0.2025
x_PM_OR3x2_ASAP7_75t_R%9 vss N_M6_d N_M7_s N_9_1 PM_OR3x2_ASAP7_75t_R%9
cc_3 N_9_1 N_B_3 0.016841f $X=0.162 $Y=0.2025
cc_4 N_9_1 N_C_3 0.0167041f $X=0.162 $Y=0.2025
x_PM_OR3x2_ASAP7_75t_R%C vss C N_M2_g N_M7_g N_C_3 N_C_4 N_C_1
+ PM_OR3x2_ASAP7_75t_R%C
cc_5 N_C_3 N_B_1 0.00128183f $X=0.189 $Y=0.0245
cc_6 N_C_4 N_B_4 0.00457371f $X=0.189 $Y=0.098
cc_7 N_C_3 N_B_3 0.00576486f $X=0.189 $Y=0.0245
x_PM_OR3x2_ASAP7_75t_R%Y vss Y N_M3_d N_M4_d N_M8_d N_M9_d N_Y_8 N_Y_2 N_Y_1
+ N_Y_13 N_Y_14 N_Y_7 PM_OR3x2_ASAP7_75t_R%Y
cc_8 N_Y_8 N_6_22 0.000693888f $X=0.2555 $Y=0.2025
cc_9 N_Y_8 N_6_23 0.000693888f $X=0.2555 $Y=0.2025
cc_10 N_Y_8 N_6_12 0.00167745f $X=0.2555 $Y=0.2025
cc_11 N_Y_8 N_6_1 0.000944763f $X=0.2555 $Y=0.2025
cc_12 N_Y_8 N_6_24 0.00235342f $X=0.2555 $Y=0.2025
cc_13 N_Y_8 N_6_17 0.00142579f $X=0.2555 $Y=0.2025
cc_14 N_Y_8 N_6_19 0.00142596f $X=0.2555 $Y=0.2025
cc_15 N_Y_2 N_6_12 0.00193506f $X=0.27 $Y=0.2025
cc_16 N_Y_1 N_6_13 0.00193565f $X=0.27 $Y=0.0675
cc_17 N_Y_13 N_6_22 0.00360082f $X=0.27 $Y=0.054
cc_18 N_Y_14 N_6_23 0.0036009f $X=0.27 $Y=0.1865
cc_19 N_Y_7 N_6_1 0.00469748f $X=0.2555 $Y=0.0675
cc_20 N_Y_7 N_6_13 0.0103591f $X=0.2555 $Y=0.0675
cc_21 N_Y_7 N_6_12 0.055291f $X=0.2555 $Y=0.0675
cc_22 N_Y_8 N_6_13 0.0669603f $X=0.2555 $Y=0.2025
x_PM_OR3x2_ASAP7_75t_R%6 vss N_M3_g N_M8_g N_M4_g N_M9_g N_M1_d N_M2_s N_M0_s
+ N_M5_s N_6_16 N_6_4 N_6_20 N_6_21 N_6_3 N_6_14 N_6_15 N_6_5 N_6_1 N_6_12
+ N_6_22 N_6_23 N_6_18 N_6_24 N_6_17 N_6_19 N_6_13 PM_OR3x2_ASAP7_75t_R%6
cc_23 N_6_16 N_A_3 0.0155412f $X=0.056 $Y=0.2025
cc_24 N_6_4 N_A_3 0.00245378f $X=0.054 $Y=0.2025
cc_25 N_6_20 N_A_4 0.00119381f $X=0.21 $Y=0.036
cc_26 N_6_21 N_A_4 0.00127196f $X=0.21 $Y=0.234
cc_27 N_6_3 N_A_3 0.00141001f $X=0.054 $Y=0.0675
cc_28 N_6_16 N_A_1 0.0018678f $X=0.056 $Y=0.2025
cc_29 N_6_3 N_A_4 0.00415673f $X=0.054 $Y=0.0675
cc_30 N_6_14 N_A_3 0.0545941f $X=0.056 $Y=0.0675
cc_31 N_6_15 N_B_1 0.000882401f $X=0.1475 $Y=0.0675
cc_32 N_6_5 N_B_3 0.00108648f $X=0.162 $Y=0.0675
cc_33 N_6_20 N_B_4 0.00111977f $X=0.21 $Y=0.036
cc_34 N_6_21 N_B_4 0.00142355f $X=0.21 $Y=0.234
cc_35 N_6_5 N_B_4 0.00320292f $X=0.162 $Y=0.0675
cc_36 N_6_15 N_B_3 0.0360651f $X=0.1475 $Y=0.0675
cc_37 N_6_1 N_C_3 0.000807306f $X=0.243 $Y=0.135
cc_38 N_6_5 N_C_3 0.00192131f $X=0.162 $Y=0.0675
cc_39 N_6_20 N_C_4 0.00091384f $X=0.21 $Y=0.036
cc_40 N_6_21 N_C_4 0.00104667f $X=0.21 $Y=0.234
cc_41 N_6_15 N_C_1 0.00131249f $X=0.1475 $Y=0.0675
cc_42 N_6_12 N_C_3 0.00165635f $X=0.243 $Y=0.0245
cc_43 N_6_22 N_C_4 0.00167629f $X=0.231 $Y=0.106
cc_44 N_6_23 N_C_4 0.00169505f $X=0.231 $Y=0.164
cc_45 N_6_18 N_C_4 0.00682817f $X=0.231 $Y=0.135
cc_46 N_6_15 N_C_3 0.0365344f $X=0.1475 $Y=0.0675
x_PM_OR3x2_ASAP7_75t_R%A vss A N_M0_g N_M5_g N_A_3 N_A_4 N_A_1
+ PM_OR3x2_ASAP7_75t_R%A
x_PM_OR3x2_ASAP7_75t_R%B vss B N_M1_g N_M6_g N_B_1 N_B_4 N_B_3
+ PM_OR3x2_ASAP7_75t_R%B
cc_47 N_B_1 N_A_3 0.00127589f $X=0.135 $Y=0.1355
cc_48 N_B_4 N_A_4 0.00473531f $X=0.135 $Y=0.098
cc_49 N_B_3 N_A_3 0.00592276f $X=0.135 $Y=0.0245

* End of included file OR3x2_ASAP7_75t_R.pex.sp.pxi
.ends

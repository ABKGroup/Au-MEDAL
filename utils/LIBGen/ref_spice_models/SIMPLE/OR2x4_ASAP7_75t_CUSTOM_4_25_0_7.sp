.subckt PM_OR2x4_ASAP7_75t_R%7 vss 2 3 1
c1 1 vss 0.000774653f $X=0.108 $Y=0.2025
r1 2 1 0.209877 $w=8.1e-08 $l=1.7e-08 $layer=P_src_drn $thickness=1e-09
+ $X=0.0906 $Y=0.2025 $X2=0.108 $Y2=0.2025
r2 3 1 0.209877 $w=8.1e-08 $l=1.7e-08 $layer=P_src_drn $thickness=1e-09
+ $X=0.1253 $Y=0.2025 $X2=0.108 $Y2=0.2025
.ends

.subckt PM_OR2x4_ASAP7_75t_R%B vss 24 9 15 1 8 3 4 7
c1 1 vss 0.00426072f $X=0.0715 $Y=0.1355
c2 3 vss 0.0391208f $X=0.081 $Y=0.0245
c3 4 vss 0.00800563f $X=0.027 $Y=0.036
c4 5 vss 0.00150201f $X=0.027 $Y=0.1297
c5 6 vss 0.0088077f $X=0.027 $Y=0.1035
c6 7 vss 0.00624689f $X=0.027 $Y=0.1665
c7 8 vss 0.00212916f $X=0.047 $Y=0.135
r1 4 27 3.01711 $w=1.55e-08 $l=1.8e-08 $layer=M1 $thickness=3.6e-08 $X=0.027
+ $Y=0.036 $X2=0.027 $Y2=0.054
r2 7 25 5.73148 $w=1.38716e-08 $l=2.73e-08 $layer=M1 $thickness=3.6e-08
+ $X=0.027 $Y=0.1665 $X2=0.027 $Y2=0.1392
r3 26 27 4.19742 $w=1.3e-08 $l=1.8e-08 $layer=M1 $thickness=3.6e-08 $X=0.027
+ $Y=0.072 $X2=0.027 $Y2=0.054
r4 6 26 7.34548 $w=1.3e-08 $l=3.15e-08 $layer=M1 $thickness=3.6e-08 $X=0.027
+ $Y=0.1035 $X2=0.027 $Y2=0.072
r5 24 25 0.535733 $w=1.8e-08 $l=5.2e-09 $layer=M1 $thickness=3.6e-08 $X=0.028
+ $Y=0.134 $X2=0.027 $Y2=0.1392
r6 24 5 0.433689 $w=1.8e-08 $l=4.3e-09 $layer=M1 $thickness=3.6e-08 $X=0.028
+ $Y=0.134 $X2=0.027 $Y2=0.1297
r7 5 6 5.62944 $w=1.37143e-08 $l=2.62e-08 $layer=M1 $thickness=3.6e-08 $X=0.027
+ $Y=0.1297 $X2=0.027 $Y2=0.1035
r8 24 21 0.517402 $w=3.18182e-09 $l=1.10454e-08 $layer=M1 $thickness=3.6e-08
+ $X=0.028 $Y=0.134 $X2=0.038 $Y2=0.135
r9 20 22 2.09871 $w=1.3e-08 $l=9e-09 $layer=M1 $thickness=3.6e-08 $X=0.0545
+ $Y=0.135 $X2=0.0635 $Y2=0.135
r10 8 20 1.74892 $w=1.3e-08 $l=7.5e-09 $layer=M1 $thickness=3.6e-08 $X=0.047
+ $Y=0.135 $X2=0.0545 $Y2=0.135
r11 8 21 2.09871 $w=1.3e-08 $l=9e-09 $layer=M1 $thickness=3.6e-08 $X=0.047
+ $Y=0.135 $X2=0.038 $Y2=0.135
r12 18 22 19.3796 $a=3.24e-16 $layer=V0LIG $X=0.0625 $Y=0.1355 $X2=0.0635
+ $Y2=0.135
r13 1 17 2.36633 $w=2.3e-08 $l=1e-08 $layer=LIG $thickness=4.8e-08 $X=0.0715
+ $Y=0.1355 $X2=0.0815 $Y2=0.1355
r14 1 18 4.01497 $w=1.66722e-08 $l=9e-09 $layer=LIG $thickness=4.8e-08
+ $X=0.0715 $Y=0.1355 $X2=0.0625 $Y2=0.1355
r15 15 14 14.6259 $w=2.1e-08 $l=4.3e-08 $layer=Gate_1 $thickness=5.6e-08
+ $X=0.081 $Y=0.2025 $X2=0.081 $Y2=0.1595
r16 13 14 2.55104 $w=2.1e-08 $l=7.5e-09 $layer=Gate_1 $thickness=5.6e-08
+ $X=0.081 $Y=0.152 $X2=0.081 $Y2=0.1595
r17 12 13 5.80786 $w=2.0303e-08 $l=1.65e-08 $layer=Gate_1 $thickness=5.6e-08
+ $X=0.081 $Y=0.1355 $X2=0.081 $Y2=0.152
r18 12 17 6.35518 $w=2.13571e-08 $l=5e-10 $layer=Gate_1 $thickness=5.2381e-08
+ $X=0.081 $Y=0.1355 $X2=0.0815 $Y2=0.1355
r19 11 12 5.97793 $w=2.03235e-08 $l=1.7e-08 $layer=Gate_1 $thickness=5.6e-08
+ $X=0.081 $Y=0.1185 $X2=0.081 $Y2=0.1355
r20 10 11 7.31297 $w=2.1e-08 $l=2.15e-08 $layer=Gate_1 $thickness=5.6e-08
+ $X=0.081 $Y=0.097 $X2=0.081 $Y2=0.1185
r21 9 10 14.6259 $w=2.1e-08 $l=4.3e-08 $layer=Gate_1 $thickness=5.6e-08
+ $X=0.081 $Y=0.054 $X2=0.081 $Y2=0.097
r22 9 3 10.0341 $w=2.1e-08 $l=2.95e-08 $layer=Gate_1 $thickness=5.6e-08
+ $X=0.081 $Y=0.054 $X2=0.081 $Y2=0.0245
.ends

.subckt PM_OR2x4_ASAP7_75t_R%A vss 6 7 11 1 3 4 5
c1 1 vss 0.00654444f $X=0.135 $Y=0.135
c2 3 vss 0.0860245f $X=0.135 $Y=0.0245
c3 4 vss 0.00266928f $X=0.135 $Y=0.072
c4 5 vss 0.00254538f $X=0.135 $Y=0.198
c5 6 vss 0.00316528f $X=0.137 $Y=0.134
r1 5 15 6.16517 $w=1.44286e-08 $l=3.15e-08 $layer=M1 $thickness=3.6e-08
+ $X=0.135 $Y=0.198 $X2=0.135 $Y2=0.1665
r2 4 14 6.16517 $w=1.44286e-08 $l=3.15e-08 $layer=M1 $thickness=3.6e-08
+ $X=0.135 $Y=0.072 $X2=0.135 $Y2=0.1035
r3 6 14 7.34548 $w=1.3e-08 $l=3.15e-08 $layer=M1 $thickness=3.6e-08 $X=0.137
+ $Y=0.134 $X2=0.135 $Y2=0.1035
r4 6 15 7.34548 $w=1.3e-08 $l=3.15e-08 $layer=M1 $thickness=3.6e-08 $X=0.137
+ $Y=0.134 $X2=0.135 $Y2=0.1665
r5 1 9 10.6051 $w=1.77022e-08 $l=5e-10 $layer=LIG $thickness=5.20889e-08
+ $X=0.135 $Y=0.135 $X2=0.135 $Y2=0.1355
r6 6 1 19.3796 $a=3.24e-16 $layer=V0LIG $X=0.137 $Y=0.134 $X2=0.135 $Y2=0.135
r7 11 10 16.3266 $w=2.1e-08 $l=4.8e-08 $layer=Gate_1 $thickness=5.6e-08
+ $X=0.135 $Y=0.2025 $X2=0.135 $Y2=0.1545
r8 9 10 6.6582 $w=2.03947e-08 $l=1.9e-08 $layer=Gate_1 $thickness=5.6e-08
+ $X=0.135 $Y=0.1355 $X2=0.135 $Y2=0.1545
r9 8 9 11.4201 $w=2.06515e-08 $l=3.3e-08 $layer=Gate_1 $thickness=5.6e-08
+ $X=0.135 $Y=0.1025 $X2=0.135 $Y2=0.1355
r10 7 8 16.4967 $w=2.1e-08 $l=4.85e-08 $layer=Gate_1 $thickness=5.6e-08
+ $X=0.135 $Y=0.054 $X2=0.135 $Y2=0.1025
r11 7 3 10.0341 $w=2.1e-08 $l=2.95e-08 $layer=Gate_1 $thickness=5.6e-08
+ $X=0.135 $Y=0.054 $X2=0.135 $Y2=0.0245
.ends

.subckt PM_OR2x4_ASAP7_75t_R%5 vss 23 27 40 43 50 53 57 61 81 82 84 3 19 4 18
+ 14 13 1 16 20 21 9 15 17 11 12 22 10
c1 1 vss 0.0177288f $X=0.297 $Y=0.135
c2 3 vss 0.00896187f $X=0.054 $Y=0.2025
c3 4 vss 0.00807465f $X=0.108 $Y=0.054
c4 9 vss 0.0842722f $X=0.189 $Y=0.135
c5 10 vss 0.0806676f $X=0.243 $Y=0.135
c6 11 vss 0.0812522f $X=0.297 $Y=0.0245
c7 12 vss 0.0929434f $X=0.351 $Y=0.135
c8 13 vss 0.00951331f $X=0.0935 $Y=0.054
c9 14 vss 0.0482005f $X=0.056 $Y=0.2025
c10 15 vss 0.00273217f $X=0.178 $Y=0.036
c11 16 vss 0.000182093f $X=0.178 $Y=0.135
c12 17 vss 0.00272106f $X=0.178 $Y=0.234
c13 18 vss 0.0175771f $X=0.1565 $Y=0.234
c14 19 vss 0.00914878f $X=0.1565 $Y=0.036
c15 20 vss 0.00382116f $X=0.178 $Y=0.106
c16 21 vss 0.00396199f $X=0.178 $Y=0.164
c17 22 vss 0.00203085f $X=0.1955 $Y=0.135
r1 84 83 0.0308642 $w=8.1e-08 $l=2.5e-09 $layer=P_src_drn $thickness=1e-09
+ $X=0.0713 $Y=0.2025 $X2=0.0685 $Y2=0.2025
r2 14 83 0.154321 $w=8.1e-08 $l=1.25e-08 $layer=P_src_drn $thickness=1e-09
+ $X=0.056 $Y=0.2025 $X2=0.0685 $Y2=0.2025
r3 82 80 0.0462963 $w=5.4e-08 $l=2.5e-09 $layer=N_src_drn $thickness=1e-09
+ $X=0.1253 $Y=0.054 $X2=0.1225 $Y2=0.054
r4 4 80 0.268519 $w=5.4e-08 $l=1.45e-08 $layer=N_src_drn $thickness=1e-09
+ $X=0.108 $Y=0.054 $X2=0.1225 $Y2=0.054
r5 13 4 0.268519 $w=5.4e-08 $l=1.45e-08 $layer=N_src_drn $thickness=1e-09
+ $X=0.0935 $Y=0.054 $X2=0.108 $Y2=0.054
r6 81 13 0.0462963 $w=5.4e-08 $l=2.5e-09 $layer=N_src_drn $thickness=1e-09
+ $X=0.0906 $Y=0.054 $X2=0.0935 $Y2=0.054
r7 3 77 19.3796 $a=3.24e-16 $layer=V0LISD $X=0.054 $Y=0.2025 $X2=0.054 $Y2=0.234
r8 4 69 19.3796 $a=3.24e-16 $layer=V0LISD $X=0.108 $Y=0.054 $X2=0.112 $Y2=0.036
r9 77 78 3.73104 $w=1.3e-08 $l=1.6e-08 $layer=M1 $thickness=3.6e-08 $X=0.054
+ $Y=0.234 $X2=0.07 $Y2=0.234
r10 75 78 3.61444 $w=1.3e-08 $l=1.55e-08 $layer=M1 $thickness=3.6e-08 $X=0.0855
+ $Y=0.234 $X2=0.07 $Y2=0.234
r11 74 75 3.49785 $w=1.3e-08 $l=1.5e-08 $layer=M1 $thickness=3.6e-08 $X=0.1005
+ $Y=0.234 $X2=0.0855 $Y2=0.234
r12 73 74 5.82974 $w=1.3e-08 $l=2.5e-08 $layer=M1 $thickness=3.6e-08 $X=0.1255
+ $Y=0.234 $X2=0.1005 $Y2=0.234
r13 18 73 7.22888 $w=1.3e-08 $l=3.1e-08 $layer=M1 $thickness=3.6e-08 $X=0.1565
+ $Y=0.234 $X2=0.1255 $Y2=0.234
r14 69 70 4.31401 $w=1.3e-08 $l=1.85e-08 $layer=M1 $thickness=3.6e-08 $X=0.112
+ $Y=0.036 $X2=0.1305 $Y2=0.036
r15 19 70 6.06293 $w=1.3e-08 $l=2.6e-08 $layer=M1 $thickness=3.6e-08 $X=0.1565
+ $Y=0.036 $X2=0.1305 $Y2=0.036
r16 17 68 2.5483 $w=1.79e-08 $l=1.8e-08 $layer=M1 $thickness=3.6e-08 $X=0.178
+ $Y=0.234 $X2=0.178 $Y2=0.216
r17 17 18 3.36447 $w=1.5093e-08 $l=2.15e-08 $layer=M1 $thickness=3.6e-08
+ $X=0.178 $Y=0.234 $X2=0.1565 $Y2=0.234
r18 15 65 2.5483 $w=1.79e-08 $l=1.8e-08 $layer=M1 $thickness=3.6e-08 $X=0.178
+ $Y=0.036 $X2=0.178 $Y2=0.054
r19 15 19 3.36447 $w=1.5093e-08 $l=2.15e-08 $layer=M1 $thickness=3.6e-08
+ $X=0.178 $Y=0.036 $X2=0.1565 $Y2=0.036
r20 67 68 4.19742 $w=1.3e-08 $l=1.8e-08 $layer=M1 $thickness=3.6e-08 $X=0.178
+ $Y=0.198 $X2=0.178 $Y2=0.216
r21 66 67 2.68168 $w=1.3e-08 $l=1.15e-08 $layer=M1 $thickness=3.6e-08 $X=0.178
+ $Y=0.1865 $X2=0.178 $Y2=0.198
r22 21 66 5.24677 $w=1.3e-08 $l=2.25e-08 $layer=M1 $thickness=3.6e-08 $X=0.178
+ $Y=0.164 $X2=0.178 $Y2=0.1865
r23 64 65 4.19742 $w=1.3e-08 $l=1.8e-08 $layer=M1 $thickness=3.6e-08 $X=0.178
+ $Y=0.072 $X2=0.178 $Y2=0.054
r24 63 64 2.68168 $w=1.3e-08 $l=1.15e-08 $layer=M1 $thickness=3.6e-08 $X=0.178
+ $Y=0.0835 $X2=0.178 $Y2=0.072
r25 20 63 5.24677 $w=1.3e-08 $l=2.25e-08 $layer=M1 $thickness=3.6e-08 $X=0.178
+ $Y=0.106 $X2=0.178 $Y2=0.0835
r26 16 22 2.90051 $w=1.55714e-08 $l=1.75e-08 $layer=M1 $thickness=3.6e-08
+ $X=0.178 $Y=0.135 $X2=0.1955 $Y2=0.135
r27 16 20 5.5822 $w=1.45517e-08 $l=2.9e-08 $layer=M1 $thickness=3.6e-08
+ $X=0.178 $Y=0.135 $X2=0.178 $Y2=0.106
r28 16 21 5.5822 $w=1.45517e-08 $l=2.9e-08 $layer=M1 $thickness=3.6e-08
+ $X=0.178 $Y=0.135 $X2=0.178 $Y2=0.164
r29 61 60 14.6259 $w=2.1e-08 $l=4.3e-08 $layer=Gate_1 $thickness=5.6e-08
+ $X=0.351 $Y=0.2025 $X2=0.351 $Y2=0.1595
r30 59 60 2.7211 $w=2.1e-08 $l=8e-09 $layer=Gate_1 $thickness=5.6e-08 $X=0.351
+ $Y=0.1515 $X2=0.351 $Y2=0.1595
r31 57 58 14.6259 $w=2.1e-08 $l=4.3e-08 $layer=Gate_1 $thickness=5.6e-08
+ $X=0.351 $Y=0.0675 $X2=0.351 $Y2=0.1105
r32 55 58 2.7211 $w=2.1e-08 $l=8e-09 $layer=Gate_1 $thickness=5.6e-08 $X=0.351
+ $Y=0.1185 $X2=0.351 $Y2=0.1105
r33 12 37 6.54019 $w=2.09524e-08 $layer=Gate_1 $thickness=5.21905e-08 $X=0.351
+ $Y=0.135 $X2=0.351 $Y2=0.135
r34 12 55 5.79936 $w=2.03333e-08 $l=1.65e-08 $layer=Gate_1 $thickness=5.6e-08
+ $X=0.351 $Y=0.135 $X2=0.351 $Y2=0.1185
r35 12 59 5.79936 $w=2.03333e-08 $l=1.65e-08 $layer=Gate_1 $thickness=5.6e-08
+ $X=0.351 $Y=0.135 $X2=0.351 $Y2=0.1515
r36 53 52 16.4967 $w=2.1e-08 $l=4.85e-08 $layer=Gate_1 $thickness=5.6e-08
+ $X=0.189 $Y=0.2025 $X2=0.189 $Y2=0.154
r37 50 51 16.4967 $w=2.1e-08 $l=4.85e-08 $layer=Gate_1 $thickness=5.6e-08
+ $X=0.189 $Y=0.0675 $X2=0.189 $Y2=0.116
r38 9 34 6.54019 $w=2.09524e-08 $layer=Gate_1 $thickness=5.21905e-08 $X=0.189
+ $Y=0.135 $X2=0.189 $Y2=0.135
r39 9 51 6.6497 $w=2.04211e-08 $l=1.9e-08 $layer=Gate_1 $thickness=5.6e-08
+ $X=0.189 $Y=0.135 $X2=0.189 $Y2=0.116
r40 9 52 6.6497 $w=2.04211e-08 $l=1.9e-08 $layer=Gate_1 $thickness=5.6e-08
+ $X=0.189 $Y=0.135 $X2=0.189 $Y2=0.154
r41 45 46 2.09871 $w=1.3e-08 $l=9e-09 $layer=M1 $thickness=3.6e-08 $X=0.2055
+ $Y=0.135 $X2=0.2145 $Y2=0.135
r42 22 45 2.3319 $w=1.3e-08 $l=1e-08 $layer=M1 $thickness=3.6e-08 $X=0.1955
+ $Y=0.135 $X2=0.2055 $Y2=0.135
r43 43 42 16.4967 $w=2.1e-08 $l=4.85e-08 $layer=Gate_1 $thickness=5.6e-08
+ $X=0.243 $Y=0.2025 $X2=0.243 $Y2=0.154
r44 40 41 16.4967 $w=2.1e-08 $l=4.85e-08 $layer=Gate_1 $thickness=5.6e-08
+ $X=0.243 $Y=0.0675 $X2=0.243 $Y2=0.116
r45 10 30 6.54019 $w=2.09524e-08 $layer=Gate_1 $thickness=5.21905e-08 $X=0.243
+ $Y=0.135 $X2=0.243 $Y2=0.135
r46 10 41 6.6497 $w=2.04211e-08 $l=1.9e-08 $layer=Gate_1 $thickness=5.6e-08
+ $X=0.243 $Y=0.135 $X2=0.243 $Y2=0.116
r47 10 42 6.6497 $w=2.04211e-08 $l=1.9e-08 $layer=Gate_1 $thickness=5.6e-08
+ $X=0.243 $Y=0.135 $X2=0.243 $Y2=0.154
r48 36 37 12.6539 $w=1.77815e-08 $l=2.7e-08 $layer=LIG $thickness=4.8e-08
+ $X=0.324 $Y=0.135 $X2=0.351 $Y2=0.135
r49 32 33 8.56549 $w=1.53e-08 $l=1.45e-08 $layer=LIG $thickness=4.8e-08
+ $X=0.213 $Y=0.135 $X2=0.2275 $Y2=0.135
r50 32 46 19.3796 $a=3.24e-16 $layer=V0LIG $X=0.213 $Y=0.135 $X2=0.2145
+ $Y2=0.135
r51 31 32 6.79332 $w=1.53e-08 $l=1.15e-08 $layer=LIG $thickness=4.8e-08
+ $X=0.2015 $Y=0.135 $X2=0.213 $Y2=0.135
r52 31 34 4.08841 $w=2.066e-08 $l=1.25e-08 $layer=LIG $thickness=4.8e-08
+ $X=0.2015 $Y=0.135 $X2=0.189 $Y2=0.135
r53 30 33 5.86058 $w=1.96226e-08 $l=1.55e-08 $layer=LIG $thickness=4.8e-08
+ $X=0.243 $Y=0.135 $X2=0.2275 $Y2=0.135
r54 29 30 12.6539 $w=1.77815e-08 $l=2.7e-08 $layer=LIG $thickness=4.8e-08
+ $X=0.27 $Y=0.135 $X2=0.243 $Y2=0.135
r55 1 25 6.54019 $w=2.09524e-08 $layer=Gate_1 $thickness=5.21905e-08 $X=0.297
+ $Y=0.135 $X2=0.297 $Y2=0.135
r56 1 29 12.6539 $w=1.77815e-08 $l=2.7e-08 $layer=LIG $thickness=4.8e-08
+ $X=0.297 $Y=0.135 $X2=0.27 $Y2=0.135
r57 1 36 12.6539 $w=1.77815e-08 $l=2.7e-08 $layer=LIG $thickness=4.8e-08
+ $X=0.297 $Y=0.135 $X2=0.324 $Y2=0.135
r58 27 26 16.4967 $w=2.1e-08 $l=4.85e-08 $layer=Gate_1 $thickness=5.6e-08
+ $X=0.297 $Y=0.2025 $X2=0.297 $Y2=0.154
r59 25 26 6.6497 $w=2.04211e-08 $l=1.9e-08 $layer=Gate_1 $thickness=5.6e-08
+ $X=0.297 $Y=0.135 $X2=0.297 $Y2=0.154
r60 24 25 6.6497 $w=2.04211e-08 $l=1.9e-08 $layer=Gate_1 $thickness=5.6e-08
+ $X=0.297 $Y=0.116 $X2=0.297 $Y2=0.135
r61 23 24 16.4967 $w=2.1e-08 $l=4.85e-08 $layer=Gate_1 $thickness=5.6e-08
+ $X=0.297 $Y=0.0675 $X2=0.297 $Y2=0.116
r62 23 11 14.6259 $w=2.1e-08 $l=4.3e-08 $layer=Gate_1 $thickness=5.6e-08
+ $X=0.297 $Y=0.0675 $X2=0.297 $Y2=0.0245
r63 3 14 1e-05 $l=2e-09 $X=0.054 $Y=0.2025 $X2=0.056 $Y2=0.2025
.ends

.subckt PM_OR2x4_ASAP7_75t_R%Y vss 48 34 35 43 44 58 59 62 63 13 23 3 4 17 18 1
+ 2 24 16 15 14
c1 1 vss 0.00703956f $X=0.216 $Y=0.0675
c2 2 vss 0.00696047f $X=0.216 $Y=0.2025
c3 3 vss 0.00726197f $X=0.324 $Y=0.0675
c4 4 vss 0.00726197f $X=0.324 $Y=0.2025
c5 13 vss 0.00437572f $X=0.2015 $Y=0.0675
c6 14 vss 0.00431479f $X=0.3095 $Y=0.0675
c7 15 vss 0.00433627f $X=0.2015 $Y=0.2025
c8 16 vss 0.00430333f $X=0.3095 $Y=0.2025
c9 17 vss 0.00240019f $X=0.216 $Y=0.036
c10 18 vss 0.00240145f $X=0.216 $Y=0.234
c11 19 vss 0.00202314f $X=0.324 $Y=0.036
c12 20 vss 0.00202314f $X=0.324 $Y=0.234
c13 21 vss 0.00286039f $X=0.405 $Y=0.036
c14 22 vss 0.00286039f $X=0.405 $Y=0.234
c15 23 vss 0.0010265f $X=0.216 $Y=0.054
c16 24 vss 0.00120424f $X=0.216 $Y=0.1865
c17 25 vss 0.00825302f $X=0.226 $Y=0.036
c18 26 vss 0.00825303f $X=0.271 $Y=0.234
c19 27 vss 0.00108256f $X=0.324 $Y=0.054
c20 28 vss 0.00108256f $X=0.324 $Y=0.1865
c21 29 vss 0.00583264f $X=0.3645 $Y=0.036
c22 30 vss 0.0058839f $X=0.3645 $Y=0.234
c23 31 vss 0.00822763f $X=0.405 $Y=0.0655
r1 63 61 0.0308642 $w=8.1e-08 $l=2.5e-09 $layer=P_src_drn $thickness=1e-09
+ $X=0.2333 $Y=0.2025 $X2=0.2305 $Y2=0.2025
r2 2 61 0.179012 $w=8.1e-08 $l=1.45e-08 $layer=P_src_drn $thickness=1e-09
+ $X=0.216 $Y=0.2025 $X2=0.2305 $Y2=0.2025
r3 15 2 0.179012 $w=8.1e-08 $l=1.45e-08 $layer=P_src_drn $thickness=1e-09
+ $X=0.2015 $Y=0.2025 $X2=0.216 $Y2=0.2025
r4 62 15 0.0308642 $w=8.1e-08 $l=2.5e-09 $layer=P_src_drn $thickness=1e-09
+ $X=0.1986 $Y=0.2025 $X2=0.2015 $Y2=0.2025
r5 2 54 19.3796 $a=3.24e-16 $layer=V0LISD $X=0.216 $Y=0.2025 $X2=0.216 $Y2=0.198
r6 59 57 0.0308642 $w=8.1e-08 $l=2.5e-09 $layer=P_src_drn $thickness=1e-09
+ $X=0.3413 $Y=0.2025 $X2=0.3385 $Y2=0.2025
r7 4 57 0.179012 $w=8.1e-08 $l=1.45e-08 $layer=P_src_drn $thickness=1e-09
+ $X=0.324 $Y=0.2025 $X2=0.3385 $Y2=0.2025
r8 16 4 0.179012 $w=8.1e-08 $l=1.45e-08 $layer=P_src_drn $thickness=1e-09
+ $X=0.3095 $Y=0.2025 $X2=0.324 $Y2=0.2025
r9 58 16 0.0308642 $w=8.1e-08 $l=2.5e-09 $layer=P_src_drn $thickness=1e-09
+ $X=0.3066 $Y=0.2025 $X2=0.3095 $Y2=0.2025
r10 54 55 4.19742 $w=1.3e-08 $l=1.8e-08 $layer=M1 $thickness=3.6e-08 $X=0.216
+ $Y=0.198 $X2=0.216 $Y2=0.216
r11 24 54 2.68168 $w=1.3e-08 $l=1.15e-08 $layer=M1 $thickness=3.6e-08 $X=0.216
+ $Y=0.1865 $X2=0.216 $Y2=0.198
r12 4 52 19.3796 $a=3.24e-16 $layer=V0LISD $X=0.324 $Y=0.2025 $X2=0.324
+ $Y2=0.198
r13 18 51 0.682785 $w=1.75e-08 $l=1e-08 $layer=M1 $thickness=3.6e-08 $X=0.216
+ $Y=0.234 $X2=0.226 $Y2=0.234
r14 18 55 2.5483 $w=1.79e-08 $l=1.8e-08 $layer=M1 $thickness=3.6e-08 $X=0.216
+ $Y=0.234 $X2=0.216 $Y2=0.216
r15 52 53 4.19742 $w=1.3e-08 $l=1.8e-08 $layer=M1 $thickness=3.6e-08 $X=0.324
+ $Y=0.198 $X2=0.324 $Y2=0.216
r16 28 52 2.68168 $w=1.3e-08 $l=1.15e-08 $layer=M1 $thickness=3.6e-08 $X=0.324
+ $Y=0.1865 $X2=0.324 $Y2=0.198
r17 26 51 10.4935 $w=1.3e-08 $l=4.5e-08 $layer=M1 $thickness=3.6e-08 $X=0.271
+ $Y=0.234 $X2=0.226 $Y2=0.234
r18 20 30 8.26388 $w=1.41111e-08 $l=4.05e-08 $layer=M1 $thickness=3.6e-08
+ $X=0.324 $Y=0.234 $X2=0.3645 $Y2=0.234
r19 20 26 11.1788 $w=1.38491e-08 $l=5.3e-08 $layer=M1 $thickness=3.6e-08
+ $X=0.324 $Y=0.234 $X2=0.271 $Y2=0.234
r20 20 53 3.01711 $w=1.55e-08 $l=1.8e-08 $layer=M1 $thickness=3.6e-08 $X=0.324
+ $Y=0.234 $X2=0.324 $Y2=0.216
r21 22 50 5.22999 $w=1.59898e-08 $l=2.95e-08 $layer=M1 $thickness=3.6e-08
+ $X=0.405 $Y=0.234 $X2=0.405 $Y2=0.2045
r22 22 30 7.79507 $w=1.41111e-08 $l=4.05e-08 $layer=M1 $thickness=3.6e-08
+ $X=0.405 $Y=0.234 $X2=0.3645 $Y2=0.234
r23 49 50 8.97781 $w=1.3e-08 $l=3.85e-08 $layer=M1 $thickness=3.6e-08 $X=0.405
+ $Y=0.166 $X2=0.405 $Y2=0.2045
r24 48 49 4.31401 $w=1.3e-08 $l=1.85e-08 $layer=M1 $thickness=3.6e-08 $X=0.407
+ $Y=0.1475 $X2=0.405 $Y2=0.166
r25 48 47 0.46638 $w=1.3e-08 $l=2e-09 $layer=M1 $thickness=3.6e-08 $X=0.407
+ $Y=0.1475 $X2=0.405 $Y2=0.1455
r26 46 47 2.44849 $w=1.3e-08 $l=1.05e-08 $layer=M1 $thickness=3.6e-08 $X=0.405
+ $Y=0.135 $X2=0.405 $Y2=0.1455
r27 45 46 6.7625 $w=1.3e-08 $l=2.9e-08 $layer=M1 $thickness=3.6e-08 $X=0.405
+ $Y=0.106 $X2=0.405 $Y2=0.135
r28 31 45 9.44419 $w=1.3e-08 $l=4.05e-08 $layer=M1 $thickness=3.6e-08 $X=0.405
+ $Y=0.0655 $X2=0.405 $Y2=0.106
r29 44 42 0.0308642 $w=8.1e-08 $l=2.5e-09 $layer=N_src_drn $thickness=1e-09
+ $X=0.3413 $Y=0.0675 $X2=0.3385 $Y2=0.0675
r30 3 42 0.179012 $w=8.1e-08 $l=1.45e-08 $layer=N_src_drn $thickness=1e-09
+ $X=0.324 $Y=0.0675 $X2=0.3385 $Y2=0.0675
r31 14 3 0.179012 $w=8.1e-08 $l=1.45e-08 $layer=N_src_drn $thickness=1e-09
+ $X=0.3095 $Y=0.0675 $X2=0.324 $Y2=0.0675
r32 43 14 0.0308642 $w=8.1e-08 $l=2.5e-09 $layer=N_src_drn $thickness=1e-09
+ $X=0.3066 $Y=0.0675 $X2=0.3095 $Y2=0.0675
r33 21 29 7.79507 $w=1.41111e-08 $l=4.05e-08 $layer=M1 $thickness=3.6e-08
+ $X=0.405 $Y=0.036 $X2=0.3645 $Y2=0.036
r34 21 31 5.22999 $w=1.59898e-08 $l=2.95e-08 $layer=M1 $thickness=3.6e-08
+ $X=0.405 $Y=0.036 $X2=0.405 $Y2=0.0655
r35 3 39 19.3796 $a=3.24e-16 $layer=V0LISD $X=0.324 $Y=0.0675 $X2=0.324
+ $Y2=0.072
r36 27 39 4.19742 $w=1.3e-08 $l=1.8e-08 $layer=M1 $thickness=3.6e-08 $X=0.324
+ $Y=0.054 $X2=0.324 $Y2=0.072
r37 19 38 11.1788 $w=1.38491e-08 $l=5.3e-08 $layer=M1 $thickness=3.6e-08
+ $X=0.324 $Y=0.036 $X2=0.271 $Y2=0.036
r38 19 27 3.01711 $w=1.55e-08 $l=1.8e-08 $layer=M1 $thickness=3.6e-08 $X=0.324
+ $Y=0.036 $X2=0.324 $Y2=0.054
r39 19 29 8.26388 $w=1.41111e-08 $l=4.05e-08 $layer=M1 $thickness=3.6e-08
+ $X=0.324 $Y=0.036 $X2=0.3645 $Y2=0.036
r40 25 38 10.4935 $w=1.3e-08 $l=4.5e-08 $layer=M1 $thickness=3.6e-08 $X=0.226
+ $Y=0.036 $X2=0.271 $Y2=0.036
r41 17 23 2.5483 $w=1.79e-08 $l=1.8e-08 $layer=M1 $thickness=3.6e-08 $X=0.216
+ $Y=0.036 $X2=0.216 $Y2=0.054
r42 17 25 0.682785 $w=1.75e-08 $l=1e-08 $layer=M1 $thickness=3.6e-08 $X=0.216
+ $Y=0.036 $X2=0.226 $Y2=0.036
r43 23 36 4.19742 $w=1.3e-08 $l=1.8e-08 $layer=M1 $thickness=3.6e-08 $X=0.216
+ $Y=0.054 $X2=0.216 $Y2=0.072
r44 1 36 19.3796 $a=3.24e-16 $layer=V0LISD $X=0.216 $Y=0.0675 $X2=0.216
+ $Y2=0.072
r45 35 33 0.0308642 $w=8.1e-08 $l=2.5e-09 $layer=N_src_drn $thickness=1e-09
+ $X=0.2333 $Y=0.0675 $X2=0.2305 $Y2=0.0675
r46 1 33 0.179012 $w=8.1e-08 $l=1.45e-08 $layer=N_src_drn $thickness=1e-09
+ $X=0.216 $Y=0.0675 $X2=0.2305 $Y2=0.0675
r47 13 1 0.179012 $w=8.1e-08 $l=1.45e-08 $layer=N_src_drn $thickness=1e-09
+ $X=0.2015 $Y=0.0675 $X2=0.216 $Y2=0.0675
r48 34 13 0.0308642 $w=8.1e-08 $l=2.5e-09 $layer=N_src_drn $thickness=1e-09
+ $X=0.1986 $Y=0.0675 $X2=0.2015 $Y2=0.0675
.ends

* End of included file OR2x4_ASAP7_75t_R.pex.sp.pex

*
.subckt OR2x4_ASAP7_75t_CUSTOM_4_25_0_7 VSS VDD B A Y
*
* VSS VSS
* VDD VDD
* B B
* A A
* Y Y
*
*

M0 N_M0_d N_M0_g VSS VSS nmos_rvt L=2e-08 W=5.4e-08 nfin=2 $X=0.071 $Y=0.027
M1 VSS N_M1_g N_M1_s VSS nmos_rvt L=2e-08 W=5.4e-08 nfin=2 $X=0.125 $Y=0.027
M2 N_M2_d N_M2_g VSS VSS nmos_rvt L=2e-08 W=8.1e-08 nfin=3 $X=0.179 $Y=0.027
M3 N_M3_d N_M3_g VSS VSS nmos_rvt L=2e-08 W=8.1e-08 nfin=3 $X=0.233 $Y=0.027
M4 N_M4_d N_M4_g VSS VSS nmos_rvt L=2e-08 W=8.1e-08 nfin=3 $X=0.287 $Y=0.027
M5 N_M5_d N_M5_g VSS VSS nmos_rvt L=2e-08 W=8.1e-08 nfin=3 $X=0.341 $Y=0.027
M6 N_M6_d N_M6_g N_M6_s VDD pmos_rvt L=2e-08 W=8.1e-08 nfin=3 $X=0.071 $Y=0.162
M7 VDD N_M7_g N_M7_s VDD pmos_rvt L=2e-08 W=8.1e-08 nfin=3 $X=0.125 $Y=0.162
M8 N_M8_d N_M8_g VDD VDD pmos_rvt L=2e-08 W=8.1e-08 nfin=3 $X=0.179 $Y=0.162
M9 N_M9_d N_M9_g VDD VDD pmos_rvt L=2e-08 W=8.1e-08 nfin=3 $X=0.233 $Y=0.162
M10 N_M10_d N_M10_g VDD VDD pmos_rvt L=2e-08 W=8.1e-08 nfin=3 $X=0.287 $Y=0.162
M11 N_M11_d N_M11_g VDD VDD pmos_rvt L=2e-08 W=8.1e-08 nfin=3 $X=0.341 $Y=0.162

* .include "OR2x4_ASAP7_75t_R.pex.sp.pxi"

* Start of included file OR2x4_ASAP7_75t_R.pex.sp.pxi
x_PM_OR2x4_ASAP7_75t_R%7 vss N_M6_d N_M7_s N_7_1 PM_OR2x4_ASAP7_75t_R%7
cc_1 N_7_1 N_B_3 0.0168888f $X=0.108 $Y=0.2025
cc_2 N_7_1 N_A_3 0.0169812f $X=0.108 $Y=0.2025
x_PM_OR2x4_ASAP7_75t_R%B vss B N_M0_g N_M6_g N_B_1 N_B_8 N_B_3 N_B_4 N_B_7
+ PM_OR2x4_ASAP7_75t_R%B
x_PM_OR2x4_ASAP7_75t_R%A vss A N_M1_g N_M7_g N_A_1 N_A_3 N_A_4 N_A_5
+ PM_OR2x4_ASAP7_75t_R%A
cc_3 N_A_1 N_B_1 0.00158409f $X=0.135 $Y=0.135
cc_4 A N_B_8 0.00163842f $X=0.137 $Y=0.134
cc_5 N_A_3 N_B_3 0.00907173f $X=0.135 $Y=0.0245
x_PM_OR2x4_ASAP7_75t_R%5 vss N_M4_g N_M10_g N_M3_g N_M9_g N_M2_g N_M8_g N_M5_g
+ N_M11_g N_M0_d N_M1_s N_M6_s N_5_3 N_5_19 N_5_4 N_5_18 N_5_14 N_5_13 N_5_1
+ N_5_16 N_5_20 N_5_21 N_5_9 N_5_15 N_5_17 N_5_11 N_5_12 N_5_22 N_5_10
+ PM_OR2x4_ASAP7_75t_R%5
cc_6 N_5_3 N_B_3 0.00311154f $X=0.054 $Y=0.2025
cc_7 N_5_19 N_B_3 0.000431152f $X=0.1565 $Y=0.036
cc_8 N_5_4 N_B_3 0.000576315f $X=0.108 $Y=0.054
cc_9 N_5_19 N_B_4 0.000790296f $X=0.1565 $Y=0.036
cc_10 N_5_18 N_B_7 0.000833847f $X=0.1565 $Y=0.234
cc_11 N_5_3 N_B_7 0.00151257f $X=0.054 $Y=0.2025
cc_12 N_5_14 N_B_1 0.0022957f $X=0.056 $Y=0.2025
cc_13 N_5_13 N_B_3 0.0105395f $X=0.0935 $Y=0.054
cc_14 N_5_14 N_B_3 0.0506585f $X=0.056 $Y=0.2025
cc_15 N_5_1 N_A_3 0.000421781f $X=0.297 $Y=0.135
cc_16 N_5_3 N_A_3 0.00046997f $X=0.054 $Y=0.2025
cc_17 N_5_16 N_A_3 0.000627652f $X=0.178 $Y=0.135
cc_18 N_5_1 N_A_1 0.000730231f $X=0.297 $Y=0.135
cc_19 N_5_4 N_A_3 0.000812561f $X=0.108 $Y=0.054
cc_20 N_5_20 A 0.00172787f $X=0.178 $Y=0.106
cc_21 N_5_21 A 0.00173937f $X=0.178 $Y=0.164
cc_22 N_5_13 N_A_3 0.0105252f $X=0.0935 $Y=0.054
cc_23 N_5_16 A 0.00404117f $X=0.178 $Y=0.135
cc_24 N_5_19 N_A_4 0.0043845f $X=0.1565 $Y=0.036
cc_25 N_5_18 N_A_5 0.00487149f $X=0.1565 $Y=0.234
cc_26 N_5_9 N_A_3 0.0183931f $X=0.189 $Y=0.135
x_PM_OR2x4_ASAP7_75t_R%Y vss Y N_M2_d N_M3_d N_M4_d N_M5_d N_M10_d N_M11_d
+ N_M8_d N_M9_d N_Y_13 N_Y_23 N_Y_3 N_Y_4 N_Y_17 N_Y_18 N_Y_1 N_Y_2 N_Y_24
+ N_Y_16 N_Y_15 N_Y_14 PM_OR2x4_ASAP7_75t_R%Y
cc_27 N_Y_13 N_5_1 0.00160792f $X=0.2015 $Y=0.0675
cc_28 N_Y_13 N_5_15 0.000325311f $X=0.2015 $Y=0.0675
cc_29 N_Y_13 N_5_17 0.000337218f $X=0.2015 $Y=0.0675
cc_30 N_Y_13 N_5_20 0.000674012f $X=0.2015 $Y=0.0675
cc_31 N_Y_13 N_5_21 0.000674012f $X=0.2015 $Y=0.0675
cc_32 N_Y_13 N_5_11 0.00083919f $X=0.2015 $Y=0.0675
cc_33 N_Y_13 N_5_12 0.000839266f $X=0.2015 $Y=0.0675
cc_34 N_Y_23 N_5_22 0.0010734f $X=0.216 $Y=0.054
cc_35 N_Y_3 N_5_11 0.00145415f $X=0.324 $Y=0.0675
cc_36 N_Y_4 N_5_11 0.00145415f $X=0.324 $Y=0.2025
cc_37 N_Y_17 N_5_15 0.00145672f $X=0.216 $Y=0.036
cc_38 N_Y_18 N_5_17 0.00145686f $X=0.216 $Y=0.234
cc_39 N_Y_1 N_5_9 0.00190426f $X=0.216 $Y=0.0675
cc_40 N_Y_2 N_5_9 0.00192237f $X=0.216 $Y=0.2025
cc_41 N_Y_24 N_5_21 0.0036333f $X=0.216 $Y=0.1865
cc_42 N_Y_23 N_5_20 0.00365323f $X=0.216 $Y=0.054
cc_43 N_Y_16 N_5_1 0.0101169f $X=0.3095 $Y=0.2025
cc_44 N_Y_16 N_5_12 0.0283811f $X=0.3095 $Y=0.2025
cc_45 N_Y_15 N_5_9 0.0180822f $X=0.2015 $Y=0.2025
cc_46 N_Y_14 N_5_12 0.0543375f $X=0.3095 $Y=0.0675
cc_47 N_Y_15 N_5_10 0.0462218f $X=0.2015 $Y=0.2025
cc_48 N_Y_14 N_5_11 0.0465593f $X=0.3095 $Y=0.0675
cc_49 N_Y_13 N_5_9 0.0675181f $X=0.2015 $Y=0.0675

* End of included file OR2x4_ASAP7_75t_R.pex.sp.pxi
.ends

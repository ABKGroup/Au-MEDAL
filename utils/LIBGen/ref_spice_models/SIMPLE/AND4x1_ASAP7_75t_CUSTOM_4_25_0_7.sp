.subckt PM_AND4x1_ASAP7_75t_R%9 vss 2 3 1
c1 1 vss 0.000725509f $X=0.108 $Y=0.0675
r1 2 1 0.209877 $w=8.1e-08 $l=1.7e-08 $layer=N_src_drn $thickness=1e-09
+ $X=0.0906 $Y=0.0675 $X2=0.108 $Y2=0.0675
r2 3 1 0.209877 $w=8.1e-08 $l=1.7e-08 $layer=N_src_drn $thickness=1e-09
+ $X=0.1253 $Y=0.0675 $X2=0.108 $Y2=0.0675
.ends

.subckt PM_AND4x1_ASAP7_75t_R%11 vss 2 3 1
c1 1 vss 0.00077965f $X=0.216 $Y=0.0675
r1 2 1 0.209877 $w=8.1e-08 $l=1.7e-08 $layer=N_src_drn $thickness=1e-09
+ $X=0.1986 $Y=0.0675 $X2=0.216 $Y2=0.0675
r2 3 1 0.209877 $w=8.1e-08 $l=1.7e-08 $layer=N_src_drn $thickness=1e-09
+ $X=0.2333 $Y=0.0675 $X2=0.216 $Y2=0.0675
.ends

.subckt PM_AND4x1_ASAP7_75t_R%10 vss 2 3 1
c1 1 vss 0.000683146f $X=0.162 $Y=0.0675
r1 2 1 0.209877 $w=8.1e-08 $l=1.7e-08 $layer=N_src_drn $thickness=1e-09
+ $X=0.1446 $Y=0.0675 $X2=0.162 $Y2=0.0675
r2 3 1 0.209877 $w=8.1e-08 $l=1.7e-08 $layer=N_src_drn $thickness=1e-09
+ $X=0.1793 $Y=0.0675 $X2=0.162 $Y2=0.0675
.ends

.subckt PM_AND4x1_ASAP7_75t_R%A vss 15 5 11 4 3 1
c1 1 vss 0.00279111f $X=0.081 $Y=0.135
c2 3 vss 0.0533013f $X=0.081 $Y=0.0245
c3 4 vss 0.0069067f $X=0.081 $Y=0.098
r1 15 4 8.62802 $w=1.3e-08 $l=3.7e-08 $layer=M1 $thickness=3.6e-08 $X=0.081
+ $Y=0.138 $X2=0.081 $Y2=0.098
r2 1 8 7.07951 $w=1.89474e-08 $layer=LIG $thickness=5.17895e-08 $X=0.081
+ $Y=0.135 $X2=0.081 $Y2=0.135
r3 15 1 19.3796 $a=3.24e-16 $layer=V0LIG $X=0.081 $Y=0.138 $X2=0.081 $Y2=0.135
r4 11 10 14.6259 $w=2.1e-08 $l=4.3e-08 $layer=Gate_1 $thickness=5.6e-08
+ $X=0.081 $Y=0.2025 $X2=0.081 $Y2=0.1595
r5 9 10 3.06124 $w=2.1e-08 $l=9e-09 $layer=Gate_1 $thickness=5.6e-08 $X=0.081
+ $Y=0.1505 $X2=0.081 $Y2=0.1595
r6 8 9 5.4252 $w=2.04194e-08 $l=1.55e-08 $layer=Gate_1 $thickness=5.6e-08
+ $X=0.081 $Y=0.135 $X2=0.081 $Y2=0.1505
r7 7 8 5.4252 $w=2.04194e-08 $l=1.55e-08 $layer=Gate_1 $thickness=5.6e-08
+ $X=0.081 $Y=0.1195 $X2=0.081 $Y2=0.135
r8 6 7 3.06124 $w=2.1e-08 $l=9e-09 $layer=Gate_1 $thickness=5.6e-08 $X=0.081
+ $Y=0.1105 $X2=0.081 $Y2=0.1195
r9 5 6 14.6259 $w=2.1e-08 $l=4.3e-08 $layer=Gate_1 $thickness=5.6e-08 $X=0.081
+ $Y=0.0675 $X2=0.081 $Y2=0.1105
r10 5 3 14.6259 $w=2.1e-08 $l=4.3e-08 $layer=Gate_1 $thickness=5.6e-08 $X=0.081
+ $Y=0.0675 $X2=0.081 $Y2=0.0245
.ends

.subckt PM_AND4x1_ASAP7_75t_R%B vss 13 5 9 1 3 4
c1 1 vss 0.00294715f $X=0.135 $Y=0.135
c2 3 vss 0.0473825f $X=0.135 $Y=0.0245
c3 4 vss 0.0113166f $X=0.135 $Y=0.098
r1 13 4 8.62802 $w=1.3e-08 $l=3.7e-08 $layer=M1 $thickness=3.6e-08 $X=0.135
+ $Y=0.138 $X2=0.135 $Y2=0.098
r2 1 7 6.74717 $w=2e-08 $layer=Gate_1 $thickness=5.2e-08 $X=0.135 $Y=0.135
+ $X2=0.135 $Y2=0.135
r3 13 1 19.3796 $a=3.24e-16 $layer=V0LIG $X=0.135 $Y=0.138 $X2=0.135 $Y2=0.135
r4 9 8 16.6668 $w=2.1e-08 $l=4.9e-08 $layer=Gate_1 $thickness=5.6e-08 $X=0.135
+ $Y=0.2025 $X2=0.135 $Y2=0.1535
r5 7 8 6.46262 $w=2.04595e-08 $l=1.85e-08 $layer=Gate_1 $thickness=5.6e-08
+ $X=0.135 $Y=0.135 $X2=0.135 $Y2=0.1535
r6 6 7 6.46262 $w=2.04595e-08 $l=1.85e-08 $layer=Gate_1 $thickness=5.6e-08
+ $X=0.135 $Y=0.1165 $X2=0.135 $Y2=0.135
r7 5 6 16.6668 $w=2.1e-08 $l=4.9e-08 $layer=Gate_1 $thickness=5.6e-08 $X=0.135
+ $Y=0.0675 $X2=0.135 $Y2=0.1165
r8 5 3 14.6259 $w=2.1e-08 $l=4.3e-08 $layer=Gate_1 $thickness=5.6e-08 $X=0.135
+ $Y=0.0675 $X2=0.135 $Y2=0.0245
.ends

.subckt PM_AND4x1_ASAP7_75t_R%Y vss 18 14 27 8 11 12 7
c1 1 vss 0.00987101f $X=0.324 $Y=0.0675
c2 2 vss 0.00829406f $X=0.324 $Y=0.2025
c3 7 vss 0.0384545f $X=0.3095 $Y=0.0675
c4 8 vss 0.0384323f $X=0.3095 $Y=0.2025
c5 9 vss 0.00645167f $X=0.3125 $Y=0.036
c6 10 vss 0.00279993f $X=0.351 $Y=0.234
c7 11 vss 0.00430657f $X=0.3125 $Y=0.234
c8 12 vss 0.00567876f $X=0.351 $Y=0.0795
r1 8 2 0.154321 $w=8.1e-08 $l=1.25e-08 $layer=P_src_drn $thickness=1e-09
+ $X=0.3095 $Y=0.2025 $X2=0.324 $Y2=0.2025
r2 27 8 0.0308642 $w=8.1e-08 $l=2.5e-09 $layer=P_src_drn $thickness=1e-09
+ $X=0.3066 $Y=0.2025 $X2=0.3095 $Y2=0.2025
r3 2 22 19.3796 $a=3.24e-16 $layer=V0LISD $X=0.324 $Y=0.2025 $X2=0.324 $Y2=0.234
r4 22 23 3.14806 $w=1.3e-08 $l=1.35e-08 $layer=M1 $thickness=3.6e-08 $X=0.324
+ $Y=0.234 $X2=0.3375 $Y2=0.234
r5 11 22 2.68168 $w=1.3e-08 $l=1.15e-08 $layer=M1 $thickness=3.6e-08 $X=0.3125
+ $Y=0.234 $X2=0.324 $Y2=0.234
r6 10 21 2.5483 $w=1.79e-08 $l=1.8e-08 $layer=M1 $thickness=3.6e-08 $X=0.351
+ $Y=0.234 $X2=0.351 $Y2=0.216
r7 10 23 1.49895 $w=1.63333e-08 $l=1.35e-08 $layer=M1 $thickness=3.6e-08
+ $X=0.351 $Y=0.234 $X2=0.3375 $Y2=0.234
r8 20 21 12.2425 $w=1.3e-08 $l=5.25e-08 $layer=M1 $thickness=3.6e-08 $X=0.351
+ $Y=0.1635 $X2=0.351 $Y2=0.216
r9 19 20 10.7267 $w=1.3e-08 $l=4.6e-08 $layer=M1 $thickness=3.6e-08 $X=0.351
+ $Y=0.1175 $X2=0.351 $Y2=0.1635
r10 18 19 0.699569 $w=1.3e-08 $l=3e-09 $layer=M1 $thickness=3.6e-08 $X=0.3515
+ $Y=0.1145 $X2=0.351 $Y2=0.1175
r11 18 12 8.16164 $w=1.3e-08 $l=3.5e-08 $layer=M1 $thickness=3.6e-08 $X=0.3515
+ $Y=0.1145 $X2=0.351 $Y2=0.0795
r12 12 17 8.96345 $w=1.40345e-08 $l=4.35e-08 $layer=M1 $thickness=3.6e-08
+ $X=0.351 $Y=0.0795 $X2=0.351 $Y2=0.036
r13 16 17 1.96775 $w=1.63333e-08 $l=1.35e-08 $layer=M1 $thickness=3.6e-08
+ $X=0.3375 $Y=0.036 $X2=0.351 $Y2=0.036
r14 15 16 3.14806 $w=1.3e-08 $l=1.35e-08 $layer=M1 $thickness=3.6e-08 $X=0.324
+ $Y=0.036 $X2=0.3375 $Y2=0.036
r15 9 15 2.68168 $w=1.3e-08 $l=1.15e-08 $layer=M1 $thickness=3.6e-08 $X=0.3125
+ $Y=0.036 $X2=0.324 $Y2=0.036
r16 1 15 19.3796 $a=3.24e-16 $layer=V0LISD $X=0.324 $Y=0.0675 $X2=0.324
+ $Y2=0.036
r17 7 1 0.154321 $w=8.1e-08 $l=1.25e-08 $layer=N_src_drn $thickness=1e-09
+ $X=0.3095 $Y=0.0675 $X2=0.324 $Y2=0.0675
r18 14 7 0.0308642 $w=8.1e-08 $l=2.5e-09 $layer=N_src_drn $thickness=1e-09
+ $X=0.3066 $Y=0.0675 $X2=0.3095 $Y2=0.0675
.ends

.subckt PM_AND4x1_ASAP7_75t_R%7 vss 27 33 55 56 59 60 67 22 3 23 4 14 13 21 18
+ 15 5 1 12 26 19 25 20
c1 1 vss 0.00359838f $X=0.2875 $Y=0.135
c2 3 vss 0.00663253f $X=0.054 $Y=0.0675
c3 4 vss 0.00871839f $X=0.108 $Y=0.2025
c4 5 vss 0.00852233f $X=0.216 $Y=0.2025
c5 12 vss 0.080947f $X=0.297 $Y=0.0245
c6 13 vss 0.0377222f $X=0.056 $Y=0.0675
c7 14 vss 0.00520448f $X=0.0935 $Y=0.2025
c8 15 vss 0.00492811f $X=0.2015 $Y=0.2025
c9 16 vss 0.0028792f $X=0.027 $Y=0.036
c10 17 vss 0.00315323f $X=0.027 $Y=0.234
c11 18 vss 0.000476323f $X=0.243 $Y=0.1945
c12 19 vss 0.00272178f $X=0.243 $Y=0.234
c13 20 vss 0.00085961f $X=0.297 $Y=0.198
c14 21 vss 0.00726549f $X=0.027 $Y=0.2125
c15 22 vss 0.00470866f $X=0.0405 $Y=0.036
c16 23 vss 0.0172437f $X=0.2025 $Y=0.234
c17 24 vss 0.000611228f $X=0.243 $Y=0.216
c18 25 vss 0.00137787f $X=0.27 $Y=0.198
c19 26 vss 0.00141153f $X=0.297 $Y=0.123
r1 67 66 0.0308642 $w=8.1e-08 $l=2.5e-09 $layer=N_src_drn $thickness=1e-09
+ $X=0.0713 $Y=0.0675 $X2=0.0685 $Y2=0.0675
r2 13 66 0.154321 $w=8.1e-08 $l=1.25e-08 $layer=N_src_drn $thickness=1e-09
+ $X=0.056 $Y=0.0675 $X2=0.0685 $Y2=0.0675
r3 3 63 19.3796 $a=3.24e-16 $layer=V0LISD $X=0.054 $Y=0.0675 $X2=0.054 $Y2=0.036
r4 22 63 3.14806 $w=1.3e-08 $l=1.35e-08 $layer=M1 $thickness=3.6e-08 $X=0.0405
+ $Y=0.036 $X2=0.054 $Y2=0.036
r5 16 62 3.36447 $w=1.71023e-08 $l=2.15e-08 $layer=M1 $thickness=3.6e-08
+ $X=0.027 $Y=0.036 $X2=0.027 $Y2=0.0575
r6 16 22 1.49895 $w=1.63333e-08 $l=1.35e-08 $layer=M1 $thickness=3.6e-08
+ $X=0.027 $Y=0.036 $X2=0.0405 $Y2=0.036
r7 61 62 18.0722 $w=1.3e-08 $l=7.75e-08 $layer=M1 $thickness=3.6e-08 $X=0.027
+ $Y=0.135 $X2=0.027 $Y2=0.0575
r8 21 61 18.0722 $w=1.3e-08 $l=7.75e-08 $layer=M1 $thickness=3.6e-08 $X=0.027
+ $Y=0.2125 $X2=0.027 $Y2=0.135
r9 60 58 0.0308642 $w=8.1e-08 $l=2.5e-09 $layer=P_src_drn $thickness=1e-09
+ $X=0.1253 $Y=0.2025 $X2=0.1225 $Y2=0.2025
r10 4 58 0.179012 $w=8.1e-08 $l=1.45e-08 $layer=P_src_drn $thickness=1e-09
+ $X=0.108 $Y=0.2025 $X2=0.1225 $Y2=0.2025
r11 14 4 0.179012 $w=8.1e-08 $l=1.45e-08 $layer=P_src_drn $thickness=1e-09
+ $X=0.0935 $Y=0.2025 $X2=0.108 $Y2=0.2025
r12 59 14 0.0308642 $w=8.1e-08 $l=2.5e-09 $layer=P_src_drn $thickness=1e-09
+ $X=0.0906 $Y=0.2025 $X2=0.0935 $Y2=0.2025
r13 56 54 0.0308642 $w=8.1e-08 $l=2.5e-09 $layer=P_src_drn $thickness=1e-09
+ $X=0.2333 $Y=0.2025 $X2=0.2305 $Y2=0.2025
r14 5 54 0.179012 $w=8.1e-08 $l=1.45e-08 $layer=P_src_drn $thickness=1e-09
+ $X=0.216 $Y=0.2025 $X2=0.2305 $Y2=0.2025
r15 15 5 0.179012 $w=8.1e-08 $l=1.45e-08 $layer=P_src_drn $thickness=1e-09
+ $X=0.2015 $Y=0.2025 $X2=0.216 $Y2=0.2025
r16 55 15 0.0308642 $w=8.1e-08 $l=2.5e-09 $layer=P_src_drn $thickness=1e-09
+ $X=0.1986 $Y=0.2025 $X2=0.2015 $Y2=0.2025
r17 17 52 4.64701 $w=1.46667e-08 $l=2.7e-08 $layer=M1 $thickness=3.6e-08
+ $X=0.027 $Y=0.234 $X2=0.054 $Y2=0.234
r18 17 21 3.36447 $w=1.71023e-08 $l=2.15e-08 $layer=M1 $thickness=3.6e-08
+ $X=0.027 $Y=0.234 $X2=0.027 $Y2=0.2125
r19 4 49 19.3796 $a=3.24e-16 $layer=V0LISD $X=0.108 $Y=0.2025 $X2=0.108
+ $Y2=0.234
r20 5 43 19.3796 $a=3.24e-16 $layer=V0LISD $X=0.216 $Y=0.2025 $X2=0.216
+ $Y2=0.234
r21 51 52 6.29612 $w=1.3e-08 $l=2.7e-08 $layer=M1 $thickness=3.6e-08 $X=0.081
+ $Y=0.234 $X2=0.054 $Y2=0.234
r22 49 50 3.14806 $w=1.3e-08 $l=1.35e-08 $layer=M1 $thickness=3.6e-08 $X=0.108
+ $Y=0.234 $X2=0.1215 $Y2=0.234
r23 48 49 3.14806 $w=1.3e-08 $l=1.35e-08 $layer=M1 $thickness=3.6e-08 $X=0.0945
+ $Y=0.234 $X2=0.108 $Y2=0.234
r24 48 51 3.14806 $w=1.3e-08 $l=1.35e-08 $layer=M1 $thickness=3.6e-08 $X=0.0945
+ $Y=0.234 $X2=0.081 $Y2=0.234
r25 47 50 3.14806 $w=1.3e-08 $l=1.35e-08 $layer=M1 $thickness=3.6e-08 $X=0.135
+ $Y=0.234 $X2=0.1215 $Y2=0.234
r26 46 47 6.29612 $w=1.3e-08 $l=2.7e-08 $layer=M1 $thickness=3.6e-08 $X=0.162
+ $Y=0.234 $X2=0.135 $Y2=0.234
r27 45 46 6.29612 $w=1.3e-08 $l=2.7e-08 $layer=M1 $thickness=3.6e-08 $X=0.189
+ $Y=0.234 $X2=0.162 $Y2=0.234
r28 43 44 3.14806 $w=1.3e-08 $l=1.35e-08 $layer=M1 $thickness=3.6e-08 $X=0.216
+ $Y=0.234 $X2=0.2295 $Y2=0.234
r29 23 43 3.14806 $w=1.3e-08 $l=1.35e-08 $layer=M1 $thickness=3.6e-08 $X=0.2025
+ $Y=0.234 $X2=0.216 $Y2=0.234
r30 23 45 3.14806 $w=1.3e-08 $l=1.35e-08 $layer=M1 $thickness=3.6e-08 $X=0.2025
+ $Y=0.234 $X2=0.189 $Y2=0.234
r31 19 24 2.5483 $w=1.79e-08 $l=1.8e-08 $layer=M1 $thickness=3.6e-08 $X=0.243
+ $Y=0.234 $X2=0.243 $Y2=0.216
r32 19 44 1.49895 $w=1.63333e-08 $l=1.35e-08 $layer=M1 $thickness=3.6e-08
+ $X=0.243 $Y=0.234 $X2=0.2295 $Y2=0.234
r33 24 42 2.45586 $w=1.44e-08 $l=1.25e-08 $layer=M1 $thickness=3.6e-08 $X=0.243
+ $Y=0.216 $X2=0.243 $Y2=0.2035
r34 18 42 0.9184 $w=1.8e-08 $l=9e-09 $layer=M1 $thickness=3.6e-08 $X=0.243
+ $Y=0.1945 $X2=0.243 $Y2=0.2035
r35 25 42 4.55457 $w=1.3814e-08 $l=2.75545e-08 $layer=M1 $thickness=3.6e-08
+ $X=0.27 $Y=0.198 $X2=0.243 $Y2=0.2035
r36 20 41 3.36447 $w=1.71023e-08 $l=2.15e-08 $layer=M1 $thickness=3.6e-08
+ $X=0.297 $Y=0.198 $X2=0.297 $Y2=0.1765
r37 20 25 4.64701 $w=1.46667e-08 $l=2.7e-08 $layer=M1 $thickness=3.6e-08
+ $X=0.297 $Y=0.198 $X2=0.27 $Y2=0.198
r38 40 41 5.24677 $w=1.3e-08 $l=2.25e-08 $layer=M1 $thickness=3.6e-08 $X=0.297
+ $Y=0.154 $X2=0.297 $Y2=0.1765
r39 39 40 4.43061 $w=1.3e-08 $l=1.9e-08 $layer=M1 $thickness=3.6e-08 $X=0.297
+ $Y=0.135 $X2=0.297 $Y2=0.154
r40 26 39 2.79828 $w=1.3e-08 $l=1.2e-08 $layer=M1 $thickness=3.6e-08 $X=0.297
+ $Y=0.123 $X2=0.297 $Y2=0.135
r41 35 36 3.67195 $w=1.8e-08 $l=9.5e-09 $layer=LIG $thickness=4.8e-08 $X=0.297
+ $Y=0.135 $X2=0.3065 $Y2=0.135
r42 35 39 19.3796 $a=3.24e-16 $layer=V0LIG $X=0.297 $Y=0.135 $X2=0.297 $Y2=0.135
r43 1 35 3.67195 $w=1.8e-08 $l=9.5e-09 $layer=LIG $thickness=4.8e-08 $X=0.2875
+ $Y=0.135 $X2=0.297 $Y2=0.135
r44 33 32 14.6259 $w=2.1e-08 $l=4.3e-08 $layer=Gate_1 $thickness=5.6e-08
+ $X=0.297 $Y=0.2025 $X2=0.297 $Y2=0.1595
r45 31 32 3.06124 $w=2.1e-08 $l=9e-09 $layer=Gate_1 $thickness=5.6e-08 $X=0.297
+ $Y=0.1505 $X2=0.297 $Y2=0.1595
r46 30 31 5.4252 $w=2.04194e-08 $l=1.55e-08 $layer=Gate_1 $thickness=5.6e-08
+ $X=0.297 $Y=0.135 $X2=0.297 $Y2=0.1505
r47 30 36 3.40757 $w=1.98947e-08 $l=9.5e-09 $layer=Gate_1
+ $thickness=5.55789e-08 $X=0.297 $Y=0.135 $X2=0.3065 $Y2=0.135
r48 30 35 6.69299 $w=1.9e-08 $layer=LIG $thickness=5.2e-08 $X=0.297 $Y=0.135
+ $X2=0.297 $Y2=0.135
r49 29 30 5.4252 $w=2.04194e-08 $l=1.55e-08 $layer=Gate_1 $thickness=5.6e-08
+ $X=0.297 $Y=0.1195 $X2=0.297 $Y2=0.135
r50 28 29 3.06124 $w=2.1e-08 $l=9e-09 $layer=Gate_1 $thickness=5.6e-08 $X=0.297
+ $Y=0.1105 $X2=0.297 $Y2=0.1195
r51 27 28 14.6259 $w=2.1e-08 $l=4.3e-08 $layer=Gate_1 $thickness=5.6e-08
+ $X=0.297 $Y=0.0675 $X2=0.297 $Y2=0.1105
r52 27 12 14.6259 $w=2.1e-08 $l=4.3e-08 $layer=Gate_1 $thickness=5.6e-08
+ $X=0.297 $Y=0.0675 $X2=0.297 $Y2=0.0245
r53 3 13 1e-05 $l=2e-09 $X=0.054 $Y=0.0675 $X2=0.056 $Y2=0.0675
.ends

.subckt PM_AND4x1_ASAP7_75t_R%C vss 13 5 9 1 3 4
c1 1 vss 0.00288395f $X=0.189 $Y=0.135
c2 3 vss 0.0475404f $X=0.189 $Y=0.0245
c3 4 vss 0.0119479f $X=0.189 $Y=0.08
r1 13 4 12.8254 $w=1.3e-08 $l=5.5e-08 $layer=M1 $thickness=3.6e-08 $X=0.189
+ $Y=0.138 $X2=0.189 $Y2=0.08
r2 1 7 7.07951 $w=1.89474e-08 $layer=LIG $thickness=5.17895e-08 $X=0.189
+ $Y=0.135 $X2=0.189 $Y2=0.135
r3 13 1 19.3796 $a=3.24e-16 $layer=V0LIG $X=0.189 $Y=0.138 $X2=0.189 $Y2=0.135
r4 9 8 16.8368 $w=2.1e-08 $l=4.95e-08 $layer=Gate_1 $thickness=5.6e-08 $X=0.189
+ $Y=0.2025 $X2=0.189 $Y2=0.153
r5 7 8 6.27555 $w=2.05e-08 $l=1.8e-08 $layer=Gate_1 $thickness=5.6e-08 $X=0.189
+ $Y=0.135 $X2=0.189 $Y2=0.153
r6 6 7 6.27555 $w=2.05e-08 $l=1.8e-08 $layer=Gate_1 $thickness=5.6e-08 $X=0.189
+ $Y=0.117 $X2=0.189 $Y2=0.135
r7 5 6 16.8368 $w=2.1e-08 $l=4.95e-08 $layer=Gate_1 $thickness=5.6e-08 $X=0.189
+ $Y=0.0675 $X2=0.189 $Y2=0.117
r8 5 3 14.6259 $w=2.1e-08 $l=4.3e-08 $layer=Gate_1 $thickness=5.6e-08 $X=0.189
+ $Y=0.0675 $X2=0.189 $Y2=0.0245
.ends

.subckt PM_AND4x1_ASAP7_75t_R%D vss 15 5 9 4 3 1
c1 1 vss 0.00422116f $X=0.243 $Y=0.135
c2 3 vss 0.085432f $X=0.243 $Y=0.0245
c3 4 vss 0.0123604f $X=0.243 $Y=0.0825
r1 15 14 2.79828 $w=1.3e-08 $l=1.2e-08 $layer=M1 $thickness=3.6e-08 $X=0.243
+ $Y=0.138 $X2=0.243 $Y2=0.123
r2 4 14 9.44419 $w=1.3e-08 $l=4.05e-08 $layer=M1 $thickness=3.6e-08 $X=0.243
+ $Y=0.0825 $X2=0.243 $Y2=0.123
r3 1 7 7.07951 $w=1.89474e-08 $layer=LIG $thickness=5.17895e-08 $X=0.243
+ $Y=0.135 $X2=0.243 $Y2=0.135
r4 15 1 19.3796 $a=3.24e-16 $layer=V0LIG $X=0.243 $Y=0.138 $X2=0.243 $Y2=0.135
r5 9 8 16.8368 $w=2.1e-08 $l=4.95e-08 $layer=Gate_1 $thickness=5.6e-08 $X=0.243
+ $Y=0.2025 $X2=0.243 $Y2=0.153
r6 7 8 6.27555 $w=2.05e-08 $l=1.8e-08 $layer=Gate_1 $thickness=5.6e-08 $X=0.243
+ $Y=0.135 $X2=0.243 $Y2=0.153
r7 6 7 6.27555 $w=2.05e-08 $l=1.8e-08 $layer=Gate_1 $thickness=5.6e-08 $X=0.243
+ $Y=0.117 $X2=0.243 $Y2=0.135
r8 5 6 16.8368 $w=2.1e-08 $l=4.95e-08 $layer=Gate_1 $thickness=5.6e-08 $X=0.243
+ $Y=0.0675 $X2=0.243 $Y2=0.117
r9 5 3 14.6259 $w=2.1e-08 $l=4.3e-08 $layer=Gate_1 $thickness=5.6e-08 $X=0.243
+ $Y=0.0675 $X2=0.243 $Y2=0.0245
.ends

* End of included file AND4x1_ASAP7_75t_R.pex.sp.pex

*
.subckt AND4x1_ASAP7_75t_CUSTOM_4_25_0_7 VSS VDD A B C D Y
*
* VSS VSS
* VDD VDD
* A A
* B B
* C C
* D D
* Y Y
*
*

M0 N_M0_d N_M0_g N_M0_s VSS nmos_rvt L=2e-08 W=8.1e-08 nfin=3 $X=0.071 $Y=0.027
M1 N_M1_d N_M1_g N_M1_s VSS nmos_rvt L=2e-08 W=8.1e-08 nfin=3 $X=0.125 $Y=0.027
M2 N_M2_d N_M2_g N_M2_s VSS nmos_rvt L=2e-08 W=8.1e-08 nfin=3 $X=0.179 $Y=0.027
M3 VSS N_M3_g N_M3_s VSS nmos_rvt L=2e-08 W=8.1e-08 nfin=3 $X=0.233 $Y=0.027
M4 N_M4_d N_M4_g VSS VSS nmos_rvt L=2e-08 W=8.1e-08 nfin=3 $X=0.287 $Y=0.027
M5 N_M5_d N_M5_g VDD VDD pmos_rvt L=2e-08 W=8.1e-08 nfin=3 $X=0.071 $Y=0.162
M6 VDD N_M6_g N_M6_s VDD pmos_rvt L=2e-08 W=8.1e-08 nfin=3 $X=0.125 $Y=0.162
M7 N_M7_d N_M7_g VDD VDD pmos_rvt L=2e-08 W=8.1e-08 nfin=3 $X=0.179 $Y=0.162
M8 VDD N_M8_g N_M8_s VDD pmos_rvt L=2e-08 W=8.1e-08 nfin=3 $X=0.233 $Y=0.162
M9 N_M9_d N_M9_g VDD VDD pmos_rvt L=2e-08 W=8.1e-08 nfin=3 $X=0.287 $Y=0.162

* .include "AND4x1_ASAP7_75t_R.pex.sp.pxi"

* Start of included file AND4x1_ASAP7_75t_R.pex.sp.pxi
x_PM_AND4x1_ASAP7_75t_R%9 vss N_M0_d N_M1_s N_9_1 PM_AND4x1_ASAP7_75t_R%9
cc_1 N_9_1 N_A_3 0.0168127f $X=0.108 $Y=0.0675
cc_2 N_9_1 N_B_3 0.0169338f $X=0.108 $Y=0.0675
x_PM_AND4x1_ASAP7_75t_R%11 vss N_M2_d N_M3_s N_11_1 PM_AND4x1_ASAP7_75t_R%11
cc_3 N_11_1 N_C_3 0.0169207f $X=0.216 $Y=0.0675
cc_4 N_11_1 N_D_3 0.0167749f $X=0.216 $Y=0.0675
x_PM_AND4x1_ASAP7_75t_R%10 vss N_M1_d N_M2_s N_10_1 PM_AND4x1_ASAP7_75t_R%10
cc_5 N_10_1 N_B_3 0.0168846f $X=0.162 $Y=0.0675
cc_6 N_10_1 N_C_3 0.0169068f $X=0.162 $Y=0.0675
x_PM_AND4x1_ASAP7_75t_R%A vss A N_M0_g N_M5_g N_A_4 N_A_3 N_A_1
+ PM_AND4x1_ASAP7_75t_R%A
x_PM_AND4x1_ASAP7_75t_R%B vss B N_M1_g N_M6_g N_B_1 N_B_3 N_B_4
+ PM_AND4x1_ASAP7_75t_R%B
cc_7 N_B_1 N_A_4 0.00123829f $X=0.135 $Y=0.135
cc_8 N_B_3 N_A_3 0.00504614f $X=0.135 $Y=0.0245
cc_9 N_B_4 N_A_4 0.00589237f $X=0.135 $Y=0.098
x_PM_AND4x1_ASAP7_75t_R%Y vss Y N_M4_d N_M9_d N_Y_8 N_Y_11 N_Y_12 N_Y_7
+ PM_AND4x1_ASAP7_75t_R%Y
cc_10 N_Y_8 N_7_19 0.000365041f $X=0.3095 $Y=0.2025
cc_11 N_Y_8 N_7_25 0.000427087f $X=0.3095 $Y=0.2025
cc_12 N_Y_8 N_7_1 0.0025658f $X=0.3095 $Y=0.2025
cc_13 N_Y_11 N_7_20 0.00239227f $X=0.3125 $Y=0.234
cc_14 N_Y_12 N_7_26 0.00426053f $X=0.351 $Y=0.0795
cc_15 N_Y_7 N_7_12 0.0148622f $X=0.3095 $Y=0.0675
cc_16 N_Y_8 N_7_12 0.0571282f $X=0.3095 $Y=0.2025
x_PM_AND4x1_ASAP7_75t_R%7 vss N_M4_g N_M9_g N_M7_d N_M8_s N_M5_d N_M6_s N_M0_s
+ N_7_22 N_7_3 N_7_23 N_7_4 N_7_14 N_7_13 N_7_21 N_7_18 N_7_15 N_7_5 N_7_1
+ N_7_12 N_7_26 N_7_19 N_7_25 N_7_20 PM_AND4x1_ASAP7_75t_R%7
cc_17 N_7_22 N_A_3 0.000672274f $X=0.0405 $Y=0.036
cc_18 N_7_3 N_A_3 0.00239113f $X=0.054 $Y=0.0675
cc_19 N_7_23 N_A_4 0.00103846f $X=0.2025 $Y=0.234
cc_20 N_7_4 N_A_3 0.00112105f $X=0.108 $Y=0.2025
cc_21 N_7_14 N_A_1 0.00162711f $X=0.0935 $Y=0.2025
cc_22 N_7_13 N_A_3 0.0150537f $X=0.056 $Y=0.0675
cc_23 N_7_21 N_A_4 0.00793798f $X=0.027 $Y=0.2125
cc_24 N_7_14 N_A_3 0.0545623f $X=0.0935 $Y=0.2025
cc_25 N_7_4 N_B_3 0.00142677f $X=0.108 $Y=0.2025
cc_26 N_7_22 N_B_4 0.000383103f $X=0.0405 $Y=0.036
cc_27 N_7_14 N_B_1 0.000733835f $X=0.0935 $Y=0.2025
cc_28 N_7_23 N_B_4 0.00112101f $X=0.2025 $Y=0.234
cc_29 N_7_4 N_B_4 0.00257286f $X=0.108 $Y=0.2025
cc_30 N_7_14 N_B_3 0.0354687f $X=0.0935 $Y=0.2025
cc_31 N_7_18 N_C_3 0.000381459f $X=0.243 $Y=0.1945
cc_32 N_7_15 N_C_1 0.000676101f $X=0.2015 $Y=0.2025
cc_33 N_7_23 N_C_4 0.00104339f $X=0.2025 $Y=0.234
cc_34 N_7_5 N_C_3 0.00113066f $X=0.216 $Y=0.2025
cc_35 N_7_5 N_C_4 0.00236413f $X=0.216 $Y=0.2025
cc_36 N_7_15 N_C_3 0.0352617f $X=0.2015 $Y=0.2025
cc_37 N_7_1 N_D_3 0.000526782f $X=0.2875 $Y=0.135
cc_38 N_7_18 N_D_3 0.000528602f $X=0.243 $Y=0.1945
cc_39 N_7_5 N_D_1 0.000662505f $X=0.216 $Y=0.2025
cc_40 N_7_5 N_D_3 0.000814983f $X=0.216 $Y=0.2025
cc_41 N_7_15 N_D_1 0.00121509f $X=0.2015 $Y=0.2025
cc_42 N_7_12 N_D_3 0.0016659f $X=0.297 $Y=0.0245
cc_43 N_7_26 N_D_4 0.00343669f $X=0.297 $Y=0.123
cc_44 N_7_15 N_D_3 0.036673f $X=0.2015 $Y=0.2025
x_PM_AND4x1_ASAP7_75t_R%C vss C N_M2_g N_M7_g N_C_1 N_C_3 N_C_4
+ PM_AND4x1_ASAP7_75t_R%C
cc_45 N_C_1 N_B_1 0.00123721f $X=0.189 $Y=0.135
cc_46 N_C_3 N_B_3 0.00524596f $X=0.189 $Y=0.0245
cc_47 N_C_4 N_B_4 0.00707859f $X=0.189 $Y=0.08
x_PM_AND4x1_ASAP7_75t_R%D vss D N_M3_g N_M8_g N_D_4 N_D_3 N_D_1
+ PM_AND4x1_ASAP7_75t_R%D
cc_48 N_D_4 N_C_1 0.00117835f $X=0.243 $Y=0.0825
cc_49 N_D_3 N_C_3 0.00498949f $X=0.243 $Y=0.0245
cc_50 N_D_4 N_C_4 0.00593043f $X=0.243 $Y=0.0825

* End of included file AND4x1_ASAP7_75t_R.pex.sp.pxi
.ends

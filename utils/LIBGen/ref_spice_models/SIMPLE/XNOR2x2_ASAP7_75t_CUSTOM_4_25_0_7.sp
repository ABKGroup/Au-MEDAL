.subckt PM_XNOR2x2_ASAP7_75t_R%10 vss 2 3 1
c1 1 vss 0.000772994f $X=0.378 $Y=0.2025
r1 2 1 0.209877 $w=8.1e-08 $l=1.7e-08 $layer=P_src_drn $thickness=1e-09
+ $X=0.3606 $Y=0.2025 $X2=0.378 $Y2=0.2025
r2 3 1 0.209877 $w=8.1e-08 $l=1.7e-08 $layer=P_src_drn $thickness=1e-09
+ $X=0.3953 $Y=0.2025 $X2=0.378 $Y2=0.2025
.ends

.subckt PM_XNOR2x2_ASAP7_75t_R%3 vss 18 24 46 49 50 10 16 3 17 1 15 14 9 11 4
+ 13 12
c1 1 vss 0.00380579f $X=0.081 $Y=0.135
c2 3 vss 0.0104378f $X=0.3115 $Y=0.2025
c3 4 vss 0.00653557f $X=0.378 $Y=0.054
c4 9 vss 0.0828637f $X=0.081 $Y=0.0245
c5 10 vss 0.00505326f $X=0.3635 $Y=0.054
c6 11 vss 0.0376707f $X=0.326 $Y=0.2025
c7 12 vss 0.000585656f $X=0.081 $Y=0.072
c8 13 vss 0.00045216f $X=0.311 $Y=0.072
c9 14 vss 0.00190065f $X=0.081 $Y=0.123
c10 15 vss 0.00536104f $X=0.0945 $Y=0.072
c11 16 vss 0.00190871f $X=0.311 $Y=0.094
c12 17 vss 0.00182539f $X=0.331 $Y=0.072
r1 50 48 0.0462963 $w=5.4e-08 $l=2.5e-09 $layer=N_src_drn $thickness=1e-09
+ $X=0.3953 $Y=0.054 $X2=0.3925 $Y2=0.054
r2 4 48 0.268519 $w=5.4e-08 $l=1.45e-08 $layer=N_src_drn $thickness=1e-09
+ $X=0.378 $Y=0.054 $X2=0.3925 $Y2=0.054
r3 10 4 0.268519 $w=5.4e-08 $l=1.45e-08 $layer=N_src_drn $thickness=1e-09
+ $X=0.3635 $Y=0.054 $X2=0.378 $Y2=0.054
r4 49 10 0.0462963 $w=5.4e-08 $l=2.5e-09 $layer=N_src_drn $thickness=1e-09
+ $X=0.3606 $Y=0.054 $X2=0.3635 $Y2=0.054
r5 46 45 0.0308642 $w=8.1e-08 $l=2.5e-09 $layer=P_src_drn $thickness=1e-09
+ $X=0.3413 $Y=0.2025 $X2=0.3385 $Y2=0.2025
r6 11 45 0.154321 $w=8.1e-08 $l=1.25e-08 $layer=P_src_drn $thickness=1e-09
+ $X=0.326 $Y=0.2025 $X2=0.3385 $Y2=0.2025
r7 4 40 19.3796 $a=3.24e-16 $layer=V0LISD $X=0.378 $Y=0.054 $X2=0.3745 $Y2=0.072
r8 3 35 19.3796 $a=3.24e-16 $layer=V0LISD $X=0.3115 $Y=0.2025 $X2=0.311
+ $Y2=0.177
r9 39 40 2.3319 $w=1.3e-08 $l=1e-08 $layer=M1 $thickness=3.6e-08 $X=0.3645
+ $Y=0.072 $X2=0.3745 $Y2=0.072
r10 38 39 3.14806 $w=1.3e-08 $l=1.35e-08 $layer=M1 $thickness=3.6e-08 $X=0.351
+ $Y=0.072 $X2=0.3645 $Y2=0.072
r11 17 38 4.6638 $w=1.3e-08 $l=2e-08 $layer=M1 $thickness=3.6e-08 $X=0.331
+ $Y=0.072 $X2=0.351 $Y2=0.072
r12 34 35 7.34548 $w=1.3e-08 $l=3.15e-08 $layer=M1 $thickness=3.6e-08 $X=0.311
+ $Y=0.1455 $X2=0.311 $Y2=0.177
r13 33 34 7.46207 $w=1.3e-08 $l=3.2e-08 $layer=M1 $thickness=3.6e-08 $X=0.311
+ $Y=0.1135 $X2=0.311 $Y2=0.1455
r14 16 33 4.5472 $w=1.3e-08 $l=1.95e-08 $layer=M1 $thickness=3.6e-08 $X=0.311
+ $Y=0.094 $X2=0.311 $Y2=0.1135
r15 13 32 3.60008 $w=1.51951e-08 $l=2.05e-08 $layer=M1 $thickness=3.6e-08
+ $X=0.311 $Y=0.072 $X2=0.2905 $Y2=0.072
r16 13 16 3.94987 $w=1.50455e-08 $l=2.2e-08 $layer=M1 $thickness=3.6e-08
+ $X=0.311 $Y=0.072 $X2=0.311 $Y2=0.094
r17 13 17 3.48349 $w=1.525e-08 $l=2e-08 $layer=M1 $thickness=3.6e-08 $X=0.311
+ $Y=0.072 $X2=0.331 $Y2=0.072
r18 31 32 18.422 $w=1.3e-08 $l=7.9e-08 $layer=M1 $thickness=3.6e-08 $X=0.2115
+ $Y=0.072 $X2=0.2905 $Y2=0.072
r19 30 31 17.839 $w=1.3e-08 $l=7.65e-08 $layer=M1 $thickness=3.6e-08 $X=0.135
+ $Y=0.072 $X2=0.2115 $Y2=0.072
r20 29 30 5.24677 $w=1.3e-08 $l=2.25e-08 $layer=M1 $thickness=3.6e-08 $X=0.1125
+ $Y=0.072 $X2=0.135 $Y2=0.072
r21 15 29 4.19742 $w=1.3e-08 $l=1.8e-08 $layer=M1 $thickness=3.6e-08 $X=0.0945
+ $Y=0.072 $X2=0.1125 $Y2=0.072
r22 12 28 4.9968 $w=1.60947e-08 $l=2.85e-08 $layer=M1 $thickness=3.6e-08
+ $X=0.081 $Y=0.072 $X2=0.081 $Y2=0.1005
r23 12 15 1.49895 $w=1.63333e-08 $l=1.35e-08 $layer=M1 $thickness=3.6e-08
+ $X=0.081 $Y=0.072 $X2=0.0945 $Y2=0.072
r24 14 26 2.79828 $w=1.3e-08 $l=1.2e-08 $layer=M1 $thickness=3.6e-08 $X=0.081
+ $Y=0.123 $X2=0.081 $Y2=0.135
r25 14 28 5.24677 $w=1.3e-08 $l=2.25e-08 $layer=M1 $thickness=3.6e-08 $X=0.081
+ $Y=0.123 $X2=0.081 $Y2=0.1005
r26 1 21 10.4265 $w=1.765e-08 $layer=LIG $thickness=5.2e-08 $X=0.081 $Y=0.135
+ $X2=0.081 $Y2=0.135
r27 1 26 19.3796 $a=3.24e-16 $layer=V0LIG $X=0.081 $Y=0.135 $X2=0.081 $Y2=0.135
r28 24 23 14.6259 $w=2.1e-08 $l=4.3e-08 $layer=Gate_1 $thickness=5.6e-08
+ $X=0.081 $Y=0.2025 $X2=0.081 $Y2=0.1595
r29 22 23 2.7211 $w=2.1e-08 $l=8e-09 $layer=Gate_1 $thickness=5.6e-08 $X=0.081
+ $Y=0.1515 $X2=0.081 $Y2=0.1595
r30 21 22 5.79936 $w=2.03333e-08 $l=1.65e-08 $layer=Gate_1 $thickness=5.6e-08
+ $X=0.081 $Y=0.135 $X2=0.081 $Y2=0.1515
r31 20 21 5.79936 $w=2.03333e-08 $l=1.65e-08 $layer=Gate_1 $thickness=5.6e-08
+ $X=0.081 $Y=0.1185 $X2=0.081 $Y2=0.135
r32 19 20 2.7211 $w=2.1e-08 $l=8e-09 $layer=Gate_1 $thickness=5.6e-08 $X=0.081
+ $Y=0.1105 $X2=0.081 $Y2=0.1185
r33 18 19 14.6259 $w=2.1e-08 $l=4.3e-08 $layer=Gate_1 $thickness=5.6e-08
+ $X=0.081 $Y=0.0675 $X2=0.081 $Y2=0.1105
r34 18 9 14.6259 $w=2.1e-08 $l=4.3e-08 $layer=Gate_1 $thickness=5.6e-08
+ $X=0.081 $Y=0.0675 $X2=0.081 $Y2=0.0245
r35 3 11 1e-05 $l=1.45e-08 $X=0.3115 $Y=0.2025 $X2=0.326 $Y2=0.2025
.ends

.subckt PM_XNOR2x2_ASAP7_75t_R%Y vss 21 16 17 28 29 12 8 13 1 2 11 7
c1 1 vss 0.00852645f $X=0.486 $Y=0.0675
c2 2 vss 0.00878036f $X=0.486 $Y=0.2025
c3 7 vss 0.00442425f $X=0.4715 $Y=0.0675
c4 8 vss 0.00436683f $X=0.4715 $Y=0.2025
c5 9 vss 0.00289748f $X=0.567 $Y=0.036
c6 10 vss 0.00290499f $X=0.567 $Y=0.234
c7 11 vss 0.0078362f $X=0.4745 $Y=0.036
c8 12 vss 0.0082526f $X=0.5265 $Y=0.234
c9 13 vss 0.00834334f $X=0.567 $Y=0.054
r1 29 27 0.0308642 $w=8.1e-08 $l=2.5e-09 $layer=P_src_drn $thickness=1e-09
+ $X=0.5033 $Y=0.2025 $X2=0.5005 $Y2=0.2025
r2 2 27 0.179012 $w=8.1e-08 $l=1.45e-08 $layer=P_src_drn $thickness=1e-09
+ $X=0.486 $Y=0.2025 $X2=0.5005 $Y2=0.2025
r3 8 2 0.179012 $w=8.1e-08 $l=1.45e-08 $layer=P_src_drn $thickness=1e-09
+ $X=0.4715 $Y=0.2025 $X2=0.486 $Y2=0.2025
r4 28 8 0.0308642 $w=8.1e-08 $l=2.5e-09 $layer=P_src_drn $thickness=1e-09
+ $X=0.4686 $Y=0.2025 $X2=0.4715 $Y2=0.2025
r5 2 24 19.3796 $a=3.24e-16 $layer=V0LISD $X=0.486 $Y=0.2025 $X2=0.486 $Y2=0.234
r6 12 24 9.44419 $w=1.3e-08 $l=4.05e-08 $layer=M1 $thickness=3.6e-08 $X=0.5265
+ $Y=0.234 $X2=0.486 $Y2=0.234
r7 10 23 9.07762 $w=1.49174e-08 $l=4.6e-08 $layer=M1 $thickness=3.6e-08
+ $X=0.567 $Y=0.234 $X2=0.567 $Y2=0.188
r8 10 12 7.79507 $w=1.41111e-08 $l=4.05e-08 $layer=M1 $thickness=3.6e-08
+ $X=0.567 $Y=0.234 $X2=0.5265 $Y2=0.234
r9 22 23 8.97781 $w=1.3e-08 $l=3.85e-08 $layer=M1 $thickness=3.6e-08 $X=0.567
+ $Y=0.1495 $X2=0.567 $Y2=0.188
r10 21 22 0.46638 $w=1.3e-08 $l=2e-09 $layer=M1 $thickness=3.6e-08 $X=0.567
+ $Y=0.1475 $X2=0.567 $Y2=0.1495
r11 21 20 9.91057 $w=1.3e-08 $l=4.25e-08 $layer=M1 $thickness=3.6e-08 $X=0.567
+ $Y=0.1475 $X2=0.567 $Y2=0.105
r12 13 20 11.8927 $w=1.3e-08 $l=5.1e-08 $layer=M1 $thickness=3.6e-08 $X=0.567
+ $Y=0.054 $X2=0.567 $Y2=0.105
r13 9 19 7.79507 $w=1.41111e-08 $l=4.05e-08 $layer=M1 $thickness=3.6e-08
+ $X=0.567 $Y=0.036 $X2=0.5265 $Y2=0.036
r14 9 13 2.5483 $w=1.79e-08 $l=1.8e-08 $layer=M1 $thickness=3.6e-08 $X=0.567
+ $Y=0.036 $X2=0.567 $Y2=0.054
r15 18 19 9.44419 $w=1.3e-08 $l=4.05e-08 $layer=M1 $thickness=3.6e-08 $X=0.486
+ $Y=0.036 $X2=0.5265 $Y2=0.036
r16 11 18 2.68168 $w=1.3e-08 $l=1.15e-08 $layer=M1 $thickness=3.6e-08 $X=0.4745
+ $Y=0.036 $X2=0.486 $Y2=0.036
r17 1 18 19.3796 $a=3.24e-16 $layer=V0LISD $X=0.486 $Y=0.0675 $X2=0.486
+ $Y2=0.036
r18 17 15 0.0308642 $w=8.1e-08 $l=2.5e-09 $layer=N_src_drn $thickness=1e-09
+ $X=0.5033 $Y=0.0675 $X2=0.5005 $Y2=0.0675
r19 1 15 0.179012 $w=8.1e-08 $l=1.45e-08 $layer=N_src_drn $thickness=1e-09
+ $X=0.486 $Y=0.0675 $X2=0.5005 $Y2=0.0675
r20 7 1 0.179012 $w=8.1e-08 $l=1.45e-08 $layer=N_src_drn $thickness=1e-09
+ $X=0.4715 $Y=0.0675 $X2=0.486 $Y2=0.0675
r21 16 7 0.0308642 $w=8.1e-08 $l=2.5e-09 $layer=N_src_drn $thickness=1e-09
+ $X=0.4686 $Y=0.0675 $X2=0.4715 $Y2=0.0675
.ends

.subckt PM_XNOR2x2_ASAP7_75t_R%6 vss 27 31 42 46 58 63 67 23 14 20 5 4 3 22 16
+ 25 18 1 26 12 15 19 21 13
c1 1 vss 0.00749361f $X=0.459 $Y=0.135
c2 3 vss 0.00878047f $X=0.054 $Y=0.0675
c3 4 vss 0.00970149f $X=0.054 $Y=0.2025
c4 5 vss 0.0062073f $X=0.216 $Y=0.054
c5 12 vss 0.115146f $X=0.459 $Y=0.0245
c6 13 vss 0.0846505f $X=0.513 $Y=0.135
c7 14 vss 0.0409218f $X=0.056 $Y=0.0675
c8 15 vss 0.0405466f $X=0.2015 $Y=0.0675
c9 16 vss 0.0409198f $X=0.056 $Y=0.2025
c10 17 vss 0.00331689f $X=0.027 $Y=0.036
c11 18 vss 0.00701877f $X=0.027 $Y=0.234
c12 19 vss 0.00289028f $X=0.432 $Y=0.036
c13 20 vss 0.000905004f $X=0.432 $Y=0.072
c14 21 vss 0.000765085f $X=0.486 $Y=0.072
c15 22 vss 0.0100574f $X=0.027 $Y=0.054
c16 23 vss 0.0364544f $X=0.4075 $Y=0.036
c17 24 vss 0.000651619f $X=0.432 $Y=0.054
c18 25 vss 0.00122341f $X=0.4745 $Y=0.072
c19 26 vss 0.00219626f $X=0.486 $Y=0.135
r1 67 66 0.0308642 $w=8.1e-08 $l=2.5e-09 $layer=P_src_drn $thickness=1e-09
+ $X=0.0713 $Y=0.2025 $X2=0.0685 $Y2=0.2025
r2 16 66 0.154321 $w=8.1e-08 $l=1.25e-08 $layer=P_src_drn $thickness=1e-09
+ $X=0.056 $Y=0.2025 $X2=0.0685 $Y2=0.2025
r3 4 65 19.3796 $a=3.24e-16 $layer=V0LISD $X=0.054 $Y=0.2025 $X2=0.054 $Y2=0.234
r4 64 65 3.14806 $w=1.3e-08 $l=1.35e-08 $layer=M1 $thickness=3.6e-08 $X=0.0405
+ $Y=0.234 $X2=0.054 $Y2=0.234
r5 18 61 3.71668 $w=1.51429e-08 $l=2.1e-08 $layer=M1 $thickness=3.6e-08
+ $X=0.027 $Y=0.234 $X2=0.027 $Y2=0.213
r6 18 64 1.96775 $w=1.63333e-08 $l=1.35e-08 $layer=M1 $thickness=3.6e-08
+ $X=0.027 $Y=0.234 $X2=0.0405 $Y2=0.234
r7 63 62 0.0308642 $w=8.1e-08 $l=2.5e-09 $layer=N_src_drn $thickness=1e-09
+ $X=0.0713 $Y=0.0675 $X2=0.0685 $Y2=0.0675
r8 14 62 0.154321 $w=8.1e-08 $l=1.25e-08 $layer=N_src_drn $thickness=1e-09
+ $X=0.056 $Y=0.0675 $X2=0.0685 $Y2=0.0675
r9 60 61 8.86121 $w=1.3e-08 $l=3.8e-08 $layer=M1 $thickness=3.6e-08 $X=0.027
+ $Y=0.175 $X2=0.027 $Y2=0.213
r10 59 60 16.0901 $w=1.3e-08 $l=6.9e-08 $layer=M1 $thickness=3.6e-08 $X=0.027
+ $Y=0.106 $X2=0.027 $Y2=0.175
r11 22 59 12.1259 $w=1.3e-08 $l=5.2e-08 $layer=M1 $thickness=3.6e-08 $X=0.027
+ $Y=0.054 $X2=0.027 $Y2=0.106
r12 15 5 0.154321 $w=8.1e-08 $l=1.25e-08 $layer=N_src_drn $thickness=1e-09
+ $X=0.2015 $Y=0.0675 $X2=0.216 $Y2=0.054
r13 58 15 0.0308642 $w=8.1e-08 $l=2.5e-09 $layer=N_src_drn $thickness=1e-09
+ $X=0.1986 $Y=0.0675 $X2=0.2015 $Y2=0.0675
r14 3 54 19.3796 $a=3.24e-16 $layer=V0LISD $X=0.054 $Y=0.0675 $X2=0.054
+ $Y2=0.036
r15 17 53 1.49895 $w=1.63333e-08 $l=1.35e-08 $layer=M1 $thickness=3.6e-08
+ $X=0.027 $Y=0.036 $X2=0.0405 $Y2=0.036
r16 17 22 2.5483 $w=1.79e-08 $l=1.8e-08 $layer=M1 $thickness=3.6e-08 $X=0.027
+ $Y=0.036 $X2=0.027 $Y2=0.054
r17 5 50 19.3796 $a=3.24e-16 $layer=V0LISD $X=0.216 $Y=0.054 $X2=0.216 $Y2=0.036
r18 53 54 3.14806 $w=1.3e-08 $l=1.35e-08 $layer=M1 $thickness=3.6e-08 $X=0.0405
+ $Y=0.036 $X2=0.054 $Y2=0.036
r19 52 54 3.14806 $w=1.3e-08 $l=1.35e-08 $layer=M1 $thickness=3.6e-08 $X=0.0675
+ $Y=0.036 $X2=0.054 $Y2=0.036
r20 50 51 21.5701 $w=1.3e-08 $l=9.25e-08 $layer=M1 $thickness=3.6e-08 $X=0.216
+ $Y=0.036 $X2=0.3085 $Y2=0.036
r21 49 50 17.839 $w=1.3e-08 $l=7.65e-08 $layer=M1 $thickness=3.6e-08 $X=0.1395
+ $Y=0.036 $X2=0.216 $Y2=0.036
r22 49 52 16.7897 $w=1.3e-08 $l=7.2e-08 $layer=M1 $thickness=3.6e-08 $X=0.1395
+ $Y=0.036 $X2=0.0675 $Y2=0.036
r23 23 51 23.0858 $w=1.3e-08 $l=9.9e-08 $layer=M1 $thickness=3.6e-08 $X=0.4075
+ $Y=0.036 $X2=0.3085 $Y2=0.036
r24 19 24 2.5483 $w=1.79e-08 $l=1.8e-08 $layer=M1 $thickness=3.6e-08 $X=0.432
+ $Y=0.036 $X2=0.432 $Y2=0.054
r25 19 23 4.06404 $w=1.48367e-08 $l=2.45e-08 $layer=M1 $thickness=3.6e-08
+ $X=0.432 $Y=0.036 $X2=0.4075 $Y2=0.036
r26 20 48 4.06404 $w=1.48367e-08 $l=2.45e-08 $layer=M1 $thickness=3.6e-08
+ $X=0.432 $Y=0.072 $X2=0.4565 $Y2=0.072
r27 20 24 2.5483 $w=1.79e-08 $l=1.8e-08 $layer=M1 $thickness=3.6e-08 $X=0.432
+ $Y=0.072 $X2=0.432 $Y2=0.054
r28 25 48 4.19742 $w=1.3e-08 $l=1.8e-08 $layer=M1 $thickness=3.6e-08 $X=0.4745
+ $Y=0.072 $X2=0.4565 $Y2=0.072
r29 21 38 3.48106 $w=1.70091e-08 $l=2.2e-08 $layer=M1 $thickness=3.6e-08
+ $X=0.486 $Y=0.072 $X2=0.486 $Y2=0.094
r30 21 25 1.03257 $w=1.6913e-08 $l=1.15e-08 $layer=M1 $thickness=3.6e-08
+ $X=0.486 $Y=0.072 $X2=0.4745 $Y2=0.072
r31 46 45 14.6259 $w=2.1e-08 $l=4.3e-08 $layer=Gate_1 $thickness=5.6e-08
+ $X=0.513 $Y=0.2025 $X2=0.513 $Y2=0.1595
r32 44 45 2.7211 $w=2.1e-08 $l=8e-09 $layer=Gate_1 $thickness=5.6e-08 $X=0.513
+ $Y=0.1515 $X2=0.513 $Y2=0.1595
r33 42 43 14.6259 $w=2.1e-08 $l=4.3e-08 $layer=Gate_1 $thickness=5.6e-08
+ $X=0.513 $Y=0.0675 $X2=0.513 $Y2=0.1105
r34 40 43 2.7211 $w=2.1e-08 $l=8e-09 $layer=Gate_1 $thickness=5.6e-08 $X=0.513
+ $Y=0.1185 $X2=0.513 $Y2=0.1105
r35 13 35 6.54019 $w=2.09524e-08 $layer=Gate_1 $thickness=5.21905e-08 $X=0.513
+ $Y=0.135 $X2=0.513 $Y2=0.135
r36 13 40 5.79936 $w=2.03333e-08 $l=1.65e-08 $layer=Gate_1 $thickness=5.6e-08
+ $X=0.513 $Y=0.135 $X2=0.513 $Y2=0.1185
r37 13 44 5.79936 $w=2.03333e-08 $l=1.65e-08 $layer=Gate_1 $thickness=5.6e-08
+ $X=0.513 $Y=0.135 $X2=0.513 $Y2=0.1515
r38 37 38 5.24677 $w=1.3e-08 $l=2.25e-08 $layer=M1 $thickness=3.6e-08 $X=0.486
+ $Y=0.1165 $X2=0.486 $Y2=0.094
r39 26 34 19.3796 $a=3.24e-16 $layer=V0LIG $X=0.486 $Y=0.135 $X2=0.486 $Y2=0.135
r40 26 37 4.31401 $w=1.3e-08 $l=1.85e-08 $layer=M1 $thickness=3.6e-08 $X=0.486
+ $Y=0.135 $X2=0.486 $Y2=0.1165
r41 34 35 12.6539 $w=1.77815e-08 $l=2.7e-08 $layer=LIG $thickness=4.8e-08
+ $X=0.486 $Y=0.135 $X2=0.513 $Y2=0.135
r42 1 29 6.54019 $w=2.09524e-08 $layer=Gate_1 $thickness=5.21905e-08 $X=0.459
+ $Y=0.135 $X2=0.459 $Y2=0.135
r43 1 34 12.6539 $w=1.77815e-08 $l=2.7e-08 $layer=LIG $thickness=4.8e-08
+ $X=0.459 $Y=0.135 $X2=0.486 $Y2=0.135
r44 31 30 16.4967 $w=2.1e-08 $l=4.85e-08 $layer=Gate_1 $thickness=5.6e-08
+ $X=0.459 $Y=0.2025 $X2=0.459 $Y2=0.154
r45 29 30 6.6497 $w=2.04211e-08 $l=1.9e-08 $layer=Gate_1 $thickness=5.6e-08
+ $X=0.459 $Y=0.135 $X2=0.459 $Y2=0.154
r46 28 29 6.6497 $w=2.04211e-08 $l=1.9e-08 $layer=Gate_1 $thickness=5.6e-08
+ $X=0.459 $Y=0.116 $X2=0.459 $Y2=0.135
r47 27 28 16.4967 $w=2.1e-08 $l=4.85e-08 $layer=Gate_1 $thickness=5.6e-08
+ $X=0.459 $Y=0.0675 $X2=0.459 $Y2=0.116
r48 27 12 14.6259 $w=2.1e-08 $l=4.3e-08 $layer=Gate_1 $thickness=5.6e-08
+ $X=0.459 $Y=0.0675 $X2=0.459 $Y2=0.0245
r49 4 16 1e-05 $l=2e-09 $X=0.054 $Y=0.2025 $X2=0.056 $Y2=0.2025
r50 3 14 1e-05 $l=2e-09 $X=0.054 $Y=0.0675 $X2=0.056 $Y2=0.0675
.ends

.subckt PM_XNOR2x2_ASAP7_75t_R%B vss 21 7 13 27 31 6 5 1 4 3
c1 1 vss 0.0189116f $X=0.3415 $Y=0.135
c2 3 vss 0.110303f $X=0.189 $Y=0.135
c3 4 vss 0.0438248f $X=0.351 $Y=0.0245
c4 5 vss 0.00168258f $X=0.351 $Y=0.198
c5 6 vss 0.00213383f $X=0.351 $Y=0.1265
r1 5 24 6.16517 $w=1.44286e-08 $l=3.15e-08 $layer=M1 $thickness=3.6e-08
+ $X=0.351 $Y=0.198 $X2=0.351 $Y2=0.1665
r2 31 30 14.6259 $w=2.1e-08 $l=4.3e-08 $layer=Gate_1 $thickness=5.6e-08
+ $X=0.189 $Y=0.2025 $X2=0.189 $Y2=0.1595
r3 29 30 3.23131 $w=2.1e-08 $l=9.5e-09 $layer=Gate_1 $thickness=5.6e-08
+ $X=0.189 $Y=0.15 $X2=0.189 $Y2=0.1595
r4 27 28 14.6259 $w=2.1e-08 $l=4.3e-08 $layer=Gate_1 $thickness=5.6e-08
+ $X=0.189 $Y=0.0675 $X2=0.189 $Y2=0.1105
r5 25 28 3.23131 $w=2.1e-08 $l=9.5e-09 $layer=Gate_1 $thickness=5.6e-08
+ $X=0.189 $Y=0.12 $X2=0.189 $Y2=0.1105
r6 3 18 7.58422 $w=1.77778e-08 $layer=LIG $thickness=5.15556e-08 $X=0.189
+ $Y=0.135 $X2=0.189 $Y2=0.135
r7 3 25 5.23813 $w=2.04667e-08 $l=1.5e-08 $layer=Gate_1 $thickness=5.6e-08
+ $X=0.189 $Y=0.135 $X2=0.189 $Y2=0.12
r8 3 29 5.23813 $w=2.04667e-08 $l=1.5e-08 $layer=Gate_1 $thickness=5.6e-08
+ $X=0.189 $Y=0.135 $X2=0.189 $Y2=0.15
r9 22 24 5.36336 $w=1.3e-08 $l=2.3e-08 $layer=M1 $thickness=3.6e-08 $X=0.351
+ $Y=0.1435 $X2=0.351 $Y2=0.1665
r10 21 22 1.98211 $w=1.3e-08 $l=8.5e-09 $layer=M1 $thickness=3.6e-08 $X=0.35
+ $Y=0.135 $X2=0.351 $Y2=0.1435
r11 21 6 1.98211 $w=1.3e-08 $l=8.5e-09 $layer=M1 $thickness=3.6e-08 $X=0.35
+ $Y=0.135 $X2=0.351 $Y2=0.1265
r12 17 18 170.233 $w=1.01272e-08 $l=8.1e-08 $layer=LIG $thickness=4.8e-08
+ $X=0.27 $Y=0.135 $X2=0.189 $Y2=0.135
r13 15 16 4.49071 $w=1.6e-08 $l=9.5e-09 $layer=LIG $thickness=4.8e-08 $X=0.351
+ $Y=0.135 $X2=0.3605 $Y2=0.135
r14 21 15 28.9687 $a=2.88e-16 $layer=V0LIG $X=0.35 $Y=0.135 $X2=0.351 $Y2=0.135
r15 1 15 4.49071 $w=1.6e-08 $l=9.5e-09 $layer=LIG $thickness=4.8e-08 $X=0.3415
+ $Y=0.135 $X2=0.351 $Y2=0.135
r16 1 17 165.742 $w=9.34685e-09 $l=7.15e-08 $layer=LIG $thickness=4.8e-08
+ $X=0.3415 $Y=0.135 $X2=0.27 $Y2=0.135
r17 13 12 14.6259 $w=2.1e-08 $l=4.3e-08 $layer=Gate_1 $thickness=5.6e-08
+ $X=0.351 $Y=0.2025 $X2=0.351 $Y2=0.1595
r18 11 12 3.23131 $w=2.1e-08 $l=9.5e-09 $layer=Gate_1 $thickness=5.6e-08
+ $X=0.351 $Y=0.15 $X2=0.351 $Y2=0.1595
r19 10 11 5.23813 $w=2.04667e-08 $l=1.5e-08 $layer=Gate_1 $thickness=5.6e-08
+ $X=0.351 $Y=0.135 $X2=0.351 $Y2=0.15
r20 10 16 3.09351 $w=1.97647e-08 $l=9.5e-09 $layer=Gate_1
+ $thickness=5.55294e-08 $X=0.351 $Y=0.135 $X2=0.3605 $Y2=0.135
r21 10 15 7.11151 $w=1.78824e-08 $layer=LIG $thickness=5.17647e-08 $X=0.351
+ $Y=0.135 $X2=0.351 $Y2=0.135
r22 9 10 5.23813 $w=2.04667e-08 $l=1.5e-08 $layer=Gate_1 $thickness=5.6e-08
+ $X=0.351 $Y=0.12 $X2=0.351 $Y2=0.135
r23 8 9 7.82318 $w=2.1e-08 $l=2.3e-08 $layer=Gate_1 $thickness=5.6e-08 $X=0.351
+ $Y=0.097 $X2=0.351 $Y2=0.12
r24 7 8 14.6259 $w=2.1e-08 $l=4.3e-08 $layer=Gate_1 $thickness=5.6e-08 $X=0.351
+ $Y=0.054 $X2=0.351 $Y2=0.097
r25 7 4 10.0341 $w=2.1e-08 $l=2.95e-08 $layer=Gate_1 $thickness=5.6e-08
+ $X=0.351 $Y=0.054 $X2=0.351 $Y2=0.0245
.ends

.subckt PM_XNOR2x2_ASAP7_75t_R%A vss 31 17 21 49 52 2 14 8 10 13 1 12 15 5 6 16
+ 7 11
c1 1 vss 0.00587394f $X=0.135 $Y=0.135
c2 2 vss 0.00391413f $X=0.405 $Y=0.135
c3 5 vss 0.141475f $X=0.135 $Y=0.135
c4 6 vss 0.0854999f $X=0.405 $Y=0.0245
c5 7 vss 0.00279192f $X=0.135 $Y=0.192
c6 8 vss 0.000757936f $X=0.27 $Y=0.198
c7 9 vss 0.00352612f $X=0.27 $Y=0.234
c8 10 vss 0.00158392f $X=0.3915 $Y=0.135
c9 11 vss 0.00296527f $X=0.431 $Y=0.234
c10 12 vss 0.00303361f $X=0.135 $Y=0.166
c11 13 vss 0.0108567f $X=0.2455 $Y=0.192
c12 14 vss 0.00114938f $X=0.27 $Y=0.216
c13 15 vss 0.0143068f $X=0.4065 $Y=0.234
c14 16 vss 0.00404551f $X=0.431 $Y=0.1475
r1 52 51 16.4967 $w=2.1e-08 $l=4.85e-08 $layer=Gate_1 $thickness=5.6e-08
+ $X=0.135 $Y=0.2025 $X2=0.135 $Y2=0.154
r2 49 50 16.4967 $w=2.1e-08 $l=4.85e-08 $layer=Gate_1 $thickness=5.6e-08
+ $X=0.135 $Y=0.0675 $X2=0.135 $Y2=0.116
r3 5 50 6.6497 $w=2.04211e-08 $l=1.9e-08 $layer=Gate_1 $thickness=5.6e-08
+ $X=0.135 $Y=0.135 $X2=0.135 $Y2=0.116
r4 5 51 6.6497 $w=2.04211e-08 $l=1.9e-08 $layer=Gate_1 $thickness=5.6e-08
+ $X=0.135 $Y=0.135 $X2=0.135 $Y2=0.154
r5 1 44 19.3796 $a=3.24e-16 $layer=V0LIG $X=0.135 $Y=0.135 $X2=0.135 $Y2=0.135
r6 1 5 8.65438 $w=1.80211e-08 $layer=LIG $thickness=5.26316e-08 $X=0.135
+ $Y=0.135 $X2=0.135 $Y2=0.135
r7 44 45 2.68168 $w=1.3e-08 $l=1.15e-08 $layer=M1 $thickness=3.6e-08 $X=0.135
+ $Y=0.135 $X2=0.135 $Y2=0.1465
r8 12 45 4.5472 $w=1.3e-08 $l=1.95e-08 $layer=M1 $thickness=3.6e-08 $X=0.135
+ $Y=0.166 $X2=0.135 $Y2=0.1465
r9 7 42 10.4768 $w=1.38654e-08 $l=5.2e-08 $layer=M1 $thickness=3.6e-08 $X=0.135
+ $Y=0.192 $X2=0.187 $Y2=0.192
r10 7 12 4.41382 $w=1.63923e-08 $l=2.6e-08 $layer=M1 $thickness=3.6e-08
+ $X=0.135 $Y=0.192 $X2=0.135 $Y2=0.166
r11 13 42 13.6416 $w=1.3e-08 $l=5.85e-08 $layer=M1 $thickness=3.6e-08 $X=0.2455
+ $Y=0.192 $X2=0.187 $Y2=0.192
r12 8 40 1.0057 $w=1.55e-08 $l=6e-09 $layer=M1 $thickness=3.6e-08 $X=0.27
+ $Y=0.198 $X2=0.27 $Y2=0.204
r13 8 13 3.92057 $w=1.38108e-08 $l=2.5224e-08 $layer=M1 $thickness=3.6e-08
+ $X=0.27 $Y=0.198 $X2=0.2455 $Y2=0.192
r14 14 40 2.79828 $w=1.3e-08 $l=1.2e-08 $layer=M1 $thickness=3.6e-08 $X=0.27
+ $Y=0.216 $X2=0.27 $Y2=0.204
r15 9 39 3.13128 $w=1.51951e-08 $l=2.05e-08 $layer=M1 $thickness=3.6e-08
+ $X=0.27 $Y=0.234 $X2=0.2905 $Y2=0.234
r16 9 14 2.5483 $w=1.79e-08 $l=1.8e-08 $layer=M1 $thickness=3.6e-08 $X=0.27
+ $Y=0.234 $X2=0.27 $Y2=0.216
r17 38 39 4.78039 $w=1.3e-08 $l=2.05e-08 $layer=M1 $thickness=3.6e-08 $X=0.311
+ $Y=0.234 $X2=0.2905 $Y2=0.234
r18 37 38 4.6638 $w=1.3e-08 $l=2e-08 $layer=M1 $thickness=3.6e-08 $X=0.331
+ $Y=0.234 $X2=0.311 $Y2=0.234
r19 36 37 6.99569 $w=1.3e-08 $l=3e-08 $layer=M1 $thickness=3.6e-08 $X=0.361
+ $Y=0.234 $X2=0.331 $Y2=0.234
r20 35 36 5.71315 $w=1.3e-08 $l=2.45e-08 $layer=M1 $thickness=3.6e-08 $X=0.3855
+ $Y=0.234 $X2=0.361 $Y2=0.234
r21 15 35 4.89699 $w=1.3e-08 $l=2.1e-08 $layer=M1 $thickness=3.6e-08 $X=0.4065
+ $Y=0.234 $X2=0.3855 $Y2=0.234
r22 11 34 2.5483 $w=1.79e-08 $l=1.8e-08 $layer=M1 $thickness=3.6e-08 $X=0.431
+ $Y=0.234 $X2=0.431 $Y2=0.216
r23 11 15 4.06404 $w=1.48367e-08 $l=2.45e-08 $layer=M1 $thickness=3.6e-08
+ $X=0.431 $Y=0.234 $X2=0.4065 $Y2=0.234
r24 33 34 4.19742 $w=1.3e-08 $l=1.8e-08 $layer=M1 $thickness=3.6e-08 $X=0.431
+ $Y=0.198 $X2=0.431 $Y2=0.216
r25 32 33 4.4889 $w=1.3e-08 $l=1.93e-08 $layer=M1 $thickness=3.6e-08 $X=0.431
+ $Y=0.1787 $X2=0.431 $Y2=0.198
r26 31 32 2.50679 $w=1.3e-08 $l=1.07e-08 $layer=M1 $thickness=3.6e-08 $X=0.435
+ $Y=0.168 $X2=0.431 $Y2=0.1787
r27 31 30 2.04041 $w=1.3e-08 $l=8.8e-09 $layer=M1 $thickness=3.6e-08 $X=0.435
+ $Y=0.168 $X2=0.431 $Y2=0.1592
r28 16 28 0.867186 $w=1.3625e-08 $l=1.51162e-08 $layer=M1 $thickness=3.6e-08
+ $X=0.431 $Y=0.1475 $X2=0.4225 $Y2=0.135
r29 16 30 2.73998 $w=1.3e-08 $l=1.17e-08 $layer=M1 $thickness=3.6e-08 $X=0.431
+ $Y=0.1475 $X2=0.431 $Y2=0.1592
r30 27 28 0.983781 $w=1.35556e-08 $l=4.5e-09 $layer=M1 $thickness=3.6e-08
+ $X=0.418 $Y=0.135 $X2=0.4225 $Y2=0.135
r31 26 27 3.03147 $w=1.3e-08 $l=1.3e-08 $layer=M1 $thickness=3.6e-08 $X=0.405
+ $Y=0.135 $X2=0.418 $Y2=0.135
r32 25 26 2.56509 $w=1.3e-08 $l=1.1e-08 $layer=M1 $thickness=3.6e-08 $X=0.394
+ $Y=0.135 $X2=0.405 $Y2=0.135
r33 10 25 0.582974 $w=1.3e-08 $l=2.5e-09 $layer=M1 $thickness=3.6e-08 $X=0.3915
+ $Y=0.135 $X2=0.394 $Y2=0.135
r34 2 19 8.65438 $w=1.80211e-08 $layer=LIG $thickness=5.26316e-08 $X=0.405
+ $Y=0.135 $X2=0.405 $Y2=0.135
r35 2 26 19.3796 $a=3.24e-16 $layer=V0LIG $X=0.405 $Y=0.135 $X2=0.405 $Y2=0.135
r36 21 20 16.4967 $w=2.1e-08 $l=4.85e-08 $layer=Gate_1 $thickness=5.6e-08
+ $X=0.405 $Y=0.2025 $X2=0.405 $Y2=0.154
r37 19 20 6.6497 $w=2.04211e-08 $l=1.9e-08 $layer=Gate_1 $thickness=5.6e-08
+ $X=0.405 $Y=0.135 $X2=0.405 $Y2=0.154
r38 18 19 11.2416 $w=2.06615e-08 $l=3.25e-08 $layer=Gate_1 $thickness=5.6e-08
+ $X=0.405 $Y=0.1025 $X2=0.405 $Y2=0.135
r39 17 18 16.4967 $w=2.1e-08 $l=4.85e-08 $layer=Gate_1 $thickness=5.6e-08
+ $X=0.405 $Y=0.054 $X2=0.405 $Y2=0.1025
r40 17 6 10.0341 $w=2.1e-08 $l=2.95e-08 $layer=Gate_1 $thickness=5.6e-08
+ $X=0.405 $Y=0.054 $X2=0.405 $Y2=0.0245
.ends

* End of included file XNOR2x2_ASAP7_75t_R.pex.sp.pex

*
.subckt XNOR2x2_ASAP7_75t_CUSTOM_4_25_0_7 VSS VDD A B Y
*
* VSS VSS
* VDD VDD
* A A
* B B
* Y Y
*
*

M0 VSS N_M0_g N_M0_s VSS nmos_rvt L=2e-08 W=8.1e-08 nfin=3 $X=0.071 $Y=0.027
M1 noxref_9 N_M1_g VSS VSS nmos_rvt L=2e-08 W=8.1e-08 nfin=3 $X=0.125 $Y=0.027
M2 N_M2_d N_M2_g noxref_9 VSS nmos_rvt L=2e-08 W=8.1e-08 nfin=3 $X=0.179
+ $Y=0.027
M3 N_M3_d N_M3_g VSS VSS nmos_rvt L=2e-08 W=5.4e-08 nfin=2 $X=0.341 $Y=0.027
M4 VSS N_M4_g N_M4_s VSS nmos_rvt L=2e-08 W=5.4e-08 nfin=2 $X=0.395 $Y=0.027
M5 N_M5_d N_M5_g VSS VSS nmos_rvt L=2e-08 W=8.1e-08 nfin=3 $X=0.449 $Y=0.027
M6 N_M6_d N_M6_g VSS VSS nmos_rvt L=2e-08 W=8.1e-08 nfin=3 $X=0.503 $Y=0.027
M7 noxref_7 N_M7_g N_M7_s VDD pmos_rvt L=2e-08 W=8.1e-08 nfin=3 $X=0.071
+ $Y=0.162
M8 VDD N_M8_g noxref_7 VDD pmos_rvt L=2e-08 W=8.1e-08 nfin=3 $X=0.125 $Y=0.162
M9 noxref_7 N_M9_g VDD VDD pmos_rvt L=2e-08 W=8.1e-08 nfin=3 $X=0.179 $Y=0.162
M10 N_M10_d N_M10_g N_M10_s VDD pmos_rvt L=2e-08 W=8.1e-08 nfin=3 $X=0.341
+ $Y=0.162
M11 VDD N_M11_g N_M11_s VDD pmos_rvt L=2e-08 W=8.1e-08 nfin=3 $X=0.395 $Y=0.162
M12 N_M12_d N_M12_g VDD VDD pmos_rvt L=2e-08 W=8.1e-08 nfin=3 $X=0.449 $Y=0.162
M13 N_M13_d N_M13_g VDD VDD pmos_rvt L=2e-08 W=8.1e-08 nfin=3 $X=0.503 $Y=0.162

* .include "XNOR2x2_ASAP7_75t_R.pex.sp.pxi"

* Start of included file XNOR2x2_ASAP7_75t_R.pex.sp.pxi
x_PM_XNOR2x2_ASAP7_75t_R%10 vss N_M10_d N_M11_s N_10_1 PM_XNOR2x2_ASAP7_75t_R%10
cc_1 N_10_1 N_A_6 0.0169186f $X=0.378 $Y=0.2025
cc_2 N_10_1 N_B_4 0.0169494f $X=0.378 $Y=0.2025
x_PM_XNOR2x2_ASAP7_75t_R%3 vss N_M0_g N_M7_g N_M10_s N_M3_d N_M4_s N_3_10
+ N_3_16 N_3_3 N_3_17 N_3_1 N_3_15 N_3_14 N_3_9 N_3_11 N_3_4 N_3_13 N_3_12
+ PM_XNOR2x2_ASAP7_75t_R%3
x_PM_XNOR2x2_ASAP7_75t_R%Y vss Y N_M5_d N_M6_d N_M12_d N_M13_d N_Y_12 N_Y_8
+ N_Y_13 N_Y_1 N_Y_2 N_Y_11 N_Y_7 PM_XNOR2x2_ASAP7_75t_R%Y
cc_3 N_Y_12 N_A_16 0.000811984f $X=0.5265 $Y=0.234
cc_4 N_Y_12 N_A_11 0.00220801f $X=0.5265 $Y=0.234
cc_5 N_Y_8 N_6_19 0.000349088f $X=0.4715 $Y=0.2025
cc_6 N_Y_8 N_6_21 0.000555981f $X=0.4715 $Y=0.2025
cc_7 N_Y_8 N_6_1 0.00530285f $X=0.4715 $Y=0.2025
cc_8 N_Y_8 N_6_12 0.000795213f $X=0.4715 $Y=0.2025
cc_9 N_Y_8 N_6_25 0.000824688f $X=0.4715 $Y=0.2025
cc_10 N_Y_13 N_6_1 0.00123153f $X=0.567 $Y=0.054
cc_11 N_Y_1 N_6_26 0.00166855f $X=0.486 $Y=0.0675
cc_12 N_Y_2 N_6_12 0.00169304f $X=0.486 $Y=0.2025
cc_13 N_Y_1 N_6_12 0.00229816f $X=0.486 $Y=0.0675
cc_14 N_Y_11 N_6_21 0.00314624f $X=0.4745 $Y=0.036
cc_15 N_Y_7 N_6_13 0.0102833f $X=0.4715 $Y=0.0675
cc_16 N_Y_7 N_6_12 0.0555266f $X=0.4715 $Y=0.0675
cc_17 N_Y_8 N_6_13 0.0671227f $X=0.4715 $Y=0.2025
x_PM_XNOR2x2_ASAP7_75t_R%6 vss N_M5_g N_M12_g N_M6_g N_M13_g N_M2_d N_M0_s
+ N_M7_s N_6_23 N_6_14 N_6_20 N_6_5 N_6_4 N_6_3 N_6_22 N_6_16 N_6_25 N_6_18
+ N_6_1 N_6_26 N_6_12 N_6_15 N_6_19 N_6_21 N_6_13 PM_XNOR2x2_ASAP7_75t_R%6
cc_18 N_6_23 N_3_9 0.000317161f $X=0.4075 $Y=0.036
cc_19 N_6_14 N_3_9 0.0153089f $X=0.056 $Y=0.0675
cc_20 N_6_20 N_3_17 0.000436498f $X=0.432 $Y=0.072
cc_21 N_6_5 N_3_15 0.00162934f $X=0.216 $Y=0.054
cc_22 N_6_23 N_3_4 0.00133227f $X=0.4075 $Y=0.036
cc_23 N_6_4 N_3_1 0.000814565f $X=0.054 $Y=0.2025
cc_24 N_6_23 N_3_13 0.000917853f $X=0.4075 $Y=0.036
cc_25 N_6_4 N_3_9 0.000929705f $X=0.054 $Y=0.2025
cc_26 N_6_3 N_3_9 0.0012877f $X=0.054 $Y=0.0675
cc_27 N_6_23 N_3_12 0.00165148f $X=0.4075 $Y=0.036
cc_28 N_6_14 N_3_1 0.00167276f $X=0.056 $Y=0.0675
cc_29 N_6_23 N_3_17 0.0029614f $X=0.4075 $Y=0.036
cc_30 N_6_22 N_3_14 0.00431286f $X=0.027 $Y=0.054
cc_31 N_6_23 N_3_15 0.0202913f $X=0.4075 $Y=0.036
cc_32 N_6_16 N_3_9 0.0543175f $X=0.056 $Y=0.2025
cc_33 N_6_25 N_A_6 0.000210015f $X=0.4745 $Y=0.072
cc_34 N_6_5 N_A_1 0.000234455f $X=0.216 $Y=0.054
cc_35 N_6_22 N_A_12 0.000282868f $X=0.027 $Y=0.054
cc_36 N_6_18 N_A_7 0.000304044f $X=0.027 $Y=0.234
cc_37 N_6_1 N_A_10 0.000307345f $X=0.459 $Y=0.135
cc_38 N_6_4 N_A_12 0.000360399f $X=0.054 $Y=0.2025
cc_39 N_6_23 N_A_12 0.000368983f $X=0.4075 $Y=0.036
cc_40 N_6_5 N_A_5 0.000419992f $X=0.216 $Y=0.054
cc_41 N_6_1 N_A_2 0.00194026f $X=0.459 $Y=0.135
cc_42 N_6_20 N_A_10 0.000744799f $X=0.432 $Y=0.072
cc_43 N_6_26 N_A_16 0.00079708f $X=0.486 $Y=0.135
cc_44 N_6_26 N_A_10 0.00176375f $X=0.486 $Y=0.135
cc_45 N_6_12 N_A_6 0.00400869f $X=0.459 $Y=0.0245
cc_46 N_6_5 N_B_3 0.00163436f $X=0.216 $Y=0.054
cc_47 N_6_15 N_B_1 0.00301723f $X=0.2015 $Y=0.0675
cc_48 N_6_15 N_B_3 0.0360712f $X=0.2015 $Y=0.0675
x_PM_XNOR2x2_ASAP7_75t_R%B vss B N_M3_g N_M10_g N_M2_g N_M9_g N_B_6 N_B_5 N_B_1
+ N_B_4 N_B_3 PM_XNOR2x2_ASAP7_75t_R%B
cc_49 N_B_6 N_3_11 0.00057678f $X=0.351 $Y=0.1265
cc_50 N_B_5 N_3_16 0.000752707f $X=0.351 $Y=0.198
cc_51 N_B_1 N_3_15 0.000781126f $X=0.3415 $Y=0.135
cc_52 N_B_1 N_3_16 0.000807308f $X=0.3415 $Y=0.135
cc_53 N_B_6 N_3_17 0.000894343f $X=0.351 $Y=0.1265
cc_54 N_B_4 N_3_3 0.0028833f $X=0.351 $Y=0.0245
cc_55 N_B_4 N_3_10 0.0106753f $X=0.351 $Y=0.0245
cc_56 N_B_1 N_3_3 0.00518035f $X=0.3415 $Y=0.135
cc_57 N_B_6 N_3_16 0.00707199f $X=0.351 $Y=0.1265
cc_58 N_B_4 N_3_11 0.0506632f $X=0.351 $Y=0.0245
cc_59 N_B_1 N_A_6 0.000421984f $X=0.3415 $Y=0.135
cc_60 N_B_1 N_A_2 0.00123424f $X=0.3415 $Y=0.135
cc_61 N_B_1 N_A_13 0.000486234f $X=0.3415 $Y=0.135
cc_62 N_B_1 N_A_1 0.000520885f $X=0.3415 $Y=0.135
cc_63 N_B_5 N_A_16 0.0005463f $X=0.351 $Y=0.198
cc_64 N_B_1 N_A_8 0.00167737f $X=0.3415 $Y=0.135
cc_65 N_B_6 N_A_10 0.00228882f $X=0.351 $Y=0.1265
cc_66 N_B_5 N_A_15 0.00472878f $X=0.351 $Y=0.198
cc_67 N_B_3 N_A_5 0.00489239f $X=0.189 $Y=0.135
cc_68 N_B_4 N_A_6 0.00743744f $X=0.351 $Y=0.0245
x_PM_XNOR2x2_ASAP7_75t_R%A vss A N_M4_g N_M11_g N_M1_g N_M8_g N_A_2 N_A_14
+ N_A_8 N_A_10 N_A_13 N_A_1 N_A_12 N_A_15 N_A_5 N_A_6 N_A_16 N_A_7 N_A_11
+ PM_XNOR2x2_ASAP7_75t_R%A
cc_69 N_A_2 N_3_10 0.000670304f $X=0.405 $Y=0.135
cc_70 N_A_14 N_3_16 0.000440175f $X=0.27 $Y=0.216
cc_71 N_A_8 N_3_3 0.000453641f $X=0.27 $Y=0.198
cc_72 N_A_10 N_3_17 0.000813509f $X=0.3915 $Y=0.135
cc_73 N_A_13 N_3_3 0.000821926f $X=0.2455 $Y=0.192
cc_74 N_A_1 N_3_1 0.00217795f $X=0.135 $Y=0.135
cc_75 N_A_12 N_3_15 0.00154528f $X=0.135 $Y=0.166
cc_76 N_A_15 N_3_16 0.00162707f $X=0.4065 $Y=0.234
cc_77 N_A_15 N_3_3 0.00171751f $X=0.4065 $Y=0.234
cc_78 N_A_12 N_3_14 0.00280254f $X=0.135 $Y=0.166
cc_79 N_A_8 N_3_16 0.00284671f $X=0.27 $Y=0.198
cc_80 N_A_5 N_3_9 0.00334497f $X=0.135 $Y=0.135
cc_81 N_A_6 N_3_10 0.0264003f $X=0.405 $Y=0.0245

* End of included file XNOR2x2_ASAP7_75t_R.pex.sp.pxi
.ends

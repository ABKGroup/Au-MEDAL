.subckt PM_AND3x1_ASAP7_75t_R%8 vss 2 3 1
c1 1 vss 0.000704452f $X=0.108 $Y=0.0675
r1 2 1 0.209877 $w=8.1e-08 $l=1.7e-08 $layer=N_src_drn $thickness=1e-09
+ $X=0.0906 $Y=0.0675 $X2=0.108 $Y2=0.0675
r2 3 1 0.209877 $w=8.1e-08 $l=1.7e-08 $layer=N_src_drn $thickness=1e-09
+ $X=0.1253 $Y=0.0675 $X2=0.108 $Y2=0.0675
.ends

.subckt PM_AND3x1_ASAP7_75t_R%9 vss 2 3 1
c1 1 vss 0.00076648f $X=0.162 $Y=0.0675
r1 2 1 0.209877 $w=8.1e-08 $l=1.7e-08 $layer=N_src_drn $thickness=1e-09
+ $X=0.1446 $Y=0.0675 $X2=0.162 $Y2=0.0675
r2 3 1 0.209877 $w=8.1e-08 $l=1.7e-08 $layer=N_src_drn $thickness=1e-09
+ $X=0.1793 $Y=0.0675 $X2=0.162 $Y2=0.0675
.ends

.subckt PM_AND3x1_ASAP7_75t_R%B vss 13 5 9 1 4 3
c1 1 vss 0.00288348f $X=0.135 $Y=0.135
c2 3 vss 0.0460782f $X=0.135 $Y=0.0245
c3 4 vss 0.0102577f $X=0.135 $Y=0.098
r1 13 4 8.62802 $w=1.3e-08 $l=3.7e-08 $layer=M1 $thickness=3.6e-08 $X=0.138
+ $Y=0.137 $X2=0.135 $Y2=0.098
r2 1 7 6.74717 $w=2e-08 $layer=Gate_1 $thickness=5.2e-08 $X=0.135 $Y=0.135
+ $X2=0.135 $Y2=0.135
r3 13 1 19.3796 $a=3.24e-16 $layer=V0LIG $X=0.138 $Y=0.137 $X2=0.135 $Y2=0.135
r4 9 8 16.6668 $w=2.1e-08 $l=4.9e-08 $layer=Gate_1 $thickness=5.6e-08 $X=0.135
+ $Y=0.2025 $X2=0.135 $Y2=0.1535
r5 7 8 6.46262 $w=2.04595e-08 $l=1.85e-08 $layer=Gate_1 $thickness=5.6e-08
+ $X=0.135 $Y=0.135 $X2=0.135 $Y2=0.1535
r6 6 7 6.46262 $w=2.04595e-08 $l=1.85e-08 $layer=Gate_1 $thickness=5.6e-08
+ $X=0.135 $Y=0.1165 $X2=0.135 $Y2=0.135
r7 5 6 16.6668 $w=2.1e-08 $l=4.9e-08 $layer=Gate_1 $thickness=5.6e-08 $X=0.135
+ $Y=0.0675 $X2=0.135 $Y2=0.1165
r8 5 3 14.6259 $w=2.1e-08 $l=4.3e-08 $layer=Gate_1 $thickness=5.6e-08 $X=0.135
+ $Y=0.0675 $X2=0.135 $Y2=0.0245
.ends

.subckt PM_AND3x1_ASAP7_75t_R%Y vss 23 15 30 8 9 13 10 7
c1 1 vss 0.00787446f $X=0.27 $Y=0.0675
c2 2 vss 0.00759749f $X=0.27 $Y=0.2025
c3 7 vss 0.0383418f $X=0.2555 $Y=0.0675
c4 8 vss 0.0383295f $X=0.2555 $Y=0.2025
c5 9 vss 0.00189611f $X=0.262 $Y=0.085
c6 10 vss 0.00288154f $X=0.27 $Y=0.192
c7 11 vss 0.00126292f $X=0.297 $Y=0.192
c8 12 vss 0.00269907f $X=0.27 $Y=0.0365
c9 13 vss 0.00236232f $X=0.297 $Y=0.11
r1 8 2 0.154321 $w=8.1e-08 $l=1.25e-08 $layer=P_src_drn $thickness=1e-09
+ $X=0.2555 $Y=0.2025 $X2=0.27 $Y2=0.2025
r2 30 8 0.0308642 $w=8.1e-08 $l=2.5e-09 $layer=P_src_drn $thickness=1e-09
+ $X=0.2526 $Y=0.2025 $X2=0.2555 $Y2=0.2025
r3 2 27 19.3796 $a=3.24e-16 $layer=V0LISD $X=0.27 $Y=0.2025 $X2=0.27 $Y2=0.215
r4 26 27 2.68168 $w=1.3e-08 $l=1.15e-08 $layer=M1 $thickness=3.6e-08 $X=0.27
+ $Y=0.2035 $X2=0.27 $Y2=0.215
r5 10 25 1.96775 $w=1.63333e-08 $l=1.35e-08 $layer=M1 $thickness=3.6e-08
+ $X=0.27 $Y=0.192 $X2=0.2835 $Y2=0.192
r6 10 26 1.50137 $w=1.6913e-08 $l=1.15e-08 $layer=M1 $thickness=3.6e-08 $X=0.27
+ $Y=0.192 $X2=0.27 $Y2=0.2035
r7 11 24 4.99922 $w=1.46981e-08 $l=2.65e-08 $layer=M1 $thickness=3.6e-08
+ $X=0.297 $Y=0.192 $X2=0.297 $Y2=0.1655
r8 11 25 1.96775 $w=1.63333e-08 $l=1.35e-08 $layer=M1 $thickness=3.6e-08
+ $X=0.297 $Y=0.192 $X2=0.2835 $Y2=0.192
r9 23 24 4.19742 $w=1.3e-08 $l=1.8e-08 $layer=M1 $thickness=3.6e-08 $X=0.298
+ $Y=0.1475 $X2=0.297 $Y2=0.1655
r10 23 22 0.46638 $w=1.3e-08 $l=2e-09 $layer=M1 $thickness=3.6e-08 $X=0.298
+ $Y=0.1475 $X2=0.297 $Y2=0.1455
r11 21 22 2.44849 $w=1.3e-08 $l=1.05e-08 $layer=M1 $thickness=3.6e-08 $X=0.297
+ $Y=0.135 $X2=0.297 $Y2=0.1455
r12 13 20 4.64944 $w=1.48e-08 $l=2.5e-08 $layer=M1 $thickness=3.6e-08 $X=0.297
+ $Y=0.11 $X2=0.297 $Y2=0.085
r13 13 21 5.82974 $w=1.3e-08 $l=2.5e-08 $layer=M1 $thickness=3.6e-08 $X=0.297
+ $Y=0.11 $X2=0.297 $Y2=0.135
r14 19 20 1.96775 $w=1.63333e-08 $l=1.35e-08 $layer=M1 $thickness=3.6e-08
+ $X=0.2835 $Y=0.085 $X2=0.297 $Y2=0.085
r15 18 19 1.86571 $w=1.62e-08 $l=1.25e-08 $layer=M1 $thickness=3.6e-08 $X=0.271
+ $Y=0.085 $X2=0.2835 $Y2=0.085
r16 9 17 2.31735 $w=1.34762e-08 $l=2.01556e-08 $layer=M1 $thickness=3.6e-08
+ $X=0.262 $Y=0.085 $X2=0.27 $Y2=0.0665
r17 9 18 0.9184 $w=1.8e-08 $l=9e-09 $layer=M1 $thickness=3.6e-08 $X=0.262
+ $Y=0.085 $X2=0.271 $Y2=0.085
r18 16 17 4.31401 $w=1.3e-08 $l=1.85e-08 $layer=M1 $thickness=3.6e-08 $X=0.27
+ $Y=0.048 $X2=0.27 $Y2=0.0665
r19 12 16 2.68168 $w=1.3e-08 $l=1.15e-08 $layer=M1 $thickness=3.6e-08 $X=0.27
+ $Y=0.0365 $X2=0.27 $Y2=0.048
r20 1 16 19.3796 $a=3.24e-16 $layer=V0LISD $X=0.27 $Y=0.0675 $X2=0.27 $Y2=0.048
r21 7 1 0.154321 $w=8.1e-08 $l=1.25e-08 $layer=N_src_drn $thickness=1e-09
+ $X=0.2555 $Y=0.0675 $X2=0.27 $Y2=0.0675
r22 15 7 0.0308642 $w=8.1e-08 $l=2.5e-09 $layer=N_src_drn $thickness=1e-09
+ $X=0.2526 $Y=0.0675 $X2=0.2555 $Y2=0.0675
.ends

.subckt PM_AND3x1_ASAP7_75t_R%6 vss 23 29 63 66 67 69 4 20 19 14 3 13 15 5 17
+ 12 22 21 18 16 1
c1 1 vss 0.00376799f $X=0.243 $Y=0.135
c2 3 vss 0.00749224f $X=0.054 $Y=0.0675
c3 4 vss 0.00942566f $X=0.054 $Y=0.2025
c4 5 vss 0.00863616f $X=0.162 $Y=0.2025
c5 12 vss 0.0819292f $X=0.243 $Y=0.0245
c6 13 vss 0.0382237f $X=0.056 $Y=0.0675
c7 14 vss 0.0390784f $X=0.056 $Y=0.2025
c8 15 vss 0.00532142f $X=0.1475 $Y=0.2025
c9 16 vss 0.00287602f $X=0.225 $Y=0.0395
c10 17 vss 0.000496429f $X=0.225 $Y=0.135
c11 18 vss 0.00286074f $X=0.225 $Y=0.23
c12 19 vss 0.0166992f $X=0.207 $Y=0.036
c13 20 vss 0.0164131f $X=0.207 $Y=0.234
c14 21 vss 0.00231658f $X=0.225 $Y=0.11
c15 22 vss 0.00231452f $X=0.225 $Y=0.1635
r1 69 68 0.0308642 $w=8.1e-08 $l=2.5e-09 $layer=P_src_drn $thickness=1e-09
+ $X=0.0713 $Y=0.2025 $X2=0.0685 $Y2=0.2025
r2 14 68 0.154321 $w=8.1e-08 $l=1.25e-08 $layer=P_src_drn $thickness=1e-09
+ $X=0.056 $Y=0.2025 $X2=0.0685 $Y2=0.2025
r3 67 65 0.0308642 $w=8.1e-08 $l=2.5e-09 $layer=P_src_drn $thickness=1e-09
+ $X=0.1793 $Y=0.2025 $X2=0.1765 $Y2=0.2025
r4 5 65 0.179012 $w=8.1e-08 $l=1.45e-08 $layer=P_src_drn $thickness=1e-09
+ $X=0.162 $Y=0.2025 $X2=0.1765 $Y2=0.2025
r5 15 5 0.179012 $w=8.1e-08 $l=1.45e-08 $layer=P_src_drn $thickness=1e-09
+ $X=0.1475 $Y=0.2025 $X2=0.162 $Y2=0.2025
r6 66 15 0.0308642 $w=8.1e-08 $l=2.5e-09 $layer=P_src_drn $thickness=1e-09
+ $X=0.1446 $Y=0.2025 $X2=0.1475 $Y2=0.2025
r7 63 62 0.0308642 $w=8.1e-08 $l=2.5e-09 $layer=N_src_drn $thickness=1e-09
+ $X=0.0713 $Y=0.0675 $X2=0.0685 $Y2=0.0675
r8 13 62 0.154321 $w=8.1e-08 $l=1.25e-08 $layer=N_src_drn $thickness=1e-09
+ $X=0.056 $Y=0.0675 $X2=0.0685 $Y2=0.0675
r9 4 60 19.3796 $a=3.24e-16 $layer=V0LISD $X=0.054 $Y=0.2025 $X2=0.054 $Y2=0.234
r10 5 54 19.3796 $a=3.24e-16 $layer=V0LISD $X=0.162 $Y=0.2025 $X2=0.162
+ $Y2=0.234
r11 3 50 19.3796 $a=3.24e-16 $layer=V0LISD $X=0.054 $Y=0.0675 $X2=0.054
+ $Y2=0.036
r12 60 61 3.14806 $w=1.3e-08 $l=1.35e-08 $layer=M1 $thickness=3.6e-08 $X=0.054
+ $Y=0.234 $X2=0.0675 $Y2=0.234
r13 58 61 3.14806 $w=1.3e-08 $l=1.35e-08 $layer=M1 $thickness=3.6e-08 $X=0.081
+ $Y=0.234 $X2=0.0675 $Y2=0.234
r14 57 58 6.29612 $w=1.3e-08 $l=2.7e-08 $layer=M1 $thickness=3.6e-08 $X=0.108
+ $Y=0.234 $X2=0.081 $Y2=0.234
r15 56 57 6.29612 $w=1.3e-08 $l=2.7e-08 $layer=M1 $thickness=3.6e-08 $X=0.135
+ $Y=0.234 $X2=0.108 $Y2=0.234
r16 54 55 3.14806 $w=1.3e-08 $l=1.35e-08 $layer=M1 $thickness=3.6e-08 $X=0.162
+ $Y=0.234 $X2=0.1755 $Y2=0.234
r17 53 54 3.14806 $w=1.3e-08 $l=1.35e-08 $layer=M1 $thickness=3.6e-08 $X=0.1485
+ $Y=0.234 $X2=0.162 $Y2=0.234
r18 53 56 3.14806 $w=1.3e-08 $l=1.35e-08 $layer=M1 $thickness=3.6e-08 $X=0.1485
+ $Y=0.234 $X2=0.135 $Y2=0.234
r19 52 55 3.14806 $w=1.3e-08 $l=1.35e-08 $layer=M1 $thickness=3.6e-08 $X=0.189
+ $Y=0.234 $X2=0.1755 $Y2=0.234
r20 20 52 4.19742 $w=1.3e-08 $l=1.8e-08 $layer=M1 $thickness=3.6e-08 $X=0.207
+ $Y=0.234 $X2=0.189 $Y2=0.234
r21 50 51 3.14806 $w=1.3e-08 $l=1.35e-08 $layer=M1 $thickness=3.6e-08 $X=0.054
+ $Y=0.036 $X2=0.0675 $Y2=0.036
r22 48 51 3.14806 $w=1.3e-08 $l=1.35e-08 $layer=M1 $thickness=3.6e-08 $X=0.081
+ $Y=0.036 $X2=0.0675 $Y2=0.036
r23 47 48 6.29612 $w=1.3e-08 $l=2.7e-08 $layer=M1 $thickness=3.6e-08 $X=0.108
+ $Y=0.036 $X2=0.081 $Y2=0.036
r24 46 47 6.29612 $w=1.3e-08 $l=2.7e-08 $layer=M1 $thickness=3.6e-08 $X=0.135
+ $Y=0.036 $X2=0.108 $Y2=0.036
r25 45 46 6.29612 $w=1.3e-08 $l=2.7e-08 $layer=M1 $thickness=3.6e-08 $X=0.162
+ $Y=0.036 $X2=0.135 $Y2=0.036
r26 44 45 6.29612 $w=1.3e-08 $l=2.7e-08 $layer=M1 $thickness=3.6e-08 $X=0.189
+ $Y=0.036 $X2=0.162 $Y2=0.036
r27 19 44 4.19742 $w=1.3e-08 $l=1.8e-08 $layer=M1 $thickness=3.6e-08 $X=0.207
+ $Y=0.036 $X2=0.189 $Y2=0.036
r28 18 41 3.42509 $w=1.44286e-08 $l=1.75e-08 $layer=M1 $thickness=3.6e-08
+ $X=0.225 $Y=0.23 $X2=0.225 $Y2=0.2125
r29 18 20 2.60893 $w=1.47857e-08 $l=1.84391e-08 $layer=M1 $thickness=3.6e-08
+ $X=0.225 $Y=0.23 $X2=0.207 $Y2=0.234
r30 16 39 3.47612 $w=1.45278e-08 $l=1.8e-08 $layer=M1 $thickness=3.6e-08
+ $X=0.225 $Y=0.0395 $X2=0.225 $Y2=0.0575
r31 16 19 2.65995 $w=1.48966e-08 $l=1.83371e-08 $layer=M1 $thickness=3.6e-08
+ $X=0.225 $Y=0.0395 $X2=0.207 $Y2=0.036
r32 40 41 4.89699 $w=1.3e-08 $l=2.1e-08 $layer=M1 $thickness=3.6e-08 $X=0.225
+ $Y=0.1915 $X2=0.225 $Y2=0.2125
r33 22 40 6.52931 $w=1.3e-08 $l=2.8e-08 $layer=M1 $thickness=3.6e-08 $X=0.225
+ $Y=0.1635 $X2=0.225 $Y2=0.1915
r34 38 39 3.61444 $w=1.3e-08 $l=1.55e-08 $layer=M1 $thickness=3.6e-08 $X=0.225
+ $Y=0.073 $X2=0.225 $Y2=0.0575
r35 37 38 2.79828 $w=1.3e-08 $l=1.2e-08 $layer=M1 $thickness=3.6e-08 $X=0.225
+ $Y=0.085 $X2=0.225 $Y2=0.073
r36 21 37 5.82974 $w=1.3e-08 $l=2.5e-08 $layer=M1 $thickness=3.6e-08 $X=0.225
+ $Y=0.11 $X2=0.225 $Y2=0.085
r37 33 34 2.68168 $w=1.3e-08 $l=1.15e-08 $layer=M1 $thickness=3.6e-08 $X=0.2365
+ $Y=0.135 $X2=0.248 $Y2=0.135
r38 17 33 1.50137 $w=1.6913e-08 $l=1.15e-08 $layer=M1 $thickness=3.6e-08
+ $X=0.225 $Y=0.135 $X2=0.2365 $Y2=0.135
r39 17 21 4.64944 $w=1.48e-08 $l=2.5e-08 $layer=M1 $thickness=3.6e-08 $X=0.225
+ $Y=0.135 $X2=0.225 $Y2=0.11
r40 17 22 5.4656 $w=1.45789e-08 $l=2.85e-08 $layer=M1 $thickness=3.6e-08
+ $X=0.225 $Y=0.135 $X2=0.225 $Y2=0.1635
r41 1 26 6.74717 $w=2e-08 $layer=Gate_1 $thickness=5.2e-08 $X=0.243 $Y=0.135
+ $X2=0.243 $Y2=0.135
r42 1 34 19.3796 $a=3.24e-16 $layer=V0LIG $X=0.243 $Y=0.135 $X2=0.248 $Y2=0.135
r43 29 28 14.6259 $w=2.1e-08 $l=4.3e-08 $layer=Gate_1 $thickness=5.6e-08
+ $X=0.243 $Y=0.2025 $X2=0.243 $Y2=0.1595
r44 27 28 2.89117 $w=2.1e-08 $l=8.5e-09 $layer=Gate_1 $thickness=5.6e-08
+ $X=0.243 $Y=0.151 $X2=0.243 $Y2=0.1595
r45 26 27 5.61228 $w=2.0375e-08 $l=1.6e-08 $layer=Gate_1 $thickness=5.6e-08
+ $X=0.243 $Y=0.135 $X2=0.243 $Y2=0.151
r46 25 26 5.61228 $w=2.0375e-08 $l=1.6e-08 $layer=Gate_1 $thickness=5.6e-08
+ $X=0.243 $Y=0.119 $X2=0.243 $Y2=0.135
r47 24 25 2.89117 $w=2.1e-08 $l=8.5e-09 $layer=Gate_1 $thickness=5.6e-08
+ $X=0.243 $Y=0.1105 $X2=0.243 $Y2=0.119
r48 23 24 14.6259 $w=2.1e-08 $l=4.3e-08 $layer=Gate_1 $thickness=5.6e-08
+ $X=0.243 $Y=0.0675 $X2=0.243 $Y2=0.1105
r49 23 12 14.6259 $w=2.1e-08 $l=4.3e-08 $layer=Gate_1 $thickness=5.6e-08
+ $X=0.243 $Y=0.0675 $X2=0.243 $Y2=0.0245
r50 4 14 1e-05 $l=2e-09 $X=0.054 $Y=0.2025 $X2=0.056 $Y2=0.2025
r51 3 13 1e-05 $l=2e-09 $X=0.054 $Y=0.0675 $X2=0.056 $Y2=0.0675
.ends

.subckt PM_AND3x1_ASAP7_75t_R%C vss 4 5 9 3 1
c1 1 vss 0.00758081f $X=0.189 $Y=0.135
c2 3 vss 0.0840402f $X=0.189 $Y=0.0245
c3 4 vss 0.00497823f $X=0.189 $Y=0.137
r1 1 7 6.74717 $w=2e-08 $layer=Gate_1 $thickness=5.2e-08 $X=0.189 $Y=0.135
+ $X2=0.189 $Y2=0.135
r2 4 1 19.3796 $a=3.24e-16 $layer=V0LIG $X=0.189 $Y=0.137 $X2=0.189 $Y2=0.135
r3 9 8 16.6668 $w=2.1e-08 $l=4.9e-08 $layer=Gate_1 $thickness=5.6e-08 $X=0.189
+ $Y=0.2025 $X2=0.189 $Y2=0.1535
r4 7 8 6.46262 $w=2.04595e-08 $l=1.85e-08 $layer=Gate_1 $thickness=5.6e-08
+ $X=0.189 $Y=0.135 $X2=0.189 $Y2=0.1535
r5 6 7 6.46262 $w=2.04595e-08 $l=1.85e-08 $layer=Gate_1 $thickness=5.6e-08
+ $X=0.189 $Y=0.1165 $X2=0.189 $Y2=0.135
r6 5 6 16.6668 $w=2.1e-08 $l=4.9e-08 $layer=Gate_1 $thickness=5.6e-08 $X=0.189
+ $Y=0.0675 $X2=0.189 $Y2=0.1165
r7 5 3 14.6259 $w=2.1e-08 $l=4.3e-08 $layer=Gate_1 $thickness=5.6e-08 $X=0.189
+ $Y=0.0675 $X2=0.189 $Y2=0.0245
.ends

.subckt PM_AND3x1_ASAP7_75t_R%A vss 15 5 11 3 4 1
c1 1 vss 0.00260083f $X=0.081 $Y=0.135
c2 3 vss 0.0519554f $X=0.081 $Y=0.0245
c3 4 vss 0.0090703f $X=0.081 $Y=0.098
r1 15 4 8.62802 $w=1.3e-08 $l=3.7e-08 $layer=M1 $thickness=3.6e-08 $X=0.084
+ $Y=0.137 $X2=0.081 $Y2=0.098
r2 1 8 6.74717 $w=2e-08 $layer=Gate_1 $thickness=5.2e-08 $X=0.081 $Y=0.135
+ $X2=0.081 $Y2=0.135
r3 15 1 19.3796 $a=3.24e-16 $layer=V0LIG $X=0.084 $Y=0.137 $X2=0.081 $Y2=0.135
r4 11 10 14.6259 $w=2.1e-08 $l=4.3e-08 $layer=Gate_1 $thickness=5.6e-08
+ $X=0.081 $Y=0.2025 $X2=0.081 $Y2=0.1595
r5 9 10 2.89117 $w=2.1e-08 $l=8.5e-09 $layer=Gate_1 $thickness=5.6e-08 $X=0.081
+ $Y=0.151 $X2=0.081 $Y2=0.1595
r6 8 9 5.61228 $w=2.0375e-08 $l=1.6e-08 $layer=Gate_1 $thickness=5.6e-08
+ $X=0.081 $Y=0.135 $X2=0.081 $Y2=0.151
r7 7 8 5.61228 $w=2.0375e-08 $l=1.6e-08 $layer=Gate_1 $thickness=5.6e-08
+ $X=0.081 $Y=0.119 $X2=0.081 $Y2=0.135
r8 6 7 2.89117 $w=2.1e-08 $l=8.5e-09 $layer=Gate_1 $thickness=5.6e-08 $X=0.081
+ $Y=0.1105 $X2=0.081 $Y2=0.119
r9 5 6 14.6259 $w=2.1e-08 $l=4.3e-08 $layer=Gate_1 $thickness=5.6e-08 $X=0.081
+ $Y=0.0675 $X2=0.081 $Y2=0.1105
r10 5 3 14.6259 $w=2.1e-08 $l=4.3e-08 $layer=Gate_1 $thickness=5.6e-08 $X=0.081
+ $Y=0.0675 $X2=0.081 $Y2=0.0245
.ends

* End of included file AND3x1_ASAP7_75t_R.pex.sp.pex

*
.subckt AND3x1_ASAP7_75t_CUSTOM_4_25_0_7 VSS VDD A B C Y
*
* VSS VSS
* VDD VDD
* A A
* B B
* C C
* Y Y
*
*

M0 N_M0_d N_M0_g N_M0_s VSS nmos_rvt L=2e-08 W=8.1e-08 nfin=3 $X=0.071 $Y=0.027
M1 N_M1_d N_M1_g N_M1_s VSS nmos_rvt L=2e-08 W=8.1e-08 nfin=3 $X=0.125 $Y=0.027
M2 VSS N_M2_g N_M2_s VSS nmos_rvt L=2e-08 W=8.1e-08 nfin=3 $X=0.179 $Y=0.027
M3 N_M3_d N_M3_g VSS VSS nmos_rvt L=2e-08 W=8.1e-08 nfin=3 $X=0.233 $Y=0.027
M4 VDD N_M4_g N_M4_s VDD pmos_rvt L=2e-08 W=8.1e-08 nfin=3 $X=0.071 $Y=0.162
M5 N_M5_d N_M5_g VDD VDD pmos_rvt L=2e-08 W=8.1e-08 nfin=3 $X=0.125 $Y=0.162
M6 VDD N_M6_g N_M6_s VDD pmos_rvt L=2e-08 W=8.1e-08 nfin=3 $X=0.179 $Y=0.162
M7 N_M7_d N_M7_g VDD VDD pmos_rvt L=2e-08 W=8.1e-08 nfin=3 $X=0.233 $Y=0.162

* .include "AND3x1_ASAP7_75t_R.pex.sp.pxi"

* Start of included file AND3x1_ASAP7_75t_R.pex.sp.pxi
x_PM_AND3x1_ASAP7_75t_R%8 vss N_M0_d N_M1_s N_8_1 PM_AND3x1_ASAP7_75t_R%8
cc_1 N_8_1 N_A_3 0.0166982f $X=0.108 $Y=0.0675
cc_2 N_8_1 N_B_3 0.0167604f $X=0.108 $Y=0.0675
x_PM_AND3x1_ASAP7_75t_R%9 vss N_M1_d N_M2_s N_9_1 PM_AND3x1_ASAP7_75t_R%9
cc_3 N_9_1 N_B_3 0.016902f $X=0.162 $Y=0.0675
cc_4 N_9_1 N_C_3 0.0168036f $X=0.162 $Y=0.0675
x_PM_AND3x1_ASAP7_75t_R%B vss B N_M1_g N_M5_g N_B_1 N_B_4 N_B_3
+ PM_AND3x1_ASAP7_75t_R%B
cc_5 N_B_1 N_A_3 0.00122364f $X=0.135 $Y=0.135
cc_6 N_B_4 N_A_4 0.00473798f $X=0.135 $Y=0.098
cc_7 N_B_3 N_A_3 0.00594451f $X=0.135 $Y=0.0245
x_PM_AND3x1_ASAP7_75t_R%Y vss Y N_M3_d N_M7_d N_Y_8 N_Y_9 N_Y_13 N_Y_10 N_Y_7
+ PM_AND3x1_ASAP7_75t_R%Y
cc_8 N_Y_8 N_6_22 0.00043132f $X=0.2555 $Y=0.2025
cc_9 N_Y_8 N_6_18 0.000536152f $X=0.2555 $Y=0.2025
cc_10 N_Y_8 N_6_16 0.000553862f $X=0.2555 $Y=0.2025
cc_11 N_Y_8 N_6_1 0.00344962f $X=0.2555 $Y=0.2025
cc_12 N_Y_8 N_6_21 0.00102289f $X=0.2555 $Y=0.2025
cc_13 N_Y_9 N_6_21 0.00254307f $X=0.262 $Y=0.085
cc_14 N_Y_13 N_6_17 0.00284949f $X=0.297 $Y=0.11
cc_15 N_Y_10 N_6_22 0.00338393f $X=0.27 $Y=0.192
cc_16 N_Y_7 N_6_12 0.0149691f $X=0.2555 $Y=0.0675
cc_17 N_Y_8 N_6_12 0.057764f $X=0.2555 $Y=0.2025
x_PM_AND3x1_ASAP7_75t_R%6 vss N_M3_g N_M7_g N_M0_s N_M5_d N_M6_s N_M4_s N_6_4
+ N_6_20 N_6_19 N_6_14 N_6_3 N_6_13 N_6_15 N_6_5 N_6_17 N_6_12 N_6_22 N_6_21
+ N_6_18 N_6_16 N_6_1 PM_AND3x1_ASAP7_75t_R%6
cc_18 N_6_4 N_A_3 0.00222712f $X=0.054 $Y=0.2025
cc_19 N_6_20 N_A_4 0.00120683f $X=0.207 $Y=0.234
cc_20 N_6_19 N_A_4 0.00132107f $X=0.207 $Y=0.036
cc_21 N_6_14 N_A_1 0.00162848f $X=0.056 $Y=0.2025
cc_22 N_6_3 N_A_3 0.00171054f $X=0.054 $Y=0.0675
cc_23 N_6_4 N_A_4 0.00418988f $X=0.054 $Y=0.2025
cc_24 N_6_14 N_A_3 0.0149113f $X=0.056 $Y=0.2025
cc_25 N_6_13 N_A_3 0.0549809f $X=0.056 $Y=0.0675
cc_26 N_6_15 N_B_1 0.000769081f $X=0.1475 $Y=0.2025
cc_27 N_6_5 N_B_3 0.00108635f $X=0.162 $Y=0.2025
cc_28 N_6_20 N_B_4 0.00109314f $X=0.207 $Y=0.234
cc_29 N_6_19 N_B_4 0.00145035f $X=0.207 $Y=0.036
cc_30 N_6_5 N_B_4 0.00319499f $X=0.162 $Y=0.2025
cc_31 N_6_15 N_B_3 0.0357304f $X=0.1475 $Y=0.2025
cc_32 N_6_20 N_C_3 0.000829817f $X=0.207 $Y=0.234
cc_33 N_6_17 N_C_1 0.00091854f $X=0.225 $Y=0.135
cc_34 N_6_19 C 0.00100017f $X=0.207 $Y=0.036
cc_35 N_6_5 N_C_3 0.00107856f $X=0.162 $Y=0.2025
cc_36 N_6_15 N_C_1 0.00131425f $X=0.1475 $Y=0.2025
cc_37 N_6_12 N_C_3 0.00162937f $X=0.243 $Y=0.0245
cc_38 N_6_22 C 0.00213306f $X=0.225 $Y=0.1635
cc_39 N_6_21 C 0.00215791f $X=0.225 $Y=0.11
cc_40 N_6_17 C 0.00770108f $X=0.225 $Y=0.135
cc_41 N_6_15 N_C_3 0.0368919f $X=0.1475 $Y=0.2025
x_PM_AND3x1_ASAP7_75t_R%C vss C N_M2_g N_M6_g N_C_3 N_C_1
+ PM_AND3x1_ASAP7_75t_R%C
cc_42 N_C_3 N_B_1 0.00117832f $X=0.189 $Y=0.0245
cc_43 C N_B_4 0.00454342f $X=0.189 $Y=0.137
cc_44 N_C_3 N_B_3 0.00577787f $X=0.189 $Y=0.0245
x_PM_AND3x1_ASAP7_75t_R%A vss A N_M0_g N_M4_g N_A_3 N_A_4 N_A_1
+ PM_AND3x1_ASAP7_75t_R%A

* End of included file AND3x1_ASAP7_75t_R.pex.sp.pxi
.ends

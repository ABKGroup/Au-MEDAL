.subckt PM_AND2x6_ASAP7_75t_R%7__2 vss 2 3 1
c1 1 vss 0.000802927f $X=0.108 $Y=0.0675
r1 2 1 0.209877 $w=8.1e-08 $l=1.7e-08 $layer=N_src_drn $thickness=1e-09
+ $X=0.0906 $Y=0.0675 $X2=0.108 $Y2=0.0675
r2 3 1 0.209877 $w=8.1e-08 $l=1.7e-08 $layer=N_src_drn $thickness=1e-09
+ $X=0.1253 $Y=0.0675 $X2=0.108 $Y2=0.0675
.ends

.subckt PM_AND2x6_ASAP7_75t_R%A vss 25 12 18 38 41 1 2 9 5 6 10 11
c1 1 vss 0.00447635f $X=0.081 $Y=0.135
c2 2 vss 0.00392176f $X=0.243 $Y=0.135
c3 5 vss 0.0789966f $X=0.081 $Y=0.0245
c4 6 vss 0.0949853f $X=0.243 $Y=0.135
c5 7 vss 0.00410888f $X=0.081 $Y=0.037
c6 8 vss 0.00380397f $X=0.243 $Y=0.0365
c7 9 vss 0.0140723f $X=0.081 $Y=0.0945
c8 10 vss 0.015333f $X=0.092 $Y=0.037
c9 11 vss 0.00567777f $X=0.243 $Y=0.055
r1 41 40 16.8368 $w=2.1e-08 $l=4.95e-08 $layer=Gate_1 $thickness=5.6e-08
+ $X=0.243 $Y=0.216 $X2=0.243 $Y2=0.1665
r2 38 39 16.8368 $w=2.1e-08 $l=4.95e-08 $layer=Gate_1 $thickness=5.6e-08
+ $X=0.243 $Y=0.0675 $X2=0.243 $Y2=0.117
r3 6 39 6.27555 $w=2.05e-08 $l=1.8e-08 $layer=Gate_1 $thickness=5.6e-08
+ $X=0.243 $Y=0.135 $X2=0.243 $Y2=0.117
r4 6 40 10.8674 $w=2.07143e-08 $l=3.15e-08 $layer=Gate_1 $thickness=5.6e-08
+ $X=0.243 $Y=0.135 $X2=0.243 $Y2=0.1665
r5 2 33 19.3796 $a=3.24e-16 $layer=V0LIG $X=0.243 $Y=0.135 $X2=0.243 $Y2=0.135
r6 2 6 7.07951 $w=1.89474e-08 $layer=LIG $thickness=5.17895e-08 $X=0.243
+ $Y=0.135 $X2=0.243 $Y2=0.135
r7 32 33 2.68168 $w=1.3e-08 $l=1.15e-08 $layer=M1 $thickness=3.6e-08 $X=0.243
+ $Y=0.1235 $X2=0.243 $Y2=0.135
r8 31 32 7.22888 $w=1.3e-08 $l=3.1e-08 $layer=M1 $thickness=3.6e-08 $X=0.243
+ $Y=0.0925 $X2=0.243 $Y2=0.1235
r9 11 30 2.14973 $w=1.32632e-08 $l=9.5e-09 $layer=M1 $thickness=3.6e-08
+ $X=0.243 $Y=0.055 $X2=0.243 $Y2=0.0455
r10 11 31 8.74462 $w=1.3e-08 $l=3.75e-08 $layer=M1 $thickness=3.6e-08 $X=0.243
+ $Y=0.055 $X2=0.243 $Y2=0.0925
r11 8 30 0.9184 $w=1.8e-08 $l=9e-09 $layer=M1 $thickness=3.6e-08 $X=0.243
+ $Y=0.0365 $X2=0.243 $Y2=0.0455
r12 29 30 4.24844 $w=1.31351e-08 $l=2.83064e-08 $layer=M1 $thickness=3.6e-08
+ $X=0.216 $Y=0.037 $X2=0.243 $Y2=0.0455
r13 28 29 13.8748 $w=1.3e-08 $l=5.95e-08 $layer=M1 $thickness=3.6e-08 $X=0.1565
+ $Y=0.037 $X2=0.216 $Y2=0.037
r14 27 28 12.1259 $w=1.3e-08 $l=5.2e-08 $layer=M1 $thickness=3.6e-08 $X=0.1045
+ $Y=0.037 $X2=0.1565 $Y2=0.037
r15 10 27 2.91487 $w=1.3e-08 $l=1.25e-08 $layer=M1 $thickness=3.6e-08 $X=0.092
+ $Y=0.037 $X2=0.1045 $Y2=0.037
r16 7 23 2.5483 $w=1.79e-08 $l=1.8e-08 $layer=M1 $thickness=3.6e-08 $X=0.081
+ $Y=0.037 $X2=0.081 $Y2=0.055
r17 7 10 0.915974 $w=1.70909e-08 $l=1.1e-08 $layer=M1 $thickness=3.6e-08
+ $X=0.081 $Y=0.037 $X2=0.092 $Y2=0.037
r18 25 24 4.31401 $w=1.3e-08 $l=1.85e-08 $layer=M1 $thickness=3.6e-08 $X=0.083
+ $Y=0.14 $X2=0.081 $Y2=0.1165
r19 22 23 4.19742 $w=1.3e-08 $l=1.8e-08 $layer=M1 $thickness=3.6e-08 $X=0.081
+ $Y=0.073 $X2=0.081 $Y2=0.055
r20 9 22 5.01358 $w=1.3e-08 $l=2.15e-08 $layer=M1 $thickness=3.6e-08 $X=0.081
+ $Y=0.0945 $X2=0.081 $Y2=0.073
r21 9 24 5.13017 $w=1.3e-08 $l=2.2e-08 $layer=M1 $thickness=3.6e-08 $X=0.081
+ $Y=0.0945 $X2=0.081 $Y2=0.1165
r22 1 15 7.07951 $w=1.89474e-08 $layer=LIG $thickness=5.17895e-08 $X=0.081
+ $Y=0.135 $X2=0.081 $Y2=0.135
r23 25 1 19.3796 $a=3.24e-16 $layer=V0LIG $X=0.083 $Y=0.14 $X2=0.081 $Y2=0.135
r24 18 17 14.6259 $w=2.1e-08 $l=4.3e-08 $layer=Gate_1 $thickness=5.6e-08
+ $X=0.081 $Y=0.216 $X2=0.081 $Y2=0.173
r25 16 17 7.65311 $w=2.1e-08 $l=2.25e-08 $layer=Gate_1 $thickness=5.6e-08
+ $X=0.081 $Y=0.1505 $X2=0.081 $Y2=0.173
r26 15 16 5.4252 $w=2.04194e-08 $l=1.55e-08 $layer=Gate_1 $thickness=5.6e-08
+ $X=0.081 $Y=0.135 $X2=0.081 $Y2=0.1505
r27 14 15 5.4252 $w=2.04194e-08 $l=1.55e-08 $layer=Gate_1 $thickness=5.6e-08
+ $X=0.081 $Y=0.1195 $X2=0.081 $Y2=0.135
r28 13 14 3.06124 $w=2.1e-08 $l=9e-09 $layer=Gate_1 $thickness=5.6e-08 $X=0.081
+ $Y=0.1105 $X2=0.081 $Y2=0.1195
r29 12 13 14.6259 $w=2.1e-08 $l=4.3e-08 $layer=Gate_1 $thickness=5.6e-08
+ $X=0.081 $Y=0.0675 $X2=0.081 $Y2=0.1105
r30 12 5 14.6259 $w=2.1e-08 $l=4.3e-08 $layer=Gate_1 $thickness=5.6e-08
+ $X=0.081 $Y=0.0675 $X2=0.081 $Y2=0.0245
.ends

.subckt PM_AND2x6_ASAP7_75t_R%Y vss 41 34 35 48 49 58 59 62 63 66 67 70 71 22
+ 24 2 29 3 5 6 4 1 28 21 20 19 23
c1 1 vss 0.00874534f $X=0.324 $Y=0.0675
c2 2 vss 0.00825708f $X=0.324 $Y=0.2025
c3 3 vss 0.00878092f $X=0.432 $Y=0.0675
c4 4 vss 0.00878092f $X=0.432 $Y=0.2025
c5 5 vss 0.00924702f $X=0.54 $Y=0.0675
c6 6 vss 0.00924702f $X=0.54 $Y=0.2025
c7 19 vss 0.00429126f $X=0.3095 $Y=0.0675
c8 20 vss 0.00429355f $X=0.4175 $Y=0.0675
c9 21 vss 0.00421919f $X=0.5255 $Y=0.0675
c10 22 vss 0.00430085f $X=0.3095 $Y=0.2025
c11 23 vss 0.00428767f $X=0.4175 $Y=0.2025
c12 24 vss 0.00423254f $X=0.5255 $Y=0.2025
c13 25 vss 0.00200777f $X=0.459 $Y=0.036
c14 26 vss 0.00200777f $X=0.459 $Y=0.234
c15 27 vss 0.0137147f $X=0.3125 $Y=0.036
c16 28 vss 0.0125589f $X=0.3125 $Y=0.234
c17 29 vss 0.00499228f $X=0.459 $Y=0.083
c18 30 vss 0.00887143f $X=0.4995 $Y=0.036
c19 31 vss 0.00887143f $X=0.4995 $Y=0.234
r1 71 69 0.0308642 $w=8.1e-08 $l=2.5e-09 $layer=P_src_drn $thickness=1e-09
+ $X=0.5573 $Y=0.2025 $X2=0.5545 $Y2=0.2025
r2 6 69 0.179012 $w=8.1e-08 $l=1.45e-08 $layer=P_src_drn $thickness=1e-09
+ $X=0.54 $Y=0.2025 $X2=0.5545 $Y2=0.2025
r3 24 6 0.179012 $w=8.1e-08 $l=1.45e-08 $layer=P_src_drn $thickness=1e-09
+ $X=0.5255 $Y=0.2025 $X2=0.54 $Y2=0.2025
r4 70 24 0.0308642 $w=8.1e-08 $l=2.5e-09 $layer=P_src_drn $thickness=1e-09
+ $X=0.5226 $Y=0.2025 $X2=0.5255 $Y2=0.2025
r5 67 65 0.0308642 $w=8.1e-08 $l=2.5e-09 $layer=P_src_drn $thickness=1e-09
+ $X=0.4493 $Y=0.2025 $X2=0.4465 $Y2=0.2025
r6 4 65 0.179012 $w=8.1e-08 $l=1.45e-08 $layer=P_src_drn $thickness=1e-09
+ $X=0.432 $Y=0.2025 $X2=0.4465 $Y2=0.2025
r7 23 4 0.179012 $w=8.1e-08 $l=1.45e-08 $layer=P_src_drn $thickness=1e-09
+ $X=0.4175 $Y=0.2025 $X2=0.432 $Y2=0.2025
r8 66 23 0.0308642 $w=8.1e-08 $l=2.5e-09 $layer=P_src_drn $thickness=1e-09
+ $X=0.4146 $Y=0.2025 $X2=0.4175 $Y2=0.2025
r9 63 61 0.0308642 $w=8.1e-08 $l=2.5e-09 $layer=P_src_drn $thickness=1e-09
+ $X=0.3413 $Y=0.2025 $X2=0.3385 $Y2=0.2025
r10 2 61 0.179012 $w=8.1e-08 $l=1.45e-08 $layer=P_src_drn $thickness=1e-09
+ $X=0.324 $Y=0.2025 $X2=0.3385 $Y2=0.2025
r11 22 2 0.179012 $w=8.1e-08 $l=1.45e-08 $layer=P_src_drn $thickness=1e-09
+ $X=0.3095 $Y=0.2025 $X2=0.324 $Y2=0.2025
r12 62 22 0.0308642 $w=8.1e-08 $l=2.5e-09 $layer=P_src_drn $thickness=1e-09
+ $X=0.3066 $Y=0.2025 $X2=0.3095 $Y2=0.2025
r13 6 54 19.3796 $a=3.24e-16 $layer=V0LISD $X=0.54 $Y=0.2025 $X2=0.54 $Y2=0.234
r14 4 52 19.3796 $a=3.24e-16 $layer=V0LISD $X=0.432 $Y=0.2025 $X2=0.432
+ $Y2=0.234
r15 2 50 19.3796 $a=3.24e-16 $layer=V0LISD $X=0.324 $Y=0.2025 $X2=0.324
+ $Y2=0.234
r16 59 57 0.0308642 $w=8.1e-08 $l=2.5e-09 $layer=N_src_drn $thickness=1e-09
+ $X=0.5573 $Y=0.0675 $X2=0.5545 $Y2=0.0675
r17 5 57 0.179012 $w=8.1e-08 $l=1.45e-08 $layer=N_src_drn $thickness=1e-09
+ $X=0.54 $Y=0.0675 $X2=0.5545 $Y2=0.0675
r18 21 5 0.179012 $w=8.1e-08 $l=1.45e-08 $layer=N_src_drn $thickness=1e-09
+ $X=0.5255 $Y=0.0675 $X2=0.54 $Y2=0.0675
r19 58 21 0.0308642 $w=8.1e-08 $l=2.5e-09 $layer=N_src_drn $thickness=1e-09
+ $X=0.5226 $Y=0.0675 $X2=0.5255 $Y2=0.0675
r20 31 54 9.44419 $w=1.3e-08 $l=4.05e-08 $layer=M1 $thickness=3.6e-08 $X=0.4995
+ $Y=0.234 $X2=0.54 $Y2=0.234
r21 52 53 3.14806 $w=1.3e-08 $l=1.35e-08 $layer=M1 $thickness=3.6e-08 $X=0.432
+ $Y=0.234 $X2=0.4455 $Y2=0.234
r22 51 52 12.5922 $w=1.3e-08 $l=5.4e-08 $layer=M1 $thickness=3.6e-08 $X=0.378
+ $Y=0.234 $X2=0.432 $Y2=0.234
r23 50 51 12.5922 $w=1.3e-08 $l=5.4e-08 $layer=M1 $thickness=3.6e-08 $X=0.324
+ $Y=0.234 $X2=0.378 $Y2=0.234
r24 28 50 2.68168 $w=1.3e-08 $l=1.15e-08 $layer=M1 $thickness=3.6e-08 $X=0.3125
+ $Y=0.234 $X2=0.324 $Y2=0.234
r25 5 44 19.3796 $a=3.24e-16 $layer=V0LISD $X=0.54 $Y=0.0675 $X2=0.54 $Y2=0.036
r26 26 43 3.83327 $w=1.5093e-08 $l=2.15e-08 $layer=M1 $thickness=3.6e-08
+ $X=0.459 $Y=0.234 $X2=0.459 $Y2=0.2125
r27 26 53 1.96775 $w=1.63333e-08 $l=1.35e-08 $layer=M1 $thickness=3.6e-08
+ $X=0.459 $Y=0.234 $X2=0.4455 $Y2=0.234
r28 26 31 8.26388 $w=1.41111e-08 $l=4.05e-08 $layer=M1 $thickness=3.6e-08
+ $X=0.459 $Y=0.234 $X2=0.4995 $Y2=0.234
r29 49 47 0.0308642 $w=8.1e-08 $l=2.5e-09 $layer=N_src_drn $thickness=1e-09
+ $X=0.4493 $Y=0.0675 $X2=0.4465 $Y2=0.0675
r30 3 47 0.179012 $w=8.1e-08 $l=1.45e-08 $layer=N_src_drn $thickness=1e-09
+ $X=0.432 $Y=0.0675 $X2=0.4465 $Y2=0.0675
r31 20 3 0.179012 $w=8.1e-08 $l=1.45e-08 $layer=N_src_drn $thickness=1e-09
+ $X=0.4175 $Y=0.0675 $X2=0.432 $Y2=0.0675
r32 48 20 0.0308642 $w=8.1e-08 $l=2.5e-09 $layer=N_src_drn $thickness=1e-09
+ $X=0.4146 $Y=0.0675 $X2=0.4175 $Y2=0.0675
r33 30 44 9.44419 $w=1.3e-08 $l=4.05e-08 $layer=M1 $thickness=3.6e-08 $X=0.4995
+ $Y=0.036 $X2=0.54 $Y2=0.036
r34 42 43 8.97781 $w=1.3e-08 $l=3.85e-08 $layer=M1 $thickness=3.6e-08 $X=0.459
+ $Y=0.174 $X2=0.459 $Y2=0.2125
r35 41 42 6.17953 $w=1.3e-08 $l=2.65e-08 $layer=M1 $thickness=3.6e-08 $X=0.4615
+ $Y=0.1475 $X2=0.459 $Y2=0.174
r36 41 40 3.14806 $w=1.3e-08 $l=1.35e-08 $layer=M1 $thickness=3.6e-08 $X=0.4615
+ $Y=0.1475 $X2=0.459 $Y2=0.134
r37 29 40 11.8927 $w=1.3e-08 $l=5.1e-08 $layer=M1 $thickness=3.6e-08 $X=0.459
+ $Y=0.083 $X2=0.459 $Y2=0.134
r38 3 38 19.3796 $a=3.24e-16 $layer=V0LISD $X=0.432 $Y=0.0675 $X2=0.432
+ $Y2=0.036
r39 25 39 1.96775 $w=1.63333e-08 $l=1.35e-08 $layer=M1 $thickness=3.6e-08
+ $X=0.459 $Y=0.036 $X2=0.4455 $Y2=0.036
r40 25 29 9.77961 $w=1.39574e-08 $l=4.7e-08 $layer=M1 $thickness=3.6e-08
+ $X=0.459 $Y=0.036 $X2=0.459 $Y2=0.083
r41 25 30 8.26388 $w=1.41111e-08 $l=4.05e-08 $layer=M1 $thickness=3.6e-08
+ $X=0.459 $Y=0.036 $X2=0.4995 $Y2=0.036
r42 38 39 3.14806 $w=1.3e-08 $l=1.35e-08 $layer=M1 $thickness=3.6e-08 $X=0.432
+ $Y=0.036 $X2=0.4455 $Y2=0.036
r43 37 38 12.5922 $w=1.3e-08 $l=5.4e-08 $layer=M1 $thickness=3.6e-08 $X=0.378
+ $Y=0.036 $X2=0.432 $Y2=0.036
r44 36 37 12.5922 $w=1.3e-08 $l=5.4e-08 $layer=M1 $thickness=3.6e-08 $X=0.324
+ $Y=0.036 $X2=0.378 $Y2=0.036
r45 27 36 2.68168 $w=1.3e-08 $l=1.15e-08 $layer=M1 $thickness=3.6e-08 $X=0.3125
+ $Y=0.036 $X2=0.324 $Y2=0.036
r46 1 36 19.3796 $a=3.24e-16 $layer=V0LISD $X=0.324 $Y=0.0675 $X2=0.324
+ $Y2=0.036
r47 35 33 0.0308642 $w=8.1e-08 $l=2.5e-09 $layer=N_src_drn $thickness=1e-09
+ $X=0.3413 $Y=0.0675 $X2=0.3385 $Y2=0.0675
r48 1 33 0.179012 $w=8.1e-08 $l=1.45e-08 $layer=N_src_drn $thickness=1e-09
+ $X=0.324 $Y=0.0675 $X2=0.3385 $Y2=0.0675
r49 19 1 0.179012 $w=8.1e-08 $l=1.45e-08 $layer=N_src_drn $thickness=1e-09
+ $X=0.3095 $Y=0.0675 $X2=0.324 $Y2=0.0675
r50 34 19 0.0308642 $w=8.1e-08 $l=2.5e-09 $layer=N_src_drn $thickness=1e-09
+ $X=0.3066 $Y=0.0675 $X2=0.3095 $Y2=0.0675
.ends

.subckt PM_AND2x6_ASAP7_75t_R%5 vss 31 35 55 58 61 64 67 70 73 76 80 84 107 108
+ 111 112 115 116 22 3 18 20 19 5 1 4 25 29 30 26 27 12 21 16 13 24 14 15 17
c1 1 vss 0.0284959f $X=0.2875 $Y=0.135
c2 3 vss 0.0118075f $X=0.108 $Y=0.216
c3 4 vss 0.00761937f $X=0.162 $Y=0.0675
c4 5 vss 0.0116345f $X=0.216 $Y=0.216
c5 12 vss 0.0864576f $X=0.297 $Y=0.0245
c6 13 vss 0.0824965f $X=0.351 $Y=0.135
c7 14 vss 0.0824905f $X=0.405 $Y=0.135
c8 15 vss 0.0823455f $X=0.459 $Y=0.135
c9 16 vss 0.0828037f $X=0.513 $Y=0.135
c10 17 vss 0.0833182f $X=0.567 $Y=0.135
c11 18 vss 0.0085679f $X=0.1475 $Y=0.0675
c12 19 vss 0.00959279f $X=0.0935 $Y=0.216
c13 20 vss 0.0097978f $X=0.2015 $Y=0.216
c14 21 vss 0.00235526f $X=0.1885 $Y=0.191
c15 22 vss 0.00235574f $X=0.189 $Y=0.073
c16 23 vss 0.00731688f $X=0.189 $Y=0.234
c17 24 vss 0.00283054f $X=0.297 $Y=0.191
c18 25 vss 0.0104152f $X=0.1795 $Y=0.234
c19 26 vss 0.00286569f $X=0.1795 $Y=0.073
c20 27 vss 0.00293848f $X=0.189 $Y=0.166
c21 28 vss 0.00263294f $X=0.189 $Y=0.2125
c22 29 vss 0.00481614f $X=0.27 $Y=0.191
c23 30 vss 0.00347578f $X=0.297 $Y=0.1235
r1 116 114 0.0462963 $w=5.4e-08 $l=2.5e-09 $layer=P_src_drn $thickness=1e-09
+ $X=0.1253 $Y=0.216 $X2=0.1225 $Y2=0.216
r2 3 114 0.268519 $w=5.4e-08 $l=1.45e-08 $layer=P_src_drn $thickness=1e-09
+ $X=0.108 $Y=0.216 $X2=0.1225 $Y2=0.216
r3 19 3 0.268519 $w=5.4e-08 $l=1.45e-08 $layer=P_src_drn $thickness=1e-09
+ $X=0.0935 $Y=0.216 $X2=0.108 $Y2=0.216
r4 115 19 0.0462963 $w=5.4e-08 $l=2.5e-09 $layer=P_src_drn $thickness=1e-09
+ $X=0.0906 $Y=0.216 $X2=0.0935 $Y2=0.216
r5 112 110 0.0308642 $w=8.1e-08 $l=2.5e-09 $layer=N_src_drn $thickness=1e-09
+ $X=0.1793 $Y=0.0675 $X2=0.1765 $Y2=0.0675
r6 4 110 0.179012 $w=8.1e-08 $l=1.45e-08 $layer=N_src_drn $thickness=1e-09
+ $X=0.162 $Y=0.0675 $X2=0.1765 $Y2=0.0675
r7 18 4 0.179012 $w=8.1e-08 $l=1.45e-08 $layer=N_src_drn $thickness=1e-09
+ $X=0.1475 $Y=0.0675 $X2=0.162 $Y2=0.0675
r8 111 18 0.0308642 $w=8.1e-08 $l=2.5e-09 $layer=N_src_drn $thickness=1e-09
+ $X=0.1446 $Y=0.0675 $X2=0.1475 $Y2=0.0675
r9 108 106 0.0462963 $w=5.4e-08 $l=2.5e-09 $layer=P_src_drn $thickness=1e-09
+ $X=0.2333 $Y=0.216 $X2=0.2305 $Y2=0.216
r10 5 106 0.268519 $w=5.4e-08 $l=1.45e-08 $layer=P_src_drn $thickness=1e-09
+ $X=0.216 $Y=0.216 $X2=0.2305 $Y2=0.216
r11 20 5 0.268519 $w=5.4e-08 $l=1.45e-08 $layer=P_src_drn $thickness=1e-09
+ $X=0.2015 $Y=0.216 $X2=0.216 $Y2=0.216
r12 107 20 0.0462963 $w=5.4e-08 $l=2.5e-09 $layer=P_src_drn $thickness=1e-09
+ $X=0.1986 $Y=0.216 $X2=0.2015 $Y2=0.216
r13 3 104 19.3796 $a=3.24e-16 $layer=V0LISD $X=0.108 $Y=0.216 $X2=0.107
+ $Y2=0.234
r14 4 95 19.3796 $a=3.24e-16 $layer=V0LISD $X=0.162 $Y=0.0675 $X2=0.162
+ $Y2=0.073
r15 5 92 19.3796 $a=3.24e-16 $layer=V0LISD $X=0.216 $Y=0.216 $X2=0.216 $Y2=0.234
r16 101 102 1.28254 $w=1.3e-08 $l=5.5e-09 $layer=M1 $thickness=3.6e-08 $X=0.116
+ $Y=0.234 $X2=0.1215 $Y2=0.234
r17 101 104 2.09871 $w=1.3e-08 $l=9e-09 $layer=M1 $thickness=3.6e-08 $X=0.116
+ $Y=0.234 $X2=0.107 $Y2=0.234
r18 100 102 3.14806 $w=1.3e-08 $l=1.35e-08 $layer=M1 $thickness=3.6e-08
+ $X=0.135 $Y=0.234 $X2=0.1215 $Y2=0.234
r19 99 100 6.17953 $w=1.3e-08 $l=2.65e-08 $layer=M1 $thickness=3.6e-08
+ $X=0.1615 $Y=0.234 $X2=0.135 $Y2=0.234
r20 25 99 4.19742 $w=1.3e-08 $l=1.8e-08 $layer=M1 $thickness=3.6e-08 $X=0.1795
+ $Y=0.234 $X2=0.1615 $Y2=0.234
r21 95 96 3.03147 $w=1.3e-08 $l=1.3e-08 $layer=M1 $thickness=3.6e-08 $X=0.162
+ $Y=0.073 $X2=0.175 $Y2=0.073
r22 26 96 1.04935 $w=1.3e-08 $l=4.5e-09 $layer=M1 $thickness=3.6e-08 $X=0.1795
+ $Y=0.073 $X2=0.175 $Y2=0.073
r23 91 92 3.14806 $w=1.3e-08 $l=1.35e-08 $layer=M1 $thickness=3.6e-08 $X=0.2025
+ $Y=0.234 $X2=0.216 $Y2=0.234
r24 23 28 3.83327 $w=1.5093e-08 $l=2.15e-08 $layer=M1 $thickness=3.6e-08
+ $X=0.189 $Y=0.234 $X2=0.189 $Y2=0.2125
r25 23 91 1.96775 $w=1.63333e-08 $l=1.35e-08 $layer=M1 $thickness=3.6e-08
+ $X=0.189 $Y=0.234 $X2=0.2025 $Y2=0.234
r26 23 25 1.03499 $w=1.77368e-08 $l=9.5e-09 $layer=M1 $thickness=3.6e-08
+ $X=0.189 $Y=0.234 $X2=0.1795 $Y2=0.234
r27 22 90 3.36447 $w=1.71023e-08 $l=2.15e-08 $layer=M1 $thickness=3.6e-08
+ $X=0.189 $Y=0.073 $X2=0.189 $Y2=0.0945
r28 22 26 0.56619 $w=1.77368e-08 $l=9.5e-09 $layer=M1 $thickness=3.6e-08
+ $X=0.189 $Y=0.073 $X2=0.1795 $Y2=0.073
r29 89 90 7.92845 $w=1.3e-08 $l=3.4e-08 $layer=M1 $thickness=3.6e-08 $X=0.189
+ $Y=0.1285 $X2=0.189 $Y2=0.0945
r30 27 89 8.74462 $w=1.3e-08 $l=3.75e-08 $layer=M1 $thickness=3.6e-08 $X=0.189
+ $Y=0.166 $X2=0.189 $Y2=0.1285
r31 21 88 4.79259 $w=1.48269e-08 $l=2.6e-08 $layer=M1 $thickness=3.6e-08
+ $X=0.1885 $Y=0.191 $X2=0.2145 $Y2=0.191
r32 21 27 4.67599 $w=1.48627e-08 $l=2.5005e-08 $layer=M1 $thickness=3.6e-08
+ $X=0.1885 $Y=0.191 $X2=0.189 $Y2=0.166
r33 21 28 3.85983 $w=1.51591e-08 $l=2.15058e-08 $layer=M1 $thickness=3.6e-08
+ $X=0.1885 $Y=0.191 $X2=0.189 $Y2=0.2125
r34 87 88 4.19742 $w=1.3e-08 $l=1.8e-08 $layer=M1 $thickness=3.6e-08 $X=0.2325
+ $Y=0.191 $X2=0.2145 $Y2=0.191
r35 86 87 2.44849 $w=1.3e-08 $l=1.05e-08 $layer=M1 $thickness=3.6e-08 $X=0.243
+ $Y=0.191 $X2=0.2325 $Y2=0.191
r36 29 86 6.29612 $w=1.3e-08 $l=2.7e-08 $layer=M1 $thickness=3.6e-08 $X=0.27
+ $Y=0.191 $X2=0.243 $Y2=0.191
r37 24 53 4.18063 $w=1.6528e-08 $l=2.5e-08 $layer=M1 $thickness=3.6e-08
+ $X=0.297 $Y=0.191 $X2=0.297 $Y2=0.166
r38 24 29 4.64701 $w=1.46667e-08 $l=2.7e-08 $layer=M1 $thickness=3.6e-08
+ $X=0.297 $Y=0.191 $X2=0.27 $Y2=0.191
r39 84 83 14.6259 $w=2.1e-08 $l=4.3e-08 $layer=Gate_1 $thickness=5.6e-08
+ $X=0.567 $Y=0.2025 $X2=0.567 $Y2=0.1595
r40 82 83 2.7211 $w=2.1e-08 $l=8e-09 $layer=Gate_1 $thickness=5.6e-08 $X=0.567
+ $Y=0.1515 $X2=0.567 $Y2=0.1595
r41 80 81 14.6259 $w=2.1e-08 $l=4.3e-08 $layer=Gate_1 $thickness=5.6e-08
+ $X=0.567 $Y=0.0675 $X2=0.567 $Y2=0.1105
r42 78 81 2.7211 $w=2.1e-08 $l=8e-09 $layer=Gate_1 $thickness=5.6e-08 $X=0.567
+ $Y=0.1185 $X2=0.567 $Y2=0.1105
r43 17 49 6.54019 $w=2.09524e-08 $layer=Gate_1 $thickness=5.21905e-08 $X=0.567
+ $Y=0.135 $X2=0.567 $Y2=0.135
r44 17 78 5.79936 $w=2.03333e-08 $l=1.65e-08 $layer=Gate_1 $thickness=5.6e-08
+ $X=0.567 $Y=0.135 $X2=0.567 $Y2=0.1185
r45 17 82 5.79936 $w=2.03333e-08 $l=1.65e-08 $layer=Gate_1 $thickness=5.6e-08
+ $X=0.567 $Y=0.135 $X2=0.567 $Y2=0.1515
r46 76 75 16.4967 $w=2.1e-08 $l=4.85e-08 $layer=Gate_1 $thickness=5.6e-08
+ $X=0.513 $Y=0.2025 $X2=0.513 $Y2=0.154
r47 73 74 16.4967 $w=2.1e-08 $l=4.85e-08 $layer=Gate_1 $thickness=5.6e-08
+ $X=0.513 $Y=0.0675 $X2=0.513 $Y2=0.116
r48 16 47 6.54019 $w=2.09524e-08 $layer=Gate_1 $thickness=5.21905e-08 $X=0.513
+ $Y=0.135 $X2=0.513 $Y2=0.135
r49 16 74 6.6497 $w=2.04211e-08 $l=1.9e-08 $layer=Gate_1 $thickness=5.6e-08
+ $X=0.513 $Y=0.135 $X2=0.513 $Y2=0.116
r50 16 75 6.6497 $w=2.04211e-08 $l=1.9e-08 $layer=Gate_1 $thickness=5.6e-08
+ $X=0.513 $Y=0.135 $X2=0.513 $Y2=0.154
r51 70 69 16.4967 $w=2.1e-08 $l=4.85e-08 $layer=Gate_1 $thickness=5.6e-08
+ $X=0.459 $Y=0.2025 $X2=0.459 $Y2=0.154
r52 67 68 16.4967 $w=2.1e-08 $l=4.85e-08 $layer=Gate_1 $thickness=5.6e-08
+ $X=0.459 $Y=0.0675 $X2=0.459 $Y2=0.116
r53 15 45 6.54019 $w=2.09524e-08 $layer=Gate_1 $thickness=5.21905e-08 $X=0.459
+ $Y=0.135 $X2=0.459 $Y2=0.135
r54 15 68 6.6497 $w=2.04211e-08 $l=1.9e-08 $layer=Gate_1 $thickness=5.6e-08
+ $X=0.459 $Y=0.135 $X2=0.459 $Y2=0.116
r55 15 69 6.6497 $w=2.04211e-08 $l=1.9e-08 $layer=Gate_1 $thickness=5.6e-08
+ $X=0.459 $Y=0.135 $X2=0.459 $Y2=0.154
r56 64 63 16.4967 $w=2.1e-08 $l=4.85e-08 $layer=Gate_1 $thickness=5.6e-08
+ $X=0.405 $Y=0.2025 $X2=0.405 $Y2=0.154
r57 61 62 16.4967 $w=2.1e-08 $l=4.85e-08 $layer=Gate_1 $thickness=5.6e-08
+ $X=0.405 $Y=0.0675 $X2=0.405 $Y2=0.116
r58 14 43 6.54019 $w=2.09524e-08 $layer=Gate_1 $thickness=5.21905e-08 $X=0.405
+ $Y=0.135 $X2=0.405 $Y2=0.135
r59 14 62 6.6497 $w=2.04211e-08 $l=1.9e-08 $layer=Gate_1 $thickness=5.6e-08
+ $X=0.405 $Y=0.135 $X2=0.405 $Y2=0.116
r60 14 63 6.6497 $w=2.04211e-08 $l=1.9e-08 $layer=Gate_1 $thickness=5.6e-08
+ $X=0.405 $Y=0.135 $X2=0.405 $Y2=0.154
r61 58 57 16.4967 $w=2.1e-08 $l=4.85e-08 $layer=Gate_1 $thickness=5.6e-08
+ $X=0.351 $Y=0.2025 $X2=0.351 $Y2=0.154
r62 55 56 16.4967 $w=2.1e-08 $l=4.85e-08 $layer=Gate_1 $thickness=5.6e-08
+ $X=0.351 $Y=0.0675 $X2=0.351 $Y2=0.116
r63 13 41 6.54019 $w=2.09524e-08 $layer=Gate_1 $thickness=5.21905e-08 $X=0.351
+ $Y=0.135 $X2=0.351 $Y2=0.135
r64 13 56 6.6497 $w=2.04211e-08 $l=1.9e-08 $layer=Gate_1 $thickness=5.6e-08
+ $X=0.351 $Y=0.135 $X2=0.351 $Y2=0.116
r65 13 57 6.6497 $w=2.04211e-08 $l=1.9e-08 $layer=Gate_1 $thickness=5.6e-08
+ $X=0.351 $Y=0.135 $X2=0.351 $Y2=0.154
r66 52 53 4.43061 $w=1.3e-08 $l=1.9e-08 $layer=M1 $thickness=3.6e-08 $X=0.297
+ $Y=0.147 $X2=0.297 $Y2=0.166
r67 51 52 2.79828 $w=1.3e-08 $l=1.2e-08 $layer=M1 $thickness=3.6e-08 $X=0.297
+ $Y=0.135 $X2=0.297 $Y2=0.147
r68 30 51 2.68168 $w=1.3e-08 $l=1.15e-08 $layer=M1 $thickness=3.6e-08 $X=0.297
+ $Y=0.1235 $X2=0.297 $Y2=0.135
r69 48 49 12.6539 $w=1.77815e-08 $l=2.7e-08 $layer=LIG $thickness=4.8e-08
+ $X=0.54 $Y=0.135 $X2=0.567 $Y2=0.135
r70 47 48 12.6539 $w=1.77815e-08 $l=2.7e-08 $layer=LIG $thickness=4.8e-08
+ $X=0.513 $Y=0.135 $X2=0.54 $Y2=0.135
r71 46 47 12.6539 $w=1.77815e-08 $l=2.7e-08 $layer=LIG $thickness=4.8e-08
+ $X=0.486 $Y=0.135 $X2=0.513 $Y2=0.135
r72 45 46 12.6539 $w=1.77815e-08 $l=2.7e-08 $layer=LIG $thickness=4.8e-08
+ $X=0.459 $Y=0.135 $X2=0.486 $Y2=0.135
r73 44 45 12.6539 $w=1.77815e-08 $l=2.7e-08 $layer=LIG $thickness=4.8e-08
+ $X=0.432 $Y=0.135 $X2=0.459 $Y2=0.135
r74 43 44 12.6539 $w=1.77815e-08 $l=2.7e-08 $layer=LIG $thickness=4.8e-08
+ $X=0.405 $Y=0.135 $X2=0.432 $Y2=0.135
r75 42 43 12.6539 $w=1.77815e-08 $l=2.7e-08 $layer=LIG $thickness=4.8e-08
+ $X=0.378 $Y=0.135 $X2=0.405 $Y2=0.135
r76 41 42 12.6539 $w=1.77815e-08 $l=2.7e-08 $layer=LIG $thickness=4.8e-08
+ $X=0.351 $Y=0.135 $X2=0.378 $Y2=0.135
r77 40 41 12.6539 $w=1.77815e-08 $l=2.7e-08 $layer=LIG $thickness=4.8e-08
+ $X=0.324 $Y=0.135 $X2=0.351 $Y2=0.135
r78 38 40 10.1729 $w=1.54914e-08 $l=1.75e-08 $layer=LIG $thickness=4.8e-08
+ $X=0.3065 $Y=0.135 $X2=0.324 $Y2=0.135
r79 37 38 2.48102 $w=2.2e-08 $l=9.5e-09 $layer=LIG $thickness=4.8e-08 $X=0.297
+ $Y=0.135 $X2=0.3065 $Y2=0.135
r80 37 51 19.3796 $a=3.24e-16 $layer=V0LIG $X=0.297 $Y=0.135 $X2=0.297 $Y2=0.135
r81 1 37 2.48102 $w=2.2e-08 $l=9.5e-09 $layer=LIG $thickness=4.8e-08 $X=0.2875
+ $Y=0.135 $X2=0.297 $Y2=0.135
r82 35 34 16.4967 $w=2.1e-08 $l=4.85e-08 $layer=Gate_1 $thickness=5.6e-08
+ $X=0.297 $Y=0.2025 $X2=0.297 $Y2=0.154
r83 33 34 6.6497 $w=2.04211e-08 $l=1.9e-08 $layer=Gate_1 $thickness=5.6e-08
+ $X=0.297 $Y=0.135 $X2=0.297 $Y2=0.154
r84 33 38 4.05918 $w=2.0087e-08 $l=9.5e-09 $layer=Gate_1 $thickness=5.56522e-08
+ $X=0.297 $Y=0.135 $X2=0.3065 $Y2=0.135
r85 33 37 6.27904 $w=2.09e-08 $layer=Gate_1 $thickness=5.24e-08 $X=0.297
+ $Y=0.135 $X2=0.297 $Y2=0.135
r86 32 33 6.6497 $w=2.04211e-08 $l=1.9e-08 $layer=Gate_1 $thickness=5.6e-08
+ $X=0.297 $Y=0.116 $X2=0.297 $Y2=0.135
r87 31 32 16.4967 $w=2.1e-08 $l=4.85e-08 $layer=Gate_1 $thickness=5.6e-08
+ $X=0.297 $Y=0.0675 $X2=0.297 $Y2=0.116
r88 31 12 14.6259 $w=2.1e-08 $l=4.3e-08 $layer=Gate_1 $thickness=5.6e-08
+ $X=0.297 $Y=0.0675 $X2=0.297 $Y2=0.0245
.ends

.subckt PM_AND2x6_ASAP7_75t_R%8 vss 2 3 1
c1 1 vss 0.000763199f $X=0.216 $Y=0.0675
r1 2 1 0.209877 $w=8.1e-08 $l=1.7e-08 $layer=N_src_drn $thickness=1e-09
+ $X=0.1986 $Y=0.0675 $X2=0.216 $Y2=0.0675
r2 3 1 0.209877 $w=8.1e-08 $l=1.7e-08 $layer=N_src_drn $thickness=1e-09
+ $X=0.2333 $Y=0.0675 $X2=0.216 $Y2=0.0675
.ends

.subckt PM_AND2x6_ASAP7_75t_R%B vss 20 6 10 24 27 1 5 3 4
c1 1 vss 0.0108115f $X=0.1255 $Y=0.135
c2 3 vss 0.039416f $X=0.135 $Y=0.0245
c3 4 vss 0.0395616f $X=0.189 $Y=0.135
c4 5 vss 0.00590918f $X=0.135 $Y=0.1165
r1 27 26 16.8368 $w=2.1e-08 $l=4.95e-08 $layer=Gate_1 $thickness=5.6e-08
+ $X=0.189 $Y=0.216 $X2=0.189 $Y2=0.1665
r2 24 25 16.8368 $w=2.1e-08 $l=4.95e-08 $layer=Gate_1 $thickness=5.6e-08
+ $X=0.189 $Y=0.0675 $X2=0.189 $Y2=0.117
r3 4 16 7.07951 $w=1.89474e-08 $layer=LIG $thickness=5.17895e-08 $X=0.189
+ $Y=0.135 $X2=0.189 $Y2=0.135
r4 4 25 6.27555 $w=2.05e-08 $l=1.8e-08 $layer=Gate_1 $thickness=5.6e-08
+ $X=0.189 $Y=0.135 $X2=0.189 $Y2=0.117
r5 4 26 10.8674 $w=2.07143e-08 $l=3.15e-08 $layer=Gate_1 $thickness=5.6e-08
+ $X=0.189 $Y=0.135 $X2=0.189 $Y2=0.1665
r6 20 19 0.991056 $w=1.3e-08 $l=4.3e-09 $layer=M1 $thickness=3.6e-08 $X=0.135
+ $Y=0.152 $X2=0.135 $Y2=0.1477
r7 18 19 2.97317 $w=1.3e-08 $l=1.27e-08 $layer=M1 $thickness=3.6e-08 $X=0.135
+ $Y=0.135 $X2=0.135 $Y2=0.1477
r8 5 18 4.31401 $w=1.3e-08 $l=1.85e-08 $layer=M1 $thickness=3.6e-08 $X=0.135
+ $Y=0.1165 $X2=0.135 $Y2=0.135
r9 15 16 30.1405 $w=1.37815e-08 $l=2.7e-08 $layer=LIG $thickness=4.8e-08
+ $X=0.162 $Y=0.135 $X2=0.189 $Y2=0.135
r10 13 15 26.4685 $w=1.14914e-08 $l=1.75e-08 $layer=LIG $thickness=4.8e-08
+ $X=0.1445 $Y=0.135 $X2=0.162 $Y2=0.135
r11 12 13 3.67195 $w=1.8e-08 $l=9.5e-09 $layer=LIG $thickness=4.8e-08 $X=0.135
+ $Y=0.135 $X2=0.1445 $Y2=0.135
r12 12 18 19.3796 $a=3.24e-16 $layer=V0LIG $X=0.135 $Y=0.135 $X2=0.135 $Y2=0.135
r13 1 12 3.67195 $w=1.8e-08 $l=9.5e-09 $layer=LIG $thickness=4.8e-08 $X=0.1255
+ $Y=0.135 $X2=0.135 $Y2=0.135
r14 10 9 16.8368 $w=2.1e-08 $l=4.95e-08 $layer=Gate_1 $thickness=5.6e-08
+ $X=0.135 $Y=0.216 $X2=0.135 $Y2=0.1665
r15 8 9 10.8674 $w=2.07143e-08 $l=3.15e-08 $layer=Gate_1 $thickness=5.6e-08
+ $X=0.135 $Y=0.135 $X2=0.135 $Y2=0.1665
r16 8 13 3.40757 $w=1.98947e-08 $l=9.5e-09 $layer=Gate_1 $thickness=5.55789e-08
+ $X=0.135 $Y=0.135 $X2=0.1445 $Y2=0.135
r17 8 12 6.69299 $w=1.9e-08 $layer=LIG $thickness=5.2e-08 $X=0.135 $Y=0.135
+ $X2=0.135 $Y2=0.135
r18 7 8 6.27555 $w=2.05e-08 $l=1.8e-08 $layer=Gate_1 $thickness=5.6e-08
+ $X=0.135 $Y=0.117 $X2=0.135 $Y2=0.135
r19 6 7 16.8368 $w=2.1e-08 $l=4.95e-08 $layer=Gate_1 $thickness=5.6e-08
+ $X=0.135 $Y=0.0675 $X2=0.135 $Y2=0.117
r20 6 3 14.6259 $w=2.1e-08 $l=4.3e-08 $layer=Gate_1 $thickness=5.6e-08 $X=0.135
+ $Y=0.0675 $X2=0.135 $Y2=0.0245
.ends

* End of included file AND2x6_ASAP7_75t_R.pex.sp.pex

*
.subckt AND2x6_ASAP7_75t_CUSTOM_4_25_0_7 VSS VDD A B Y
*
* VSS VSS
* VDD VDD
* A A
* B B
* Y Y
*
*

M0 VSS N_M0_g N_M0_s VSS nmos_rvt L=2e-08 W=8.1e-08 nfin=3 $X=0.071 $Y=0.027
M1 N_M1_d N_M1_g N_M1_s VSS nmos_rvt L=2e-08 W=8.1e-08 nfin=3 $X=0.125 $Y=0.027
M2 N_M2_d N_M2_g N_M2_s VSS nmos_rvt L=2e-08 W=8.1e-08 nfin=3 $X=0.179 $Y=0.027
M3 VSS N_M3_g N_M3_s VSS nmos_rvt L=2e-08 W=8.1e-08 nfin=3 $X=0.233 $Y=0.027
M4 N_M4_d N_M4_g VSS VSS nmos_rvt L=2e-08 W=8.1e-08 nfin=3 $X=0.287 $Y=0.027
M5 N_M5_d N_M5_g VSS VSS nmos_rvt L=2e-08 W=8.1e-08 nfin=3 $X=0.341 $Y=0.027
M6 N_M6_d N_M6_g VSS VSS nmos_rvt L=2e-08 W=8.1e-08 nfin=3 $X=0.395 $Y=0.027
M7 N_M7_d N_M7_g VSS VSS nmos_rvt L=2e-08 W=8.1e-08 nfin=3 $X=0.449 $Y=0.027
M8 N_M8_d N_M8_g VSS VSS nmos_rvt L=2e-08 W=8.1e-08 nfin=3 $X=0.503 $Y=0.027
M9 N_M9_d N_M9_g VSS VSS nmos_rvt L=2e-08 W=8.1e-08 nfin=3 $X=0.557 $Y=0.027
M10 N_M10_d N_M10_g VDD VDD pmos_rvt L=2e-08 W=5.4e-08 nfin=2 $X=0.071 $Y=0.189
M11 VDD N_M11_g N_M11_s VDD pmos_rvt L=2e-08 W=5.4e-08 nfin=2 $X=0.125 $Y=0.189
M12 VDD N_M12_g N_M12_s VDD pmos_rvt L=2e-08 W=5.4e-08 nfin=2 $X=0.179 $Y=0.189
M13 N_M13_d N_M13_g VDD VDD pmos_rvt L=2e-08 W=5.4e-08 nfin=2 $X=0.233 $Y=0.189
M14 N_M14_d N_M14_g VDD VDD pmos_rvt L=2e-08 W=8.1e-08 nfin=3 $X=0.287 $Y=0.162
M15 N_M15_d N_M15_g VDD VDD pmos_rvt L=2e-08 W=8.1e-08 nfin=3 $X=0.341 $Y=0.162
M16 N_M16_d N_M16_g VDD VDD pmos_rvt L=2e-08 W=8.1e-08 nfin=3 $X=0.395 $Y=0.162
M17 N_M17_d N_M17_g VDD VDD pmos_rvt L=2e-08 W=8.1e-08 nfin=3 $X=0.449 $Y=0.162
M18 N_M18_d N_M18_g VDD VDD pmos_rvt L=2e-08 W=8.1e-08 nfin=3 $X=0.503 $Y=0.162
M19 N_M19_d N_M19_g VDD VDD pmos_rvt L=2e-08 W=8.1e-08 nfin=3 $X=0.557 $Y=0.162

* .include "AND2x6_ASAP7_75t_R.pex.sp.pxi"

* Start of included file AND2x6_ASAP7_75t_R.pex.sp.pxi
x_PM_AND2x6_ASAP7_75t_R%7__2 vss N_M0_s N_M1_d N_7__2_1
+ PM_AND2x6_ASAP7_75t_R%7__2
cc_1 N_7__2_1 N_A_5 0.0168366f $X=0.108 $Y=0.0675
cc_2 N_7__2_1 N_B_3 0.0167932f $X=0.108 $Y=0.0675
x_PM_AND2x6_ASAP7_75t_R%A vss A N_M0_g N_M10_g N_M3_g N_M13_g N_A_1 N_A_2 N_A_9
+ N_A_5 N_A_6 N_A_10 N_A_11 PM_AND2x6_ASAP7_75t_R%A
x_PM_AND2x6_ASAP7_75t_R%Y vss Y N_M4_d N_M5_d N_M6_d N_M7_d N_M8_d N_M9_d
+ N_M14_d N_M15_d N_M16_d N_M17_d N_M18_d N_M19_d N_Y_22 N_Y_24 N_Y_2 N_Y_29
+ N_Y_3 N_Y_5 N_Y_6 N_Y_4 N_Y_1 N_Y_28 N_Y_21 N_Y_20 N_Y_19 N_Y_23
+ PM_AND2x6_ASAP7_75t_R%Y
cc_3 N_Y_22 N_5_16 0.0011165f $X=0.3095 $Y=0.2025
cc_4 N_Y_22 N_5_13 0.0179914f $X=0.3095 $Y=0.2025
cc_5 N_Y_22 N_5_24 0.000367829f $X=0.3095 $Y=0.2025
cc_6 N_Y_22 N_5_29 0.000410301f $X=0.3095 $Y=0.2025
cc_7 N_Y_22 N_5_1 0.000440576f $X=0.3095 $Y=0.2025
cc_8 N_Y_22 N_5_14 0.00133876f $X=0.3095 $Y=0.2025
cc_9 N_Y_22 N_5_15 0.000814531f $X=0.3095 $Y=0.2025
cc_10 N_Y_24 N_5_16 0.0367373f $X=0.5255 $Y=0.2025
cc_11 N_Y_2 N_5_30 0.00106651f $X=0.324 $Y=0.2025
cc_12 N_Y_29 N_5_1 0.0014832f $X=0.459 $Y=0.083
cc_13 N_Y_3 N_5_15 0.00148818f $X=0.432 $Y=0.0675
cc_14 N_Y_5 N_5_16 0.00149668f $X=0.54 $Y=0.0675
cc_15 N_Y_6 N_5_16 0.00149668f $X=0.54 $Y=0.2025
cc_16 N_Y_4 N_5_15 0.00150336f $X=0.432 $Y=0.2025
cc_17 N_Y_1 N_5_13 0.00175872f $X=0.324 $Y=0.0675
cc_18 N_Y_28 N_5_24 0.00196531f $X=0.3125 $Y=0.234
cc_19 N_Y_2 N_5_13 0.0020816f $X=0.324 $Y=0.2025
cc_20 N_Y_21 N_5_17 0.0101197f $X=0.5255 $Y=0.0675
cc_21 N_Y_20 N_5_1 0.014083f $X=0.4175 $Y=0.0675
cc_22 N_Y_19 N_5_12 0.0178141f $X=0.3095 $Y=0.0675
cc_23 N_Y_20 N_5_15 0.0635541f $X=0.4175 $Y=0.0675
cc_24 N_Y_23 N_5_15 0.0178167f $X=0.4175 $Y=0.2025
cc_25 N_Y_24 N_5_17 0.0637831f $X=0.5255 $Y=0.2025
cc_26 N_Y_21 N_5_16 0.0178777f $X=0.5255 $Y=0.0675
cc_27 N_Y_19 N_5_13 0.0456612f $X=0.3095 $Y=0.0675
cc_28 N_Y_23 N_5_14 0.0458173f $X=0.4175 $Y=0.2025
cc_29 N_Y_22 N_5_12 0.0488812f $X=0.3095 $Y=0.2025
x_PM_AND2x6_ASAP7_75t_R%5 vss N_M4_g N_M14_g N_M5_g N_M15_g N_M6_g N_M16_g
+ N_M7_g N_M17_g N_M8_g N_M18_g N_M9_g N_M19_g N_M12_s N_M13_d N_M1_s N_M2_s
+ N_M10_d N_M11_s N_5_22 N_5_3 N_5_18 N_5_20 N_5_19 N_5_5 N_5_1 N_5_4 N_5_25
+ N_5_29 N_5_30 N_5_26 N_5_27 N_5_12 N_5_21 N_5_16 N_5_13 N_5_24 N_5_14 N_5_15
+ N_5_17 PM_AND2x6_ASAP7_75t_R%5
cc_30 N_5_22 N_A_5 0.000213429f $X=0.189 $Y=0.073
cc_31 N_5_3 N_A_5 0.000974109f $X=0.108 $Y=0.216
cc_32 N_5_18 N_A_5 0.000263472f $X=0.1475 $Y=0.0675
cc_33 N_5_20 N_A_6 0.0107841f $X=0.2015 $Y=0.216
cc_34 N_5_19 N_A_1 0.000336434f $X=0.0935 $Y=0.216
cc_35 N_5_5 N_A_6 0.000390697f $X=0.216 $Y=0.216
cc_36 N_5_1 N_A_6 0.000481161f $X=0.2875 $Y=0.135
cc_37 N_5_4 N_A_10 0.00171499f $X=0.162 $Y=0.0675
cc_38 N_5_25 N_A_9 0.000597415f $X=0.1795 $Y=0.234
cc_39 N_5_1 N_A_2 0.00240185f $X=0.2875 $Y=0.135
cc_40 N_5_29 N_A_11 0.000972757f $X=0.27 $Y=0.191
cc_41 N_5_30 N_A_11 0.00101061f $X=0.297 $Y=0.1235
cc_42 N_5_22 N_A_10 0.00151276f $X=0.189 $Y=0.073
cc_43 N_5_26 N_A_9 0.00212111f $X=0.1795 $Y=0.073
cc_44 N_5_27 N_A_11 0.00526574f $X=0.189 $Y=0.166
cc_45 N_5_26 N_A_10 0.00735486f $X=0.1795 $Y=0.073
cc_46 N_5_12 N_A_6 0.0173843f $X=0.297 $Y=0.0245
cc_47 N_5_19 N_A_5 0.0257351f $X=0.0935 $Y=0.216
cc_48 N_5_20 N_B_4 0.0108441f $X=0.2015 $Y=0.216
cc_49 N_5_19 N_B_4 0.00033868f $X=0.0935 $Y=0.216
cc_50 N_5_21 N_B_4 0.000377523f $X=0.1885 $Y=0.191
cc_51 N_5_5 N_B_4 0.000417947f $X=0.216 $Y=0.216
cc_52 N_5_4 N_B_5 0.000435247f $X=0.162 $Y=0.0675
cc_53 N_5_3 N_B_3 0.000696305f $X=0.108 $Y=0.216
cc_54 N_5_4 N_B_1 0.00072994f $X=0.162 $Y=0.0675
cc_55 N_5_26 N_B_5 0.000899987f $X=0.1795 $Y=0.073
cc_56 N_5_25 N_B_5 0.000959391f $X=0.1795 $Y=0.234
cc_57 N_5_4 N_B_4 0.00208937f $X=0.162 $Y=0.0675
cc_58 N_5_18 N_B_1 0.00347886f $X=0.1475 $Y=0.0675
cc_59 N_5_19 N_B_3 0.0105732f $X=0.0935 $Y=0.216
cc_60 N_5_27 N_B_5 0.00627545f $X=0.189 $Y=0.166
cc_61 N_5_18 N_B_3 0.0528277f $X=0.1475 $Y=0.0675
cc_62 N_5_18 N_B_4 0.0465184f $X=0.1475 $Y=0.0675
x_PM_AND2x6_ASAP7_75t_R%8 vss N_M2_d N_M3_s N_8_1 PM_AND2x6_ASAP7_75t_R%8
cc_63 N_8_1 N_A_6 0.0168859f $X=0.216 $Y=0.0675
cc_64 N_8_1 N_B_4 0.0168275f $X=0.216 $Y=0.0675
x_PM_AND2x6_ASAP7_75t_R%B vss B N_M1_g N_M11_g N_M2_g N_M12_g N_B_1 N_B_5 N_B_3
+ N_B_4 PM_AND2x6_ASAP7_75t_R%B
cc_65 N_B_1 N_A_1 0.00101305f $X=0.1255 $Y=0.135
cc_66 N_B_1 N_A_2 0.00190158f $X=0.1255 $Y=0.135
cc_67 N_B_5 N_A_9 0.00389279f $X=0.135 $Y=0.1165
cc_68 N_B_3 N_A_5 0.00708234f $X=0.135 $Y=0.0245
cc_69 N_B_4 N_A_6 0.00840525f $X=0.189 $Y=0.135

* End of included file AND2x6_ASAP7_75t_R.pex.sp.pxi
.ends

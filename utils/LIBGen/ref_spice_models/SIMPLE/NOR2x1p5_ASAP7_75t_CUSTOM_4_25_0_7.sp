.subckt PM_NOR2x1p5_ASAP7_75t_R%A vss 34 12 16 31 37 40 11 1 5 3 4 9 6
c1 1 vss 0.015362f $X=0.135 $Y=0.1355
c2 3 vss 0.0551454f $X=0.081 $Y=0.1355
c3 4 vss 0.10491f $X=0.135 $Y=0.0245
c4 5 vss 0.0827413f $X=0.189 $Y=0.1355
c5 6 vss 0.00993292f $X=0.027 $Y=0.036
c6 7 vss 0.00260853f $X=0.027 $Y=0.135
c7 8 vss 0.0108812f $X=0.027 $Y=0.234
c8 9 vss 0.0133794f $X=0.027 $Y=0.1035
c9 10 vss 0.0139716f $X=0.027 $Y=0.1665
c10 11 vss 0.00412627f $X=0.0455 $Y=0.135
r1 8 45 3.01711 $w=1.55e-08 $l=1.8e-08 $layer=M1 $thickness=3.6e-08 $X=0.027
+ $Y=0.234 $X2=0.027 $Y2=0.216
r2 6 43 3.01711 $w=1.55e-08 $l=1.8e-08 $layer=M1 $thickness=3.6e-08 $X=0.027
+ $Y=0.036 $X2=0.027 $Y2=0.054
r3 44 45 4.19742 $w=1.3e-08 $l=1.8e-08 $layer=M1 $thickness=3.6e-08 $X=0.027
+ $Y=0.198 $X2=0.027 $Y2=0.216
r4 10 44 7.34548 $w=1.3e-08 $l=3.15e-08 $layer=M1 $thickness=3.6e-08 $X=0.027
+ $Y=0.1665 $X2=0.027 $Y2=0.198
r5 42 43 4.19742 $w=1.3e-08 $l=1.8e-08 $layer=M1 $thickness=3.6e-08 $X=0.027
+ $Y=0.072 $X2=0.027 $Y2=0.054
r6 9 42 7.34548 $w=1.3e-08 $l=3.15e-08 $layer=M1 $thickness=3.6e-08 $X=0.027
+ $Y=0.1035 $X2=0.027 $Y2=0.072
r7 7 11 3.1337 $w=1.54324e-08 $l=1.85e-08 $layer=M1 $thickness=3.6e-08 $X=0.027
+ $Y=0.135 $X2=0.0455 $Y2=0.135
r8 7 9 6.16517 $w=1.44286e-08 $l=3.15e-08 $layer=M1 $thickness=3.6e-08 $X=0.027
+ $Y=0.135 $X2=0.027 $Y2=0.1035
r9 7 10 6.16517 $w=1.44286e-08 $l=3.15e-08 $layer=M1 $thickness=3.6e-08
+ $X=0.027 $Y=0.135 $X2=0.027 $Y2=0.1665
r10 40 39 16.3266 $w=2.1e-08 $l=4.8e-08 $layer=Gate_1 $thickness=5.6e-08
+ $X=0.189 $Y=0.2025 $X2=0.189 $Y2=0.1545
r11 37 38 16.4967 $w=2.1e-08 $l=4.85e-08 $layer=Gate_1 $thickness=5.6e-08
+ $X=0.189 $Y=0.054 $X2=0.189 $Y2=0.1025
r12 5 25 6.4735 $w=2.13953e-08 $layer=Gate_1 $thickness=5.22791e-08 $X=0.189
+ $Y=0.1355 $X2=0.189 $Y2=0.1355
r13 5 38 11.4201 $w=2.06515e-08 $l=3.3e-08 $layer=Gate_1 $thickness=5.6e-08
+ $X=0.189 $Y=0.1355 $X2=0.189 $Y2=0.1025
r14 5 39 6.6582 $w=2.03947e-08 $l=1.9e-08 $layer=Gate_1 $thickness=5.6e-08
+ $X=0.189 $Y=0.1355 $X2=0.189 $Y2=0.1545
r15 34 33 2.79828 $w=1.3e-08 $l=1.2e-08 $layer=M1 $thickness=3.6e-08 $X=0.07
+ $Y=0.136 $X2=0.058 $Y2=0.135
r16 11 33 2.91487 $w=1.3e-08 $l=1.25e-08 $layer=M1 $thickness=3.6e-08 $X=0.0455
+ $Y=0.135 $X2=0.058 $Y2=0.135
r17 31 30 14.6259 $w=2.1e-08 $l=4.3e-08 $layer=Gate_1 $thickness=5.6e-08
+ $X=0.081 $Y=0.2025 $X2=0.081 $Y2=0.1595
r18 29 30 2.55104 $w=2.1e-08 $l=7.5e-09 $layer=Gate_1 $thickness=5.6e-08
+ $X=0.081 $Y=0.152 $X2=0.081 $Y2=0.1595
r19 3 21 4.10717 $w=2e-08 $layer=Gate_1 $thickness=5.6e-08 $X=0.081 $Y=0.1355
+ $X2=0.081 $Y2=0.1355
r20 3 29 5.80786 $w=2.0303e-08 $l=1.65e-08 $layer=Gate_1 $thickness=5.6e-08
+ $X=0.081 $Y=0.1355 $X2=0.081 $Y2=0.152
r21 24 25 10.1596 $w=1.87815e-08 $l=2.7e-08 $layer=LIG $thickness=4.8e-08
+ $X=0.162 $Y=0.1355 $X2=0.189 $Y2=0.1355
r22 34 23 19.3796 $a=3.24e-16 $layer=V0LIG $X=0.07 $Y=0.136 $X2=0.066 $Y2=0.1355
r23 20 21 1.4198 $w=2.3e-08 $l=4e-09 $layer=LIG $thickness=4.8e-08 $X=0.085
+ $Y=0.1355 $X2=0.081 $Y2=0.1355
r24 19 20 2.36633 $w=2.3e-08 $l=1e-08 $layer=LIG $thickness=4.8e-08 $X=0.075
+ $Y=0.1355 $X2=0.085 $Y2=0.1355
r25 19 23 3.23868 $w=1.92778e-08 $l=9e-09 $layer=LIG $thickness=4.8e-08
+ $X=0.075 $Y=0.1355 $X2=0.066 $Y2=0.1355
r26 18 20 9.21311 $w=1.80478e-08 $l=2.3e-08 $layer=LIG $thickness=4.8e-08
+ $X=0.108 $Y=0.1355 $X2=0.085 $Y2=0.1355
r27 1 14 6.4735 $w=2.13953e-08 $layer=Gate_1 $thickness=5.22791e-08 $X=0.135
+ $Y=0.1355 $X2=0.135 $Y2=0.1355
r28 1 18 10.1596 $w=1.87815e-08 $l=2.7e-08 $layer=LIG $thickness=4.8e-08
+ $X=0.135 $Y=0.1355 $X2=0.108 $Y2=0.1355
r29 1 24 10.1596 $w=1.87815e-08 $l=2.7e-08 $layer=LIG $thickness=4.8e-08
+ $X=0.135 $Y=0.1355 $X2=0.162 $Y2=0.1355
r30 16 15 16.3266 $w=2.1e-08 $l=4.8e-08 $layer=Gate_1 $thickness=5.6e-08
+ $X=0.135 $Y=0.2025 $X2=0.135 $Y2=0.1545
r31 14 15 6.6582 $w=2.03947e-08 $l=1.9e-08 $layer=Gate_1 $thickness=5.6e-08
+ $X=0.135 $Y=0.1355 $X2=0.135 $Y2=0.1545
r32 13 14 6.82827 $w=2.04103e-08 $l=1.95e-08 $layer=Gate_1 $thickness=5.6e-08
+ $X=0.135 $Y=0.116 $X2=0.135 $Y2=0.1355
r33 12 13 16.4967 $w=2.1e-08 $l=4.85e-08 $layer=Gate_1 $thickness=5.6e-08
+ $X=0.135 $Y=0.0675 $X2=0.135 $Y2=0.116
r34 12 4 14.6259 $w=2.1e-08 $l=4.3e-08 $layer=Gate_1 $thickness=5.6e-08
+ $X=0.135 $Y=0.0675 $X2=0.135 $Y2=0.0245
.ends

.subckt PM_NOR2x1p5_ASAP7_75t_R%Y vss 49 27 41 42 44 58 61 62 16 23 1 17 19 25
+ 5 2 18 3 4 20 24
c1 1 vss 0.00715268f $X=0.108 $Y=0.0675
c2 2 vss 0.00769212f $X=0.216 $Y=0.054
c3 3 vss 0.00407515f $X=0.27 $Y=0.2025
c4 4 vss 0.00706494f $X=0.324 $Y=0.0675
c5 5 vss 0.00577211f $X=0.378 $Y=0.2025
c6 16 vss 0.00340646f $X=0.11 $Y=0.0675
c7 17 vss 0.00379282f $X=0.2015 $Y=0.054
c8 18 vss 0.00342352f $X=0.3095 $Y=0.0675
c9 19 vss 0.00203891f $X=0.2555 $Y=0.2025
c10 20 vss 0.0357411f $X=0.3635 $Y=0.2025
c11 21 vss 0.00278554f $X=0.405 $Y=0.036
c12 22 vss 0.00262958f $X=0.405 $Y=0.234
c13 23 vss 0.0255714f $X=0.0965 $Y=0.036
c14 24 vss 0.0102663f $X=0.3535 $Y=0.234
c15 25 vss 0.00524508f $X=0.405 $Y=0.054
r1 62 60 0.0308642 $w=8.1e-08 $l=2.5e-09 $layer=P_src_drn $thickness=1e-09
+ $X=0.2873 $Y=0.2025 $X2=0.2845 $Y2=0.2025
r2 3 60 0.179012 $w=8.1e-08 $l=1.45e-08 $layer=P_src_drn $thickness=1e-09
+ $X=0.27 $Y=0.2025 $X2=0.2845 $Y2=0.2025
r3 19 3 0.179012 $w=8.1e-08 $l=1.45e-08 $layer=P_src_drn $thickness=1e-09
+ $X=0.2555 $Y=0.2025 $X2=0.27 $Y2=0.2025
r4 61 19 0.0308642 $w=8.1e-08 $l=2.5e-09 $layer=P_src_drn $thickness=1e-09
+ $X=0.2526 $Y=0.2025 $X2=0.2555 $Y2=0.2025
r5 20 5 0.154321 $w=8.1e-08 $l=1.25e-08 $layer=P_src_drn $thickness=1e-09
+ $X=0.3635 $Y=0.2025 $X2=0.378 $Y2=0.2025
r6 58 20 0.0308642 $w=8.1e-08 $l=2.5e-09 $layer=P_src_drn $thickness=1e-09
+ $X=0.3606 $Y=0.2025 $X2=0.3635 $Y2=0.2025
r7 3 55 19.3796 $a=3.24e-16 $layer=V0LISD $X=0.27 $Y=0.2025 $X2=0.27 $Y2=0.234
r8 5 53 19.3796 $a=3.24e-16 $layer=V0LISD $X=0.378 $Y=0.2025 $X2=0.378 $Y2=0.234
r9 55 56 8.97781 $w=1.3e-08 $l=3.85e-08 $layer=M1 $thickness=3.6e-08 $X=0.27
+ $Y=0.234 $X2=0.3085 $Y2=0.234
r10 53 54 3.14806 $w=1.3e-08 $l=1.35e-08 $layer=M1 $thickness=3.6e-08 $X=0.378
+ $Y=0.234 $X2=0.3915 $Y2=0.234
r11 24 53 5.71315 $w=1.3e-08 $l=2.45e-08 $layer=M1 $thickness=3.6e-08 $X=0.3535
+ $Y=0.234 $X2=0.378 $Y2=0.234
r12 24 56 10.4935 $w=1.3e-08 $l=4.5e-08 $layer=M1 $thickness=3.6e-08 $X=0.3535
+ $Y=0.234 $X2=0.3085 $Y2=0.234
r13 22 52 2.5483 $w=1.79e-08 $l=1.8e-08 $layer=M1 $thickness=3.6e-08 $X=0.405
+ $Y=0.234 $X2=0.405 $Y2=0.216
r14 22 54 1.49895 $w=1.63333e-08 $l=1.35e-08 $layer=M1 $thickness=3.6e-08
+ $X=0.405 $Y=0.234 $X2=0.3915 $Y2=0.234
r15 51 52 4.19742 $w=1.3e-08 $l=1.8e-08 $layer=M1 $thickness=3.6e-08 $X=0.405
+ $Y=0.198 $X2=0.405 $Y2=0.216
r16 50 51 7.17059 $w=1.3e-08 $l=3.08e-08 $layer=M1 $thickness=3.6e-08 $X=0.405
+ $Y=0.1672 $X2=0.405 $Y2=0.198
r17 49 50 5.18847 $w=1.3e-08 $l=2.22e-08 $layer=M1 $thickness=3.6e-08 $X=0.405
+ $Y=0.145 $X2=0.405 $Y2=0.1672
r18 49 48 0.174892 $w=1.3e-08 $l=8e-10 $layer=M1 $thickness=3.6e-08 $X=0.405
+ $Y=0.145 $X2=0.405 $Y2=0.1442
r19 47 48 2.15701 $w=1.3e-08 $l=9.2e-09 $layer=M1 $thickness=3.6e-08 $X=0.405
+ $Y=0.135 $X2=0.405 $Y2=0.1442
r20 46 47 7.34548 $w=1.3e-08 $l=3.15e-08 $layer=M1 $thickness=3.6e-08 $X=0.405
+ $Y=0.1035 $X2=0.405 $Y2=0.135
r21 45 46 7.34548 $w=1.3e-08 $l=3.15e-08 $layer=M1 $thickness=3.6e-08 $X=0.405
+ $Y=0.072 $X2=0.405 $Y2=0.1035
r22 25 45 4.19742 $w=1.3e-08 $l=1.8e-08 $layer=M1 $thickness=3.6e-08 $X=0.405
+ $Y=0.054 $X2=0.405 $Y2=0.072
r23 18 4 0.154321 $w=8.1e-08 $l=1.25e-08 $layer=N_src_drn $thickness=1e-09
+ $X=0.3095 $Y=0.0675 $X2=0.324 $Y2=0.0675
r24 44 18 0.0308642 $w=8.1e-08 $l=2.5e-09 $layer=N_src_drn $thickness=1e-09
+ $X=0.3066 $Y=0.0675 $X2=0.3095 $Y2=0.0675
r25 42 40 0.0462963 $w=5.4e-08 $l=2.5e-09 $layer=N_src_drn $thickness=1e-09
+ $X=0.2333 $Y=0.054 $X2=0.2305 $Y2=0.054
r26 2 40 0.268519 $w=5.4e-08 $l=1.45e-08 $layer=N_src_drn $thickness=1e-09
+ $X=0.216 $Y=0.054 $X2=0.2305 $Y2=0.054
r27 17 2 0.268519 $w=5.4e-08 $l=1.45e-08 $layer=N_src_drn $thickness=1e-09
+ $X=0.2015 $Y=0.054 $X2=0.216 $Y2=0.054
r28 41 17 0.0462963 $w=5.4e-08 $l=2.5e-09 $layer=N_src_drn $thickness=1e-09
+ $X=0.1986 $Y=0.054 $X2=0.2015 $Y2=0.054
r29 21 38 7.2121 $w=1.41842e-08 $l=3.8e-08 $layer=M1 $thickness=3.6e-08
+ $X=0.405 $Y=0.036 $X2=0.367 $Y2=0.036
r30 21 25 2.5483 $w=1.79e-08 $l=1.8e-08 $layer=M1 $thickness=3.6e-08 $X=0.405
+ $Y=0.036 $X2=0.405 $Y2=0.054
r31 4 36 19.3796 $a=3.24e-16 $layer=V0LISD $X=0.324 $Y=0.0675 $X2=0.324
+ $Y2=0.036
r32 2 33 19.3796 $a=3.24e-16 $layer=V0LISD $X=0.216 $Y=0.054 $X2=0.216 $Y2=0.036
r33 37 38 7.34548 $w=1.3e-08 $l=3.15e-08 $layer=M1 $thickness=3.6e-08 $X=0.3355
+ $Y=0.036 $X2=0.367 $Y2=0.036
r34 36 37 2.68168 $w=1.3e-08 $l=1.15e-08 $layer=M1 $thickness=3.6e-08 $X=0.324
+ $Y=0.036 $X2=0.3355 $Y2=0.036
r35 35 36 8.86121 $w=1.3e-08 $l=3.8e-08 $layer=M1 $thickness=3.6e-08 $X=0.286
+ $Y=0.036 $X2=0.324 $Y2=0.036
r36 34 35 10.4935 $w=1.3e-08 $l=4.5e-08 $layer=M1 $thickness=3.6e-08 $X=0.241
+ $Y=0.036 $X2=0.286 $Y2=0.036
r37 33 34 5.82974 $w=1.3e-08 $l=2.5e-08 $layer=M1 $thickness=3.6e-08 $X=0.216
+ $Y=0.036 $X2=0.241 $Y2=0.036
r38 32 33 7.22888 $w=1.3e-08 $l=3.1e-08 $layer=M1 $thickness=3.6e-08 $X=0.185
+ $Y=0.036 $X2=0.216 $Y2=0.036
r39 31 32 9.44418 $w=1.3e-08 $l=4.05e-08 $layer=M1 $thickness=3.6e-08 $X=0.1445
+ $Y=0.036 $X2=0.185 $Y2=0.036
r40 30 31 5.36336 $w=1.3e-08 $l=2.3e-08 $layer=M1 $thickness=3.6e-08 $X=0.1215
+ $Y=0.036 $X2=0.1445 $Y2=0.036
r41 29 30 2.2153 $w=1.3e-08 $l=9.5e-09 $layer=M1 $thickness=3.6e-08 $X=0.112
+ $Y=0.036 $X2=0.1215 $Y2=0.036
r42 28 29 2.09871 $w=1.3e-08 $l=9e-09 $layer=M1 $thickness=3.6e-08 $X=0.103
+ $Y=0.036 $X2=0.112 $Y2=0.036
r43 23 28 1.51573 $w=1.3e-08 $l=6.5e-09 $layer=M1 $thickness=3.6e-08 $X=0.0965
+ $Y=0.036 $X2=0.103 $Y2=0.036
r44 1 29 19.3796 $a=3.24e-16 $layer=V0LISD $X=0.108 $Y=0.0675 $X2=0.112
+ $Y2=0.036
r45 27 26 0.0308642 $w=8.1e-08 $l=2.5e-09 $layer=N_src_drn $thickness=1e-09
+ $X=0.1253 $Y=0.0675 $X2=0.1225 $Y2=0.0675
r46 16 26 0.154321 $w=8.1e-08 $l=1.25e-08 $layer=N_src_drn $thickness=1e-09
+ $X=0.11 $Y=0.0675 $X2=0.1225 $Y2=0.0675
r47 1 16 1e-05 $l=2e-09 $X=0.108 $Y=0.0675 $X2=0.11 $Y2=0.0675
.ends

.subckt PM_NOR2x1p5_ASAP7_75t_R%5 vss 18 19 34 35 38 39 11 1 12 13 2 3 15 14
c1 1 vss 0.00862159f $X=0.108 $Y=0.2025
c2 2 vss 0.00635193f $X=0.216 $Y=0.2025
c3 3 vss 0.00265559f $X=0.324 $Y=0.2025
c4 11 vss 0.00426811f $X=0.0935 $Y=0.2025
c5 12 vss 0.00305825f $X=0.2015 $Y=0.2025
c6 13 vss 0.00186396f $X=0.3095 $Y=0.2025
c7 14 vss 0.0115783f $X=0.0965 $Y=0.234
c8 15 vss 0.00152591f $X=0.2045 $Y=0.198
r1 39 37 0.0308642 $w=8.1e-08 $l=2.5e-09 $layer=P_src_drn $thickness=1e-09
+ $X=0.3413 $Y=0.2025 $X2=0.3385 $Y2=0.2025
r2 3 37 0.179012 $w=8.1e-08 $l=1.45e-08 $layer=P_src_drn $thickness=1e-09
+ $X=0.324 $Y=0.2025 $X2=0.3385 $Y2=0.2025
r3 13 3 0.179012 $w=8.1e-08 $l=1.45e-08 $layer=P_src_drn $thickness=1e-09
+ $X=0.3095 $Y=0.2025 $X2=0.324 $Y2=0.2025
r4 38 13 0.0308642 $w=8.1e-08 $l=2.5e-09 $layer=P_src_drn $thickness=1e-09
+ $X=0.3066 $Y=0.2025 $X2=0.3095 $Y2=0.2025
r5 3 30 19.3796 $a=3.24e-16 $layer=V0LISD $X=0.324 $Y=0.2025 $X2=0.324 $Y2=0.198
r6 35 33 0.0308642 $w=8.1e-08 $l=2.5e-09 $layer=P_src_drn $thickness=1e-09
+ $X=0.2333 $Y=0.2025 $X2=0.2305 $Y2=0.2025
r7 2 33 0.179012 $w=8.1e-08 $l=1.45e-08 $layer=P_src_drn $thickness=1e-09
+ $X=0.216 $Y=0.2025 $X2=0.2305 $Y2=0.2025
r8 12 2 0.179012 $w=8.1e-08 $l=1.45e-08 $layer=P_src_drn $thickness=1e-09
+ $X=0.2015 $Y=0.2025 $X2=0.216 $Y2=0.2025
r9 34 12 0.0308642 $w=8.1e-08 $l=2.5e-09 $layer=P_src_drn $thickness=1e-09
+ $X=0.1986 $Y=0.2025 $X2=0.2015 $Y2=0.2025
r10 29 30 8.39483 $w=1.3e-08 $l=3.6e-08 $layer=M1 $thickness=3.6e-08 $X=0.288
+ $Y=0.198 $X2=0.324 $Y2=0.198
r11 28 29 6.7625 $w=1.3e-08 $l=2.9e-08 $layer=M1 $thickness=3.6e-08 $X=0.259
+ $Y=0.198 $X2=0.288 $Y2=0.198
r12 27 28 4.19742 $w=1.3e-08 $l=1.8e-08 $layer=M1 $thickness=3.6e-08 $X=0.241
+ $Y=0.198 $X2=0.259 $Y2=0.198
r13 26 27 5.82974 $w=1.3e-08 $l=2.5e-08 $layer=M1 $thickness=3.6e-08 $X=0.216
+ $Y=0.198 $X2=0.241 $Y2=0.198
r14 15 26 2.68168 $w=1.3e-08 $l=1.15e-08 $layer=M1 $thickness=3.6e-08 $X=0.2045
+ $Y=0.198 $X2=0.216 $Y2=0.198
r15 2 25 19.3796 $a=3.24e-16 $layer=V0LISD $X=0.216 $Y=0.2025 $X2=0.216
+ $Y2=0.234
r16 2 26 19.3796 $a=3.24e-16 $layer=V0LISD $X=0.216 $Y=0.2025 $X2=0.216
+ $Y2=0.198
r17 24 25 2.68168 $w=1.3e-08 $l=1.15e-08 $layer=M1 $thickness=3.6e-08 $X=0.2045
+ $Y=0.234 $X2=0.216 $Y2=0.234
r18 23 24 7.34548 $w=1.3e-08 $l=3.15e-08 $layer=M1 $thickness=3.6e-08 $X=0.173
+ $Y=0.234 $X2=0.2045 $Y2=0.234
r19 22 23 9.91056 $w=1.3e-08 $l=4.25e-08 $layer=M1 $thickness=3.6e-08 $X=0.1305
+ $Y=0.234 $X2=0.173 $Y2=0.234
r20 21 22 4.31401 $w=1.3e-08 $l=1.85e-08 $layer=M1 $thickness=3.6e-08 $X=0.112
+ $Y=0.234 $X2=0.1305 $Y2=0.234
r21 20 21 2.09871 $w=1.3e-08 $l=9e-09 $layer=M1 $thickness=3.6e-08 $X=0.103
+ $Y=0.234 $X2=0.112 $Y2=0.234
r22 14 20 1.51573 $w=1.3e-08 $l=6.5e-09 $layer=M1 $thickness=3.6e-08 $X=0.0965
+ $Y=0.234 $X2=0.103 $Y2=0.234
r23 1 21 19.3796 $a=3.24e-16 $layer=V0LISD $X=0.108 $Y=0.2025 $X2=0.112
+ $Y2=0.234
r24 19 17 0.0308642 $w=8.1e-08 $l=2.5e-09 $layer=P_src_drn $thickness=1e-09
+ $X=0.1253 $Y=0.2025 $X2=0.1225 $Y2=0.2025
r25 1 17 0.179012 $w=8.1e-08 $l=1.45e-08 $layer=P_src_drn $thickness=1e-09
+ $X=0.108 $Y=0.2025 $X2=0.1225 $Y2=0.2025
r26 11 1 0.179012 $w=8.1e-08 $l=1.45e-08 $layer=P_src_drn $thickness=1e-09
+ $X=0.0935 $Y=0.2025 $X2=0.108 $Y2=0.2025
r27 18 11 0.0308642 $w=8.1e-08 $l=2.5e-09 $layer=P_src_drn $thickness=1e-09
+ $X=0.0906 $Y=0.2025 $X2=0.0935 $Y2=0.2025
.ends

.subckt PM_NOR2x1p5_ASAP7_75t_R%B vss 42 12 16 31 34 40 6 10 9 1 11 8 3 4 5 7
c1 1 vss 0.0154723f $X=0.2335 $Y=0.135
c2 3 vss 0.0496867f $X=0.243 $Y=0.0245
c3 4 vss 0.0594039f $X=0.297 $Y=0.135
c4 5 vss 0.0220406f $X=0.351 $Y=0.135
c5 6 vss 0.00634305f $X=0.135 $Y=0.198
c6 7 vss 0.00635736f $X=0.135 $Y=0.072
c7 8 vss 0.00492797f $X=0.135 $Y=0.1307
c8 9 vss 0.00570986f $X=0.135 $Y=0.1035
c9 10 vss 0.00581101f $X=0.135 $Y=0.1665
c10 11 vss 0.00688667f $X=0.218 $Y=0.135
r1 6 10 6.16517 $w=1.44286e-08 $l=3.15e-08 $layer=M1 $thickness=3.6e-08
+ $X=0.135 $Y=0.198 $X2=0.135 $Y2=0.1665
r2 7 9 6.16517 $w=1.44286e-08 $l=3.15e-08 $layer=M1 $thickness=3.6e-08 $X=0.135
+ $Y=0.072 $X2=0.135 $Y2=0.1035
r3 10 43 5.62944 $w=1.37143e-08 $l=2.63e-08 $layer=M1 $thickness=3.6e-08
+ $X=0.135 $Y=0.1665 $X2=0.135 $Y2=0.1402
r4 42 43 0.433689 $w=1.8e-08 $l=4.2e-09 $layer=M1 $thickness=3.6e-08 $X=0.135
+ $Y=0.136 $X2=0.135 $Y2=0.1402
r5 42 8 0.535733 $w=1.8e-08 $l=5.3e-09 $layer=M1 $thickness=3.6e-08 $X=0.135
+ $Y=0.136 $X2=0.135 $Y2=0.1307
r6 8 9 5.73148 $w=1.38716e-08 $l=2.72e-08 $layer=M1 $thickness=3.6e-08 $X=0.135
+ $Y=0.1307 $X2=0.135 $Y2=0.1035
r7 40 39 14.6259 $w=2.1e-08 $l=4.3e-08 $layer=Gate_1 $thickness=5.6e-08
+ $X=0.351 $Y=0.2025 $X2=0.351 $Y2=0.1595
r8 38 39 2.7211 $w=2.1e-08 $l=8e-09 $layer=Gate_1 $thickness=5.6e-08 $X=0.351
+ $Y=0.1515 $X2=0.351 $Y2=0.1595
r9 5 24 6.54019 $w=2.09524e-08 $layer=Gate_1 $thickness=5.21905e-08 $X=0.351
+ $Y=0.135 $X2=0.351 $Y2=0.135
r10 5 38 5.79936 $w=2.03333e-08 $l=1.65e-08 $layer=Gate_1 $thickness=5.6e-08
+ $X=0.351 $Y=0.135 $X2=0.351 $Y2=0.1515
r11 34 33 16.4967 $w=2.1e-08 $l=4.85e-08 $layer=Gate_1 $thickness=5.6e-08
+ $X=0.297 $Y=0.2025 $X2=0.297 $Y2=0.154
r12 31 32 16.4967 $w=2.1e-08 $l=4.85e-08 $layer=Gate_1 $thickness=5.6e-08
+ $X=0.297 $Y=0.0675 $X2=0.297 $Y2=0.116
r13 4 22 6.54019 $w=2.09524e-08 $layer=Gate_1 $thickness=5.21905e-08 $X=0.297
+ $Y=0.135 $X2=0.297 $Y2=0.135
r14 4 32 6.6497 $w=2.04211e-08 $l=1.9e-08 $layer=Gate_1 $thickness=5.6e-08
+ $X=0.297 $Y=0.135 $X2=0.297 $Y2=0.116
r15 4 33 6.6497 $w=2.04211e-08 $l=1.9e-08 $layer=Gate_1 $thickness=5.6e-08
+ $X=0.297 $Y=0.135 $X2=0.297 $Y2=0.154
r16 42 29 2.26632 $w=7.16216e-09 $l=1.8527e-08 $layer=M1 $thickness=3.6e-08
+ $X=0.135 $Y=0.136 $X2=0.1535 $Y2=0.135
r17 28 29 6.7625 $w=1.3e-08 $l=2.9e-08 $layer=M1 $thickness=3.6e-08 $X=0.1825
+ $Y=0.135 $X2=0.1535 $Y2=0.135
r18 11 26 5.82974 $w=1.3e-08 $l=2.5e-08 $layer=M1 $thickness=3.6e-08 $X=0.218
+ $Y=0.135 $X2=0.243 $Y2=0.135
r19 11 28 8.27824 $w=1.3e-08 $l=3.55e-08 $layer=M1 $thickness=3.6e-08 $X=0.218
+ $Y=0.135 $X2=0.1825 $Y2=0.135
r20 23 24 12.6539 $w=1.77815e-08 $l=2.7e-08 $layer=LIG $thickness=4.8e-08
+ $X=0.324 $Y=0.135 $X2=0.351 $Y2=0.135
r21 22 23 12.6539 $w=1.77815e-08 $l=2.7e-08 $layer=LIG $thickness=4.8e-08
+ $X=0.297 $Y=0.135 $X2=0.324 $Y2=0.135
r22 21 22 12.6539 $w=1.77815e-08 $l=2.7e-08 $layer=LIG $thickness=4.8e-08
+ $X=0.27 $Y=0.135 $X2=0.297 $Y2=0.135
r23 19 21 10.1729 $w=1.54914e-08 $l=1.75e-08 $layer=LIG $thickness=4.8e-08
+ $X=0.2525 $Y=0.135 $X2=0.27 $Y2=0.135
r24 18 19 2.48102 $w=2.2e-08 $l=9.5e-09 $layer=LIG $thickness=4.8e-08 $X=0.243
+ $Y=0.135 $X2=0.2525 $Y2=0.135
r25 18 26 19.3796 $a=3.24e-16 $layer=V0LIG $X=0.243 $Y=0.135 $X2=0.243 $Y2=0.135
r26 1 18 2.48102 $w=2.2e-08 $l=9.5e-09 $layer=LIG $thickness=4.8e-08 $X=0.2335
+ $Y=0.135 $X2=0.243 $Y2=0.135
r27 16 15 16.4967 $w=2.1e-08 $l=4.85e-08 $layer=Gate_1 $thickness=5.6e-08
+ $X=0.243 $Y=0.2025 $X2=0.243 $Y2=0.154
r28 14 15 6.6497 $w=2.04211e-08 $l=1.9e-08 $layer=Gate_1 $thickness=5.6e-08
+ $X=0.243 $Y=0.135 $X2=0.243 $Y2=0.154
r29 14 19 4.05918 $w=2.0087e-08 $l=9.5e-09 $layer=Gate_1 $thickness=5.56522e-08
+ $X=0.243 $Y=0.135 $X2=0.2525 $Y2=0.135
r30 14 18 6.27904 $w=2.09e-08 $layer=Gate_1 $thickness=5.24e-08 $X=0.243
+ $Y=0.135 $X2=0.243 $Y2=0.135
r31 13 14 11.2416 $w=2.06615e-08 $l=3.25e-08 $layer=Gate_1 $thickness=5.6e-08
+ $X=0.243 $Y=0.1025 $X2=0.243 $Y2=0.135
r32 12 13 16.4967 $w=2.1e-08 $l=4.85e-08 $layer=Gate_1 $thickness=5.6e-08
+ $X=0.243 $Y=0.054 $X2=0.243 $Y2=0.1025
r33 12 3 10.0341 $w=2.1e-08 $l=2.95e-08 $layer=Gate_1 $thickness=5.6e-08
+ $X=0.243 $Y=0.054 $X2=0.243 $Y2=0.0245
.ends

* End of included file NOR2x1p5_ASAP7_75t_R.pex.sp.pex

*
.subckt NOR2x1p5_ASAP7_75t_CUSTOM_4_25_0_7 VSS VDD A B Y
*
* VSS VSS
* VDD VDD
* A A
* B B
* Y Y
*
*

M0 VSS N_M0_g N_M0_s VSS nmos_rvt L=2e-08 W=8.1e-08 nfin=3 $X=0.125 $Y=0.027
M1 VSS N_M1_g N_M1_s VSS nmos_rvt L=2e-08 W=5.4e-08 nfin=2 $X=0.179 $Y=0.027
M2 VSS N_M2_g N_M2_s VSS nmos_rvt L=2e-08 W=5.4e-08 nfin=2 $X=0.233 $Y=0.027
M3 VSS N_M3_g N_M3_s VSS nmos_rvt L=2e-08 W=8.1e-08 nfin=3 $X=0.287 $Y=0.027
M4 N_M4_d N_M4_g VDD VDD pmos_rvt L=2e-08 W=8.1e-08 nfin=3 $X=0.071 $Y=0.162
M5 N_M5_d N_M5_g VDD VDD pmos_rvt L=2e-08 W=8.1e-08 nfin=3 $X=0.125 $Y=0.162
M6 N_M6_d N_M6_g VDD VDD pmos_rvt L=2e-08 W=8.1e-08 nfin=3 $X=0.179 $Y=0.162
M7 N_M7_d N_M7_g N_M7_s VDD pmos_rvt L=2e-08 W=8.1e-08 nfin=3 $X=0.233 $Y=0.162
M8 N_M8_d N_M8_g N_M8_s VDD pmos_rvt L=2e-08 W=8.1e-08 nfin=3 $X=0.287 $Y=0.162
M9 N_M9_d N_M9_g N_M9_s VDD pmos_rvt L=2e-08 W=8.1e-08 nfin=3 $X=0.341 $Y=0.162

* .include "NOR2x1p5_ASAP7_75t_R.pex.sp.pxi"

* Start of included file NOR2x1p5_ASAP7_75t_R.pex.sp.pxi
x_PM_NOR2x1p5_ASAP7_75t_R%A vss A N_M0_g N_M5_g N_M4_g N_M1_g N_M6_g N_A_11
+ N_A_1 N_A_5 N_A_3 N_A_4 N_A_9 N_A_6 PM_NOR2x1p5_ASAP7_75t_R%A
x_PM_NOR2x1p5_ASAP7_75t_R%Y vss Y N_M0_s N_M1_s N_M2_s N_M3_s N_M9_d N_M7_d
+ N_M8_d N_Y_16 N_Y_23 N_Y_1 N_Y_17 N_Y_19 N_Y_25 N_Y_5 N_Y_2 N_Y_18 N_Y_3
+ N_Y_4 N_Y_20 N_Y_24 PM_NOR2x1p5_ASAP7_75t_R%Y
cc_1 N_Y_16 N_A_9 0.000404123f $X=0.11 $Y=0.0675
cc_2 N_Y_16 N_A_6 0.000430115f $X=0.11 $Y=0.0675
cc_3 N_Y_23 N_A_5 0.000624008f $X=0.0965 $Y=0.036
cc_4 N_Y_1 N_A_3 0.00228156f $X=0.108 $Y=0.0675
cc_5 N_Y_16 N_A_1 0.00276263f $X=0.11 $Y=0.0675
cc_6 N_Y_17 N_A_5 0.0239074f $X=0.2015 $Y=0.054
cc_7 N_Y_16 N_A_3 0.0188437f $X=0.11 $Y=0.0675
cc_8 N_Y_16 N_A_4 0.0530632f $X=0.11 $Y=0.0675
cc_9 N_Y_19 N_B_1 0.000434386f $X=0.2555 $Y=0.2025
cc_10 N_Y_19 N_B_3 0.0333672f $X=0.2555 $Y=0.2025
cc_11 N_Y_1 N_B_7 0.000598374f $X=0.108 $Y=0.0675
cc_12 N_Y_1 N_B_9 0.000651465f $X=0.108 $Y=0.0675
cc_13 N_Y_25 N_B_1 0.000690749f $X=0.405 $Y=0.054
cc_14 N_Y_5 N_B_5 0.000742946f $X=0.378 $Y=0.2025
cc_15 N_Y_2 N_B_11 0.00110762f $X=0.216 $Y=0.054
cc_16 N_Y_18 N_B_4 0.0116038f $X=0.3095 $Y=0.0675
cc_17 N_Y_3 N_B_3 0.00165195f $X=0.27 $Y=0.2025
cc_18 N_Y_4 N_B_4 0.00201454f $X=0.324 $Y=0.0675
cc_19 N_Y_17 N_B_3 0.0103144f $X=0.2015 $Y=0.054
cc_20 N_Y_23 N_B_7 0.00548873f $X=0.0965 $Y=0.036
cc_21 N_Y_18 N_B_1 0.00678508f $X=0.3095 $Y=0.0675
cc_22 N_Y_20 N_B_5 0.0522482f $X=0.3635 $Y=0.2025
cc_23 N_Y_18 N_B_5 0.0205992f $X=0.3095 $Y=0.0675
cc_24 N_Y_19 N_B_4 0.0687726f $X=0.2555 $Y=0.2025
cc_25 N_Y_25 N_5_15 0.00057189f $X=0.405 $Y=0.054
cc_26 N_Y_3 N_5_15 0.000937566f $X=0.27 $Y=0.2025
cc_27 N_Y_19 N_5_13 0.00107207f $X=0.2555 $Y=0.2025
cc_28 N_Y_19 N_5_12 0.00107598f $X=0.2555 $Y=0.2025
cc_29 N_Y_5 N_5_3 0.00127008f $X=0.378 $Y=0.2025
cc_30 N_Y_3 N_5_3 0.00270143f $X=0.27 $Y=0.2025
cc_31 N_Y_3 N_5_2 0.00389226f $X=0.27 $Y=0.2025
cc_32 N_Y_24 N_5_15 0.0117951f $X=0.3535 $Y=0.234
x_PM_NOR2x1p5_ASAP7_75t_R%5 vss N_M4_d N_M5_d N_M6_d N_M7_s N_M8_s N_M9_s
+ N_5_11 N_5_1 N_5_12 N_5_13 N_5_2 N_5_3 N_5_15 N_5_14 PM_NOR2x1p5_ASAP7_75t_R%5
cc_33 N_5_11 N_A_5 0.000613233f $X=0.0935 $Y=0.2025
cc_34 N_5_11 N_A_3 0.0183925f $X=0.0935 $Y=0.2025
cc_35 N_5_1 N_A_4 0.00172688f $X=0.108 $Y=0.2025
cc_36 N_5_11 N_A_1 0.00312991f $X=0.0935 $Y=0.2025
cc_37 N_5_12 N_A_5 0.0320738f $X=0.2015 $Y=0.2025
cc_38 N_5_11 N_A_4 0.0483257f $X=0.0935 $Y=0.2025
cc_39 N_5_13 N_B_1 0.00358461f $X=0.3095 $Y=0.2025
cc_40 N_5_13 N_B_10 0.000647386f $X=0.3095 $Y=0.2025
cc_41 N_5_13 N_B_6 0.000695507f $X=0.3095 $Y=0.2025
cc_42 N_5_13 N_B_4 0.0371644f $X=0.3095 $Y=0.2025
cc_43 N_5_2 N_B_3 0.000954118f $X=0.216 $Y=0.2025
cc_44 N_5_3 N_B_4 0.00149788f $X=0.324 $Y=0.2025
cc_45 N_5_15 N_B_11 0.00324282f $X=0.2045 $Y=0.198
cc_46 N_5_14 N_B_6 0.0043099f $X=0.0965 $Y=0.234
cc_47 N_5_12 N_B_3 0.0321403f $X=0.2015 $Y=0.2025
cc_48 N_5_13 N_B_5 0.0291106f $X=0.3095 $Y=0.2025
x_PM_NOR2x1p5_ASAP7_75t_R%B vss B N_M2_g N_M7_g N_M3_g N_M8_g N_M9_g N_B_6
+ N_B_10 N_B_9 N_B_1 N_B_11 N_B_8 N_B_3 N_B_4 N_B_5 N_B_7
+ PM_NOR2x1p5_ASAP7_75t_R%B
cc_49 N_B_6 N_A_11 0.000470216f $X=0.135 $Y=0.198
cc_50 N_B_10 N_A_1 0.000685415f $X=0.135 $Y=0.1665
cc_51 N_B_9 N_A_1 0.000747505f $X=0.135 $Y=0.1035
cc_52 N_B_1 N_A_1 0.000780576f $X=0.2335 $Y=0.135
cc_53 N_B_11 N_A_1 0.000880412f $X=0.218 $Y=0.135
cc_54 N_B_8 N_A_11 0.00106423f $X=0.135 $Y=0.1307
cc_55 N_B_8 N_A_1 0.00291907f $X=0.135 $Y=0.1307
cc_56 N_B_3 N_A_5 0.00712733f $X=0.243 $Y=0.0245

* End of included file NOR2x1p5_ASAP7_75t_R.pex.sp.pxi
.ends

.subckt PM_XNOR2xp5_ASAP7_75t_R%8 vss 2 3 1
c1 1 vss 0.000798361f $X=0.108 $Y=0.0675
r1 2 1 0.209877 $w=8.1e-08 $l=1.7e-08 $layer=N_src_drn $thickness=1e-09
+ $X=0.0906 $Y=0.0675 $X2=0.108 $Y2=0.0675
r2 3 1 0.209877 $w=8.1e-08 $l=1.7e-08 $layer=N_src_drn $thickness=1e-09
+ $X=0.1253 $Y=0.0675 $X2=0.108 $Y2=0.0675
.ends

.subckt PM_XNOR2xp5_ASAP7_75t_R%A vss 26 16 22 43 46 5 1 12 9 6 11 14 2 15
c1 1 vss 0.00441606f $X=0.081 $Y=0.135
c2 2 vss 0.00613926f $X=0.351 $Y=0.135
c3 5 vss 0.0789106f $X=0.081 $Y=0.0245
c4 6 vss 0.14142f $X=0.351 $Y=0.135
c5 7 vss 0.00376111f $X=0.081 $Y=0.036
c6 8 vss 0.00343887f $X=0.216 $Y=0.036
c7 9 vss 0.000771708f $X=0.216 $Y=0.0665
c8 10 vss 0.00358863f $X=0.351 $Y=0.072
c9 11 vss 0.0110385f $X=0.081 $Y=0.098
c10 12 vss 0.0115533f $X=0.092 $Y=0.036
c11 13 vss 0.000935349f $X=0.216 $Y=0.054
c12 14 vss 0.0121965f $X=0.243 $Y=0.072
c13 15 vss 0.00509242f $X=0.351 $Y=0.101
r1 46 45 16.4967 $w=2.1e-08 $l=4.85e-08 $layer=Gate_1 $thickness=5.6e-08
+ $X=0.351 $Y=0.2025 $X2=0.351 $Y2=0.154
r2 43 44 16.4967 $w=2.1e-08 $l=4.85e-08 $layer=Gate_1 $thickness=5.6e-08
+ $X=0.351 $Y=0.0675 $X2=0.351 $Y2=0.116
r3 6 44 6.6497 $w=2.04211e-08 $l=1.9e-08 $layer=Gate_1 $thickness=5.6e-08
+ $X=0.351 $Y=0.135 $X2=0.351 $Y2=0.116
r4 6 45 6.6497 $w=2.04211e-08 $l=1.9e-08 $layer=Gate_1 $thickness=5.6e-08
+ $X=0.351 $Y=0.135 $X2=0.351 $Y2=0.154
r5 2 38 19.3796 $a=3.24e-16 $layer=V0LIG $X=0.351 $Y=0.135 $X2=0.351 $Y2=0.135
r6 2 6 8.65438 $w=1.80211e-08 $layer=LIG $thickness=5.26316e-08 $X=0.351
+ $Y=0.135 $X2=0.351 $Y2=0.135
r7 37 38 2.68168 $w=1.3e-08 $l=1.15e-08 $layer=M1 $thickness=3.6e-08 $X=0.351
+ $Y=0.1235 $X2=0.351 $Y2=0.135
r8 15 37 5.24677 $w=1.3e-08 $l=2.25e-08 $layer=M1 $thickness=3.6e-08 $X=0.351
+ $Y=0.101 $X2=0.351 $Y2=0.1235
r9 10 36 9.89378 $w=1.39091e-08 $l=4.95e-08 $layer=M1 $thickness=3.6e-08
+ $X=0.351 $Y=0.072 $X2=0.3015 $Y2=0.072
r10 10 15 5.11339 $w=1.60414e-08 $l=2.9e-08 $layer=M1 $thickness=3.6e-08
+ $X=0.351 $Y=0.072 $X2=0.351 $Y2=0.101
r11 14 36 13.6416 $w=1.3e-08 $l=5.85e-08 $layer=M1 $thickness=3.6e-08 $X=0.243
+ $Y=0.072 $X2=0.3015 $Y2=0.072
r12 9 13 2.45586 $w=1.44e-08 $l=1.25e-08 $layer=M1 $thickness=3.6e-08 $X=0.216
+ $Y=0.0665 $X2=0.216 $Y2=0.054
r13 9 14 4.55457 $w=1.3814e-08 $l=2.75545e-08 $layer=M1 $thickness=3.6e-08
+ $X=0.216 $Y=0.0665 $X2=0.243 $Y2=0.072
r14 8 33 3.59766 $w=1.5e-08 $l=2.25e-08 $layer=M1 $thickness=3.6e-08 $X=0.216
+ $Y=0.036 $X2=0.1935 $Y2=0.036
r15 8 13 2.5483 $w=1.79e-08 $l=1.8e-08 $layer=M1 $thickness=3.6e-08 $X=0.216
+ $Y=0.036 $X2=0.216 $Y2=0.054
r16 32 33 5.24677 $w=1.3e-08 $l=2.25e-08 $layer=M1 $thickness=3.6e-08 $X=0.171
+ $Y=0.036 $X2=0.1935 $Y2=0.036
r17 31 32 4.19742 $w=1.3e-08 $l=1.8e-08 $layer=M1 $thickness=3.6e-08 $X=0.153
+ $Y=0.036 $X2=0.171 $Y2=0.036
r18 30 31 4.19742 $w=1.3e-08 $l=1.8e-08 $layer=M1 $thickness=3.6e-08 $X=0.135
+ $Y=0.036 $X2=0.153 $Y2=0.036
r19 29 30 5.82974 $w=1.3e-08 $l=2.5e-08 $layer=M1 $thickness=3.6e-08 $X=0.11
+ $Y=0.036 $X2=0.135 $Y2=0.036
r20 12 29 4.19742 $w=1.3e-08 $l=1.8e-08 $layer=M1 $thickness=3.6e-08 $X=0.092
+ $Y=0.036 $X2=0.11 $Y2=0.036
r21 7 28 3.36447 $w=1.71023e-08 $l=2.15e-08 $layer=M1 $thickness=3.6e-08
+ $X=0.081 $Y=0.036 $X2=0.081 $Y2=0.0575
r22 7 12 0.915974 $w=1.70909e-08 $l=1.1e-08 $layer=M1 $thickness=3.6e-08
+ $X=0.081 $Y=0.036 $X2=0.092 $Y2=0.036
r23 26 11 8.62802 $w=1.3e-08 $l=3.7e-08 $layer=M1 $thickness=3.6e-08 $X=0.077
+ $Y=0.136 $X2=0.081 $Y2=0.098
r24 11 28 9.44419 $w=1.3e-08 $l=4.05e-08 $layer=M1 $thickness=3.6e-08 $X=0.081
+ $Y=0.098 $X2=0.081 $Y2=0.0575
r25 1 19 8.65438 $w=1.80211e-08 $layer=LIG $thickness=5.26316e-08 $X=0.081
+ $Y=0.135 $X2=0.081 $Y2=0.135
r26 26 1 19.3796 $a=3.24e-16 $layer=V0LIG $X=0.077 $Y=0.136 $X2=0.081 $Y2=0.135
r27 22 21 14.6259 $w=2.1e-08 $l=4.3e-08 $layer=Gate_1 $thickness=5.6e-08
+ $X=0.081 $Y=0.216 $X2=0.081 $Y2=0.173
r28 20 21 7.31297 $w=2.1e-08 $l=2.15e-08 $layer=Gate_1 $thickness=5.6e-08
+ $X=0.081 $Y=0.1515 $X2=0.081 $Y2=0.173
r29 19 20 5.79936 $w=2.03333e-08 $l=1.65e-08 $layer=Gate_1 $thickness=5.6e-08
+ $X=0.081 $Y=0.135 $X2=0.081 $Y2=0.1515
r30 18 19 5.79936 $w=2.03333e-08 $l=1.65e-08 $layer=Gate_1 $thickness=5.6e-08
+ $X=0.081 $Y=0.1185 $X2=0.081 $Y2=0.135
r31 17 18 2.7211 $w=2.1e-08 $l=8e-09 $layer=Gate_1 $thickness=5.6e-08 $X=0.081
+ $Y=0.1105 $X2=0.081 $Y2=0.1185
r32 16 17 14.6259 $w=2.1e-08 $l=4.3e-08 $layer=Gate_1 $thickness=5.6e-08
+ $X=0.081 $Y=0.0675 $X2=0.081 $Y2=0.1105
r33 16 5 14.6259 $w=2.1e-08 $l=4.3e-08 $layer=Gate_1 $thickness=5.6e-08
+ $X=0.081 $Y=0.0675 $X2=0.081 $Y2=0.0245
.ends

.subckt PM_XNOR2xp5_ASAP7_75t_R%5 vss 20 26 41 48 49 11 15 4 3 1 16 18 9 19 10
+ 14
c1 1 vss 0.00381126f $X=0.405 $Y=0.135
c2 3 vss 0.00786366f $X=0.108 $Y=0.216
c3 4 vss 0.0104619f $X=0.1745 $Y=0.0675
c4 9 vss 0.082793f $X=0.405 $Y=0.0245
c5 10 vss 0.0377307f $X=0.1475 $Y=0.0675
c6 11 vss 0.00482746f $X=0.0935 $Y=0.216
c7 12 vss 0.000460855f $X=0.171 $Y=0.1945
c8 13 vss 0.00309573f $X=0.171 $Y=0.234
c9 14 vss 0.000604429f $X=0.405 $Y=0.198
c10 15 vss 0.00739677f $X=0.153 $Y=0.234
c11 16 vss 0.00201485f $X=0.171 $Y=0.1765
c12 17 vss 0.00075384f $X=0.171 $Y=0.216
c13 18 vss 0.00672589f $X=0.3915 $Y=0.198
c14 19 vss 0.00182333f $X=0.405 $Y=0.1235
r1 49 47 0.0462963 $w=5.4e-08 $l=2.5e-09 $layer=P_src_drn $thickness=1e-09
+ $X=0.1253 $Y=0.216 $X2=0.1225 $Y2=0.216
r2 3 47 0.268519 $w=5.4e-08 $l=1.45e-08 $layer=P_src_drn $thickness=1e-09
+ $X=0.108 $Y=0.216 $X2=0.1225 $Y2=0.216
r3 11 3 0.268519 $w=5.4e-08 $l=1.45e-08 $layer=P_src_drn $thickness=1e-09
+ $X=0.0935 $Y=0.216 $X2=0.108 $Y2=0.216
r4 48 11 0.0462963 $w=5.4e-08 $l=2.5e-09 $layer=P_src_drn $thickness=1e-09
+ $X=0.0906 $Y=0.216 $X2=0.0935 $Y2=0.216
r5 3 44 19.3796 $a=3.24e-16 $layer=V0LISD $X=0.108 $Y=0.216 $X2=0.108 $Y2=0.234
r6 44 45 3.14806 $w=1.3e-08 $l=1.35e-08 $layer=M1 $thickness=3.6e-08 $X=0.108
+ $Y=0.234 $X2=0.1215 $Y2=0.234
r7 42 45 3.14806 $w=1.3e-08 $l=1.35e-08 $layer=M1 $thickness=3.6e-08 $X=0.135
+ $Y=0.234 $X2=0.1215 $Y2=0.234
r8 15 42 4.19742 $w=1.3e-08 $l=1.8e-08 $layer=M1 $thickness=3.6e-08 $X=0.153
+ $Y=0.234 $X2=0.135 $Y2=0.234
r9 10 4 0.154321 $w=8.1e-08 $l=1.25e-08 $layer=N_src_drn $thickness=1e-09
+ $X=0.1475 $Y=0.0675 $X2=0.1745 $Y2=0.0675
r10 41 10 0.0308642 $w=8.1e-08 $l=2.5e-09 $layer=N_src_drn $thickness=1e-09
+ $X=0.1446 $Y=0.0675 $X2=0.1475 $Y2=0.0675
r11 13 17 2.5483 $w=1.79e-08 $l=1.8e-08 $layer=M1 $thickness=3.6e-08 $X=0.171
+ $Y=0.234 $X2=0.171 $Y2=0.216
r12 13 15 2.5483 $w=1.55e-08 $l=1.8e-08 $layer=M1 $thickness=3.6e-08 $X=0.171
+ $Y=0.234 $X2=0.153 $Y2=0.234
r13 4 37 19.3796 $a=3.24e-16 $layer=V0LISD $X=0.1745 $Y=0.0675 $X2=0.171
+ $Y2=0.09
r14 17 36 2.45586 $w=1.44e-08 $l=1.25e-08 $layer=M1 $thickness=3.6e-08 $X=0.171
+ $Y=0.216 $X2=0.171 $Y2=0.2035
r15 37 38 9.67738 $w=1.3e-08 $l=4.15e-08 $layer=M1 $thickness=3.6e-08 $X=0.171
+ $Y=0.09 $X2=0.171 $Y2=0.1315
r16 16 38 10.4935 $w=1.3e-08 $l=4.5e-08 $layer=M1 $thickness=3.6e-08 $X=0.171
+ $Y=0.1765 $X2=0.171 $Y2=0.1315
r17 12 36 0.9184 $w=1.8e-08 $l=9e-09 $layer=M1 $thickness=3.6e-08 $X=0.171
+ $Y=0.1945 $X2=0.171 $Y2=0.2035
r18 12 16 3.47612 $w=1.45278e-08 $l=1.8e-08 $layer=M1 $thickness=3.6e-08
+ $X=0.171 $Y=0.1945 $X2=0.171 $Y2=0.1765
r19 35 36 3.50522 $w=1.40294e-08 $l=2.31625e-08 $layer=M1 $thickness=3.6e-08
+ $X=0.1935 $Y=0.198 $X2=0.171 $Y2=0.2035
r20 34 35 8.86121 $w=1.3e-08 $l=3.8e-08 $layer=M1 $thickness=3.6e-08 $X=0.2315
+ $Y=0.198 $X2=0.1935 $Y2=0.198
r21 33 34 15.7403 $w=1.3e-08 $l=6.75e-08 $layer=M1 $thickness=3.6e-08 $X=0.299
+ $Y=0.198 $X2=0.2315 $Y2=0.198
r22 32 33 12.1259 $w=1.3e-08 $l=5.2e-08 $layer=M1 $thickness=3.6e-08 $X=0.351
+ $Y=0.198 $X2=0.299 $Y2=0.198
r23 31 32 5.24677 $w=1.3e-08 $l=2.25e-08 $layer=M1 $thickness=3.6e-08 $X=0.3735
+ $Y=0.198 $X2=0.351 $Y2=0.198
r24 18 31 4.19742 $w=1.3e-08 $l=1.8e-08 $layer=M1 $thickness=3.6e-08 $X=0.3915
+ $Y=0.198 $X2=0.3735 $Y2=0.198
r25 14 30 3.36447 $w=1.71023e-08 $l=2.15e-08 $layer=M1 $thickness=3.6e-08
+ $X=0.405 $Y=0.198 $X2=0.405 $Y2=0.1765
r26 14 18 1.49895 $w=1.63333e-08 $l=1.35e-08 $layer=M1 $thickness=3.6e-08
+ $X=0.405 $Y=0.198 $X2=0.3915 $Y2=0.198
r27 29 30 5.24677 $w=1.3e-08 $l=2.25e-08 $layer=M1 $thickness=3.6e-08 $X=0.405
+ $Y=0.154 $X2=0.405 $Y2=0.1765
r28 28 29 4.43061 $w=1.3e-08 $l=1.9e-08 $layer=M1 $thickness=3.6e-08 $X=0.405
+ $Y=0.135 $X2=0.405 $Y2=0.154
r29 19 28 2.68168 $w=1.3e-08 $l=1.15e-08 $layer=M1 $thickness=3.6e-08 $X=0.405
+ $Y=0.1235 $X2=0.405 $Y2=0.135
r30 1 23 10.4265 $w=1.765e-08 $layer=LIG $thickness=5.2e-08 $X=0.405 $Y=0.135
+ $X2=0.405 $Y2=0.135
r31 1 28 19.3796 $a=3.24e-16 $layer=V0LIG $X=0.405 $Y=0.135 $X2=0.405 $Y2=0.135
r32 26 25 14.6259 $w=2.1e-08 $l=4.3e-08 $layer=Gate_1 $thickness=5.6e-08
+ $X=0.405 $Y=0.2025 $X2=0.405 $Y2=0.1595
r33 24 25 2.7211 $w=2.1e-08 $l=8e-09 $layer=Gate_1 $thickness=5.6e-08 $X=0.405
+ $Y=0.1515 $X2=0.405 $Y2=0.1595
r34 23 24 5.79936 $w=2.03333e-08 $l=1.65e-08 $layer=Gate_1 $thickness=5.6e-08
+ $X=0.405 $Y=0.135 $X2=0.405 $Y2=0.1515
r35 22 23 5.79936 $w=2.03333e-08 $l=1.65e-08 $layer=Gate_1 $thickness=5.6e-08
+ $X=0.405 $Y=0.1185 $X2=0.405 $Y2=0.135
r36 21 22 2.7211 $w=2.1e-08 $l=8e-09 $layer=Gate_1 $thickness=5.6e-08 $X=0.405
+ $Y=0.1105 $X2=0.405 $Y2=0.1185
r37 20 21 14.6259 $w=2.1e-08 $l=4.3e-08 $layer=Gate_1 $thickness=5.6e-08
+ $X=0.405 $Y=0.0675 $X2=0.405 $Y2=0.1105
r38 20 9 14.6259 $w=2.1e-08 $l=4.3e-08 $layer=Gate_1 $thickness=5.6e-08
+ $X=0.405 $Y=0.0675 $X2=0.405 $Y2=0.0245
.ends

.subckt PM_XNOR2xp5_ASAP7_75t_R%Y vss 22 18 31 33 11 12 3 15 16 10
c1 2 vss 0.0099549f $X=0.432 $Y=0.0675
c2 3 vss 0.00842761f $X=0.432 $Y=0.2025
c3 10 vss 0.0382437f $X=0.4175 $Y=0.0675
c4 11 vss 0.0443344f $X=0.272 $Y=0.2025
c5 12 vss 0.0382454f $X=0.4175 $Y=0.2025
c6 13 vss 0.00609706f $X=0.432 $Y=0.036
c7 14 vss 0.00276409f $X=0.459 $Y=0.234
c8 15 vss 0.0168387f $X=0.432 $Y=0.234
c9 16 vss 0.00545996f $X=0.459 $Y=0.054
r1 33 32 0.0308642 $w=8.1e-08 $l=2.5e-09 $layer=P_src_drn $thickness=1e-09
+ $X=0.2873 $Y=0.2025 $X2=0.2845 $Y2=0.2025
r2 11 32 0.154321 $w=8.1e-08 $l=1.25e-08 $layer=P_src_drn $thickness=1e-09
+ $X=0.272 $Y=0.2025 $X2=0.2845 $Y2=0.2025
r3 12 3 0.154321 $w=8.1e-08 $l=1.25e-08 $layer=P_src_drn $thickness=1e-09
+ $X=0.4175 $Y=0.2025 $X2=0.432 $Y2=0.2025
r4 31 12 0.0308642 $w=8.1e-08 $l=2.5e-09 $layer=P_src_drn $thickness=1e-09
+ $X=0.4146 $Y=0.2025 $X2=0.4175 $Y2=0.2025
r5 11 27 19.3796 $a=3.24e-16 $layer=V0LISD $X=0.272 $Y=0.2025 $X2=0.27 $Y2=0.234
r6 3 15 19.3796 $a=3.24e-16 $layer=V0LISD $X=0.432 $Y=0.2025 $X2=0.432 $Y2=0.234
r7 27 28 17.839 $w=1.3e-08 $l=7.65e-08 $layer=M1 $thickness=3.6e-08 $X=0.27
+ $Y=0.234 $X2=0.3465 $Y2=0.234
r8 25 28 16.7897 $w=1.3e-08 $l=7.2e-08 $layer=M1 $thickness=3.6e-08 $X=0.4185
+ $Y=0.234 $X2=0.3465 $Y2=0.234
r9 15 24 3.14806 $w=1.3e-08 $l=1.35e-08 $layer=M1 $thickness=3.6e-08 $X=0.432
+ $Y=0.234 $X2=0.4455 $Y2=0.234
r10 15 25 3.14806 $w=1.3e-08 $l=1.35e-08 $layer=M1 $thickness=3.6e-08 $X=0.432
+ $Y=0.234 $X2=0.4185 $Y2=0.234
r11 14 23 2.5483 $w=1.79e-08 $l=1.8e-08 $layer=M1 $thickness=3.6e-08 $X=0.459
+ $Y=0.234 $X2=0.459 $Y2=0.216
r12 14 24 1.49895 $w=1.63333e-08 $l=1.35e-08 $layer=M1 $thickness=3.6e-08
+ $X=0.459 $Y=0.234 $X2=0.4455 $Y2=0.234
r13 22 23 12.1259 $w=1.3e-08 $l=5.2e-08 $layer=M1 $thickness=3.6e-08 $X=0.457
+ $Y=0.135 $X2=0.459 $Y2=0.216
r14 22 21 16.7897 $w=1.3e-08 $l=7.2e-08 $layer=M1 $thickness=3.6e-08 $X=0.457
+ $Y=0.135 $X2=0.459 $Y2=0.092
r15 16 20 3.01711 $w=1.55e-08 $l=1.8e-08 $layer=M1 $thickness=3.6e-08 $X=0.459
+ $Y=0.054 $X2=0.459 $Y2=0.036
r16 16 21 8.86121 $w=1.3e-08 $l=3.8e-08 $layer=M1 $thickness=3.6e-08 $X=0.459
+ $Y=0.054 $X2=0.459 $Y2=0.092
r17 19 20 1.96775 $w=1.63333e-08 $l=1.35e-08 $layer=M1 $thickness=3.6e-08
+ $X=0.4455 $Y=0.036 $X2=0.459 $Y2=0.036
r18 13 19 3.14806 $w=1.3e-08 $l=1.35e-08 $layer=M1 $thickness=3.6e-08 $X=0.432
+ $Y=0.036 $X2=0.4455 $Y2=0.036
r19 2 13 19.3796 $a=3.24e-16 $layer=V0LISD $X=0.432 $Y=0.0675 $X2=0.432
+ $Y2=0.036
r20 10 2 0.154321 $w=8.1e-08 $l=1.25e-08 $layer=N_src_drn $thickness=1e-09
+ $X=0.4175 $Y=0.0675 $X2=0.432 $Y2=0.0675
r21 18 10 0.0308642 $w=8.1e-08 $l=2.5e-09 $layer=N_src_drn $thickness=1e-09
+ $X=0.4146 $Y=0.0675 $X2=0.4175 $Y2=0.0675
.ends

.subckt PM_XNOR2xp5_ASAP7_75t_R%B vss 21 6 12 25 29 1 5 4 3
c1 1 vss 0.018739f $X=0.1255 $Y=0.135
c2 3 vss 0.043557f $X=0.135 $Y=0.0245
c3 4 vss 0.109991f $X=0.297 $Y=0.135
c4 5 vss 0.00478586f $X=0.135 $Y=0.0725
r1 29 28 14.6259 $w=2.1e-08 $l=4.3e-08 $layer=Gate_1 $thickness=5.6e-08
+ $X=0.297 $Y=0.2025 $X2=0.297 $Y2=0.1595
r2 27 28 3.23131 $w=2.1e-08 $l=9.5e-09 $layer=Gate_1 $thickness=5.6e-08
+ $X=0.297 $Y=0.15 $X2=0.297 $Y2=0.1595
r3 25 26 14.6259 $w=2.1e-08 $l=4.3e-08 $layer=Gate_1 $thickness=5.6e-08
+ $X=0.297 $Y=0.0675 $X2=0.297 $Y2=0.1105
r4 23 26 3.23131 $w=2.1e-08 $l=9.5e-09 $layer=Gate_1 $thickness=5.6e-08
+ $X=0.297 $Y=0.12 $X2=0.297 $Y2=0.1105
r5 4 18 7.58422 $w=1.77778e-08 $layer=LIG $thickness=5.15556e-08 $X=0.297
+ $Y=0.135 $X2=0.297 $Y2=0.135
r6 4 23 5.23813 $w=2.04667e-08 $l=1.5e-08 $layer=Gate_1 $thickness=5.6e-08
+ $X=0.297 $Y=0.135 $X2=0.297 $Y2=0.12
r7 4 27 5.23813 $w=2.04667e-08 $l=1.5e-08 $layer=Gate_1 $thickness=5.6e-08
+ $X=0.297 $Y=0.135 $X2=0.297 $Y2=0.15
r8 21 20 7.92845 $w=1.3e-08 $l=3.4e-08 $layer=M1 $thickness=3.6e-08 $X=0.136
+ $Y=0.135 $X2=0.135 $Y2=0.101
r9 5 20 6.64591 $w=1.3e-08 $l=2.85e-08 $layer=M1 $thickness=3.6e-08 $X=0.135
+ $Y=0.0725 $X2=0.135 $Y2=0.101
r10 17 18 170.233 $w=1.01272e-08 $l=8.1e-08 $layer=LIG $thickness=4.8e-08
+ $X=0.216 $Y=0.135 $X2=0.297 $Y2=0.135
r11 15 17 165.742 $w=9.34685e-09 $l=7.15e-08 $layer=LIG $thickness=4.8e-08
+ $X=0.1445 $Y=0.135 $X2=0.216 $Y2=0.135
r12 14 15 4.49071 $w=1.6e-08 $l=9.5e-09 $layer=LIG $thickness=4.8e-08 $X=0.135
+ $Y=0.135 $X2=0.1445 $Y2=0.135
r13 21 14 28.9687 $a=2.88e-16 $layer=V0LIG $X=0.136 $Y=0.135 $X2=0.135 $Y2=0.135
r14 1 14 4.49071 $w=1.6e-08 $l=9.5e-09 $layer=LIG $thickness=4.8e-08 $X=0.1255
+ $Y=0.135 $X2=0.135 $Y2=0.135
r15 12 11 14.6259 $w=2.1e-08 $l=4.3e-08 $layer=Gate_1 $thickness=5.6e-08
+ $X=0.135 $Y=0.216 $X2=0.135 $Y2=0.173
r16 10 11 7.82318 $w=2.1e-08 $l=2.3e-08 $layer=Gate_1 $thickness=5.6e-08
+ $X=0.135 $Y=0.15 $X2=0.135 $Y2=0.173
r17 9 10 5.23813 $w=2.04667e-08 $l=1.5e-08 $layer=Gate_1 $thickness=5.6e-08
+ $X=0.135 $Y=0.135 $X2=0.135 $Y2=0.15
r18 9 15 3.09351 $w=1.97647e-08 $l=9.5e-09 $layer=Gate_1 $thickness=5.55294e-08
+ $X=0.135 $Y=0.135 $X2=0.1445 $Y2=0.135
r19 9 14 7.11151 $w=1.78824e-08 $layer=LIG $thickness=5.17647e-08 $X=0.135
+ $Y=0.135 $X2=0.135 $Y2=0.135
r20 8 9 5.23813 $w=2.04667e-08 $l=1.5e-08 $layer=Gate_1 $thickness=5.6e-08
+ $X=0.135 $Y=0.12 $X2=0.135 $Y2=0.135
r21 7 8 3.23131 $w=2.1e-08 $l=9.5e-09 $layer=Gate_1 $thickness=5.6e-08 $X=0.135
+ $Y=0.1105 $X2=0.135 $Y2=0.12
r22 6 7 14.6259 $w=2.1e-08 $l=4.3e-08 $layer=Gate_1 $thickness=5.6e-08 $X=0.135
+ $Y=0.0675 $X2=0.135 $Y2=0.1105
r23 6 3 14.6259 $w=2.1e-08 $l=4.3e-08 $layer=Gate_1 $thickness=5.6e-08 $X=0.135
+ $Y=0.0675 $X2=0.135 $Y2=0.0245
.ends

* End of included file XNOR2xp5_ASAP7_75t_R.pex.sp.pex

*
.subckt XNOR2xp5_ASAP7_75t_CUSTOM_4_25_0_7 VSS VDD A B Y
*
* VSS VSS
* VDD VDD
* A A
* B B
* Y Y
*
*

M0 N_M0_d N_M0_g VSS VSS nmos_rvt L=2e-08 W=8.1e-08 nfin=3 $X=0.071 $Y=0.027
M1 N_M1_d N_M1_g N_M1_s VSS nmos_rvt L=2e-08 W=8.1e-08 nfin=3 $X=0.125 $Y=0.027
M2 VSS N_M2_g noxref_6 VSS nmos_rvt L=2e-08 W=8.1e-08 nfin=3 $X=0.287 $Y=0.027
M3 noxref_6 N_M3_g VSS VSS nmos_rvt L=2e-08 W=8.1e-08 nfin=3 $X=0.341 $Y=0.027
M4 N_M4_d N_M4_g noxref_6 VSS nmos_rvt L=2e-08 W=8.1e-08 nfin=3 $X=0.395
+ $Y=0.027
M5 N_M5_d N_M5_g VDD VDD pmos_rvt L=2e-08 W=5.4e-08 nfin=2 $X=0.071 $Y=0.189
M6 VDD N_M6_g N_M6_s VDD pmos_rvt L=2e-08 W=5.4e-08 nfin=2 $X=0.125 $Y=0.189
M7 noxref_9 N_M7_g N_M7_s VDD pmos_rvt L=2e-08 W=8.1e-08 nfin=3 $X=0.287
+ $Y=0.162
M8 VDD N_M8_g noxref_9 VDD pmos_rvt L=2e-08 W=8.1e-08 nfin=3 $X=0.341 $Y=0.162
M9 N_M9_d N_M9_g VDD VDD pmos_rvt L=2e-08 W=8.1e-08 nfin=3 $X=0.395 $Y=0.162

* .include "XNOR2xp5_ASAP7_75t_R.pex.sp.pxi"

* Start of included file XNOR2xp5_ASAP7_75t_R.pex.sp.pxi
x_PM_XNOR2xp5_ASAP7_75t_R%8 vss N_M0_d N_M1_s N_8_1 PM_XNOR2xp5_ASAP7_75t_R%8
cc_1 N_8_1 N_A_5 0.0167813f $X=0.108 $Y=0.0675
cc_2 N_8_1 N_B_3 0.016729f $X=0.108 $Y=0.0675
x_PM_XNOR2xp5_ASAP7_75t_R%A vss A N_M0_g N_M5_g N_M3_g N_M8_g N_A_5 N_A_1
+ N_A_12 N_A_9 N_A_6 N_A_11 N_A_14 N_A_2 N_A_15 PM_XNOR2xp5_ASAP7_75t_R%A
x_PM_XNOR2xp5_ASAP7_75t_R%5 vss N_M4_g N_M9_g N_M1_d N_M5_d N_M6_s N_5_11
+ N_5_15 N_5_4 N_5_3 N_5_1 N_5_16 N_5_18 N_5_9 N_5_19 N_5_10 N_5_14
+ PM_XNOR2xp5_ASAP7_75t_R%5
cc_3 N_5_11 N_A_1 0.000360746f $X=0.0935 $Y=0.216
cc_4 N_5_11 N_A_9 0.0004871f $X=0.0935 $Y=0.216
cc_5 N_5_15 N_A_11 0.000598492f $X=0.153 $Y=0.234
cc_6 N_5_4 N_A_14 0.000708898f $X=0.1745 $Y=0.0675
cc_7 N_5_3 N_A_5 0.000730601f $X=0.108 $Y=0.216
cc_8 N_5_1 N_A_2 0.00209785f $X=0.405 $Y=0.135
cc_9 N_5_16 N_A_11 0.00132679f $X=0.171 $Y=0.1765
cc_10 N_5_16 N_A_12 0.00166986f $X=0.171 $Y=0.1765
cc_11 N_5_4 N_A_12 0.00178247f $X=0.1745 $Y=0.0675
cc_12 N_5_18 N_A_15 0.00198401f $X=0.3915 $Y=0.198
cc_13 N_5_16 N_A_9 0.00251388f $X=0.171 $Y=0.1765
cc_14 N_5_9 N_A_6 0.00334238f $X=0.405 $Y=0.0245
cc_15 N_5_19 N_A_15 0.00346357f $X=0.405 $Y=0.1235
cc_16 N_5_11 N_A_5 0.0262797f $X=0.0935 $Y=0.216
cc_17 N_5_10 N_B_5 0.00125667f $X=0.1475 $Y=0.0675
cc_18 N_5_3 N_B_3 0.000695148f $X=0.108 $Y=0.216
cc_19 N_5_15 N_B_5 0.000755617f $X=0.153 $Y=0.234
cc_20 N_5_16 N_B_1 0.000773959f $X=0.171 $Y=0.1765
cc_21 N_5_18 N_B_1 0.000777787f $X=0.3915 $Y=0.198
cc_22 N_5_4 N_B_3 0.00275518f $X=0.1745 $Y=0.0675
cc_23 N_5_11 N_B_3 0.0105535f $X=0.0935 $Y=0.216
cc_24 N_5_4 N_B_1 0.00509609f $X=0.1745 $Y=0.0675
cc_25 N_5_16 N_B_5 0.0105009f $X=0.171 $Y=0.1765
cc_26 N_5_10 N_B_3 0.0502961f $X=0.1475 $Y=0.0675
x_PM_XNOR2xp5_ASAP7_75t_R%Y vss Y N_M4_d N_M9_d N_M7_s N_Y_11 N_Y_12 N_Y_3
+ N_Y_15 N_Y_16 N_Y_10 PM_XNOR2xp5_ASAP7_75t_R%Y
cc_27 N_Y_11 N_B_1 0.00288557f $X=0.272 $Y=0.2025
cc_28 N_Y_11 N_B_4 0.0372057f $X=0.272 $Y=0.2025
cc_29 N_Y_12 N_5_1 0.00249577f $X=0.4175 $Y=0.2025
cc_30 N_Y_12 N_5_18 0.00121064f $X=0.4175 $Y=0.2025
cc_31 N_Y_3 N_5_9 0.00128452f $X=0.432 $Y=0.2025
cc_32 N_Y_15 N_5_14 0.00164147f $X=0.432 $Y=0.234
cc_33 N_Y_16 N_5_19 0.00428444f $X=0.459 $Y=0.054
cc_34 N_Y_10 N_5_9 0.0148233f $X=0.4175 $Y=0.0675
cc_35 N_Y_15 N_5_18 0.0124233f $X=0.432 $Y=0.234
cc_36 N_Y_12 N_5_9 0.0562676f $X=0.4175 $Y=0.2025
x_PM_XNOR2xp5_ASAP7_75t_R%B vss B N_M1_g N_M6_g N_M2_g N_M7_g N_B_1 N_B_5 N_B_4
+ N_B_3 PM_XNOR2xp5_ASAP7_75t_R%B
cc_37 N_B_1 N_A_5 0.000914411f $X=0.1255 $Y=0.135
cc_38 N_B_1 N_A_1 0.00169346f $X=0.1255 $Y=0.135
cc_39 N_B_5 N_A_12 0.0010208f $X=0.135 $Y=0.0725
cc_40 N_B_1 N_A_9 0.00177802f $X=0.1255 $Y=0.135
cc_41 N_B_4 N_A_6 0.00489858f $X=0.297 $Y=0.135
cc_42 N_B_5 N_A_11 0.00605439f $X=0.135 $Y=0.0725
cc_43 N_B_3 N_A_5 0.00757606f $X=0.135 $Y=0.0245

* End of included file XNOR2xp5_ASAP7_75t_R.pex.sp.pxi
.ends

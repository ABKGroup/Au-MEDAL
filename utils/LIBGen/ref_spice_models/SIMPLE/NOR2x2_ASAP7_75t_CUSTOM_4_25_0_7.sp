.subckt PM_NOR2x2_ASAP7_75t_R%A vss 27 9 13 25 33 36 39 6 1 8 3 5 4 7
c1 1 vss 0.0233484f $X=0.189 $Y=0.1355
c2 3 vss 0.087523f $X=0.189 $Y=0.0245
c3 4 vss 0.0512992f $X=0.243 $Y=0.1355
c4 5 vss 0.0512992f $X=0.297 $Y=0.1355
c5 6 vss 0.087523f $X=0.351 $Y=0.1355
c6 7 vss 0.00613115f $X=0.27 $Y=0.072
c7 8 vss 0.00638241f $X=0.27 $Y=0.1095
r1 7 29 2.31754 $w=1.6e-08 $l=1.5e-08 $layer=M1 $thickness=3.6e-08 $X=0.27
+ $Y=0.072 $X2=0.27 $Y2=0.087
r2 39 38 16.3266 $w=2.1e-08 $l=4.8e-08 $layer=Gate_1 $thickness=5.6e-08
+ $X=0.351 $Y=0.2025 $X2=0.351 $Y2=0.1545
r3 36 37 16.4967 $w=2.1e-08 $l=4.85e-08 $layer=Gate_1 $thickness=5.6e-08
+ $X=0.351 $Y=0.0675 $X2=0.351 $Y2=0.116
r4 6 21 6.4735 $w=2.13953e-08 $layer=Gate_1 $thickness=5.22791e-08 $X=0.351
+ $Y=0.1355 $X2=0.351 $Y2=0.1355
r5 6 37 6.82827 $w=2.04103e-08 $l=1.95e-08 $layer=Gate_1 $thickness=5.6e-08
+ $X=0.351 $Y=0.1355 $X2=0.351 $Y2=0.116
r6 6 38 6.6582 $w=2.03947e-08 $l=1.9e-08 $layer=Gate_1 $thickness=5.6e-08
+ $X=0.351 $Y=0.1355 $X2=0.351 $Y2=0.1545
r7 33 32 16.3266 $w=2.1e-08 $l=4.8e-08 $layer=Gate_1 $thickness=5.6e-08
+ $X=0.297 $Y=0.2025 $X2=0.297 $Y2=0.1545
r8 5 19 6.4735 $w=2.13953e-08 $layer=Gate_1 $thickness=5.22791e-08 $X=0.297
+ $Y=0.1355 $X2=0.297 $Y2=0.1355
r9 5 32 6.6582 $w=2.03947e-08 $l=1.9e-08 $layer=Gate_1 $thickness=5.6e-08
+ $X=0.297 $Y=0.1355 $X2=0.297 $Y2=0.1545
r10 27 8 5.94634 $w=1.3e-08 $l=2.55e-08 $layer=M1 $thickness=3.6e-08 $X=0.272
+ $Y=0.136 $X2=0.27 $Y2=0.1095
r11 8 29 5.24677 $w=1.3e-08 $l=2.25e-08 $layer=M1 $thickness=3.6e-08 $X=0.27
+ $Y=0.1095 $X2=0.27 $Y2=0.087
r12 25 24 16.3266 $w=2.1e-08 $l=4.8e-08 $layer=Gate_1 $thickness=5.6e-08
+ $X=0.243 $Y=0.2025 $X2=0.243 $Y2=0.1545
r13 4 17 6.4735 $w=2.13953e-08 $layer=Gate_1 $thickness=5.22791e-08 $X=0.243
+ $Y=0.1355 $X2=0.243 $Y2=0.1355
r14 4 24 6.6582 $w=2.03947e-08 $l=1.9e-08 $layer=Gate_1 $thickness=5.6e-08
+ $X=0.243 $Y=0.1355 $X2=0.243 $Y2=0.1545
r15 20 21 10.1596 $w=1.87815e-08 $l=2.7e-08 $layer=LIG $thickness=4.8e-08
+ $X=0.324 $Y=0.1355 $X2=0.351 $Y2=0.1355
r16 19 20 10.1596 $w=1.87815e-08 $l=2.7e-08 $layer=LIG $thickness=4.8e-08
+ $X=0.297 $Y=0.1355 $X2=0.324 $Y2=0.1355
r17 18 19 10.1596 $w=1.87815e-08 $l=2.7e-08 $layer=LIG $thickness=4.8e-08
+ $X=0.27 $Y=0.1355 $X2=0.297 $Y2=0.1355
r18 27 18 19.3796 $a=3.24e-16 $layer=V0LIG $X=0.272 $Y=0.136 $X2=0.27 $Y2=0.1355
r19 17 18 10.1596 $w=1.87815e-08 $l=2.7e-08 $layer=LIG $thickness=4.8e-08
+ $X=0.243 $Y=0.1355 $X2=0.27 $Y2=0.1355
r20 16 17 10.1596 $w=1.87815e-08 $l=2.7e-08 $layer=LIG $thickness=4.8e-08
+ $X=0.216 $Y=0.1355 $X2=0.243 $Y2=0.1355
r21 1 11 6.4735 $w=2.13953e-08 $layer=Gate_1 $thickness=5.22791e-08 $X=0.189
+ $Y=0.1355 $X2=0.189 $Y2=0.1355
r22 1 16 10.1596 $w=1.87815e-08 $l=2.7e-08 $layer=LIG $thickness=4.8e-08
+ $X=0.189 $Y=0.1355 $X2=0.216 $Y2=0.1355
r23 13 12 16.3266 $w=2.1e-08 $l=4.8e-08 $layer=Gate_1 $thickness=5.6e-08
+ $X=0.189 $Y=0.2025 $X2=0.189 $Y2=0.1545
r24 11 12 6.6582 $w=2.03947e-08 $l=1.9e-08 $layer=Gate_1 $thickness=5.6e-08
+ $X=0.189 $Y=0.1355 $X2=0.189 $Y2=0.1545
r25 10 11 6.82827 $w=2.04103e-08 $l=1.95e-08 $layer=Gate_1 $thickness=5.6e-08
+ $X=0.189 $Y=0.116 $X2=0.189 $Y2=0.1355
r26 9 10 16.4967 $w=2.1e-08 $l=4.85e-08 $layer=Gate_1 $thickness=5.6e-08
+ $X=0.189 $Y=0.0675 $X2=0.189 $Y2=0.116
r27 9 3 14.6259 $w=2.1e-08 $l=4.3e-08 $layer=Gate_1 $thickness=5.6e-08 $X=0.189
+ $Y=0.0675 $X2=0.189 $Y2=0.0245
.ends

.subckt PM_NOR2x2_ASAP7_75t_R%B vss 43 23 27 39 66 69 72 20 19 21 17 13 1 2 11
+ 6 7 10 15 18 5 8 12 14 9 16 22
c1 1 vss 0.00840149f $X=0.135 $Y=0.135
c2 2 vss 0.00840149f $X=0.4495 $Y=0.135
c3 5 vss 0.0203132f $X=0.081 $Y=0.135
c4 6 vss 0.04698f $X=0.135 $Y=0.0245
c5 7 vss 0.04698f $X=0.405 $Y=0.135
c6 8 vss 0.0203132f $X=0.459 $Y=0.135
c7 9 vss 0.00406568f $X=0.081 $Y=0.072
c8 10 vss 0.00324897f $X=0.081 $Y=0.162
c9 11 vss 0.0035599f $X=0.209 $Y=0.1585
c10 12 vss 0.00373974f $X=0.209 $Y=0.198
c11 13 vss 0.0035599f $X=0.331 $Y=0.1675
c12 14 vss 0.00373974f $X=0.331 $Y=0.198
c13 15 vss 0.00324897f $X=0.459 $Y=0.162
c14 16 vss 0.00372453f $X=0.081 $Y=0.1035
c15 17 vss 0.00470568f $X=0.0995 $Y=0.162
c16 18 vss 0.00354193f $X=0.209 $Y=0.18
c17 19 vss 0.00525903f $X=0.23 $Y=0.198
c18 20 vss 0.00354193f $X=0.331 $Y=0.18
c19 21 vss 0.00474321f $X=0.379 $Y=0.162
c20 22 vss 0.00382848f $X=0.459 $Y=0.1095
r1 72 71 16.4967 $w=2.1e-08 $l=4.85e-08 $layer=Gate_1 $thickness=5.6e-08
+ $X=0.405 $Y=0.2025 $X2=0.405 $Y2=0.154
r2 69 70 16.4967 $w=2.1e-08 $l=4.85e-08 $layer=Gate_1 $thickness=5.6e-08
+ $X=0.405 $Y=0.0675 $X2=0.405 $Y2=0.116
r3 7 59 6.54019 $w=2.09524e-08 $layer=Gate_1 $thickness=5.21905e-08 $X=0.405
+ $Y=0.135 $X2=0.405 $Y2=0.135
r4 7 70 6.6497 $w=2.04211e-08 $l=1.9e-08 $layer=Gate_1 $thickness=5.6e-08
+ $X=0.405 $Y=0.135 $X2=0.405 $Y2=0.116
r5 7 71 6.6497 $w=2.04211e-08 $l=1.9e-08 $layer=Gate_1 $thickness=5.6e-08
+ $X=0.405 $Y=0.135 $X2=0.405 $Y2=0.154
r6 66 65 14.6259 $w=2.1e-08 $l=4.3e-08 $layer=Gate_1 $thickness=5.6e-08
+ $X=0.459 $Y=0.2025 $X2=0.459 $Y2=0.1595
r7 64 65 2.7211 $w=2.1e-08 $l=8e-09 $layer=Gate_1 $thickness=5.6e-08 $X=0.459
+ $Y=0.1515 $X2=0.459 $Y2=0.1595
r8 8 56 6.27904 $w=2.09e-08 $layer=Gate_1 $thickness=5.24e-08 $X=0.459 $Y=0.135
+ $X2=0.459 $Y2=0.135
r9 8 64 5.79936 $w=2.03333e-08 $l=1.65e-08 $layer=Gate_1 $thickness=5.6e-08
+ $X=0.459 $Y=0.135 $X2=0.459 $Y2=0.1515
r10 58 59 12.6539 $w=1.77815e-08 $l=2.7e-08 $layer=LIG $thickness=4.8e-08
+ $X=0.432 $Y=0.135 $X2=0.405 $Y2=0.135
r11 2 56 2.48102 $w=2.2e-08 $l=9.5e-09 $layer=LIG $thickness=4.8e-08 $X=0.4495
+ $Y=0.135 $X2=0.459 $Y2=0.135
r12 2 58 10.1729 $w=1.54914e-08 $l=1.75e-08 $layer=LIG $thickness=4.8e-08
+ $X=0.4495 $Y=0.135 $X2=0.432 $Y2=0.135
r13 54 55 3.14806 $w=1.3e-08 $l=1.35e-08 $layer=M1 $thickness=3.6e-08 $X=0.459
+ $Y=0.135 $X2=0.459 $Y2=0.1485
r14 54 56 19.3796 $a=3.24e-16 $layer=V0LIG $X=0.459 $Y=0.135 $X2=0.459 $Y2=0.135
r15 22 54 5.94634 $w=1.3e-08 $l=2.55e-08 $layer=M1 $thickness=3.6e-08 $X=0.459
+ $Y=0.1095 $X2=0.459 $Y2=0.135
r16 15 53 4.18063 $w=1.48e-08 $l=2.5e-08 $layer=M1 $thickness=3.6e-08 $X=0.459
+ $Y=0.162 $X2=0.434 $Y2=0.162
r17 15 55 1.49895 $w=1.95333e-08 $l=1.35e-08 $layer=M1 $thickness=3.6e-08
+ $X=0.459 $Y=0.162 $X2=0.459 $Y2=0.1485
r18 21 53 12.8254 $w=1.3e-08 $l=5.5e-08 $layer=M1 $thickness=3.6e-08 $X=0.379
+ $Y=0.162 $X2=0.434 $Y2=0.162
r19 13 20 2.45586 $w=1.44e-08 $l=1.25e-08 $layer=M1 $thickness=3.6e-08 $X=0.331
+ $Y=0.1675 $X2=0.331 $Y2=0.18
r20 13 21 9.45156 $w=1.34118e-08 $l=4.83141e-08 $layer=M1 $thickness=3.6e-08
+ $X=0.331 $Y=0.1675 $X2=0.379 $Y2=0.162
r21 14 51 5.46317 $w=1.44754e-08 $l=3.05e-08 $layer=M1 $thickness=3.6e-08
+ $X=0.331 $Y=0.198 $X2=0.3005 $Y2=0.198
r22 14 20 2.5483 $w=1.79e-08 $l=1.8e-08 $layer=M1 $thickness=3.6e-08 $X=0.331
+ $Y=0.198 $X2=0.331 $Y2=0.18
r23 50 51 7.11229 $w=1.3e-08 $l=3.05e-08 $layer=M1 $thickness=3.6e-08 $X=0.27
+ $Y=0.198 $X2=0.3005 $Y2=0.198
r24 49 50 4.31401 $w=1.3e-08 $l=1.85e-08 $layer=M1 $thickness=3.6e-08 $X=0.2515
+ $Y=0.198 $X2=0.27 $Y2=0.198
r25 19 49 5.01358 $w=1.3e-08 $l=2.15e-08 $layer=M1 $thickness=3.6e-08 $X=0.23
+ $Y=0.198 $X2=0.2515 $Y2=0.198
r26 12 18 2.5483 $w=1.79e-08 $l=1.8e-08 $layer=M1 $thickness=3.6e-08 $X=0.209
+ $Y=0.198 $X2=0.209 $Y2=0.18
r27 12 19 3.24787 $w=1.51429e-08 $l=2.1e-08 $layer=M1 $thickness=3.6e-08
+ $X=0.209 $Y=0.198 $X2=0.23 $Y2=0.198
r28 18 48 2.45586 $w=1.44e-08 $l=1.25e-08 $layer=M1 $thickness=3.6e-08 $X=0.209
+ $Y=0.18 $X2=0.209 $Y2=0.1675
r29 11 48 0.9184 $w=1.8e-08 $l=9e-09 $layer=M1 $thickness=3.6e-08 $X=0.209
+ $Y=0.1585 $X2=0.209 $Y2=0.1675
r30 47 48 9.45156 $w=1.34118e-08 $l=4.83141e-08 $layer=M1 $thickness=3.6e-08
+ $X=0.161 $Y=0.162 $X2=0.209 $Y2=0.1675
r31 46 47 10.6101 $w=1.3e-08 $l=4.55e-08 $layer=M1 $thickness=3.6e-08 $X=0.1155
+ $Y=0.162 $X2=0.161 $Y2=0.162
r32 17 46 3.73104 $w=1.3e-08 $l=1.6e-08 $layer=M1 $thickness=3.6e-08 $X=0.0995
+ $Y=0.162 $X2=0.1155 $Y2=0.162
r33 10 44 0.507892 $w=2.25351e-08 $l=9.3e-09 $layer=M1 $thickness=3.6e-08
+ $X=0.081 $Y=0.162 $X2=0.081 $Y2=0.1527
r34 10 17 2.6649 $w=1.54324e-08 $l=1.85e-08 $layer=M1 $thickness=3.6e-08
+ $X=0.081 $Y=0.162 $X2=0.0995 $Y2=0.162
r35 9 16 6.16517 $w=1.44286e-08 $l=3.15e-08 $layer=M1 $thickness=3.6e-08
+ $X=0.081 $Y=0.072 $X2=0.081 $Y2=0.1035
r36 43 44 0.174892 $w=1.3e-08 $l=7e-10 $layer=M1 $thickness=3.6e-08 $X=0.084
+ $Y=0.152 $X2=0.081 $Y2=0.1527
r37 43 42 0.991057 $w=1.3e-08 $l=4.3e-09 $layer=M1 $thickness=3.6e-08 $X=0.084
+ $Y=0.152 $X2=0.081 $Y2=0.1477
r38 41 42 2.97317 $w=1.3e-08 $l=1.27e-08 $layer=M1 $thickness=3.6e-08 $X=0.081
+ $Y=0.135 $X2=0.081 $Y2=0.1477
r39 16 41 7.34548 $w=1.3e-08 $l=3.15e-08 $layer=M1 $thickness=3.6e-08 $X=0.081
+ $Y=0.1035 $X2=0.081 $Y2=0.135
r40 39 38 14.6259 $w=2.1e-08 $l=4.3e-08 $layer=Gate_1 $thickness=5.6e-08
+ $X=0.081 $Y=0.2025 $X2=0.081 $Y2=0.1595
r41 37 38 2.7211 $w=2.1e-08 $l=8e-09 $layer=Gate_1 $thickness=5.6e-08 $X=0.081
+ $Y=0.1515 $X2=0.081 $Y2=0.1595
r42 5 31 6.27904 $w=2.09e-08 $layer=Gate_1 $thickness=5.24e-08 $X=0.081
+ $Y=0.135 $X2=0.081 $Y2=0.135
r43 5 37 5.79936 $w=2.03333e-08 $l=1.65e-08 $layer=Gate_1 $thickness=5.6e-08
+ $X=0.081 $Y=0.135 $X2=0.081 $Y2=0.1515
r44 31 32 2.48102 $w=2.2e-08 $l=9.5e-09 $layer=LIG $thickness=4.8e-08 $X=0.081
+ $Y=0.135 $X2=0.0905 $Y2=0.135
r45 31 41 19.3796 $a=3.24e-16 $layer=V0LIG $X=0.081 $Y=0.135 $X2=0.081 $Y2=0.135
r46 29 32 10.1729 $w=1.54914e-08 $l=1.75e-08 $layer=LIG $thickness=4.8e-08
+ $X=0.108 $Y=0.135 $X2=0.0905 $Y2=0.135
r47 1 25 6.54019 $w=2.09524e-08 $layer=Gate_1 $thickness=5.21905e-08 $X=0.135
+ $Y=0.135 $X2=0.135 $Y2=0.135
r48 1 29 12.6539 $w=1.77815e-08 $l=2.7e-08 $layer=LIG $thickness=4.8e-08
+ $X=0.135 $Y=0.135 $X2=0.108 $Y2=0.135
r49 27 26 16.4967 $w=2.1e-08 $l=4.85e-08 $layer=Gate_1 $thickness=5.6e-08
+ $X=0.135 $Y=0.2025 $X2=0.135 $Y2=0.154
r50 25 26 6.6497 $w=2.04211e-08 $l=1.9e-08 $layer=Gate_1 $thickness=5.6e-08
+ $X=0.135 $Y=0.135 $X2=0.135 $Y2=0.154
r51 24 25 6.6497 $w=2.04211e-08 $l=1.9e-08 $layer=Gate_1 $thickness=5.6e-08
+ $X=0.135 $Y=0.116 $X2=0.135 $Y2=0.135
r52 23 24 16.4967 $w=2.1e-08 $l=4.85e-08 $layer=Gate_1 $thickness=5.6e-08
+ $X=0.135 $Y=0.0675 $X2=0.135 $Y2=0.116
r53 23 6 14.6259 $w=2.1e-08 $l=4.3e-08 $layer=Gate_1 $thickness=5.6e-08
+ $X=0.135 $Y=0.0675 $X2=0.135 $Y2=0.0245
.ends

.subckt PM_NOR2x2_ASAP7_75t_R%5 vss 24 25 42 43 46 47 49 51 19 17 3 1 5 2 4 21
+ 16 20 18
c1 1 vss 0.00579591f $X=0.054 $Y=0.2025
c2 2 vss 0.00601042f $X=0.162 $Y=0.2025
c3 3 vss 0.00836679f $X=0.27 $Y=0.2025
c4 4 vss 0.00601042f $X=0.378 $Y=0.2025
c5 5 vss 0.00579591f $X=0.486 $Y=0.2025
c6 16 vss 0.0352557f $X=0.056 $Y=0.2025
c7 17 vss 0.00311515f $X=0.1475 $Y=0.2025
c8 18 vss 0.00433037f $X=0.2555 $Y=0.2025
c9 19 vss 0.00311515f $X=0.3635 $Y=0.2025
c10 20 vss 0.0352557f $X=0.4715 $Y=0.2025
c11 21 vss 0.0355961f $X=0.2305 $Y=0.234
r1 20 5 0.154321 $w=8.1e-08 $l=1.25e-08 $layer=P_src_drn $thickness=1e-09
+ $X=0.4715 $Y=0.2025 $X2=0.486 $Y2=0.2025
r2 51 20 0.0308642 $w=8.1e-08 $l=2.5e-09 $layer=P_src_drn $thickness=1e-09
+ $X=0.4686 $Y=0.2025 $X2=0.4715 $Y2=0.2025
r3 49 48 0.0308642 $w=8.1e-08 $l=2.5e-09 $layer=P_src_drn $thickness=1e-09
+ $X=0.0713 $Y=0.2025 $X2=0.0685 $Y2=0.2025
r4 16 48 0.154321 $w=8.1e-08 $l=1.25e-08 $layer=P_src_drn $thickness=1e-09
+ $X=0.056 $Y=0.2025 $X2=0.0685 $Y2=0.2025
r5 47 45 0.0308642 $w=8.1e-08 $l=2.5e-09 $layer=P_src_drn $thickness=1e-09
+ $X=0.1793 $Y=0.2025 $X2=0.1765 $Y2=0.2025
r6 2 45 0.179012 $w=8.1e-08 $l=1.45e-08 $layer=P_src_drn $thickness=1e-09
+ $X=0.162 $Y=0.2025 $X2=0.1765 $Y2=0.2025
r7 17 2 0.179012 $w=8.1e-08 $l=1.45e-08 $layer=P_src_drn $thickness=1e-09
+ $X=0.1475 $Y=0.2025 $X2=0.162 $Y2=0.2025
r8 46 17 0.0308642 $w=8.1e-08 $l=2.5e-09 $layer=P_src_drn $thickness=1e-09
+ $X=0.1446 $Y=0.2025 $X2=0.1475 $Y2=0.2025
r9 43 41 0.0308642 $w=8.1e-08 $l=2.5e-09 $layer=P_src_drn $thickness=1e-09
+ $X=0.2873 $Y=0.2025 $X2=0.2845 $Y2=0.2025
r10 3 41 0.179012 $w=8.1e-08 $l=1.45e-08 $layer=P_src_drn $thickness=1e-09
+ $X=0.27 $Y=0.2025 $X2=0.2845 $Y2=0.2025
r11 18 3 0.179012 $w=8.1e-08 $l=1.45e-08 $layer=P_src_drn $thickness=1e-09
+ $X=0.2555 $Y=0.2025 $X2=0.27 $Y2=0.2025
r12 42 18 0.0308642 $w=8.1e-08 $l=2.5e-09 $layer=P_src_drn $thickness=1e-09
+ $X=0.2526 $Y=0.2025 $X2=0.2555 $Y2=0.2025
r13 5 38 19.3796 $a=3.24e-16 $layer=V0LISD $X=0.486 $Y=0.2025 $X2=0.486
+ $Y2=0.234
r14 1 32 19.3796 $a=3.24e-16 $layer=V0LISD $X=0.054 $Y=0.2025 $X2=0.054
+ $Y2=0.234
r15 2 29 19.3796 $a=3.24e-16 $layer=V0LISD $X=0.162 $Y=0.2025 $X2=0.162
+ $Y2=0.234
r16 3 26 19.3796 $a=3.24e-16 $layer=V0LISD $X=0.27 $Y=0.2025 $X2=0.27 $Y2=0.234
r17 37 38 8.97781 $w=1.3e-08 $l=3.85e-08 $layer=M1 $thickness=3.6e-08 $X=0.4475
+ $Y=0.234 $X2=0.486 $Y2=0.234
r18 36 37 10.4935 $w=1.3e-08 $l=4.5e-08 $layer=M1 $thickness=3.6e-08 $X=0.4025
+ $Y=0.234 $X2=0.4475 $Y2=0.234
r19 35 36 5.71315 $w=1.3e-08 $l=2.45e-08 $layer=M1 $thickness=3.6e-08 $X=0.378
+ $Y=0.234 $X2=0.4025 $Y2=0.234
r20 34 35 5.47996 $w=1.3e-08 $l=2.35e-08 $layer=M1 $thickness=3.6e-08 $X=0.3545
+ $Y=0.234 $X2=0.378 $Y2=0.234
r21 32 33 8.97781 $w=1.3e-08 $l=3.85e-08 $layer=M1 $thickness=3.6e-08 $X=0.054
+ $Y=0.234 $X2=0.0925 $Y2=0.234
r22 29 30 5.47996 $w=1.3e-08 $l=2.35e-08 $layer=M1 $thickness=3.6e-08 $X=0.162
+ $Y=0.234 $X2=0.1855 $Y2=0.234
r23 28 29 5.71315 $w=1.3e-08 $l=2.45e-08 $layer=M1 $thickness=3.6e-08 $X=0.1375
+ $Y=0.234 $X2=0.162 $Y2=0.234
r24 28 33 10.4935 $w=1.3e-08 $l=4.5e-08 $layer=M1 $thickness=3.6e-08 $X=0.1375
+ $Y=0.234 $X2=0.0925 $Y2=0.234
r25 27 34 10.4935 $w=1.3e-08 $l=4.5e-08 $layer=M1 $thickness=3.6e-08 $X=0.3095
+ $Y=0.234 $X2=0.3545 $Y2=0.234
r26 26 27 9.211 $w=1.3e-08 $l=3.95e-08 $layer=M1 $thickness=3.6e-08 $X=0.27
+ $Y=0.234 $X2=0.3095 $Y2=0.234
r27 21 26 9.211 $w=1.3e-08 $l=3.95e-08 $layer=M1 $thickness=3.6e-08 $X=0.2305
+ $Y=0.234 $X2=0.27 $Y2=0.234
r28 21 30 10.4935 $w=1.3e-08 $l=4.5e-08 $layer=M1 $thickness=3.6e-08 $X=0.2305
+ $Y=0.234 $X2=0.1855 $Y2=0.234
r29 4 35 19.3796 $a=3.24e-16 $layer=V0LISD $X=0.378 $Y=0.2025 $X2=0.378
+ $Y2=0.234
r30 24 23 0.0308642 $w=8.1e-08 $l=2.5e-09 $layer=P_src_drn $thickness=1e-09
+ $X=0.3953 $Y=0.2025 $X2=0.3925 $Y2=0.2025
r31 4 23 0.179012 $w=8.1e-08 $l=1.45e-08 $layer=P_src_drn $thickness=1e-09
+ $X=0.378 $Y=0.2025 $X2=0.3925 $Y2=0.2025
r32 19 4 0.179012 $w=8.1e-08 $l=1.45e-08 $layer=P_src_drn $thickness=1e-09
+ $X=0.3635 $Y=0.2025 $X2=0.378 $Y2=0.2025
r33 25 19 0.0308642 $w=8.1e-08 $l=2.5e-09 $layer=P_src_drn $thickness=1e-09
+ $X=0.3606 $Y=0.2025 $X2=0.3635 $Y2=0.2025
r34 1 16 1e-05 $l=2e-09 $X=0.054 $Y=0.2025 $X2=0.056 $Y2=0.2025
.ends

.subckt PM_NOR2x2_ASAP7_75t_R%Y vss 64 35 56 58 60 77 78 81 82 24 1 2 6 5 23 19
+ 22 31 32 30 29 33 21 20 3 4 28 26
c1 1 vss 0.00691854f $X=0.108 $Y=0.0675
c2 2 vss 0.00278454f $X=0.108 $Y=0.2025
c3 3 vss 0.00643688f $X=0.216 $Y=0.0675
c4 4 vss 0.00644916f $X=0.324 $Y=0.0675
c5 5 vss 0.00695712f $X=0.432 $Y=0.0675
c6 6 vss 0.00278454f $X=0.432 $Y=0.2025
c7 19 vss 0.00332981f $X=0.11 $Y=0.0675
c8 20 vss 0.00329867f $X=0.2015 $Y=0.0675
c9 21 vss 0.00329867f $X=0.326 $Y=0.0675
c10 22 vss 0.00333247f $X=0.4175 $Y=0.0675
c11 23 vss 0.00191775f $X=0.0935 $Y=0.2025
c12 24 vss 0.00191775f $X=0.4175 $Y=0.2025
c13 25 vss 0.00272927f $X=0.027 $Y=0.036
c14 26 vss 0.0010436f $X=0.027 $Y=0.198
c15 27 vss 0.00276547f $X=0.513 $Y=0.036
c16 28 vss 0.00104305f $X=0.513 $Y=0.198
c17 29 vss 0.00372111f $X=0.027 $Y=0.054
c18 30 vss 0.0373173f $X=0.0855 $Y=0.036
c19 31 vss 0.000799567f $X=0.038 $Y=0.198
c20 32 vss 0.000799567f $X=0.502 $Y=0.198
c21 33 vss 0.00372365f $X=0.513 $Y=0.054
r1 82 80 0.0308642 $w=8.1e-08 $l=2.5e-09 $layer=P_src_drn $thickness=1e-09
+ $X=0.4493 $Y=0.2025 $X2=0.4465 $Y2=0.2025
r2 6 80 0.179012 $w=8.1e-08 $l=1.45e-08 $layer=P_src_drn $thickness=1e-09
+ $X=0.432 $Y=0.2025 $X2=0.4465 $Y2=0.2025
r3 24 6 0.179012 $w=8.1e-08 $l=1.45e-08 $layer=P_src_drn $thickness=1e-09
+ $X=0.4175 $Y=0.2025 $X2=0.432 $Y2=0.2025
r4 81 24 0.0308642 $w=8.1e-08 $l=2.5e-09 $layer=P_src_drn $thickness=1e-09
+ $X=0.4146 $Y=0.2025 $X2=0.4175 $Y2=0.2025
r5 78 76 0.0308642 $w=8.1e-08 $l=2.5e-09 $layer=P_src_drn $thickness=1e-09
+ $X=0.1253 $Y=0.2025 $X2=0.1225 $Y2=0.2025
r6 2 76 0.179012 $w=8.1e-08 $l=1.45e-08 $layer=P_src_drn $thickness=1e-09
+ $X=0.108 $Y=0.2025 $X2=0.1225 $Y2=0.2025
r7 23 2 0.179012 $w=8.1e-08 $l=1.45e-08 $layer=P_src_drn $thickness=1e-09
+ $X=0.0935 $Y=0.2025 $X2=0.108 $Y2=0.2025
r8 77 23 0.0308642 $w=8.1e-08 $l=2.5e-09 $layer=P_src_drn $thickness=1e-09
+ $X=0.0906 $Y=0.2025 $X2=0.0935 $Y2=0.2025
r9 6 73 19.3796 $a=3.24e-16 $layer=V0LISD $X=0.432 $Y=0.2025 $X2=0.432 $Y2=0.198
r10 2 69 19.3796 $a=3.24e-16 $layer=V0LISD $X=0.108 $Y=0.2025 $X2=0.108
+ $Y2=0.198
r11 73 74 5.24677 $w=1.3e-08 $l=2.25e-08 $layer=M1 $thickness=3.6e-08 $X=0.432
+ $Y=0.198 $X2=0.4545 $Y2=0.198
r12 71 74 6.8791 $w=1.3e-08 $l=2.95e-08 $layer=M1 $thickness=3.6e-08 $X=0.484
+ $Y=0.198 $X2=0.4545 $Y2=0.198
r13 32 71 4.19742 $w=1.3e-08 $l=1.8e-08 $layer=M1 $thickness=3.6e-08 $X=0.502
+ $Y=0.198 $X2=0.484 $Y2=0.198
r14 68 69 5.24677 $w=1.3e-08 $l=2.25e-08 $layer=M1 $thickness=3.6e-08 $X=0.0855
+ $Y=0.198 $X2=0.108 $Y2=0.198
r15 67 68 6.8791 $w=1.3e-08 $l=2.95e-08 $layer=M1 $thickness=3.6e-08 $X=0.056
+ $Y=0.198 $X2=0.0855 $Y2=0.198
r16 31 67 4.19742 $w=1.3e-08 $l=1.8e-08 $layer=M1 $thickness=3.6e-08 $X=0.038
+ $Y=0.198 $X2=0.056 $Y2=0.198
r17 28 66 2.5483 $w=1.79e-08 $l=1.8e-08 $layer=M1 $thickness=3.6e-08 $X=0.513
+ $Y=0.198 $X2=0.513 $Y2=0.18
r18 28 32 0.915974 $w=1.70909e-08 $l=1.1e-08 $layer=M1 $thickness=3.6e-08
+ $X=0.513 $Y=0.198 $X2=0.502 $Y2=0.198
r19 26 54 2.5483 $w=1.79e-08 $l=1.8e-08 $layer=M1 $thickness=3.6e-08 $X=0.027
+ $Y=0.198 $X2=0.027 $Y2=0.18
r20 26 31 0.915974 $w=1.70909e-08 $l=1.1e-08 $layer=M1 $thickness=3.6e-08
+ $X=0.027 $Y=0.198 $X2=0.038 $Y2=0.198
r21 65 66 5.07188 $w=1.3e-08 $l=2.18e-08 $layer=M1 $thickness=3.6e-08 $X=0.513
+ $Y=0.1582 $X2=0.513 $Y2=0.18
r22 64 65 3.08976 $w=1.3e-08 $l=1.32e-08 $layer=M1 $thickness=3.6e-08 $X=0.514
+ $Y=0.145 $X2=0.513 $Y2=0.1582
r23 64 63 6.12123 $w=1.3e-08 $l=2.63e-08 $layer=M1 $thickness=3.6e-08 $X=0.514
+ $Y=0.145 $X2=0.513 $Y2=0.1187
r24 62 63 7.40378 $w=1.3e-08 $l=3.17e-08 $layer=M1 $thickness=3.6e-08 $X=0.513
+ $Y=0.087 $X2=0.513 $Y2=0.1187
r25 61 62 3.49785 $w=1.3e-08 $l=1.5e-08 $layer=M1 $thickness=3.6e-08 $X=0.513
+ $Y=0.072 $X2=0.513 $Y2=0.087
r26 33 61 4.19742 $w=1.3e-08 $l=1.8e-08 $layer=M1 $thickness=3.6e-08 $X=0.513
+ $Y=0.054 $X2=0.513 $Y2=0.072
r27 22 5 0.154321 $w=8.1e-08 $l=1.25e-08 $layer=N_src_drn $thickness=1e-09
+ $X=0.4175 $Y=0.0675 $X2=0.432 $Y2=0.0675
r28 60 22 0.0308642 $w=8.1e-08 $l=2.5e-09 $layer=N_src_drn $thickness=1e-09
+ $X=0.4146 $Y=0.0675 $X2=0.4175 $Y2=0.0675
r29 58 57 0.0308642 $w=8.1e-08 $l=2.5e-09 $layer=N_src_drn $thickness=1e-09
+ $X=0.3413 $Y=0.0675 $X2=0.3385 $Y2=0.0675
r30 21 57 0.154321 $w=8.1e-08 $l=1.25e-08 $layer=N_src_drn $thickness=1e-09
+ $X=0.326 $Y=0.0675 $X2=0.3385 $Y2=0.0675
r31 20 3 0.154321 $w=8.1e-08 $l=1.25e-08 $layer=N_src_drn $thickness=1e-09
+ $X=0.2015 $Y=0.0675 $X2=0.216 $Y2=0.0675
r32 56 20 0.0308642 $w=8.1e-08 $l=2.5e-09 $layer=N_src_drn $thickness=1e-09
+ $X=0.1986 $Y=0.0675 $X2=0.2015 $Y2=0.0675
r33 53 54 12.5922 $w=1.3e-08 $l=5.4e-08 $layer=M1 $thickness=3.6e-08 $X=0.027
+ $Y=0.126 $X2=0.027 $Y2=0.18
r34 52 53 12.5922 $w=1.3e-08 $l=5.4e-08 $layer=M1 $thickness=3.6e-08 $X=0.027
+ $Y=0.072 $X2=0.027 $Y2=0.126
r35 29 52 4.19742 $w=1.3e-08 $l=1.8e-08 $layer=M1 $thickness=3.6e-08 $X=0.027
+ $Y=0.054 $X2=0.027 $Y2=0.072
r36 27 51 4.64701 $w=1.46667e-08 $l=2.7e-08 $layer=M1 $thickness=3.6e-08
+ $X=0.513 $Y=0.036 $X2=0.486 $Y2=0.036
r37 27 33 2.5483 $w=1.79e-08 $l=1.8e-08 $layer=M1 $thickness=3.6e-08 $X=0.513
+ $Y=0.036 $X2=0.513 $Y2=0.054
r38 5 48 19.3796 $a=3.24e-16 $layer=V0LISD $X=0.432 $Y=0.0675 $X2=0.432
+ $Y2=0.036
r39 4 46 19.3796 $a=3.24e-16 $layer=V0LISD $X=0.324 $Y=0.0675 $X2=0.3275
+ $Y2=0.036
r40 3 40 19.3796 $a=3.24e-16 $layer=V0LISD $X=0.216 $Y=0.0675 $X2=0.2125
+ $Y2=0.036
r41 25 37 4.64701 $w=1.46667e-08 $l=2.7e-08 $layer=M1 $thickness=3.6e-08
+ $X=0.027 $Y=0.036 $X2=0.054 $Y2=0.036
r42 25 29 2.5483 $w=1.79e-08 $l=1.8e-08 $layer=M1 $thickness=3.6e-08 $X=0.027
+ $Y=0.036 $X2=0.027 $Y2=0.054
r43 50 51 6.29612 $w=1.3e-08 $l=2.7e-08 $layer=M1 $thickness=3.6e-08 $X=0.459
+ $Y=0.036 $X2=0.486 $Y2=0.036
r44 49 50 3.14806 $w=1.3e-08 $l=1.35e-08 $layer=M1 $thickness=3.6e-08 $X=0.4455
+ $Y=0.036 $X2=0.459 $Y2=0.036
r45 48 49 3.14806 $w=1.3e-08 $l=1.35e-08 $layer=M1 $thickness=3.6e-08 $X=0.432
+ $Y=0.036 $X2=0.4455 $Y2=0.036
r46 47 48 12.5922 $w=1.3e-08 $l=5.4e-08 $layer=M1 $thickness=3.6e-08 $X=0.378
+ $Y=0.036 $X2=0.432 $Y2=0.036
r47 46 47 11.7761 $w=1.3e-08 $l=5.05e-08 $layer=M1 $thickness=3.6e-08 $X=0.3275
+ $Y=0.036 $X2=0.378 $Y2=0.036
r48 45 46 2.09871 $w=1.3e-08 $l=9e-09 $layer=M1 $thickness=3.6e-08 $X=0.3185
+ $Y=0.036 $X2=0.3275 $Y2=0.036
r49 44 45 5.01358 $w=1.3e-08 $l=2.15e-08 $layer=M1 $thickness=3.6e-08 $X=0.297
+ $Y=0.036 $X2=0.3185 $Y2=0.036
r50 43 44 8.51143 $w=1.3e-08 $l=3.65e-08 $layer=M1 $thickness=3.6e-08 $X=0.2605
+ $Y=0.036 $X2=0.297 $Y2=0.036
r51 42 43 6.29612 $w=1.3e-08 $l=2.7e-08 $layer=M1 $thickness=3.6e-08 $X=0.2335
+ $Y=0.036 $X2=0.2605 $Y2=0.036
r52 41 42 2.79828 $w=1.3e-08 $l=1.2e-08 $layer=M1 $thickness=3.6e-08 $X=0.2215
+ $Y=0.036 $X2=0.2335 $Y2=0.036
r53 40 41 2.09871 $w=1.3e-08 $l=9e-09 $layer=M1 $thickness=3.6e-08 $X=0.2125
+ $Y=0.036 $X2=0.2215 $Y2=0.036
r54 39 40 11.7761 $w=1.3e-08 $l=5.05e-08 $layer=M1 $thickness=3.6e-08 $X=0.162
+ $Y=0.036 $X2=0.2125 $Y2=0.036
r55 38 39 11.4263 $w=1.3e-08 $l=4.9e-08 $layer=M1 $thickness=3.6e-08 $X=0.113
+ $Y=0.036 $X2=0.162 $Y2=0.036
r56 36 38 2.09871 $w=1.3e-08 $l=9e-09 $layer=M1 $thickness=3.6e-08 $X=0.104
+ $Y=0.036 $X2=0.113 $Y2=0.036
r57 30 36 4.31401 $w=1.3e-08 $l=1.85e-08 $layer=M1 $thickness=3.6e-08 $X=0.0855
+ $Y=0.036 $X2=0.104 $Y2=0.036
r58 30 37 7.34548 $w=1.3e-08 $l=3.15e-08 $layer=M1 $thickness=3.6e-08 $X=0.0855
+ $Y=0.036 $X2=0.054 $Y2=0.036
r59 1 36 19.3796 $a=3.24e-16 $layer=V0LISD $X=0.108 $Y=0.0675 $X2=0.104
+ $Y2=0.036
r60 35 34 0.0308642 $w=8.1e-08 $l=2.5e-09 $layer=N_src_drn $thickness=1e-09
+ $X=0.1253 $Y=0.0675 $X2=0.1225 $Y2=0.0675
r61 19 34 0.154321 $w=8.1e-08 $l=1.25e-08 $layer=N_src_drn $thickness=1e-09
+ $X=0.11 $Y=0.0675 $X2=0.1225 $Y2=0.0675
r62 4 21 1e-05 $l=2e-09 $X=0.324 $Y=0.0675 $X2=0.326 $Y2=0.0675
r63 1 19 1e-05 $l=2e-09 $X=0.108 $Y=0.0675 $X2=0.11 $Y2=0.0675
.ends

* End of included file NOR2x2_ASAP7_75t_R.pex.sp.pex

*
.subckt NOR2x2_ASAP7_75t_CUSTOM_4_25_0_7 VSS VDD B A Y
*
* VSS VSS
* VDD VDD
* B B
* A A
* Y Y
*
*

M0 VSS N_M0_g N_M0_s VSS nmos_rvt L=2e-08 W=8.1e-08 nfin=3 $X=0.125 $Y=0.027
M1 N_M1_d N_M1_g VSS VSS nmos_rvt L=2e-08 W=8.1e-08 nfin=3 $X=0.179 $Y=0.027
M2 N_M2_d N_M2_g VSS VSS nmos_rvt L=2e-08 W=8.1e-08 nfin=3 $X=0.341 $Y=0.027
M3 VSS N_M3_g N_M3_s VSS nmos_rvt L=2e-08 W=8.1e-08 nfin=3 $X=0.395 $Y=0.027
M4 N_M4_d N_M4_g N_M4_s VDD pmos_rvt L=2e-08 W=8.1e-08 nfin=3 $X=0.071 $Y=0.162
M5 N_M5_d N_M5_g N_M5_s VDD pmos_rvt L=2e-08 W=8.1e-08 nfin=3 $X=0.125 $Y=0.162
M6 VDD N_M6_g N_M6_s VDD pmos_rvt L=2e-08 W=8.1e-08 nfin=3 $X=0.179 $Y=0.162
M7 VDD N_M7_g N_M7_s VDD pmos_rvt L=2e-08 W=8.1e-08 nfin=3 $X=0.233 $Y=0.162
M8 VDD N_M8_g N_M8_s VDD pmos_rvt L=2e-08 W=8.1e-08 nfin=3 $X=0.287 $Y=0.162
M9 VDD N_M9_g N_M9_s VDD pmos_rvt L=2e-08 W=8.1e-08 nfin=3 $X=0.341 $Y=0.162
M10 N_M10_d N_M10_g N_M10_s VDD pmos_rvt L=2e-08 W=8.1e-08 nfin=3 $X=0.395
+ $Y=0.162
M11 N_M11_d N_M11_g N_M11_s VDD pmos_rvt L=2e-08 W=8.1e-08 nfin=3 $X=0.449
+ $Y=0.162

* .include "NOR2x2_ASAP7_75t_R.pex.sp.pxi"

* Start of included file NOR2x2_ASAP7_75t_R.pex.sp.pxi
x_PM_NOR2x2_ASAP7_75t_R%A vss A N_M1_g N_M6_g N_M7_g N_M8_g N_M2_g N_M9_g N_A_6
+ N_A_1 N_A_8 N_A_3 N_A_5 N_A_4 N_A_7 PM_NOR2x2_ASAP7_75t_R%A
cc_1 N_A_6 N_B_20 0.000226007f $X=0.351 $Y=0.1355
cc_2 N_A_6 N_B_19 0.000282433f $X=0.351 $Y=0.1355
cc_3 N_A_1 N_B_21 0.000526083f $X=0.189 $Y=0.1355
cc_4 N_A_1 N_B_17 0.000576768f $X=0.189 $Y=0.1355
cc_5 N_A_8 N_B_13 0.00066444f $X=0.27 $Y=0.1095
cc_6 N_A_1 N_B_1 0.000833291f $X=0.189 $Y=0.1355
cc_7 N_A_1 N_B_2 0.000833291f $X=0.189 $Y=0.1355
cc_8 N_A_8 N_B_19 0.00131057f $X=0.27 $Y=0.1095
cc_9 N_A_1 N_B_19 0.00235318f $X=0.189 $Y=0.1355
cc_10 N_A_8 N_B_11 0.00280425f $X=0.27 $Y=0.1095
cc_11 N_A_3 N_B_6 0.00340927f $X=0.189 $Y=0.0245
cc_12 N_A_6 N_B_7 0.00447406f $X=0.351 $Y=0.1355
x_PM_NOR2x2_ASAP7_75t_R%B vss B N_M0_g N_M5_g N_M4_g N_M11_g N_M3_g N_M10_g
+ N_B_20 N_B_19 N_B_21 N_B_17 N_B_13 N_B_1 N_B_2 N_B_11 N_B_6 N_B_7 N_B_10
+ N_B_15 N_B_18 N_B_5 N_B_8 N_B_12 N_B_14 N_B_9 N_B_16 N_B_22
+ PM_NOR2x2_ASAP7_75t_R%B
x_PM_NOR2x2_ASAP7_75t_R%5 vss N_M10_s N_M9_s N_M7_s N_M8_s N_M5_s N_M6_s N_M4_s
+ N_M11_s N_5_19 N_5_17 N_5_3 N_5_1 N_5_5 N_5_2 N_5_4 N_5_21 N_5_16 N_5_20
+ N_5_18 PM_NOR2x2_ASAP7_75t_R%5
cc_13 N_5_19 N_B_2 0.00021766f $X=0.3635 $Y=0.2025
cc_14 N_5_19 N_B_10 0.000229268f $X=0.3635 $Y=0.2025
cc_15 N_5_19 N_B_15 0.000229268f $X=0.3635 $Y=0.2025
cc_16 N_5_19 N_B_18 0.000258908f $X=0.3635 $Y=0.2025
cc_17 N_5_19 N_B_20 0.000258908f $X=0.3635 $Y=0.2025
cc_18 N_5_19 N_B_5 0.000419194f $X=0.3635 $Y=0.2025
cc_19 N_5_19 N_B_8 0.000419194f $X=0.3635 $Y=0.2025
cc_20 N_5_17 N_B_6 0.0330405f $X=0.1475 $Y=0.2025
cc_21 N_5_3 N_B_19 0.001274f $X=0.27 $Y=0.2025
cc_22 N_5_1 N_B_5 0.00103572f $X=0.054 $Y=0.2025
cc_23 N_5_5 N_B_8 0.00103572f $X=0.486 $Y=0.2025
cc_24 N_5_2 N_B_17 0.00116279f $X=0.162 $Y=0.2025
cc_25 N_5_4 N_B_21 0.00116441f $X=0.378 $Y=0.2025
cc_26 N_5_21 N_B_12 0.00126338f $X=0.2305 $Y=0.234
cc_27 N_5_21 N_B_14 0.00126338f $X=0.2305 $Y=0.234
cc_28 N_5_2 N_B_6 0.00141823f $X=0.162 $Y=0.2025
cc_29 N_5_4 N_B_7 0.00141823f $X=0.378 $Y=0.2025
cc_30 N_5_16 N_B_1 0.00157458f $X=0.056 $Y=0.2025
cc_31 N_5_20 N_B_2 0.00157458f $X=0.4715 $Y=0.2025
cc_32 N_5_16 N_B_5 0.0328948f $X=0.056 $Y=0.2025
cc_33 N_5_20 N_B_8 0.0328948f $X=0.4715 $Y=0.2025
cc_34 N_5_21 N_B_19 0.0107291f $X=0.2305 $Y=0.234
cc_35 N_5_19 N_B_7 0.0342414f $X=0.3635 $Y=0.2025
cc_36 N_5_18 N_A_3 0.000639794f $X=0.2555 $Y=0.2025
cc_37 N_5_18 N_A_6 0.000639794f $X=0.2555 $Y=0.2025
cc_38 N_5_3 N_A_5 0.00172583f $X=0.27 $Y=0.2025
cc_39 N_5_18 N_A_1 0.00366046f $X=0.2555 $Y=0.2025
cc_40 N_5_17 N_A_3 0.0326155f $X=0.1475 $Y=0.2025
cc_41 N_5_19 N_A_6 0.0326155f $X=0.3635 $Y=0.2025
cc_42 N_5_18 N_A_4 0.0187671f $X=0.2555 $Y=0.2025
cc_43 N_5_18 N_A_5 0.0498395f $X=0.2555 $Y=0.2025
x_PM_NOR2x2_ASAP7_75t_R%Y vss Y N_M0_s N_M1_d N_M2_d N_M3_s N_M4_d N_M5_d
+ N_M10_d N_M11_d N_Y_24 N_Y_1 N_Y_2 N_Y_6 N_Y_5 N_Y_23 N_Y_19 N_Y_22 N_Y_31
+ N_Y_32 N_Y_30 N_Y_29 N_Y_33 N_Y_21 N_Y_20 N_Y_3 N_Y_4 N_Y_28 N_Y_26
+ PM_NOR2x2_ASAP7_75t_R%Y
cc_44 N_Y_24 N_B_6 0.000292256f $X=0.4175 $Y=0.2025
cc_45 N_Y_1 N_B_9 0.000397871f $X=0.108 $Y=0.0675
cc_46 N_Y_2 N_B_17 0.000671682f $X=0.108 $Y=0.2025
cc_47 N_Y_6 N_B_21 0.000671682f $X=0.432 $Y=0.2025
cc_48 N_Y_1 N_B_1 0.000736605f $X=0.108 $Y=0.0675
cc_49 N_Y_5 N_B_2 0.000736605f $X=0.432 $Y=0.0675
cc_50 N_Y_23 N_B_6 0.0482015f $X=0.0935 $Y=0.2025
cc_51 N_Y_19 N_B_6 0.0113133f $X=0.11 $Y=0.0675
cc_52 N_Y_22 N_B_7 0.0318956f $X=0.4175 $Y=0.0675
cc_53 N_Y_2 N_B_5 0.00184255f $X=0.108 $Y=0.2025
cc_54 N_Y_6 N_B_8 0.00184255f $X=0.432 $Y=0.2025
cc_55 N_Y_5 N_B_7 0.00235462f $X=0.432 $Y=0.0675
cc_56 N_Y_31 N_B_17 0.0023742f $X=0.038 $Y=0.198
cc_57 N_Y_32 N_B_21 0.00247515f $X=0.502 $Y=0.198
cc_58 N_Y_1 N_B_6 0.002682f $X=0.108 $Y=0.0675
cc_59 N_Y_30 N_B_9 0.00295052f $X=0.0855 $Y=0.036
cc_60 N_Y_30 N_B_11 0.00356247f $X=0.0855 $Y=0.036
cc_61 N_Y_31 N_B_10 0.0037538f $X=0.038 $Y=0.198
cc_62 N_Y_32 N_B_15 0.0037538f $X=0.502 $Y=0.198
cc_63 N_Y_29 N_B_16 0.00433736f $X=0.027 $Y=0.054
cc_64 N_Y_33 N_B_22 0.00479083f $X=0.513 $Y=0.054
cc_65 N_Y_23 N_B_1 0.00486438f $X=0.0935 $Y=0.2025
cc_66 N_Y_24 N_B_2 0.00486438f $X=0.4175 $Y=0.2025
cc_67 N_Y_23 N_B_5 0.055574f $X=0.0935 $Y=0.2025
cc_68 N_Y_24 N_B_8 0.055574f $X=0.4175 $Y=0.2025
cc_69 N_Y_19 N_B_5 0.0206069f $X=0.11 $Y=0.0675
cc_70 N_Y_24 N_B_7 0.0497226f $X=0.4175 $Y=0.2025
cc_71 N_Y_21 N_A_8 0.000979031f $X=0.326 $Y=0.0675
cc_72 N_Y_20 N_A_3 0.0301181f $X=0.2015 $Y=0.0675
cc_73 N_Y_21 N_A_6 0.0301181f $X=0.326 $Y=0.0675
cc_74 N_Y_3 N_A_4 0.00225069f $X=0.216 $Y=0.0675
cc_75 N_Y_4 N_A_5 0.00225069f $X=0.324 $Y=0.0675
cc_76 N_Y_21 N_A_1 0.0052057f $X=0.326 $Y=0.0675
cc_77 N_Y_30 N_A_7 0.00553324f $X=0.0855 $Y=0.036
cc_78 N_Y_20 N_A_4 0.0402116f $X=0.2015 $Y=0.0675
cc_79 N_Y_21 N_A_5 0.0409134f $X=0.326 $Y=0.0675
cc_80 N_Y_24 N_5_21 0.000584404f $X=0.4175 $Y=0.2025
cc_81 N_Y_30 N_5_21 0.000602842f $X=0.0855 $Y=0.036
cc_82 N_Y_28 N_5_21 0.000625995f $X=0.513 $Y=0.198
cc_83 N_Y_26 N_5_21 0.000629559f $X=0.027 $Y=0.198
cc_84 N_Y_29 N_5_1 0.000637845f $X=0.027 $Y=0.054
cc_85 N_Y_31 N_5_1 0.000660536f $X=0.038 $Y=0.198
cc_86 N_Y_32 N_5_5 0.000660536f $X=0.502 $Y=0.198
cc_87 N_Y_33 N_5_5 0.000691066f $X=0.513 $Y=0.054
cc_88 N_Y_2 N_5_21 0.000725435f $X=0.108 $Y=0.2025
cc_89 N_Y_6 N_5_21 0.000725435f $X=0.432 $Y=0.2025
cc_90 N_Y_23 N_5_16 0.000782186f $X=0.0935 $Y=0.2025
cc_91 N_Y_24 N_5_20 0.000782186f $X=0.4175 $Y=0.2025
cc_92 N_Y_23 N_5_17 0.00108287f $X=0.0935 $Y=0.2025
cc_93 N_Y_24 N_5_19 0.00108287f $X=0.4175 $Y=0.2025
cc_94 N_Y_2 N_5_1 0.00220338f $X=0.108 $Y=0.2025
cc_95 N_Y_6 N_5_5 0.00220338f $X=0.432 $Y=0.2025
cc_96 N_Y_31 N_5_21 0.00337243f $X=0.038 $Y=0.198
cc_97 N_Y_32 N_5_21 0.00337243f $X=0.502 $Y=0.198
cc_98 N_Y_2 N_5_2 0.00366365f $X=0.108 $Y=0.2025
cc_99 N_Y_6 N_5_4 0.00366365f $X=0.432 $Y=0.2025
cc_100 N_Y_3 N_5_21 0.00928038f $X=0.216 $Y=0.0675

* End of included file NOR2x2_ASAP7_75t_R.pex.sp.pxi
.ends

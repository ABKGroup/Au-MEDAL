.subckt PM_XOR2x2_ASAP7_75t_R%9 vss 2 3 1
c1 1 vss 0.00077296f $X=0.378 $Y=0.0675
r1 2 1 0.209877 $w=8.1e-08 $l=1.7e-08 $layer=N_src_drn $thickness=1e-09
+ $X=0.3606 $Y=0.0675 $X2=0.378 $Y2=0.0675
r2 3 1 0.209877 $w=8.1e-08 $l=1.7e-08 $layer=N_src_drn $thickness=1e-09
+ $X=0.3953 $Y=0.0675 $X2=0.378 $Y2=0.0675
.ends

.subckt PM_XOR2x2_ASAP7_75t_R%3 vss 18 24 46 49 50 11 4 16 3 17 1 15 14 9 10 13
+ 12
c1 1 vss 0.0038056f $X=0.081 $Y=0.135
c2 3 vss 0.0104375f $X=0.3115 $Y=0.0675
c3 4 vss 0.00653059f $X=0.378 $Y=0.187
c4 9 vss 0.0828563f $X=0.081 $Y=0.0245
c5 10 vss 0.0376648f $X=0.326 $Y=0.0675
c6 11 vss 0.00505248f $X=0.3635 $Y=0.216
c7 12 vss 0.000585621f $X=0.081 $Y=0.198
c8 13 vss 0.000452037f $X=0.311 $Y=0.198
c9 14 vss 0.00189907f $X=0.081 $Y=0.1235
c10 15 vss 0.00535753f $X=0.0945 $Y=0.198
c11 16 vss 0.00190577f $X=0.311 $Y=0.176
c12 17 vss 0.0017986f $X=0.331 $Y=0.198
r1 50 48 0.0462963 $w=5.4e-08 $l=2.5e-09 $layer=P_src_drn $thickness=1e-09
+ $X=0.3953 $Y=0.216 $X2=0.3925 $Y2=0.216
r2 44 48 0.268519 $w=5.4e-08 $l=1.45e-08 $layer=P_src_drn $thickness=1e-09
+ $X=0.378 $Y=0.216 $X2=0.3925 $Y2=0.216
r3 11 44 0.268519 $w=5.4e-08 $l=1.45e-08 $layer=P_src_drn $thickness=1e-09
+ $X=0.3635 $Y=0.216 $X2=0.378 $Y2=0.216
r4 49 11 0.0462963 $w=5.4e-08 $l=2.5e-09 $layer=P_src_drn $thickness=1e-09
+ $X=0.3606 $Y=0.216 $X2=0.3635 $Y2=0.216
r5 46 45 0.0308642 $w=8.1e-08 $l=2.5e-09 $layer=N_src_drn $thickness=1e-09
+ $X=0.3413 $Y=0.0675 $X2=0.3385 $Y2=0.0675
r6 10 45 0.154321 $w=8.1e-08 $l=1.25e-08 $layer=N_src_drn $thickness=1e-09
+ $X=0.326 $Y=0.0675 $X2=0.3385 $Y2=0.0675
r7 4 44 17.0927 $w=2.02e-08 $l=2.9e-08 $layer=LISD $thickness=2.7e-08 $X=0.378
+ $Y=0.187 $X2=0.378 $Y2=0.216
r8 3 34 19.3796 $a=3.24e-16 $layer=V0LISD $X=0.3115 $Y=0.0675 $X2=0.311
+ $Y2=0.093
r9 40 44 19.3796 $a=3.24e-16 $layer=V0LISD $X=0.3745 $Y=0.198 $X2=0.378
+ $Y2=0.216
r10 39 40 2.3319 $w=1.3e-08 $l=1e-08 $layer=M1 $thickness=3.6e-08 $X=0.3645
+ $Y=0.198 $X2=0.3745 $Y2=0.198
r11 38 39 3.14806 $w=1.3e-08 $l=1.35e-08 $layer=M1 $thickness=3.6e-08 $X=0.351
+ $Y=0.198 $X2=0.3645 $Y2=0.198
r12 17 38 4.6638 $w=1.3e-08 $l=2e-08 $layer=M1 $thickness=3.6e-08 $X=0.331
+ $Y=0.198 $X2=0.351 $Y2=0.198
r13 34 35 7.34548 $w=1.3e-08 $l=3.15e-08 $layer=M1 $thickness=3.6e-08 $X=0.311
+ $Y=0.093 $X2=0.311 $Y2=0.1245
r14 33 35 7.46207 $w=1.3e-08 $l=3.2e-08 $layer=M1 $thickness=3.6e-08 $X=0.311
+ $Y=0.1565 $X2=0.311 $Y2=0.1245
r15 16 33 4.5472 $w=1.3e-08 $l=1.95e-08 $layer=M1 $thickness=3.6e-08 $X=0.311
+ $Y=0.176 $X2=0.311 $Y2=0.1565
r16 13 32 3.60008 $w=1.51951e-08 $l=2.05e-08 $layer=M1 $thickness=3.6e-08
+ $X=0.311 $Y=0.198 $X2=0.2905 $Y2=0.198
r17 13 16 3.94987 $w=1.50455e-08 $l=2.2e-08 $layer=M1 $thickness=3.6e-08
+ $X=0.311 $Y=0.198 $X2=0.311 $Y2=0.176
r18 13 17 3.48349 $w=1.525e-08 $l=2e-08 $layer=M1 $thickness=3.6e-08 $X=0.311
+ $Y=0.198 $X2=0.331 $Y2=0.198
r19 31 32 18.422 $w=1.3e-08 $l=7.9e-08 $layer=M1 $thickness=3.6e-08 $X=0.2115
+ $Y=0.198 $X2=0.2905 $Y2=0.198
r20 30 31 17.839 $w=1.3e-08 $l=7.65e-08 $layer=M1 $thickness=3.6e-08 $X=0.135
+ $Y=0.198 $X2=0.2115 $Y2=0.198
r21 29 30 5.24677 $w=1.3e-08 $l=2.25e-08 $layer=M1 $thickness=3.6e-08 $X=0.1125
+ $Y=0.198 $X2=0.135 $Y2=0.198
r22 15 29 4.19742 $w=1.3e-08 $l=1.8e-08 $layer=M1 $thickness=3.6e-08 $X=0.0945
+ $Y=0.198 $X2=0.1125 $Y2=0.198
r23 12 28 4.9968 $w=1.60947e-08 $l=2.85e-08 $layer=M1 $thickness=3.6e-08
+ $X=0.081 $Y=0.198 $X2=0.081 $Y2=0.1695
r24 12 15 1.49895 $w=1.63333e-08 $l=1.35e-08 $layer=M1 $thickness=3.6e-08
+ $X=0.081 $Y=0.198 $X2=0.0945 $Y2=0.198
r25 27 28 5.24677 $w=1.3e-08 $l=2.25e-08 $layer=M1 $thickness=3.6e-08 $X=0.081
+ $Y=0.147 $X2=0.081 $Y2=0.1695
r26 26 27 2.79828 $w=1.3e-08 $l=1.2e-08 $layer=M1 $thickness=3.6e-08 $X=0.081
+ $Y=0.135 $X2=0.081 $Y2=0.147
r27 14 26 2.68168 $w=1.3e-08 $l=1.15e-08 $layer=M1 $thickness=3.6e-08 $X=0.081
+ $Y=0.1235 $X2=0.081 $Y2=0.135
r28 1 21 10.4265 $w=1.765e-08 $layer=LIG $thickness=5.2e-08 $X=0.081 $Y=0.135
+ $X2=0.081 $Y2=0.135
r29 1 26 19.3796 $a=3.24e-16 $layer=V0LIG $X=0.081 $Y=0.135 $X2=0.081 $Y2=0.135
r30 24 23 14.6259 $w=2.1e-08 $l=4.3e-08 $layer=Gate_1 $thickness=5.6e-08
+ $X=0.081 $Y=0.2025 $X2=0.081 $Y2=0.1595
r31 22 23 2.7211 $w=2.1e-08 $l=8e-09 $layer=Gate_1 $thickness=5.6e-08 $X=0.081
+ $Y=0.1515 $X2=0.081 $Y2=0.1595
r32 21 22 5.79936 $w=2.03333e-08 $l=1.65e-08 $layer=Gate_1 $thickness=5.6e-08
+ $X=0.081 $Y=0.135 $X2=0.081 $Y2=0.1515
r33 20 21 5.79936 $w=2.03333e-08 $l=1.65e-08 $layer=Gate_1 $thickness=5.6e-08
+ $X=0.081 $Y=0.1185 $X2=0.081 $Y2=0.135
r34 19 20 2.7211 $w=2.1e-08 $l=8e-09 $layer=Gate_1 $thickness=5.6e-08 $X=0.081
+ $Y=0.1105 $X2=0.081 $Y2=0.1185
r35 18 19 14.6259 $w=2.1e-08 $l=4.3e-08 $layer=Gate_1 $thickness=5.6e-08
+ $X=0.081 $Y=0.0675 $X2=0.081 $Y2=0.1105
r36 18 9 14.6259 $w=2.1e-08 $l=4.3e-08 $layer=Gate_1 $thickness=5.6e-08
+ $X=0.081 $Y=0.0675 $X2=0.081 $Y2=0.0245
r37 3 10 1e-05 $l=1.45e-08 $X=0.3115 $Y=0.0675 $X2=0.326 $Y2=0.0675
.ends

.subckt PM_XOR2x2_ASAP7_75t_R%6 vss 27 31 42 46 59 64 68 23 14 19 5 3 4 15 22
+ 17 1 25 26 12 16 20 21 13
c1 1 vss 0.00743813f $X=0.459 $Y=0.135
c2 3 vss 0.00970549f $X=0.054 $Y=0.0675
c3 4 vss 0.0087854f $X=0.054 $Y=0.2025
c4 5 vss 0.00620872f $X=0.216 $Y=0.216
c5 12 vss 0.11515f $X=0.459 $Y=0.0245
c6 13 vss 0.0846808f $X=0.513 $Y=0.135
c7 14 vss 0.0409432f $X=0.056 $Y=0.0675
c8 15 vss 0.0409452f $X=0.056 $Y=0.2025
c9 16 vss 0.040576f $X=0.2015 $Y=0.2025
c10 17 vss 0.00702902f $X=0.027 $Y=0.036
c11 18 vss 0.00332183f $X=0.027 $Y=0.234
c12 19 vss 0.00069583f $X=0.432 $Y=0.198
c13 20 vss 0.00289075f $X=0.432 $Y=0.234
c14 21 vss 0.000760776f $X=0.486 $Y=0.198
c15 22 vss 0.0100993f $X=0.027 $Y=0.216
c16 23 vss 0.036363f $X=0.4225 $Y=0.234
c17 24 vss 0.000651632f $X=0.432 $Y=0.216
c18 25 vss 0.00118471f $X=0.4745 $Y=0.198
c19 26 vss 0.00214877f $X=0.486 $Y=0.1225
r1 68 67 0.0308642 $w=8.1e-08 $l=2.5e-09 $layer=N_src_drn $thickness=1e-09
+ $X=0.0713 $Y=0.0675 $X2=0.0685 $Y2=0.0675
r2 14 67 0.154321 $w=8.1e-08 $l=1.25e-08 $layer=N_src_drn $thickness=1e-09
+ $X=0.056 $Y=0.0675 $X2=0.0685 $Y2=0.0675
r3 3 66 19.3796 $a=3.24e-16 $layer=V0LISD $X=0.054 $Y=0.0675 $X2=0.054 $Y2=0.036
r4 65 66 3.14806 $w=1.3e-08 $l=1.35e-08 $layer=M1 $thickness=3.6e-08 $X=0.0405
+ $Y=0.036 $X2=0.054 $Y2=0.036
r5 17 62 3.71668 $w=1.51429e-08 $l=2.1e-08 $layer=M1 $thickness=3.6e-08
+ $X=0.027 $Y=0.036 $X2=0.027 $Y2=0.057
r6 17 65 1.96775 $w=1.63333e-08 $l=1.35e-08 $layer=M1 $thickness=3.6e-08
+ $X=0.027 $Y=0.036 $X2=0.0405 $Y2=0.036
r7 64 63 0.0308642 $w=8.1e-08 $l=2.5e-09 $layer=P_src_drn $thickness=1e-09
+ $X=0.0713 $Y=0.2025 $X2=0.0685 $Y2=0.2025
r8 15 63 0.154321 $w=8.1e-08 $l=1.25e-08 $layer=P_src_drn $thickness=1e-09
+ $X=0.056 $Y=0.2025 $X2=0.0685 $Y2=0.2025
r9 61 62 8.86121 $w=1.3e-08 $l=3.8e-08 $layer=M1 $thickness=3.6e-08 $X=0.027
+ $Y=0.095 $X2=0.027 $Y2=0.057
r10 60 61 16.0901 $w=1.3e-08 $l=6.9e-08 $layer=M1 $thickness=3.6e-08 $X=0.027
+ $Y=0.164 $X2=0.027 $Y2=0.095
r11 22 60 12.1259 $w=1.3e-08 $l=5.2e-08 $layer=M1 $thickness=3.6e-08 $X=0.027
+ $Y=0.216 $X2=0.027 $Y2=0.164
r12 16 5 0.154321 $w=8.1e-08 $l=1.25e-08 $layer=P_src_drn $thickness=1e-09
+ $X=0.2015 $Y=0.2025 $X2=0.216 $Y2=0.216
r13 59 16 0.0308642 $w=8.1e-08 $l=2.5e-09 $layer=P_src_drn $thickness=1e-09
+ $X=0.1986 $Y=0.2025 $X2=0.2015 $Y2=0.2025
r14 4 55 19.3796 $a=3.24e-16 $layer=V0LISD $X=0.054 $Y=0.2025 $X2=0.054
+ $Y2=0.234
r15 18 54 1.49895 $w=1.63333e-08 $l=1.35e-08 $layer=M1 $thickness=3.6e-08
+ $X=0.027 $Y=0.234 $X2=0.0405 $Y2=0.234
r16 18 22 2.5483 $w=1.79e-08 $l=1.8e-08 $layer=M1 $thickness=3.6e-08 $X=0.027
+ $Y=0.234 $X2=0.027 $Y2=0.216
r17 5 51 19.3796 $a=3.24e-16 $layer=V0LISD $X=0.216 $Y=0.216 $X2=0.216 $Y2=0.234
r18 54 55 3.14806 $w=1.3e-08 $l=1.35e-08 $layer=M1 $thickness=3.6e-08 $X=0.0405
+ $Y=0.234 $X2=0.054 $Y2=0.234
r19 53 55 3.14806 $w=1.3e-08 $l=1.35e-08 $layer=M1 $thickness=3.6e-08 $X=0.0675
+ $Y=0.234 $X2=0.054 $Y2=0.234
r20 51 52 21.5701 $w=1.3e-08 $l=9.25e-08 $layer=M1 $thickness=3.6e-08 $X=0.216
+ $Y=0.234 $X2=0.3085 $Y2=0.234
r21 50 51 17.839 $w=1.3e-08 $l=7.65e-08 $layer=M1 $thickness=3.6e-08 $X=0.1395
+ $Y=0.234 $X2=0.216 $Y2=0.234
r22 50 53 16.7897 $w=1.3e-08 $l=7.2e-08 $layer=M1 $thickness=3.6e-08 $X=0.1395
+ $Y=0.234 $X2=0.0675 $Y2=0.234
r23 49 52 22.9692 $w=1.3e-08 $l=9.85e-08 $layer=M1 $thickness=3.6e-08 $X=0.407
+ $Y=0.234 $X2=0.3085 $Y2=0.234
r24 23 49 3.61444 $w=1.3e-08 $l=1.55e-08 $layer=M1 $thickness=3.6e-08 $X=0.4225
+ $Y=0.234 $X2=0.407 $Y2=0.234
r25 20 24 2.5483 $w=1.79e-08 $l=1.8e-08 $layer=M1 $thickness=3.6e-08 $X=0.432
+ $Y=0.234 $X2=0.432 $Y2=0.216
r26 20 23 0.56619 $w=1.77368e-08 $l=9.5e-09 $layer=M1 $thickness=3.6e-08
+ $X=0.432 $Y=0.234 $X2=0.4225 $Y2=0.234
r27 19 48 4.06404 $w=1.48367e-08 $l=2.45e-08 $layer=M1 $thickness=3.6e-08
+ $X=0.432 $Y=0.198 $X2=0.4565 $Y2=0.198
r28 19 24 2.5483 $w=1.79e-08 $l=1.8e-08 $layer=M1 $thickness=3.6e-08 $X=0.432
+ $Y=0.198 $X2=0.432 $Y2=0.216
r29 25 48 4.19742 $w=1.3e-08 $l=1.8e-08 $layer=M1 $thickness=3.6e-08 $X=0.4745
+ $Y=0.198 $X2=0.4565 $Y2=0.198
r30 21 39 3.48106 $w=1.70091e-08 $l=2.2e-08 $layer=M1 $thickness=3.6e-08
+ $X=0.486 $Y=0.198 $X2=0.486 $Y2=0.176
r31 21 25 1.03257 $w=1.6913e-08 $l=1.15e-08 $layer=M1 $thickness=3.6e-08
+ $X=0.486 $Y=0.198 $X2=0.4745 $Y2=0.198
r32 46 45 14.6259 $w=2.1e-08 $l=4.3e-08 $layer=Gate_1 $thickness=5.6e-08
+ $X=0.513 $Y=0.2025 $X2=0.513 $Y2=0.1595
r33 44 45 2.7211 $w=2.1e-08 $l=8e-09 $layer=Gate_1 $thickness=5.6e-08 $X=0.513
+ $Y=0.1515 $X2=0.513 $Y2=0.1595
r34 42 43 14.6259 $w=2.1e-08 $l=4.3e-08 $layer=Gate_1 $thickness=5.6e-08
+ $X=0.513 $Y=0.0675 $X2=0.513 $Y2=0.1105
r35 40 43 2.7211 $w=2.1e-08 $l=8e-09 $layer=Gate_1 $thickness=5.6e-08 $X=0.513
+ $Y=0.1185 $X2=0.513 $Y2=0.1105
r36 13 35 6.54019 $w=2.09524e-08 $layer=Gate_1 $thickness=5.21905e-08 $X=0.513
+ $Y=0.135 $X2=0.513 $Y2=0.135
r37 13 40 5.79936 $w=2.03333e-08 $l=1.65e-08 $layer=Gate_1 $thickness=5.6e-08
+ $X=0.513 $Y=0.135 $X2=0.513 $Y2=0.1185
r38 13 44 5.79936 $w=2.03333e-08 $l=1.65e-08 $layer=Gate_1 $thickness=5.6e-08
+ $X=0.513 $Y=0.135 $X2=0.513 $Y2=0.1515
r39 38 39 5.24677 $w=1.3e-08 $l=2.25e-08 $layer=M1 $thickness=3.6e-08 $X=0.486
+ $Y=0.1535 $X2=0.486 $Y2=0.176
r40 37 38 4.31401 $w=1.3e-08 $l=1.85e-08 $layer=M1 $thickness=3.6e-08 $X=0.486
+ $Y=0.135 $X2=0.486 $Y2=0.1535
r41 26 37 2.91487 $w=1.3e-08 $l=1.25e-08 $layer=M1 $thickness=3.6e-08 $X=0.486
+ $Y=0.1225 $X2=0.486 $Y2=0.135
r42 34 35 12.6539 $w=1.77815e-08 $l=2.7e-08 $layer=LIG $thickness=4.8e-08
+ $X=0.486 $Y=0.135 $X2=0.513 $Y2=0.135
r43 34 37 19.3796 $a=3.24e-16 $layer=V0LIG $X=0.486 $Y=0.135 $X2=0.486 $Y2=0.135
r44 1 29 6.54019 $w=2.09524e-08 $layer=Gate_1 $thickness=5.21905e-08 $X=0.459
+ $Y=0.135 $X2=0.459 $Y2=0.135
r45 1 34 12.6539 $w=1.77815e-08 $l=2.7e-08 $layer=LIG $thickness=4.8e-08
+ $X=0.459 $Y=0.135 $X2=0.486 $Y2=0.135
r46 31 30 16.4967 $w=2.1e-08 $l=4.85e-08 $layer=Gate_1 $thickness=5.6e-08
+ $X=0.459 $Y=0.2025 $X2=0.459 $Y2=0.154
r47 29 30 6.6497 $w=2.04211e-08 $l=1.9e-08 $layer=Gate_1 $thickness=5.6e-08
+ $X=0.459 $Y=0.135 $X2=0.459 $Y2=0.154
r48 28 29 6.6497 $w=2.04211e-08 $l=1.9e-08 $layer=Gate_1 $thickness=5.6e-08
+ $X=0.459 $Y=0.116 $X2=0.459 $Y2=0.135
r49 27 28 16.4967 $w=2.1e-08 $l=4.85e-08 $layer=Gate_1 $thickness=5.6e-08
+ $X=0.459 $Y=0.0675 $X2=0.459 $Y2=0.116
r50 27 12 14.6259 $w=2.1e-08 $l=4.3e-08 $layer=Gate_1 $thickness=5.6e-08
+ $X=0.459 $Y=0.0675 $X2=0.459 $Y2=0.0245
r51 3 14 1e-05 $l=2e-09 $X=0.054 $Y=0.0675 $X2=0.056 $Y2=0.0675
r52 4 15 1e-05 $l=2e-09 $X=0.054 $Y=0.2025 $X2=0.056 $Y2=0.2025
.ends

.subckt PM_XOR2x2_ASAP7_75t_R%Y vss 21 16 17 28 29 11 8 13 2 1 12 7
c1 1 vss 0.00881386f $X=0.486 $Y=0.0675
c2 2 vss 0.00858715f $X=0.486 $Y=0.2025
c3 7 vss 0.00436366f $X=0.4715 $Y=0.0675
c4 8 vss 0.00441991f $X=0.4715 $Y=0.2025
c5 9 vss 0.00290288f $X=0.567 $Y=0.036
c6 10 vss 0.00289538f $X=0.567 $Y=0.234
c7 11 vss 0.00823822f $X=0.486 $Y=0.036
c8 12 vss 0.00783051f $X=0.5265 $Y=0.234
c9 13 vss 0.00833459f $X=0.567 $Y=0.082
r1 29 27 0.0308642 $w=8.1e-08 $l=2.5e-09 $layer=P_src_drn $thickness=1e-09
+ $X=0.5033 $Y=0.2025 $X2=0.5005 $Y2=0.2025
r2 2 27 0.179012 $w=8.1e-08 $l=1.45e-08 $layer=P_src_drn $thickness=1e-09
+ $X=0.486 $Y=0.2025 $X2=0.5005 $Y2=0.2025
r3 8 2 0.179012 $w=8.1e-08 $l=1.45e-08 $layer=P_src_drn $thickness=1e-09
+ $X=0.4715 $Y=0.2025 $X2=0.486 $Y2=0.2025
r4 28 8 0.0308642 $w=8.1e-08 $l=2.5e-09 $layer=P_src_drn $thickness=1e-09
+ $X=0.4686 $Y=0.2025 $X2=0.4715 $Y2=0.2025
r5 2 25 19.3796 $a=3.24e-16 $layer=V0LISD $X=0.486 $Y=0.2025 $X2=0.486 $Y2=0.234
r6 12 25 9.44419 $w=1.3e-08 $l=4.05e-08 $layer=M1 $thickness=3.6e-08 $X=0.5265
+ $Y=0.234 $X2=0.486 $Y2=0.234
r7 10 23 2.5483 $w=1.79e-08 $l=1.8e-08 $layer=M1 $thickness=3.6e-08 $X=0.567
+ $Y=0.234 $X2=0.567 $Y2=0.216
r8 10 12 7.79507 $w=1.41111e-08 $l=4.05e-08 $layer=M1 $thickness=3.6e-08
+ $X=0.567 $Y=0.234 $X2=0.5265 $Y2=0.234
r9 22 23 8.97781 $w=1.3e-08 $l=3.85e-08 $layer=M1 $thickness=3.6e-08 $X=0.567
+ $Y=0.1775 $X2=0.567 $Y2=0.216
r10 21 22 6.99569 $w=1.3e-08 $l=3e-08 $layer=M1 $thickness=3.6e-08 $X=0.567
+ $Y=0.1475 $X2=0.567 $Y2=0.1775
r11 21 20 3.38125 $w=1.3e-08 $l=1.45e-08 $layer=M1 $thickness=3.6e-08 $X=0.567
+ $Y=0.1475 $X2=0.567 $Y2=0.133
r12 13 20 11.8927 $w=1.3e-08 $l=5.1e-08 $layer=M1 $thickness=3.6e-08 $X=0.567
+ $Y=0.082 $X2=0.567 $Y2=0.133
r13 9 19 7.79507 $w=1.41111e-08 $l=4.05e-08 $layer=M1 $thickness=3.6e-08
+ $X=0.567 $Y=0.036 $X2=0.5265 $Y2=0.036
r14 9 13 9.07762 $w=1.49174e-08 $l=4.6e-08 $layer=M1 $thickness=3.6e-08
+ $X=0.567 $Y=0.036 $X2=0.567 $Y2=0.082
r15 11 19 9.44419 $w=1.3e-08 $l=4.05e-08 $layer=M1 $thickness=3.6e-08 $X=0.486
+ $Y=0.036 $X2=0.5265 $Y2=0.036
r16 1 11 19.3796 $a=3.24e-16 $layer=V0LISD $X=0.486 $Y=0.0675 $X2=0.486
+ $Y2=0.036
r17 17 15 0.0308642 $w=8.1e-08 $l=2.5e-09 $layer=N_src_drn $thickness=1e-09
+ $X=0.5033 $Y=0.0675 $X2=0.5005 $Y2=0.0675
r18 1 15 0.179012 $w=8.1e-08 $l=1.45e-08 $layer=N_src_drn $thickness=1e-09
+ $X=0.486 $Y=0.0675 $X2=0.5005 $Y2=0.0675
r19 7 1 0.179012 $w=8.1e-08 $l=1.45e-08 $layer=N_src_drn $thickness=1e-09
+ $X=0.4715 $Y=0.0675 $X2=0.486 $Y2=0.0675
r20 16 7 0.0308642 $w=8.1e-08 $l=2.5e-09 $layer=N_src_drn $thickness=1e-09
+ $X=0.4686 $Y=0.0675 $X2=0.4715 $Y2=0.0675
.ends

.subckt PM_XOR2x2_ASAP7_75t_R%A vss 24 7 13 29 33 6 5 1 4 3
c1 1 vss 0.0189114f $X=0.3415 $Y=0.135
c2 3 vss 0.110373f $X=0.189 $Y=0.135
c3 4 vss 0.0438633f $X=0.351 $Y=0.0245
c4 5 vss 0.00165365f $X=0.351 $Y=0.072
c5 6 vss 0.00224302f $X=0.351 $Y=0.1265
r1 5 23 3.3086 $w=1.53377e-08 $l=1.92e-08 $layer=M1 $thickness=3.6e-08 $X=0.351
+ $Y=0.072 $X2=0.351 $Y2=0.0912
r2 33 32 14.6259 $w=2.1e-08 $l=4.3e-08 $layer=Gate_1 $thickness=5.6e-08
+ $X=0.189 $Y=0.2025 $X2=0.189 $Y2=0.1595
r3 31 32 3.23131 $w=2.1e-08 $l=9.5e-09 $layer=Gate_1 $thickness=5.6e-08
+ $X=0.189 $Y=0.15 $X2=0.189 $Y2=0.1595
r4 29 30 14.6259 $w=2.1e-08 $l=4.3e-08 $layer=Gate_1 $thickness=5.6e-08
+ $X=0.189 $Y=0.0675 $X2=0.189 $Y2=0.1105
r5 27 30 3.23131 $w=2.1e-08 $l=9.5e-09 $layer=Gate_1 $thickness=5.6e-08
+ $X=0.189 $Y=0.12 $X2=0.189 $Y2=0.1105
r6 3 18 7.58422 $w=1.77778e-08 $layer=LIG $thickness=5.15556e-08 $X=0.189
+ $Y=0.135 $X2=0.189 $Y2=0.135
r7 3 27 5.23813 $w=2.04667e-08 $l=1.5e-08 $layer=Gate_1 $thickness=5.6e-08
+ $X=0.189 $Y=0.135 $X2=0.189 $Y2=0.12
r8 3 31 5.23813 $w=2.04667e-08 $l=1.5e-08 $layer=Gate_1 $thickness=5.6e-08
+ $X=0.189 $Y=0.135 $X2=0.189 $Y2=0.15
r9 24 25 2.85657 $w=1.3e-08 $l=1.22e-08 $layer=M1 $thickness=3.6e-08 $X=0.351
+ $Y=0.102 $X2=0.351 $Y2=0.1142
r10 24 23 2.50679 $w=1.3e-08 $l=1.08e-08 $layer=M1 $thickness=3.6e-08 $X=0.351
+ $Y=0.102 $X2=0.351 $Y2=0.0912
r11 6 21 1.98211 $w=1.3e-08 $l=8.5e-09 $layer=M1 $thickness=3.6e-08 $X=0.351
+ $Y=0.1265 $X2=0.351 $Y2=0.135
r12 6 25 2.85657 $w=1.3e-08 $l=1.23e-08 $layer=M1 $thickness=3.6e-08 $X=0.351
+ $Y=0.1265 $X2=0.351 $Y2=0.1142
r13 17 18 170.233 $w=1.01272e-08 $l=8.1e-08 $layer=LIG $thickness=4.8e-08
+ $X=0.27 $Y=0.135 $X2=0.189 $Y2=0.135
r14 15 16 4.49071 $w=1.6e-08 $l=9.5e-09 $layer=LIG $thickness=4.8e-08 $X=0.351
+ $Y=0.135 $X2=0.3605 $Y2=0.135
r15 15 21 28.9687 $a=2.88e-16 $layer=V0LIG $X=0.351 $Y=0.135 $X2=0.351 $Y2=0.135
r16 1 15 4.49071 $w=1.6e-08 $l=9.5e-09 $layer=LIG $thickness=4.8e-08 $X=0.3415
+ $Y=0.135 $X2=0.351 $Y2=0.135
r17 1 17 165.742 $w=9.34685e-09 $l=7.15e-08 $layer=LIG $thickness=4.8e-08
+ $X=0.3415 $Y=0.135 $X2=0.27 $Y2=0.135
r18 13 12 14.6259 $w=2.1e-08 $l=4.3e-08 $layer=Gate_1 $thickness=5.6e-08
+ $X=0.351 $Y=0.216 $X2=0.351 $Y2=0.173
r19 11 12 7.82318 $w=2.1e-08 $l=2.3e-08 $layer=Gate_1 $thickness=5.6e-08
+ $X=0.351 $Y=0.15 $X2=0.351 $Y2=0.173
r20 10 11 5.23813 $w=2.04667e-08 $l=1.5e-08 $layer=Gate_1 $thickness=5.6e-08
+ $X=0.351 $Y=0.135 $X2=0.351 $Y2=0.15
r21 10 16 3.09351 $w=1.97647e-08 $l=9.5e-09 $layer=Gate_1
+ $thickness=5.55294e-08 $X=0.351 $Y=0.135 $X2=0.3605 $Y2=0.135
r22 10 15 7.11151 $w=1.78824e-08 $layer=LIG $thickness=5.17647e-08 $X=0.351
+ $Y=0.135 $X2=0.351 $Y2=0.135
r23 9 10 5.23813 $w=2.04667e-08 $l=1.5e-08 $layer=Gate_1 $thickness=5.6e-08
+ $X=0.351 $Y=0.12 $X2=0.351 $Y2=0.135
r24 8 9 3.23131 $w=2.1e-08 $l=9.5e-09 $layer=Gate_1 $thickness=5.6e-08 $X=0.351
+ $Y=0.1105 $X2=0.351 $Y2=0.12
r25 7 8 14.6259 $w=2.1e-08 $l=4.3e-08 $layer=Gate_1 $thickness=5.6e-08 $X=0.351
+ $Y=0.0675 $X2=0.351 $Y2=0.1105
r26 7 4 14.6259 $w=2.1e-08 $l=4.3e-08 $layer=Gate_1 $thickness=5.6e-08 $X=0.351
+ $Y=0.0675 $X2=0.351 $Y2=0.0245
.ends

.subckt PM_XOR2x2_ASAP7_75t_R%B vss 29 18 22 49 52 2 6 15 9 10 14 1 13 16 5 17
+ 7 12 11
c1 1 vss 0.00587302f $X=0.135 $Y=0.135
c2 2 vss 0.00388719f $X=0.405 $Y=0.135
c3 5 vss 0.141445f $X=0.135 $Y=0.135
c4 6 vss 0.0854913f $X=0.405 $Y=0.0245
c5 7 vss 0.00279153f $X=0.135 $Y=0.078
c6 8 vss 0.00352438f $X=0.27 $Y=0.036
c7 9 vss 0.000756503f $X=0.27 $Y=0.072
c8 10 vss 0.000851638f $X=0.3915 $Y=0.135
c9 11 vss 0.0029643f $X=0.431 $Y=0.036
c10 12 vss 0.000790567f $X=0.431 $Y=0.1302
c11 13 vss 0.0030218f $X=0.135 $Y=0.104
c12 14 vss 0.0108407f $X=0.2455 $Y=0.078
c13 15 vss 0.00114759f $X=0.27 $Y=0.054
c14 16 vss 0.0142772f $X=0.4065 $Y=0.036
c15 17 vss 0.0039973f $X=0.431 $Y=0.1225
r1 52 51 16.4967 $w=2.1e-08 $l=4.85e-08 $layer=Gate_1 $thickness=5.6e-08
+ $X=0.135 $Y=0.2025 $X2=0.135 $Y2=0.154
r2 49 50 16.4967 $w=2.1e-08 $l=4.85e-08 $layer=Gate_1 $thickness=5.6e-08
+ $X=0.135 $Y=0.0675 $X2=0.135 $Y2=0.116
r3 5 50 6.6497 $w=2.04211e-08 $l=1.9e-08 $layer=Gate_1 $thickness=5.6e-08
+ $X=0.135 $Y=0.135 $X2=0.135 $Y2=0.116
r4 5 51 6.6497 $w=2.04211e-08 $l=1.9e-08 $layer=Gate_1 $thickness=5.6e-08
+ $X=0.135 $Y=0.135 $X2=0.135 $Y2=0.154
r5 1 44 19.3796 $a=3.24e-16 $layer=V0LIG $X=0.135 $Y=0.135 $X2=0.135 $Y2=0.135
r6 1 5 8.65438 $w=1.80211e-08 $layer=LIG $thickness=5.26316e-08 $X=0.135
+ $Y=0.135 $X2=0.135 $Y2=0.135
r7 43 44 2.68168 $w=1.3e-08 $l=1.15e-08 $layer=M1 $thickness=3.6e-08 $X=0.135
+ $Y=0.1235 $X2=0.135 $Y2=0.135
r8 13 43 4.5472 $w=1.3e-08 $l=1.95e-08 $layer=M1 $thickness=3.6e-08 $X=0.135
+ $Y=0.104 $X2=0.135 $Y2=0.1235
r9 7 42 10.4768 $w=1.38654e-08 $l=5.2e-08 $layer=M1 $thickness=3.6e-08 $X=0.135
+ $Y=0.078 $X2=0.187 $Y2=0.078
r10 7 13 4.41382 $w=1.63923e-08 $l=2.6e-08 $layer=M1 $thickness=3.6e-08
+ $X=0.135 $Y=0.078 $X2=0.135 $Y2=0.104
r11 14 42 13.6416 $w=1.3e-08 $l=5.85e-08 $layer=M1 $thickness=3.6e-08 $X=0.2455
+ $Y=0.078 $X2=0.187 $Y2=0.078
r12 9 40 1.0057 $w=1.55e-08 $l=6e-09 $layer=M1 $thickness=3.6e-08 $X=0.27
+ $Y=0.072 $X2=0.27 $Y2=0.066
r13 9 14 3.92057 $w=1.38108e-08 $l=2.5224e-08 $layer=M1 $thickness=3.6e-08
+ $X=0.27 $Y=0.072 $X2=0.2455 $Y2=0.078
r14 15 40 2.79828 $w=1.3e-08 $l=1.2e-08 $layer=M1 $thickness=3.6e-08 $X=0.27
+ $Y=0.054 $X2=0.27 $Y2=0.066
r15 8 39 3.13128 $w=1.51951e-08 $l=2.05e-08 $layer=M1 $thickness=3.6e-08
+ $X=0.27 $Y=0.036 $X2=0.2905 $Y2=0.036
r16 8 15 2.5483 $w=1.79e-08 $l=1.8e-08 $layer=M1 $thickness=3.6e-08 $X=0.27
+ $Y=0.036 $X2=0.27 $Y2=0.054
r17 38 39 4.78039 $w=1.3e-08 $l=2.05e-08 $layer=M1 $thickness=3.6e-08 $X=0.311
+ $Y=0.036 $X2=0.2905 $Y2=0.036
r18 37 38 4.6638 $w=1.3e-08 $l=2e-08 $layer=M1 $thickness=3.6e-08 $X=0.331
+ $Y=0.036 $X2=0.311 $Y2=0.036
r19 36 37 6.99569 $w=1.3e-08 $l=3e-08 $layer=M1 $thickness=3.6e-08 $X=0.361
+ $Y=0.036 $X2=0.331 $Y2=0.036
r20 35 36 5.71315 $w=1.3e-08 $l=2.45e-08 $layer=M1 $thickness=3.6e-08 $X=0.3855
+ $Y=0.036 $X2=0.361 $Y2=0.036
r21 16 35 4.89699 $w=1.3e-08 $l=2.1e-08 $layer=M1 $thickness=3.6e-08 $X=0.4065
+ $Y=0.036 $X2=0.3855 $Y2=0.036
r22 11 34 2.5483 $w=1.79e-08 $l=1.8e-08 $layer=M1 $thickness=3.6e-08 $X=0.431
+ $Y=0.036 $X2=0.431 $Y2=0.054
r23 11 16 4.06404 $w=1.48367e-08 $l=2.45e-08 $layer=M1 $thickness=3.6e-08
+ $X=0.431 $Y=0.036 $X2=0.4065 $Y2=0.036
r24 33 34 4.19742 $w=1.3e-08 $l=1.8e-08 $layer=M1 $thickness=3.6e-08 $X=0.431
+ $Y=0.072 $X2=0.431 $Y2=0.054
r25 32 33 6.52931 $w=1.3e-08 $l=2.8e-08 $layer=M1 $thickness=3.6e-08 $X=0.431
+ $Y=0.1 $X2=0.431 $Y2=0.072
r26 17 32 5.24677 $w=1.3e-08 $l=2.25e-08 $layer=M1 $thickness=3.6e-08 $X=0.431
+ $Y=0.1225 $X2=0.431 $Y2=0.1
r27 29 12 0.484711 $w=1.8e-08 $l=4.8e-09 $layer=M1 $thickness=3.6e-08 $X=0.429
+ $Y=0.135 $X2=0.431 $Y2=0.1302
r28 12 17 1.24985 $w=1.57419e-08 $l=7.7e-09 $layer=M1 $thickness=3.6e-08
+ $X=0.431 $Y=0.1302 $X2=0.431 $Y2=0.1225
r29 29 28 0.983781 $w=1.35556e-08 $l=1.3e-08 $layer=M1 $thickness=3.6e-08
+ $X=0.429 $Y=0.135 $X2=0.418 $Y2=0.135
r30 27 28 3.03147 $w=1.3e-08 $l=1.3e-08 $layer=M1 $thickness=3.6e-08 $X=0.405
+ $Y=0.135 $X2=0.418 $Y2=0.135
r31 26 27 2.56509 $w=1.3e-08 $l=1.1e-08 $layer=M1 $thickness=3.6e-08 $X=0.394
+ $Y=0.135 $X2=0.405 $Y2=0.135
r32 10 26 0.582974 $w=1.3e-08 $l=2.5e-09 $layer=M1 $thickness=3.6e-08 $X=0.3915
+ $Y=0.135 $X2=0.394 $Y2=0.135
r33 2 20 8.65438 $w=1.80211e-08 $layer=LIG $thickness=5.26316e-08 $X=0.405
+ $Y=0.135 $X2=0.405 $Y2=0.135
r34 2 27 19.3796 $a=3.24e-16 $layer=V0LIG $X=0.405 $Y=0.135 $X2=0.405 $Y2=0.135
r35 22 21 16.4967 $w=2.1e-08 $l=4.85e-08 $layer=Gate_1 $thickness=5.6e-08
+ $X=0.405 $Y=0.216 $X2=0.405 $Y2=0.1675
r36 20 21 11.2416 $w=2.06615e-08 $l=3.25e-08 $layer=Gate_1 $thickness=5.6e-08
+ $X=0.405 $Y=0.135 $X2=0.405 $Y2=0.1675
r37 19 20 6.6497 $w=2.04211e-08 $l=1.9e-08 $layer=Gate_1 $thickness=5.6e-08
+ $X=0.405 $Y=0.116 $X2=0.405 $Y2=0.135
r38 18 19 16.4967 $w=2.1e-08 $l=4.85e-08 $layer=Gate_1 $thickness=5.6e-08
+ $X=0.405 $Y=0.0675 $X2=0.405 $Y2=0.116
r39 18 6 14.6259 $w=2.1e-08 $l=4.3e-08 $layer=Gate_1 $thickness=5.6e-08
+ $X=0.405 $Y=0.0675 $X2=0.405 $Y2=0.0245
.ends

* End of included file XOR2x2_ASAP7_75t_R.pex.sp.pex

*
.subckt XOR2x2_ASAP7_75t_CUSTOM_4_25_0_7 VSS VDD B A Y
*
* VSS VSS
* VDD VDD
* B B
* A A
* Y Y
*
*

M0 noxref_7 N_M0_g N_M0_s VSS nmos_rvt L=2e-08 W=8.1e-08 nfin=3 $X=0.071
+ $Y=0.027
M1 VSS N_M1_g noxref_7 VSS nmos_rvt L=2e-08 W=8.1e-08 nfin=3 $X=0.125 $Y=0.027
M2 noxref_7 N_M2_g VSS VSS nmos_rvt L=2e-08 W=8.1e-08 nfin=3 $X=0.179 $Y=0.027
M3 N_M3_d N_M3_g N_M3_s VSS nmos_rvt L=2e-08 W=8.1e-08 nfin=3 $X=0.341 $Y=0.027
M4 VSS N_M4_g N_M4_s VSS nmos_rvt L=2e-08 W=8.1e-08 nfin=3 $X=0.395 $Y=0.027
M5 N_M5_d N_M5_g VSS VSS nmos_rvt L=2e-08 W=8.1e-08 nfin=3 $X=0.449 $Y=0.027
M6 N_M6_d N_M6_g VSS VSS nmos_rvt L=2e-08 W=8.1e-08 nfin=3 $X=0.503 $Y=0.027
M7 VDD N_M7_g N_M7_s VDD pmos_rvt L=2e-08 W=8.1e-08 nfin=3 $X=0.071 $Y=0.162
M8 noxref_10 N_M8_g VDD VDD pmos_rvt L=2e-08 W=8.1e-08 nfin=3 $X=0.125 $Y=0.162
M9 N_M9_d N_M9_g noxref_10 VDD pmos_rvt L=2e-08 W=8.1e-08 nfin=3 $X=0.179
+ $Y=0.162
M10 N_M10_d N_M10_g VDD VDD pmos_rvt L=2e-08 W=5.4e-08 nfin=2 $X=0.341 $Y=0.189
M11 VDD N_M11_g N_M11_s VDD pmos_rvt L=2e-08 W=5.4e-08 nfin=2 $X=0.395 $Y=0.189
M12 N_M12_d N_M12_g VDD VDD pmos_rvt L=2e-08 W=8.1e-08 nfin=3 $X=0.449 $Y=0.162
M13 N_M13_d N_M13_g VDD VDD pmos_rvt L=2e-08 W=8.1e-08 nfin=3 $X=0.503 $Y=0.162

* .include "XOR2x2_ASAP7_75t_R.pex.sp.pxi"

* Start of included file XOR2x2_ASAP7_75t_R.pex.sp.pxi
x_PM_XOR2x2_ASAP7_75t_R%9 vss N_M3_d N_M4_s N_9_1 PM_XOR2x2_ASAP7_75t_R%9
cc_1 N_9_1 N_B_6 0.0169179f $X=0.378 $Y=0.0675
cc_2 N_9_1 N_A_4 0.0169502f $X=0.378 $Y=0.0675
x_PM_XOR2x2_ASAP7_75t_R%3 vss N_M0_g N_M7_g N_M3_s N_M10_d N_M11_s N_3_11 N_3_4
+ N_3_16 N_3_3 N_3_17 N_3_1 N_3_15 N_3_14 N_3_9 N_3_10 N_3_13 N_3_12
+ PM_XOR2x2_ASAP7_75t_R%3
x_PM_XOR2x2_ASAP7_75t_R%6 vss N_M5_g N_M12_g N_M6_g N_M13_g N_M9_d N_M7_s
+ N_M0_s N_6_23 N_6_14 N_6_19 N_6_5 N_6_3 N_6_4 N_6_15 N_6_22 N_6_17 N_6_1
+ N_6_25 N_6_26 N_6_12 N_6_16 N_6_20 N_6_21 N_6_13 PM_XOR2x2_ASAP7_75t_R%6
cc_3 N_6_23 N_3_9 0.000313756f $X=0.4225 $Y=0.234
cc_4 N_6_14 N_3_9 0.015252f $X=0.056 $Y=0.0675
cc_5 N_6_19 N_3_9 0.00043187f $X=0.432 $Y=0.198
cc_6 N_6_5 N_3_15 0.00162934f $X=0.216 $Y=0.216
cc_7 N_6_23 N_3_4 0.00131823f $X=0.4225 $Y=0.234
cc_8 N_6_3 N_3_1 0.000814565f $X=0.054 $Y=0.0675
cc_9 N_6_23 N_3_13 0.000917526f $X=0.4225 $Y=0.234
cc_10 N_6_3 N_3_9 0.000929705f $X=0.054 $Y=0.0675
cc_11 N_6_4 N_3_9 0.0012877f $X=0.054 $Y=0.2025
cc_12 N_6_23 N_3_12 0.00165148f $X=0.4225 $Y=0.234
cc_13 N_6_15 N_3_1 0.00167276f $X=0.056 $Y=0.2025
cc_14 N_6_23 N_3_17 0.00292693f $X=0.4225 $Y=0.234
cc_15 N_6_22 N_3_14 0.00431286f $X=0.027 $Y=0.216
cc_16 N_6_23 N_3_15 0.0202218f $X=0.4225 $Y=0.234
cc_17 N_6_15 N_3_9 0.0543384f $X=0.056 $Y=0.2025
cc_18 N_6_19 N_B_6 0.000191568f $X=0.432 $Y=0.198
cc_19 N_6_3 N_B_1 0.000234455f $X=0.054 $Y=0.0675
cc_20 N_6_22 N_B_13 0.000282868f $X=0.027 $Y=0.216
cc_21 N_6_17 N_B_7 0.000304044f $X=0.027 $Y=0.036
cc_22 N_6_1 N_B_12 0.000345625f $X=0.459 $Y=0.135
cc_23 N_6_3 N_B_13 0.000356146f $X=0.054 $Y=0.0675
cc_24 N_6_1 N_B_2 0.00187542f $X=0.459 $Y=0.135
cc_25 N_6_25 N_B_12 0.000370336f $X=0.4745 $Y=0.198
cc_26 N_6_5 N_B_5 0.000419992f $X=0.216 $Y=0.216
cc_27 N_6_23 N_B_13 0.000492826f $X=0.4225 $Y=0.234
cc_28 N_6_26 N_B_17 0.000768182f $X=0.486 $Y=0.1225
cc_29 N_6_26 N_B_12 0.00152822f $X=0.486 $Y=0.1225
cc_30 N_6_19 N_B_12 0.00190155f $X=0.432 $Y=0.198
cc_31 N_6_12 N_B_6 0.00400093f $X=0.459 $Y=0.0245
cc_32 N_6_5 N_A_3 0.00163436f $X=0.216 $Y=0.216
cc_33 N_6_16 N_A_1 0.00301587f $X=0.2015 $Y=0.2025
cc_34 N_6_16 N_A_3 0.0359935f $X=0.2015 $Y=0.2025
x_PM_XOR2x2_ASAP7_75t_R%Y vss Y N_M5_d N_M6_d N_M12_d N_M13_d N_Y_11 N_Y_8
+ N_Y_13 N_Y_2 N_Y_1 N_Y_12 N_Y_7 PM_XOR2x2_ASAP7_75t_R%Y
cc_35 N_Y_11 N_B_17 0.00111076f $X=0.486 $Y=0.036
cc_36 N_Y_11 N_B_11 0.00214017f $X=0.486 $Y=0.036
cc_37 N_Y_8 N_6_20 0.000348835f $X=0.4715 $Y=0.2025
cc_38 N_Y_8 N_6_21 0.000555577f $X=0.4715 $Y=0.2025
cc_39 N_Y_8 N_6_1 0.00529535f $X=0.4715 $Y=0.2025
cc_40 N_Y_8 N_6_25 0.000822702f $X=0.4715 $Y=0.2025
cc_41 N_Y_8 N_6_13 0.00083886f $X=0.4715 $Y=0.2025
cc_42 N_Y_13 N_6_1 0.00122896f $X=0.567 $Y=0.082
cc_43 N_Y_2 N_6_26 0.00162884f $X=0.486 $Y=0.2025
cc_44 N_Y_1 N_6_13 0.00169041f $X=0.486 $Y=0.0675
cc_45 N_Y_2 N_6_12 0.00231977f $X=0.486 $Y=0.2025
cc_46 N_Y_12 N_6_21 0.00314357f $X=0.5265 $Y=0.234
cc_47 N_Y_7 N_6_12 0.0103874f $X=0.4715 $Y=0.0675
cc_48 N_Y_7 N_6_13 0.0550853f $X=0.4715 $Y=0.0675
cc_49 N_Y_8 N_6_12 0.0673093f $X=0.4715 $Y=0.2025
x_PM_XOR2x2_ASAP7_75t_R%A vss A N_M3_g N_M10_g N_M2_g N_M9_g N_A_6 N_A_5 N_A_1
+ N_A_4 N_A_3 PM_XOR2x2_ASAP7_75t_R%A
cc_50 N_A_6 N_3_10 0.00057678f $X=0.351 $Y=0.1265
cc_51 N_A_5 N_3_16 0.000752438f $X=0.351 $Y=0.072
cc_52 N_A_1 N_3_15 0.000761587f $X=0.3415 $Y=0.135
cc_53 N_A_1 N_3_16 0.000805036f $X=0.3415 $Y=0.135
cc_54 N_A_6 N_3_17 0.000891823f $X=0.351 $Y=0.1265
cc_55 N_A_4 N_3_3 0.0028833f $X=0.351 $Y=0.0245
cc_56 N_A_4 N_3_11 0.0106753f $X=0.351 $Y=0.0245
cc_57 N_A_1 N_3_3 0.00518035f $X=0.3415 $Y=0.135
cc_58 N_A_6 N_3_16 0.00707817f $X=0.351 $Y=0.1265
cc_59 N_A_4 N_3_10 0.050658f $X=0.351 $Y=0.0245
cc_60 N_A_1 N_B_10 0.00044079f $X=0.3415 $Y=0.135
cc_61 N_A_1 N_B_2 0.00122638f $X=0.3415 $Y=0.135
cc_62 N_A_1 N_B_14 0.000486222f $X=0.3415 $Y=0.135
cc_63 N_A_1 N_B_1 0.000520885f $X=0.3415 $Y=0.135
cc_64 N_A_5 N_B_17 0.000553731f $X=0.351 $Y=0.072
cc_65 N_A_1 N_B_9 0.00167873f $X=0.3415 $Y=0.135
cc_66 N_A_6 N_B_10 0.00210224f $X=0.351 $Y=0.1265
cc_67 N_A_5 N_B_16 0.00473279f $X=0.351 $Y=0.072
cc_68 N_A_3 N_B_5 0.00489239f $X=0.189 $Y=0.135
cc_69 N_A_4 N_B_6 0.00758025f $X=0.351 $Y=0.0245
x_PM_XOR2x2_ASAP7_75t_R%B vss B N_M4_g N_M11_g N_M1_g N_M8_g N_B_2 N_B_6 N_B_15
+ N_B_9 N_B_10 N_B_14 N_B_1 N_B_13 N_B_16 N_B_5 N_B_17 N_B_7 N_B_12 N_B_11
+ PM_XOR2x2_ASAP7_75t_R%B
cc_70 N_B_2 N_3_11 0.000930052f $X=0.405 $Y=0.135
cc_71 N_B_6 N_3_4 0.000406851f $X=0.405 $Y=0.0245
cc_72 N_B_15 N_3_16 0.000440175f $X=0.27 $Y=0.054
cc_73 N_B_9 N_3_3 0.000453689f $X=0.27 $Y=0.072
cc_74 N_B_10 N_3_17 0.000773663f $X=0.3915 $Y=0.135
cc_75 N_B_14 N_3_3 0.000821869f $X=0.2455 $Y=0.078
cc_76 N_B_1 N_3_1 0.00217795f $X=0.135 $Y=0.135
cc_77 N_B_13 N_3_15 0.00156677f $X=0.135 $Y=0.104
cc_78 N_B_16 N_3_16 0.00162707f $X=0.4065 $Y=0.036
cc_79 N_B_16 N_3_3 0.00171751f $X=0.4065 $Y=0.036
cc_80 N_B_13 N_3_14 0.00280254f $X=0.135 $Y=0.104
cc_81 N_B_9 N_3_16 0.0028507f $X=0.27 $Y=0.072
cc_82 N_B_5 N_3_9 0.00334497f $X=0.135 $Y=0.135
cc_83 N_B_6 N_3_11 0.0260063f $X=0.405 $Y=0.0245

* End of included file XOR2x2_ASAP7_75t_R.pex.sp.pxi
.ends

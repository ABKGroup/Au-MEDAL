.subckt PM_OR2x6_ASAP7_75t_R%7__2 vss 2 3 1
c1 1 vss 0.00082064f $X=0.108 $Y=0.2025
r1 2 1 0.209877 $w=8.1e-08 $l=1.7e-08 $layer=P_src_drn $thickness=1e-09
+ $X=0.0906 $Y=0.2025 $X2=0.108 $Y2=0.2025
r2 3 1 0.209877 $w=8.1e-08 $l=1.7e-08 $layer=P_src_drn $thickness=1e-09
+ $X=0.1253 $Y=0.2025 $X2=0.108 $Y2=0.2025
.ends

.subckt PM_OR2x6_ASAP7_75t_R%8 vss 2 3 1
c1 1 vss 0.000750466f $X=0.216 $Y=0.2025
r1 2 1 0.209877 $w=8.1e-08 $l=1.7e-08 $layer=P_src_drn $thickness=1e-09
+ $X=0.1986 $Y=0.2025 $X2=0.216 $Y2=0.2025
r2 3 1 0.209877 $w=8.1e-08 $l=1.7e-08 $layer=P_src_drn $thickness=1e-09
+ $X=0.2333 $Y=0.2025 $X2=0.216 $Y2=0.2025
.ends

.subckt PM_OR2x6_ASAP7_75t_R%5 vss 30 34 55 58 61 64 67 70 73 76 80 84 94 95
+ 103 104 107 108 25 20 19 18 28 3 5 26 1 22 4 29 12 21 24 23 14 17 16 15 13
c1 1 vss 0.0285731f $X=0.2875 $Y=0.135
c2 3 vss 0.0112576f $X=0.108 $Y=0.054
c3 4 vss 0.00844581f $X=0.162 $Y=0.2025
c4 5 vss 0.0112708f $X=0.216 $Y=0.054
c5 12 vss 0.114751f $X=0.297 $Y=0.0245
c6 13 vss 0.0823479f $X=0.351 $Y=0.135
c7 14 vss 0.0823428f $X=0.405 $Y=0.135
c8 15 vss 0.0822029f $X=0.459 $Y=0.135
c9 16 vss 0.0826537f $X=0.513 $Y=0.135
c10 17 vss 0.0826431f $X=0.567 $Y=0.135
c11 18 vss 0.00918392f $X=0.0935 $Y=0.054
c12 19 vss 0.00924406f $X=0.2015 $Y=0.054
c13 20 vss 0.00813199f $X=0.1475 $Y=0.2025
c14 21 vss 0.00484172f $X=0.243 $Y=0.036
c15 22 vss 0.00232095f $X=0.243 $Y=0.0755
c16 23 vss 0.00263195f $X=0.297 $Y=0.079
c17 24 vss 0.00263475f $X=0.297 $Y=0.198
c18 25 vss 0.0142646f $X=0.1755 $Y=0.036
c19 26 vss 0.00755186f $X=0.27 $Y=0.198
c20 27 vss 0.00272164f $X=0.243 $Y=0.0665
c21 28 vss 0.00327533f $X=0.27 $Y=0.079
c22 29 vss 0.00378703f $X=0.297 $Y=0.1045
r1 108 106 0.0462963 $w=5.4e-08 $l=2.5e-09 $layer=N_src_drn $thickness=1e-09
+ $X=0.1253 $Y=0.054 $X2=0.1225 $Y2=0.054
r2 3 106 0.268519 $w=5.4e-08 $l=1.45e-08 $layer=N_src_drn $thickness=1e-09
+ $X=0.108 $Y=0.054 $X2=0.1225 $Y2=0.054
r3 18 3 0.268519 $w=5.4e-08 $l=1.45e-08 $layer=N_src_drn $thickness=1e-09
+ $X=0.0935 $Y=0.054 $X2=0.108 $Y2=0.054
r4 107 18 0.0462963 $w=5.4e-08 $l=2.5e-09 $layer=N_src_drn $thickness=1e-09
+ $X=0.0906 $Y=0.054 $X2=0.0935 $Y2=0.054
r5 104 102 0.0462963 $w=5.4e-08 $l=2.5e-09 $layer=N_src_drn $thickness=1e-09
+ $X=0.2333 $Y=0.054 $X2=0.2305 $Y2=0.054
r6 5 102 0.268519 $w=5.4e-08 $l=1.45e-08 $layer=N_src_drn $thickness=1e-09
+ $X=0.216 $Y=0.054 $X2=0.2305 $Y2=0.054
r7 19 5 0.268519 $w=5.4e-08 $l=1.45e-08 $layer=N_src_drn $thickness=1e-09
+ $X=0.2015 $Y=0.054 $X2=0.216 $Y2=0.054
r8 103 19 0.0462963 $w=5.4e-08 $l=2.5e-09 $layer=N_src_drn $thickness=1e-09
+ $X=0.1986 $Y=0.054 $X2=0.2015 $Y2=0.054
r9 3 99 19.3796 $a=3.24e-16 $layer=V0LISD $X=0.108 $Y=0.054 $X2=0.108 $Y2=0.036
r10 5 96 19.3796 $a=3.24e-16 $layer=V0LISD $X=0.216 $Y=0.054 $X2=0.216 $Y2=0.036
r11 99 100 5.24677 $w=1.3e-08 $l=2.25e-08 $layer=M1 $thickness=3.6e-08 $X=0.108
+ $Y=0.036 $X2=0.1305 $Y2=0.036
r12 96 97 3.14806 $w=1.3e-08 $l=1.35e-08 $layer=M1 $thickness=3.6e-08 $X=0.216
+ $Y=0.036 $X2=0.2295 $Y2=0.036
r13 25 96 9.44419 $w=1.3e-08 $l=4.05e-08 $layer=M1 $thickness=3.6e-08 $X=0.1755
+ $Y=0.036 $X2=0.216 $Y2=0.036
r14 25 100 10.4935 $w=1.3e-08 $l=4.5e-08 $layer=M1 $thickness=3.6e-08 $X=0.1755
+ $Y=0.036 $X2=0.1305 $Y2=0.036
r15 21 91 2.5483 $w=1.79e-08 $l=1.8e-08 $layer=M1 $thickness=3.6e-08 $X=0.243
+ $Y=0.036 $X2=0.243 $Y2=0.054
r16 21 97 1.49895 $w=1.63333e-08 $l=1.35e-08 $layer=M1 $thickness=3.6e-08
+ $X=0.243 $Y=0.036 $X2=0.2295 $Y2=0.036
r17 95 93 0.0308642 $w=8.1e-08 $l=2.5e-09 $layer=P_src_drn $thickness=1e-09
+ $X=0.1793 $Y=0.2025 $X2=0.1765 $Y2=0.2025
r18 4 93 0.179012 $w=8.1e-08 $l=1.45e-08 $layer=P_src_drn $thickness=1e-09
+ $X=0.162 $Y=0.2025 $X2=0.1765 $Y2=0.2025
r19 20 4 0.179012 $w=8.1e-08 $l=1.45e-08 $layer=P_src_drn $thickness=1e-09
+ $X=0.1475 $Y=0.2025 $X2=0.162 $Y2=0.2025
r20 94 20 0.0308642 $w=8.1e-08 $l=2.5e-09 $layer=P_src_drn $thickness=1e-09
+ $X=0.1446 $Y=0.2025 $X2=0.1475 $Y2=0.2025
r21 27 91 2.91487 $w=1.3e-08 $l=1.25e-08 $layer=M1 $thickness=3.6e-08 $X=0.243
+ $Y=0.0665 $X2=0.243 $Y2=0.054
r22 4 88 19.3796 $a=3.24e-16 $layer=V0LISD $X=0.162 $Y=0.2025 $X2=0.162
+ $Y2=0.198
r23 22 28 4.75866 $w=1.41702e-08 $l=2.72259e-08 $layer=M1 $thickness=3.6e-08
+ $X=0.243 $Y=0.0755 $X2=0.27 $Y2=0.079
r24 22 27 1.37741 $w=1.60556e-08 $l=9e-09 $layer=M1 $thickness=3.6e-08 $X=0.243
+ $Y=0.0755 $X2=0.243 $Y2=0.0665
r25 88 89 9.44419 $w=1.3e-08 $l=4.05e-08 $layer=M1 $thickness=3.6e-08 $X=0.162
+ $Y=0.198 $X2=0.2025 $Y2=0.198
r26 86 89 9.44419 $w=1.3e-08 $l=4.05e-08 $layer=M1 $thickness=3.6e-08 $X=0.243
+ $Y=0.198 $X2=0.2025 $Y2=0.198
r27 26 86 6.29612 $w=1.3e-08 $l=2.7e-08 $layer=M1 $thickness=3.6e-08 $X=0.27
+ $Y=0.198 $X2=0.243 $Y2=0.198
r28 24 53 2.5483 $w=1.79e-08 $l=1.8e-08 $layer=M1 $thickness=3.6e-08 $X=0.297
+ $Y=0.198 $X2=0.297 $Y2=0.18
r29 24 26 4.64701 $w=1.46667e-08 $l=2.7e-08 $layer=M1 $thickness=3.6e-08
+ $X=0.297 $Y=0.198 $X2=0.27 $Y2=0.198
r30 23 29 4.29723 $w=1.64588e-08 $l=2.55e-08 $layer=M1 $thickness=3.6e-08
+ $X=0.297 $Y=0.079 $X2=0.297 $Y2=0.1045
r31 23 28 4.64701 $w=1.46667e-08 $l=2.7e-08 $layer=M1 $thickness=3.6e-08
+ $X=0.297 $Y=0.079 $X2=0.27 $Y2=0.079
r32 84 83 14.6259 $w=2.1e-08 $l=4.3e-08 $layer=Gate_1 $thickness=5.6e-08
+ $X=0.567 $Y=0.2025 $X2=0.567 $Y2=0.1595
r33 82 83 2.7211 $w=2.1e-08 $l=8e-09 $layer=Gate_1 $thickness=5.6e-08 $X=0.567
+ $Y=0.1515 $X2=0.567 $Y2=0.1595
r34 80 81 14.6259 $w=2.1e-08 $l=4.3e-08 $layer=Gate_1 $thickness=5.6e-08
+ $X=0.567 $Y=0.0675 $X2=0.567 $Y2=0.1105
r35 78 81 2.7211 $w=2.1e-08 $l=8e-09 $layer=Gate_1 $thickness=5.6e-08 $X=0.567
+ $Y=0.1185 $X2=0.567 $Y2=0.1105
r36 17 48 6.54019 $w=2.09524e-08 $layer=Gate_1 $thickness=5.21905e-08 $X=0.567
+ $Y=0.135 $X2=0.567 $Y2=0.135
r37 17 78 5.79936 $w=2.03333e-08 $l=1.65e-08 $layer=Gate_1 $thickness=5.6e-08
+ $X=0.567 $Y=0.135 $X2=0.567 $Y2=0.1185
r38 17 82 5.79936 $w=2.03333e-08 $l=1.65e-08 $layer=Gate_1 $thickness=5.6e-08
+ $X=0.567 $Y=0.135 $X2=0.567 $Y2=0.1515
r39 76 75 16.4967 $w=2.1e-08 $l=4.85e-08 $layer=Gate_1 $thickness=5.6e-08
+ $X=0.513 $Y=0.2025 $X2=0.513 $Y2=0.154
r40 73 74 16.4967 $w=2.1e-08 $l=4.85e-08 $layer=Gate_1 $thickness=5.6e-08
+ $X=0.513 $Y=0.0675 $X2=0.513 $Y2=0.116
r41 16 46 6.54019 $w=2.09524e-08 $layer=Gate_1 $thickness=5.21905e-08 $X=0.513
+ $Y=0.135 $X2=0.513 $Y2=0.135
r42 16 74 6.6497 $w=2.04211e-08 $l=1.9e-08 $layer=Gate_1 $thickness=5.6e-08
+ $X=0.513 $Y=0.135 $X2=0.513 $Y2=0.116
r43 16 75 6.6497 $w=2.04211e-08 $l=1.9e-08 $layer=Gate_1 $thickness=5.6e-08
+ $X=0.513 $Y=0.135 $X2=0.513 $Y2=0.154
r44 70 69 16.4967 $w=2.1e-08 $l=4.85e-08 $layer=Gate_1 $thickness=5.6e-08
+ $X=0.459 $Y=0.2025 $X2=0.459 $Y2=0.154
r45 67 68 16.4967 $w=2.1e-08 $l=4.85e-08 $layer=Gate_1 $thickness=5.6e-08
+ $X=0.459 $Y=0.0675 $X2=0.459 $Y2=0.116
r46 15 44 6.54019 $w=2.09524e-08 $layer=Gate_1 $thickness=5.21905e-08 $X=0.459
+ $Y=0.135 $X2=0.459 $Y2=0.135
r47 15 68 6.6497 $w=2.04211e-08 $l=1.9e-08 $layer=Gate_1 $thickness=5.6e-08
+ $X=0.459 $Y=0.135 $X2=0.459 $Y2=0.116
r48 15 69 6.6497 $w=2.04211e-08 $l=1.9e-08 $layer=Gate_1 $thickness=5.6e-08
+ $X=0.459 $Y=0.135 $X2=0.459 $Y2=0.154
r49 64 63 16.4967 $w=2.1e-08 $l=4.85e-08 $layer=Gate_1 $thickness=5.6e-08
+ $X=0.405 $Y=0.2025 $X2=0.405 $Y2=0.154
r50 61 62 16.4967 $w=2.1e-08 $l=4.85e-08 $layer=Gate_1 $thickness=5.6e-08
+ $X=0.405 $Y=0.0675 $X2=0.405 $Y2=0.116
r51 14 42 6.54019 $w=2.09524e-08 $layer=Gate_1 $thickness=5.21905e-08 $X=0.405
+ $Y=0.135 $X2=0.405 $Y2=0.135
r52 14 62 6.6497 $w=2.04211e-08 $l=1.9e-08 $layer=Gate_1 $thickness=5.6e-08
+ $X=0.405 $Y=0.135 $X2=0.405 $Y2=0.116
r53 14 63 6.6497 $w=2.04211e-08 $l=1.9e-08 $layer=Gate_1 $thickness=5.6e-08
+ $X=0.405 $Y=0.135 $X2=0.405 $Y2=0.154
r54 58 57 16.4967 $w=2.1e-08 $l=4.85e-08 $layer=Gate_1 $thickness=5.6e-08
+ $X=0.351 $Y=0.2025 $X2=0.351 $Y2=0.154
r55 55 56 16.4967 $w=2.1e-08 $l=4.85e-08 $layer=Gate_1 $thickness=5.6e-08
+ $X=0.351 $Y=0.0675 $X2=0.351 $Y2=0.116
r56 13 40 6.54019 $w=2.09524e-08 $layer=Gate_1 $thickness=5.21905e-08 $X=0.351
+ $Y=0.135 $X2=0.351 $Y2=0.135
r57 13 56 6.6497 $w=2.04211e-08 $l=1.9e-08 $layer=Gate_1 $thickness=5.6e-08
+ $X=0.351 $Y=0.135 $X2=0.351 $Y2=0.116
r58 13 57 6.6497 $w=2.04211e-08 $l=1.9e-08 $layer=Gate_1 $thickness=5.6e-08
+ $X=0.351 $Y=0.135 $X2=0.351 $Y2=0.154
r59 52 53 5.24677 $w=1.3e-08 $l=2.25e-08 $layer=M1 $thickness=3.6e-08 $X=0.297
+ $Y=0.1575 $X2=0.297 $Y2=0.18
r60 51 52 5.24677 $w=1.3e-08 $l=2.25e-08 $layer=M1 $thickness=3.6e-08 $X=0.297
+ $Y=0.135 $X2=0.297 $Y2=0.1575
r61 50 51 2.68168 $w=1.3e-08 $l=1.15e-08 $layer=M1 $thickness=3.6e-08 $X=0.297
+ $Y=0.1235 $X2=0.297 $Y2=0.135
r62 29 50 4.43061 $w=1.3e-08 $l=1.9e-08 $layer=M1 $thickness=3.6e-08 $X=0.297
+ $Y=0.1045 $X2=0.297 $Y2=0.1235
r63 47 48 12.6539 $w=1.77815e-08 $l=2.7e-08 $layer=LIG $thickness=4.8e-08
+ $X=0.54 $Y=0.135 $X2=0.567 $Y2=0.135
r64 46 47 12.6539 $w=1.77815e-08 $l=2.7e-08 $layer=LIG $thickness=4.8e-08
+ $X=0.513 $Y=0.135 $X2=0.54 $Y2=0.135
r65 45 46 12.6539 $w=1.77815e-08 $l=2.7e-08 $layer=LIG $thickness=4.8e-08
+ $X=0.486 $Y=0.135 $X2=0.513 $Y2=0.135
r66 44 45 12.6539 $w=1.77815e-08 $l=2.7e-08 $layer=LIG $thickness=4.8e-08
+ $X=0.459 $Y=0.135 $X2=0.486 $Y2=0.135
r67 43 44 12.6539 $w=1.77815e-08 $l=2.7e-08 $layer=LIG $thickness=4.8e-08
+ $X=0.432 $Y=0.135 $X2=0.459 $Y2=0.135
r68 42 43 12.6539 $w=1.77815e-08 $l=2.7e-08 $layer=LIG $thickness=4.8e-08
+ $X=0.405 $Y=0.135 $X2=0.432 $Y2=0.135
r69 41 42 12.6539 $w=1.77815e-08 $l=2.7e-08 $layer=LIG $thickness=4.8e-08
+ $X=0.378 $Y=0.135 $X2=0.405 $Y2=0.135
r70 40 41 12.6539 $w=1.77815e-08 $l=2.7e-08 $layer=LIG $thickness=4.8e-08
+ $X=0.351 $Y=0.135 $X2=0.378 $Y2=0.135
r71 39 40 12.6539 $w=1.77815e-08 $l=2.7e-08 $layer=LIG $thickness=4.8e-08
+ $X=0.324 $Y=0.135 $X2=0.351 $Y2=0.135
r72 37 39 10.1729 $w=1.54914e-08 $l=1.75e-08 $layer=LIG $thickness=4.8e-08
+ $X=0.3065 $Y=0.135 $X2=0.324 $Y2=0.135
r73 36 37 2.48102 $w=2.2e-08 $l=9.5e-09 $layer=LIG $thickness=4.8e-08 $X=0.297
+ $Y=0.135 $X2=0.3065 $Y2=0.135
r74 36 51 19.3796 $a=3.24e-16 $layer=V0LIG $X=0.297 $Y=0.135 $X2=0.297 $Y2=0.135
r75 1 36 2.48102 $w=2.2e-08 $l=9.5e-09 $layer=LIG $thickness=4.8e-08 $X=0.2875
+ $Y=0.135 $X2=0.297 $Y2=0.135
r76 34 33 16.4967 $w=2.1e-08 $l=4.85e-08 $layer=Gate_1 $thickness=5.6e-08
+ $X=0.297 $Y=0.2025 $X2=0.297 $Y2=0.154
r77 32 33 6.6497 $w=2.04211e-08 $l=1.9e-08 $layer=Gate_1 $thickness=5.6e-08
+ $X=0.297 $Y=0.135 $X2=0.297 $Y2=0.154
r78 32 37 4.05918 $w=2.0087e-08 $l=9.5e-09 $layer=Gate_1 $thickness=5.56522e-08
+ $X=0.297 $Y=0.135 $X2=0.3065 $Y2=0.135
r79 32 36 6.27904 $w=2.09e-08 $layer=Gate_1 $thickness=5.24e-08 $X=0.297
+ $Y=0.135 $X2=0.297 $Y2=0.135
r80 31 32 6.6497 $w=2.04211e-08 $l=1.9e-08 $layer=Gate_1 $thickness=5.6e-08
+ $X=0.297 $Y=0.116 $X2=0.297 $Y2=0.135
r81 30 31 16.4967 $w=2.1e-08 $l=4.85e-08 $layer=Gate_1 $thickness=5.6e-08
+ $X=0.297 $Y=0.0675 $X2=0.297 $Y2=0.116
r82 30 12 14.6259 $w=2.1e-08 $l=4.3e-08 $layer=Gate_1 $thickness=5.6e-08
+ $X=0.297 $Y=0.0675 $X2=0.297 $Y2=0.0245
.ends

.subckt PM_OR2x6_ASAP7_75t_R%Y vss 40 32 33 44 45 48 49 60 61 64 65 68 69 19 28
+ 23 24 21 27 2 5 6 3 4 1 22 20
c1 1 vss 0.00837848f $X=0.324 $Y=0.0675
c2 2 vss 0.00823724f $X=0.324 $Y=0.2025
c3 3 vss 0.00859025f $X=0.432 $Y=0.0675
c4 4 vss 0.00859025f $X=0.432 $Y=0.2025
c5 5 vss 0.0084887f $X=0.54 $Y=0.0675
c6 6 vss 0.0084887f $X=0.54 $Y=0.2025
c7 19 vss 0.00436745f $X=0.3095 $Y=0.0675
c8 20 vss 0.00434997f $X=0.4175 $Y=0.0675
c9 21 vss 0.00426434f $X=0.5255 $Y=0.0675
c10 22 vss 0.00434388f $X=0.3095 $Y=0.2025
c11 23 vss 0.00435058f $X=0.4175 $Y=0.2025
c12 24 vss 0.00425222f $X=0.5255 $Y=0.2025
c13 25 vss 0.00286681f $X=0.621 $Y=0.036
c14 26 vss 0.00286681f $X=0.621 $Y=0.234
c15 27 vss 0.0294244f $X=0.3125 $Y=0.234
c16 28 vss 0.0271745f $X=0.3125 $Y=0.036
c17 29 vss 0.00846287f $X=0.621 $Y=0.096
r1 69 67 0.0308642 $w=8.1e-08 $l=2.5e-09 $layer=P_src_drn $thickness=1e-09
+ $X=0.5573 $Y=0.2025 $X2=0.5545 $Y2=0.2025
r2 6 67 0.179012 $w=8.1e-08 $l=1.45e-08 $layer=P_src_drn $thickness=1e-09
+ $X=0.54 $Y=0.2025 $X2=0.5545 $Y2=0.2025
r3 24 6 0.179012 $w=8.1e-08 $l=1.45e-08 $layer=P_src_drn $thickness=1e-09
+ $X=0.5255 $Y=0.2025 $X2=0.54 $Y2=0.2025
r4 68 24 0.0308642 $w=8.1e-08 $l=2.5e-09 $layer=P_src_drn $thickness=1e-09
+ $X=0.5226 $Y=0.2025 $X2=0.5255 $Y2=0.2025
r5 65 63 0.0308642 $w=8.1e-08 $l=2.5e-09 $layer=P_src_drn $thickness=1e-09
+ $X=0.4493 $Y=0.2025 $X2=0.4465 $Y2=0.2025
r6 4 63 0.179012 $w=8.1e-08 $l=1.45e-08 $layer=P_src_drn $thickness=1e-09
+ $X=0.432 $Y=0.2025 $X2=0.4465 $Y2=0.2025
r7 23 4 0.179012 $w=8.1e-08 $l=1.45e-08 $layer=P_src_drn $thickness=1e-09
+ $X=0.4175 $Y=0.2025 $X2=0.432 $Y2=0.2025
r8 64 23 0.0308642 $w=8.1e-08 $l=2.5e-09 $layer=P_src_drn $thickness=1e-09
+ $X=0.4146 $Y=0.2025 $X2=0.4175 $Y2=0.2025
r9 61 59 0.0308642 $w=8.1e-08 $l=2.5e-09 $layer=P_src_drn $thickness=1e-09
+ $X=0.3413 $Y=0.2025 $X2=0.3385 $Y2=0.2025
r10 2 59 0.179012 $w=8.1e-08 $l=1.45e-08 $layer=P_src_drn $thickness=1e-09
+ $X=0.324 $Y=0.2025 $X2=0.3385 $Y2=0.2025
r11 22 2 0.179012 $w=8.1e-08 $l=1.45e-08 $layer=P_src_drn $thickness=1e-09
+ $X=0.3095 $Y=0.2025 $X2=0.324 $Y2=0.2025
r12 60 22 0.0308642 $w=8.1e-08 $l=2.5e-09 $layer=P_src_drn $thickness=1e-09
+ $X=0.3066 $Y=0.2025 $X2=0.3095 $Y2=0.2025
r13 6 54 19.3796 $a=3.24e-16 $layer=V0LISD $X=0.54 $Y=0.2025 $X2=0.54 $Y2=0.234
r14 4 52 19.3796 $a=3.24e-16 $layer=V0LISD $X=0.432 $Y=0.2025 $X2=0.432
+ $Y2=0.234
r15 2 50 19.3796 $a=3.24e-16 $layer=V0LISD $X=0.324 $Y=0.2025 $X2=0.324
+ $Y2=0.234
r16 54 55 9.44419 $w=1.3e-08 $l=4.05e-08 $layer=M1 $thickness=3.6e-08 $X=0.54
+ $Y=0.234 $X2=0.5805 $Y2=0.234
r17 53 54 12.5922 $w=1.3e-08 $l=5.4e-08 $layer=M1 $thickness=3.6e-08 $X=0.486
+ $Y=0.234 $X2=0.54 $Y2=0.234
r18 52 53 12.5922 $w=1.3e-08 $l=5.4e-08 $layer=M1 $thickness=3.6e-08 $X=0.432
+ $Y=0.234 $X2=0.486 $Y2=0.234
r19 51 52 12.5922 $w=1.3e-08 $l=5.4e-08 $layer=M1 $thickness=3.6e-08 $X=0.378
+ $Y=0.234 $X2=0.432 $Y2=0.234
r20 50 51 12.5922 $w=1.3e-08 $l=5.4e-08 $layer=M1 $thickness=3.6e-08 $X=0.324
+ $Y=0.234 $X2=0.378 $Y2=0.234
r21 27 50 2.68168 $w=1.3e-08 $l=1.15e-08 $layer=M1 $thickness=3.6e-08 $X=0.3125
+ $Y=0.234 $X2=0.324 $Y2=0.234
r22 26 41 9.4274 $w=1.48568e-08 $l=4.75e-08 $layer=M1 $thickness=3.6e-08
+ $X=0.621 $Y=0.234 $X2=0.621 $Y2=0.1865
r23 26 55 7.79507 $w=1.41111e-08 $l=4.05e-08 $layer=M1 $thickness=3.6e-08
+ $X=0.621 $Y=0.234 $X2=0.5805 $Y2=0.234
r24 49 47 0.0308642 $w=8.1e-08 $l=2.5e-09 $layer=N_src_drn $thickness=1e-09
+ $X=0.5573 $Y=0.0675 $X2=0.5545 $Y2=0.0675
r25 5 47 0.179012 $w=8.1e-08 $l=1.45e-08 $layer=N_src_drn $thickness=1e-09
+ $X=0.54 $Y=0.0675 $X2=0.5545 $Y2=0.0675
r26 21 5 0.179012 $w=8.1e-08 $l=1.45e-08 $layer=N_src_drn $thickness=1e-09
+ $X=0.5255 $Y=0.0675 $X2=0.54 $Y2=0.0675
r27 48 21 0.0308642 $w=8.1e-08 $l=2.5e-09 $layer=N_src_drn $thickness=1e-09
+ $X=0.5226 $Y=0.0675 $X2=0.5255 $Y2=0.0675
r28 45 43 0.0308642 $w=8.1e-08 $l=2.5e-09 $layer=N_src_drn $thickness=1e-09
+ $X=0.4493 $Y=0.0675 $X2=0.4465 $Y2=0.0675
r29 3 43 0.179012 $w=8.1e-08 $l=1.45e-08 $layer=N_src_drn $thickness=1e-09
+ $X=0.432 $Y=0.0675 $X2=0.4465 $Y2=0.0675
r30 20 3 0.179012 $w=8.1e-08 $l=1.45e-08 $layer=N_src_drn $thickness=1e-09
+ $X=0.4175 $Y=0.0675 $X2=0.432 $Y2=0.0675
r31 44 20 0.0308642 $w=8.1e-08 $l=2.5e-09 $layer=N_src_drn $thickness=1e-09
+ $X=0.4146 $Y=0.0675 $X2=0.4175 $Y2=0.0675
r32 40 41 9.0944 $w=1.3e-08 $l=3.9e-08 $layer=M1 $thickness=3.6e-08 $X=0.6215
+ $Y=0.1475 $X2=0.621 $Y2=0.1865
r33 40 29 12.0093 $w=1.3e-08 $l=5.15e-08 $layer=M1 $thickness=3.6e-08 $X=0.6215
+ $Y=0.1475 $X2=0.621 $Y2=0.096
r34 5 38 19.3796 $a=3.24e-16 $layer=V0LISD $X=0.54 $Y=0.0675 $X2=0.54 $Y2=0.036
r35 3 36 19.3796 $a=3.24e-16 $layer=V0LISD $X=0.432 $Y=0.0675 $X2=0.432
+ $Y2=0.036
r36 25 39 7.79507 $w=1.41111e-08 $l=4.05e-08 $layer=M1 $thickness=3.6e-08
+ $X=0.621 $Y=0.036 $X2=0.5805 $Y2=0.036
r37 25 29 12.3423 $w=1.447e-08 $l=6e-08 $layer=M1 $thickness=3.6e-08 $X=0.621
+ $Y=0.036 $X2=0.621 $Y2=0.096
r38 38 39 9.44419 $w=1.3e-08 $l=4.05e-08 $layer=M1 $thickness=3.6e-08 $X=0.54
+ $Y=0.036 $X2=0.5805 $Y2=0.036
r39 37 38 12.5922 $w=1.3e-08 $l=5.4e-08 $layer=M1 $thickness=3.6e-08 $X=0.486
+ $Y=0.036 $X2=0.54 $Y2=0.036
r40 36 37 12.5922 $w=1.3e-08 $l=5.4e-08 $layer=M1 $thickness=3.6e-08 $X=0.432
+ $Y=0.036 $X2=0.486 $Y2=0.036
r41 35 36 12.5922 $w=1.3e-08 $l=5.4e-08 $layer=M1 $thickness=3.6e-08 $X=0.378
+ $Y=0.036 $X2=0.432 $Y2=0.036
r42 34 35 12.5922 $w=1.3e-08 $l=5.4e-08 $layer=M1 $thickness=3.6e-08 $X=0.324
+ $Y=0.036 $X2=0.378 $Y2=0.036
r43 28 34 2.68168 $w=1.3e-08 $l=1.15e-08 $layer=M1 $thickness=3.6e-08 $X=0.3125
+ $Y=0.036 $X2=0.324 $Y2=0.036
r44 1 34 19.3796 $a=3.24e-16 $layer=V0LISD $X=0.324 $Y=0.0675 $X2=0.324
+ $Y2=0.036
r45 33 31 0.0308642 $w=8.1e-08 $l=2.5e-09 $layer=N_src_drn $thickness=1e-09
+ $X=0.3413 $Y=0.0675 $X2=0.3385 $Y2=0.0675
r46 1 31 0.179012 $w=8.1e-08 $l=1.45e-08 $layer=N_src_drn $thickness=1e-09
+ $X=0.324 $Y=0.0675 $X2=0.3385 $Y2=0.0675
r47 19 1 0.179012 $w=8.1e-08 $l=1.45e-08 $layer=N_src_drn $thickness=1e-09
+ $X=0.3095 $Y=0.0675 $X2=0.324 $Y2=0.0675
r48 32 19 0.0308642 $w=8.1e-08 $l=2.5e-09 $layer=N_src_drn $thickness=1e-09
+ $X=0.3066 $Y=0.0675 $X2=0.3095 $Y2=0.0675
.ends

.subckt PM_OR2x6_ASAP7_75t_R%A vss 38 10 14 28 31 1 7 3 8 9 4 6
c1 1 vss 0.00571183f $X=0.1255 $Y=0.108
c2 3 vss 0.0354869f $X=0.135 $Y=0.0245
c3 4 vss 0.0352413f $X=0.189 $Y=0.108
c4 5 vss 0.00445995f $X=0.027 $Y=0.072
c5 6 vss 0.00060534f $X=0.135 $Y=0.0755
c6 7 vss 0.0244469f $X=0.027 $Y=0.0935
c7 8 vss 0.00664932f $X=0.11 $Y=0.072
c8 9 vss 0.00201684f $X=0.135 $Y=0.0935
r1 38 37 3.32295 $w=1.3e-08 $l=1.43e-08 $layer=M1 $thickness=3.6e-08 $X=0.019
+ $Y=0.134 $X2=0.027 $Y2=0.1197
r2 7 37 6.12123 $w=1.3e-08 $l=2.62e-08 $layer=M1 $thickness=3.6e-08 $X=0.027
+ $Y=0.0935 $X2=0.027 $Y2=0.1197
r3 5 36 4.64701 $w=1.46667e-08 $l=2.7e-08 $layer=M1 $thickness=3.6e-08 $X=0.027
+ $Y=0.072 $X2=0.054 $Y2=0.072
r4 5 7 3.36447 $w=1.71023e-08 $l=2.15e-08 $layer=M1 $thickness=3.6e-08 $X=0.027
+ $Y=0.072 $X2=0.027 $Y2=0.0935
r5 35 36 6.29612 $w=1.3e-08 $l=2.7e-08 $layer=M1 $thickness=3.6e-08 $X=0.081
+ $Y=0.072 $X2=0.054 $Y2=0.072
r6 34 35 2.56509 $w=1.3e-08 $l=1.1e-08 $layer=M1 $thickness=3.6e-08 $X=0.092
+ $Y=0.072 $X2=0.081 $Y2=0.072
r7 8 34 4.19742 $w=1.3e-08 $l=1.8e-08 $layer=M1 $thickness=3.6e-08 $X=0.11
+ $Y=0.072 $X2=0.092 $Y2=0.072
r8 6 23 1.37741 $w=1.60556e-08 $l=9e-09 $layer=M1 $thickness=3.6e-08 $X=0.135
+ $Y=0.0755 $X2=0.135 $Y2=0.0845
r9 6 8 4.29228 $w=1.42791e-08 $l=2.52438e-08 $layer=M1 $thickness=3.6e-08
+ $X=0.135 $Y=0.0755 $X2=0.11 $Y2=0.072
r10 31 30 21.0886 $w=2.1e-08 $l=6.2e-08 $layer=Gate_1 $thickness=5.6e-08
+ $X=0.189 $Y=0.2025 $X2=0.189 $Y2=0.1405
r11 28 29 11.9048 $w=2.1e-08 $l=3.5e-08 $layer=Gate_1 $thickness=5.6e-08
+ $X=0.189 $Y=0.054 $X2=0.189 $Y2=0.089
r12 4 20 6.54019 $w=2.09524e-08 $layer=Gate_1 $thickness=5.21905e-08 $X=0.189
+ $Y=0.108 $X2=0.189 $Y2=0.108
r13 4 29 6.6497 $w=2.04211e-08 $l=1.9e-08 $layer=Gate_1 $thickness=5.6e-08
+ $X=0.189 $Y=0.108 $X2=0.189 $Y2=0.089
r14 4 30 11.2416 $w=2.06615e-08 $l=3.25e-08 $layer=Gate_1 $thickness=5.6e-08
+ $X=0.189 $Y=0.108 $X2=0.189 $Y2=0.1405
r15 22 24 2.09871 $w=1.3e-08 $l=9e-09 $layer=M1 $thickness=3.6e-08 $X=0.135
+ $Y=0.1025 $X2=0.135 $Y2=0.1115
r16 9 22 2.09871 $w=1.3e-08 $l=9e-09 $layer=M1 $thickness=3.6e-08 $X=0.135
+ $Y=0.0935 $X2=0.135 $Y2=0.1025
r17 9 23 2.09871 $w=1.3e-08 $l=9e-09 $layer=M1 $thickness=3.6e-08 $X=0.135
+ $Y=0.0935 $X2=0.135 $Y2=0.0845
r18 19 20 12.6539 $w=1.77815e-08 $l=2.7e-08 $layer=LIG $thickness=4.8e-08
+ $X=0.162 $Y=0.108 $X2=0.189 $Y2=0.108
r19 17 19 10.1729 $w=1.54914e-08 $l=1.75e-08 $layer=LIG $thickness=4.8e-08
+ $X=0.1445 $Y=0.108 $X2=0.162 $Y2=0.108
r20 16 17 2.48102 $w=2.2e-08 $l=9.5e-09 $layer=LIG $thickness=4.8e-08 $X=0.135
+ $Y=0.108 $X2=0.1445 $Y2=0.108
r21 16 24 19.3796 $a=3.24e-16 $layer=V0LIG $X=0.135 $Y=0.108 $X2=0.135
+ $Y2=0.1115
r22 1 16 2.48102 $w=2.2e-08 $l=9.5e-09 $layer=LIG $thickness=4.8e-08 $X=0.1255
+ $Y=0.108 $X2=0.135 $Y2=0.108
r23 14 13 21.0886 $w=2.1e-08 $l=6.2e-08 $layer=Gate_1 $thickness=5.6e-08
+ $X=0.135 $Y=0.2025 $X2=0.135 $Y2=0.1405
r24 12 13 11.2416 $w=2.06615e-08 $l=3.25e-08 $layer=Gate_1 $thickness=5.6e-08
+ $X=0.135 $Y=0.108 $X2=0.135 $Y2=0.1405
r25 12 17 4.05918 $w=2.0087e-08 $l=9.5e-09 $layer=Gate_1 $thickness=5.56522e-08
+ $X=0.135 $Y=0.108 $X2=0.1445 $Y2=0.108
r26 12 16 6.27904 $w=2.09e-08 $layer=Gate_1 $thickness=5.24e-08 $X=0.135
+ $Y=0.108 $X2=0.135 $Y2=0.108
r27 11 12 6.6497 $w=2.04211e-08 $l=1.9e-08 $layer=Gate_1 $thickness=5.6e-08
+ $X=0.135 $Y=0.089 $X2=0.135 $Y2=0.108
r28 10 11 11.9048 $w=2.1e-08 $l=3.5e-08 $layer=Gate_1 $thickness=5.6e-08
+ $X=0.135 $Y=0.054 $X2=0.135 $Y2=0.089
r29 10 3 10.0341 $w=2.1e-08 $l=2.95e-08 $layer=Gate_1 $thickness=5.6e-08
+ $X=0.135 $Y=0.054 $X2=0.135 $Y2=0.0245
.ends

.subckt PM_OR2x6_ASAP7_75t_R%B vss 29 12 18 36 39 11 1 9 10 5 7 6 8 2
c1 1 vss 0.00609666f $X=0.081 $Y=0.135
c2 2 vss 0.00647867f $X=0.243 $Y=0.135
c3 5 vss 0.0797685f $X=0.081 $Y=0.0245
c4 6 vss 0.0956969f $X=0.243 $Y=0.135
c5 7 vss 0.00163799f $X=0.081 $Y=0.162
c6 8 vss 0.00226027f $X=0.243 $Y=0.162
c7 9 vss 0.00185191f $X=0.081 $Y=0.114
c8 10 vss 0.00602912f $X=0.081 $Y=0.18
c9 11 vss 0.00289959f $X=0.108 $Y=0.162
r1 39 38 16.4967 $w=2.1e-08 $l=4.85e-08 $layer=Gate_1 $thickness=5.6e-08
+ $X=0.243 $Y=0.2025 $X2=0.243 $Y2=0.154
r2 36 37 16.4967 $w=2.1e-08 $l=4.85e-08 $layer=Gate_1 $thickness=5.6e-08
+ $X=0.243 $Y=0.054 $X2=0.243 $Y2=0.1025
r3 6 37 11.2416 $w=2.06615e-08 $l=3.25e-08 $layer=Gate_1 $thickness=5.6e-08
+ $X=0.243 $Y=0.135 $X2=0.243 $Y2=0.1025
r4 6 38 6.6497 $w=2.04211e-08 $l=1.9e-08 $layer=Gate_1 $thickness=5.6e-08
+ $X=0.243 $Y=0.135 $X2=0.243 $Y2=0.154
r5 2 32 19.3796 $a=3.24e-16 $layer=V0LIG $X=0.243 $Y=0.135 $X2=0.243 $Y2=0.135
r6 2 6 10.4265 $w=1.765e-08 $layer=LIG $thickness=5.2e-08 $X=0.243 $Y=0.135
+ $X2=0.243 $Y2=0.135
r7 32 33 3.14806 $w=1.3e-08 $l=1.35e-08 $layer=M1 $thickness=3.6e-08 $X=0.243
+ $Y=0.135 $X2=0.243 $Y2=0.1485
r8 8 30 8.08899 $w=1.41321e-08 $l=3.98e-08 $layer=M1 $thickness=3.6e-08
+ $X=0.243 $Y=0.162 $X2=0.2032 $Y2=0.162
r9 8 33 1.96775 $w=1.63333e-08 $l=1.35e-08 $layer=M1 $thickness=3.6e-08
+ $X=0.243 $Y=0.162 $X2=0.243 $Y2=0.1485
r10 29 30 7.28718 $w=1.3e-08 $l=3.12e-08 $layer=M1 $thickness=3.6e-08 $X=0.172
+ $Y=0.163 $X2=0.2032 $Y2=0.162
r11 29 28 2.85657 $w=1.3e-08 $l=1.23e-08 $layer=M1 $thickness=3.6e-08 $X=0.172
+ $Y=0.163 $X2=0.1597 $Y2=0.162
r12 27 28 3.20636 $w=1.3e-08 $l=1.37e-08 $layer=M1 $thickness=3.6e-08 $X=0.146
+ $Y=0.162 $X2=0.1597 $Y2=0.162
r13 26 27 2.56509 $w=1.3e-08 $l=1.1e-08 $layer=M1 $thickness=3.6e-08 $X=0.135
+ $Y=0.162 $X2=0.146 $Y2=0.162
r14 11 26 6.29612 $w=1.3e-08 $l=2.7e-08 $layer=M1 $thickness=3.6e-08 $X=0.108
+ $Y=0.162 $X2=0.135 $Y2=0.162
r15 7 22 1.96775 $w=1.63333e-08 $l=1.35e-08 $layer=M1 $thickness=3.6e-08
+ $X=0.081 $Y=0.162 $X2=0.081 $Y2=0.1485
r16 7 10 3.01711 $w=1.55e-08 $l=1.8e-08 $layer=M1 $thickness=3.6e-08 $X=0.081
+ $Y=0.162 $X2=0.081 $Y2=0.18
r17 7 11 5.11582 $w=1.46667e-08 $l=2.7e-08 $layer=M1 $thickness=3.6e-08
+ $X=0.081 $Y=0.162 $X2=0.108 $Y2=0.162
r18 21 22 3.14806 $w=1.3e-08 $l=1.35e-08 $layer=M1 $thickness=3.6e-08 $X=0.081
+ $Y=0.135 $X2=0.081 $Y2=0.1485
r19 20 21 2.56509 $w=1.3e-08 $l=1.1e-08 $layer=M1 $thickness=3.6e-08 $X=0.081
+ $Y=0.124 $X2=0.081 $Y2=0.135
r20 9 20 2.3319 $w=1.3e-08 $l=1e-08 $layer=M1 $thickness=3.6e-08 $X=0.081
+ $Y=0.114 $X2=0.081 $Y2=0.124
r21 1 15 10.4265 $w=1.765e-08 $layer=LIG $thickness=5.2e-08 $X=0.081 $Y=0.135
+ $X2=0.081 $Y2=0.135
r22 1 21 19.3796 $a=3.24e-16 $layer=V0LIG $X=0.081 $Y=0.135 $X2=0.081 $Y2=0.135
r23 18 17 14.6259 $w=2.1e-08 $l=4.3e-08 $layer=Gate_1 $thickness=5.6e-08
+ $X=0.081 $Y=0.2025 $X2=0.081 $Y2=0.1595
r24 16 17 2.7211 $w=2.1e-08 $l=8e-09 $layer=Gate_1 $thickness=5.6e-08 $X=0.081
+ $Y=0.1515 $X2=0.081 $Y2=0.1595
r25 15 16 5.79936 $w=2.03333e-08 $l=1.65e-08 $layer=Gate_1 $thickness=5.6e-08
+ $X=0.081 $Y=0.135 $X2=0.081 $Y2=0.1515
r26 14 15 5.79936 $w=2.03333e-08 $l=1.65e-08 $layer=Gate_1 $thickness=5.6e-08
+ $X=0.081 $Y=0.1185 $X2=0.081 $Y2=0.135
r27 13 14 7.31297 $w=2.1e-08 $l=2.15e-08 $layer=Gate_1 $thickness=5.6e-08
+ $X=0.081 $Y=0.097 $X2=0.081 $Y2=0.1185
r28 12 13 14.6259 $w=2.1e-08 $l=4.3e-08 $layer=Gate_1 $thickness=5.6e-08
+ $X=0.081 $Y=0.054 $X2=0.081 $Y2=0.097
r29 12 5 10.0341 $w=2.1e-08 $l=2.95e-08 $layer=Gate_1 $thickness=5.6e-08
+ $X=0.081 $Y=0.054 $X2=0.081 $Y2=0.0245
.ends

* End of included file OR2x6_ASAP7_75t_R.pex.sp.pex

*
.subckt OR2x6_ASAP7_75t_CUSTOM_4_25_0_7 VSS VDD B A Y
*
* VSS VSS
* VDD VDD
* B B
* A A
* Y Y
*
*

M0 N_M0_d N_M0_g VSS VSS nmos_rvt L=2e-08 W=5.4e-08 nfin=2 $X=0.071 $Y=0.027
M1 VSS N_M1_g N_M1_s VSS nmos_rvt L=2e-08 W=5.4e-08 nfin=2 $X=0.125 $Y=0.027
M2 VSS N_M2_g N_M2_s VSS nmos_rvt L=2e-08 W=5.4e-08 nfin=2 $X=0.179 $Y=0.027
M3 N_M3_d N_M3_g VSS VSS nmos_rvt L=2e-08 W=5.4e-08 nfin=2 $X=0.233 $Y=0.027
M4 N_M4_d N_M4_g VSS VSS nmos_rvt L=2e-08 W=8.1e-08 nfin=3 $X=0.287 $Y=0.027
M5 N_M5_d N_M5_g VSS VSS nmos_rvt L=2e-08 W=8.1e-08 nfin=3 $X=0.341 $Y=0.027
M6 N_M6_d N_M6_g VSS VSS nmos_rvt L=2e-08 W=8.1e-08 nfin=3 $X=0.395 $Y=0.027
M7 N_M7_d N_M7_g VSS VSS nmos_rvt L=2e-08 W=8.1e-08 nfin=3 $X=0.449 $Y=0.027
M8 N_M8_d N_M8_g VSS VSS nmos_rvt L=2e-08 W=8.1e-08 nfin=3 $X=0.503 $Y=0.027
M9 N_M9_d N_M9_g VSS VSS nmos_rvt L=2e-08 W=8.1e-08 nfin=3 $X=0.557 $Y=0.027
M10 VDD N_M10_g N_M10_s VDD pmos_rvt L=2e-08 W=8.1e-08 nfin=3 $X=0.071 $Y=0.162
M11 N_M11_d N_M11_g N_M11_s VDD pmos_rvt L=2e-08 W=8.1e-08 nfin=3 $X=0.125
+ $Y=0.162
M12 N_M12_d N_M12_g N_M12_s VDD pmos_rvt L=2e-08 W=8.1e-08 nfin=3 $X=0.179
+ $Y=0.162
M13 VDD N_M13_g N_M13_s VDD pmos_rvt L=2e-08 W=8.1e-08 nfin=3 $X=0.233 $Y=0.162
M14 N_M14_d N_M14_g VDD VDD pmos_rvt L=2e-08 W=8.1e-08 nfin=3 $X=0.287 $Y=0.162
M15 N_M15_d N_M15_g VDD VDD pmos_rvt L=2e-08 W=8.1e-08 nfin=3 $X=0.341 $Y=0.162
M16 N_M16_d N_M16_g VDD VDD pmos_rvt L=2e-08 W=8.1e-08 nfin=3 $X=0.395 $Y=0.162
M17 N_M17_d N_M17_g VDD VDD pmos_rvt L=2e-08 W=8.1e-08 nfin=3 $X=0.449 $Y=0.162
M18 N_M18_d N_M18_g VDD VDD pmos_rvt L=2e-08 W=8.1e-08 nfin=3 $X=0.503 $Y=0.162
M19 N_M19_d N_M19_g VDD VDD pmos_rvt L=2e-08 W=8.1e-08 nfin=3 $X=0.557 $Y=0.162

* .include "OR2x6_ASAP7_75t_R.pex.sp.pxi"

* Start of included file OR2x6_ASAP7_75t_R.pex.sp.pxi
x_PM_OR2x6_ASAP7_75t_R%7__2 vss N_M10_s N_M11_d N_7__2_1
+ PM_OR2x6_ASAP7_75t_R%7__2
cc_1 N_7__2_1 N_B_5 0.0168084f $X=0.108 $Y=0.2025
cc_2 N_7__2_1 N_A_3 0.0168033f $X=0.108 $Y=0.2025
x_PM_OR2x6_ASAP7_75t_R%8 vss N_M12_d N_M13_s N_8_1 PM_OR2x6_ASAP7_75t_R%8
cc_3 N_8_1 N_B_6 0.0168673f $X=0.216 $Y=0.2025
cc_4 N_8_1 N_A_4 0.0168587f $X=0.216 $Y=0.2025
x_PM_OR2x6_ASAP7_75t_R%5 vss N_M4_g N_M14_g N_M5_g N_M15_g N_M6_g N_M16_g
+ N_M7_g N_M17_g N_M8_g N_M18_g N_M9_g N_M19_g N_M11_s N_M12_s N_M2_s N_M3_d
+ N_M0_d N_M1_s N_5_25 N_5_20 N_5_19 N_5_18 N_5_28 N_5_3 N_5_5 N_5_26 N_5_1
+ N_5_22 N_5_4 N_5_29 N_5_12 N_5_21 N_5_24 N_5_23 N_5_14 N_5_17 N_5_16 N_5_15
+ N_5_13 PM_OR2x6_ASAP7_75t_R%5
cc_5 N_5_25 N_B_5 0.000268235f $X=0.1755 $Y=0.036
cc_6 N_5_20 N_B_5 0.000291539f $X=0.1475 $Y=0.2025
cc_7 N_5_19 N_B_5 0.000328726f $X=0.2015 $Y=0.054
cc_8 N_5_18 N_B_1 0.000343341f $X=0.0935 $Y=0.054
cc_9 N_5_28 N_B_8 0.000344648f $X=0.27 $Y=0.079
cc_10 N_5_3 N_B_5 0.000379779f $X=0.108 $Y=0.054
cc_11 N_5_5 N_B_6 0.000402977f $X=0.216 $Y=0.054
cc_12 N_5_26 N_B_10 0.000466105f $X=0.27 $Y=0.198
cc_13 N_5_1 N_B_6 0.00052494f $X=0.2875 $Y=0.135
cc_14 N_5_22 N_B_8 0.000567002f $X=0.243 $Y=0.0755
cc_15 N_5_4 N_B_11 0.00197185f $X=0.162 $Y=0.2025
cc_16 N_5_1 N_B_2 0.00239814f $X=0.2875 $Y=0.135
cc_17 N_5_26 N_B_8 0.00140946f $X=0.27 $Y=0.198
cc_18 N_5_29 N_B_8 0.00266266f $X=0.297 $Y=0.1045
cc_19 N_5_19 N_B_6 0.0105797f $X=0.2015 $Y=0.054
cc_20 N_5_26 N_B_11 0.0093139f $X=0.27 $Y=0.198
cc_21 N_5_12 N_B_6 0.017372f $X=0.297 $Y=0.0245
cc_22 N_5_18 N_B_5 0.0257734f $X=0.0935 $Y=0.054
cc_23 N_5_4 N_A_4 0.000235927f $X=0.162 $Y=0.2025
cc_24 N_5_26 N_A_4 0.000337009f $X=0.27 $Y=0.198
cc_25 N_5_19 N_A_4 0.0110729f $X=0.2015 $Y=0.054
cc_26 N_5_18 N_A_3 0.0110211f $X=0.0935 $Y=0.054
cc_27 N_5_3 N_A_1 0.000487481f $X=0.108 $Y=0.054
cc_28 N_5_25 N_A_9 0.000556262f $X=0.1755 $Y=0.036
cc_29 N_5_3 N_A_8 0.000579928f $X=0.108 $Y=0.054
cc_30 N_5_5 N_A_4 0.000708635f $X=0.216 $Y=0.054
cc_31 N_5_20 N_A_3 0.034839f $X=0.1475 $Y=0.2025
cc_32 N_5_3 N_A_3 0.00129258f $X=0.108 $Y=0.054
cc_33 N_5_4 N_A_3 0.00139584f $X=0.162 $Y=0.2025
cc_34 N_5_25 N_A_8 0.00211805f $X=0.1755 $Y=0.036
cc_35 N_5_18 N_A_1 0.00264593f $X=0.0935 $Y=0.054
cc_36 N_5_25 N_A_6 0.00409081f $X=0.1755 $Y=0.036
cc_37 N_5_20 N_A_4 0.0644378f $X=0.1475 $Y=0.2025
x_PM_OR2x6_ASAP7_75t_R%Y vss Y N_M4_d N_M5_d N_M6_d N_M7_d N_M8_d N_M9_d
+ N_M14_d N_M15_d N_M16_d N_M17_d N_M18_d N_M19_d N_Y_19 N_Y_28 N_Y_23 N_Y_24
+ N_Y_21 N_Y_27 N_Y_2 N_Y_5 N_Y_6 N_Y_3 N_Y_4 N_Y_1 N_Y_22 N_Y_20
+ PM_OR2x6_ASAP7_75t_R%Y
cc_38 N_Y_19 N_5_21 0.000123477f $X=0.3095 $Y=0.0675
cc_39 N_Y_19 N_5_24 0.000278935f $X=0.3095 $Y=0.0675
cc_40 N_Y_19 N_5_28 0.000287983f $X=0.3095 $Y=0.0675
cc_41 N_Y_19 N_5_1 0.000957059f $X=0.3095 $Y=0.0675
cc_42 N_Y_19 N_5_23 0.000373437f $X=0.3095 $Y=0.0675
cc_43 N_Y_19 N_5_26 0.000771235f $X=0.3095 $Y=0.0675
cc_44 N_Y_19 N_5_12 0.0567796f $X=0.3095 $Y=0.0675
cc_45 N_Y_19 N_5_14 0.000819783f $X=0.3095 $Y=0.0675
cc_46 N_Y_28 N_5_23 0.000819814f $X=0.3125 $Y=0.036
cc_47 N_Y_23 N_5_14 0.0109718f $X=0.4175 $Y=0.2025
cc_48 N_Y_24 N_5_17 0.0110774f $X=0.5255 $Y=0.2025
cc_49 N_Y_21 N_5_16 0.0290557f $X=0.5255 $Y=0.0675
cc_50 N_Y_27 N_5_24 0.00129008f $X=0.3125 $Y=0.234
cc_51 N_Y_2 N_5_29 0.00138295f $X=0.324 $Y=0.2025
cc_52 N_Y_5 N_5_17 0.00153715f $X=0.54 $Y=0.0675
cc_53 N_Y_6 N_5_17 0.00153715f $X=0.54 $Y=0.2025
cc_54 N_Y_3 N_5_15 0.0016887f $X=0.432 $Y=0.0675
cc_55 N_Y_4 N_5_14 0.00169045f $X=0.432 $Y=0.2025
cc_56 N_Y_28 N_5_15 0.00173443f $X=0.3125 $Y=0.036
cc_57 N_Y_2 N_5_12 0.00210559f $X=0.324 $Y=0.2025
cc_58 N_Y_1 N_5_12 0.00211738f $X=0.324 $Y=0.0675
cc_59 N_Y_27 N_5_15 0.00227963f $X=0.3125 $Y=0.234
cc_60 N_Y_22 N_5_13 0.0101308f $X=0.3095 $Y=0.2025
cc_61 N_Y_23 N_5_1 0.0137492f $X=0.4175 $Y=0.2025
cc_62 N_Y_20 N_5_14 0.0542395f $X=0.4175 $Y=0.0675
cc_63 N_Y_23 N_5_15 0.0180376f $X=0.4175 $Y=0.2025
cc_64 N_Y_22 N_5_12 0.0180506f $X=0.3095 $Y=0.2025
cc_65 N_Y_24 N_5_16 0.0544266f $X=0.5255 $Y=0.2025
cc_66 N_Y_21 N_5_17 0.0361421f $X=0.5255 $Y=0.0675
cc_67 N_Y_20 N_5_15 0.0462836f $X=0.4175 $Y=0.0675
cc_68 N_Y_19 N_5_13 0.0470368f $X=0.3095 $Y=0.0675
x_PM_OR2x6_ASAP7_75t_R%A vss A N_M1_g N_M11_g N_M2_g N_M12_g N_A_1 N_A_7 N_A_3
+ N_A_8 N_A_9 N_A_4 N_A_6 PM_OR2x6_ASAP7_75t_R%A
cc_69 N_A_1 N_B_11 0.000646962f $X=0.1255 $Y=0.108
cc_70 N_A_7 N_B_1 0.000678403f $X=0.027 $Y=0.0935
cc_71 N_A_3 N_B_1 0.000978507f $X=0.135 $Y=0.0245
cc_72 N_A_8 N_B_9 0.00117644f $X=0.11 $Y=0.072
cc_73 N_A_7 N_B_10 0.00126682f $X=0.027 $Y=0.0935
cc_74 N_A_9 N_B_9 0.00139909f $X=0.135 $Y=0.0935
cc_75 N_A_9 N_B_11 0.00183301f $X=0.135 $Y=0.0935
cc_76 N_A_1 N_B_5 0.00186952f $X=0.1255 $Y=0.108
cc_77 N_A_7 N_B_9 0.00224051f $X=0.027 $Y=0.0935
cc_78 N_A_7 N_B_7 0.00335501f $X=0.027 $Y=0.0935
cc_79 N_A_4 N_B_6 0.00708267f $X=0.189 $Y=0.108
cc_80 N_A_3 N_B_5 0.00843977f $X=0.135 $Y=0.0245
x_PM_OR2x6_ASAP7_75t_R%B vss B N_M0_g N_M10_g N_M3_g N_M13_g N_B_11 N_B_1 N_B_9
+ N_B_10 N_B_5 N_B_7 N_B_6 N_B_8 N_B_2 PM_OR2x6_ASAP7_75t_R%B

* End of included file OR2x6_ASAP7_75t_R.pex.sp.pxi
.ends

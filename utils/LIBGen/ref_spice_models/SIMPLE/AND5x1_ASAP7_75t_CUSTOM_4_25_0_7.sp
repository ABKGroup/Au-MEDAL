.subckt PM_AND5x1_ASAP7_75t_R%10 vss 2 3 1
c1 1 vss 0.000714227f $X=0.108 $Y=0.0675
r1 2 1 0.209877 $w=8.1e-08 $l=1.7e-08 $layer=N_src_drn $thickness=1e-09
+ $X=0.0906 $Y=0.0675 $X2=0.108 $Y2=0.0675
r2 3 1 0.209877 $w=8.1e-08 $l=1.7e-08 $layer=N_src_drn $thickness=1e-09
+ $X=0.1253 $Y=0.0675 $X2=0.108 $Y2=0.0675
.ends

.subckt PM_AND5x1_ASAP7_75t_R%12 vss 2 3 1
c1 1 vss 0.000704578f $X=0.216 $Y=0.0675
r1 2 1 0.209877 $w=8.1e-08 $l=1.7e-08 $layer=N_src_drn $thickness=1e-09
+ $X=0.1986 $Y=0.0675 $X2=0.216 $Y2=0.0675
r2 3 1 0.209877 $w=8.1e-08 $l=1.7e-08 $layer=N_src_drn $thickness=1e-09
+ $X=0.2333 $Y=0.0675 $X2=0.216 $Y2=0.0675
.ends

.subckt PM_AND5x1_ASAP7_75t_R%13 vss 2 3 1
c1 1 vss 0.000755716f $X=0.27 $Y=0.0675
r1 2 1 0.209877 $w=8.1e-08 $l=1.7e-08 $layer=N_src_drn $thickness=1e-09
+ $X=0.2526 $Y=0.0675 $X2=0.27 $Y2=0.0675
r2 3 1 0.209877 $w=8.1e-08 $l=1.7e-08 $layer=N_src_drn $thickness=1e-09
+ $X=0.2873 $Y=0.0675 $X2=0.27 $Y2=0.0675
.ends

.subckt PM_AND5x1_ASAP7_75t_R%A vss 15 5 11 3 4 1
c1 1 vss 0.0019031f $X=0.081 $Y=0.134
c2 3 vss 0.042023f $X=0.081 $Y=0.0245
c3 4 vss 0.0100597f $X=0.081 $Y=0.0975
r1 15 4 8.51143 $w=1.3e-08 $l=3.65e-08 $layer=M1 $thickness=3.6e-08 $X=0.081
+ $Y=0.135 $X2=0.081 $Y2=0.0975
r2 1 8 6.74717 $w=2e-08 $layer=Gate_1 $thickness=5.2e-08 $X=0.081 $Y=0.134
+ $X2=0.081 $Y2=0.134
r3 15 1 19.3796 $a=3.24e-16 $layer=V0LIG $X=0.081 $Y=0.135 $X2=0.081 $Y2=0.134
r4 11 10 14.6259 $w=2.1e-08 $l=4.3e-08 $layer=Gate_1 $thickness=5.6e-08
+ $X=0.081 $Y=0.216 $X2=0.081 $Y2=0.173
r5 9 10 7.65311 $w=2.1e-08 $l=2.25e-08 $layer=Gate_1 $thickness=5.6e-08
+ $X=0.081 $Y=0.1505 $X2=0.081 $Y2=0.173
r6 8 9 5.78235 $w=2.03939e-08 $l=1.65e-08 $layer=Gate_1 $thickness=5.6e-08
+ $X=0.081 $Y=0.134 $X2=0.081 $Y2=0.1505
r7 7 8 5.44221 $w=2.03548e-08 $l=1.55e-08 $layer=Gate_1 $thickness=5.6e-08
+ $X=0.081 $Y=0.1185 $X2=0.081 $Y2=0.134
r8 6 7 2.7211 $w=2.1e-08 $l=8e-09 $layer=Gate_1 $thickness=5.6e-08 $X=0.081
+ $Y=0.1105 $X2=0.081 $Y2=0.1185
r9 5 6 14.6259 $w=2.1e-08 $l=4.3e-08 $layer=Gate_1 $thickness=5.6e-08 $X=0.081
+ $Y=0.0675 $X2=0.081 $Y2=0.1105
r10 5 3 14.6259 $w=2.1e-08 $l=4.3e-08 $layer=Gate_1 $thickness=5.6e-08 $X=0.081
+ $Y=0.0675 $X2=0.081 $Y2=0.0245
.ends

.subckt PM_AND5x1_ASAP7_75t_R%C vss 13 5 9 1 4 3
c1 1 vss 0.00152053f $X=0.189 $Y=0.1345
c2 3 vss 0.0384916f $X=0.189 $Y=0.0245
c3 4 vss 0.0118982f $X=0.189 $Y=0.0795
r1 13 4 12.7088 $w=1.3e-08 $l=5.45e-08 $layer=M1 $thickness=3.6e-08 $X=0.189
+ $Y=0.135 $X2=0.189 $Y2=0.0795
r2 1 7 6.8952 $w=1.94872e-08 $layer=LIG $thickness=5.18974e-08 $X=0.189
+ $Y=0.1345 $X2=0.189 $Y2=0.1345
r3 13 1 19.3796 $a=3.24e-16 $layer=V0LIG $X=0.189 $Y=0.135 $X2=0.189 $Y2=0.1345
r4 9 8 16.8368 $w=2.1e-08 $l=4.95e-08 $layer=Gate_1 $thickness=5.6e-08 $X=0.189
+ $Y=0.216 $X2=0.189 $Y2=0.1665
r5 7 8 11.046 $w=2.07031e-08 $l=3.2e-08 $layer=Gate_1 $thickness=5.6e-08
+ $X=0.189 $Y=0.1345 $X2=0.189 $Y2=0.1665
r6 6 7 6.28405 $w=2.04722e-08 $l=1.8e-08 $layer=Gate_1 $thickness=5.6e-08
+ $X=0.189 $Y=0.1165 $X2=0.189 $Y2=0.1345
r7 5 6 16.6668 $w=2.1e-08 $l=4.9e-08 $layer=Gate_1 $thickness=5.6e-08 $X=0.189
+ $Y=0.0675 $X2=0.189 $Y2=0.1165
r8 5 3 14.6259 $w=2.1e-08 $l=4.3e-08 $layer=Gate_1 $thickness=5.6e-08 $X=0.189
+ $Y=0.0675 $X2=0.189 $Y2=0.0245
.ends

.subckt PM_AND5x1_ASAP7_75t_R%D vss 13 5 9 1 4 3
c1 1 vss 0.00155671f $X=0.243 $Y=0.1345
c2 3 vss 0.0387647f $X=0.243 $Y=0.0245
c3 4 vss 0.0126304f $X=0.243 $Y=0.0795
r1 13 4 12.7088 $w=1.3e-08 $l=5.45e-08 $layer=M1 $thickness=3.6e-08 $X=0.243
+ $Y=0.135 $X2=0.243 $Y2=0.0795
r2 1 7 6.8952 $w=1.94872e-08 $layer=LIG $thickness=5.18974e-08 $X=0.243
+ $Y=0.1345 $X2=0.243 $Y2=0.1345
r3 13 1 19.3796 $a=3.24e-16 $layer=V0LIG $X=0.243 $Y=0.135 $X2=0.243 $Y2=0.1345
r4 9 8 16.8368 $w=2.1e-08 $l=4.95e-08 $layer=Gate_1 $thickness=5.6e-08 $X=0.243
+ $Y=0.216 $X2=0.243 $Y2=0.1665
r5 7 8 11.046 $w=2.07031e-08 $l=3.2e-08 $layer=Gate_1 $thickness=5.6e-08
+ $X=0.243 $Y=0.1345 $X2=0.243 $Y2=0.1665
r6 6 7 6.28405 $w=2.04722e-08 $l=1.8e-08 $layer=Gate_1 $thickness=5.6e-08
+ $X=0.243 $Y=0.1165 $X2=0.243 $Y2=0.1345
r7 5 6 16.6668 $w=2.1e-08 $l=4.9e-08 $layer=Gate_1 $thickness=5.6e-08 $X=0.243
+ $Y=0.0675 $X2=0.243 $Y2=0.1165
r8 5 3 14.6259 $w=2.1e-08 $l=4.3e-08 $layer=Gate_1 $thickness=5.6e-08 $X=0.243
+ $Y=0.0675 $X2=0.243 $Y2=0.0245
.ends

.subckt PM_AND5x1_ASAP7_75t_R%E vss 15 5 9 3 4 1
c1 1 vss 0.00775914f $X=0.297 $Y=0.1345
c2 3 vss 0.0988665f $X=0.297 $Y=0.0245
c3 4 vss 0.00971179f $X=0.297 $Y=0.0805
r1 15 14 3.14806 $w=1.3e-08 $l=1.35e-08 $layer=M1 $thickness=3.6e-08 $X=0.297
+ $Y=0.135 $X2=0.297 $Y2=0.1205
r2 4 14 9.32759 $w=1.3e-08 $l=4e-08 $layer=M1 $thickness=3.6e-08 $X=0.297
+ $Y=0.0805 $X2=0.297 $Y2=0.1205
r3 1 7 6.8952 $w=1.94872e-08 $layer=LIG $thickness=5.18974e-08 $X=0.297
+ $Y=0.1345 $X2=0.297 $Y2=0.1345
r4 15 1 19.3796 $a=3.24e-16 $layer=V0LIG $X=0.297 $Y=0.135 $X2=0.297 $Y2=0.1345
r5 9 8 16.8368 $w=2.1e-08 $l=4.95e-08 $layer=Gate_1 $thickness=5.6e-08 $X=0.297
+ $Y=0.216 $X2=0.297 $Y2=0.1665
r6 7 8 11.046 $w=2.07031e-08 $l=3.2e-08 $layer=Gate_1 $thickness=5.6e-08
+ $X=0.297 $Y=0.1345 $X2=0.297 $Y2=0.1665
r7 6 7 6.28405 $w=2.04722e-08 $l=1.8e-08 $layer=Gate_1 $thickness=5.6e-08
+ $X=0.297 $Y=0.1165 $X2=0.297 $Y2=0.1345
r8 5 6 16.6668 $w=2.1e-08 $l=4.9e-08 $layer=Gate_1 $thickness=5.6e-08 $X=0.297
+ $Y=0.0675 $X2=0.297 $Y2=0.1165
r9 5 3 14.6259 $w=2.1e-08 $l=4.3e-08 $layer=Gate_1 $thickness=5.6e-08 $X=0.297
+ $Y=0.0675 $X2=0.297 $Y2=0.0245
.ends

.subckt PM_AND5x1_ASAP7_75t_R%Y vss 20 15 27 7 11 13 8
c1 1 vss 0.00869343f $X=0.378 $Y=0.0675
c2 2 vss 0.00819578f $X=0.378 $Y=0.2025
c3 7 vss 0.0382719f $X=0.3635 $Y=0.0675
c4 8 vss 0.0382812f $X=0.3635 $Y=0.2025
c5 9 vss 0.00277623f $X=0.405 $Y=0.036
c6 10 vss 0.00276172f $X=0.405 $Y=0.234
c7 11 vss 0.00443948f $X=0.3645 $Y=0.234
c8 12 vss 0.00618229f $X=0.3645 $Y=0.036
c9 13 vss 0.00533685f $X=0.405 $Y=0.0805
r1 8 2 0.154321 $w=8.1e-08 $l=1.25e-08 $layer=P_src_drn $thickness=1e-09
+ $X=0.3635 $Y=0.2025 $X2=0.378 $Y2=0.2025
r2 27 8 0.0308642 $w=8.1e-08 $l=2.5e-09 $layer=P_src_drn $thickness=1e-09
+ $X=0.3606 $Y=0.2025 $X2=0.3635 $Y2=0.2025
r3 2 23 19.3796 $a=3.24e-16 $layer=V0LISD $X=0.378 $Y=0.2025 $X2=0.378 $Y2=0.234
r4 23 24 3.14806 $w=1.3e-08 $l=1.35e-08 $layer=M1 $thickness=3.6e-08 $X=0.378
+ $Y=0.234 $X2=0.3915 $Y2=0.234
r5 11 23 3.14806 $w=1.3e-08 $l=1.35e-08 $layer=M1 $thickness=3.6e-08 $X=0.3645
+ $Y=0.234 $X2=0.378 $Y2=0.234
r6 10 22 2.5483 $w=1.79e-08 $l=1.8e-08 $layer=M1 $thickness=3.6e-08 $X=0.405
+ $Y=0.234 $X2=0.405 $Y2=0.216
r7 10 24 1.49895 $w=1.63333e-08 $l=1.35e-08 $layer=M1 $thickness=3.6e-08
+ $X=0.405 $Y=0.234 $X2=0.3915 $Y2=0.234
r8 21 22 11.1348 $w=1.3e-08 $l=4.78e-08 $layer=M1 $thickness=3.6e-08 $X=0.405
+ $Y=0.1682 $X2=0.405 $Y2=0.216
r9 20 21 9.1527 $w=1.3e-08 $l=3.92e-08 $layer=M1 $thickness=3.6e-08 $X=0.409
+ $Y=0.129 $X2=0.405 $Y2=0.1682
r10 20 19 1.57403 $w=1.3e-08 $l=6.8e-09 $layer=M1 $thickness=3.6e-08 $X=0.409
+ $Y=0.129 $X2=0.405 $Y2=0.1222
r11 13 19 9.73567 $w=1.3e-08 $l=4.17e-08 $layer=M1 $thickness=3.6e-08 $X=0.405
+ $Y=0.0805 $X2=0.405 $Y2=0.1222
r12 9 17 1.49895 $w=1.63333e-08 $l=1.35e-08 $layer=M1 $thickness=3.6e-08
+ $X=0.405 $Y=0.036 $X2=0.3915 $Y2=0.036
r13 9 13 8.72783 $w=1.4982e-08 $l=4.45e-08 $layer=M1 $thickness=3.6e-08
+ $X=0.405 $Y=0.036 $X2=0.405 $Y2=0.0805
r14 16 17 3.14806 $w=1.3e-08 $l=1.35e-08 $layer=M1 $thickness=3.6e-08 $X=0.378
+ $Y=0.036 $X2=0.3915 $Y2=0.036
r15 12 16 3.14806 $w=1.3e-08 $l=1.35e-08 $layer=M1 $thickness=3.6e-08 $X=0.3645
+ $Y=0.036 $X2=0.378 $Y2=0.036
r16 1 16 19.3796 $a=3.24e-16 $layer=V0LISD $X=0.378 $Y=0.0675 $X2=0.378
+ $Y2=0.036
r17 7 1 0.154321 $w=8.1e-08 $l=1.25e-08 $layer=N_src_drn $thickness=1e-09
+ $X=0.3635 $Y=0.0675 $X2=0.378 $Y2=0.0675
r18 15 7 0.0308642 $w=8.1e-08 $l=2.5e-09 $layer=N_src_drn $thickness=1e-09
+ $X=0.3606 $Y=0.0675 $X2=0.3635 $Y2=0.0675
.ends

.subckt PM_AND5x1_ASAP7_75t_R%8 vss 30 36 61 62 65 66 70 75 20 4 3 26 16 17 25
+ 18 5 6 22 19 1 29 15 24 23 28
c1 1 vss 0.00359734f $X=0.351 $Y=0.1345
c2 3 vss 0.00656291f $X=0.054 $Y=0.0675
c3 4 vss 0.00728807f $X=0.054 $Y=0.216
c4 5 vss 0.00729455f $X=0.162 $Y=0.216
c5 6 vss 0.00745541f $X=0.27 $Y=0.216
c6 15 vss 0.0988863f $X=0.351 $Y=0.0245
c7 16 vss 0.0381583f $X=0.056 $Y=0.0675
c8 17 vss 0.0288699f $X=0.056 $Y=0.216
c9 18 vss 0.0042423f $X=0.1475 $Y=0.216
c10 19 vss 0.0044601f $X=0.2555 $Y=0.216
c11 20 vss 0.00622859f $X=0.027 $Y=0.036
c12 21 vss 0.00287721f $X=0.027 $Y=0.234
c13 22 vss 0.000493568f $X=0.297 $Y=0.1945
c14 23 vss 0.00272411f $X=0.297 $Y=0.234
c15 24 vss 0.000768715f $X=0.351 $Y=0.198
c16 25 vss 0.00599166f $X=0.027 $Y=0.2125
c17 26 vss 0.0214937f $X=0.2565 $Y=0.234
c18 27 vss 0.000485183f $X=0.297 $Y=0.216
c19 28 vss 0.00136954f $X=0.324 $Y=0.198
c20 29 vss 0.00150554f $X=0.351 $Y=0.1205
r1 75 74 0.0308642 $w=8.1e-08 $l=2.5e-09 $layer=N_src_drn $thickness=1e-09
+ $X=0.0713 $Y=0.0675 $X2=0.0685 $Y2=0.0675
r2 16 74 0.154321 $w=8.1e-08 $l=1.25e-08 $layer=N_src_drn $thickness=1e-09
+ $X=0.056 $Y=0.0675 $X2=0.0685 $Y2=0.0675
r3 3 72 19.3796 $a=3.24e-16 $layer=V0LISD $X=0.054 $Y=0.0675 $X2=0.054 $Y2=0.036
r4 71 72 3.14806 $w=1.3e-08 $l=1.35e-08 $layer=M1 $thickness=3.6e-08 $X=0.0405
+ $Y=0.036 $X2=0.054 $Y2=0.036
r5 20 68 3.83327 $w=1.5093e-08 $l=2.15e-08 $layer=M1 $thickness=3.6e-08
+ $X=0.027 $Y=0.036 $X2=0.027 $Y2=0.0575
r6 20 71 1.96775 $w=1.63333e-08 $l=1.35e-08 $layer=M1 $thickness=3.6e-08
+ $X=0.027 $Y=0.036 $X2=0.0405 $Y2=0.036
r7 70 69 0.0462963 $w=5.4e-08 $l=2.5e-09 $layer=P_src_drn $thickness=1e-09
+ $X=0.0713 $Y=0.216 $X2=0.0685 $Y2=0.216
r8 17 69 0.231482 $w=5.4e-08 $l=1.25e-08 $layer=P_src_drn $thickness=1e-09
+ $X=0.056 $Y=0.216 $X2=0.0685 $Y2=0.216
r9 67 68 18.0722 $w=1.3e-08 $l=7.75e-08 $layer=M1 $thickness=3.6e-08 $X=0.027
+ $Y=0.135 $X2=0.027 $Y2=0.0575
r10 25 67 18.0722 $w=1.3e-08 $l=7.75e-08 $layer=M1 $thickness=3.6e-08 $X=0.027
+ $Y=0.2125 $X2=0.027 $Y2=0.135
r11 66 64 0.0462963 $w=5.4e-08 $l=2.5e-09 $layer=P_src_drn $thickness=1e-09
+ $X=0.1793 $Y=0.216 $X2=0.1765 $Y2=0.216
r12 5 64 0.268519 $w=5.4e-08 $l=1.45e-08 $layer=P_src_drn $thickness=1e-09
+ $X=0.162 $Y=0.216 $X2=0.1765 $Y2=0.216
r13 18 5 0.268519 $w=5.4e-08 $l=1.45e-08 $layer=P_src_drn $thickness=1e-09
+ $X=0.1475 $Y=0.216 $X2=0.162 $Y2=0.216
r14 65 18 0.0462963 $w=5.4e-08 $l=2.5e-09 $layer=P_src_drn $thickness=1e-09
+ $X=0.1446 $Y=0.216 $X2=0.1475 $Y2=0.216
r15 61 60 0.0462963 $w=5.4e-08 $l=2.5e-09 $layer=P_src_drn $thickness=1e-09
+ $X=0.2873 $Y=0.216 $X2=0.2845 $Y2=0.216
r16 6 60 0.268519 $w=5.4e-08 $l=1.45e-08 $layer=P_src_drn $thickness=1e-09
+ $X=0.27 $Y=0.216 $X2=0.2845 $Y2=0.216
r17 19 6 0.268519 $w=5.4e-08 $l=1.45e-08 $layer=P_src_drn $thickness=1e-09
+ $X=0.2555 $Y=0.216 $X2=0.27 $Y2=0.216
r18 62 19 0.0462963 $w=5.4e-08 $l=2.5e-09 $layer=P_src_drn $thickness=1e-09
+ $X=0.2526 $Y=0.216 $X2=0.2555 $Y2=0.216
r19 4 57 19.3796 $a=3.24e-16 $layer=V0LISD $X=0.054 $Y=0.216 $X2=0.054 $Y2=0.234
r20 21 56 1.49895 $w=1.63333e-08 $l=1.35e-08 $layer=M1 $thickness=3.6e-08
+ $X=0.027 $Y=0.234 $X2=0.0405 $Y2=0.234
r21 21 25 3.36447 $w=1.71023e-08 $l=2.15e-08 $layer=M1 $thickness=3.6e-08
+ $X=0.027 $Y=0.234 $X2=0.027 $Y2=0.2125
r22 5 50 19.3796 $a=3.24e-16 $layer=V0LISD $X=0.162 $Y=0.216 $X2=0.162 $Y2=0.234
r23 6 44 19.3796 $a=3.24e-16 $layer=V0LISD $X=0.27 $Y=0.216 $X2=0.27 $Y2=0.234
r24 57 58 2.91487 $w=1.3e-08 $l=1.25e-08 $layer=M1 $thickness=3.6e-08 $X=0.054
+ $Y=0.234 $X2=0.0665 $Y2=0.234
r25 56 57 3.14806 $w=1.3e-08 $l=1.35e-08 $layer=M1 $thickness=3.6e-08 $X=0.0405
+ $Y=0.234 $X2=0.054 $Y2=0.234
r26 55 58 1.04935 $w=1.3e-08 $l=4.5e-09 $layer=M1 $thickness=3.6e-08 $X=0.071
+ $Y=0.234 $X2=0.0665 $Y2=0.234
r27 54 55 2.3319 $w=1.3e-08 $l=1e-08 $layer=M1 $thickness=3.6e-08 $X=0.081
+ $Y=0.234 $X2=0.071 $Y2=0.234
r28 53 54 6.29612 $w=1.3e-08 $l=2.7e-08 $layer=M1 $thickness=3.6e-08 $X=0.108
+ $Y=0.234 $X2=0.081 $Y2=0.234
r29 52 53 6.29612 $w=1.3e-08 $l=2.7e-08 $layer=M1 $thickness=3.6e-08 $X=0.135
+ $Y=0.234 $X2=0.108 $Y2=0.234
r30 50 51 3.14806 $w=1.3e-08 $l=1.35e-08 $layer=M1 $thickness=3.6e-08 $X=0.162
+ $Y=0.234 $X2=0.1755 $Y2=0.234
r31 49 50 3.14806 $w=1.3e-08 $l=1.35e-08 $layer=M1 $thickness=3.6e-08 $X=0.1485
+ $Y=0.234 $X2=0.162 $Y2=0.234
r32 49 52 3.14806 $w=1.3e-08 $l=1.35e-08 $layer=M1 $thickness=3.6e-08 $X=0.1485
+ $Y=0.234 $X2=0.135 $Y2=0.234
r33 48 51 3.14806 $w=1.3e-08 $l=1.35e-08 $layer=M1 $thickness=3.6e-08 $X=0.189
+ $Y=0.234 $X2=0.1755 $Y2=0.234
r34 47 48 6.29612 $w=1.3e-08 $l=2.7e-08 $layer=M1 $thickness=3.6e-08 $X=0.216
+ $Y=0.234 $X2=0.189 $Y2=0.234
r35 46 47 6.29612 $w=1.3e-08 $l=2.7e-08 $layer=M1 $thickness=3.6e-08 $X=0.243
+ $Y=0.234 $X2=0.216 $Y2=0.234
r36 44 45 3.14806 $w=1.3e-08 $l=1.35e-08 $layer=M1 $thickness=3.6e-08 $X=0.27
+ $Y=0.234 $X2=0.2835 $Y2=0.234
r37 26 44 3.14806 $w=1.3e-08 $l=1.35e-08 $layer=M1 $thickness=3.6e-08 $X=0.2565
+ $Y=0.234 $X2=0.27 $Y2=0.234
r38 26 46 3.14806 $w=1.3e-08 $l=1.35e-08 $layer=M1 $thickness=3.6e-08 $X=0.2565
+ $Y=0.234 $X2=0.243 $Y2=0.234
r39 23 27 2.5483 $w=1.79e-08 $l=1.8e-08 $layer=M1 $thickness=3.6e-08 $X=0.297
+ $Y=0.234 $X2=0.297 $Y2=0.216
r40 23 45 1.49895 $w=1.63333e-08 $l=1.35e-08 $layer=M1 $thickness=3.6e-08
+ $X=0.297 $Y=0.234 $X2=0.2835 $Y2=0.234
r41 27 43 2.45586 $w=1.44e-08 $l=1.25e-08 $layer=M1 $thickness=3.6e-08 $X=0.297
+ $Y=0.216 $X2=0.297 $Y2=0.2035
r42 22 43 0.9184 $w=1.8e-08 $l=9e-09 $layer=M1 $thickness=3.6e-08 $X=0.297
+ $Y=0.1945 $X2=0.297 $Y2=0.2035
r43 28 43 4.55457 $w=1.3814e-08 $l=2.75545e-08 $layer=M1 $thickness=3.6e-08
+ $X=0.324 $Y=0.198 $X2=0.297 $Y2=0.2035
r44 24 42 3.36447 $w=1.71023e-08 $l=2.15e-08 $layer=M1 $thickness=3.6e-08
+ $X=0.351 $Y=0.198 $X2=0.351 $Y2=0.1765
r45 24 28 4.64701 $w=1.46667e-08 $l=2.7e-08 $layer=M1 $thickness=3.6e-08
+ $X=0.351 $Y=0.198 $X2=0.324 $Y2=0.198
r46 41 42 5.36336 $w=1.3e-08 $l=2.3e-08 $layer=M1 $thickness=3.6e-08 $X=0.351
+ $Y=0.1535 $X2=0.351 $Y2=0.1765
r47 40 41 4.5472 $w=1.3e-08 $l=1.95e-08 $layer=M1 $thickness=3.6e-08 $X=0.351
+ $Y=0.134 $X2=0.351 $Y2=0.1535
r48 29 40 3.14806 $w=1.3e-08 $l=1.35e-08 $layer=M1 $thickness=3.6e-08 $X=0.351
+ $Y=0.1205 $X2=0.351 $Y2=0.134
r49 1 33 6.8952 $w=1.94872e-08 $layer=LIG $thickness=5.18974e-08 $X=0.351
+ $Y=0.1345 $X2=0.351 $Y2=0.1345
r50 1 40 19.3796 $a=3.24e-16 $layer=V0LIG $X=0.351 $Y=0.1345 $X2=0.351 $Y2=0.134
r51 36 35 14.6259 $w=2.1e-08 $l=4.3e-08 $layer=Gate_1 $thickness=5.6e-08
+ $X=0.351 $Y=0.2025 $X2=0.351 $Y2=0.1595
r52 34 35 3.06124 $w=2.1e-08 $l=9e-09 $layer=Gate_1 $thickness=5.6e-08 $X=0.351
+ $Y=0.1505 $X2=0.351 $Y2=0.1595
r53 33 34 5.60378 $w=2.04063e-08 $l=1.6e-08 $layer=Gate_1 $thickness=5.6e-08
+ $X=0.351 $Y=0.1345 $X2=0.351 $Y2=0.1505
r54 32 33 5.43371 $w=2.03871e-08 $l=1.55e-08 $layer=Gate_1 $thickness=5.6e-08
+ $X=0.351 $Y=0.119 $X2=0.351 $Y2=0.1345
r55 31 32 2.89117 $w=2.1e-08 $l=8.5e-09 $layer=Gate_1 $thickness=5.6e-08
+ $X=0.351 $Y=0.1105 $X2=0.351 $Y2=0.119
r56 30 31 14.6259 $w=2.1e-08 $l=4.3e-08 $layer=Gate_1 $thickness=5.6e-08
+ $X=0.351 $Y=0.0675 $X2=0.351 $Y2=0.1105
r57 30 15 14.6259 $w=2.1e-08 $l=4.3e-08 $layer=Gate_1 $thickness=5.6e-08
+ $X=0.351 $Y=0.0675 $X2=0.351 $Y2=0.0245
r58 3 16 1e-05 $l=2e-09 $X=0.054 $Y=0.0675 $X2=0.056 $Y2=0.0675
r59 4 17 1e-05 $l=2e-09 $X=0.054 $Y=0.216 $X2=0.056 $Y2=0.216
.ends

.subckt PM_AND5x1_ASAP7_75t_R%11 vss 2 3 1
c1 1 vss 0.000690824f $X=0.162 $Y=0.0675
r1 2 1 0.209877 $w=8.1e-08 $l=1.7e-08 $layer=N_src_drn $thickness=1e-09
+ $X=0.1446 $Y=0.0675 $X2=0.162 $Y2=0.0675
r2 3 1 0.209877 $w=8.1e-08 $l=1.7e-08 $layer=N_src_drn $thickness=1e-09
+ $X=0.1793 $Y=0.0675 $X2=0.162 $Y2=0.0675
.ends

.subckt PM_AND5x1_ASAP7_75t_R%B vss 15 5 9 1 4 3
c1 1 vss 0.00173782f $X=0.135 $Y=0.1345
c2 3 vss 0.0384135f $X=0.135 $Y=0.0245
c3 4 vss 0.0118663f $X=0.135 $Y=0.0575
r1 15 14 8.51143 $w=1.3e-08 $l=3.65e-08 $layer=M1 $thickness=3.6e-08 $X=0.135
+ $Y=0.135 $X2=0.135 $Y2=0.0975
r2 4 14 9.32759 $w=1.3e-08 $l=4e-08 $layer=M1 $thickness=3.6e-08 $X=0.135
+ $Y=0.0575 $X2=0.135 $Y2=0.0975
r3 1 7 6.8952 $w=1.94872e-08 $layer=LIG $thickness=5.18974e-08 $X=0.135
+ $Y=0.1345 $X2=0.135 $Y2=0.1345
r4 15 1 19.3796 $a=3.24e-16 $layer=V0LIG $X=0.135 $Y=0.135 $X2=0.135 $Y2=0.1345
r5 9 8 16.8368 $w=2.1e-08 $l=4.95e-08 $layer=Gate_1 $thickness=5.6e-08 $X=0.135
+ $Y=0.216 $X2=0.135 $Y2=0.1665
r6 7 8 11.046 $w=2.07031e-08 $l=3.2e-08 $layer=Gate_1 $thickness=5.6e-08
+ $X=0.135 $Y=0.1345 $X2=0.135 $Y2=0.1665
r7 6 7 6.28405 $w=2.04722e-08 $l=1.8e-08 $layer=Gate_1 $thickness=5.6e-08
+ $X=0.135 $Y=0.1165 $X2=0.135 $Y2=0.1345
r8 5 6 16.6668 $w=2.1e-08 $l=4.9e-08 $layer=Gate_1 $thickness=5.6e-08 $X=0.135
+ $Y=0.0675 $X2=0.135 $Y2=0.1165
r9 5 3 14.6259 $w=2.1e-08 $l=4.3e-08 $layer=Gate_1 $thickness=5.6e-08 $X=0.135
+ $Y=0.0675 $X2=0.135 $Y2=0.0245
.ends

* End of included file AND5x1_ASAP7_75t_R.pex.sp.pex

*
.subckt AND5x1_ASAP7_75t_CUSTOM_4_25_0_7 VSS VDD A B C D E Y
*
* VSS VSS
* VDD VDD
* A A
* B B
* C C
* D D
* E E
* Y Y
*
*

M0 N_M0_d N_M0_g N_M0_s VSS nmos_rvt L=2e-08 W=8.1e-08 nfin=3 $X=0.071 $Y=0.027
M1 N_M1_d N_M1_g N_M1_s VSS nmos_rvt L=2e-08 W=8.1e-08 nfin=3 $X=0.125 $Y=0.027
M2 N_M2_d N_M2_g N_M2_s VSS nmos_rvt L=2e-08 W=8.1e-08 nfin=3 $X=0.179 $Y=0.027
M3 N_M3_d N_M3_g N_M3_s VSS nmos_rvt L=2e-08 W=8.1e-08 nfin=3 $X=0.233 $Y=0.027
M4 VSS N_M4_g N_M4_s VSS nmos_rvt L=2e-08 W=8.1e-08 nfin=3 $X=0.287 $Y=0.027
M5 N_M5_d N_M5_g VSS VSS nmos_rvt L=2e-08 W=8.1e-08 nfin=3 $X=0.341 $Y=0.027
M6 VDD N_M6_g N_M6_s VDD pmos_rvt L=2e-08 W=5.4e-08 nfin=2 $X=0.071 $Y=0.189
M7 N_M7_d N_M7_g VDD VDD pmos_rvt L=2e-08 W=5.4e-08 nfin=2 $X=0.125 $Y=0.189
M8 VDD N_M8_g N_M8_s VDD pmos_rvt L=2e-08 W=5.4e-08 nfin=2 $X=0.179 $Y=0.189
M9 N_M9_d N_M9_g VDD VDD pmos_rvt L=2e-08 W=5.4e-08 nfin=2 $X=0.233 $Y=0.189
M10 VDD N_M10_g N_M10_s VDD pmos_rvt L=2e-08 W=5.4e-08 nfin=2 $X=0.287 $Y=0.189
M11 N_M11_d N_M11_g VDD VDD pmos_rvt L=2e-08 W=8.1e-08 nfin=3 $X=0.341 $Y=0.162

* .include "AND5x1_ASAP7_75t_R.pex.sp.pxi"

* Start of included file AND5x1_ASAP7_75t_R.pex.sp.pxi
x_PM_AND5x1_ASAP7_75t_R%10 vss N_M0_d N_M1_s N_10_1 PM_AND5x1_ASAP7_75t_R%10
cc_1 N_10_1 N_A_3 0.0169546f $X=0.108 $Y=0.0675
cc_2 N_10_1 N_B_3 0.0169862f $X=0.108 $Y=0.0675
x_PM_AND5x1_ASAP7_75t_R%12 vss N_M2_d N_M3_s N_12_1 PM_AND5x1_ASAP7_75t_R%12
cc_3 N_12_1 N_C_3 0.0168963f $X=0.216 $Y=0.0675
cc_4 N_12_1 N_D_3 0.0168791f $X=0.216 $Y=0.0675
x_PM_AND5x1_ASAP7_75t_R%13 vss N_M3_d N_M4_s N_13_1 PM_AND5x1_ASAP7_75t_R%13
cc_5 N_13_1 N_D_3 0.016967f $X=0.27 $Y=0.0675
cc_6 N_13_1 N_E_3 0.0169329f $X=0.27 $Y=0.0675
x_PM_AND5x1_ASAP7_75t_R%A vss A N_M0_g N_M6_g N_A_3 N_A_4 N_A_1
+ PM_AND5x1_ASAP7_75t_R%A
x_PM_AND5x1_ASAP7_75t_R%C vss C N_M2_g N_M8_g N_C_1 N_C_4 N_C_3
+ PM_AND5x1_ASAP7_75t_R%C
cc_7 N_C_1 N_B_1 0.00148209f $X=0.189 $Y=0.1345
cc_8 N_C_4 N_B_4 0.00638069f $X=0.189 $Y=0.0795
cc_9 N_C_3 N_B_3 0.00808229f $X=0.189 $Y=0.0245
x_PM_AND5x1_ASAP7_75t_R%D vss D N_M3_g N_M9_g N_D_1 N_D_4 N_D_3
+ PM_AND5x1_ASAP7_75t_R%D
cc_10 N_D_1 N_C_1 0.00148517f $X=0.243 $Y=0.1345
cc_11 N_D_4 N_C_4 0.00637146f $X=0.243 $Y=0.0795
cc_12 N_D_3 N_C_3 0.00810802f $X=0.243 $Y=0.0245
x_PM_AND5x1_ASAP7_75t_R%E vss E N_M4_g N_M10_g N_E_3 N_E_4 N_E_1
+ PM_AND5x1_ASAP7_75t_R%E
cc_13 N_E_3 N_D_1 0.00149755f $X=0.297 $Y=0.0245
cc_14 N_E_4 N_D_4 0.00525883f $X=0.297 $Y=0.0805
cc_15 N_E_3 N_D_3 0.00791823f $X=0.297 $Y=0.0245
x_PM_AND5x1_ASAP7_75t_R%Y vss Y N_M5_d N_M11_d N_Y_7 N_Y_11 N_Y_13 N_Y_8
+ PM_AND5x1_ASAP7_75t_R%Y
cc_16 N_Y_7 N_8_24 0.000247822f $X=0.3635 $Y=0.0675
cc_17 N_Y_7 N_8_23 0.000363944f $X=0.3635 $Y=0.0675
cc_18 N_Y_7 N_8_28 0.00045997f $X=0.3635 $Y=0.0675
cc_19 N_Y_7 N_8_1 0.00246088f $X=0.3635 $Y=0.0675
cc_20 N_Y_11 N_8_24 0.00262448f $X=0.3645 $Y=0.234
cc_21 N_Y_13 N_8_29 0.00443608f $X=0.405 $Y=0.0805
cc_22 N_Y_8 N_8_15 0.0148941f $X=0.3635 $Y=0.2025
cc_23 N_Y_7 N_8_15 0.0576765f $X=0.3635 $Y=0.0675
x_PM_AND5x1_ASAP7_75t_R%8 vss N_M5_g N_M11_g N_M10_s N_M9_d N_M7_d N_M8_s
+ N_M6_s N_M0_s N_8_20 N_8_4 N_8_3 N_8_26 N_8_16 N_8_17 N_8_25 N_8_18 N_8_5
+ N_8_6 N_8_22 N_8_19 N_8_1 N_8_29 N_8_15 N_8_24 N_8_23 N_8_28
+ PM_AND5x1_ASAP7_75t_R%8
cc_24 N_8_20 N_A_3 0.000505323f $X=0.027 $Y=0.036
cc_25 N_8_4 N_A_3 0.000672038f $X=0.054 $Y=0.216
cc_26 N_8_3 N_A_1 0.000789482f $X=0.054 $Y=0.0675
cc_27 N_8_26 N_A_4 0.00103063f $X=0.2565 $Y=0.234
cc_28 N_8_16 N_A_1 0.00139258f $X=0.056 $Y=0.0675
cc_29 N_8_3 N_A_3 0.00162102f $X=0.054 $Y=0.0675
cc_30 N_8_17 N_A_3 0.0107117f $X=0.056 $Y=0.216
cc_31 N_8_25 N_A_4 0.00785331f $X=0.027 $Y=0.2125
cc_32 N_8_16 N_A_3 0.0501602f $X=0.056 $Y=0.0675
cc_33 N_8_3 N_B_3 0.000353558f $X=0.054 $Y=0.0675
cc_34 N_8_18 N_B_1 0.000357446f $X=0.1475 $Y=0.216
cc_35 N_8_5 N_B_3 0.000687745f $X=0.162 $Y=0.216
cc_36 N_8_26 N_B_4 0.00113263f $X=0.2565 $Y=0.234
cc_37 N_8_3 N_B_4 0.00220677f $X=0.054 $Y=0.0675
cc_38 N_8_18 N_B_3 0.0261864f $X=0.1475 $Y=0.216
cc_39 N_8_18 N_C_1 0.000363828f $X=0.1475 $Y=0.216
cc_40 N_8_5 N_C_3 0.000685756f $X=0.162 $Y=0.216
cc_41 N_8_26 N_C_4 0.0011316f $X=0.2565 $Y=0.234
cc_42 N_8_5 N_C_4 0.00180283f $X=0.162 $Y=0.216
cc_43 N_8_18 N_C_3 0.0261481f $X=0.1475 $Y=0.216
cc_44 N_8_6 N_D_3 0.000643244f $X=0.27 $Y=0.216
cc_45 N_8_26 N_D_4 0.00102652f $X=0.2565 $Y=0.234
cc_46 N_8_22 N_D_4 0.00247757f $X=0.297 $Y=0.1945
cc_47 N_8_19 N_D_3 0.0260442f $X=0.2555 $Y=0.216
cc_48 N_8_6 N_E_3 0.000445865f $X=0.27 $Y=0.216
cc_49 N_8_22 N_E_3 0.000542498f $X=0.297 $Y=0.1945
cc_50 N_8_1 N_E_3 0.000891742f $X=0.351 $Y=0.1345
cc_51 N_8_1 N_E_1 0.00127515f $X=0.351 $Y=0.1345
cc_52 N_8_29 N_E_4 0.00348944f $X=0.351 $Y=0.1205
cc_53 N_8_19 N_E_3 0.0104712f $X=0.2555 $Y=0.216
cc_54 N_8_15 N_E_3 0.0182312f $X=0.351 $Y=0.0245
x_PM_AND5x1_ASAP7_75t_R%11 vss N_M1_d N_M2_s N_11_1 PM_AND5x1_ASAP7_75t_R%11
cc_55 N_11_1 N_B_3 0.0168742f $X=0.162 $Y=0.0675
cc_56 N_11_1 N_C_3 0.0169148f $X=0.162 $Y=0.0675
x_PM_AND5x1_ASAP7_75t_R%B vss B N_M1_g N_M7_g N_B_1 N_B_4 N_B_3
+ PM_AND5x1_ASAP7_75t_R%B
cc_57 N_B_1 N_A_3 0.00148765f $X=0.135 $Y=0.1345
cc_58 N_B_4 N_A_4 0.00537112f $X=0.135 $Y=0.0575
cc_59 N_B_3 N_A_3 0.00796795f $X=0.135 $Y=0.0245

* End of included file AND5x1_ASAP7_75t_R.pex.sp.pxi
.ends

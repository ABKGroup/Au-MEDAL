.subckt PM_AND2x2_ASAP7_75t_R%7 vss 2 3 1
c1 1 vss 0.000888387f $X=0.108 $Y=0.0675
r1 2 1 0.209877 $w=8.1e-08 $l=1.7e-08 $layer=N_src_drn $thickness=1e-09
+ $X=0.0906 $Y=0.0675 $X2=0.108 $Y2=0.0675
r2 3 1 0.209877 $w=8.1e-08 $l=1.7e-08 $layer=N_src_drn $thickness=1e-09
+ $X=0.1253 $Y=0.0675 $X2=0.108 $Y2=0.0675
.ends

.subckt PM_AND2x2_ASAP7_75t_R%5 vss 22 26 38 42 61 62 64 3 4 17 19 11 12 18 15
+ 1 20 21 9 10 16 14
c1 1 vss 0.00723184f $X=0.1795 $Y=0.1345
c2 3 vss 0.00860088f $X=0.0665 $Y=0.0675
c3 4 vss 0.00809058f $X=0.108 $Y=0.216
c4 9 vss 0.0840361f $X=0.189 $Y=0.0245
c5 10 vss 0.0867121f $X=0.243 $Y=0.1345
c6 11 vss 0.0419198f $X=0.056 $Y=0.0675
c7 12 vss 0.00656204f $X=0.0935 $Y=0.216
c8 13 vss 0.00274608f $X=0.079 $Y=0.0305
c9 14 vss 0.00287459f $X=0.171 $Y=0.036
c10 15 vss 0.00107909f $X=0.171 $Y=0.135
c11 16 vss 0.00285194f $X=0.171 $Y=0.234
c12 17 vss 0.00155062f $X=0.079 $Y=0.054
c13 18 vss 0.00797342f $X=0.153 $Y=0.036
c14 19 vss 0.00787453f $X=0.153 $Y=0.234
c15 20 vss 0.00302753f $X=0.171 $Y=0.106
c16 21 vss 0.0030883f $X=0.171 $Y=0.164
r1 64 63 0.0308642 $w=8.1e-08 $l=2.5e-09 $layer=N_src_drn $thickness=1e-09
+ $X=0.0713 $Y=0.0675 $X2=0.0685 $Y2=0.0675
r2 11 63 0.154321 $w=8.1e-08 $l=1.25e-08 $layer=N_src_drn $thickness=1e-09
+ $X=0.056 $Y=0.0675 $X2=0.0685 $Y2=0.0675
r3 3 57 19.3796 $a=3.24e-16 $layer=V0LISD $X=0.0665 $Y=0.0675 $X2=0.079
+ $Y2=0.0755
r4 62 60 0.0462963 $w=5.4e-08 $l=2.5e-09 $layer=P_src_drn $thickness=1e-09
+ $X=0.1253 $Y=0.216 $X2=0.1225 $Y2=0.216
r5 4 60 0.268519 $w=5.4e-08 $l=1.45e-08 $layer=P_src_drn $thickness=1e-09
+ $X=0.108 $Y=0.216 $X2=0.1225 $Y2=0.216
r6 12 4 0.268519 $w=5.4e-08 $l=1.45e-08 $layer=P_src_drn $thickness=1e-09
+ $X=0.0935 $Y=0.216 $X2=0.108 $Y2=0.216
r7 61 12 0.0462963 $w=5.4e-08 $l=2.5e-09 $layer=P_src_drn $thickness=1e-09
+ $X=0.0906 $Y=0.216 $X2=0.0935 $Y2=0.216
r8 56 57 2.09871 $w=1.3e-08 $l=9e-09 $layer=M1 $thickness=3.6e-08 $X=0.079
+ $Y=0.0665 $X2=0.079 $Y2=0.0755
r9 17 56 2.91487 $w=1.3e-08 $l=1.25e-08 $layer=M1 $thickness=3.6e-08 $X=0.079
+ $Y=0.054 $X2=0.079 $Y2=0.0665
r10 17 55 2.65995 $w=1.48966e-08 $l=1.45e-08 $layer=M1 $thickness=3.6e-08
+ $X=0.079 $Y=0.054 $X2=0.079 $Y2=0.0395
r11 4 53 19.3796 $a=3.24e-16 $layer=V0LISD $X=0.108 $Y=0.216 $X2=0.108 $Y2=0.234
r12 13 50 1.05672 $w=1.56923e-08 $l=1.32004e-08 $layer=M1 $thickness=3.6e-08
+ $X=0.079 $Y=0.0305 $X2=0.091 $Y2=0.036
r13 13 55 0.9184 $w=1.8e-08 $l=9e-09 $layer=M1 $thickness=3.6e-08 $X=0.079
+ $Y=0.0305 $X2=0.079 $Y2=0.0395
r14 53 54 3.14806 $w=1.3e-08 $l=1.35e-08 $layer=M1 $thickness=3.6e-08 $X=0.108
+ $Y=0.234 $X2=0.1215 $Y2=0.234
r15 51 54 3.14806 $w=1.3e-08 $l=1.35e-08 $layer=M1 $thickness=3.6e-08 $X=0.135
+ $Y=0.234 $X2=0.1215 $Y2=0.234
r16 19 51 4.19742 $w=1.3e-08 $l=1.8e-08 $layer=M1 $thickness=3.6e-08 $X=0.153
+ $Y=0.234 $X2=0.135 $Y2=0.234
r17 49 50 4.43061 $w=1.3e-08 $l=1.9e-08 $layer=M1 $thickness=3.6e-08 $X=0.11
+ $Y=0.036 $X2=0.091 $Y2=0.036
r18 48 49 5.82974 $w=1.3e-08 $l=2.5e-08 $layer=M1 $thickness=3.6e-08 $X=0.135
+ $Y=0.036 $X2=0.11 $Y2=0.036
r19 18 48 4.19742 $w=1.3e-08 $l=1.8e-08 $layer=M1 $thickness=3.6e-08 $X=0.153
+ $Y=0.036 $X2=0.135 $Y2=0.036
r20 16 47 3.36447 $w=1.71023e-08 $l=2.15e-08 $layer=M1 $thickness=3.6e-08
+ $X=0.171 $Y=0.234 $X2=0.171 $Y2=0.2125
r21 16 19 2.5483 $w=1.55e-08 $l=1.8e-08 $layer=M1 $thickness=3.6e-08 $X=0.171
+ $Y=0.234 $X2=0.153 $Y2=0.234
r22 14 45 3.36447 $w=1.71023e-08 $l=2.15e-08 $layer=M1 $thickness=3.6e-08
+ $X=0.171 $Y=0.036 $X2=0.171 $Y2=0.0575
r23 14 18 2.5483 $w=1.55e-08 $l=1.8e-08 $layer=M1 $thickness=3.6e-08 $X=0.171
+ $Y=0.036 $X2=0.153 $Y2=0.036
r24 46 47 4.78039 $w=1.3e-08 $l=2.05e-08 $layer=M1 $thickness=3.6e-08 $X=0.171
+ $Y=0.192 $X2=0.171 $Y2=0.2125
r25 21 46 6.52931 $w=1.3e-08 $l=2.8e-08 $layer=M1 $thickness=3.6e-08 $X=0.171
+ $Y=0.164 $X2=0.171 $Y2=0.192
r26 44 45 4.78039 $w=1.3e-08 $l=2.05e-08 $layer=M1 $thickness=3.6e-08 $X=0.171
+ $Y=0.078 $X2=0.171 $Y2=0.0575
r27 20 44 6.52931 $w=1.3e-08 $l=2.8e-08 $layer=M1 $thickness=3.6e-08 $X=0.171
+ $Y=0.106 $X2=0.171 $Y2=0.078
r28 42 41 14.6259 $w=2.1e-08 $l=4.3e-08 $layer=Gate_1 $thickness=5.6e-08
+ $X=0.243 $Y=0.2025 $X2=0.243 $Y2=0.1595
r29 40 41 2.7211 $w=2.1e-08 $l=8e-09 $layer=Gate_1 $thickness=5.6e-08 $X=0.243
+ $Y=0.1515 $X2=0.243 $Y2=0.1595
r30 38 39 14.6259 $w=2.1e-08 $l=4.3e-08 $layer=Gate_1 $thickness=5.6e-08
+ $X=0.243 $Y=0.0675 $X2=0.243 $Y2=0.1105
r31 36 39 2.55104 $w=2.1e-08 $l=7.5e-09 $layer=Gate_1 $thickness=5.6e-08
+ $X=0.243 $Y=0.118 $X2=0.243 $Y2=0.1105
r32 10 32 6.4735 $w=2.13953e-08 $layer=Gate_1 $thickness=5.22791e-08 $X=0.243
+ $Y=0.1345 $X2=0.243 $Y2=0.1345
r33 10 36 5.80786 $w=2.0303e-08 $l=1.65e-08 $layer=Gate_1 $thickness=5.6e-08
+ $X=0.243 $Y=0.1345 $X2=0.243 $Y2=0.118
r34 10 40 5.97793 $w=2.03235e-08 $l=1.7e-08 $layer=Gate_1 $thickness=5.6e-08
+ $X=0.243 $Y=0.1345 $X2=0.243 $Y2=0.1515
r35 15 34 3.01711 $w=1.55e-08 $l=1.8e-08 $layer=M1 $thickness=3.6e-08 $X=0.171
+ $Y=0.135 $X2=0.189 $Y2=0.135
r36 15 20 5.5822 $w=1.45517e-08 $l=2.9e-08 $layer=M1 $thickness=3.6e-08
+ $X=0.171 $Y=0.135 $X2=0.171 $Y2=0.106
r37 15 21 5.5822 $w=1.45517e-08 $l=2.9e-08 $layer=M1 $thickness=3.6e-08
+ $X=0.171 $Y=0.135 $X2=0.171 $Y2=0.164
r38 31 32 10.1596 $w=1.87815e-08 $l=2.7e-08 $layer=LIG $thickness=4.8e-08
+ $X=0.216 $Y=0.1345 $X2=0.243 $Y2=0.1345
r39 29 31 7.91162 $w=1.64914e-08 $l=1.75e-08 $layer=LIG $thickness=4.8e-08
+ $X=0.1985 $Y=0.1345 $X2=0.216 $Y2=0.1345
r40 28 29 2.24801 $w=2.3e-08 $l=9.5e-09 $layer=LIG $thickness=4.8e-08 $X=0.189
+ $Y=0.1345 $X2=0.1985 $Y2=0.1345
r41 28 34 19.3796 $a=3.24e-16 $layer=V0LIG $X=0.189 $Y=0.1345 $X2=0.189
+ $Y2=0.135
r42 1 28 2.24801 $w=2.3e-08 $l=9.5e-09 $layer=LIG $thickness=4.8e-08 $X=0.1795
+ $Y=0.1345 $X2=0.189 $Y2=0.1345
r43 26 25 16.4967 $w=2.1e-08 $l=4.85e-08 $layer=Gate_1 $thickness=5.6e-08
+ $X=0.189 $Y=0.2025 $X2=0.189 $Y2=0.154
r44 24 25 6.82827 $w=2.04103e-08 $l=1.95e-08 $layer=Gate_1 $thickness=5.6e-08
+ $X=0.189 $Y=0.1345 $X2=0.189 $Y2=0.154
r45 24 29 4.22548 $w=2.0125e-08 $l=9.5e-09 $layer=Gate_1 $thickness=5.56667e-08
+ $X=0.189 $Y=0.1345 $X2=0.1985 $Y2=0.1345
r46 24 28 6.23686 $w=2.13171e-08 $layer=Gate_1 $thickness=5.24878e-08 $X=0.189
+ $Y=0.1345 $X2=0.189 $Y2=0.1345
r47 23 24 6.6582 $w=2.03947e-08 $l=1.9e-08 $layer=Gate_1 $thickness=5.6e-08
+ $X=0.189 $Y=0.1155 $X2=0.189 $Y2=0.1345
r48 22 23 16.3266 $w=2.1e-08 $l=4.8e-08 $layer=Gate_1 $thickness=5.6e-08
+ $X=0.189 $Y=0.0675 $X2=0.189 $Y2=0.1155
r49 22 9 14.6259 $w=2.1e-08 $l=4.3e-08 $layer=Gate_1 $thickness=5.6e-08
+ $X=0.189 $Y=0.0675 $X2=0.189 $Y2=0.0245
r50 3 11 1e-05 $l=1.05e-08 $X=0.0665 $Y=0.0675 $X2=0.056 $Y2=0.0675
.ends

.subckt PM_AND2x2_ASAP7_75t_R%Y vss 27 20 21 34 35 7 1 13 14 8
c1 1 vss 0.00727254f $X=0.216 $Y=0.0675
c2 2 vss 0.00730926f $X=0.216 $Y=0.2025
c3 7 vss 0.00444274f $X=0.2015 $Y=0.0675
c4 8 vss 0.00438557f $X=0.2015 $Y=0.2025
c5 9 vss 0.00255684f $X=0.216 $Y=0.036
c6 10 vss 0.00255684f $X=0.216 $Y=0.234
c7 11 vss 0.00290883f $X=0.297 $Y=0.036
c8 12 vss 0.00290883f $X=0.297 $Y=0.234
c9 13 vss 0.00101719f $X=0.216 $Y=0.054
c10 14 vss 0.00120214f $X=0.216 $Y=0.1865
c11 15 vss 0.00591835f $X=0.2565 $Y=0.036
c12 16 vss 0.00592796f $X=0.2565 $Y=0.234
c13 17 vss 0.00837151f $X=0.297 $Y=0.0655
r1 35 33 0.0308642 $w=8.1e-08 $l=2.5e-09 $layer=P_src_drn $thickness=1e-09
+ $X=0.2333 $Y=0.2025 $X2=0.2305 $Y2=0.2025
r2 2 33 0.179012 $w=8.1e-08 $l=1.45e-08 $layer=P_src_drn $thickness=1e-09
+ $X=0.216 $Y=0.2025 $X2=0.2305 $Y2=0.2025
r3 8 2 0.179012 $w=8.1e-08 $l=1.45e-08 $layer=P_src_drn $thickness=1e-09
+ $X=0.2015 $Y=0.2025 $X2=0.216 $Y2=0.2025
r4 34 8 0.0308642 $w=8.1e-08 $l=2.5e-09 $layer=P_src_drn $thickness=1e-09
+ $X=0.1986 $Y=0.2025 $X2=0.2015 $Y2=0.2025
r5 2 30 19.3796 $a=3.24e-16 $layer=V0LISD $X=0.216 $Y=0.2025 $X2=0.216 $Y2=0.198
r6 30 31 4.19742 $w=1.3e-08 $l=1.8e-08 $layer=M1 $thickness=3.6e-08 $X=0.216
+ $Y=0.198 $X2=0.216 $Y2=0.216
r7 14 30 2.68168 $w=1.3e-08 $l=1.15e-08 $layer=M1 $thickness=3.6e-08 $X=0.216
+ $Y=0.1865 $X2=0.216 $Y2=0.198
r8 10 16 7.79507 $w=1.41111e-08 $l=4.05e-08 $layer=M1 $thickness=3.6e-08
+ $X=0.216 $Y=0.234 $X2=0.2565 $Y2=0.234
r9 10 31 2.5483 $w=1.79e-08 $l=1.8e-08 $layer=M1 $thickness=3.6e-08 $X=0.216
+ $Y=0.234 $X2=0.216 $Y2=0.216
r10 12 29 5.22999 $w=1.59898e-08 $l=2.95e-08 $layer=M1 $thickness=3.6e-08
+ $X=0.297 $Y=0.234 $X2=0.297 $Y2=0.2045
r11 12 16 7.79507 $w=1.41111e-08 $l=4.05e-08 $layer=M1 $thickness=3.6e-08
+ $X=0.297 $Y=0.234 $X2=0.2565 $Y2=0.234
r12 28 29 8.97781 $w=1.3e-08 $l=3.85e-08 $layer=M1 $thickness=3.6e-08 $X=0.297
+ $Y=0.166 $X2=0.297 $Y2=0.2045
r13 27 28 4.31401 $w=1.3e-08 $l=1.85e-08 $layer=M1 $thickness=3.6e-08 $X=0.297
+ $Y=0.1475 $X2=0.297 $Y2=0.166
r14 27 26 0.46638 $w=1.3e-08 $l=2e-09 $layer=M1 $thickness=3.6e-08 $X=0.297
+ $Y=0.1475 $X2=0.297 $Y2=0.1455
r15 25 26 2.44849 $w=1.3e-08 $l=1.05e-08 $layer=M1 $thickness=3.6e-08 $X=0.297
+ $Y=0.135 $X2=0.297 $Y2=0.1455
r16 24 25 6.7625 $w=1.3e-08 $l=2.9e-08 $layer=M1 $thickness=3.6e-08 $X=0.297
+ $Y=0.106 $X2=0.297 $Y2=0.135
r17 17 24 9.44419 $w=1.3e-08 $l=4.05e-08 $layer=M1 $thickness=3.6e-08 $X=0.297
+ $Y=0.0655 $X2=0.297 $Y2=0.106
r18 11 15 7.79507 $w=1.41111e-08 $l=4.05e-08 $layer=M1 $thickness=3.6e-08
+ $X=0.297 $Y=0.036 $X2=0.2565 $Y2=0.036
r19 11 17 5.22999 $w=1.59898e-08 $l=2.95e-08 $layer=M1 $thickness=3.6e-08
+ $X=0.297 $Y=0.036 $X2=0.297 $Y2=0.0655
r20 9 13 2.5483 $w=1.79e-08 $l=1.8e-08 $layer=M1 $thickness=3.6e-08 $X=0.216
+ $Y=0.036 $X2=0.216 $Y2=0.054
r21 9 15 7.79507 $w=1.41111e-08 $l=4.05e-08 $layer=M1 $thickness=3.6e-08
+ $X=0.216 $Y=0.036 $X2=0.2565 $Y2=0.036
r22 13 22 4.19742 $w=1.3e-08 $l=1.8e-08 $layer=M1 $thickness=3.6e-08 $X=0.216
+ $Y=0.054 $X2=0.216 $Y2=0.072
r23 1 22 19.3796 $a=3.24e-16 $layer=V0LISD $X=0.216 $Y=0.0675 $X2=0.216
+ $Y2=0.072
r24 21 19 0.0308642 $w=8.1e-08 $l=2.5e-09 $layer=N_src_drn $thickness=1e-09
+ $X=0.2333 $Y=0.0675 $X2=0.2305 $Y2=0.0675
r25 1 19 0.179012 $w=8.1e-08 $l=1.45e-08 $layer=N_src_drn $thickness=1e-09
+ $X=0.216 $Y=0.0675 $X2=0.2305 $Y2=0.0675
r26 7 1 0.179012 $w=8.1e-08 $l=1.45e-08 $layer=N_src_drn $thickness=1e-09
+ $X=0.2015 $Y=0.0675 $X2=0.216 $Y2=0.0675
r27 20 7 0.0308642 $w=8.1e-08 $l=2.5e-09 $layer=N_src_drn $thickness=1e-09
+ $X=0.1986 $Y=0.0675 $X2=0.2015 $Y2=0.0675
.ends

.subckt PM_AND2x2_ASAP7_75t_R%B vss 20 8 14 7 3 1 6 5
c1 1 vss 0.00251142f $X=0.075 $Y=0.1345
c2 3 vss 0.0389823f $X=0.081 $Y=0.0245
c3 4 vss 0.0013873f $X=0.027 $Y=0.135
c4 5 vss 0.00997878f $X=0.027 $Y=0.106
c5 6 vss 0.0124634f $X=0.027 $Y=0.172
c6 7 vss 0.00238999f $X=0.0485 $Y=0.135
r1 4 7 3.83327 $w=1.5093e-08 $l=2.15e-08 $layer=M1 $thickness=3.6e-08 $X=0.027
+ $Y=0.135 $X2=0.0485 $Y2=0.135
r2 4 5 5.5822 $w=1.45517e-08 $l=2.9e-08 $layer=M1 $thickness=3.6e-08 $X=0.027
+ $Y=0.135 $X2=0.027 $Y2=0.106
r3 4 6 7.44771 $w=1.42162e-08 $l=3.7e-08 $layer=M1 $thickness=3.6e-08 $X=0.027
+ $Y=0.135 $X2=0.027 $Y2=0.172
r4 20 7 3.96423 $w=1.3e-08 $l=1.7e-08 $layer=M1 $thickness=3.6e-08 $X=0.073
+ $Y=0.133 $X2=0.0485 $Y2=0.135
r5 20 18 19.3796 $a=3.24e-16 $layer=V0LIG $X=0.073 $Y=0.133 $X2=0.066 $Y2=0.1345
r6 1 16 2.36633 $w=2.3e-08 $l=1e-08 $layer=LIG $thickness=4.8e-08 $X=0.075
+ $Y=0.1345 $X2=0.085 $Y2=0.1345
r7 1 18 3.23868 $w=1.92778e-08 $l=9e-09 $layer=LIG $thickness=4.8e-08 $X=0.075
+ $Y=0.1345 $X2=0.066 $Y2=0.1345
r8 14 13 14.6259 $w=2.1e-08 $l=4.3e-08 $layer=Gate_1 $thickness=5.6e-08
+ $X=0.081 $Y=0.216 $X2=0.081 $Y2=0.173
r9 12 13 7.31297 $w=2.1e-08 $l=2.15e-08 $layer=Gate_1 $thickness=5.6e-08
+ $X=0.081 $Y=0.1515 $X2=0.081 $Y2=0.173
r10 11 12 5.97793 $w=2.03235e-08 $l=1.7e-08 $layer=Gate_1 $thickness=5.6e-08
+ $X=0.081 $Y=0.1345 $X2=0.081 $Y2=0.1515
r11 11 16 5.52696 $w=2.10286e-08 $l=4e-09 $layer=Gate_1 $thickness=5.32571e-08
+ $X=0.081 $Y=0.1345 $X2=0.085 $Y2=0.1345
r12 10 11 5.80786 $w=2.0303e-08 $l=1.65e-08 $layer=Gate_1 $thickness=5.6e-08
+ $X=0.081 $Y=0.118 $X2=0.081 $Y2=0.1345
r13 9 10 2.55104 $w=2.1e-08 $l=7.5e-09 $layer=Gate_1 $thickness=5.6e-08
+ $X=0.081 $Y=0.1105 $X2=0.081 $Y2=0.118
r14 8 9 14.6259 $w=2.1e-08 $l=4.3e-08 $layer=Gate_1 $thickness=5.6e-08 $X=0.081
+ $Y=0.0675 $X2=0.081 $Y2=0.1105
r15 8 3 14.6259 $w=2.1e-08 $l=4.3e-08 $layer=Gate_1 $thickness=5.6e-08 $X=0.081
+ $Y=0.0675 $X2=0.081 $Y2=0.0245
.ends

.subckt PM_AND2x2_ASAP7_75t_R%A vss 4 5 9 3 1
c1 1 vss 0.00732324f $X=0.135 $Y=0.135
c2 3 vss 0.0864924f $X=0.135 $Y=0.0245
c3 4 vss 0.00456996f $X=0.135 $Y=0.133
r1 1 7 6.54019 $w=2.09524e-08 $layer=Gate_1 $thickness=5.21905e-08 $X=0.135
+ $Y=0.135 $X2=0.135 $Y2=0.135
r2 4 1 19.3796 $a=3.24e-16 $layer=V0LIG $X=0.135 $Y=0.133 $X2=0.135 $Y2=0.135
r3 9 8 16.4967 $w=2.1e-08 $l=4.85e-08 $layer=Gate_1 $thickness=5.6e-08 $X=0.135
+ $Y=0.216 $X2=0.135 $Y2=0.1675
r4 7 8 11.2416 $w=2.06615e-08 $l=3.25e-08 $layer=Gate_1 $thickness=5.6e-08
+ $X=0.135 $Y=0.135 $X2=0.135 $Y2=0.1675
r5 6 7 6.6497 $w=2.04211e-08 $l=1.9e-08 $layer=Gate_1 $thickness=5.6e-08
+ $X=0.135 $Y=0.116 $X2=0.135 $Y2=0.135
r6 5 6 16.4967 $w=2.1e-08 $l=4.85e-08 $layer=Gate_1 $thickness=5.6e-08 $X=0.135
+ $Y=0.0675 $X2=0.135 $Y2=0.116
r7 5 3 14.6259 $w=2.1e-08 $l=4.3e-08 $layer=Gate_1 $thickness=5.6e-08 $X=0.135
+ $Y=0.0675 $X2=0.135 $Y2=0.0245
.ends

* End of included file AND2x2_ASAP7_75t_R.pex.sp.pex

*
.subckt AND2x2_ASAP7_75t_CUSTOM_4_25_0_7 VSS VDD B A Y
*
* VSS VSS
* VDD VDD
* B B
* A A
* Y Y
*
*

M0 N_M0_d N_M0_g N_M0_s VSS nmos_rvt L=2e-08 W=8.1e-08 nfin=3 $X=0.071 $Y=0.027
M1 VSS N_M1_g N_M1_s VSS nmos_rvt L=2e-08 W=8.1e-08 nfin=3 $X=0.125 $Y=0.027
M2 N_M2_d N_M2_g VSS VSS nmos_rvt L=2e-08 W=8.1e-08 nfin=3 $X=0.179 $Y=0.027
M3 N_M3_d N_M3_g VSS VSS nmos_rvt L=2e-08 W=8.1e-08 nfin=3 $X=0.233 $Y=0.027
M4 N_M4_d N_M4_g VDD VDD pmos_rvt L=2e-08 W=5.4e-08 nfin=2 $X=0.071 $Y=0.189
M5 VDD N_M5_g N_M5_s VDD pmos_rvt L=2e-08 W=5.4e-08 nfin=2 $X=0.125 $Y=0.189
M6 N_M6_d N_M6_g VDD VDD pmos_rvt L=2e-08 W=8.1e-08 nfin=3 $X=0.179 $Y=0.162
M7 N_M7_d N_M7_g VDD VDD pmos_rvt L=2e-08 W=8.1e-08 nfin=3 $X=0.233 $Y=0.162

* .include "AND2x2_ASAP7_75t_R.pex.sp.pxi"

* Start of included file AND2x2_ASAP7_75t_R.pex.sp.pxi
x_PM_AND2x2_ASAP7_75t_R%7 vss N_M0_d N_M1_s N_7_1 PM_AND2x2_ASAP7_75t_R%7
cc_1 N_7_1 N_B_3 0.0167803f $X=0.108 $Y=0.0675
cc_2 N_7_1 N_A_3 0.0167765f $X=0.108 $Y=0.0675
x_PM_AND2x2_ASAP7_75t_R%5 vss N_M2_g N_M6_g N_M3_g N_M7_g N_M4_d N_M5_s N_M0_s
+ N_5_3 N_5_4 N_5_17 N_5_19 N_5_11 N_5_12 N_5_18 N_5_15 N_5_1 N_5_20 N_5_21
+ N_5_9 N_5_10 N_5_16 N_5_14 PM_AND2x2_ASAP7_75t_R%5
cc_3 N_5_3 N_B_3 0.00484061f $X=0.0665 $Y=0.0675
cc_4 N_5_4 N_B_3 0.000576498f $X=0.108 $Y=0.216
cc_5 N_5_17 N_B_7 0.000747759f $X=0.079 $Y=0.054
cc_6 N_5_3 N_B_1 0.000764051f $X=0.0665 $Y=0.0675
cc_7 N_5_19 N_B_6 0.00104193f $X=0.153 $Y=0.234
cc_8 N_5_11 N_B_1 0.00236527f $X=0.056 $Y=0.0675
cc_9 N_5_17 N_B_5 0.00360146f $X=0.079 $Y=0.054
cc_10 N_5_12 N_B_3 0.0105385f $X=0.0935 $Y=0.216
cc_11 N_5_11 N_B_3 0.0511002f $X=0.056 $Y=0.0675
cc_12 N_5_4 N_A_3 0.000644429f $X=0.108 $Y=0.216
cc_13 N_5_18 A 0.000805286f $X=0.153 $Y=0.036
cc_14 N_5_15 N_A_1 0.000829186f $X=0.171 $Y=0.135
cc_15 N_5_19 A 0.000834376f $X=0.153 $Y=0.234
cc_16 N_5_3 N_A_3 0.00089437f $X=0.0665 $Y=0.0675
cc_17 N_5_1 N_A_1 0.00168784f $X=0.1795 $Y=0.1345
cc_18 N_5_20 A 0.00200781f $X=0.171 $Y=0.106
cc_19 N_5_21 A 0.00214454f $X=0.171 $Y=0.164
cc_20 N_5_12 N_A_3 0.0105186f $X=0.0935 $Y=0.216
cc_21 N_5_15 A 0.00828132f $X=0.171 $Y=0.135
cc_22 N_5_9 N_A_3 0.0192937f $X=0.189 $Y=0.0245
x_PM_AND2x2_ASAP7_75t_R%Y vss Y N_M2_d N_M3_d N_M6_d N_M7_d N_Y_7 N_Y_1 N_Y_13
+ N_Y_14 N_Y_8 PM_AND2x2_ASAP7_75t_R%Y
cc_23 N_Y_7 N_5_1 0.00643454f $X=0.2015 $Y=0.0675
cc_24 N_Y_7 N_5_15 0.000763371f $X=0.2015 $Y=0.0675
cc_25 N_Y_7 N_5_10 0.0587321f $X=0.2015 $Y=0.0675
cc_26 N_Y_7 N_5_16 0.00109083f $X=0.2015 $Y=0.0675
cc_27 N_Y_7 N_5_14 0.00109085f $X=0.2015 $Y=0.0675
cc_28 N_Y_1 N_5_9 0.00187894f $X=0.216 $Y=0.0675
cc_29 N_Y_13 N_5_20 0.00290653f $X=0.216 $Y=0.054
cc_30 N_Y_14 N_5_21 0.00291999f $X=0.216 $Y=0.1865
cc_31 N_Y_8 N_5_9 0.028747f $X=0.2015 $Y=0.2025
cc_32 N_Y_7 N_5_9 0.0494005f $X=0.2015 $Y=0.0675
x_PM_AND2x2_ASAP7_75t_R%B vss B N_M0_g N_M4_g N_B_7 N_B_3 N_B_1 N_B_6 N_B_5
+ PM_AND2x2_ASAP7_75t_R%B
x_PM_AND2x2_ASAP7_75t_R%A vss A N_M1_g N_M5_g N_A_3 N_A_1
+ PM_AND2x2_ASAP7_75t_R%A
cc_33 A N_B_7 0.00192195f $X=0.135 $Y=0.133
cc_34 N_A_3 N_B_3 0.0089379f $X=0.135 $Y=0.0245

* End of included file AND2x2_ASAP7_75t_R.pex.sp.pxi
.ends

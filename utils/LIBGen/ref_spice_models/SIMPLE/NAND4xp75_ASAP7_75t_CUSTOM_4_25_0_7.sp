.subckt PM_NAND4xp75_ASAP7_75t_R%7 vss 16 17 28 29 32 33 10 1 11 12 3 13 2
c1 1 vss 0.00861283f $X=0.108 $Y=0.0675
c2 2 vss 0.00597509f $X=0.216 $Y=0.0675
c3 3 vss 0.00388092f $X=0.324 $Y=0.0675
c4 10 vss 0.00451098f $X=0.0935 $Y=0.0675
c5 11 vss 0.00313409f $X=0.2015 $Y=0.0675
c6 12 vss 0.0018954f $X=0.3095 $Y=0.0675
c7 13 vss 0.0209804f $X=0.0935 $Y=0.036
r1 33 31 0.0308642 $w=8.1e-08 $l=2.5e-09 $layer=N_src_drn $thickness=1e-09
+ $X=0.3413 $Y=0.0675 $X2=0.3385 $Y2=0.0675
r2 3 31 0.179012 $w=8.1e-08 $l=1.45e-08 $layer=N_src_drn $thickness=1e-09
+ $X=0.324 $Y=0.0675 $X2=0.3385 $Y2=0.0675
r3 12 3 0.179012 $w=8.1e-08 $l=1.45e-08 $layer=N_src_drn $thickness=1e-09
+ $X=0.3095 $Y=0.0675 $X2=0.324 $Y2=0.0675
r4 32 12 0.0308642 $w=8.1e-08 $l=2.5e-09 $layer=N_src_drn $thickness=1e-09
+ $X=0.3066 $Y=0.0675 $X2=0.3095 $Y2=0.0675
r5 29 27 0.0308642 $w=8.1e-08 $l=2.5e-09 $layer=N_src_drn $thickness=1e-09
+ $X=0.2333 $Y=0.0675 $X2=0.2305 $Y2=0.0675
r6 2 27 0.179012 $w=8.1e-08 $l=1.45e-08 $layer=N_src_drn $thickness=1e-09
+ $X=0.216 $Y=0.0675 $X2=0.2305 $Y2=0.0675
r7 11 2 0.179012 $w=8.1e-08 $l=1.45e-08 $layer=N_src_drn $thickness=1e-09
+ $X=0.2015 $Y=0.0675 $X2=0.216 $Y2=0.0675
r8 28 11 0.0308642 $w=8.1e-08 $l=2.5e-09 $layer=N_src_drn $thickness=1e-09
+ $X=0.1986 $Y=0.0675 $X2=0.2015 $Y2=0.0675
r9 3 24 19.3796 $a=3.24e-16 $layer=V0LISD $X=0.324 $Y=0.0675 $X2=0.324 $Y2=0.036
r10 2 21 19.3796 $a=3.24e-16 $layer=V0LISD $X=0.216 $Y=0.0675 $X2=0.216
+ $Y2=0.036
r11 23 24 8.97781 $w=1.3e-08 $l=3.85e-08 $layer=M1 $thickness=3.6e-08 $X=0.2855
+ $Y=0.036 $X2=0.324 $Y2=0.036
r12 22 23 10.4935 $w=1.3e-08 $l=4.5e-08 $layer=M1 $thickness=3.6e-08 $X=0.2405
+ $Y=0.036 $X2=0.2855 $Y2=0.036
r13 21 22 5.71315 $w=1.3e-08 $l=2.45e-08 $layer=M1 $thickness=3.6e-08 $X=0.216
+ $Y=0.036 $X2=0.2405 $Y2=0.036
r14 20 21 12.5922 $w=1.3e-08 $l=5.4e-08 $layer=M1 $thickness=3.6e-08 $X=0.162
+ $Y=0.036 $X2=0.216 $Y2=0.036
r15 19 20 12.5922 $w=1.3e-08 $l=5.4e-08 $layer=M1 $thickness=3.6e-08 $X=0.108
+ $Y=0.036 $X2=0.162 $Y2=0.036
r16 18 19 2.56509 $w=1.3e-08 $l=1.1e-08 $layer=M1 $thickness=3.6e-08 $X=0.097
+ $Y=0.036 $X2=0.108 $Y2=0.036
r17 13 18 0.816164 $w=1.3e-08 $l=3.5e-09 $layer=M1 $thickness=3.6e-08 $X=0.0935
+ $Y=0.036 $X2=0.097 $Y2=0.036
r18 1 19 19.3796 $a=3.24e-16 $layer=V0LISD $X=0.108 $Y=0.0675 $X2=0.108
+ $Y2=0.036
r19 17 15 0.0308642 $w=8.1e-08 $l=2.5e-09 $layer=N_src_drn $thickness=1e-09
+ $X=0.1253 $Y=0.0675 $X2=0.1225 $Y2=0.0675
r20 1 15 0.179012 $w=8.1e-08 $l=1.45e-08 $layer=N_src_drn $thickness=1e-09
+ $X=0.108 $Y=0.0675 $X2=0.1225 $Y2=0.0675
r21 10 1 0.179012 $w=8.1e-08 $l=1.45e-08 $layer=N_src_drn $thickness=1e-09
+ $X=0.0935 $Y=0.0675 $X2=0.108 $Y2=0.0675
r22 16 10 0.0308642 $w=8.1e-08 $l=2.5e-09 $layer=N_src_drn $thickness=1e-09
+ $X=0.0906 $Y=0.0675 $X2=0.0935 $Y2=0.0675
.ends

.subckt PM_NAND4xp75_ASAP7_75t_R%D vss 28 12 18 34 37 40 43 5 1 6 3 4 11 8
c1 1 vss 0.0102647f $X=0.0715 $Y=0.135
c2 3 vss 0.0750431f $X=0.081 $Y=0.0245
c3 4 vss 0.0708274f $X=0.135 $Y=0.135
c4 5 vss 0.0737516f $X=0.189 $Y=0.135
c5 6 vss 0.010554f $X=0.027 $Y=0.036
c6 7 vss 0.00240199f $X=0.027 $Y=0.135
c7 8 vss 0.0105035f $X=0.027 $Y=0.234
c8 9 vss 0.0134788f $X=0.027 $Y=0.1225
c9 10 vss 0.0128361f $X=0.027 $Y=0.172
c10 11 vss 0.00558928f $X=0.0645 $Y=0.135
r1 8 48 3.83327 $w=1.5093e-08 $l=2.15e-08 $layer=M1 $thickness=3.6e-08 $X=0.027
+ $Y=0.234 $X2=0.027 $Y2=0.2125
r2 6 47 3.01711 $w=1.55e-08 $l=1.8e-08 $layer=M1 $thickness=3.6e-08 $X=0.027
+ $Y=0.036 $X2=0.027 $Y2=0.054
r3 10 48 9.44419 $w=1.3e-08 $l=4.05e-08 $layer=M1 $thickness=3.6e-08 $X=0.027
+ $Y=0.172 $X2=0.027 $Y2=0.2125
r4 46 47 2.91487 $w=1.3e-08 $l=1.25e-08 $layer=M1 $thickness=3.6e-08 $X=0.027
+ $Y=0.0665 $X2=0.027 $Y2=0.054
r5 45 46 6.52931 $w=1.3e-08 $l=2.8e-08 $layer=M1 $thickness=3.6e-08 $X=0.027
+ $Y=0.0945 $X2=0.027 $Y2=0.0665
r6 9 45 6.52931 $w=1.3e-08 $l=2.8e-08 $layer=M1 $thickness=3.6e-08 $X=0.027
+ $Y=0.1225 $X2=0.027 $Y2=0.0945
r7 7 30 3.36689 $w=1.53077e-08 $l=1.95e-08 $layer=M1 $thickness=3.6e-08
+ $X=0.027 $Y=0.135 $X2=0.0465 $Y2=0.135
r8 7 9 1.73456 $w=1.66e-08 $l=1.25e-08 $layer=M1 $thickness=3.6e-08 $X=0.027
+ $Y=0.135 $X2=0.027 $Y2=0.1225
r9 7 10 7.44771 $w=1.42162e-08 $l=3.7e-08 $layer=M1 $thickness=3.6e-08 $X=0.027
+ $Y=0.135 $X2=0.027 $Y2=0.172
r10 43 42 16.8368 $w=2.1e-08 $l=4.95e-08 $layer=Gate_1 $thickness=5.6e-08
+ $X=0.189 $Y=0.216 $X2=0.189 $Y2=0.1665
r11 40 41 16.8368 $w=2.1e-08 $l=4.95e-08 $layer=Gate_1 $thickness=5.6e-08
+ $X=0.189 $Y=0.0675 $X2=0.189 $Y2=0.117
r12 5 26 7.07951 $w=1.89474e-08 $layer=LIG $thickness=5.17895e-08 $X=0.189
+ $Y=0.135 $X2=0.189 $Y2=0.135
r13 5 41 6.27555 $w=2.05e-08 $l=1.8e-08 $layer=Gate_1 $thickness=5.6e-08
+ $X=0.189 $Y=0.135 $X2=0.189 $Y2=0.117
r14 5 42 10.8674 $w=2.07143e-08 $l=3.15e-08 $layer=Gate_1 $thickness=5.6e-08
+ $X=0.189 $Y=0.135 $X2=0.189 $Y2=0.1665
r15 37 36 16.8368 $w=2.1e-08 $l=4.95e-08 $layer=Gate_1 $thickness=5.6e-08
+ $X=0.135 $Y=0.216 $X2=0.135 $Y2=0.1665
r16 34 35 16.8368 $w=2.1e-08 $l=4.95e-08 $layer=Gate_1 $thickness=5.6e-08
+ $X=0.135 $Y=0.0675 $X2=0.135 $Y2=0.117
r17 4 24 7.07951 $w=1.89474e-08 $layer=LIG $thickness=5.17895e-08 $X=0.135
+ $Y=0.135 $X2=0.135 $Y2=0.135
r18 4 35 6.27555 $w=2.05e-08 $l=1.8e-08 $layer=Gate_1 $thickness=5.6e-08
+ $X=0.135 $Y=0.135 $X2=0.135 $Y2=0.117
r19 4 36 10.8674 $w=2.07143e-08 $l=3.15e-08 $layer=Gate_1 $thickness=5.6e-08
+ $X=0.135 $Y=0.135 $X2=0.135 $Y2=0.1665
r20 28 11 3.84763 $w=1.3e-08 $l=1.65e-08 $layer=M1 $thickness=3.6e-08 $X=0.081
+ $Y=0.138 $X2=0.0645 $Y2=0.135
r21 11 30 4.19742 $w=1.3e-08 $l=1.8e-08 $layer=M1 $thickness=3.6e-08 $X=0.0645
+ $Y=0.135 $X2=0.0465 $Y2=0.135
r22 25 26 30.1405 $w=1.37815e-08 $l=2.7e-08 $layer=LIG $thickness=4.8e-08
+ $X=0.162 $Y=0.135 $X2=0.189 $Y2=0.135
r23 24 25 30.1405 $w=1.37815e-08 $l=2.7e-08 $layer=LIG $thickness=4.8e-08
+ $X=0.135 $Y=0.135 $X2=0.162 $Y2=0.135
r24 23 24 30.1405 $w=1.37815e-08 $l=2.7e-08 $layer=LIG $thickness=4.8e-08
+ $X=0.108 $Y=0.135 $X2=0.135 $Y2=0.135
r25 21 23 26.4685 $w=1.14914e-08 $l=1.75e-08 $layer=LIG $thickness=4.8e-08
+ $X=0.0905 $Y=0.135 $X2=0.108 $Y2=0.135
r26 20 21 3.67195 $w=1.8e-08 $l=9.5e-09 $layer=LIG $thickness=4.8e-08 $X=0.081
+ $Y=0.135 $X2=0.0905 $Y2=0.135
r27 28 20 19.3796 $a=3.24e-16 $layer=V0LIG $X=0.081 $Y=0.138 $X2=0.081 $Y2=0.135
r28 1 20 3.67195 $w=1.8e-08 $l=9.5e-09 $layer=LIG $thickness=4.8e-08 $X=0.0715
+ $Y=0.135 $X2=0.081 $Y2=0.135
r29 18 17 14.6259 $w=2.1e-08 $l=4.3e-08 $layer=Gate_1 $thickness=5.6e-08
+ $X=0.081 $Y=0.216 $X2=0.081 $Y2=0.173
r30 16 17 7.65311 $w=2.1e-08 $l=2.25e-08 $layer=Gate_1 $thickness=5.6e-08
+ $X=0.081 $Y=0.1505 $X2=0.081 $Y2=0.173
r31 15 16 5.4252 $w=2.04194e-08 $l=1.55e-08 $layer=Gate_1 $thickness=5.6e-08
+ $X=0.081 $Y=0.135 $X2=0.081 $Y2=0.1505
r32 15 21 3.40757 $w=1.98947e-08 $l=9.5e-09 $layer=Gate_1
+ $thickness=5.55789e-08 $X=0.081 $Y=0.135 $X2=0.0905 $Y2=0.135
r33 15 20 6.69299 $w=1.9e-08 $layer=LIG $thickness=5.2e-08 $X=0.081 $Y=0.135
+ $X2=0.081 $Y2=0.135
r34 14 15 5.4252 $w=2.04194e-08 $l=1.55e-08 $layer=Gate_1 $thickness=5.6e-08
+ $X=0.081 $Y=0.1195 $X2=0.081 $Y2=0.135
r35 13 14 3.06124 $w=2.1e-08 $l=9e-09 $layer=Gate_1 $thickness=5.6e-08 $X=0.081
+ $Y=0.1105 $X2=0.081 $Y2=0.1195
r36 12 13 14.6259 $w=2.1e-08 $l=4.3e-08 $layer=Gate_1 $thickness=5.6e-08
+ $X=0.081 $Y=0.0675 $X2=0.081 $Y2=0.1105
r37 12 3 14.6259 $w=2.1e-08 $l=4.3e-08 $layer=Gate_1 $thickness=5.6e-08
+ $X=0.081 $Y=0.0675 $X2=0.081 $Y2=0.0245
.ends

.subckt PM_NAND4xp75_ASAP7_75t_R%B vss 35 9 13 24 27 30 33 1 3 7 5 6 4 8
c1 1 vss 0.0168558f $X=0.405 $Y=0.135
c2 3 vss 0.0397133f $X=0.405 $Y=0.0245
c3 4 vss 0.0393041f $X=0.459 $Y=0.135
c4 5 vss 0.0395916f $X=0.513 $Y=0.135
c5 6 vss 0.00731008f $X=0.513 $Y=0.11
c6 7 vss 0.00779751f $X=0.54 $Y=0.1035
c7 8 vss 0.00867054f $X=0.513 $Y=0.1225
r1 7 37 1.30447 $w=1.47857e-08 $l=1.49833e-08 $layer=M1 $thickness=3.6e-08
+ $X=0.54 $Y=0.1035 $X2=0.5265 $Y2=0.11
r2 6 8 1.73456 $w=1.66e-08 $l=1.25e-08 $layer=M1 $thickness=3.6e-08 $X=0.513
+ $Y=0.11 $X2=0.513 $Y2=0.1225
r3 6 37 1.96775 $w=1.63333e-08 $l=1.35e-08 $layer=M1 $thickness=3.6e-08
+ $X=0.513 $Y=0.11 $X2=0.5265 $Y2=0.11
r4 35 8 2.91487 $w=1.3e-08 $l=1.25e-08 $layer=M1 $thickness=3.6e-08 $X=0.521
+ $Y=0.138 $X2=0.513 $Y2=0.1225
r5 33 32 16.6668 $w=2.1e-08 $l=4.9e-08 $layer=Gate_1 $thickness=5.6e-08
+ $X=0.513 $Y=0.216 $X2=0.513 $Y2=0.167
r6 30 31 16.6668 $w=2.1e-08 $l=4.9e-08 $layer=Gate_1 $thickness=5.6e-08
+ $X=0.513 $Y=0.0675 $X2=0.513 $Y2=0.1165
r7 5 20 6.4296 $w=2e-08 $layer=Gate_1 $thickness=5.22105e-08 $X=0.513 $Y=0.135
+ $X2=0.513 $Y2=0.135
r8 5 31 6.46262 $w=2.04595e-08 $l=1.85e-08 $layer=Gate_1 $thickness=5.6e-08
+ $X=0.513 $Y=0.135 $X2=0.513 $Y2=0.1165
r9 5 32 11.0545 $w=2.06875e-08 $l=3.2e-08 $layer=Gate_1 $thickness=5.6e-08
+ $X=0.513 $Y=0.135 $X2=0.513 $Y2=0.167
r10 27 26 16.6668 $w=2.1e-08 $l=4.9e-08 $layer=Gate_1 $thickness=5.6e-08
+ $X=0.459 $Y=0.216 $X2=0.459 $Y2=0.167
r11 24 25 16.6668 $w=2.1e-08 $l=4.9e-08 $layer=Gate_1 $thickness=5.6e-08
+ $X=0.459 $Y=0.0675 $X2=0.459 $Y2=0.1165
r12 4 17 6.74717 $w=2e-08 $layer=Gate_1 $thickness=5.2e-08 $X=0.459 $Y=0.135
+ $X2=0.459 $Y2=0.135
r13 4 25 6.46262 $w=2.04595e-08 $l=1.85e-08 $layer=Gate_1 $thickness=5.6e-08
+ $X=0.459 $Y=0.135 $X2=0.459 $Y2=0.1165
r14 4 26 11.0545 $w=2.06875e-08 $l=3.2e-08 $layer=Gate_1 $thickness=5.6e-08
+ $X=0.459 $Y=0.135 $X2=0.459 $Y2=0.167
r15 35 20 19.3796 $a=3.24e-16 $layer=V0LIG $X=0.521 $Y=0.138 $X2=0.513 $Y2=0.135
r16 19 20 3.01694 $w=2e-08 $l=9.5e-09 $layer=LIG $thickness=4.8e-08 $X=0.5035
+ $Y=0.135 $X2=0.513 $Y2=0.135
r17 18 19 17.097 $w=1.34914e-08 $l=1.75e-08 $layer=LIG $thickness=4.8e-08
+ $X=0.486 $Y=0.135 $X2=0.5035 $Y2=0.135
r18 17 18 20.114 $w=1.57815e-08 $l=2.7e-08 $layer=LIG $thickness=4.8e-08
+ $X=0.459 $Y=0.135 $X2=0.486 $Y2=0.135
r19 16 17 20.114 $w=1.57815e-08 $l=2.7e-08 $layer=LIG $thickness=4.8e-08
+ $X=0.432 $Y=0.135 $X2=0.459 $Y2=0.135
r20 1 11 6.74717 $w=2e-08 $layer=Gate_1 $thickness=5.2e-08 $X=0.405 $Y=0.135
+ $X2=0.405 $Y2=0.135
r21 1 16 20.114 $w=1.57815e-08 $l=2.7e-08 $layer=LIG $thickness=4.8e-08
+ $X=0.405 $Y=0.135 $X2=0.432 $Y2=0.135
r22 13 12 16.6668 $w=2.1e-08 $l=4.9e-08 $layer=Gate_1 $thickness=5.6e-08
+ $X=0.405 $Y=0.216 $X2=0.405 $Y2=0.167
r23 11 12 11.0545 $w=2.06875e-08 $l=3.2e-08 $layer=Gate_1 $thickness=5.6e-08
+ $X=0.405 $Y=0.135 $X2=0.405 $Y2=0.167
r24 10 11 6.46262 $w=2.04595e-08 $l=1.85e-08 $layer=Gate_1 $thickness=5.6e-08
+ $X=0.405 $Y=0.1165 $X2=0.405 $Y2=0.135
r25 9 10 16.6668 $w=2.1e-08 $l=4.9e-08 $layer=Gate_1 $thickness=5.6e-08
+ $X=0.405 $Y=0.0675 $X2=0.405 $Y2=0.1165
r26 9 3 14.6259 $w=2.1e-08 $l=4.3e-08 $layer=Gate_1 $thickness=5.6e-08 $X=0.405
+ $Y=0.0675 $X2=0.405 $Y2=0.0245
.ends

.subckt PM_NAND4xp75_ASAP7_75t_R%A vss 20 7 11 23 26 30 34 3 6 1 5 4
c1 1 vss 0.0196081f $X=0.621 $Y=0.135
c2 3 vss 0.0414634f $X=0.567 $Y=0.135
c3 4 vss 0.0403058f $X=0.621 $Y=0.0245
c4 5 vss 0.0435553f $X=0.675 $Y=0.135
c5 6 vss 0.0100543f $X=0.621 $Y=0.1125
r1 34 33 14.6259 $w=2.1e-08 $l=4.3e-08 $layer=Gate_1 $thickness=5.6e-08
+ $X=0.675 $Y=0.216 $X2=0.675 $Y2=0.173
r2 32 33 7.48304 $w=2.1e-08 $l=2.2e-08 $layer=Gate_1 $thickness=5.6e-08
+ $X=0.675 $Y=0.151 $X2=0.675 $Y2=0.173
r3 30 31 14.6259 $w=2.1e-08 $l=4.3e-08 $layer=Gate_1 $thickness=5.6e-08
+ $X=0.675 $Y=0.0675 $X2=0.675 $Y2=0.1105
r4 28 31 2.89117 $w=2.1e-08 $l=8.5e-09 $layer=Gate_1 $thickness=5.6e-08
+ $X=0.675 $Y=0.119 $X2=0.675 $Y2=0.1105
r5 5 17 6.74717 $w=2e-08 $layer=Gate_1 $thickness=5.2e-08 $X=0.675 $Y=0.135
+ $X2=0.675 $Y2=0.135
r6 5 28 5.61228 $w=2.0375e-08 $l=1.6e-08 $layer=Gate_1 $thickness=5.6e-08
+ $X=0.675 $Y=0.135 $X2=0.675 $Y2=0.119
r7 5 32 5.61228 $w=2.0375e-08 $l=1.6e-08 $layer=Gate_1 $thickness=5.6e-08
+ $X=0.675 $Y=0.135 $X2=0.675 $Y2=0.151
r8 26 25 16.6668 $w=2.1e-08 $l=4.9e-08 $layer=Gate_1 $thickness=5.6e-08
+ $X=0.567 $Y=0.216 $X2=0.567 $Y2=0.167
r9 23 24 16.6668 $w=2.1e-08 $l=4.9e-08 $layer=Gate_1 $thickness=5.6e-08
+ $X=0.567 $Y=0.0675 $X2=0.567 $Y2=0.1165
r10 3 14 6.74717 $w=2e-08 $layer=Gate_1 $thickness=5.2e-08 $X=0.567 $Y=0.135
+ $X2=0.567 $Y2=0.135
r11 3 24 6.46262 $w=2.04595e-08 $l=1.85e-08 $layer=Gate_1 $thickness=5.6e-08
+ $X=0.567 $Y=0.135 $X2=0.567 $Y2=0.1165
r12 3 25 11.0545 $w=2.06875e-08 $l=3.2e-08 $layer=Gate_1 $thickness=5.6e-08
+ $X=0.567 $Y=0.135 $X2=0.567 $Y2=0.167
r13 20 19 2.91487 $w=1.3e-08 $l=1.25e-08 $layer=M1 $thickness=3.6e-08 $X=0.621
+ $Y=0.138 $X2=0.621 $Y2=0.1225
r14 6 19 2.3319 $w=1.3e-08 $l=1e-08 $layer=M1 $thickness=3.6e-08 $X=0.621
+ $Y=0.1125 $X2=0.621 $Y2=0.1225
r15 16 17 20.114 $w=1.57815e-08 $l=2.7e-08 $layer=LIG $thickness=4.8e-08
+ $X=0.648 $Y=0.135 $X2=0.675 $Y2=0.135
r16 13 14 20.114 $w=1.57815e-08 $l=2.7e-08 $layer=LIG $thickness=4.8e-08
+ $X=0.594 $Y=0.135 $X2=0.567 $Y2=0.135
r17 1 9 6.74717 $w=2e-08 $layer=Gate_1 $thickness=5.2e-08 $X=0.621 $Y=0.135
+ $X2=0.621 $Y2=0.135
r18 1 13 20.114 $w=1.57815e-08 $l=2.7e-08 $layer=LIG $thickness=4.8e-08
+ $X=0.621 $Y=0.135 $X2=0.594 $Y2=0.135
r19 1 16 20.114 $w=1.57815e-08 $l=2.7e-08 $layer=LIG $thickness=4.8e-08
+ $X=0.621 $Y=0.135 $X2=0.648 $Y2=0.135
r20 20 1 19.3796 $a=3.24e-16 $layer=V0LIG $X=0.621 $Y=0.138 $X2=0.621 $Y2=0.135
r21 11 10 16.6668 $w=2.1e-08 $l=4.9e-08 $layer=Gate_1 $thickness=5.6e-08
+ $X=0.621 $Y=0.216 $X2=0.621 $Y2=0.167
r22 9 10 11.0545 $w=2.06875e-08 $l=3.2e-08 $layer=Gate_1 $thickness=5.6e-08
+ $X=0.621 $Y=0.135 $X2=0.621 $Y2=0.167
r23 8 9 6.46262 $w=2.04595e-08 $l=1.85e-08 $layer=Gate_1 $thickness=5.6e-08
+ $X=0.621 $Y=0.1165 $X2=0.621 $Y2=0.135
r24 7 8 16.6668 $w=2.1e-08 $l=4.9e-08 $layer=Gate_1 $thickness=5.6e-08 $X=0.621
+ $Y=0.0675 $X2=0.621 $Y2=0.1165
r25 7 4 14.6259 $w=2.1e-08 $l=4.3e-08 $layer=Gate_1 $thickness=5.6e-08 $X=0.621
+ $Y=0.0675 $X2=0.621 $Y2=0.0245
.ends

.subckt PM_NAND4xp75_ASAP7_75t_R%9 vss 16 17 29 30 33 34 10 2 1 13 11 12 3
c1 1 vss 0.00397755f $X=0.432 $Y=0.0675
c2 2 vss 0.0036498f $X=0.54 $Y=0.0675
c3 3 vss 0.0038358f $X=0.648 $Y=0.0675
c4 10 vss 0.00186739f $X=0.4175 $Y=0.0675
c5 11 vss 0.00190843f $X=0.5255 $Y=0.0675
c6 12 vss 0.00189102f $X=0.6335 $Y=0.0675
c7 13 vss 0.0192654f $X=0.6095 $Y=0.036
r1 34 32 0.0308642 $w=8.1e-08 $l=2.5e-09 $layer=N_src_drn $thickness=1e-09
+ $X=0.4493 $Y=0.0675 $X2=0.4465 $Y2=0.0675
r2 1 32 0.179012 $w=8.1e-08 $l=1.45e-08 $layer=N_src_drn $thickness=1e-09
+ $X=0.432 $Y=0.0675 $X2=0.4465 $Y2=0.0675
r3 10 1 0.179012 $w=8.1e-08 $l=1.45e-08 $layer=N_src_drn $thickness=1e-09
+ $X=0.4175 $Y=0.0675 $X2=0.432 $Y2=0.0675
r4 33 10 0.0308642 $w=8.1e-08 $l=2.5e-09 $layer=N_src_drn $thickness=1e-09
+ $X=0.4146 $Y=0.0675 $X2=0.4175 $Y2=0.0675
r5 30 28 0.0308642 $w=8.1e-08 $l=2.5e-09 $layer=N_src_drn $thickness=1e-09
+ $X=0.5573 $Y=0.0675 $X2=0.5545 $Y2=0.0675
r6 2 28 0.179012 $w=8.1e-08 $l=1.45e-08 $layer=N_src_drn $thickness=1e-09
+ $X=0.54 $Y=0.0675 $X2=0.5545 $Y2=0.0675
r7 11 2 0.179012 $w=8.1e-08 $l=1.45e-08 $layer=N_src_drn $thickness=1e-09
+ $X=0.5255 $Y=0.0675 $X2=0.54 $Y2=0.0675
r8 29 11 0.0308642 $w=8.1e-08 $l=2.5e-09 $layer=N_src_drn $thickness=1e-09
+ $X=0.5226 $Y=0.0675 $X2=0.5255 $Y2=0.0675
r9 1 25 19.3796 $a=3.24e-16 $layer=V0LISD $X=0.432 $Y=0.0675 $X2=0.432 $Y2=0.036
r10 2 21 19.3796 $a=3.24e-16 $layer=V0LISD $X=0.54 $Y=0.0675 $X2=0.54 $Y2=0.036
r11 25 26 8.86121 $w=1.3e-08 $l=3.8e-08 $layer=M1 $thickness=3.6e-08 $X=0.432
+ $Y=0.036 $X2=0.47 $Y2=0.036
r12 23 26 7.34548 $w=1.3e-08 $l=3.15e-08 $layer=M1 $thickness=3.6e-08 $X=0.5015
+ $Y=0.036 $X2=0.47 $Y2=0.036
r13 22 23 3.73104 $w=1.3e-08 $l=1.6e-08 $layer=M1 $thickness=3.6e-08 $X=0.5175
+ $Y=0.036 $X2=0.5015 $Y2=0.036
r14 21 22 5.24677 $w=1.3e-08 $l=2.25e-08 $layer=M1 $thickness=3.6e-08 $X=0.54
+ $Y=0.036 $X2=0.5175 $Y2=0.036
r15 20 21 5.71315 $w=1.3e-08 $l=2.45e-08 $layer=M1 $thickness=3.6e-08 $X=0.5645
+ $Y=0.036 $X2=0.54 $Y2=0.036
r16 13 18 8.97781 $w=1.3e-08 $l=3.85e-08 $layer=M1 $thickness=3.6e-08 $X=0.6095
+ $Y=0.036 $X2=0.648 $Y2=0.036
r17 13 20 10.4935 $w=1.3e-08 $l=4.5e-08 $layer=M1 $thickness=3.6e-08 $X=0.6095
+ $Y=0.036 $X2=0.5645 $Y2=0.036
r18 3 18 19.3796 $a=3.24e-16 $layer=V0LISD $X=0.648 $Y=0.0675 $X2=0.648
+ $Y2=0.036
r19 17 15 0.0308642 $w=8.1e-08 $l=2.5e-09 $layer=N_src_drn $thickness=1e-09
+ $X=0.6653 $Y=0.0675 $X2=0.6625 $Y2=0.0675
r20 3 15 0.179012 $w=8.1e-08 $l=1.45e-08 $layer=N_src_drn $thickness=1e-09
+ $X=0.648 $Y=0.0675 $X2=0.6625 $Y2=0.0675
r21 12 3 0.179012 $w=8.1e-08 $l=1.45e-08 $layer=N_src_drn $thickness=1e-09
+ $X=0.6335 $Y=0.0675 $X2=0.648 $Y2=0.0675
r22 16 12 0.0308642 $w=8.1e-08 $l=2.5e-09 $layer=N_src_drn $thickness=1e-09
+ $X=0.6306 $Y=0.0675 $X2=0.6335 $Y2=0.0675
.ends

.subckt PM_NAND4xp75_ASAP7_75t_R%Y vss 50 40 41 54 78 79 82 83 86 87 90 91 94
+ 95 98 99 28 1 35 2 27 29 3 5 31 30 4 36 26 6 32 8 37 7 25
c1 1 vss 0.00743537f $X=0.108 $Y=0.216
c2 2 vss 0.00709555f $X=0.216 $Y=0.216
c3 3 vss 0.00761789f $X=0.324 $Y=0.216
c4 4 vss 0.00731369f $X=0.432 $Y=0.216
c5 5 vss 0.00708077f $X=0.54 $Y=0.216
c6 6 vss 0.00276001f $X=0.594 $Y=0.0675
c7 7 vss 0.00724507f $X=0.648 $Y=0.216
c8 8 vss 0.00496555f $X=0.702 $Y=0.0675
c9 25 vss 0.00211654f $X=0.5795 $Y=0.0675
c10 26 vss 0.0356353f $X=0.6875 $Y=0.0675
c11 27 vss 0.00374334f $X=0.0935 $Y=0.216
c12 28 vss 0.00355938f $X=0.2015 $Y=0.216
c13 29 vss 0.00369402f $X=0.3095 $Y=0.216
c14 30 vss 0.00368269f $X=0.4175 $Y=0.216
c15 31 vss 0.00354229f $X=0.5255 $Y=0.216
c16 32 vss 0.0037259f $X=0.6335 $Y=0.216
c17 33 vss 0.00134432f $X=0.729 $Y=0.072
c18 34 vss 0.00290493f $X=0.729 $Y=0.234
c19 35 vss 0.0545185f $X=0.6345 $Y=0.234
c20 36 vss 0.00197998f $X=0.5825 $Y=0.072
c21 37 vss 0.00495475f $X=0.729 $Y=0.0935
r1 99 97 0.0462963 $w=5.4e-08 $l=2.5e-09 $layer=P_src_drn $thickness=1e-09
+ $X=0.1253 $Y=0.216 $X2=0.1225 $Y2=0.216
r2 1 97 0.268519 $w=5.4e-08 $l=1.45e-08 $layer=P_src_drn $thickness=1e-09
+ $X=0.108 $Y=0.216 $X2=0.1225 $Y2=0.216
r3 27 1 0.268519 $w=5.4e-08 $l=1.45e-08 $layer=P_src_drn $thickness=1e-09
+ $X=0.0935 $Y=0.216 $X2=0.108 $Y2=0.216
r4 98 27 0.0462963 $w=5.4e-08 $l=2.5e-09 $layer=P_src_drn $thickness=1e-09
+ $X=0.0906 $Y=0.216 $X2=0.0935 $Y2=0.216
r5 95 93 0.0462963 $w=5.4e-08 $l=2.5e-09 $layer=P_src_drn $thickness=1e-09
+ $X=0.2333 $Y=0.216 $X2=0.2305 $Y2=0.216
r6 2 93 0.268519 $w=5.4e-08 $l=1.45e-08 $layer=P_src_drn $thickness=1e-09
+ $X=0.216 $Y=0.216 $X2=0.2305 $Y2=0.216
r7 28 2 0.268519 $w=5.4e-08 $l=1.45e-08 $layer=P_src_drn $thickness=1e-09
+ $X=0.2015 $Y=0.216 $X2=0.216 $Y2=0.216
r8 94 28 0.0462963 $w=5.4e-08 $l=2.5e-09 $layer=P_src_drn $thickness=1e-09
+ $X=0.1986 $Y=0.216 $X2=0.2015 $Y2=0.216
r9 91 89 0.0462963 $w=5.4e-08 $l=2.5e-09 $layer=P_src_drn $thickness=1e-09
+ $X=0.4493 $Y=0.216 $X2=0.4465 $Y2=0.216
r10 4 89 0.268519 $w=5.4e-08 $l=1.45e-08 $layer=P_src_drn $thickness=1e-09
+ $X=0.432 $Y=0.216 $X2=0.4465 $Y2=0.216
r11 30 4 0.268519 $w=5.4e-08 $l=1.45e-08 $layer=P_src_drn $thickness=1e-09
+ $X=0.4175 $Y=0.216 $X2=0.432 $Y2=0.216
r12 90 30 0.0462963 $w=5.4e-08 $l=2.5e-09 $layer=P_src_drn $thickness=1e-09
+ $X=0.4146 $Y=0.216 $X2=0.4175 $Y2=0.216
r13 87 85 0.0462963 $w=5.4e-08 $l=2.5e-09 $layer=P_src_drn $thickness=1e-09
+ $X=0.3413 $Y=0.216 $X2=0.3385 $Y2=0.216
r14 3 85 0.268519 $w=5.4e-08 $l=1.45e-08 $layer=P_src_drn $thickness=1e-09
+ $X=0.324 $Y=0.216 $X2=0.3385 $Y2=0.216
r15 29 3 0.268519 $w=5.4e-08 $l=1.45e-08 $layer=P_src_drn $thickness=1e-09
+ $X=0.3095 $Y=0.216 $X2=0.324 $Y2=0.216
r16 86 29 0.0462963 $w=5.4e-08 $l=2.5e-09 $layer=P_src_drn $thickness=1e-09
+ $X=0.3066 $Y=0.216 $X2=0.3095 $Y2=0.216
r17 83 81 0.0462963 $w=5.4e-08 $l=2.5e-09 $layer=P_src_drn $thickness=1e-09
+ $X=0.5573 $Y=0.216 $X2=0.5545 $Y2=0.216
r18 5 81 0.268519 $w=5.4e-08 $l=1.45e-08 $layer=P_src_drn $thickness=1e-09
+ $X=0.54 $Y=0.216 $X2=0.5545 $Y2=0.216
r19 31 5 0.268519 $w=5.4e-08 $l=1.45e-08 $layer=P_src_drn $thickness=1e-09
+ $X=0.5255 $Y=0.216 $X2=0.54 $Y2=0.216
r20 82 31 0.0462963 $w=5.4e-08 $l=2.5e-09 $layer=P_src_drn $thickness=1e-09
+ $X=0.5226 $Y=0.216 $X2=0.5255 $Y2=0.216
r21 79 77 0.0462963 $w=5.4e-08 $l=2.5e-09 $layer=P_src_drn $thickness=1e-09
+ $X=0.6653 $Y=0.216 $X2=0.6625 $Y2=0.216
r22 7 77 0.268519 $w=5.4e-08 $l=1.45e-08 $layer=P_src_drn $thickness=1e-09
+ $X=0.648 $Y=0.216 $X2=0.6625 $Y2=0.216
r23 32 7 0.268519 $w=5.4e-08 $l=1.45e-08 $layer=P_src_drn $thickness=1e-09
+ $X=0.6335 $Y=0.216 $X2=0.648 $Y2=0.216
r24 78 32 0.0462963 $w=5.4e-08 $l=2.5e-09 $layer=P_src_drn $thickness=1e-09
+ $X=0.6306 $Y=0.216 $X2=0.6335 $Y2=0.216
r25 1 73 19.3796 $a=3.24e-16 $layer=V0LISD $X=0.108 $Y=0.216 $X2=0.108 $Y2=0.234
r26 2 71 19.3796 $a=3.24e-16 $layer=V0LISD $X=0.216 $Y=0.216 $X2=0.216 $Y2=0.234
r27 4 67 19.3796 $a=3.24e-16 $layer=V0LISD $X=0.432 $Y=0.216 $X2=0.432 $Y2=0.234
r28 3 65 19.3796 $a=3.24e-16 $layer=V0LISD $X=0.324 $Y=0.216 $X2=0.324 $Y2=0.234
r29 5 60 19.3796 $a=3.24e-16 $layer=V0LISD $X=0.54 $Y=0.216 $X2=0.54 $Y2=0.234
r30 7 55 19.3796 $a=3.24e-16 $layer=V0LISD $X=0.648 $Y=0.216 $X2=0.648 $Y2=0.234
r31 73 74 12.5922 $w=1.3e-08 $l=5.4e-08 $layer=M1 $thickness=3.6e-08 $X=0.108
+ $Y=0.234 $X2=0.162 $Y2=0.234
r32 71 74 12.5922 $w=1.3e-08 $l=5.4e-08 $layer=M1 $thickness=3.6e-08 $X=0.216
+ $Y=0.234 $X2=0.162 $Y2=0.234
r33 70 71 9.44419 $w=1.3e-08 $l=4.05e-08 $layer=M1 $thickness=3.6e-08 $X=0.2565
+ $Y=0.234 $X2=0.216 $Y2=0.234
r34 69 70 9.44419 $w=1.3e-08 $l=4.05e-08 $layer=M1 $thickness=3.6e-08 $X=0.297
+ $Y=0.234 $X2=0.2565 $Y2=0.234
r35 67 68 8.86121 $w=1.3e-08 $l=3.8e-08 $layer=M1 $thickness=3.6e-08 $X=0.432
+ $Y=0.234 $X2=0.47 $Y2=0.234
r36 66 67 12.5922 $w=1.3e-08 $l=5.4e-08 $layer=M1 $thickness=3.6e-08 $X=0.378
+ $Y=0.234 $X2=0.432 $Y2=0.234
r37 65 66 12.5922 $w=1.3e-08 $l=5.4e-08 $layer=M1 $thickness=3.6e-08 $X=0.324
+ $Y=0.234 $X2=0.378 $Y2=0.234
r38 64 65 3.14806 $w=1.3e-08 $l=1.35e-08 $layer=M1 $thickness=3.6e-08 $X=0.3105
+ $Y=0.234 $X2=0.324 $Y2=0.234
r39 64 69 3.14806 $w=1.3e-08 $l=1.35e-08 $layer=M1 $thickness=3.6e-08 $X=0.3105
+ $Y=0.234 $X2=0.297 $Y2=0.234
r40 63 68 7.34548 $w=1.3e-08 $l=3.15e-08 $layer=M1 $thickness=3.6e-08 $X=0.5015
+ $Y=0.234 $X2=0.47 $Y2=0.234
r41 62 63 2.68168 $w=1.3e-08 $l=1.15e-08 $layer=M1 $thickness=3.6e-08 $X=0.513
+ $Y=0.234 $X2=0.5015 $Y2=0.234
r42 61 62 3.14806 $w=1.3e-08 $l=1.35e-08 $layer=M1 $thickness=3.6e-08 $X=0.5265
+ $Y=0.234 $X2=0.513 $Y2=0.234
r43 60 61 3.14806 $w=1.3e-08 $l=1.35e-08 $layer=M1 $thickness=3.6e-08 $X=0.54
+ $Y=0.234 $X2=0.5265 $Y2=0.234
r44 59 60 5.71315 $w=1.3e-08 $l=2.45e-08 $layer=M1 $thickness=3.6e-08 $X=0.5645
+ $Y=0.234 $X2=0.54 $Y2=0.234
r45 58 59 7.34548 $w=1.3e-08 $l=3.15e-08 $layer=M1 $thickness=3.6e-08 $X=0.596
+ $Y=0.234 $X2=0.5645 $Y2=0.234
r46 57 58 5.82974 $w=1.3e-08 $l=2.5e-08 $layer=M1 $thickness=3.6e-08 $X=0.621
+ $Y=0.234 $X2=0.596 $Y2=0.234
r47 55 56 9.44419 $w=1.3e-08 $l=4.05e-08 $layer=M1 $thickness=3.6e-08 $X=0.648
+ $Y=0.234 $X2=0.6885 $Y2=0.234
r48 35 55 3.14806 $w=1.3e-08 $l=1.35e-08 $layer=M1 $thickness=3.6e-08 $X=0.6345
+ $Y=0.234 $X2=0.648 $Y2=0.234
r49 35 57 3.14806 $w=1.3e-08 $l=1.35e-08 $layer=M1 $thickness=3.6e-08 $X=0.6345
+ $Y=0.234 $X2=0.621 $Y2=0.234
r50 34 52 3.36447 $w=1.71023e-08 $l=2.15e-08 $layer=M1 $thickness=3.6e-08
+ $X=0.729 $Y=0.234 $X2=0.729 $Y2=0.2125
r51 34 56 7.79507 $w=1.41111e-08 $l=4.05e-08 $layer=M1 $thickness=3.6e-08
+ $X=0.729 $Y=0.234 $X2=0.6885 $Y2=0.234
r52 26 8 0.154321 $w=8.1e-08 $l=1.25e-08 $layer=N_src_drn $thickness=1e-09
+ $X=0.6875 $Y=0.0675 $X2=0.702 $Y2=0.0675
r53 54 26 0.0308642 $w=8.1e-08 $l=2.5e-09 $layer=N_src_drn $thickness=1e-09
+ $X=0.6846 $Y=0.0675 $X2=0.6875 $Y2=0.0675
r54 51 52 9.1527 $w=1.3e-08 $l=3.93e-08 $layer=M1 $thickness=3.6e-08 $X=0.729
+ $Y=0.1732 $X2=0.729 $Y2=0.2125
r55 50 51 6.35442 $w=1.3e-08 $l=2.72e-08 $layer=M1 $thickness=3.6e-08 $X=0.732
+ $Y=0.146 $X2=0.729 $Y2=0.1732
r56 50 49 4.72209 $w=1.3e-08 $l=2.03e-08 $layer=M1 $thickness=3.6e-08 $X=0.732
+ $Y=0.146 $X2=0.729 $Y2=0.1257
r57 37 49 7.52037 $w=1.3e-08 $l=3.22e-08 $layer=M1 $thickness=3.6e-08 $X=0.729
+ $Y=0.0935 $X2=0.729 $Y2=0.1257
r58 8 47 19.3796 $a=3.24e-16 $layer=V0LISD $X=0.702 $Y=0.0675 $X2=0.703
+ $Y2=0.072
r59 33 48 1.38235 $w=1.64615e-08 $l=1.3e-08 $layer=M1 $thickness=3.6e-08
+ $X=0.729 $Y=0.072 $X2=0.716 $Y2=0.072
r60 33 37 3.36447 $w=1.71023e-08 $l=2.15e-08 $layer=M1 $thickness=3.6e-08
+ $X=0.729 $Y=0.072 $X2=0.729 $Y2=0.0935
r61 47 48 3.03147 $w=1.3e-08 $l=1.3e-08 $layer=M1 $thickness=3.6e-08 $X=0.703
+ $Y=0.072 $X2=0.716 $Y2=0.072
r62 46 47 5.36336 $w=1.3e-08 $l=2.3e-08 $layer=M1 $thickness=3.6e-08 $X=0.68
+ $Y=0.072 $X2=0.703 $Y2=0.072
r63 45 46 7.46207 $w=1.3e-08 $l=3.2e-08 $layer=M1 $thickness=3.6e-08 $X=0.648
+ $Y=0.072 $X2=0.68 $Y2=0.072
r64 44 45 6.29612 $w=1.3e-08 $l=2.7e-08 $layer=M1 $thickness=3.6e-08 $X=0.621
+ $Y=0.072 $X2=0.648 $Y2=0.072
r65 43 44 3.14806 $w=1.3e-08 $l=1.35e-08 $layer=M1 $thickness=3.6e-08 $X=0.6075
+ $Y=0.072 $X2=0.621 $Y2=0.072
r66 42 43 3.14806 $w=1.3e-08 $l=1.35e-08 $layer=M1 $thickness=3.6e-08 $X=0.594
+ $Y=0.072 $X2=0.6075 $Y2=0.072
r67 36 42 2.68168 $w=1.3e-08 $l=1.15e-08 $layer=M1 $thickness=3.6e-08 $X=0.5825
+ $Y=0.072 $X2=0.594 $Y2=0.072
r68 6 42 19.3796 $a=3.24e-16 $layer=V0LISD $X=0.594 $Y=0.0675 $X2=0.594
+ $Y2=0.072
r69 40 39 0.0308642 $w=8.1e-08 $l=2.5e-09 $layer=N_src_drn $thickness=1e-09
+ $X=0.6113 $Y=0.0675 $X2=0.6085 $Y2=0.0675
r70 6 39 0.179012 $w=8.1e-08 $l=1.45e-08 $layer=N_src_drn $thickness=1e-09
+ $X=0.594 $Y=0.0675 $X2=0.6085 $Y2=0.0675
r71 25 6 0.179012 $w=8.1e-08 $l=1.45e-08 $layer=N_src_drn $thickness=1e-09
+ $X=0.5795 $Y=0.0675 $X2=0.594 $Y2=0.0675
r72 41 25 0.0308642 $w=8.1e-08 $l=2.5e-09 $layer=N_src_drn $thickness=1e-09
+ $X=0.5766 $Y=0.0675 $X2=0.5795 $Y2=0.0675
.ends

.subckt PM_NAND4xp75_ASAP7_75t_R%8 vss 16 17 29 30 33 34 10 13 1 11 12 3 2
c1 1 vss 0.00288592f $X=0.27 $Y=0.0675
c2 2 vss 0.00264799f $X=0.378 $Y=0.0675
c3 3 vss 0.00280412f $X=0.486 $Y=0.0675
c4 10 vss 0.00192706f $X=0.2555 $Y=0.0675
c5 11 vss 0.00198896f $X=0.3635 $Y=0.0675
c6 12 vss 0.00180935f $X=0.4715 $Y=0.0675
c7 13 vss 0.00352269f $X=0.2585 $Y=0.072
r1 34 32 0.0308642 $w=8.1e-08 $l=2.5e-09 $layer=N_src_drn $thickness=1e-09
+ $X=0.5033 $Y=0.0675 $X2=0.5005 $Y2=0.0675
r2 3 32 0.179012 $w=8.1e-08 $l=1.45e-08 $layer=N_src_drn $thickness=1e-09
+ $X=0.486 $Y=0.0675 $X2=0.5005 $Y2=0.0675
r3 12 3 0.179012 $w=8.1e-08 $l=1.45e-08 $layer=N_src_drn $thickness=1e-09
+ $X=0.4715 $Y=0.0675 $X2=0.486 $Y2=0.0675
r4 33 12 0.0308642 $w=8.1e-08 $l=2.5e-09 $layer=N_src_drn $thickness=1e-09
+ $X=0.4686 $Y=0.0675 $X2=0.4715 $Y2=0.0675
r5 30 28 0.0308642 $w=8.1e-08 $l=2.5e-09 $layer=N_src_drn $thickness=1e-09
+ $X=0.3953 $Y=0.0675 $X2=0.3925 $Y2=0.0675
r6 2 28 0.179012 $w=8.1e-08 $l=1.45e-08 $layer=N_src_drn $thickness=1e-09
+ $X=0.378 $Y=0.0675 $X2=0.3925 $Y2=0.0675
r7 11 2 0.179012 $w=8.1e-08 $l=1.45e-08 $layer=N_src_drn $thickness=1e-09
+ $X=0.3635 $Y=0.0675 $X2=0.378 $Y2=0.0675
r8 29 11 0.0308642 $w=8.1e-08 $l=2.5e-09 $layer=N_src_drn $thickness=1e-09
+ $X=0.3606 $Y=0.0675 $X2=0.3635 $Y2=0.0675
r9 3 25 19.3796 $a=3.24e-16 $layer=V0LISD $X=0.486 $Y=0.0675 $X2=0.485 $Y2=0.072
r10 2 22 19.3796 $a=3.24e-16 $layer=V0LISD $X=0.378 $Y=0.0675 $X2=0.378
+ $Y2=0.072
r11 24 25 9.56078 $w=1.3e-08 $l=4.1e-08 $layer=M1 $thickness=3.6e-08 $X=0.444
+ $Y=0.072 $X2=0.485 $Y2=0.072
r12 23 24 10.3769 $w=1.3e-08 $l=4.45e-08 $layer=M1 $thickness=3.6e-08 $X=0.3995
+ $Y=0.072 $X2=0.444 $Y2=0.072
r13 22 23 5.01358 $w=1.3e-08 $l=2.15e-08 $layer=M1 $thickness=3.6e-08 $X=0.378
+ $Y=0.072 $X2=0.3995 $Y2=0.072
r14 21 22 5.47996 $w=1.3e-08 $l=2.35e-08 $layer=M1 $thickness=3.6e-08 $X=0.3545
+ $Y=0.072 $X2=0.378 $Y2=0.072
r15 20 21 7.34548 $w=1.3e-08 $l=3.15e-08 $layer=M1 $thickness=3.6e-08 $X=0.323
+ $Y=0.072 $X2=0.3545 $Y2=0.072
r16 19 20 7.11229 $w=1.3e-08 $l=3.05e-08 $layer=M1 $thickness=3.6e-08 $X=0.2925
+ $Y=0.072 $X2=0.323 $Y2=0.072
r17 18 19 5.24677 $w=1.3e-08 $l=2.25e-08 $layer=M1 $thickness=3.6e-08 $X=0.27
+ $Y=0.072 $X2=0.2925 $Y2=0.072
r18 13 18 2.68168 $w=1.3e-08 $l=1.15e-08 $layer=M1 $thickness=3.6e-08 $X=0.2585
+ $Y=0.072 $X2=0.27 $Y2=0.072
r19 1 18 19.3796 $a=3.24e-16 $layer=V0LISD $X=0.27 $Y=0.0675 $X2=0.27 $Y2=0.072
r20 17 15 0.0308642 $w=8.1e-08 $l=2.5e-09 $layer=N_src_drn $thickness=1e-09
+ $X=0.2873 $Y=0.0675 $X2=0.2845 $Y2=0.0675
r21 1 15 0.179012 $w=8.1e-08 $l=1.45e-08 $layer=N_src_drn $thickness=1e-09
+ $X=0.27 $Y=0.0675 $X2=0.2845 $Y2=0.0675
r22 10 1 0.179012 $w=8.1e-08 $l=1.45e-08 $layer=N_src_drn $thickness=1e-09
+ $X=0.2555 $Y=0.0675 $X2=0.27 $Y2=0.0675
r23 16 10 0.0308642 $w=8.1e-08 $l=2.5e-09 $layer=N_src_drn $thickness=1e-09
+ $X=0.2526 $Y=0.0675 $X2=0.2555 $Y2=0.0675
.ends

.subckt PM_NAND4xp75_ASAP7_75t_R%C vss 9 10 14 23 26 31 34 1 6 3 5 8 4 7
c1 1 vss 0.0141707f $X=0.243 $Y=0.135
c2 3 vss 0.0385689f $X=0.243 $Y=0.0245
c3 4 vss 0.0382691f $X=0.297 $Y=0.135
c4 5 vss 0.0387452f $X=0.351 $Y=0.135
c5 6 vss 0.00731427f $X=0.216 $Y=0.11
c6 7 vss 0.00613541f $X=0.297 $Y=0.11
c7 8 vss 0.00648486f $X=0.272 $Y=0.11
c8 9 vss 0.00765338f $X=0.3 $Y=0.138
r1 6 36 4.53284 $w=1.48367e-08 $l=2.45e-08 $layer=M1 $thickness=3.6e-08
+ $X=0.216 $Y=0.11 $X2=0.2405 $Y2=0.11
r2 8 36 7.34548 $w=1.3e-08 $l=3.15e-08 $layer=M1 $thickness=3.6e-08 $X=0.272
+ $Y=0.11 $X2=0.2405 $Y2=0.11
r3 7 28 1.26576 $w=2.0056e-08 $l=1.25e-08 $layer=M1 $thickness=3.6e-08 $X=0.297
+ $Y=0.11 $X2=0.297 $Y2=0.1225
r4 7 8 4.18063 $w=1.48e-08 $l=2.5e-08 $layer=M1 $thickness=3.6e-08 $X=0.297
+ $Y=0.11 $X2=0.272 $Y2=0.11
r5 34 33 16.8368 $w=2.1e-08 $l=4.95e-08 $layer=Gate_1 $thickness=5.6e-08
+ $X=0.351 $Y=0.216 $X2=0.351 $Y2=0.1665
r6 31 32 16.8368 $w=2.1e-08 $l=4.95e-08 $layer=Gate_1 $thickness=5.6e-08
+ $X=0.351 $Y=0.0675 $X2=0.351 $Y2=0.117
r7 5 20 7.07951 $w=1.89474e-08 $layer=LIG $thickness=5.17895e-08 $X=0.351
+ $Y=0.135 $X2=0.351 $Y2=0.135
r8 5 32 6.27555 $w=2.05e-08 $l=1.8e-08 $layer=Gate_1 $thickness=5.6e-08
+ $X=0.351 $Y=0.135 $X2=0.351 $Y2=0.117
r9 5 33 10.8674 $w=2.07143e-08 $l=3.15e-08 $layer=Gate_1 $thickness=5.6e-08
+ $X=0.351 $Y=0.135 $X2=0.351 $Y2=0.1665
r10 9 18 19.3796 $a=3.24e-16 $layer=V0LIG $X=0.3 $Y=0.138 $X2=0.297 $Y2=0.135
r11 9 28 2.91487 $w=1.3e-08 $l=1.25e-08 $layer=M1 $thickness=3.6e-08 $X=0.3
+ $Y=0.138 $X2=0.297 $Y2=0.1225
r12 26 25 16.8368 $w=2.1e-08 $l=4.95e-08 $layer=Gate_1 $thickness=5.6e-08
+ $X=0.297 $Y=0.216 $X2=0.297 $Y2=0.1665
r13 23 24 16.8368 $w=2.1e-08 $l=4.95e-08 $layer=Gate_1 $thickness=5.6e-08
+ $X=0.297 $Y=0.0675 $X2=0.297 $Y2=0.117
r14 4 18 7.07951 $w=1.89474e-08 $layer=LIG $thickness=5.17895e-08 $X=0.297
+ $Y=0.135 $X2=0.297 $Y2=0.135
r15 4 24 6.27555 $w=2.05e-08 $l=1.8e-08 $layer=Gate_1 $thickness=5.6e-08
+ $X=0.297 $Y=0.135 $X2=0.297 $Y2=0.117
r16 4 25 10.8674 $w=2.07143e-08 $l=3.15e-08 $layer=Gate_1 $thickness=5.6e-08
+ $X=0.297 $Y=0.135 $X2=0.297 $Y2=0.1665
r17 19 20 30.1405 $w=1.37815e-08 $l=2.7e-08 $layer=LIG $thickness=4.8e-08
+ $X=0.324 $Y=0.135 $X2=0.351 $Y2=0.135
r18 18 19 30.1405 $w=1.37815e-08 $l=2.7e-08 $layer=LIG $thickness=4.8e-08
+ $X=0.297 $Y=0.135 $X2=0.324 $Y2=0.135
r19 17 18 30.1405 $w=1.37815e-08 $l=2.7e-08 $layer=LIG $thickness=4.8e-08
+ $X=0.27 $Y=0.135 $X2=0.297 $Y2=0.135
r20 1 12 7.07951 $w=1.89474e-08 $layer=LIG $thickness=5.17895e-08 $X=0.243
+ $Y=0.135 $X2=0.243 $Y2=0.135
r21 1 17 30.1405 $w=1.37815e-08 $l=2.7e-08 $layer=LIG $thickness=4.8e-08
+ $X=0.243 $Y=0.135 $X2=0.27 $Y2=0.135
r22 14 13 16.8368 $w=2.1e-08 $l=4.95e-08 $layer=Gate_1 $thickness=5.6e-08
+ $X=0.243 $Y=0.216 $X2=0.243 $Y2=0.1665
r23 12 13 10.8674 $w=2.07143e-08 $l=3.15e-08 $layer=Gate_1 $thickness=5.6e-08
+ $X=0.243 $Y=0.135 $X2=0.243 $Y2=0.1665
r24 11 12 6.27555 $w=2.05e-08 $l=1.8e-08 $layer=Gate_1 $thickness=5.6e-08
+ $X=0.243 $Y=0.117 $X2=0.243 $Y2=0.135
r25 10 11 16.8368 $w=2.1e-08 $l=4.95e-08 $layer=Gate_1 $thickness=5.6e-08
+ $X=0.243 $Y=0.0675 $X2=0.243 $Y2=0.117
r26 10 3 14.6259 $w=2.1e-08 $l=4.3e-08 $layer=Gate_1 $thickness=5.6e-08
+ $X=0.243 $Y=0.0675 $X2=0.243 $Y2=0.0245
.ends

* End of included file NAND4xp75_ASAP7_75t_R.pex.sp.pex

*
.subckt NAND4xp75_ASAP7_75t_CUSTOM_4_25_0_7 VSS VDD D C B A Y
*
* VSS VSS
* VDD VDD
* D D
* C C
* B B
* A A
* Y Y
*
*

M0 N_M0_d N_M0_g VSS VSS nmos_rvt L=2e-08 W=8.1e-08 nfin=3 $X=0.071 $Y=0.027
M1 N_M1_d N_M1_g VSS VSS nmos_rvt L=2e-08 W=8.1e-08 nfin=3 $X=0.125 $Y=0.027
M2 N_M2_d N_M2_g VSS VSS nmos_rvt L=2e-08 W=8.1e-08 nfin=3 $X=0.179 $Y=0.027
M3 N_M3_d N_M3_g N_M3_s VSS nmos_rvt L=2e-08 W=8.1e-08 nfin=3 $X=0.233 $Y=0.027
M4 N_M4_d N_M4_g N_M4_s VSS nmos_rvt L=2e-08 W=8.1e-08 nfin=3 $X=0.287 $Y=0.027
M5 N_M5_d N_M5_g N_M5_s VSS nmos_rvt L=2e-08 W=8.1e-08 nfin=3 $X=0.341 $Y=0.027
M6 N_M6_d N_M6_g N_M6_s VSS nmos_rvt L=2e-08 W=8.1e-08 nfin=3 $X=0.395 $Y=0.027
M7 N_M7_d N_M7_g N_M7_s VSS nmos_rvt L=2e-08 W=8.1e-08 nfin=3 $X=0.449 $Y=0.027
M8 N_M8_d N_M8_g N_M8_s VSS nmos_rvt L=2e-08 W=8.1e-08 nfin=3 $X=0.503 $Y=0.027
M9 N_M9_d N_M9_g N_M9_s VSS nmos_rvt L=2e-08 W=8.1e-08 nfin=3 $X=0.557 $Y=0.027
M10 N_M10_d N_M10_g N_M10_s VSS nmos_rvt L=2e-08 W=8.1e-08 nfin=3 $X=0.611
+ $Y=0.027
M11 N_M11_d N_M11_g N_M11_s VSS nmos_rvt L=2e-08 W=8.1e-08 nfin=3 $X=0.665
+ $Y=0.027
M12 N_M12_d N_M12_g VDD VDD pmos_rvt L=2e-08 W=5.4e-08 nfin=2 $X=0.071 $Y=0.189
M13 N_M13_d N_M13_g VDD VDD pmos_rvt L=2e-08 W=5.4e-08 nfin=2 $X=0.125 $Y=0.189
M14 N_M14_d N_M14_g VDD VDD pmos_rvt L=2e-08 W=5.4e-08 nfin=2 $X=0.179 $Y=0.189
M15 VDD N_M15_g N_M15_s VDD pmos_rvt L=2e-08 W=5.4e-08 nfin=2 $X=0.233 $Y=0.189
M16 VDD N_M16_g N_M16_s VDD pmos_rvt L=2e-08 W=5.4e-08 nfin=2 $X=0.287 $Y=0.189
M17 VDD N_M17_g N_M17_s VDD pmos_rvt L=2e-08 W=5.4e-08 nfin=2 $X=0.341 $Y=0.189
M18 N_M18_d N_M18_g VDD VDD pmos_rvt L=2e-08 W=5.4e-08 nfin=2 $X=0.395 $Y=0.189
M19 N_M19_d N_M19_g VDD VDD pmos_rvt L=2e-08 W=5.4e-08 nfin=2 $X=0.449 $Y=0.189
M20 N_M20_d N_M20_g VDD VDD pmos_rvt L=2e-08 W=5.4e-08 nfin=2 $X=0.503 $Y=0.189
M21 VDD N_M21_g N_M21_s VDD pmos_rvt L=2e-08 W=5.4e-08 nfin=2 $X=0.557 $Y=0.189
M22 VDD N_M22_g N_M22_s VDD pmos_rvt L=2e-08 W=5.4e-08 nfin=2 $X=0.611 $Y=0.189
M23 VDD N_M23_g N_M23_s VDD pmos_rvt L=2e-08 W=5.4e-08 nfin=2 $X=0.665 $Y=0.189

* .include "NAND4xp75_ASAP7_75t_R.pex.sp.pxi"

* Start of included file NAND4xp75_ASAP7_75t_R.pex.sp.pxi
x_PM_NAND4xp75_ASAP7_75t_R%7 vss N_M0_d N_M1_d N_M2_d N_M3_s N_M4_s N_M5_s
+ N_7_10 N_7_1 N_7_11 N_7_12 N_7_3 N_7_13 N_7_2 PM_NAND4xp75_ASAP7_75t_R%7
cc_1 N_7_10 N_D_6 0.00039321f $X=0.0935 $Y=0.0675
cc_2 N_7_10 N_D_5 0.00197578f $X=0.0935 $Y=0.0675
cc_3 N_7_1 N_D_3 0.00181536f $X=0.108 $Y=0.0675
cc_4 N_7_10 N_D_1 0.00277538f $X=0.0935 $Y=0.0675
cc_5 N_7_11 N_D_5 0.0326216f $X=0.2015 $Y=0.0675
cc_6 N_7_10 N_D_3 0.0354939f $X=0.0935 $Y=0.0675
cc_7 N_7_10 N_D_4 0.0301854f $X=0.0935 $Y=0.0675
cc_8 N_7_12 N_C_6 0.00026429f $X=0.3095 $Y=0.0675
cc_9 N_7_12 N_C_8 0.000397491f $X=0.3095 $Y=0.0675
cc_10 N_7_12 N_C_3 0.0017728f $X=0.3095 $Y=0.0675
cc_11 N_7_12 N_C_5 0.0370019f $X=0.3095 $Y=0.0675
cc_12 N_7_3 N_C_5 0.00156498f $X=0.324 $Y=0.0675
cc_13 N_7_12 N_C_1 0.00249611f $X=0.3095 $Y=0.0675
cc_14 N_7_13 N_C_6 0.00285072f $X=0.0935 $Y=0.036
cc_15 N_7_11 N_C_3 0.0323334f $X=0.2015 $Y=0.0675
cc_16 N_7_12 N_C_4 0.0287744f $X=0.3095 $Y=0.0675
x_PM_NAND4xp75_ASAP7_75t_R%D vss D N_M0_g N_M12_g N_M1_g N_M13_g N_M2_g N_M14_g
+ N_D_5 N_D_1 N_D_6 N_D_3 N_D_4 N_D_11 N_D_8 PM_NAND4xp75_ASAP7_75t_R%D
x_PM_NAND4xp75_ASAP7_75t_R%B vss B N_M6_g N_M18_g N_M7_g N_M19_g N_M8_g N_M20_g
+ N_B_1 N_B_3 N_B_7 N_B_5 N_B_6 N_B_4 N_B_8 PM_NAND4xp75_ASAP7_75t_R%B
cc_17 N_B_1 N_C_1 0.00119628f $X=0.405 $Y=0.135
cc_18 N_B_3 N_C_5 0.00584355f $X=0.405 $Y=0.0245
x_PM_NAND4xp75_ASAP7_75t_R%A vss A N_M10_g N_M22_g N_M9_g N_M21_g N_M11_g
+ N_M23_g N_A_3 N_A_6 N_A_1 N_A_5 N_A_4 PM_NAND4xp75_ASAP7_75t_R%A
cc_19 N_A_3 N_B_1 0.000450442f $X=0.567 $Y=0.135
cc_20 N_A_6 N_B_7 0.000580905f $X=0.621 $Y=0.1125
cc_21 N_A_1 N_B_7 0.00143073f $X=0.621 $Y=0.135
cc_22 N_A_3 N_B_5 0.00635734f $X=0.567 $Y=0.135
x_PM_NAND4xp75_ASAP7_75t_R%9 vss N_M10_s N_M11_s N_M8_d N_M9_s N_M6_d N_M7_d
+ N_9_10 N_9_2 N_9_1 N_9_13 N_9_11 N_9_12 N_9_3 PM_NAND4xp75_ASAP7_75t_R%9
cc_23 N_9_10 N_B_5 0.000419883f $X=0.4175 $Y=0.0675
cc_24 N_9_2 N_B_5 0.0013411f $X=0.54 $Y=0.0675
cc_25 N_9_1 N_B_3 0.00146759f $X=0.432 $Y=0.0675
cc_26 N_9_13 N_B_7 0.00228037f $X=0.6095 $Y=0.036
cc_27 N_9_10 N_B_1 0.00267147f $X=0.4175 $Y=0.0675
cc_28 N_9_11 N_B_5 0.0324935f $X=0.5255 $Y=0.0675
cc_29 N_9_10 N_B_4 0.0179205f $X=0.4175 $Y=0.0675
cc_30 N_9_10 N_B_3 0.0478315f $X=0.4175 $Y=0.0675
cc_31 N_9_12 N_A_5 0.0364498f $X=0.6335 $Y=0.0675
cc_32 N_9_3 N_A_4 0.0015748f $X=0.648 $Y=0.0675
cc_33 N_9_12 N_A_1 0.00265716f $X=0.6335 $Y=0.0675
cc_34 N_9_11 N_A_3 0.032284f $X=0.5255 $Y=0.0675
cc_35 N_9_12 N_A_4 0.0295259f $X=0.6335 $Y=0.0675
cc_36 N_9_11 N_8_12 0.00105209f $X=0.5255 $Y=0.0675
cc_37 N_9_10 N_8_11 0.0010682f $X=0.4175 $Y=0.0675
cc_38 N_9_2 N_8_3 0.00107342f $X=0.54 $Y=0.0675
cc_39 N_9_1 N_8_2 0.00114831f $X=0.432 $Y=0.0675
cc_40 N_9_1 N_8_3 0.00530679f $X=0.432 $Y=0.0675
cc_41 N_9_13 N_8_13 0.0112233f $X=0.6095 $Y=0.036
x_PM_NAND4xp75_ASAP7_75t_R%Y vss Y N_M10_d N_M9_d N_M11_d N_M22_s N_M23_s
+ N_M20_d N_M21_s N_M16_s N_M17_s N_M18_d N_M19_d N_M14_d N_M15_s N_M12_d
+ N_M13_d N_Y_28 N_Y_1 N_Y_35 N_Y_2 N_Y_27 N_Y_29 N_Y_3 N_Y_5 N_Y_31 N_Y_30
+ N_Y_4 N_Y_36 N_Y_26 N_Y_6 N_Y_32 N_Y_8 N_Y_37 N_Y_7 N_Y_25
+ PM_NAND4xp75_ASAP7_75t_R%Y
cc_42 N_Y_28 N_D_3 0.0003301f $X=0.2015 $Y=0.216
cc_43 N_Y_1 N_D_11 0.000352786f $X=0.108 $Y=0.216
cc_44 N_Y_35 N_D_8 0.000424148f $X=0.6345 $Y=0.234
cc_45 N_Y_2 N_D_5 0.000563486f $X=0.216 $Y=0.216
cc_46 N_Y_27 N_D_1 0.00094191f $X=0.0935 $Y=0.216
cc_47 N_Y_35 N_D_5 0.00104485f $X=0.6345 $Y=0.234
cc_48 N_Y_1 N_D_3 0.00116321f $X=0.108 $Y=0.216
cc_49 N_Y_28 N_D_5 0.0242145f $X=0.2015 $Y=0.216
cc_50 N_Y_27 N_D_4 0.0263955f $X=0.0935 $Y=0.216
cc_51 N_Y_27 N_D_3 0.0226921f $X=0.0935 $Y=0.216
cc_52 N_Y_2 N_C_8 0.000242793f $X=0.216 $Y=0.216
cc_53 N_Y_28 N_C_3 0.0244167f $X=0.2015 $Y=0.216
cc_54 N_Y_2 N_C_3 0.000629231f $X=0.216 $Y=0.216
cc_55 N_Y_29 N_C_1 0.000994367f $X=0.3095 $Y=0.216
cc_56 N_Y_3 N_C_4 0.00103264f $X=0.324 $Y=0.216
cc_57 N_Y_35 C 0.00202753f $X=0.6345 $Y=0.234
cc_58 N_Y_3 C 0.00211492f $X=0.324 $Y=0.216
cc_59 N_Y_29 N_C_5 0.0136032f $X=0.3095 $Y=0.216
cc_60 N_Y_29 N_C_4 0.035491f $X=0.3095 $Y=0.216
cc_61 N_Y_35 N_B_3 0.000217953f $X=0.6345 $Y=0.234
cc_62 N_Y_5 N_B_1 0.000227039f $X=0.54 $Y=0.216
cc_63 N_Y_31 N_B_5 0.0246443f $X=0.5255 $Y=0.216
cc_64 N_Y_30 N_B_4 0.0271162f $X=0.4175 $Y=0.216
cc_65 N_Y_5 N_B_5 0.000755489f $X=0.54 $Y=0.216
cc_66 N_Y_4 N_B_4 0.000832002f $X=0.432 $Y=0.216
cc_67 N_Y_30 N_B_1 0.00146433f $X=0.4175 $Y=0.216
cc_68 N_Y_36 N_B_7 0.00161057f $X=0.5825 $Y=0.072
cc_69 N_Y_35 N_B_8 0.00169952f $X=0.6345 $Y=0.234
cc_70 N_Y_5 N_B_8 0.00216838f $X=0.54 $Y=0.216
cc_71 N_Y_30 N_B_3 0.0225065f $X=0.4175 $Y=0.216
cc_72 N_Y_26 N_A_3 0.000423577f $X=0.6875 $Y=0.0675
cc_73 N_Y_6 N_A_3 0.000438754f $X=0.594 $Y=0.0675
cc_74 N_Y_5 N_A_3 0.00049135f $X=0.54 $Y=0.216
cc_75 N_Y_32 N_A_5 0.0215323f $X=0.6335 $Y=0.216
cc_76 N_Y_6 N_A_1 0.000697857f $X=0.594 $Y=0.0675
cc_77 N_Y_8 N_A_5 0.000766743f $X=0.702 $Y=0.0675
cc_78 N_Y_37 N_A_1 0.000793036f $X=0.729 $Y=0.0935
cc_79 N_Y_7 N_A_5 0.00106618f $X=0.648 $Y=0.216
cc_80 N_Y_36 N_A_6 0.00142985f $X=0.5825 $Y=0.072
cc_81 N_Y_35 N_A_6 0.00157926f $X=0.6345 $Y=0.234
cc_82 N_Y_6 N_A_4 0.00163427f $X=0.594 $Y=0.0675
cc_83 N_Y_31 N_A_3 0.0104579f $X=0.5255 $Y=0.216
cc_84 N_Y_7 N_A_6 0.00388599f $X=0.648 $Y=0.216
cc_85 N_Y_25 N_A_1 0.00466445f $X=0.5795 $Y=0.0675
cc_86 N_Y_26 N_A_5 0.046666f $X=0.6875 $Y=0.0675
cc_87 N_Y_25 N_A_4 0.0499198f $X=0.5795 $Y=0.0675
cc_88 N_Y_25 N_A_3 0.0444371f $X=0.5795 $Y=0.0675
cc_89 N_Y_26 N_9_13 0.000535465f $X=0.6875 $Y=0.0675
cc_90 N_Y_25 N_9_13 0.000558248f $X=0.5795 $Y=0.0675
cc_91 N_Y_6 N_9_13 0.000670988f $X=0.594 $Y=0.0675
cc_92 N_Y_25 N_9_12 0.00105992f $X=0.5795 $Y=0.0675
cc_93 N_Y_26 N_9_12 0.00108687f $X=0.6875 $Y=0.0675
cc_94 N_Y_8 N_9_3 0.00120692f $X=0.702 $Y=0.0675
cc_95 N_Y_6 N_9_3 0.00291552f $X=0.594 $Y=0.0675
cc_96 N_Y_6 N_9_2 0.00360279f $X=0.594 $Y=0.0675
cc_97 N_Y_36 N_9_13 0.00961864f $X=0.5825 $Y=0.072
x_PM_NAND4xp75_ASAP7_75t_R%8 vss N_M3_d N_M4_d N_M5_d N_M6_s N_M7_s N_M8_s
+ N_8_10 N_8_13 N_8_1 N_8_11 N_8_12 N_8_3 N_8_2 PM_NAND4xp75_ASAP7_75t_R%8
cc_98 N_8_10 N_C_5 0.00113152f $X=0.2555 $Y=0.0675
cc_99 N_8_10 N_C_6 0.00046683f $X=0.2555 $Y=0.0675
cc_100 N_8_10 N_C_8 0.000629138f $X=0.2555 $Y=0.0675
cc_101 N_8_13 N_C_8 0.00152022f $X=0.2585 $Y=0.072
cc_102 N_8_1 N_C_4 0.00173386f $X=0.27 $Y=0.0675
cc_103 N_8_10 N_C_1 0.0027477f $X=0.2555 $Y=0.0675
cc_104 N_8_13 N_C_7 0.00387257f $X=0.2585 $Y=0.072
cc_105 N_8_11 N_C_5 0.0318611f $X=0.3635 $Y=0.0675
cc_106 N_8_10 N_C_4 0.0353368f $X=0.2555 $Y=0.0675
cc_107 N_8_10 N_C_3 0.0296817f $X=0.2555 $Y=0.0675
cc_108 N_8_12 N_B_3 0.0011151f $X=0.4715 $Y=0.0675
cc_109 N_8_12 N_B_6 0.000435157f $X=0.4715 $Y=0.0675
cc_110 N_8_12 N_B_7 0.000504292f $X=0.4715 $Y=0.0675
cc_111 N_8_13 N_B_6 0.000742029f $X=0.2585 $Y=0.072
cc_112 N_8_13 N_B_1 0.00147755f $X=0.2585 $Y=0.072
cc_113 N_8_3 N_B_4 0.00152434f $X=0.486 $Y=0.0675
cc_114 N_8_12 N_B_1 0.00310536f $X=0.4715 $Y=0.0675
cc_115 N_8_11 N_B_3 0.0321332f $X=0.3635 $Y=0.0675
cc_116 N_8_12 N_B_5 0.0183071f $X=0.4715 $Y=0.0675
cc_117 N_8_12 N_B_4 0.046642f $X=0.4715 $Y=0.0675
cc_118 N_8_10 N_7_13 0.00115251f $X=0.2555 $Y=0.0675
cc_119 N_8_10 N_7_12 0.0011626f $X=0.2555 $Y=0.0675
cc_120 N_8_1 N_7_2 0.00353191f $X=0.27 $Y=0.0675
cc_121 N_8_2 N_7_3 0.00389556f $X=0.378 $Y=0.0675
cc_122 N_8_13 N_7_13 0.0109723f $X=0.2585 $Y=0.072
x_PM_NAND4xp75_ASAP7_75t_R%C vss C N_M3_g N_M15_g N_M4_g N_M16_g N_M5_g N_M17_g
+ N_C_1 N_C_6 N_C_3 N_C_5 N_C_8 N_C_4 N_C_7 PM_NAND4xp75_ASAP7_75t_R%C
cc_123 N_C_1 N_D_5 0.000476027f $X=0.243 $Y=0.135
cc_124 N_C_6 N_D_1 0.00147053f $X=0.216 $Y=0.11
cc_125 N_C_3 N_D_5 0.00611791f $X=0.243 $Y=0.0245

* End of included file NAND4xp75_ASAP7_75t_R.pex.sp.pxi
.ends

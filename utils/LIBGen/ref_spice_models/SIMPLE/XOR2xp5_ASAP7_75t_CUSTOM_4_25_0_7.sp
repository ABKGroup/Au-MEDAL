.subckt PM_XOR2xp5_ASAP7_75t_R%9 vss 2 3 1
c1 1 vss 0.000789803f $X=0.108 $Y=0.2025
r1 2 1 0.209877 $w=8.1e-08 $l=1.7e-08 $layer=P_src_drn $thickness=1e-09
+ $X=0.0906 $Y=0.2025 $X2=0.108 $Y2=0.2025
r2 3 1 0.209877 $w=8.1e-08 $l=1.7e-08 $layer=P_src_drn $thickness=1e-09
+ $X=0.1253 $Y=0.2025 $X2=0.108 $Y2=0.2025
.ends

.subckt PM_XOR2xp5_ASAP7_75t_R%A vss 31 19 25 52 55 5 17 1 2 14 9 15 6 12 18
c1 1 vss 0.00726262f $X=0.072 $Y=0.135
c2 2 vss 0.00620295f $X=0.351 $Y=0.135
c3 5 vss 0.0776186f $X=0.081 $Y=0.0245
c4 6 vss 0.141107f $X=0.351 $Y=0.135
c5 7 vss 0.0011713f $X=0.027 $Y=0.135
c6 8 vss 0.00376648f $X=0.027 $Y=0.234
c7 9 vss 0.000761935f $X=0.216 $Y=0.201
c8 10 vss 0.00344467f $X=0.216 $Y=0.234
c9 11 vss 0.003574f $X=0.351 $Y=0.198
c10 12 vss 0.010017f $X=0.027 $Y=0.1035
c11 13 vss 0.00656535f $X=0.027 $Y=0.1665
c12 14 vss 0.00150923f $X=0.0455 $Y=0.135
c13 15 vss 0.0173853f $X=0.057 $Y=0.234
c14 16 vss 0.000880971f $X=0.216 $Y=0.216
c15 17 vss 0.0120194f $X=0.2405 $Y=0.198
c16 18 vss 0.00436754f $X=0.351 $Y=0.169
r1 55 54 16.4967 $w=2.1e-08 $l=4.85e-08 $layer=Gate_1 $thickness=5.6e-08
+ $X=0.351 $Y=0.2025 $X2=0.351 $Y2=0.154
r2 52 53 16.4967 $w=2.1e-08 $l=4.85e-08 $layer=Gate_1 $thickness=5.6e-08
+ $X=0.351 $Y=0.0675 $X2=0.351 $Y2=0.116
r3 6 53 6.6497 $w=2.04211e-08 $l=1.9e-08 $layer=Gate_1 $thickness=5.6e-08
+ $X=0.351 $Y=0.135 $X2=0.351 $Y2=0.116
r4 6 54 6.6497 $w=2.04211e-08 $l=1.9e-08 $layer=Gate_1 $thickness=5.6e-08
+ $X=0.351 $Y=0.135 $X2=0.351 $Y2=0.154
r5 2 47 19.3796 $a=3.24e-16 $layer=V0LIG $X=0.351 $Y=0.135 $X2=0.351 $Y2=0.135
r6 2 6 8.65438 $w=1.80211e-08 $layer=LIG $thickness=5.26316e-08 $X=0.351
+ $Y=0.135 $X2=0.351 $Y2=0.135
r7 47 48 2.68168 $w=1.3e-08 $l=1.15e-08 $layer=M1 $thickness=3.6e-08 $X=0.351
+ $Y=0.135 $X2=0.351 $Y2=0.1465
r8 18 48 5.24677 $w=1.3e-08 $l=2.25e-08 $layer=M1 $thickness=3.6e-08 $X=0.351
+ $Y=0.169 $X2=0.351 $Y2=0.1465
r9 11 45 10.4768 $w=1.38654e-08 $l=5.2e-08 $layer=M1 $thickness=3.6e-08
+ $X=0.351 $Y=0.198 $X2=0.299 $Y2=0.198
r10 11 18 5.11339 $w=1.60414e-08 $l=2.9e-08 $layer=M1 $thickness=3.6e-08
+ $X=0.351 $Y=0.198 $X2=0.351 $Y2=0.169
r11 17 45 13.6416 $w=1.3e-08 $l=5.85e-08 $layer=M1 $thickness=3.6e-08 $X=0.2405
+ $Y=0.198 $X2=0.299 $Y2=0.198
r12 9 16 2.71097 $w=1.5e-08 $l=1.5e-08 $layer=M1 $thickness=3.6e-08 $X=0.216
+ $Y=0.201 $X2=0.216 $Y2=0.216
r13 9 17 4.22671 $w=1.43953e-08 $l=2.4683e-08 $layer=M1 $thickness=3.6e-08
+ $X=0.216 $Y=0.201 $X2=0.2405 $Y2=0.198
r14 10 43 3.59766 $w=1.5e-08 $l=2.25e-08 $layer=M1 $thickness=3.6e-08 $X=0.216
+ $Y=0.234 $X2=0.1935 $Y2=0.234
r15 10 16 2.5483 $w=1.79e-08 $l=1.8e-08 $layer=M1 $thickness=3.6e-08 $X=0.216
+ $Y=0.234 $X2=0.216 $Y2=0.216
r16 42 43 5.24677 $w=1.3e-08 $l=2.25e-08 $layer=M1 $thickness=3.6e-08 $X=0.171
+ $Y=0.234 $X2=0.1935 $Y2=0.234
r17 41 42 4.19742 $w=1.3e-08 $l=1.8e-08 $layer=M1 $thickness=3.6e-08 $X=0.153
+ $Y=0.234 $X2=0.171 $Y2=0.234
r18 40 41 6.52931 $w=1.3e-08 $l=2.8e-08 $layer=M1 $thickness=3.6e-08 $X=0.125
+ $Y=0.234 $X2=0.153 $Y2=0.234
r19 39 40 5.82974 $w=1.3e-08 $l=2.5e-08 $layer=M1 $thickness=3.6e-08 $X=0.1
+ $Y=0.234 $X2=0.125 $Y2=0.234
r20 38 39 3.26466 $w=1.3e-08 $l=1.4e-08 $layer=M1 $thickness=3.6e-08 $X=0.086
+ $Y=0.234 $X2=0.1 $Y2=0.234
r21 15 38 6.7625 $w=1.3e-08 $l=2.9e-08 $layer=M1 $thickness=3.6e-08 $X=0.057
+ $Y=0.234 $X2=0.086 $Y2=0.234
r22 8 37 2.5483 $w=1.79e-08 $l=1.8e-08 $layer=M1 $thickness=3.6e-08 $X=0.027
+ $Y=0.234 $X2=0.027 $Y2=0.216
r23 8 15 5.34658 $w=1.45e-08 $l=3e-08 $layer=M1 $thickness=3.6e-08 $X=0.027
+ $Y=0.234 $X2=0.057 $Y2=0.234
r24 36 37 4.19742 $w=1.3e-08 $l=1.8e-08 $layer=M1 $thickness=3.6e-08 $X=0.027
+ $Y=0.198 $X2=0.027 $Y2=0.216
r25 13 36 7.34548 $w=1.3e-08 $l=3.15e-08 $layer=M1 $thickness=3.6e-08 $X=0.027
+ $Y=0.1665 $X2=0.027 $Y2=0.198
r26 7 14 3.1337 $w=1.54324e-08 $l=1.85e-08 $layer=M1 $thickness=3.6e-08
+ $X=0.027 $Y=0.135 $X2=0.0455 $Y2=0.135
r27 7 12 6.16517 $w=1.44286e-08 $l=3.15e-08 $layer=M1 $thickness=3.6e-08
+ $X=0.027 $Y=0.135 $X2=0.027 $Y2=0.1035
r28 7 13 6.16517 $w=1.44286e-08 $l=3.15e-08 $layer=M1 $thickness=3.6e-08
+ $X=0.027 $Y=0.135 $X2=0.027 $Y2=0.1665
r29 31 14 4.31401 $w=1.3e-08 $l=1.85e-08 $layer=M1 $thickness=3.6e-08 $X=0.06
+ $Y=0.134 $X2=0.0455 $Y2=0.135
r30 31 29 19.3796 $a=3.24e-16 $layer=V0LIG $X=0.06 $Y=0.134 $X2=0.063 $Y2=0.135
r31 1 27 2.6116 $w=2.2e-08 $l=1e-08 $layer=LIG $thickness=4.8e-08 $X=0.072
+ $Y=0.135 $X2=0.082 $Y2=0.135
r32 1 29 4.98695 $w=1.60444e-08 $l=9e-09 $layer=LIG $thickness=4.8e-08 $X=0.072
+ $Y=0.135 $X2=0.063 $Y2=0.135
r33 25 24 14.6259 $w=2.1e-08 $l=4.3e-08 $layer=Gate_1 $thickness=5.6e-08
+ $X=0.081 $Y=0.2025 $X2=0.081 $Y2=0.1595
r34 23 24 2.7211 $w=2.1e-08 $l=8e-09 $layer=Gate_1 $thickness=5.6e-08 $X=0.081
+ $Y=0.1515 $X2=0.081 $Y2=0.1595
r35 22 23 5.79936 $w=2.03333e-08 $l=1.65e-08 $layer=Gate_1 $thickness=5.6e-08
+ $X=0.081 $Y=0.135 $X2=0.081 $Y2=0.1515
r36 22 27 6.27904 $w=2.09e-08 $l=1e-09 $layer=Gate_1 $thickness=5.24e-08
+ $X=0.081 $Y=0.135 $X2=0.082 $Y2=0.135
r37 21 22 5.79936 $w=2.03333e-08 $l=1.65e-08 $layer=Gate_1 $thickness=5.6e-08
+ $X=0.081 $Y=0.1185 $X2=0.081 $Y2=0.135
r38 20 21 7.31297 $w=2.1e-08 $l=2.15e-08 $layer=Gate_1 $thickness=5.6e-08
+ $X=0.081 $Y=0.097 $X2=0.081 $Y2=0.1185
r39 19 20 14.6259 $w=2.1e-08 $l=4.3e-08 $layer=Gate_1 $thickness=5.6e-08
+ $X=0.081 $Y=0.054 $X2=0.081 $Y2=0.097
r40 19 5 10.0341 $w=2.1e-08 $l=2.95e-08 $layer=Gate_1 $thickness=5.6e-08
+ $X=0.081 $Y=0.054 $X2=0.081 $Y2=0.0245
.ends

.subckt PM_XOR2xp5_ASAP7_75t_R%5 vss 20 26 45 48 49 10 3 4 15 1 17 18 19 9 11
+ 13 14
c1 1 vss 0.00379972f $X=0.405 $Y=0.135
c2 3 vss 0.00776974f $X=0.108 $Y=0.054
c3 4 vss 0.0104558f $X=0.1745 $Y=0.2025
c4 9 vss 0.082617f $X=0.405 $Y=0.0245
c5 10 vss 0.00474871f $X=0.0935 $Y=0.054
c6 11 vss 0.0374815f $X=0.1475 $Y=0.2025
c7 12 vss 0.00312603f $X=0.171 $Y=0.036
c8 13 vss 0.000443049f $X=0.171 $Y=0.072
c9 14 vss 0.000585341f $X=0.405 $Y=0.072
c10 15 vss 0.00707286f $X=0.153 $Y=0.036
c11 16 vss 0.000732011f $X=0.171 $Y=0.054
c12 17 vss 0.0018693f $X=0.171 $Y=0.1005
c13 18 vss 0.00672263f $X=0.3915 $Y=0.072
c14 19 vss 0.00183342f $X=0.405 $Y=0.123
r1 49 47 0.0462963 $w=5.4e-08 $l=2.5e-09 $layer=N_src_drn $thickness=1e-09
+ $X=0.1253 $Y=0.054 $X2=0.1225 $Y2=0.054
r2 3 47 0.268519 $w=5.4e-08 $l=1.45e-08 $layer=N_src_drn $thickness=1e-09
+ $X=0.108 $Y=0.054 $X2=0.1225 $Y2=0.054
r3 10 3 0.268519 $w=5.4e-08 $l=1.45e-08 $layer=N_src_drn $thickness=1e-09
+ $X=0.0935 $Y=0.054 $X2=0.108 $Y2=0.054
r4 48 10 0.0462963 $w=5.4e-08 $l=2.5e-09 $layer=N_src_drn $thickness=1e-09
+ $X=0.0906 $Y=0.054 $X2=0.0935 $Y2=0.054
r5 3 39 19.3796 $a=3.24e-16 $layer=V0LISD $X=0.108 $Y=0.054 $X2=0.112 $Y2=0.036
r6 11 4 0.154321 $w=8.1e-08 $l=1.25e-08 $layer=P_src_drn $thickness=1e-09
+ $X=0.1475 $Y=0.2025 $X2=0.1745 $Y2=0.2025
r7 45 11 0.0308642 $w=8.1e-08 $l=2.5e-09 $layer=P_src_drn $thickness=1e-09
+ $X=0.1446 $Y=0.2025 $X2=0.1475 $Y2=0.2025
r8 39 40 4.31401 $w=1.3e-08 $l=1.85e-08 $layer=M1 $thickness=3.6e-08 $X=0.112
+ $Y=0.036 $X2=0.1305 $Y2=0.036
r9 15 40 5.24677 $w=1.3e-08 $l=2.25e-08 $layer=M1 $thickness=3.6e-08 $X=0.153
+ $Y=0.036 $X2=0.1305 $Y2=0.036
r10 4 37 19.3796 $a=3.24e-16 $layer=V0LISD $X=0.1745 $Y=0.2025 $X2=0.171
+ $Y2=0.18
r11 12 16 2.5483 $w=1.79e-08 $l=1.8e-08 $layer=M1 $thickness=3.6e-08 $X=0.171
+ $Y=0.036 $X2=0.171 $Y2=0.054
r12 12 15 2.5483 $w=1.55e-08 $l=1.8e-08 $layer=M1 $thickness=3.6e-08 $X=0.171
+ $Y=0.036 $X2=0.153 $Y2=0.036
r13 36 37 8.04505 $w=1.3e-08 $l=3.45e-08 $layer=M1 $thickness=3.6e-08 $X=0.171
+ $Y=0.1455 $X2=0.171 $Y2=0.18
r14 17 36 10.4935 $w=1.3e-08 $l=4.5e-08 $layer=M1 $thickness=3.6e-08 $X=0.171
+ $Y=0.1005 $X2=0.171 $Y2=0.1455
r15 13 35 4.06646 $w=1.5e-08 $l=2.25e-08 $layer=M1 $thickness=3.6e-08 $X=0.171
+ $Y=0.072 $X2=0.1935 $Y2=0.072
r16 13 16 3.01711 $w=1.55e-08 $l=1.8e-08 $layer=M1 $thickness=3.6e-08 $X=0.171
+ $Y=0.072 $X2=0.171 $Y2=0.054
r17 13 17 5.4656 $w=1.45789e-08 $l=2.85e-08 $layer=M1 $thickness=3.6e-08
+ $X=0.171 $Y=0.072 $X2=0.171 $Y2=0.1005
r18 34 35 8.86121 $w=1.3e-08 $l=3.8e-08 $layer=M1 $thickness=3.6e-08 $X=0.2315
+ $Y=0.072 $X2=0.1935 $Y2=0.072
r19 33 34 15.7403 $w=1.3e-08 $l=6.75e-08 $layer=M1 $thickness=3.6e-08 $X=0.299
+ $Y=0.072 $X2=0.2315 $Y2=0.072
r20 32 33 12.1259 $w=1.3e-08 $l=5.2e-08 $layer=M1 $thickness=3.6e-08 $X=0.351
+ $Y=0.072 $X2=0.299 $Y2=0.072
r21 31 32 5.24677 $w=1.3e-08 $l=2.25e-08 $layer=M1 $thickness=3.6e-08 $X=0.3735
+ $Y=0.072 $X2=0.351 $Y2=0.072
r22 18 31 4.19742 $w=1.3e-08 $l=1.8e-08 $layer=M1 $thickness=3.6e-08 $X=0.3915
+ $Y=0.072 $X2=0.3735 $Y2=0.072
r23 14 30 4.9968 $w=1.60947e-08 $l=2.85e-08 $layer=M1 $thickness=3.6e-08
+ $X=0.405 $Y=0.072 $X2=0.405 $Y2=0.1005
r24 14 18 1.49895 $w=1.63333e-08 $l=1.35e-08 $layer=M1 $thickness=3.6e-08
+ $X=0.405 $Y=0.072 $X2=0.3915 $Y2=0.072
r25 19 28 2.79828 $w=1.3e-08 $l=1.2e-08 $layer=M1 $thickness=3.6e-08 $X=0.405
+ $Y=0.123 $X2=0.405 $Y2=0.135
r26 19 30 5.24677 $w=1.3e-08 $l=2.25e-08 $layer=M1 $thickness=3.6e-08 $X=0.405
+ $Y=0.123 $X2=0.405 $Y2=0.1005
r27 1 23 10.4265 $w=1.765e-08 $layer=LIG $thickness=5.2e-08 $X=0.405 $Y=0.135
+ $X2=0.405 $Y2=0.135
r28 1 28 19.3796 $a=3.24e-16 $layer=V0LIG $X=0.405 $Y=0.135 $X2=0.405 $Y2=0.135
r29 26 25 14.6259 $w=2.1e-08 $l=4.3e-08 $layer=Gate_1 $thickness=5.6e-08
+ $X=0.405 $Y=0.2025 $X2=0.405 $Y2=0.1595
r30 24 25 2.7211 $w=2.1e-08 $l=8e-09 $layer=Gate_1 $thickness=5.6e-08 $X=0.405
+ $Y=0.1515 $X2=0.405 $Y2=0.1595
r31 23 24 5.79936 $w=2.03333e-08 $l=1.65e-08 $layer=Gate_1 $thickness=5.6e-08
+ $X=0.405 $Y=0.135 $X2=0.405 $Y2=0.1515
r32 22 23 5.79936 $w=2.03333e-08 $l=1.65e-08 $layer=Gate_1 $thickness=5.6e-08
+ $X=0.405 $Y=0.1185 $X2=0.405 $Y2=0.135
r33 21 22 2.7211 $w=2.1e-08 $l=8e-09 $layer=Gate_1 $thickness=5.6e-08 $X=0.405
+ $Y=0.1105 $X2=0.405 $Y2=0.1185
r34 20 21 14.6259 $w=2.1e-08 $l=4.3e-08 $layer=Gate_1 $thickness=5.6e-08
+ $X=0.405 $Y=0.0675 $X2=0.405 $Y2=0.1105
r35 20 9 14.6259 $w=2.1e-08 $l=4.3e-08 $layer=Gate_1 $thickness=5.6e-08
+ $X=0.405 $Y=0.0675 $X2=0.405 $Y2=0.0245
.ends

.subckt PM_XOR2xp5_ASAP7_75t_R%B vss 22 8 14 28 32 5 1 6 7 4 3
c1 1 vss 0.0186723f $X=0.1255 $Y=0.135
c2 3 vss 0.0434607f $X=0.135 $Y=0.0245
c3 4 vss 0.10987f $X=0.297 $Y=0.135
c4 5 vss 0.00191827f $X=0.135 $Y=0.198
c5 6 vss 0.00179511f $X=0.135 $Y=0.072
c6 7 vss 0.00342156f $X=0.135 $Y=0.1265
r1 5 25 6.16517 $w=1.44286e-08 $l=3.15e-08 $layer=M1 $thickness=3.6e-08
+ $X=0.135 $Y=0.198 $X2=0.135 $Y2=0.1665
r2 6 24 6.16517 $w=1.44286e-08 $l=3.15e-08 $layer=M1 $thickness=3.6e-08
+ $X=0.135 $Y=0.072 $X2=0.135 $Y2=0.1035
r3 32 31 14.6259 $w=2.1e-08 $l=4.3e-08 $layer=Gate_1 $thickness=5.6e-08
+ $X=0.297 $Y=0.2025 $X2=0.297 $Y2=0.1595
r4 30 31 3.23131 $w=2.1e-08 $l=9.5e-09 $layer=Gate_1 $thickness=5.6e-08
+ $X=0.297 $Y=0.15 $X2=0.297 $Y2=0.1595
r5 28 29 14.6259 $w=2.1e-08 $l=4.3e-08 $layer=Gate_1 $thickness=5.6e-08
+ $X=0.297 $Y=0.0675 $X2=0.297 $Y2=0.1105
r6 26 29 3.23131 $w=2.1e-08 $l=9.5e-09 $layer=Gate_1 $thickness=5.6e-08
+ $X=0.297 $Y=0.12 $X2=0.297 $Y2=0.1105
r7 4 20 7.58422 $w=1.77778e-08 $layer=LIG $thickness=5.15556e-08 $X=0.297
+ $Y=0.135 $X2=0.297 $Y2=0.135
r8 4 26 5.23813 $w=2.04667e-08 $l=1.5e-08 $layer=Gate_1 $thickness=5.6e-08
+ $X=0.297 $Y=0.135 $X2=0.297 $Y2=0.12
r9 4 30 5.23813 $w=2.04667e-08 $l=1.5e-08 $layer=Gate_1 $thickness=5.6e-08
+ $X=0.297 $Y=0.135 $X2=0.297 $Y2=0.15
r10 23 25 5.36336 $w=1.3e-08 $l=2.3e-08 $layer=M1 $thickness=3.6e-08 $X=0.135
+ $Y=0.1435 $X2=0.135 $Y2=0.1665
r11 22 23 1.98211 $w=1.3e-08 $l=8.5e-09 $layer=M1 $thickness=3.6e-08 $X=0.136
+ $Y=0.135 $X2=0.135 $Y2=0.1435
r12 22 7 1.98211 $w=1.3e-08 $l=8.5e-09 $layer=M1 $thickness=3.6e-08 $X=0.136
+ $Y=0.135 $X2=0.135 $Y2=0.1265
r13 7 24 5.36336 $w=1.3e-08 $l=2.3e-08 $layer=M1 $thickness=3.6e-08 $X=0.135
+ $Y=0.1265 $X2=0.135 $Y2=0.1035
r14 19 20 170.233 $w=1.01272e-08 $l=8.1e-08 $layer=LIG $thickness=4.8e-08
+ $X=0.216 $Y=0.135 $X2=0.297 $Y2=0.135
r15 17 19 165.742 $w=9.34685e-09 $l=7.15e-08 $layer=LIG $thickness=4.8e-08
+ $X=0.1445 $Y=0.135 $X2=0.216 $Y2=0.135
r16 16 17 4.49071 $w=1.6e-08 $l=9.5e-09 $layer=LIG $thickness=4.8e-08 $X=0.135
+ $Y=0.135 $X2=0.1445 $Y2=0.135
r17 22 16 28.9687 $a=2.88e-16 $layer=V0LIG $X=0.136 $Y=0.135 $X2=0.135 $Y2=0.135
r18 1 16 4.49071 $w=1.6e-08 $l=9.5e-09 $layer=LIG $thickness=4.8e-08 $X=0.1255
+ $Y=0.135 $X2=0.135 $Y2=0.135
r19 14 13 14.6259 $w=2.1e-08 $l=4.3e-08 $layer=Gate_1 $thickness=5.6e-08
+ $X=0.135 $Y=0.2025 $X2=0.135 $Y2=0.1595
r20 12 13 3.23131 $w=2.1e-08 $l=9.5e-09 $layer=Gate_1 $thickness=5.6e-08
+ $X=0.135 $Y=0.15 $X2=0.135 $Y2=0.1595
r21 11 12 5.23813 $w=2.04667e-08 $l=1.5e-08 $layer=Gate_1 $thickness=5.6e-08
+ $X=0.135 $Y=0.135 $X2=0.135 $Y2=0.15
r22 11 17 3.09351 $w=1.97647e-08 $l=9.5e-09 $layer=Gate_1
+ $thickness=5.55294e-08 $X=0.135 $Y=0.135 $X2=0.1445 $Y2=0.135
r23 11 16 7.11151 $w=1.78824e-08 $layer=LIG $thickness=5.17647e-08 $X=0.135
+ $Y=0.135 $X2=0.135 $Y2=0.135
r24 10 11 5.23813 $w=2.04667e-08 $l=1.5e-08 $layer=Gate_1 $thickness=5.6e-08
+ $X=0.135 $Y=0.12 $X2=0.135 $Y2=0.135
r25 9 10 7.82318 $w=2.1e-08 $l=2.3e-08 $layer=Gate_1 $thickness=5.6e-08
+ $X=0.135 $Y=0.097 $X2=0.135 $Y2=0.12
r26 8 9 14.6259 $w=2.1e-08 $l=4.3e-08 $layer=Gate_1 $thickness=5.6e-08 $X=0.135
+ $Y=0.054 $X2=0.135 $Y2=0.097
r27 8 3 10.0341 $w=2.1e-08 $l=2.95e-08 $layer=Gate_1 $thickness=5.6e-08
+ $X=0.135 $Y=0.054 $X2=0.135 $Y2=0.0245
.ends

.subckt PM_XOR2xp5_ASAP7_75t_R%Y vss 25 18 29 33 10 12 2 15 11 16
c1 2 vss 0.00844441f $X=0.432 $Y=0.0675
c2 3 vss 0.00980967f $X=0.432 $Y=0.2025
c3 10 vss 0.0443282f $X=0.272 $Y=0.0675
c4 11 vss 0.0382264f $X=0.4175 $Y=0.0675
c5 12 vss 0.0382245f $X=0.4175 $Y=0.2025
c6 13 vss 0.0060795f $X=0.459 $Y=0.234
c7 14 vss 0.00276014f $X=0.459 $Y=0.036
c8 15 vss 0.0168455f $X=0.2585 $Y=0.036
c9 16 vss 0.00547357f $X=0.459 $Y=0.054
r1 12 3 0.154321 $w=8.1e-08 $l=1.25e-08 $layer=P_src_drn $thickness=1e-09
+ $X=0.4175 $Y=0.2025 $X2=0.432 $Y2=0.2025
r2 33 12 0.0308642 $w=8.1e-08 $l=2.5e-09 $layer=P_src_drn $thickness=1e-09
+ $X=0.4146 $Y=0.2025 $X2=0.4175 $Y2=0.2025
r3 3 30 19.3796 $a=3.24e-16 $layer=V0LISD $X=0.432 $Y=0.2025 $X2=0.432 $Y2=0.234
r4 30 31 3.14806 $w=1.3e-08 $l=1.35e-08 $layer=M1 $thickness=3.6e-08 $X=0.432
+ $Y=0.234 $X2=0.4455 $Y2=0.234
r5 13 27 3.01711 $w=1.55e-08 $l=1.8e-08 $layer=M1 $thickness=3.6e-08 $X=0.459
+ $Y=0.234 $X2=0.459 $Y2=0.216
r6 13 31 1.96775 $w=1.63333e-08 $l=1.35e-08 $layer=M1 $thickness=3.6e-08
+ $X=0.459 $Y=0.234 $X2=0.4455 $Y2=0.234
r7 11 2 0.154321 $w=8.1e-08 $l=1.25e-08 $layer=N_src_drn $thickness=1e-09
+ $X=0.4175 $Y=0.0675 $X2=0.432 $Y2=0.0675
r8 29 11 0.0308642 $w=8.1e-08 $l=2.5e-09 $layer=N_src_drn $thickness=1e-09
+ $X=0.4146 $Y=0.0675 $X2=0.4175 $Y2=0.0675
r9 26 27 8.86121 $w=1.3e-08 $l=3.8e-08 $layer=M1 $thickness=3.6e-08 $X=0.459
+ $Y=0.178 $X2=0.459 $Y2=0.216
r10 25 26 16.7897 $w=1.3e-08 $l=7.2e-08 $layer=M1 $thickness=3.6e-08 $X=0.457
+ $Y=0.135 $X2=0.459 $Y2=0.178
r11 25 16 12.1259 $w=1.3e-08 $l=5.2e-08 $layer=M1 $thickness=3.6e-08 $X=0.457
+ $Y=0.135 $X2=0.459 $Y2=0.054
r12 2 23 19.3796 $a=3.24e-16 $layer=V0LISD $X=0.432 $Y=0.0675 $X2=0.432
+ $Y2=0.036
r13 14 24 1.49895 $w=1.63333e-08 $l=1.35e-08 $layer=M1 $thickness=3.6e-08
+ $X=0.459 $Y=0.036 $X2=0.4455 $Y2=0.036
r14 14 16 2.5483 $w=1.79e-08 $l=1.8e-08 $layer=M1 $thickness=3.6e-08 $X=0.459
+ $Y=0.036 $X2=0.459 $Y2=0.054
r15 23 24 3.14806 $w=1.3e-08 $l=1.35e-08 $layer=M1 $thickness=3.6e-08 $X=0.432
+ $Y=0.036 $X2=0.4455 $Y2=0.036
r16 22 23 3.14806 $w=1.3e-08 $l=1.35e-08 $layer=M1 $thickness=3.6e-08 $X=0.4185
+ $Y=0.036 $X2=0.432 $Y2=0.036
r17 21 22 16.7897 $w=1.3e-08 $l=7.2e-08 $layer=M1 $thickness=3.6e-08 $X=0.3465
+ $Y=0.036 $X2=0.4185 $Y2=0.036
r18 20 21 17.839 $w=1.3e-08 $l=7.65e-08 $layer=M1 $thickness=3.6e-08 $X=0.27
+ $Y=0.036 $X2=0.3465 $Y2=0.036
r19 15 20 2.68168 $w=1.3e-08 $l=1.15e-08 $layer=M1 $thickness=3.6e-08 $X=0.2585
+ $Y=0.036 $X2=0.27 $Y2=0.036
r20 10 20 19.3796 $a=3.24e-16 $layer=V0LISD $X=0.272 $Y=0.0675 $X2=0.27
+ $Y2=0.036
r21 18 17 0.0308642 $w=8.1e-08 $l=2.5e-09 $layer=N_src_drn $thickness=1e-09
+ $X=0.2873 $Y=0.0675 $X2=0.2845 $Y2=0.0675
r22 10 17 0.154321 $w=8.1e-08 $l=1.25e-08 $layer=N_src_drn $thickness=1e-09
+ $X=0.272 $Y=0.0675 $X2=0.2845 $Y2=0.0675
.ends

* End of included file XOR2xp5_ASAP7_75t_R.pex.sp.pex

*
.subckt XOR2xp5_ASAP7_75t_CUSTOM_4_25_0_7 VSS VDD A B Y
*
* VSS VSS
* VDD VDD
* A A
* B B
* Y Y
*
*

M0 N_M0_d N_M0_g VSS VSS nmos_rvt L=2e-08 W=5.4e-08 nfin=2 $X=0.071 $Y=0.027
M1 VSS N_M1_g N_M1_s VSS nmos_rvt L=2e-08 W=5.4e-08 nfin=2 $X=0.125 $Y=0.027
M2 noxref_8 N_M2_g N_M2_s VSS nmos_rvt L=2e-08 W=8.1e-08 nfin=3 $X=0.287
+ $Y=0.027
M3 VSS N_M3_g noxref_8 VSS nmos_rvt L=2e-08 W=8.1e-08 nfin=3 $X=0.341 $Y=0.027
M4 N_M4_d N_M4_g VSS VSS nmos_rvt L=2e-08 W=8.1e-08 nfin=3 $X=0.395 $Y=0.027
M5 N_M5_d N_M5_g VDD VDD pmos_rvt L=2e-08 W=8.1e-08 nfin=3 $X=0.071 $Y=0.162
M6 N_M6_d N_M6_g N_M6_s VDD pmos_rvt L=2e-08 W=8.1e-08 nfin=3 $X=0.125 $Y=0.162
M7 VDD N_M7_g noxref_6 VDD pmos_rvt L=2e-08 W=8.1e-08 nfin=3 $X=0.287 $Y=0.162
M8 noxref_6 N_M8_g VDD VDD pmos_rvt L=2e-08 W=8.1e-08 nfin=3 $X=0.341 $Y=0.162
M9 N_M9_d N_M9_g noxref_6 VDD pmos_rvt L=2e-08 W=8.1e-08 nfin=3 $X=0.395
+ $Y=0.162

* .include "XOR2xp5_ASAP7_75t_R.pex.sp.pxi"

* Start of included file XOR2xp5_ASAP7_75t_R.pex.sp.pxi
x_PM_XOR2xp5_ASAP7_75t_R%9 vss N_M5_d N_M6_s N_9_1 PM_XOR2xp5_ASAP7_75t_R%9
cc_1 N_9_1 N_A_5 0.0168341f $X=0.108 $Y=0.2025
cc_2 N_9_1 N_B_3 0.0168883f $X=0.108 $Y=0.2025
x_PM_XOR2xp5_ASAP7_75t_R%A vss A N_M0_g N_M5_g N_M3_g N_M8_g N_A_5 N_A_17 N_A_1
+ N_A_2 N_A_14 N_A_9 N_A_15 N_A_6 N_A_12 N_A_18 PM_XOR2xp5_ASAP7_75t_R%A
x_PM_XOR2xp5_ASAP7_75t_R%5 vss N_M4_g N_M9_g N_M6_d N_M0_d N_M1_s N_5_10 N_5_3
+ N_5_4 N_5_15 N_5_1 N_5_17 N_5_18 N_5_19 N_5_9 N_5_11 N_5_13 N_5_14
+ PM_XOR2xp5_ASAP7_75t_R%5
cc_3 N_5_10 N_A_9 0.000374031f $X=0.0935 $Y=0.054
cc_4 N_5_10 N_A_1 0.000472447f $X=0.0935 $Y=0.054
cc_5 N_5_3 N_A_5 0.000586306f $X=0.108 $Y=0.054
cc_6 N_5_4 N_A_17 0.000724497f $X=0.1745 $Y=0.2025
cc_7 N_5_15 N_A_12 0.000857996f $X=0.153 $Y=0.036
cc_8 N_5_1 N_A_2 0.0021814f $X=0.405 $Y=0.135
cc_9 N_5_17 N_A_15 0.00162061f $X=0.171 $Y=0.1005
cc_10 N_5_4 N_A_15 0.00162595f $X=0.1745 $Y=0.2025
cc_11 N_5_18 N_A_18 0.00167172f $X=0.3915 $Y=0.072
cc_12 N_5_17 N_A_9 0.00244236f $X=0.171 $Y=0.1005
cc_13 N_5_19 N_A_18 0.00273159f $X=0.405 $Y=0.123
cc_14 N_5_9 N_A_6 0.00334667f $X=0.405 $Y=0.0245
cc_15 N_5_10 N_A_5 0.0262323f $X=0.0935 $Y=0.054
cc_16 N_5_11 N_B_6 0.000359851f $X=0.1475 $Y=0.2025
cc_17 N_5_11 N_B_7 0.000703734f $X=0.1475 $Y=0.2025
cc_18 N_5_18 N_B_1 0.000764557f $X=0.3915 $Y=0.072
cc_19 N_5_17 N_B_1 0.000830229f $X=0.171 $Y=0.1005
cc_20 N_5_17 N_B_5 0.000852696f $X=0.171 $Y=0.1005
cc_21 N_5_3 N_B_3 0.000864739f $X=0.108 $Y=0.054
cc_22 N_5_13 N_B_6 0.00234941f $X=0.171 $Y=0.072
cc_23 N_5_4 N_B_3 0.00292801f $X=0.1745 $Y=0.2025
cc_24 N_5_15 N_B_6 0.0029527f $X=0.153 $Y=0.036
cc_25 N_5_10 N_B_3 0.0105439f $X=0.0935 $Y=0.054
cc_26 N_5_4 N_B_1 0.00510509f $X=0.1745 $Y=0.2025
cc_27 N_5_17 N_B_7 0.00883274f $X=0.171 $Y=0.1005
cc_28 N_5_11 N_B_3 0.0503118f $X=0.1475 $Y=0.2025
x_PM_XOR2xp5_ASAP7_75t_R%B vss B N_M1_g N_M6_g N_M2_g N_M7_g N_B_5 N_B_1 N_B_6
+ N_B_7 N_B_4 N_B_3 PM_XOR2xp5_ASAP7_75t_R%B
cc_29 N_B_5 N_A_5 0.000223375f $X=0.135 $Y=0.198
cc_30 N_B_1 N_A_5 0.000297746f $X=0.1255 $Y=0.135
cc_31 N_B_6 N_A_5 0.000303556f $X=0.135 $Y=0.072
cc_32 N_B_1 N_A_17 0.000404232f $X=0.1255 $Y=0.135
cc_33 N_B_1 N_A_1 0.0017349f $X=0.1255 $Y=0.135
cc_34 N_B_1 N_A_2 0.000522319f $X=0.1255 $Y=0.135
cc_35 N_B_6 N_A_14 0.000543613f $X=0.135 $Y=0.072
cc_36 N_B_1 N_A_9 0.0017248f $X=0.1255 $Y=0.135
cc_37 N_B_7 N_A_14 0.00196774f $X=0.135 $Y=0.1265
cc_38 N_B_5 N_A_15 0.00481767f $X=0.135 $Y=0.198
cc_39 N_B_4 N_A_6 0.00489475f $X=0.297 $Y=0.135
cc_40 N_B_3 N_A_5 0.00771698f $X=0.135 $Y=0.0245
x_PM_XOR2xp5_ASAP7_75t_R%Y vss Y N_M2_s N_M4_d N_M9_d N_Y_10 N_Y_12 N_Y_2
+ N_Y_15 N_Y_11 N_Y_16 PM_XOR2xp5_ASAP7_75t_R%Y
cc_41 N_Y_10 N_B_1 0.00293434f $X=0.272 $Y=0.0675
cc_42 N_Y_10 N_B_4 0.0373042f $X=0.272 $Y=0.0675
cc_43 N_Y_12 N_5_1 0.000814796f $X=0.4175 $Y=0.2025
cc_44 N_Y_12 N_5_18 0.00120369f $X=0.4175 $Y=0.2025
cc_45 N_Y_2 N_5_9 0.00128776f $X=0.432 $Y=0.0675
cc_46 N_Y_15 N_5_14 0.00165158f $X=0.2585 $Y=0.036
cc_47 N_Y_11 N_5_1 0.00167271f $X=0.4175 $Y=0.0675
cc_48 N_Y_16 N_5_19 0.00431613f $X=0.459 $Y=0.054
cc_49 N_Y_11 N_5_9 0.014891f $X=0.4175 $Y=0.0675
cc_50 N_Y_15 N_5_18 0.0124124f $X=0.2585 $Y=0.036
cc_51 N_Y_12 N_5_9 0.0561773f $X=0.4175 $Y=0.2025

* End of included file XOR2xp5_ASAP7_75t_R.pex.sp.pxi
.ends

.subckt PM_MAJIxp5_ASAP7_75t_R%9 vss 2 3 1
c1 1 vss 0.00076114f $X=0.216 $Y=0.0675
r1 2 1 0.209877 $w=8.1e-08 $l=1.7e-08 $layer=N_src_drn $thickness=1e-09
+ $X=0.1986 $Y=0.0675 $X2=0.216 $Y2=0.0675
r2 3 1 0.209877 $w=8.1e-08 $l=1.7e-08 $layer=N_src_drn $thickness=1e-09
+ $X=0.2333 $Y=0.0675 $X2=0.216 $Y2=0.0675
.ends

.subckt PM_MAJIxp5_ASAP7_75t_R%B vss 25 17 23 43 46 1 16 13 2 15 9 14 5 6 11 10
c1 1 vss 0.00423695f $X=0.081 $Y=0.135
c2 2 vss 0.00119854f $X=0.243 $Y=0.135
c3 5 vss 0.0894649f $X=0.081 $Y=0.0245
c4 6 vss 0.0086703f $X=0.243 $Y=0.135
c5 7 vss 0.0018938f $X=0.027 $Y=0.135
c6 8 vss 0.00386178f $X=0.027 $Y=0.198
c7 9 vss 0.000938393f $X=0.189 $Y=0.135
c8 10 vss 0.000654665f $X=0.189 $Y=0.198
c9 11 vss 0.0145651f $X=0.027 $Y=0.098
c10 12 vss 0.00543614f $X=0.027 $Y=0.154
c11 13 vss 0.00301788f $X=0.0492 $Y=0.135
c12 14 vss 0.00908877f $X=0.065 $Y=0.198
c13 15 vss 0.00145011f $X=0.189 $Y=0.1765
c14 16 vss 0.00282457f $X=0.216 $Y=0.135
r1 46 45 16.4967 $w=2.1e-08 $l=4.85e-08 $layer=Gate_1 $thickness=5.6e-08
+ $X=0.243 $Y=0.2025 $X2=0.243 $Y2=0.154
r2 43 44 16.4967 $w=2.1e-08 $l=4.85e-08 $layer=Gate_1 $thickness=5.6e-08
+ $X=0.243 $Y=0.0675 $X2=0.243 $Y2=0.116
r3 6 44 6.6497 $w=2.04211e-08 $l=1.9e-08 $layer=Gate_1 $thickness=5.6e-08
+ $X=0.243 $Y=0.135 $X2=0.243 $Y2=0.116
r4 6 45 6.6497 $w=2.04211e-08 $l=1.9e-08 $layer=Gate_1 $thickness=5.6e-08
+ $X=0.243 $Y=0.135 $X2=0.243 $Y2=0.154
r5 2 39 19.3796 $a=3.24e-16 $layer=V0LIG $X=0.243 $Y=0.135 $X2=0.243 $Y2=0.135
r6 2 6 10.4265 $w=1.765e-08 $layer=LIG $thickness=5.2e-08 $X=0.243 $Y=0.135
+ $X2=0.243 $Y2=0.135
r7 16 39 6.29612 $w=1.3e-08 $l=2.7e-08 $layer=M1 $thickness=3.6e-08 $X=0.216
+ $Y=0.135 $X2=0.243 $Y2=0.135
r8 9 38 2.78149 $w=1.76421e-08 $l=1.9e-08 $layer=M1 $thickness=3.6e-08 $X=0.189
+ $Y=0.135 $X2=0.189 $Y2=0.154
r9 9 16 4.64701 $w=1.46667e-08 $l=2.7e-08 $layer=M1 $thickness=3.6e-08 $X=0.189
+ $Y=0.135 $X2=0.216 $Y2=0.135
r10 15 38 5.24677 $w=1.3e-08 $l=2.25e-08 $layer=M1 $thickness=3.6e-08 $X=0.189
+ $Y=0.1765 $X2=0.189 $Y2=0.154
r11 10 37 4.64701 $w=1.46667e-08 $l=2.7e-08 $layer=M1 $thickness=3.6e-08
+ $X=0.189 $Y=0.198 $X2=0.162 $Y2=0.198
r12 10 15 3.36447 $w=1.71023e-08 $l=2.15e-08 $layer=M1 $thickness=3.6e-08
+ $X=0.189 $Y=0.198 $X2=0.189 $Y2=0.1765
r13 36 37 6.29612 $w=1.3e-08 $l=2.7e-08 $layer=M1 $thickness=3.6e-08 $X=0.135
+ $Y=0.198 $X2=0.162 $Y2=0.198
r14 35 36 5.71315 $w=1.3e-08 $l=2.45e-08 $layer=M1 $thickness=3.6e-08 $X=0.1105
+ $Y=0.198 $X2=0.135 $Y2=0.198
r15 34 35 3.73104 $w=1.3e-08 $l=1.6e-08 $layer=M1 $thickness=3.6e-08 $X=0.0945
+ $Y=0.198 $X2=0.1105 $Y2=0.198
r16 14 34 6.8791 $w=1.3e-08 $l=2.95e-08 $layer=M1 $thickness=3.6e-08 $X=0.065
+ $Y=0.198 $X2=0.0945 $Y2=0.198
r17 8 33 3.36447 $w=1.71023e-08 $l=2.15e-08 $layer=M1 $thickness=3.6e-08
+ $X=0.027 $Y=0.198 $X2=0.027 $Y2=0.1765
r18 8 14 7.2121 $w=1.41842e-08 $l=3.8e-08 $layer=M1 $thickness=3.6e-08 $X=0.027
+ $Y=0.198 $X2=0.065 $Y2=0.198
r19 12 33 5.24677 $w=1.3e-08 $l=2.25e-08 $layer=M1 $thickness=3.6e-08 $X=0.027
+ $Y=0.154 $X2=0.027 $Y2=0.1765
r20 7 13 4.00816 $w=1.50225e-08 $l=2.22e-08 $layer=M1 $thickness=3.6e-08
+ $X=0.027 $Y=0.135 $X2=0.0492 $Y2=0.135
r21 7 11 7.44771 $w=1.42162e-08 $l=3.7e-08 $layer=M1 $thickness=3.6e-08
+ $X=0.027 $Y=0.135 $X2=0.027 $Y2=0.098
r22 7 12 3.2503 $w=1.53684e-08 $l=1.9e-08 $layer=M1 $thickness=3.6e-08 $X=0.027
+ $Y=0.135 $X2=0.027 $Y2=0.154
r23 26 27 3.08976 $w=1.3e-08 $l=1.33e-08 $layer=M1 $thickness=3.6e-08 $X=0.0677
+ $Y=0.135 $X2=0.081 $Y2=0.135
r24 25 26 1.10765 $w=1.3e-08 $l=4.7e-09 $layer=M1 $thickness=3.6e-08 $X=0.063
+ $Y=0.135 $X2=0.0677 $Y2=0.135
r25 25 13 3.20636 $w=1.3e-08 $l=1.38e-08 $layer=M1 $thickness=3.6e-08 $X=0.063
+ $Y=0.135 $X2=0.0492 $Y2=0.135
r26 1 20 10.4265 $w=1.765e-08 $layer=LIG $thickness=5.2e-08 $X=0.081 $Y=0.135
+ $X2=0.081 $Y2=0.135
r27 1 27 19.3796 $a=3.24e-16 $layer=V0LIG $X=0.081 $Y=0.135 $X2=0.081 $Y2=0.135
r28 23 22 14.6259 $w=2.1e-08 $l=4.3e-08 $layer=Gate_1 $thickness=5.6e-08
+ $X=0.081 $Y=0.2025 $X2=0.081 $Y2=0.1595
r29 21 22 2.7211 $w=2.1e-08 $l=8e-09 $layer=Gate_1 $thickness=5.6e-08 $X=0.081
+ $Y=0.1515 $X2=0.081 $Y2=0.1595
r30 20 21 5.79936 $w=2.03333e-08 $l=1.65e-08 $layer=Gate_1 $thickness=5.6e-08
+ $X=0.081 $Y=0.135 $X2=0.081 $Y2=0.1515
r31 19 20 5.79936 $w=2.03333e-08 $l=1.65e-08 $layer=Gate_1 $thickness=5.6e-08
+ $X=0.081 $Y=0.1185 $X2=0.081 $Y2=0.135
r32 18 19 2.7211 $w=2.1e-08 $l=8e-09 $layer=Gate_1 $thickness=5.6e-08 $X=0.081
+ $Y=0.1105 $X2=0.081 $Y2=0.1185
r33 17 18 14.6259 $w=2.1e-08 $l=4.3e-08 $layer=Gate_1 $thickness=5.6e-08
+ $X=0.081 $Y=0.0675 $X2=0.081 $Y2=0.1105
r34 17 5 14.6259 $w=2.1e-08 $l=4.3e-08 $layer=Gate_1 $thickness=5.6e-08
+ $X=0.081 $Y=0.0675 $X2=0.081 $Y2=0.0245
.ends

.subckt PM_MAJIxp5_ASAP7_75t_R%A vss 14 5 11 3 4 1
c1 1 vss 0.000740969f $X=0.297 $Y=0.135
c2 3 vss 0.0245f $X=0.297 $Y=0.0245
c3 4 vss 0.00410013f $X=0.297 $Y=0.135
r1 14 15 1.22425 $w=1.3e-08 $l=5.2e-09 $layer=M1 $thickness=3.6e-08 $X=0.296
+ $Y=0.116 $X2=0.297 $Y2=0.1212
r2 4 15 3.20636 $w=1.3e-08 $l=1.38e-08 $layer=M1 $thickness=3.6e-08 $X=0.297
+ $Y=0.135 $X2=0.297 $Y2=0.1212
r3 1 8 10.4265 $w=1.765e-08 $layer=LIG $thickness=5.2e-08 $X=0.297 $Y=0.135
+ $X2=0.297 $Y2=0.135
r4 1 4 19.3796 $a=3.24e-16 $layer=V0LIG $X=0.297 $Y=0.135 $X2=0.297 $Y2=0.135
r5 11 10 14.6259 $w=2.1e-08 $l=4.3e-08 $layer=Gate_1 $thickness=5.6e-08
+ $X=0.297 $Y=0.2025 $X2=0.297 $Y2=0.1595
r6 9 10 2.7211 $w=2.1e-08 $l=8e-09 $layer=Gate_1 $thickness=5.6e-08 $X=0.297
+ $Y=0.1515 $X2=0.297 $Y2=0.1595
r7 8 9 5.79936 $w=2.03333e-08 $l=1.65e-08 $layer=Gate_1 $thickness=5.6e-08
+ $X=0.297 $Y=0.135 $X2=0.297 $Y2=0.1515
r8 7 8 5.79936 $w=2.03333e-08 $l=1.65e-08 $layer=Gate_1 $thickness=5.6e-08
+ $X=0.297 $Y=0.1185 $X2=0.297 $Y2=0.135
r9 6 7 2.7211 $w=2.1e-08 $l=8e-09 $layer=Gate_1 $thickness=5.6e-08 $X=0.297
+ $Y=0.1105 $X2=0.297 $Y2=0.1185
r10 5 6 14.6259 $w=2.1e-08 $l=4.3e-08 $layer=Gate_1 $thickness=5.6e-08 $X=0.297
+ $Y=0.0675 $X2=0.297 $Y2=0.1105
r11 5 3 14.6259 $w=2.1e-08 $l=4.3e-08 $layer=Gate_1 $thickness=5.6e-08 $X=0.297
+ $Y=0.0675 $X2=0.297 $Y2=0.0245
.ends

.subckt PM_MAJIxp5_ASAP7_75t_R%6 vss 12 13 24 7 1 9 8 2
c1 1 vss 0.00906982f $X=0.108 $Y=0.0675
c2 2 vss 0.00605497f $X=0.324 $Y=0.0675
c3 7 vss 0.00448747f $X=0.0935 $Y=0.0675
c4 8 vss 0.0360795f $X=0.3095 $Y=0.0675
c5 9 vss 0.0221094f $X=0.0945 $Y=0.036
r1 8 2 0.154321 $w=8.1e-08 $l=1.25e-08 $layer=N_src_drn $thickness=1e-09
+ $X=0.3095 $Y=0.0675 $X2=0.324 $Y2=0.0675
r2 24 8 0.0308642 $w=8.1e-08 $l=2.5e-09 $layer=N_src_drn $thickness=1e-09
+ $X=0.3066 $Y=0.0675 $X2=0.3095 $Y2=0.0675
r3 2 21 19.3796 $a=3.24e-16 $layer=V0LISD $X=0.324 $Y=0.0675 $X2=0.324 $Y2=0.036
r4 20 21 9.0944 $w=1.3e-08 $l=3.9e-08 $layer=M1 $thickness=3.6e-08 $X=0.285
+ $Y=0.036 $X2=0.324 $Y2=0.036
r5 19 20 15.7403 $w=1.3e-08 $l=6.75e-08 $layer=M1 $thickness=3.6e-08 $X=0.2175
+ $Y=0.036 $X2=0.285 $Y2=0.036
r6 18 19 12.942 $w=1.3e-08 $l=5.55e-08 $layer=M1 $thickness=3.6e-08 $X=0.162
+ $Y=0.036 $X2=0.2175 $Y2=0.036
r7 17 18 6.29612 $w=1.3e-08 $l=2.7e-08 $layer=M1 $thickness=3.6e-08 $X=0.135
+ $Y=0.036 $X2=0.162 $Y2=0.036
r8 16 17 3.14806 $w=1.3e-08 $l=1.35e-08 $layer=M1 $thickness=3.6e-08 $X=0.1215
+ $Y=0.036 $X2=0.135 $Y2=0.036
r9 15 16 3.14806 $w=1.3e-08 $l=1.35e-08 $layer=M1 $thickness=3.6e-08 $X=0.108
+ $Y=0.036 $X2=0.1215 $Y2=0.036
r10 14 15 2.56509 $w=1.3e-08 $l=1.1e-08 $layer=M1 $thickness=3.6e-08 $X=0.097
+ $Y=0.036 $X2=0.108 $Y2=0.036
r11 9 14 0.582974 $w=1.3e-08 $l=2.5e-09 $layer=M1 $thickness=3.6e-08 $X=0.0945
+ $Y=0.036 $X2=0.097 $Y2=0.036
r12 1 15 19.3796 $a=3.24e-16 $layer=V0LISD $X=0.108 $Y=0.0675 $X2=0.108
+ $Y2=0.036
r13 13 11 0.0308642 $w=8.1e-08 $l=2.5e-09 $layer=N_src_drn $thickness=1e-09
+ $X=0.1253 $Y=0.0675 $X2=0.1225 $Y2=0.0675
r14 1 11 0.179012 $w=8.1e-08 $l=1.45e-08 $layer=N_src_drn $thickness=1e-09
+ $X=0.108 $Y=0.0675 $X2=0.1225 $Y2=0.0675
r15 7 1 0.179012 $w=8.1e-08 $l=1.45e-08 $layer=N_src_drn $thickness=1e-09
+ $X=0.0935 $Y=0.0675 $X2=0.108 $Y2=0.0675
r16 12 7 0.0308642 $w=8.1e-08 $l=2.5e-09 $layer=N_src_drn $thickness=1e-09
+ $X=0.0906 $Y=0.0675 $X2=0.0935 $Y2=0.0675
.ends

.subckt PM_MAJIxp5_ASAP7_75t_R%7 vss 12 13 21 7 1 9 2 8
c1 1 vss 0.00884712f $X=0.108 $Y=0.2025
c2 2 vss 0.00602422f $X=0.324 $Y=0.2025
c3 7 vss 0.0045019f $X=0.0935 $Y=0.2025
c4 8 vss 0.0358924f $X=0.3095 $Y=0.2025
c5 9 vss 0.0210074f $X=0.0965 $Y=0.234
r1 8 2 0.154321 $w=8.1e-08 $l=1.25e-08 $layer=P_src_drn $thickness=1e-09
+ $X=0.3095 $Y=0.2025 $X2=0.324 $Y2=0.2025
r2 21 8 0.0308642 $w=8.1e-08 $l=2.5e-09 $layer=P_src_drn $thickness=1e-09
+ $X=0.3066 $Y=0.2025 $X2=0.3095 $Y2=0.2025
r3 2 18 19.3796 $a=3.24e-16 $layer=V0LISD $X=0.324 $Y=0.2025 $X2=0.324 $Y2=0.234
r4 17 18 9.0944 $w=1.3e-08 $l=3.9e-08 $layer=M1 $thickness=3.6e-08 $X=0.285
+ $Y=0.234 $X2=0.324 $Y2=0.234
r5 16 17 13.6416 $w=1.3e-08 $l=5.85e-08 $layer=M1 $thickness=3.6e-08 $X=0.2265
+ $Y=0.234 $X2=0.285 $Y2=0.234
r6 15 16 16.0901 $w=1.3e-08 $l=6.9e-08 $layer=M1 $thickness=3.6e-08 $X=0.1575
+ $Y=0.234 $X2=0.2265 $Y2=0.234
r7 14 15 11.5429 $w=1.3e-08 $l=4.95e-08 $layer=M1 $thickness=3.6e-08 $X=0.108
+ $Y=0.234 $X2=0.1575 $Y2=0.234
r8 9 14 2.68168 $w=1.3e-08 $l=1.15e-08 $layer=M1 $thickness=3.6e-08 $X=0.0965
+ $Y=0.234 $X2=0.108 $Y2=0.234
r9 1 14 19.3796 $a=3.24e-16 $layer=V0LISD $X=0.108 $Y=0.2025 $X2=0.108 $Y2=0.234
r10 13 11 0.0308642 $w=8.1e-08 $l=2.5e-09 $layer=P_src_drn $thickness=1e-09
+ $X=0.1253 $Y=0.2025 $X2=0.1225 $Y2=0.2025
r11 1 11 0.179012 $w=8.1e-08 $l=1.45e-08 $layer=P_src_drn $thickness=1e-09
+ $X=0.108 $Y=0.2025 $X2=0.1225 $Y2=0.2025
r12 7 1 0.179012 $w=8.1e-08 $l=1.45e-08 $layer=P_src_drn $thickness=1e-09
+ $X=0.0935 $Y=0.2025 $X2=0.108 $Y2=0.2025
r13 12 7 0.0308642 $w=8.1e-08 $l=2.5e-09 $layer=P_src_drn $thickness=1e-09
+ $X=0.0906 $Y=0.2025 $X2=0.0935 $Y2=0.2025
.ends

.subckt PM_MAJIxp5_ASAP7_75t_R%Y vss 25 16 17 36 37 8 11 1 2 7 12 13
c1 1 vss 0.00322866f $X=0.27 $Y=0.0675
c2 2 vss 0.00322866f $X=0.27 $Y=0.2025
c3 7 vss 0.00260767f $X=0.2555 $Y=0.0675
c4 8 vss 0.0023966f $X=0.2555 $Y=0.2025
c5 9 vss 0.00102402f $X=0.352 $Y=0.072
c6 10 vss 0.00102402f $X=0.352 $Y=0.198
c7 11 vss 0.000991491f $X=0.256 $Y=0.072
c8 12 vss 0.000862026f $X=0.3405 $Y=0.198
c9 13 vss 0.00229677f $X=0.352 $Y=0.0935
r1 37 35 0.0308642 $w=8.1e-08 $l=2.5e-09 $layer=P_src_drn $thickness=1e-09
+ $X=0.2873 $Y=0.2025 $X2=0.2845 $Y2=0.2025
r2 2 35 0.179012 $w=8.1e-08 $l=1.45e-08 $layer=P_src_drn $thickness=1e-09
+ $X=0.27 $Y=0.2025 $X2=0.2845 $Y2=0.2025
r3 8 2 0.179012 $w=8.1e-08 $l=1.45e-08 $layer=P_src_drn $thickness=1e-09
+ $X=0.2555 $Y=0.2025 $X2=0.27 $Y2=0.2025
r4 36 8 0.0308642 $w=8.1e-08 $l=2.5e-09 $layer=P_src_drn $thickness=1e-09
+ $X=0.2526 $Y=0.2025 $X2=0.2555 $Y2=0.2025
r5 2 31 19.3796 $a=3.24e-16 $layer=V0LISD $X=0.27 $Y=0.2025 $X2=0.269 $Y2=0.198
r6 31 32 3.26466 $w=1.3e-08 $l=1.4e-08 $layer=M1 $thickness=3.6e-08 $X=0.269
+ $Y=0.198 $X2=0.283 $Y2=0.198
r7 29 32 3.26466 $w=1.3e-08 $l=1.4e-08 $layer=M1 $thickness=3.6e-08 $X=0.297
+ $Y=0.198 $X2=0.283 $Y2=0.198
r8 28 29 5.82974 $w=1.3e-08 $l=2.5e-08 $layer=M1 $thickness=3.6e-08 $X=0.322
+ $Y=0.198 $X2=0.297 $Y2=0.198
r9 12 28 4.31401 $w=1.3e-08 $l=1.85e-08 $layer=M1 $thickness=3.6e-08 $X=0.3405
+ $Y=0.198 $X2=0.322 $Y2=0.198
r10 10 27 3.36447 $w=1.71023e-08 $l=2.15e-08 $layer=M1 $thickness=3.6e-08
+ $X=0.352 $Y=0.198 $X2=0.352 $Y2=0.1765
r11 10 12 1.03257 $w=1.6913e-08 $l=1.15e-08 $layer=M1 $thickness=3.6e-08
+ $X=0.352 $Y=0.198 $X2=0.3405 $Y2=0.198
r12 26 27 6.70421 $w=1.3e-08 $l=2.88e-08 $layer=M1 $thickness=3.6e-08 $X=0.352
+ $Y=0.1477 $X2=0.352 $Y2=0.1765
r13 25 26 3.90593 $w=1.3e-08 $l=1.67e-08 $layer=M1 $thickness=3.6e-08 $X=0.354
+ $Y=0.131 $X2=0.352 $Y2=0.1477
r14 25 24 2.97317 $w=1.3e-08 $l=1.28e-08 $layer=M1 $thickness=3.6e-08 $X=0.354
+ $Y=0.131 $X2=0.352 $Y2=0.1182
r15 13 24 5.77145 $w=1.3e-08 $l=2.47e-08 $layer=M1 $thickness=3.6e-08 $X=0.352
+ $Y=0.0935 $X2=0.352 $Y2=0.1182
r16 9 23 1.03257 $w=1.6913e-08 $l=1.15e-08 $layer=M1 $thickness=3.6e-08
+ $X=0.352 $Y=0.072 $X2=0.3405 $Y2=0.072
r17 9 13 3.36447 $w=1.71023e-08 $l=2.15e-08 $layer=M1 $thickness=3.6e-08
+ $X=0.352 $Y=0.072 $X2=0.352 $Y2=0.0935
r18 22 23 4.31401 $w=1.3e-08 $l=1.85e-08 $layer=M1 $thickness=3.6e-08 $X=0.322
+ $Y=0.072 $X2=0.3405 $Y2=0.072
r19 21 22 5.82974 $w=1.3e-08 $l=2.5e-08 $layer=M1 $thickness=3.6e-08 $X=0.297
+ $Y=0.072 $X2=0.322 $Y2=0.072
r20 20 21 3.26466 $w=1.3e-08 $l=1.4e-08 $layer=M1 $thickness=3.6e-08 $X=0.283
+ $Y=0.072 $X2=0.297 $Y2=0.072
r21 19 20 3.26466 $w=1.3e-08 $l=1.4e-08 $layer=M1 $thickness=3.6e-08 $X=0.269
+ $Y=0.072 $X2=0.283 $Y2=0.072
r22 18 19 2.44849 $w=1.3e-08 $l=1.05e-08 $layer=M1 $thickness=3.6e-08 $X=0.2585
+ $Y=0.072 $X2=0.269 $Y2=0.072
r23 11 18 0.582974 $w=1.3e-08 $l=2.5e-09 $layer=M1 $thickness=3.6e-08 $X=0.256
+ $Y=0.072 $X2=0.2585 $Y2=0.072
r24 1 19 19.3796 $a=3.24e-16 $layer=V0LISD $X=0.27 $Y=0.0675 $X2=0.269 $Y2=0.072
r25 17 15 0.0308642 $w=8.1e-08 $l=2.5e-09 $layer=N_src_drn $thickness=1e-09
+ $X=0.2873 $Y=0.0675 $X2=0.2845 $Y2=0.0675
r26 1 15 0.179012 $w=8.1e-08 $l=1.45e-08 $layer=N_src_drn $thickness=1e-09
+ $X=0.27 $Y=0.0675 $X2=0.2845 $Y2=0.0675
r27 7 1 0.179012 $w=8.1e-08 $l=1.45e-08 $layer=N_src_drn $thickness=1e-09
+ $X=0.2555 $Y=0.0675 $X2=0.27 $Y2=0.0675
r28 16 7 0.0308642 $w=8.1e-08 $l=2.5e-09 $layer=N_src_drn $thickness=1e-09
+ $X=0.2526 $Y=0.0675 $X2=0.2555 $Y2=0.0675
.ends

.subckt PM_MAJIxp5_ASAP7_75t_R%10 vss 2 3 1
c1 1 vss 0.000748332f $X=0.216 $Y=0.2025
r1 2 1 0.209877 $w=8.1e-08 $l=1.7e-08 $layer=P_src_drn $thickness=1e-09
+ $X=0.1986 $Y=0.2025 $X2=0.216 $Y2=0.2025
r2 3 1 0.209877 $w=8.1e-08 $l=1.7e-08 $layer=P_src_drn $thickness=1e-09
+ $X=0.2333 $Y=0.2025 $X2=0.216 $Y2=0.2025
.ends

.subckt PM_MAJIxp5_ASAP7_75t_R%C vss 19 6 10 25 28 4 1 5 3
c1 1 vss 0.0169236f $X=0.1255 $Y=0.135
c2 3 vss 0.0828948f $X=0.135 $Y=0.0245
c3 4 vss 0.0858723f $X=0.189 $Y=0.135
c4 5 vss 0.00586363f $X=0.135 $Y=0.135
r1 28 27 16.4967 $w=2.1e-08 $l=4.85e-08 $layer=Gate_1 $thickness=5.6e-08
+ $X=0.189 $Y=0.2025 $X2=0.189 $Y2=0.154
r2 25 26 16.4967 $w=2.1e-08 $l=4.85e-08 $layer=Gate_1 $thickness=5.6e-08
+ $X=0.189 $Y=0.0675 $X2=0.189 $Y2=0.116
r3 4 16 6.54019 $w=2.09524e-08 $layer=Gate_1 $thickness=5.21905e-08 $X=0.189
+ $Y=0.135 $X2=0.189 $Y2=0.135
r4 4 26 6.6497 $w=2.04211e-08 $l=1.9e-08 $layer=Gate_1 $thickness=5.6e-08
+ $X=0.189 $Y=0.135 $X2=0.189 $Y2=0.116
r5 4 27 6.6497 $w=2.04211e-08 $l=1.9e-08 $layer=Gate_1 $thickness=5.6e-08
+ $X=0.189 $Y=0.135 $X2=0.189 $Y2=0.154
r6 19 20 1.22425 $w=1.3e-08 $l=5.2e-09 $layer=M1 $thickness=3.6e-08 $X=0.138
+ $Y=0.116 $X2=0.135 $Y2=0.1212
r7 5 12 19.3796 $a=3.24e-16 $layer=V0LIG $X=0.135 $Y=0.135 $X2=0.135 $Y2=0.135
r8 5 20 3.20636 $w=1.3e-08 $l=1.38e-08 $layer=M1 $thickness=3.6e-08 $X=0.135
+ $Y=0.135 $X2=0.135 $Y2=0.1212
r9 15 16 12.6539 $w=1.77815e-08 $l=2.7e-08 $layer=LIG $thickness=4.8e-08
+ $X=0.162 $Y=0.135 $X2=0.189 $Y2=0.135
r10 13 15 10.1729 $w=1.54914e-08 $l=1.75e-08 $layer=LIG $thickness=4.8e-08
+ $X=0.1445 $Y=0.135 $X2=0.162 $Y2=0.135
r11 12 13 2.48102 $w=2.2e-08 $l=9.5e-09 $layer=LIG $thickness=4.8e-08 $X=0.135
+ $Y=0.135 $X2=0.1445 $Y2=0.135
r12 1 12 2.48102 $w=2.2e-08 $l=9.5e-09 $layer=LIG $thickness=4.8e-08 $X=0.1255
+ $Y=0.135 $X2=0.135 $Y2=0.135
r13 10 9 16.4967 $w=2.1e-08 $l=4.85e-08 $layer=Gate_1 $thickness=5.6e-08
+ $X=0.135 $Y=0.2025 $X2=0.135 $Y2=0.154
r14 8 9 6.6497 $w=2.04211e-08 $l=1.9e-08 $layer=Gate_1 $thickness=5.6e-08
+ $X=0.135 $Y=0.135 $X2=0.135 $Y2=0.154
r15 8 13 4.05918 $w=2.0087e-08 $l=9.5e-09 $layer=Gate_1 $thickness=5.56522e-08
+ $X=0.135 $Y=0.135 $X2=0.1445 $Y2=0.135
r16 8 12 6.27904 $w=2.09e-08 $layer=Gate_1 $thickness=5.24e-08 $X=0.135
+ $Y=0.135 $X2=0.135 $Y2=0.135
r17 7 8 6.6497 $w=2.04211e-08 $l=1.9e-08 $layer=Gate_1 $thickness=5.6e-08
+ $X=0.135 $Y=0.116 $X2=0.135 $Y2=0.135
r18 6 7 16.4967 $w=2.1e-08 $l=4.85e-08 $layer=Gate_1 $thickness=5.6e-08
+ $X=0.135 $Y=0.0675 $X2=0.135 $Y2=0.116
r19 6 3 14.6259 $w=2.1e-08 $l=4.3e-08 $layer=Gate_1 $thickness=5.6e-08 $X=0.135
+ $Y=0.0675 $X2=0.135 $Y2=0.0245
.ends

* End of included file MAJIxp5_ASAP7_75t_R.pex.sp.pex

*
.subckt MAJIxp5_ASAP7_75t_CUSTOM_4_25_0_7 VSS VDD B C A Y
*
* VSS VSS
* VDD VDD
* B B
* C C
* A A
* Y Y
*
*

M0 N_M0_d N_M0_g VSS VSS nmos_rvt L=2e-08 W=8.1e-08 nfin=3 $X=0.071 $Y=0.027
M1 VSS N_M1_g N_M1_s VSS nmos_rvt L=2e-08 W=8.1e-08 nfin=3 $X=0.125 $Y=0.027
M2 N_M2_d N_M2_g VSS VSS nmos_rvt L=2e-08 W=8.1e-08 nfin=3 $X=0.179 $Y=0.027
M3 N_M3_d N_M3_g N_M3_s VSS nmos_rvt L=2e-08 W=8.1e-08 nfin=3 $X=0.233 $Y=0.027
M4 N_M4_d N_M4_g N_M4_s VSS nmos_rvt L=2e-08 W=8.1e-08 nfin=3 $X=0.287 $Y=0.027
M5 N_M5_d N_M5_g VDD VDD pmos_rvt L=2e-08 W=8.1e-08 nfin=3 $X=0.071 $Y=0.162
M6 VDD N_M6_g N_M6_s VDD pmos_rvt L=2e-08 W=8.1e-08 nfin=3 $X=0.125 $Y=0.162
M7 N_M7_d N_M7_g VDD VDD pmos_rvt L=2e-08 W=8.1e-08 nfin=3 $X=0.179 $Y=0.162
M8 N_M8_d N_M8_g N_M8_s VDD pmos_rvt L=2e-08 W=8.1e-08 nfin=3 $X=0.233 $Y=0.162
M9 N_M9_d N_M9_g N_M9_s VDD pmos_rvt L=2e-08 W=8.1e-08 nfin=3 $X=0.287 $Y=0.162

* .include "MAJIxp5_ASAP7_75t_R.pex.sp.pxi"

* Start of included file MAJIxp5_ASAP7_75t_R.pex.sp.pxi
x_PM_MAJIxp5_ASAP7_75t_R%9 vss N_M2_d N_M3_s N_9_1 PM_MAJIxp5_ASAP7_75t_R%9
cc_1 N_9_1 N_B_6 0.0167315f $X=0.216 $Y=0.0675
cc_2 N_9_1 N_C_4 0.0169049f $X=0.216 $Y=0.0675
x_PM_MAJIxp5_ASAP7_75t_R%B vss B N_M0_g N_M5_g N_M3_g N_M8_g N_B_1 N_B_16
+ N_B_13 N_B_2 N_B_15 N_B_9 N_B_14 N_B_5 N_B_6 N_B_11 N_B_10
+ PM_MAJIxp5_ASAP7_75t_R%B
x_PM_MAJIxp5_ASAP7_75t_R%A vss A N_M4_g N_M9_g N_A_3 N_A_4 N_A_1
+ PM_MAJIxp5_ASAP7_75t_R%A
cc_3 N_A_3 N_B_2 0.000965267f $X=0.297 $Y=0.0245
cc_4 N_A_4 N_B_16 0.00161076f $X=0.297 $Y=0.135
cc_5 N_A_3 N_B_6 0.00407878f $X=0.297 $Y=0.0245
x_PM_MAJIxp5_ASAP7_75t_R%6 vss N_M0_d N_M1_s N_M4_d N_6_7 N_6_1 N_6_9 N_6_8
+ N_6_2 PM_MAJIxp5_ASAP7_75t_R%6
cc_6 N_6_7 N_B_1 0.000928163f $X=0.0935 $Y=0.0675
cc_7 N_6_7 N_B_11 0.000418316f $X=0.0935 $Y=0.0675
cc_8 N_6_1 N_B_5 0.000935792f $X=0.108 $Y=0.0675
cc_9 N_6_9 N_B_16 0.00127002f $X=0.0945 $Y=0.036
cc_10 N_6_7 N_B_5 0.034488f $X=0.0935 $Y=0.0675
cc_11 N_6_7 N_C_1 0.000914129f $X=0.0935 $Y=0.0675
cc_12 N_6_1 N_C_3 0.00111759f $X=0.108 $Y=0.0675
cc_13 N_6_9 N_C_5 0.00131374f $X=0.0945 $Y=0.036
cc_14 N_6_1 N_C_5 0.00181403f $X=0.108 $Y=0.0675
cc_15 N_6_7 N_C_3 0.0342098f $X=0.0935 $Y=0.0675
cc_16 N_6_8 N_A_3 0.0359098f $X=0.3095 $Y=0.0675
x_PM_MAJIxp5_ASAP7_75t_R%7 vss N_M5_d N_M6_s N_M9_d N_7_7 N_7_1 N_7_9 N_7_2
+ N_7_8 PM_MAJIxp5_ASAP7_75t_R%7
cc_17 N_7_7 N_B_15 0.000251941f $X=0.0935 $Y=0.2025
cc_18 N_7_7 N_B_14 0.000553513f $X=0.0935 $Y=0.2025
cc_19 N_7_7 N_B_1 0.000636529f $X=0.0935 $Y=0.2025
cc_20 N_7_1 N_B_5 0.00158094f $X=0.108 $Y=0.2025
cc_21 N_7_9 N_B_14 0.00408089f $X=0.0965 $Y=0.234
cc_22 N_7_9 N_B_10 0.00556151f $X=0.0965 $Y=0.234
cc_23 N_7_7 N_B_5 0.0341814f $X=0.0935 $Y=0.2025
cc_24 N_7_7 N_C_1 0.000805088f $X=0.0935 $Y=0.2025
cc_25 N_7_7 N_C_3 0.0346708f $X=0.0935 $Y=0.2025
cc_26 N_7_2 N_A_3 0.000948672f $X=0.324 $Y=0.2025
cc_27 N_7_8 N_A_3 0.0348791f $X=0.3095 $Y=0.2025
x_PM_MAJIxp5_ASAP7_75t_R%Y vss Y N_M3_d N_M4_s N_M8_d N_M9_s N_Y_8 N_Y_11 N_Y_1
+ N_Y_2 N_Y_7 N_Y_12 N_Y_13 PM_MAJIxp5_ASAP7_75t_R%Y
cc_28 N_Y_8 N_B_2 0.00080016f $X=0.2555 $Y=0.2025
cc_29 N_Y_11 N_B_16 0.000481571f $X=0.256 $Y=0.072
cc_30 N_Y_1 N_B_2 0.000744621f $X=0.27 $Y=0.0675
cc_31 N_Y_1 N_B_6 0.00102646f $X=0.27 $Y=0.0675
cc_32 N_Y_2 N_B_6 0.00102646f $X=0.27 $Y=0.2025
cc_33 N_Y_7 N_B_2 0.00156861f $X=0.2555 $Y=0.0675
cc_34 N_Y_12 N_B_16 0.00158333f $X=0.3405 $Y=0.198
cc_35 N_Y_7 N_B_6 0.0142496f $X=0.2555 $Y=0.0675
cc_36 N_Y_8 N_B_6 0.0533501f $X=0.2555 $Y=0.2025
cc_37 N_Y_2 N_A_3 0.000756739f $X=0.27 $Y=0.2025
cc_38 N_Y_2 N_A_1 0.000841264f $X=0.27 $Y=0.2025
cc_39 N_Y_11 N_A_4 0.000952194f $X=0.256 $Y=0.072
cc_40 N_Y_12 N_A_4 0.00097616f $X=0.3405 $Y=0.198
cc_41 N_Y_7 N_A_1 0.00144183f $X=0.2555 $Y=0.0675
cc_42 N_Y_13 N_A_4 0.00445382f $X=0.352 $Y=0.0935
cc_43 N_Y_7 N_A_3 0.0140553f $X=0.2555 $Y=0.0675
cc_44 N_Y_8 N_A_3 0.0528406f $X=0.2555 $Y=0.2025
cc_45 N_Y_1 N_6_9 0.000666367f $X=0.27 $Y=0.0675
cc_46 N_Y_11 N_6_2 0.000674921f $X=0.256 $Y=0.072
cc_47 N_Y_7 N_6_8 0.000750844f $X=0.2555 $Y=0.0675
cc_48 N_Y_1 N_6_2 0.00387072f $X=0.27 $Y=0.0675
cc_49 N_Y_11 N_6_9 0.00977748f $X=0.256 $Y=0.072
cc_50 N_Y_2 N_7_9 0.000666367f $X=0.27 $Y=0.2025
cc_51 N_Y_12 N_7_2 0.000674921f $X=0.3405 $Y=0.198
cc_52 N_Y_8 N_7_8 0.000750597f $X=0.2555 $Y=0.2025
cc_53 N_Y_2 N_7_2 0.00387072f $X=0.27 $Y=0.2025
cc_54 N_Y_12 N_7_9 0.00950172f $X=0.3405 $Y=0.198
x_PM_MAJIxp5_ASAP7_75t_R%10 vss N_M7_d N_M8_s N_10_1 PM_MAJIxp5_ASAP7_75t_R%10
cc_55 N_10_1 N_B_6 0.0168226f $X=0.216 $Y=0.2025
cc_56 N_10_1 N_C_4 0.0169049f $X=0.216 $Y=0.2025
x_PM_MAJIxp5_ASAP7_75t_R%C vss C N_M1_g N_M6_g N_M2_g N_M7_g N_C_4 N_C_1 N_C_5
+ N_C_3 PM_MAJIxp5_ASAP7_75t_R%C
cc_57 N_C_4 N_B_1 0.000367473f $X=0.189 $Y=0.135
cc_58 N_C_4 N_B_16 0.000398273f $X=0.189 $Y=0.135
cc_59 N_C_1 N_B_1 0.000558679f $X=0.1255 $Y=0.135
cc_60 N_C_1 N_B_13 0.000644893f $X=0.1255 $Y=0.135
cc_61 N_C_1 N_B_2 0.000663865f $X=0.1255 $Y=0.135
cc_62 N_C_5 N_B_15 0.000716609f $X=0.135 $Y=0.135
cc_63 N_C_5 N_B_9 0.000820024f $X=0.135 $Y=0.135
cc_64 N_C_5 N_B_14 0.00117519f $X=0.135 $Y=0.135
cc_65 N_C_1 N_B_9 0.00222788f $X=0.1255 $Y=0.135
cc_66 N_C_3 N_B_5 0.00345439f $X=0.135 $Y=0.0245
cc_67 N_C_5 N_B_13 0.00407266f $X=0.135 $Y=0.135
cc_68 N_C_4 N_B_6 0.0073516f $X=0.189 $Y=0.135

* End of included file MAJIxp5_ASAP7_75t_R.pex.sp.pxi
.ends

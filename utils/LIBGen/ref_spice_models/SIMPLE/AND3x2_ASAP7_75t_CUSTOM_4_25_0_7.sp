.subckt PM_AND3x2_ASAP7_75t_R%8 vss 2 3 1
c1 1 vss 0.000709764f $X=0.108 $Y=0.0675
r1 2 1 0.209877 $w=8.1e-08 $l=1.7e-08 $layer=N_src_drn $thickness=1e-09
+ $X=0.0906 $Y=0.0675 $X2=0.108 $Y2=0.0675
r2 3 1 0.209877 $w=8.1e-08 $l=1.7e-08 $layer=N_src_drn $thickness=1e-09
+ $X=0.1253 $Y=0.0675 $X2=0.108 $Y2=0.0675
.ends

.subckt PM_AND3x2_ASAP7_75t_R%B vss 13 5 9 1 4 3
c1 1 vss 0.00725516f $X=0.135 $Y=0.135
c2 3 vss 0.046692f $X=0.135 $Y=0.0245
c3 4 vss 0.00500483f $X=0.135 $Y=0.098
r1 13 4 8.62802 $w=1.3e-08 $l=3.7e-08 $layer=M1 $thickness=3.6e-08 $X=0.138
+ $Y=0.137 $X2=0.135 $Y2=0.098
r2 1 7 6.74717 $w=2e-08 $layer=Gate_1 $thickness=5.2e-08 $X=0.135 $Y=0.135
+ $X2=0.135 $Y2=0.135
r3 13 1 19.3796 $a=3.24e-16 $layer=V0LIG $X=0.138 $Y=0.137 $X2=0.135 $Y2=0.135
r4 9 8 16.6668 $w=2.1e-08 $l=4.9e-08 $layer=Gate_1 $thickness=5.6e-08 $X=0.135
+ $Y=0.2025 $X2=0.135 $Y2=0.1535
r5 7 8 6.46262 $w=2.04595e-08 $l=1.85e-08 $layer=Gate_1 $thickness=5.6e-08
+ $X=0.135 $Y=0.135 $X2=0.135 $Y2=0.1535
r6 6 7 6.46262 $w=2.04595e-08 $l=1.85e-08 $layer=Gate_1 $thickness=5.6e-08
+ $X=0.135 $Y=0.1165 $X2=0.135 $Y2=0.135
r7 5 6 16.6668 $w=2.1e-08 $l=4.9e-08 $layer=Gate_1 $thickness=5.6e-08 $X=0.135
+ $Y=0.0675 $X2=0.135 $Y2=0.1165
r8 5 3 14.6259 $w=2.1e-08 $l=4.3e-08 $layer=Gate_1 $thickness=5.6e-08 $X=0.135
+ $Y=0.0675 $X2=0.135 $Y2=0.0245
.ends

.subckt PM_AND3x2_ASAP7_75t_R%C vss 13 5 9 3 4 1
c1 1 vss 0.00749331f $X=0.189 $Y=0.135
c2 3 vss 0.0842267f $X=0.189 $Y=0.0245
c3 4 vss 0.00461997f $X=0.189 $Y=0.098
r1 13 4 8.62802 $w=1.3e-08 $l=3.7e-08 $layer=M1 $thickness=3.6e-08 $X=0.189
+ $Y=0.137 $X2=0.189 $Y2=0.098
r2 1 7 6.74717 $w=2e-08 $layer=Gate_1 $thickness=5.2e-08 $X=0.189 $Y=0.135
+ $X2=0.189 $Y2=0.135
r3 13 1 19.3796 $a=3.24e-16 $layer=V0LIG $X=0.189 $Y=0.137 $X2=0.189 $Y2=0.135
r4 9 8 16.6668 $w=2.1e-08 $l=4.9e-08 $layer=Gate_1 $thickness=5.6e-08 $X=0.189
+ $Y=0.2025 $X2=0.189 $Y2=0.1535
r5 7 8 6.46262 $w=2.04595e-08 $l=1.85e-08 $layer=Gate_1 $thickness=5.6e-08
+ $X=0.189 $Y=0.135 $X2=0.189 $Y2=0.1535
r6 6 7 6.46262 $w=2.04595e-08 $l=1.85e-08 $layer=Gate_1 $thickness=5.6e-08
+ $X=0.189 $Y=0.1165 $X2=0.189 $Y2=0.135
r7 5 6 16.6668 $w=2.1e-08 $l=4.9e-08 $layer=Gate_1 $thickness=5.6e-08 $X=0.189
+ $Y=0.0675 $X2=0.189 $Y2=0.1165
r8 5 3 14.6259 $w=2.1e-08 $l=4.3e-08 $layer=Gate_1 $thickness=5.6e-08 $X=0.189
+ $Y=0.0675 $X2=0.189 $Y2=0.0245
.ends

.subckt PM_AND3x2_ASAP7_75t_R%Y vss 28 20 21 36 37 7 1 2 14 13 8
c1 1 vss 0.00727614f $X=0.27 $Y=0.0675
c2 2 vss 0.00735408f $X=0.27 $Y=0.2025
c3 7 vss 0.00447419f $X=0.2555 $Y=0.0675
c4 8 vss 0.00452755f $X=0.2555 $Y=0.2025
c5 9 vss 0.00258166f $X=0.27 $Y=0.036
c6 10 vss 0.00258166f $X=0.27 $Y=0.234
c7 11 vss 0.00291437f $X=0.351 $Y=0.036
c8 12 vss 0.00291437f $X=0.351 $Y=0.234
c9 13 vss 0.00132906f $X=0.27 $Y=0.054
c10 14 vss 0.000921364f $X=0.27 $Y=0.1865
c11 15 vss 0.00596413f $X=0.2815 $Y=0.036
c12 16 vss 0.00597892f $X=0.313 $Y=0.234
c13 17 vss 0.00819883f $X=0.351 $Y=0.0655
r1 37 35 0.0308642 $w=8.1e-08 $l=2.5e-09 $layer=P_src_drn $thickness=1e-09
+ $X=0.2873 $Y=0.2025 $X2=0.2845 $Y2=0.2025
r2 2 35 0.179012 $w=8.1e-08 $l=1.45e-08 $layer=P_src_drn $thickness=1e-09
+ $X=0.27 $Y=0.2025 $X2=0.2845 $Y2=0.2025
r3 8 2 0.179012 $w=8.1e-08 $l=1.45e-08 $layer=P_src_drn $thickness=1e-09
+ $X=0.2555 $Y=0.2025 $X2=0.27 $Y2=0.2025
r4 36 8 0.0308642 $w=8.1e-08 $l=2.5e-09 $layer=P_src_drn $thickness=1e-09
+ $X=0.2526 $Y=0.2025 $X2=0.2555 $Y2=0.2025
r5 2 32 19.3796 $a=3.24e-16 $layer=V0LISD $X=0.27 $Y=0.2025 $X2=0.27 $Y2=0.198
r6 32 33 4.19742 $w=1.3e-08 $l=1.8e-08 $layer=M1 $thickness=3.6e-08 $X=0.27
+ $Y=0.198 $X2=0.27 $Y2=0.216
r7 14 32 2.68168 $w=1.3e-08 $l=1.15e-08 $layer=M1 $thickness=3.6e-08 $X=0.27
+ $Y=0.1865 $X2=0.27 $Y2=0.198
r8 10 31 1.03257 $w=1.6913e-08 $l=1.15e-08 $layer=M1 $thickness=3.6e-08 $X=0.27
+ $Y=0.234 $X2=0.2815 $Y2=0.234
r9 10 33 2.5483 $w=1.79e-08 $l=1.8e-08 $layer=M1 $thickness=3.6e-08 $X=0.27
+ $Y=0.234 $X2=0.27 $Y2=0.216
r10 16 31 7.34548 $w=1.3e-08 $l=3.15e-08 $layer=M1 $thickness=3.6e-08 $X=0.313
+ $Y=0.234 $X2=0.2815 $Y2=0.234
r11 12 30 5.22999 $w=1.59898e-08 $l=2.95e-08 $layer=M1 $thickness=3.6e-08
+ $X=0.351 $Y=0.234 $X2=0.351 $Y2=0.2045
r12 12 16 7.2121 $w=1.41842e-08 $l=3.8e-08 $layer=M1 $thickness=3.6e-08
+ $X=0.351 $Y=0.234 $X2=0.313 $Y2=0.234
r13 29 30 8.97781 $w=1.3e-08 $l=3.85e-08 $layer=M1 $thickness=3.6e-08 $X=0.351
+ $Y=0.166 $X2=0.351 $Y2=0.2045
r14 28 29 4.31401 $w=1.3e-08 $l=1.85e-08 $layer=M1 $thickness=3.6e-08 $X=0.352
+ $Y=0.1475 $X2=0.351 $Y2=0.166
r15 28 27 0.46638 $w=1.3e-08 $l=2e-09 $layer=M1 $thickness=3.6e-08 $X=0.352
+ $Y=0.1475 $X2=0.351 $Y2=0.1455
r16 26 27 2.44849 $w=1.3e-08 $l=1.05e-08 $layer=M1 $thickness=3.6e-08 $X=0.351
+ $Y=0.135 $X2=0.351 $Y2=0.1455
r17 25 26 6.7625 $w=1.3e-08 $l=2.9e-08 $layer=M1 $thickness=3.6e-08 $X=0.351
+ $Y=0.106 $X2=0.351 $Y2=0.135
r18 17 25 9.44419 $w=1.3e-08 $l=4.05e-08 $layer=M1 $thickness=3.6e-08 $X=0.351
+ $Y=0.0655 $X2=0.351 $Y2=0.106
r19 11 24 7.2121 $w=1.41842e-08 $l=3.8e-08 $layer=M1 $thickness=3.6e-08
+ $X=0.351 $Y=0.036 $X2=0.313 $Y2=0.036
r20 11 17 5.22999 $w=1.59898e-08 $l=2.95e-08 $layer=M1 $thickness=3.6e-08
+ $X=0.351 $Y=0.036 $X2=0.351 $Y2=0.0655
r21 15 24 7.34548 $w=1.3e-08 $l=3.15e-08 $layer=M1 $thickness=3.6e-08 $X=0.2815
+ $Y=0.036 $X2=0.313 $Y2=0.036
r22 9 13 2.5483 $w=1.79e-08 $l=1.8e-08 $layer=M1 $thickness=3.6e-08 $X=0.27
+ $Y=0.036 $X2=0.27 $Y2=0.054
r23 9 15 1.03257 $w=1.6913e-08 $l=1.15e-08 $layer=M1 $thickness=3.6e-08 $X=0.27
+ $Y=0.036 $X2=0.2815 $Y2=0.036
r24 13 22 4.19742 $w=1.3e-08 $l=1.8e-08 $layer=M1 $thickness=3.6e-08 $X=0.27
+ $Y=0.054 $X2=0.27 $Y2=0.072
r25 1 22 19.3796 $a=3.24e-16 $layer=V0LISD $X=0.27 $Y=0.0675 $X2=0.27 $Y2=0.072
r26 21 19 0.0308642 $w=8.1e-08 $l=2.5e-09 $layer=N_src_drn $thickness=1e-09
+ $X=0.2873 $Y=0.0675 $X2=0.2845 $Y2=0.0675
r27 1 19 0.179012 $w=8.1e-08 $l=1.45e-08 $layer=N_src_drn $thickness=1e-09
+ $X=0.27 $Y=0.0675 $X2=0.2845 $Y2=0.0675
r28 7 1 0.179012 $w=8.1e-08 $l=1.45e-08 $layer=N_src_drn $thickness=1e-09
+ $X=0.2555 $Y=0.0675 $X2=0.27 $Y2=0.0675
r29 20 7 0.0308642 $w=8.1e-08 $l=2.5e-09 $layer=N_src_drn $thickness=1e-09
+ $X=0.2526 $Y=0.0675 $X2=0.2555 $Y2=0.0675
.ends

.subckt PM_AND3x2_ASAP7_75t_R%6 vss 25 29 39 43 68 71 72 74 14 3 21 20 4 15 5
+ 16 1 18 12 23 22 24 19 17 13
c1 1 vss 0.00690141f $X=0.243 $Y=0.135
c2 3 vss 0.00799688f $X=0.054 $Y=0.0675
c3 4 vss 0.00986482f $X=0.054 $Y=0.2025
c4 5 vss 0.00867137f $X=0.162 $Y=0.2025
c5 12 vss 0.0812687f $X=0.243 $Y=0.0245
c6 13 vss 0.0840224f $X=0.297 $Y=0.135
c7 14 vss 0.0399907f $X=0.056 $Y=0.0675
c8 15 vss 0.04062f $X=0.056 $Y=0.2025
c9 16 vss 0.00671705f $X=0.1475 $Y=0.2025
c10 17 vss 0.00286069f $X=0.225 $Y=0.036
c11 18 vss 0.000183953f $X=0.225 $Y=0.135
c12 19 vss 0.00283096f $X=0.225 $Y=0.234
c13 20 vss 0.0180477f $X=0.207 $Y=0.036
c14 21 vss 0.0176993f $X=0.207 $Y=0.234
c15 22 vss 0.00258802f $X=0.225 $Y=0.106
c16 23 vss 0.00265882f $X=0.225 $Y=0.164
c17 24 vss 0.00118418f $X=0.27 $Y=0.135
r1 74 73 0.0308642 $w=8.1e-08 $l=2.5e-09 $layer=P_src_drn $thickness=1e-09
+ $X=0.0713 $Y=0.2025 $X2=0.0685 $Y2=0.2025
r2 15 73 0.154321 $w=8.1e-08 $l=1.25e-08 $layer=P_src_drn $thickness=1e-09
+ $X=0.056 $Y=0.2025 $X2=0.0685 $Y2=0.2025
r3 72 70 0.0308642 $w=8.1e-08 $l=2.5e-09 $layer=P_src_drn $thickness=1e-09
+ $X=0.1793 $Y=0.2025 $X2=0.1765 $Y2=0.2025
r4 5 70 0.179012 $w=8.1e-08 $l=1.45e-08 $layer=P_src_drn $thickness=1e-09
+ $X=0.162 $Y=0.2025 $X2=0.1765 $Y2=0.2025
r5 16 5 0.179012 $w=8.1e-08 $l=1.45e-08 $layer=P_src_drn $thickness=1e-09
+ $X=0.1475 $Y=0.2025 $X2=0.162 $Y2=0.2025
r6 71 16 0.0308642 $w=8.1e-08 $l=2.5e-09 $layer=P_src_drn $thickness=1e-09
+ $X=0.1446 $Y=0.2025 $X2=0.1475 $Y2=0.2025
r7 68 67 0.0308642 $w=8.1e-08 $l=2.5e-09 $layer=N_src_drn $thickness=1e-09
+ $X=0.0713 $Y=0.0675 $X2=0.0685 $Y2=0.0675
r8 14 67 0.154321 $w=8.1e-08 $l=1.25e-08 $layer=N_src_drn $thickness=1e-09
+ $X=0.056 $Y=0.0675 $X2=0.0685 $Y2=0.0675
r9 4 65 19.3796 $a=3.24e-16 $layer=V0LISD $X=0.054 $Y=0.2025 $X2=0.054 $Y2=0.234
r10 5 59 19.3796 $a=3.24e-16 $layer=V0LISD $X=0.162 $Y=0.2025 $X2=0.162
+ $Y2=0.234
r11 3 55 19.3796 $a=3.24e-16 $layer=V0LISD $X=0.054 $Y=0.0675 $X2=0.054
+ $Y2=0.036
r12 65 66 3.14806 $w=1.3e-08 $l=1.35e-08 $layer=M1 $thickness=3.6e-08 $X=0.054
+ $Y=0.234 $X2=0.0675 $Y2=0.234
r13 63 66 3.14806 $w=1.3e-08 $l=1.35e-08 $layer=M1 $thickness=3.6e-08 $X=0.081
+ $Y=0.234 $X2=0.0675 $Y2=0.234
r14 62 63 6.29612 $w=1.3e-08 $l=2.7e-08 $layer=M1 $thickness=3.6e-08 $X=0.108
+ $Y=0.234 $X2=0.081 $Y2=0.234
r15 61 62 6.29612 $w=1.3e-08 $l=2.7e-08 $layer=M1 $thickness=3.6e-08 $X=0.135
+ $Y=0.234 $X2=0.108 $Y2=0.234
r16 59 60 3.14806 $w=1.3e-08 $l=1.35e-08 $layer=M1 $thickness=3.6e-08 $X=0.162
+ $Y=0.234 $X2=0.1755 $Y2=0.234
r17 58 59 3.14806 $w=1.3e-08 $l=1.35e-08 $layer=M1 $thickness=3.6e-08 $X=0.1485
+ $Y=0.234 $X2=0.162 $Y2=0.234
r18 58 61 3.14806 $w=1.3e-08 $l=1.35e-08 $layer=M1 $thickness=3.6e-08 $X=0.1485
+ $Y=0.234 $X2=0.135 $Y2=0.234
r19 57 60 3.14806 $w=1.3e-08 $l=1.35e-08 $layer=M1 $thickness=3.6e-08 $X=0.189
+ $Y=0.234 $X2=0.1755 $Y2=0.234
r20 21 57 4.19742 $w=1.3e-08 $l=1.8e-08 $layer=M1 $thickness=3.6e-08 $X=0.207
+ $Y=0.234 $X2=0.189 $Y2=0.234
r21 55 56 3.14806 $w=1.3e-08 $l=1.35e-08 $layer=M1 $thickness=3.6e-08 $X=0.054
+ $Y=0.036 $X2=0.0675 $Y2=0.036
r22 53 56 3.14806 $w=1.3e-08 $l=1.35e-08 $layer=M1 $thickness=3.6e-08 $X=0.081
+ $Y=0.036 $X2=0.0675 $Y2=0.036
r23 52 53 6.29612 $w=1.3e-08 $l=2.7e-08 $layer=M1 $thickness=3.6e-08 $X=0.108
+ $Y=0.036 $X2=0.081 $Y2=0.036
r24 51 52 6.29612 $w=1.3e-08 $l=2.7e-08 $layer=M1 $thickness=3.6e-08 $X=0.135
+ $Y=0.036 $X2=0.108 $Y2=0.036
r25 50 51 6.29612 $w=1.3e-08 $l=2.7e-08 $layer=M1 $thickness=3.6e-08 $X=0.162
+ $Y=0.036 $X2=0.135 $Y2=0.036
r26 49 50 6.29612 $w=1.3e-08 $l=2.7e-08 $layer=M1 $thickness=3.6e-08 $X=0.189
+ $Y=0.036 $X2=0.162 $Y2=0.036
r27 20 49 4.19742 $w=1.3e-08 $l=1.8e-08 $layer=M1 $thickness=3.6e-08 $X=0.207
+ $Y=0.036 $X2=0.189 $Y2=0.036
r28 19 48 3.36447 $w=1.71023e-08 $l=2.15e-08 $layer=M1 $thickness=3.6e-08
+ $X=0.225 $Y=0.234 $X2=0.225 $Y2=0.2125
r29 19 21 2.5483 $w=1.55e-08 $l=1.8e-08 $layer=M1 $thickness=3.6e-08 $X=0.225
+ $Y=0.234 $X2=0.207 $Y2=0.234
r30 17 46 3.36447 $w=1.71023e-08 $l=2.15e-08 $layer=M1 $thickness=3.6e-08
+ $X=0.225 $Y=0.036 $X2=0.225 $Y2=0.0575
r31 17 20 2.5483 $w=1.55e-08 $l=1.8e-08 $layer=M1 $thickness=3.6e-08 $X=0.225
+ $Y=0.036 $X2=0.207 $Y2=0.036
r32 47 48 4.78039 $w=1.3e-08 $l=2.05e-08 $layer=M1 $thickness=3.6e-08 $X=0.225
+ $Y=0.192 $X2=0.225 $Y2=0.2125
r33 23 47 6.52931 $w=1.3e-08 $l=2.8e-08 $layer=M1 $thickness=3.6e-08 $X=0.225
+ $Y=0.164 $X2=0.225 $Y2=0.192
r34 45 46 4.78039 $w=1.3e-08 $l=2.05e-08 $layer=M1 $thickness=3.6e-08 $X=0.225
+ $Y=0.078 $X2=0.225 $Y2=0.0575
r35 22 45 6.52931 $w=1.3e-08 $l=2.8e-08 $layer=M1 $thickness=3.6e-08 $X=0.225
+ $Y=0.106 $X2=0.225 $Y2=0.078
r36 18 35 4.06646 $w=1.5e-08 $l=2.25e-08 $layer=M1 $thickness=3.6e-08 $X=0.225
+ $Y=0.135 $X2=0.2475 $Y2=0.135
r37 18 22 5.5822 $w=1.45517e-08 $l=2.9e-08 $layer=M1 $thickness=3.6e-08
+ $X=0.225 $Y=0.135 $X2=0.225 $Y2=0.106
r38 18 23 5.5822 $w=1.45517e-08 $l=2.9e-08 $layer=M1 $thickness=3.6e-08
+ $X=0.225 $Y=0.135 $X2=0.225 $Y2=0.164
r39 43 42 14.6259 $w=2.1e-08 $l=4.3e-08 $layer=Gate_1 $thickness=5.6e-08
+ $X=0.297 $Y=0.2025 $X2=0.297 $Y2=0.1595
r40 41 42 2.89117 $w=2.1e-08 $l=8.5e-09 $layer=Gate_1 $thickness=5.6e-08
+ $X=0.297 $Y=0.151 $X2=0.297 $Y2=0.1595
r41 39 40 14.6259 $w=2.1e-08 $l=4.3e-08 $layer=Gate_1 $thickness=5.6e-08
+ $X=0.297 $Y=0.0675 $X2=0.297 $Y2=0.1105
r42 37 40 2.89117 $w=2.1e-08 $l=8.5e-09 $layer=Gate_1 $thickness=5.6e-08
+ $X=0.297 $Y=0.119 $X2=0.297 $Y2=0.1105
r43 13 33 6.74717 $w=2e-08 $layer=Gate_1 $thickness=5.2e-08 $X=0.297 $Y=0.135
+ $X2=0.297 $Y2=0.135
r44 13 37 5.61228 $w=2.0375e-08 $l=1.6e-08 $layer=Gate_1 $thickness=5.6e-08
+ $X=0.297 $Y=0.135 $X2=0.297 $Y2=0.119
r45 13 41 5.61228 $w=2.0375e-08 $l=1.6e-08 $layer=Gate_1 $thickness=5.6e-08
+ $X=0.297 $Y=0.135 $X2=0.297 $Y2=0.151
r46 24 32 19.3796 $a=3.24e-16 $layer=V0LIG $X=0.27 $Y=0.135 $X2=0.27 $Y2=0.135
r47 24 35 5.24677 $w=1.3e-08 $l=2.25e-08 $layer=M1 $thickness=3.6e-08 $X=0.27
+ $Y=0.135 $X2=0.2475 $Y2=0.135
r48 32 33 20.114 $w=1.57815e-08 $l=2.7e-08 $layer=LIG $thickness=4.8e-08
+ $X=0.27 $Y=0.135 $X2=0.297 $Y2=0.135
r49 1 27 6.74717 $w=2e-08 $layer=Gate_1 $thickness=5.2e-08 $X=0.243 $Y=0.135
+ $X2=0.243 $Y2=0.135
r50 1 32 20.114 $w=1.57815e-08 $l=2.7e-08 $layer=LIG $thickness=4.8e-08
+ $X=0.243 $Y=0.135 $X2=0.27 $Y2=0.135
r51 29 28 16.6668 $w=2.1e-08 $l=4.9e-08 $layer=Gate_1 $thickness=5.6e-08
+ $X=0.243 $Y=0.2025 $X2=0.243 $Y2=0.1535
r52 27 28 6.46262 $w=2.04595e-08 $l=1.85e-08 $layer=Gate_1 $thickness=5.6e-08
+ $X=0.243 $Y=0.135 $X2=0.243 $Y2=0.1535
r53 26 27 6.46262 $w=2.04595e-08 $l=1.85e-08 $layer=Gate_1 $thickness=5.6e-08
+ $X=0.243 $Y=0.1165 $X2=0.243 $Y2=0.135
r54 25 26 16.6668 $w=2.1e-08 $l=4.9e-08 $layer=Gate_1 $thickness=5.6e-08
+ $X=0.243 $Y=0.0675 $X2=0.243 $Y2=0.1165
r55 25 12 14.6259 $w=2.1e-08 $l=4.3e-08 $layer=Gate_1 $thickness=5.6e-08
+ $X=0.243 $Y=0.0675 $X2=0.243 $Y2=0.0245
r56 4 15 1e-05 $l=2e-09 $X=0.054 $Y=0.2025 $X2=0.056 $Y2=0.2025
r57 3 14 1e-05 $l=2e-09 $X=0.054 $Y=0.0675 $X2=0.056 $Y2=0.0675
.ends

.subckt PM_AND3x2_ASAP7_75t_R%9 vss 2 3 1
c1 1 vss 0.000772052f $X=0.162 $Y=0.0675
r1 2 1 0.209877 $w=8.1e-08 $l=1.7e-08 $layer=N_src_drn $thickness=1e-09
+ $X=0.1446 $Y=0.0675 $X2=0.162 $Y2=0.0675
r2 3 1 0.209877 $w=8.1e-08 $l=1.7e-08 $layer=N_src_drn $thickness=1e-09
+ $X=0.1793 $Y=0.0675 $X2=0.162 $Y2=0.0675
.ends

.subckt PM_AND3x2_ASAP7_75t_R%A vss 15 5 11 3 4 1
c1 1 vss 0.00277113f $X=0.081 $Y=0.135
c2 3 vss 0.051986f $X=0.081 $Y=0.0245
c3 4 vss 0.00915634f $X=0.081 $Y=0.098
r1 15 4 8.62802 $w=1.3e-08 $l=3.7e-08 $layer=M1 $thickness=3.6e-08 $X=0.08
+ $Y=0.137 $X2=0.081 $Y2=0.098
r2 1 8 6.74717 $w=2e-08 $layer=Gate_1 $thickness=5.2e-08 $X=0.081 $Y=0.135
+ $X2=0.081 $Y2=0.135
r3 15 1 19.3796 $a=3.24e-16 $layer=V0LIG $X=0.08 $Y=0.137 $X2=0.081 $Y2=0.135
r4 11 10 14.6259 $w=2.1e-08 $l=4.3e-08 $layer=Gate_1 $thickness=5.6e-08
+ $X=0.081 $Y=0.2025 $X2=0.081 $Y2=0.1595
r5 9 10 2.89117 $w=2.1e-08 $l=8.5e-09 $layer=Gate_1 $thickness=5.6e-08 $X=0.081
+ $Y=0.151 $X2=0.081 $Y2=0.1595
r6 8 9 5.61228 $w=2.0375e-08 $l=1.6e-08 $layer=Gate_1 $thickness=5.6e-08
+ $X=0.081 $Y=0.135 $X2=0.081 $Y2=0.151
r7 7 8 5.61228 $w=2.0375e-08 $l=1.6e-08 $layer=Gate_1 $thickness=5.6e-08
+ $X=0.081 $Y=0.119 $X2=0.081 $Y2=0.135
r8 6 7 2.89117 $w=2.1e-08 $l=8.5e-09 $layer=Gate_1 $thickness=5.6e-08 $X=0.081
+ $Y=0.1105 $X2=0.081 $Y2=0.119
r9 5 6 14.6259 $w=2.1e-08 $l=4.3e-08 $layer=Gate_1 $thickness=5.6e-08 $X=0.081
+ $Y=0.0675 $X2=0.081 $Y2=0.1105
r10 5 3 14.6259 $w=2.1e-08 $l=4.3e-08 $layer=Gate_1 $thickness=5.6e-08 $X=0.081
+ $Y=0.0675 $X2=0.081 $Y2=0.0245
.ends

* End of included file AND3x2_ASAP7_75t_R.pex.sp.pex

*
.subckt AND3x2_ASAP7_75t_CUSTOM_4_25_0_7 VSS VDD A B C Y
*
* VSS VSS
* VDD VDD
* A A
* B B
* C C
* Y Y
*
*

M0 N_M0_d N_M0_g N_M0_s VSS nmos_rvt L=2e-08 W=8.1e-08 nfin=3 $X=0.071 $Y=0.027
M1 N_M1_d N_M1_g N_M1_s VSS nmos_rvt L=2e-08 W=8.1e-08 nfin=3 $X=0.125 $Y=0.027
M2 VSS N_M2_g N_M2_s VSS nmos_rvt L=2e-08 W=8.1e-08 nfin=3 $X=0.179 $Y=0.027
M3 N_M3_d N_M3_g VSS VSS nmos_rvt L=2e-08 W=8.1e-08 nfin=3 $X=0.233 $Y=0.027
M4 N_M4_d N_M4_g VSS VSS nmos_rvt L=2e-08 W=8.1e-08 nfin=3 $X=0.287 $Y=0.027
M5 VDD N_M5_g N_M5_s VDD pmos_rvt L=2e-08 W=8.1e-08 nfin=3 $X=0.071 $Y=0.162
M6 N_M6_d N_M6_g VDD VDD pmos_rvt L=2e-08 W=8.1e-08 nfin=3 $X=0.125 $Y=0.162
M7 VDD N_M7_g N_M7_s VDD pmos_rvt L=2e-08 W=8.1e-08 nfin=3 $X=0.179 $Y=0.162
M8 N_M8_d N_M8_g VDD VDD pmos_rvt L=2e-08 W=8.1e-08 nfin=3 $X=0.233 $Y=0.162
M9 N_M9_d N_M9_g VDD VDD pmos_rvt L=2e-08 W=8.1e-08 nfin=3 $X=0.287 $Y=0.162

* .include "AND3x2_ASAP7_75t_R.pex.sp.pxi"

* Start of included file AND3x2_ASAP7_75t_R.pex.sp.pxi
x_PM_AND3x2_ASAP7_75t_R%8 vss N_M0_d N_M1_s N_8_1 PM_AND3x2_ASAP7_75t_R%8
cc_1 N_8_1 N_A_3 0.0166913f $X=0.108 $Y=0.0675
cc_2 N_8_1 N_B_3 0.0167616f $X=0.108 $Y=0.0675
x_PM_AND3x2_ASAP7_75t_R%B vss B N_M1_g N_M6_g N_B_1 N_B_4 N_B_3
+ PM_AND3x2_ASAP7_75t_R%B
cc_3 N_B_1 N_A_3 0.00120117f $X=0.135 $Y=0.135
cc_4 N_B_4 N_A_4 0.00473386f $X=0.135 $Y=0.098
cc_5 N_B_3 N_A_3 0.00594995f $X=0.135 $Y=0.0245
x_PM_AND3x2_ASAP7_75t_R%C vss C N_M2_g N_M7_g N_C_3 N_C_4 N_C_1
+ PM_AND3x2_ASAP7_75t_R%C
cc_6 N_C_3 N_B_1 0.00118112f $X=0.189 $Y=0.0245
cc_7 N_C_4 N_B_4 0.00458452f $X=0.189 $Y=0.098
cc_8 N_C_3 N_B_3 0.00579562f $X=0.189 $Y=0.0245
x_PM_AND3x2_ASAP7_75t_R%Y vss Y N_M3_d N_M4_d N_M8_d N_M9_d N_Y_7 N_Y_1 N_Y_2
+ N_Y_14 N_Y_13 N_Y_8 PM_AND3x2_ASAP7_75t_R%Y
cc_9 N_Y_7 N_6_22 0.000619056f $X=0.2555 $Y=0.0675
cc_10 N_Y_7 N_6_23 0.000619056f $X=0.2555 $Y=0.0675
cc_11 N_Y_7 N_6_12 0.0386109f $X=0.2555 $Y=0.0675
cc_12 N_Y_7 N_6_24 0.0023903f $X=0.2555 $Y=0.0675
cc_13 N_Y_7 N_6_1 0.00108206f $X=0.2555 $Y=0.0675
cc_14 N_Y_7 N_6_19 0.00109204f $X=0.2555 $Y=0.0675
cc_15 N_Y_7 N_6_17 0.00109228f $X=0.2555 $Y=0.0675
cc_16 N_Y_1 N_6_13 0.00187646f $X=0.27 $Y=0.0675
cc_17 N_Y_2 N_6_13 0.00187744f $X=0.27 $Y=0.2025
cc_18 N_Y_14 N_6_23 0.00306473f $X=0.27 $Y=0.1865
cc_19 N_Y_13 N_6_22 0.00306631f $X=0.27 $Y=0.054
cc_20 N_Y_8 N_6_1 0.00442669f $X=0.2555 $Y=0.2025
cc_21 N_Y_8 N_6_13 0.0103435f $X=0.2555 $Y=0.2025
cc_22 N_Y_8 N_6_12 0.0184989f $X=0.2555 $Y=0.2025
cc_23 N_Y_7 N_6_13 0.0665842f $X=0.2555 $Y=0.0675
x_PM_AND3x2_ASAP7_75t_R%6 vss N_M3_g N_M8_g N_M4_g N_M9_g N_M0_s N_M6_d N_M7_s
+ N_M5_s N_6_14 N_6_3 N_6_21 N_6_20 N_6_4 N_6_15 N_6_5 N_6_16 N_6_1 N_6_18
+ N_6_12 N_6_23 N_6_22 N_6_24 N_6_19 N_6_17 N_6_13 PM_AND3x2_ASAP7_75t_R%6
cc_24 N_6_14 N_A_3 0.0154542f $X=0.056 $Y=0.0675
cc_25 N_6_3 N_A_3 0.0025519f $X=0.054 $Y=0.0675
cc_26 N_6_21 N_A_4 0.00120282f $X=0.207 $Y=0.234
cc_27 N_6_20 N_A_4 0.00131316f $X=0.207 $Y=0.036
cc_28 N_6_4 N_A_3 0.00139407f $X=0.054 $Y=0.2025
cc_29 N_6_14 N_A_1 0.00162537f $X=0.056 $Y=0.0675
cc_30 N_6_4 N_A_4 0.00416789f $X=0.054 $Y=0.2025
cc_31 N_6_15 N_A_3 0.0547052f $X=0.056 $Y=0.2025
cc_32 N_6_5 N_B_1 0.000457387f $X=0.162 $Y=0.2025
cc_33 N_6_16 N_B_1 0.000766056f $X=0.1475 $Y=0.2025
cc_34 N_6_5 N_B_3 0.00108643f $X=0.162 $Y=0.2025
cc_35 N_6_21 N_B_4 0.0011024f $X=0.207 $Y=0.234
cc_36 N_6_20 N_B_4 0.00143929f $X=0.207 $Y=0.036
cc_37 N_6_5 N_B_4 0.00320958f $X=0.162 $Y=0.2025
cc_38 N_6_16 N_B_3 0.0354414f $X=0.1475 $Y=0.2025
cc_39 N_6_1 N_C_3 0.000761256f $X=0.243 $Y=0.135
cc_40 N_6_21 N_C_3 0.000839495f $X=0.207 $Y=0.234
cc_41 N_6_18 N_C_1 0.000989671f $X=0.225 $Y=0.135
cc_42 N_6_20 N_C_4 0.000994663f $X=0.207 $Y=0.036
cc_43 N_6_5 N_C_3 0.00107784f $X=0.162 $Y=0.2025
cc_44 N_6_16 N_C_1 0.00124448f $X=0.1475 $Y=0.2025
cc_45 N_6_12 N_C_3 0.00163535f $X=0.243 $Y=0.0245
cc_46 N_6_23 N_C_4 0.00212925f $X=0.225 $Y=0.164
cc_47 N_6_22 N_C_4 0.00214007f $X=0.225 $Y=0.106
cc_48 N_6_18 N_C_4 0.00780159f $X=0.225 $Y=0.135
cc_49 N_6_16 N_C_3 0.0363709f $X=0.1475 $Y=0.2025
x_PM_AND3x2_ASAP7_75t_R%9 vss N_M1_d N_M2_s N_9_1 PM_AND3x2_ASAP7_75t_R%9
cc_50 N_9_1 N_B_3 0.0168345f $X=0.162 $Y=0.0675
cc_51 N_9_1 N_C_3 0.0167109f $X=0.162 $Y=0.0675
x_PM_AND3x2_ASAP7_75t_R%A vss A N_M0_g N_M5_g N_A_3 N_A_4 N_A_1
+ PM_AND3x2_ASAP7_75t_R%A

* End of included file AND3x2_ASAP7_75t_R.pex.sp.pxi
.ends

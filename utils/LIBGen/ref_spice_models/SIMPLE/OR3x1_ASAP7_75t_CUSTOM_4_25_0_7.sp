.subckt PM_OR3x1_ASAP7_75t_R%8 vss 2 3 1
c1 1 vss 0.000704422f $X=0.108 $Y=0.2025
r1 2 1 0.209877 $w=8.1e-08 $l=1.7e-08 $layer=P_src_drn $thickness=1e-09
+ $X=0.0906 $Y=0.2025 $X2=0.108 $Y2=0.2025
r2 3 1 0.209877 $w=8.1e-08 $l=1.7e-08 $layer=P_src_drn $thickness=1e-09
+ $X=0.1253 $Y=0.2025 $X2=0.108 $Y2=0.2025
.ends

.subckt PM_OR3x1_ASAP7_75t_R%9 vss 2 3 1
c1 1 vss 0.000764644f $X=0.162 $Y=0.2025
r1 2 1 0.209877 $w=8.1e-08 $l=1.7e-08 $layer=P_src_drn $thickness=1e-09
+ $X=0.1446 $Y=0.2025 $X2=0.162 $Y2=0.2025
r2 3 1 0.209877 $w=8.1e-08 $l=1.7e-08 $layer=P_src_drn $thickness=1e-09
+ $X=0.1793 $Y=0.2025 $X2=0.162 $Y2=0.2025
.ends

.subckt PM_OR3x1_ASAP7_75t_R%A vss 13 5 11 3 4 1
c1 1 vss 0.00274766f $X=0.081 $Y=0.1355
c2 3 vss 0.0518874f $X=0.081 $Y=0.0245
c3 4 vss 0.00900845f $X=0.081 $Y=0.098
r1 13 4 8.62802 $w=1.3e-08 $l=3.7e-08 $layer=M1 $thickness=3.6e-08 $X=0.081
+ $Y=0.134 $X2=0.081 $Y2=0.098
r2 1 8 10.9005 $w=1.765e-08 $layer=LIG $thickness=5.2e-08 $X=0.081 $Y=0.1355
+ $X2=0.081 $Y2=0.1355
r3 13 1 19.3796 $a=3.24e-16 $layer=V0LIG $X=0.081 $Y=0.134 $X2=0.081 $Y2=0.1355
r4 11 10 14.6259 $w=2.1e-08 $l=4.3e-08 $layer=Gate_1 $thickness=5.6e-08
+ $X=0.081 $Y=0.2025 $X2=0.081 $Y2=0.1595
r5 9 10 2.55104 $w=2.1e-08 $l=7.5e-09 $layer=Gate_1 $thickness=5.6e-08 $X=0.081
+ $Y=0.152 $X2=0.081 $Y2=0.1595
r6 8 9 5.80786 $w=2.0303e-08 $l=1.65e-08 $layer=Gate_1 $thickness=5.6e-08
+ $X=0.081 $Y=0.1355 $X2=0.081 $Y2=0.152
r7 7 8 5.97793 $w=2.03235e-08 $l=1.7e-08 $layer=Gate_1 $thickness=5.6e-08
+ $X=0.081 $Y=0.1185 $X2=0.081 $Y2=0.1355
r8 6 7 2.7211 $w=2.1e-08 $l=8e-09 $layer=Gate_1 $thickness=5.6e-08 $X=0.081
+ $Y=0.1105 $X2=0.081 $Y2=0.1185
r9 5 6 14.6259 $w=2.1e-08 $l=4.3e-08 $layer=Gate_1 $thickness=5.6e-08 $X=0.081
+ $Y=0.0675 $X2=0.081 $Y2=0.1105
r10 5 3 14.6259 $w=2.1e-08 $l=4.3e-08 $layer=Gate_1 $thickness=5.6e-08 $X=0.081
+ $Y=0.0675 $X2=0.081 $Y2=0.0245
.ends

.subckt PM_OR3x1_ASAP7_75t_R%B vss 11 5 9 1 4 3
c1 1 vss 0.00284177f $X=0.135 $Y=0.1355
c2 3 vss 0.0460099f $X=0.135 $Y=0.0245
c3 4 vss 0.00991203f $X=0.135 $Y=0.098
r1 11 4 8.62802 $w=1.3e-08 $l=3.7e-08 $layer=M1 $thickness=3.6e-08 $X=0.136
+ $Y=0.134 $X2=0.135 $Y2=0.098
r2 1 7 10.9005 $w=1.765e-08 $layer=LIG $thickness=5.2e-08 $X=0.135 $Y=0.1355
+ $X2=0.135 $Y2=0.1355
r3 11 1 19.3796 $a=3.24e-16 $layer=V0LIG $X=0.136 $Y=0.134 $X2=0.135 $Y2=0.1355
r4 9 8 16.3266 $w=2.1e-08 $l=4.8e-08 $layer=Gate_1 $thickness=5.6e-08 $X=0.135
+ $Y=0.2025 $X2=0.135 $Y2=0.1545
r5 7 8 6.6582 $w=2.03947e-08 $l=1.9e-08 $layer=Gate_1 $thickness=5.6e-08
+ $X=0.135 $Y=0.1355 $X2=0.135 $Y2=0.1545
r6 6 7 6.82827 $w=2.04103e-08 $l=1.95e-08 $layer=Gate_1 $thickness=5.6e-08
+ $X=0.135 $Y=0.116 $X2=0.135 $Y2=0.1355
r7 5 6 16.4967 $w=2.1e-08 $l=4.85e-08 $layer=Gate_1 $thickness=5.6e-08 $X=0.135
+ $Y=0.0675 $X2=0.135 $Y2=0.116
r8 5 3 14.6259 $w=2.1e-08 $l=4.3e-08 $layer=Gate_1 $thickness=5.6e-08 $X=0.135
+ $Y=0.0675 $X2=0.135 $Y2=0.0245
.ends

.subckt PM_OR3x1_ASAP7_75t_R%6 vss 23 29 66 67 69 71 3 19 20 4 15 13 14 5 17 12
+ 21 22 18 16 1
c1 1 vss 0.00372324f $X=0.236 $Y=0.135
c2 3 vss 0.00942294f $X=0.054 $Y=0.0675
c3 4 vss 0.00738214f $X=0.054 $Y=0.2025
c4 5 vss 0.00863718f $X=0.162 $Y=0.0675
c5 12 vss 0.0819447f $X=0.243 $Y=0.0245
c6 13 vss 0.0390614f $X=0.056 $Y=0.0675
c7 14 vss 0.00540868f $X=0.1475 $Y=0.0675
c8 15 vss 0.0383155f $X=0.056 $Y=0.2025
c9 16 vss 0.00286968f $X=0.225 $Y=0.0395
c10 17 vss 0.000474396f $X=0.225 $Y=0.135
c11 18 vss 0.00289295f $X=0.225 $Y=0.23
c12 19 vss 0.0164215f $X=0.207 $Y=0.036
c13 20 vss 0.0167089f $X=0.207 $Y=0.234
c14 21 vss 0.00228627f $X=0.225 $Y=0.11
c15 22 vss 0.0022863f $X=0.225 $Y=0.1635
r1 71 70 0.0308642 $w=8.1e-08 $l=2.5e-09 $layer=P_src_drn $thickness=1e-09
+ $X=0.0713 $Y=0.2025 $X2=0.0685 $Y2=0.2025
r2 15 70 0.154321 $w=8.1e-08 $l=1.25e-08 $layer=P_src_drn $thickness=1e-09
+ $X=0.056 $Y=0.2025 $X2=0.0685 $Y2=0.2025
r3 69 68 0.0308642 $w=8.1e-08 $l=2.5e-09 $layer=N_src_drn $thickness=1e-09
+ $X=0.0713 $Y=0.0675 $X2=0.0685 $Y2=0.0675
r4 13 68 0.154321 $w=8.1e-08 $l=1.25e-08 $layer=N_src_drn $thickness=1e-09
+ $X=0.056 $Y=0.0675 $X2=0.0685 $Y2=0.0675
r5 67 65 0.0308642 $w=8.1e-08 $l=2.5e-09 $layer=N_src_drn $thickness=1e-09
+ $X=0.1793 $Y=0.0675 $X2=0.1765 $Y2=0.0675
r6 5 65 0.179012 $w=8.1e-08 $l=1.45e-08 $layer=N_src_drn $thickness=1e-09
+ $X=0.162 $Y=0.0675 $X2=0.1765 $Y2=0.0675
r7 14 5 0.179012 $w=8.1e-08 $l=1.45e-08 $layer=N_src_drn $thickness=1e-09
+ $X=0.1475 $Y=0.0675 $X2=0.162 $Y2=0.0675
r8 66 14 0.0308642 $w=8.1e-08 $l=2.5e-09 $layer=N_src_drn $thickness=1e-09
+ $X=0.1446 $Y=0.0675 $X2=0.1475 $Y2=0.0675
r9 4 62 19.3796 $a=3.24e-16 $layer=V0LISD $X=0.054 $Y=0.2025 $X2=0.054 $Y2=0.234
r10 3 54 19.3796 $a=3.24e-16 $layer=V0LISD $X=0.054 $Y=0.0675 $X2=0.054
+ $Y2=0.036
r11 5 48 19.3796 $a=3.24e-16 $layer=V0LISD $X=0.162 $Y=0.0675 $X2=0.162
+ $Y2=0.036
r12 62 63 3.14806 $w=1.3e-08 $l=1.35e-08 $layer=M1 $thickness=3.6e-08 $X=0.054
+ $Y=0.234 $X2=0.0675 $Y2=0.234
r13 60 63 3.14806 $w=1.3e-08 $l=1.35e-08 $layer=M1 $thickness=3.6e-08 $X=0.081
+ $Y=0.234 $X2=0.0675 $Y2=0.234
r14 59 60 6.29612 $w=1.3e-08 $l=2.7e-08 $layer=M1 $thickness=3.6e-08 $X=0.108
+ $Y=0.234 $X2=0.081 $Y2=0.234
r15 58 59 6.29612 $w=1.3e-08 $l=2.7e-08 $layer=M1 $thickness=3.6e-08 $X=0.135
+ $Y=0.234 $X2=0.108 $Y2=0.234
r16 57 58 6.29612 $w=1.3e-08 $l=2.7e-08 $layer=M1 $thickness=3.6e-08 $X=0.162
+ $Y=0.234 $X2=0.135 $Y2=0.234
r17 56 57 6.29612 $w=1.3e-08 $l=2.7e-08 $layer=M1 $thickness=3.6e-08 $X=0.189
+ $Y=0.234 $X2=0.162 $Y2=0.234
r18 20 56 4.19742 $w=1.3e-08 $l=1.8e-08 $layer=M1 $thickness=3.6e-08 $X=0.207
+ $Y=0.234 $X2=0.189 $Y2=0.234
r19 54 55 3.14806 $w=1.3e-08 $l=1.35e-08 $layer=M1 $thickness=3.6e-08 $X=0.054
+ $Y=0.036 $X2=0.0675 $Y2=0.036
r20 52 55 3.14806 $w=1.3e-08 $l=1.35e-08 $layer=M1 $thickness=3.6e-08 $X=0.081
+ $Y=0.036 $X2=0.0675 $Y2=0.036
r21 51 52 6.29612 $w=1.3e-08 $l=2.7e-08 $layer=M1 $thickness=3.6e-08 $X=0.108
+ $Y=0.036 $X2=0.081 $Y2=0.036
r22 50 51 6.29612 $w=1.3e-08 $l=2.7e-08 $layer=M1 $thickness=3.6e-08 $X=0.135
+ $Y=0.036 $X2=0.108 $Y2=0.036
r23 48 49 3.14806 $w=1.3e-08 $l=1.35e-08 $layer=M1 $thickness=3.6e-08 $X=0.162
+ $Y=0.036 $X2=0.1755 $Y2=0.036
r24 47 48 3.14806 $w=1.3e-08 $l=1.35e-08 $layer=M1 $thickness=3.6e-08 $X=0.1485
+ $Y=0.036 $X2=0.162 $Y2=0.036
r25 47 50 3.14806 $w=1.3e-08 $l=1.35e-08 $layer=M1 $thickness=3.6e-08 $X=0.1485
+ $Y=0.036 $X2=0.135 $Y2=0.036
r26 46 49 3.14806 $w=1.3e-08 $l=1.35e-08 $layer=M1 $thickness=3.6e-08 $X=0.189
+ $Y=0.036 $X2=0.1755 $Y2=0.036
r27 19 46 4.19742 $w=1.3e-08 $l=1.8e-08 $layer=M1 $thickness=3.6e-08 $X=0.207
+ $Y=0.036 $X2=0.189 $Y2=0.036
r28 18 43 3.42509 $w=1.44286e-08 $l=1.75e-08 $layer=M1 $thickness=3.6e-08
+ $X=0.225 $Y=0.23 $X2=0.225 $Y2=0.2125
r29 18 20 2.60893 $w=1.47857e-08 $l=1.84391e-08 $layer=M1 $thickness=3.6e-08
+ $X=0.225 $Y=0.23 $X2=0.207 $Y2=0.234
r30 16 41 3.47612 $w=1.45278e-08 $l=1.8e-08 $layer=M1 $thickness=3.6e-08
+ $X=0.225 $Y=0.0395 $X2=0.225 $Y2=0.0575
r31 16 19 2.65995 $w=1.48966e-08 $l=1.83371e-08 $layer=M1 $thickness=3.6e-08
+ $X=0.225 $Y=0.0395 $X2=0.207 $Y2=0.036
r32 42 43 4.89699 $w=1.3e-08 $l=2.1e-08 $layer=M1 $thickness=3.6e-08 $X=0.225
+ $Y=0.1915 $X2=0.225 $Y2=0.2125
r33 22 42 6.52931 $w=1.3e-08 $l=2.8e-08 $layer=M1 $thickness=3.6e-08 $X=0.225
+ $Y=0.1635 $X2=0.225 $Y2=0.1915
r34 40 41 3.61444 $w=1.3e-08 $l=1.55e-08 $layer=M1 $thickness=3.6e-08 $X=0.225
+ $Y=0.073 $X2=0.225 $Y2=0.0575
r35 39 40 2.79828 $w=1.3e-08 $l=1.2e-08 $layer=M1 $thickness=3.6e-08 $X=0.225
+ $Y=0.085 $X2=0.225 $Y2=0.073
r36 21 39 5.82974 $w=1.3e-08 $l=2.5e-08 $layer=M1 $thickness=3.6e-08 $X=0.225
+ $Y=0.11 $X2=0.225 $Y2=0.085
r37 35 36 2.68168 $w=1.3e-08 $l=1.15e-08 $layer=M1 $thickness=3.6e-08 $X=0.2365
+ $Y=0.135 $X2=0.248 $Y2=0.135
r38 17 35 1.50137 $w=1.6913e-08 $l=1.15e-08 $layer=M1 $thickness=3.6e-08
+ $X=0.225 $Y=0.135 $X2=0.2365 $Y2=0.135
r39 17 21 4.64944 $w=1.48e-08 $l=2.5e-08 $layer=M1 $thickness=3.6e-08 $X=0.225
+ $Y=0.135 $X2=0.225 $Y2=0.11
r40 17 22 5.4656 $w=1.45789e-08 $l=2.85e-08 $layer=M1 $thickness=3.6e-08
+ $X=0.225 $Y=0.135 $X2=0.225 $Y2=0.1635
r41 31 36 19.3796 $a=3.24e-16 $layer=V0LIG $X=0.246 $Y=0.135 $X2=0.248 $Y2=0.135
r42 1 31 2.6116 $w=2.2e-08 $l=1e-08 $layer=LIG $thickness=4.8e-08 $X=0.236
+ $Y=0.135 $X2=0.246 $Y2=0.135
r43 29 28 14.6259 $w=2.1e-08 $l=4.3e-08 $layer=Gate_1 $thickness=5.6e-08
+ $X=0.243 $Y=0.2025 $X2=0.243 $Y2=0.1595
r44 27 28 2.7211 $w=2.1e-08 $l=8e-09 $layer=Gate_1 $thickness=5.6e-08 $X=0.243
+ $Y=0.1515 $X2=0.243 $Y2=0.1595
r45 26 27 5.79936 $w=2.03333e-08 $l=1.65e-08 $layer=Gate_1 $thickness=5.6e-08
+ $X=0.243 $Y=0.135 $X2=0.243 $Y2=0.1515
r46 26 31 5.75672 $w=2.07778e-08 $l=3e-09 $layer=Gate_1 $thickness=5.28889e-08
+ $X=0.243 $Y=0.135 $X2=0.246 $Y2=0.135
r47 25 26 5.79936 $w=2.03333e-08 $l=1.65e-08 $layer=Gate_1 $thickness=5.6e-08
+ $X=0.243 $Y=0.1185 $X2=0.243 $Y2=0.135
r48 24 25 2.7211 $w=2.1e-08 $l=8e-09 $layer=Gate_1 $thickness=5.6e-08 $X=0.243
+ $Y=0.1105 $X2=0.243 $Y2=0.1185
r49 23 24 14.6259 $w=2.1e-08 $l=4.3e-08 $layer=Gate_1 $thickness=5.6e-08
+ $X=0.243 $Y=0.0675 $X2=0.243 $Y2=0.1105
r50 23 12 14.6259 $w=2.1e-08 $l=4.3e-08 $layer=Gate_1 $thickness=5.6e-08
+ $X=0.243 $Y=0.0675 $X2=0.243 $Y2=0.0245
r51 4 15 1e-05 $l=2e-09 $X=0.054 $Y=0.2025 $X2=0.056 $Y2=0.2025
r52 3 13 1e-05 $l=2e-09 $X=0.054 $Y=0.0675 $X2=0.056 $Y2=0.0675
.ends

.subckt PM_OR3x1_ASAP7_75t_R%Y vss 23 15 30 7 9 13 10 8
c1 1 vss 0.00741454f $X=0.27 $Y=0.0675
c2 2 vss 0.00776128f $X=0.27 $Y=0.2025
c3 7 vss 0.038345f $X=0.2555 $Y=0.0675
c4 8 vss 0.03835f $X=0.2555 $Y=0.2025
c5 9 vss 0.00191425f $X=0.2615 $Y=0.085
c6 10 vss 0.00298306f $X=0.27 $Y=0.192
c7 11 vss 0.00127938f $X=0.297 $Y=0.192
c8 12 vss 0.00289137f $X=0.27 $Y=0.0425
c9 13 vss 0.00238495f $X=0.297 $Y=0.11
r1 8 2 0.154321 $w=8.1e-08 $l=1.25e-08 $layer=P_src_drn $thickness=1e-09
+ $X=0.2555 $Y=0.2025 $X2=0.27 $Y2=0.2025
r2 30 8 0.0308642 $w=8.1e-08 $l=2.5e-09 $layer=P_src_drn $thickness=1e-09
+ $X=0.2526 $Y=0.2025 $X2=0.2555 $Y2=0.2025
r3 2 27 19.3796 $a=3.24e-16 $layer=V0LISD $X=0.27 $Y=0.2025 $X2=0.27 $Y2=0.217
r4 26 27 2.91487 $w=1.3e-08 $l=1.25e-08 $layer=M1 $thickness=3.6e-08 $X=0.27
+ $Y=0.2045 $X2=0.27 $Y2=0.217
r5 10 25 1.96775 $w=1.63333e-08 $l=1.35e-08 $layer=M1 $thickness=3.6e-08
+ $X=0.27 $Y=0.192 $X2=0.2835 $Y2=0.192
r6 10 26 1.73456 $w=1.66e-08 $l=1.25e-08 $layer=M1 $thickness=3.6e-08 $X=0.27
+ $Y=0.192 $X2=0.27 $Y2=0.2045
r7 11 24 4.99922 $w=1.46981e-08 $l=2.65e-08 $layer=M1 $thickness=3.6e-08
+ $X=0.297 $Y=0.192 $X2=0.297 $Y2=0.1655
r8 11 25 1.96775 $w=1.63333e-08 $l=1.35e-08 $layer=M1 $thickness=3.6e-08
+ $X=0.297 $Y=0.192 $X2=0.2835 $Y2=0.192
r9 23 24 4.19742 $w=1.3e-08 $l=1.8e-08 $layer=M1 $thickness=3.6e-08 $X=0.297
+ $Y=0.1475 $X2=0.297 $Y2=0.1655
r10 23 22 0.46638 $w=1.3e-08 $l=2e-09 $layer=M1 $thickness=3.6e-08 $X=0.297
+ $Y=0.1475 $X2=0.297 $Y2=0.1455
r11 21 22 2.44849 $w=1.3e-08 $l=1.05e-08 $layer=M1 $thickness=3.6e-08 $X=0.297
+ $Y=0.135 $X2=0.297 $Y2=0.1455
r12 13 20 4.64944 $w=1.48e-08 $l=2.5e-08 $layer=M1 $thickness=3.6e-08 $X=0.297
+ $Y=0.11 $X2=0.297 $Y2=0.085
r13 13 21 5.82974 $w=1.3e-08 $l=2.5e-08 $layer=M1 $thickness=3.6e-08 $X=0.297
+ $Y=0.11 $X2=0.297 $Y2=0.135
r14 19 20 1.96775 $w=1.63333e-08 $l=1.35e-08 $layer=M1 $thickness=3.6e-08
+ $X=0.2835 $Y=0.085 $X2=0.297 $Y2=0.085
r15 18 19 1.91673 $w=1.62692e-08 $l=1.3e-08 $layer=M1 $thickness=3.6e-08
+ $X=0.2705 $Y=0.085 $X2=0.2835 $Y2=0.085
r16 9 17 0.867186 $w=1.3625e-08 $l=1.51162e-08 $layer=M1 $thickness=3.6e-08
+ $X=0.2615 $Y=0.085 $X2=0.27 $Y2=0.0725
r17 9 18 0.9184 $w=1.8e-08 $l=9e-09 $layer=M1 $thickness=3.6e-08 $X=0.2615
+ $Y=0.085 $X2=0.2705 $Y2=0.085
r18 16 17 2.91487 $w=1.3e-08 $l=1.25e-08 $layer=M1 $thickness=3.6e-08 $X=0.27
+ $Y=0.06 $X2=0.27 $Y2=0.0725
r19 12 16 4.08082 $w=1.3e-08 $l=1.75e-08 $layer=M1 $thickness=3.6e-08 $X=0.27
+ $Y=0.0425 $X2=0.27 $Y2=0.06
r20 1 16 19.3796 $a=3.24e-16 $layer=V0LISD $X=0.27 $Y=0.0675 $X2=0.27 $Y2=0.06
r21 7 1 0.154321 $w=8.1e-08 $l=1.25e-08 $layer=N_src_drn $thickness=1e-09
+ $X=0.2555 $Y=0.0675 $X2=0.27 $Y2=0.0675
r22 15 7 0.0308642 $w=8.1e-08 $l=2.5e-09 $layer=N_src_drn $thickness=1e-09
+ $X=0.2526 $Y=0.0675 $X2=0.2555 $Y2=0.0675
.ends

.subckt PM_OR3x1_ASAP7_75t_R%C vss 4 5 9 3 1
c1 1 vss 0.00759262f $X=0.189 $Y=0.135
c2 3 vss 0.0840243f $X=0.189 $Y=0.0245
c3 4 vss 0.00493702f $X=0.187 $Y=0.134
r1 1 7 10.6051 $w=1.77022e-08 $l=5e-10 $layer=LIG $thickness=5.20889e-08
+ $X=0.189 $Y=0.135 $X2=0.189 $Y2=0.1355
r2 4 1 19.3796 $a=3.24e-16 $layer=V0LIG $X=0.187 $Y=0.134 $X2=0.189 $Y2=0.135
r3 9 8 16.3266 $w=2.1e-08 $l=4.8e-08 $layer=Gate_1 $thickness=5.6e-08 $X=0.189
+ $Y=0.2025 $X2=0.189 $Y2=0.1545
r4 7 8 6.6582 $w=2.03947e-08 $l=1.9e-08 $layer=Gate_1 $thickness=5.6e-08
+ $X=0.189 $Y=0.1355 $X2=0.189 $Y2=0.1545
r5 6 7 6.82827 $w=2.04103e-08 $l=1.95e-08 $layer=Gate_1 $thickness=5.6e-08
+ $X=0.189 $Y=0.116 $X2=0.189 $Y2=0.1355
r6 5 6 16.4967 $w=2.1e-08 $l=4.85e-08 $layer=Gate_1 $thickness=5.6e-08 $X=0.189
+ $Y=0.0675 $X2=0.189 $Y2=0.116
r7 5 3 14.6259 $w=2.1e-08 $l=4.3e-08 $layer=Gate_1 $thickness=5.6e-08 $X=0.189
+ $Y=0.0675 $X2=0.189 $Y2=0.0245
.ends

* End of included file OR3x1_ASAP7_75t_R.pex.sp.pex

*
.subckt OR3x1_ASAP7_75t_CUSTOM_4_25_0_7 VSS VDD A B C Y
*
* VSS VSS
* VDD VDD
* A A
* B B
* C C
* Y Y
*
*

M0 VSS N_M0_g N_M0_s VSS nmos_rvt L=2e-08 W=8.1e-08 nfin=3 $X=0.071 $Y=0.027
M1 N_M1_d N_M1_g VSS VSS nmos_rvt L=2e-08 W=8.1e-08 nfin=3 $X=0.125 $Y=0.027
M2 VSS N_M2_g N_M2_s VSS nmos_rvt L=2e-08 W=8.1e-08 nfin=3 $X=0.179 $Y=0.027
M3 N_M3_d N_M3_g VSS VSS nmos_rvt L=2e-08 W=8.1e-08 nfin=3 $X=0.233 $Y=0.027
M4 N_M4_d N_M4_g N_M4_s VDD pmos_rvt L=2e-08 W=8.1e-08 nfin=3 $X=0.071 $Y=0.162
M5 N_M5_d N_M5_g N_M5_s VDD pmos_rvt L=2e-08 W=8.1e-08 nfin=3 $X=0.125 $Y=0.162
M6 VDD N_M6_g N_M6_s VDD pmos_rvt L=2e-08 W=8.1e-08 nfin=3 $X=0.179 $Y=0.162
M7 N_M7_d N_M7_g VDD VDD pmos_rvt L=2e-08 W=8.1e-08 nfin=3 $X=0.233 $Y=0.162

* .include "OR3x1_ASAP7_75t_R.pex.sp.pxi"

* Start of included file OR3x1_ASAP7_75t_R.pex.sp.pxi
x_PM_OR3x1_ASAP7_75t_R%8 vss N_M4_d N_M5_s N_8_1 PM_OR3x1_ASAP7_75t_R%8
cc_1 N_8_1 N_A_3 0.0166982f $X=0.108 $Y=0.2025
cc_2 N_8_1 N_B_3 0.0167604f $X=0.108 $Y=0.2025
x_PM_OR3x1_ASAP7_75t_R%9 vss N_M5_d N_M6_s N_9_1 PM_OR3x1_ASAP7_75t_R%9
cc_3 N_9_1 N_B_3 0.0169205f $X=0.162 $Y=0.2025
cc_4 N_9_1 N_C_3 0.0167869f $X=0.162 $Y=0.2025
x_PM_OR3x1_ASAP7_75t_R%A vss A N_M0_g N_M4_g N_A_3 N_A_4 N_A_1
+ PM_OR3x1_ASAP7_75t_R%A
x_PM_OR3x1_ASAP7_75t_R%B vss B N_M1_g N_M5_g N_B_1 N_B_4 N_B_3
+ PM_OR3x1_ASAP7_75t_R%B
cc_5 N_B_1 N_A_3 0.00127009f $X=0.135 $Y=0.1355
cc_6 N_B_4 N_A_4 0.00473921f $X=0.135 $Y=0.098
cc_7 N_B_3 N_A_3 0.00591244f $X=0.135 $Y=0.0245
x_PM_OR3x1_ASAP7_75t_R%6 vss N_M3_g N_M7_g N_M1_d N_M2_s N_M0_s N_M4_s N_6_3
+ N_6_19 N_6_20 N_6_4 N_6_15 N_6_13 N_6_14 N_6_5 N_6_17 N_6_12 N_6_21 N_6_22
+ N_6_18 N_6_16 N_6_1 PM_OR3x1_ASAP7_75t_R%6
cc_8 N_6_3 N_A_3 0.0021462f $X=0.054 $Y=0.0675
cc_9 N_6_19 N_A_4 0.00120683f $X=0.207 $Y=0.036
cc_10 N_6_20 N_A_4 0.00132107f $X=0.207 $Y=0.234
cc_11 N_6_4 N_A_3 0.00171457f $X=0.054 $Y=0.2025
cc_12 N_6_15 N_A_1 0.00180987f $X=0.056 $Y=0.2025
cc_13 N_6_3 N_A_4 0.00417813f $X=0.054 $Y=0.0675
cc_14 N_6_13 N_A_3 0.0149118f $X=0.056 $Y=0.0675
cc_15 N_6_15 N_A_3 0.0550527f $X=0.056 $Y=0.2025
cc_16 N_6_14 N_B_1 0.000885339f $X=0.1475 $Y=0.0675
cc_17 N_6_5 N_B_3 0.00108635f $X=0.162 $Y=0.0675
cc_18 N_6_19 N_B_4 0.00109315f $X=0.207 $Y=0.036
cc_19 N_6_20 N_B_4 0.00145035f $X=0.207 $Y=0.234
cc_20 N_6_5 N_B_4 0.00318845f $X=0.162 $Y=0.0675
cc_21 N_6_14 N_B_3 0.0361058f $X=0.1475 $Y=0.0675
cc_22 N_6_19 N_C_3 0.000829821f $X=0.207 $Y=0.036
cc_23 N_6_17 N_C_1 0.000876838f $X=0.225 $Y=0.135
cc_24 N_6_20 C 0.00100015f $X=0.207 $Y=0.234
cc_25 N_6_5 N_C_3 0.00107839f $X=0.162 $Y=0.0675
cc_26 N_6_14 N_C_1 0.0014149f $X=0.1475 $Y=0.0675
cc_27 N_6_12 N_C_3 0.00162941f $X=0.243 $Y=0.0245
cc_28 N_6_21 C 0.00211718f $X=0.225 $Y=0.11
cc_29 N_6_22 C 0.00215753f $X=0.225 $Y=0.1635
cc_30 N_6_17 C 0.00763201f $X=0.225 $Y=0.135
cc_31 N_6_14 N_C_3 0.0371385f $X=0.1475 $Y=0.0675
x_PM_OR3x1_ASAP7_75t_R%Y vss Y N_M3_d N_M7_d N_Y_7 N_Y_9 N_Y_13 N_Y_10 N_Y_8
+ PM_OR3x1_ASAP7_75t_R%Y
cc_32 N_Y_7 N_6_21 0.00145734f $X=0.2555 $Y=0.0675
cc_33 N_Y_7 N_6_18 0.000538426f $X=0.2555 $Y=0.0675
cc_34 N_Y_7 N_6_16 0.000547981f $X=0.2555 $Y=0.0675
cc_35 N_Y_7 N_6_1 0.00327204f $X=0.2555 $Y=0.0675
cc_36 N_Y_9 N_6_21 0.00250205f $X=0.2615 $Y=0.085
cc_37 N_Y_13 N_6_17 0.00278915f $X=0.297 $Y=0.11
cc_38 N_Y_10 N_6_22 0.00332256f $X=0.27 $Y=0.192
cc_39 N_Y_8 N_6_12 0.0149247f $X=0.2555 $Y=0.2025
cc_40 N_Y_7 N_6_12 0.0577207f $X=0.2555 $Y=0.0675
x_PM_OR3x1_ASAP7_75t_R%C vss C N_M2_g N_M6_g N_C_3 N_C_1 PM_OR3x1_ASAP7_75t_R%C
cc_41 N_C_3 N_B_1 0.00127525f $X=0.189 $Y=0.0245
cc_42 C N_B_4 0.00454676f $X=0.187 $Y=0.134
cc_43 N_C_3 N_B_3 0.00575361f $X=0.189 $Y=0.0245

* End of included file OR3x1_ASAP7_75t_R.pex.sp.pxi
.ends

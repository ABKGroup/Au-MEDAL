.subckt PM_XOR2x1_ASAP7_75t_R%5 vss 21 25 36 39 55 58 59 11 1 18 4 20 19 16 3
+ 10 9 12 14 15
c1 1 vss 0.00739182f $X=0.3955 $Y=0.135
c2 3 vss 0.00929275f $X=0.108 $Y=0.0675
c3 4 vss 0.01123f $X=0.175 $Y=0.2025
c4 9 vss 0.0811939f $X=0.405 $Y=0.0245
c5 10 vss 0.0810137f $X=0.459 $Y=0.135
c6 11 vss 0.00886921f $X=0.0935 $Y=0.0675
c7 12 vss 0.041932f $X=0.1475 $Y=0.2025
c8 13 vss 0.00296056f $X=0.1835 $Y=0.036
c9 14 vss 0.000466192f $X=0.1835 $Y=0.072
c10 15 vss 0.000442375f $X=0.405 $Y=0.072
c11 16 vss 0.00885332f $X=0.159 $Y=0.036
c12 17 vss 0.000706914f $X=0.1835 $Y=0.054
c13 18 vss 0.00216479f $X=0.183 $Y=0.1035
c14 19 vss 0.00603264f $X=0.3805 $Y=0.072
c15 20 vss 0.00141732f $X=0.405 $Y=0.135
r1 59 57 0.0308642 $w=8.1e-08 $l=2.5e-09 $layer=N_src_drn $thickness=1e-09
+ $X=0.1253 $Y=0.0675 $X2=0.1225 $Y2=0.0675
r2 3 57 0.179012 $w=8.1e-08 $l=1.45e-08 $layer=N_src_drn $thickness=1e-09
+ $X=0.108 $Y=0.0675 $X2=0.1225 $Y2=0.0675
r3 11 3 0.179012 $w=8.1e-08 $l=1.45e-08 $layer=N_src_drn $thickness=1e-09
+ $X=0.0935 $Y=0.0675 $X2=0.108 $Y2=0.0675
r4 58 11 0.0308642 $w=8.1e-08 $l=2.5e-09 $layer=N_src_drn $thickness=1e-09
+ $X=0.0906 $Y=0.0675 $X2=0.0935 $Y2=0.0675
r5 3 50 19.3796 $a=3.24e-16 $layer=V0LISD $X=0.108 $Y=0.0675 $X2=0.112 $Y2=0.036
r6 12 4 0.154321 $w=8.1e-08 $l=1.25e-08 $layer=P_src_drn $thickness=1e-09
+ $X=0.1475 $Y=0.2025 $X2=0.175 $Y2=0.2025
r7 55 12 0.0308642 $w=8.1e-08 $l=2.5e-09 $layer=P_src_drn $thickness=1e-09
+ $X=0.1446 $Y=0.2025 $X2=0.1475 $Y2=0.2025
r8 50 51 4.31401 $w=1.3e-08 $l=1.85e-08 $layer=M1 $thickness=3.6e-08 $X=0.112
+ $Y=0.036 $X2=0.1305 $Y2=0.036
r9 16 51 6.64591 $w=1.3e-08 $l=2.85e-08 $layer=M1 $thickness=3.6e-08 $X=0.159
+ $Y=0.036 $X2=0.1305 $Y2=0.036
r10 4 47 19.3796 $a=3.24e-16 $layer=V0LISD $X=0.175 $Y=0.2025 $X2=0.183
+ $Y2=0.174
r11 13 17 2.23928 $w=1.65e-08 $l=1.8e-08 $layer=M1 $thickness=3.6e-08 $X=0.1835
+ $Y=0.036 $X2=0.1835 $Y2=0.054
r12 13 16 3.94193 $w=1.70327e-08 $l=2.45e-08 $layer=M1 $thickness=3.6e-08
+ $X=0.1835 $Y=0.036 $X2=0.159 $Y2=0.036
r13 46 47 3.96423 $w=1.3e-08 $l=1.7e-08 $layer=M1 $thickness=3.6e-08 $X=0.183
+ $Y=0.157 $X2=0.183 $Y2=0.174
r14 45 46 4.5472 $w=1.3e-08 $l=1.95e-08 $layer=M1 $thickness=3.6e-08 $X=0.183
+ $Y=0.1375 $X2=0.183 $Y2=0.157
r15 18 45 7.92845 $w=1.3e-08 $l=3.4e-08 $layer=M1 $thickness=3.6e-08 $X=0.183
+ $Y=0.1035 $X2=0.183 $Y2=0.1375
r16 14 44 3.27685 $w=1.54359e-08 $l=1.95e-08 $layer=M1 $thickness=3.6e-08
+ $X=0.1835 $Y=0.072 $X2=0.203 $Y2=0.072
r17 14 17 2.64331 $w=1.65e-08 $l=1.8e-08 $layer=M1 $thickness=3.6e-08 $X=0.1835
+ $Y=0.072 $X2=0.1835 $Y2=0.054
r18 14 18 6.19173 $w=1.44844e-08 $l=3.1504e-08 $layer=M1 $thickness=3.6e-08
+ $X=0.1835 $Y=0.072 $X2=0.183 $Y2=0.1035
r19 43 44 7.34548 $w=1.3e-08 $l=3.15e-08 $layer=M1 $thickness=3.6e-08 $X=0.2345
+ $Y=0.072 $X2=0.203 $Y2=0.072
r20 42 43 10.7267 $w=1.3e-08 $l=4.6e-08 $layer=M1 $thickness=3.6e-08 $X=0.2805
+ $Y=0.072 $X2=0.2345 $Y2=0.072
r21 41 42 12.7088 $w=1.3e-08 $l=5.45e-08 $layer=M1 $thickness=3.6e-08 $X=0.335
+ $Y=0.072 $X2=0.2805 $Y2=0.072
r22 19 41 10.6101 $w=1.3e-08 $l=4.55e-08 $layer=M1 $thickness=3.6e-08 $X=0.3805
+ $Y=0.072 $X2=0.335 $Y2=0.072
r23 15 33 5.69636 $w=1.58e-08 $l=3.15e-08 $layer=M1 $thickness=3.6e-08 $X=0.405
+ $Y=0.072 $X2=0.405 $Y2=0.1035
r24 15 19 4.06404 $w=1.48367e-08 $l=2.45e-08 $layer=M1 $thickness=3.6e-08
+ $X=0.405 $Y=0.072 $X2=0.3805 $Y2=0.072
r25 39 38 16.4967 $w=2.1e-08 $l=4.85e-08 $layer=Gate_1 $thickness=5.6e-08
+ $X=0.459 $Y=0.2025 $X2=0.459 $Y2=0.154
r26 36 37 16.4967 $w=2.1e-08 $l=4.85e-08 $layer=Gate_1 $thickness=5.6e-08
+ $X=0.459 $Y=0.0675 $X2=0.459 $Y2=0.116
r27 10 31 6.54019 $w=2.09524e-08 $layer=Gate_1 $thickness=5.21905e-08 $X=0.459
+ $Y=0.135 $X2=0.459 $Y2=0.135
r28 10 37 6.6497 $w=2.04211e-08 $l=1.9e-08 $layer=Gate_1 $thickness=5.6e-08
+ $X=0.459 $Y=0.135 $X2=0.459 $Y2=0.116
r29 10 38 6.6497 $w=2.04211e-08 $l=1.9e-08 $layer=Gate_1 $thickness=5.6e-08
+ $X=0.459 $Y=0.135 $X2=0.459 $Y2=0.154
r30 20 27 19.3796 $a=3.24e-16 $layer=V0LIG $X=0.405 $Y=0.135 $X2=0.405 $Y2=0.135
r31 20 33 7.34548 $w=1.3e-08 $l=3.15e-08 $layer=M1 $thickness=3.6e-08 $X=0.405
+ $Y=0.135 $X2=0.405 $Y2=0.1035
r32 30 31 12.6539 $w=1.77815e-08 $l=2.7e-08 $layer=LIG $thickness=4.8e-08
+ $X=0.432 $Y=0.135 $X2=0.459 $Y2=0.135
r33 28 30 10.1729 $w=1.54914e-08 $l=1.75e-08 $layer=LIG $thickness=4.8e-08
+ $X=0.4145 $Y=0.135 $X2=0.432 $Y2=0.135
r34 27 28 2.48102 $w=2.2e-08 $l=9.5e-09 $layer=LIG $thickness=4.8e-08 $X=0.405
+ $Y=0.135 $X2=0.4145 $Y2=0.135
r35 1 27 2.48102 $w=2.2e-08 $l=9.5e-09 $layer=LIG $thickness=4.8e-08 $X=0.3955
+ $Y=0.135 $X2=0.405 $Y2=0.135
r36 25 24 16.4967 $w=2.1e-08 $l=4.85e-08 $layer=Gate_1 $thickness=5.6e-08
+ $X=0.405 $Y=0.2025 $X2=0.405 $Y2=0.154
r37 23 24 6.6497 $w=2.04211e-08 $l=1.9e-08 $layer=Gate_1 $thickness=5.6e-08
+ $X=0.405 $Y=0.135 $X2=0.405 $Y2=0.154
r38 23 28 4.05918 $w=2.0087e-08 $l=9.5e-09 $layer=Gate_1 $thickness=5.56522e-08
+ $X=0.405 $Y=0.135 $X2=0.4145 $Y2=0.135
r39 23 27 6.27904 $w=2.09e-08 $layer=Gate_1 $thickness=5.24e-08 $X=0.405
+ $Y=0.135 $X2=0.405 $Y2=0.135
r40 22 23 6.6497 $w=2.04211e-08 $l=1.9e-08 $layer=Gate_1 $thickness=5.6e-08
+ $X=0.405 $Y=0.116 $X2=0.405 $Y2=0.135
r41 21 22 16.4967 $w=2.1e-08 $l=4.85e-08 $layer=Gate_1 $thickness=5.6e-08
+ $X=0.405 $Y=0.0675 $X2=0.405 $Y2=0.116
r42 21 9 14.6259 $w=2.1e-08 $l=4.3e-08 $layer=Gate_1 $thickness=5.6e-08
+ $X=0.405 $Y=0.0675 $X2=0.405 $Y2=0.0245
.ends

.subckt PM_XOR2x1_ASAP7_75t_R%Y vss 32 23 45 46 51 54 55 20 17 15 1 4 13 19 21
+ 14 16 3 2
c1 1 vss 0.00622385f $X=0.27 $Y=0.0675
c2 2 vss 0.00823628f $X=0.432 $Y=0.0675
c3 3 vss 0.009231f $X=0.432 $Y=0.2025
c4 4 vss 0.00748971f $X=0.594 $Y=0.0675
c5 13 vss 0.0359101f $X=0.272 $Y=0.0675
c6 14 vss 0.00443485f $X=0.4175 $Y=0.0675
c7 15 vss 0.0361749f $X=0.5795 $Y=0.0675
c8 16 vss 0.00433356f $X=0.4175 $Y=0.2025
c9 17 vss 0.00342301f $X=0.459 $Y=0.184
c10 18 vss 0.00201997f $X=0.459 $Y=0.036
c11 19 vss 0.0155532f $X=0.2585 $Y=0.036
c12 20 vss 0.00213714f $X=0.459 $Y=0.054
c13 21 vss 0.0125862f $X=0.486 $Y=0.036
r1 55 53 0.0308642 $w=8.1e-08 $l=2.5e-09 $layer=P_src_drn $thickness=1e-09
+ $X=0.4493 $Y=0.2025 $X2=0.4465 $Y2=0.2025
r2 3 53 0.179012 $w=8.1e-08 $l=1.45e-08 $layer=P_src_drn $thickness=1e-09
+ $X=0.432 $Y=0.2025 $X2=0.4465 $Y2=0.2025
r3 16 3 0.179012 $w=8.1e-08 $l=1.45e-08 $layer=P_src_drn $thickness=1e-09
+ $X=0.4175 $Y=0.2025 $X2=0.432 $Y2=0.2025
r4 54 16 0.0308642 $w=8.1e-08 $l=2.5e-09 $layer=P_src_drn $thickness=1e-09
+ $X=0.4146 $Y=0.2025 $X2=0.4175 $Y2=0.2025
r5 15 4 0.154321 $w=8.1e-08 $l=1.25e-08 $layer=N_src_drn $thickness=1e-09
+ $X=0.5795 $Y=0.0675 $X2=0.594 $Y2=0.0675
r6 51 15 0.0308642 $w=8.1e-08 $l=2.5e-09 $layer=N_src_drn $thickness=1e-09
+ $X=0.5766 $Y=0.0675 $X2=0.5795 $Y2=0.0675
r7 3 48 19.3796 $a=3.24e-16 $layer=V0LISD $X=0.432 $Y=0.2025 $X2=0.432 $Y2=0.184
r8 4 40 19.3796 $a=3.24e-16 $layer=V0LISD $X=0.594 $Y=0.0675 $X2=0.594 $Y2=0.036
r9 48 49 3.14806 $w=1.3e-08 $l=1.35e-08 $layer=M1 $thickness=3.6e-08 $X=0.432
+ $Y=0.184 $X2=0.4455 $Y2=0.184
r10 17 35 3.94987 $w=1.50455e-08 $l=2.2e-08 $layer=M1 $thickness=3.6e-08
+ $X=0.459 $Y=0.184 $X2=0.459 $Y2=0.162
r11 17 49 1.96775 $w=1.63333e-08 $l=1.35e-08 $layer=M1 $thickness=3.6e-08
+ $X=0.459 $Y=0.184 $X2=0.4455 $Y2=0.184
r12 46 44 0.0308642 $w=8.1e-08 $l=2.5e-09 $layer=N_src_drn $thickness=1e-09
+ $X=0.4493 $Y=0.0675 $X2=0.4465 $Y2=0.0675
r13 2 44 0.179012 $w=8.1e-08 $l=1.45e-08 $layer=N_src_drn $thickness=1e-09
+ $X=0.432 $Y=0.0675 $X2=0.4465 $Y2=0.0675
r14 14 2 0.179012 $w=8.1e-08 $l=1.45e-08 $layer=N_src_drn $thickness=1e-09
+ $X=0.4175 $Y=0.0675 $X2=0.432 $Y2=0.0675
r15 45 14 0.0308642 $w=8.1e-08 $l=2.5e-09 $layer=N_src_drn $thickness=1e-09
+ $X=0.4146 $Y=0.0675 $X2=0.4175 $Y2=0.0675
r16 39 40 3.14806 $w=1.3e-08 $l=1.35e-08 $layer=M1 $thickness=3.6e-08 $X=0.5805
+ $Y=0.036 $X2=0.594 $Y2=0.036
r17 38 39 6.8791 $w=1.3e-08 $l=2.95e-08 $layer=M1 $thickness=3.6e-08 $X=0.551
+ $Y=0.036 $X2=0.5805 $Y2=0.036
r18 37 38 6.29612 $w=1.3e-08 $l=2.7e-08 $layer=M1 $thickness=3.6e-08 $X=0.524
+ $Y=0.036 $X2=0.551 $Y2=0.036
r19 36 37 2.56509 $w=1.3e-08 $l=1.1e-08 $layer=M1 $thickness=3.6e-08 $X=0.513
+ $Y=0.036 $X2=0.524 $Y2=0.036
r20 21 36 6.29612 $w=1.3e-08 $l=2.7e-08 $layer=M1 $thickness=3.6e-08 $X=0.486
+ $Y=0.036 $X2=0.513 $Y2=0.036
r21 34 35 6.64591 $w=1.3e-08 $l=2.85e-08 $layer=M1 $thickness=3.6e-08 $X=0.459
+ $Y=0.1335 $X2=0.459 $Y2=0.162
r22 33 34 6.58761 $w=1.3e-08 $l=2.83e-08 $layer=M1 $thickness=3.6e-08 $X=0.459
+ $Y=0.1052 $X2=0.459 $Y2=0.1335
r23 32 33 3.08976 $w=1.3e-08 $l=1.32e-08 $layer=M1 $thickness=3.6e-08 $X=0.457
+ $Y=0.092 $X2=0.459 $Y2=0.1052
r24 32 31 1.34084 $w=1.3e-08 $l=5.8e-09 $layer=M1 $thickness=3.6e-08 $X=0.457
+ $Y=0.092 $X2=0.459 $Y2=0.0862
r25 30 31 3.32295 $w=1.3e-08 $l=1.42e-08 $layer=M1 $thickness=3.6e-08 $X=0.459
+ $Y=0.072 $X2=0.459 $Y2=0.0862
r26 20 30 4.19742 $w=1.3e-08 $l=1.8e-08 $layer=M1 $thickness=3.6e-08 $X=0.459
+ $Y=0.054 $X2=0.459 $Y2=0.072
r27 2 28 19.3796 $a=3.24e-16 $layer=V0LISD $X=0.432 $Y=0.0675 $X2=0.432
+ $Y2=0.036
r28 18 29 1.96775 $w=1.63333e-08 $l=1.35e-08 $layer=M1 $thickness=3.6e-08
+ $X=0.459 $Y=0.036 $X2=0.4455 $Y2=0.036
r29 18 20 3.01711 $w=1.55e-08 $l=1.8e-08 $layer=M1 $thickness=3.6e-08 $X=0.459
+ $Y=0.036 $X2=0.459 $Y2=0.054
r30 18 21 5.11582 $w=1.46667e-08 $l=2.7e-08 $layer=M1 $thickness=3.6e-08
+ $X=0.459 $Y=0.036 $X2=0.486 $Y2=0.036
r31 28 29 3.14806 $w=1.3e-08 $l=1.35e-08 $layer=M1 $thickness=3.6e-08 $X=0.432
+ $Y=0.036 $X2=0.4455 $Y2=0.036
r32 27 28 2.68168 $w=1.3e-08 $l=1.15e-08 $layer=M1 $thickness=3.6e-08 $X=0.4205
+ $Y=0.036 $X2=0.432 $Y2=0.036
r33 26 27 1.04935 $w=1.3e-08 $l=4.5e-09 $layer=M1 $thickness=3.6e-08 $X=0.416
+ $Y=0.036 $X2=0.4205 $Y2=0.036
r34 25 26 16.2067 $w=1.3e-08 $l=6.95e-08 $layer=M1 $thickness=3.6e-08 $X=0.3465
+ $Y=0.036 $X2=0.416 $Y2=0.036
r35 24 25 17.839 $w=1.3e-08 $l=7.65e-08 $layer=M1 $thickness=3.6e-08 $X=0.27
+ $Y=0.036 $X2=0.3465 $Y2=0.036
r36 19 24 2.68168 $w=1.3e-08 $l=1.15e-08 $layer=M1 $thickness=3.6e-08 $X=0.2585
+ $Y=0.036 $X2=0.27 $Y2=0.036
r37 1 24 19.3796 $a=3.24e-16 $layer=V0LISD $X=0.27 $Y=0.0675 $X2=0.27 $Y2=0.036
r38 23 22 0.0308642 $w=8.1e-08 $l=2.5e-09 $layer=N_src_drn $thickness=1e-09
+ $X=0.2873 $Y=0.0675 $X2=0.2845 $Y2=0.0675
r39 13 22 0.154321 $w=8.1e-08 $l=1.25e-08 $layer=N_src_drn $thickness=1e-09
+ $X=0.272 $Y=0.0675 $X2=0.2845 $Y2=0.0675
r40 1 13 1e-05 $l=2e-09 $X=0.27 $Y=0.0675 $X2=0.272 $Y2=0.0675
.ends

.subckt PM_XOR2x1_ASAP7_75t_R%A vss 40 28 34 78 81 84 87 9 2 17 1 24 22 18 23
+ 16 14 21 19 3 25 12 8 7 20
c1 1 vss 0.00922464f $X=0.072 $Y=0.135
c2 2 vss 0.00592228f $X=0.351 $Y=0.135
c3 3 vss 0.0058663f $X=0.513 $Y=0.135
c4 7 vss 0.0856139f $X=0.081 $Y=0.0245
c5 8 vss 0.140135f $X=0.351 $Y=0.135
c6 9 vss 0.140201f $X=0.513 $Y=0.135
c7 10 vss 0.00113221f $X=0.027 $Y=0.135
c8 11 vss 0.00365012f $X=0.027 $Y=0.234
c9 12 vss 0.000590845f $X=0.222 $Y=0.1955
c10 13 vss 0.00355539f $X=0.222 $Y=0.234
c11 14 vss 0.00037153f $X=0.314 $Y=0.135
c12 15 vss 0.00341498f $X=0.314 $Y=0.189
c13 16 vss 0.00952192f $X=0.027 $Y=0.1035
c14 17 vss 0.00613351f $X=0.027 $Y=0.1465
c15 18 vss 0.00125655f $X=0.0455 $Y=0.135
c16 19 vss 0.0177314f $X=0.057 $Y=0.234
c17 20 vss 0.00108061f $X=0.222 $Y=0.214
c18 21 vss 0.00596667f $X=0.2435 $Y=0.194
c19 22 vss 0.00163927f $X=0.314 $Y=0.1775
c20 23 vss 0.000850923f $X=0.3325 $Y=0.135
c21 24 vss 0.00593182f $X=0.513 $Y=0.1775
c22 25 vss 0.0120827f $X=0.3015 $Y=0.189
r1 87 86 16.4967 $w=2.1e-08 $l=4.85e-08 $layer=Gate_1 $thickness=5.6e-08
+ $X=0.351 $Y=0.2025 $X2=0.351 $Y2=0.154
r2 84 85 16.4967 $w=2.1e-08 $l=4.85e-08 $layer=Gate_1 $thickness=5.6e-08
+ $X=0.351 $Y=0.0675 $X2=0.351 $Y2=0.116
r3 8 85 6.6497 $w=2.04211e-08 $l=1.9e-08 $layer=Gate_1 $thickness=5.6e-08
+ $X=0.351 $Y=0.135 $X2=0.351 $Y2=0.116
r4 8 86 6.6497 $w=2.04211e-08 $l=1.9e-08 $layer=Gate_1 $thickness=5.6e-08
+ $X=0.351 $Y=0.135 $X2=0.351 $Y2=0.154
r5 81 80 16.4967 $w=2.1e-08 $l=4.85e-08 $layer=Gate_1 $thickness=5.6e-08
+ $X=0.513 $Y=0.2025 $X2=0.513 $Y2=0.154
r6 78 79 16.4967 $w=2.1e-08 $l=4.85e-08 $layer=Gate_1 $thickness=5.6e-08
+ $X=0.513 $Y=0.0675 $X2=0.513 $Y2=0.116
r7 9 79 6.6497 $w=2.04211e-08 $l=1.9e-08 $layer=Gate_1 $thickness=5.6e-08
+ $X=0.513 $Y=0.135 $X2=0.513 $Y2=0.116
r8 9 80 6.6497 $w=2.04211e-08 $l=1.9e-08 $layer=Gate_1 $thickness=5.6e-08
+ $X=0.513 $Y=0.135 $X2=0.513 $Y2=0.154
r9 2 73 19.3796 $a=3.24e-16 $layer=V0LIG $X=0.351 $Y=0.135 $X2=0.351 $Y2=0.135
r10 2 8 8.65438 $w=1.80211e-08 $layer=LIG $thickness=5.26316e-08 $X=0.351
+ $Y=0.135 $X2=0.351 $Y2=0.135
r11 3 69 19.3796 $a=3.24e-16 $layer=V0LIG $X=0.513 $Y=0.135 $X2=0.513 $Y2=0.135
r12 3 9 10.4265 $w=1.765e-08 $layer=LIG $thickness=5.2e-08 $X=0.513 $Y=0.135
+ $X2=0.513 $Y2=0.135
r13 23 73 4.31401 $w=1.3e-08 $l=1.85e-08 $layer=M1 $thickness=3.6e-08 $X=0.3325
+ $Y=0.135 $X2=0.351 $Y2=0.135
r14 69 70 2.68168 $w=1.3e-08 $l=1.15e-08 $layer=M1 $thickness=3.6e-08 $X=0.513
+ $Y=0.135 $X2=0.513 $Y2=0.1465
r15 67 70 3.61444 $w=1.3e-08 $l=1.55e-08 $layer=M1 $thickness=3.6e-08 $X=0.513
+ $Y=0.162 $X2=0.513 $Y2=0.1465
r16 24 66 2.09871 $w=1.3e-08 $l=9e-09 $layer=M1 $thickness=3.6e-08 $X=0.513
+ $Y=0.1775 $X2=0.513 $Y2=0.1865
r17 24 67 3.61444 $w=1.3e-08 $l=1.55e-08 $layer=M1 $thickness=3.6e-08 $X=0.513
+ $Y=0.1775 $X2=0.513 $Y2=0.162
r18 14 61 1.03257 $w=2.06696e-08 $l=1.15e-08 $layer=M1 $thickness=3.6e-08
+ $X=0.314 $Y=0.135 $X2=0.314 $Y2=0.1465
r19 14 23 2.6649 $w=1.54324e-08 $l=1.85e-08 $layer=M1 $thickness=3.6e-08
+ $X=0.314 $Y=0.135 $X2=0.3325 $Y2=0.135
r20 64 66 19.5347 $a=3.24e-16 $layer=V1 $X=0.513 $Y=0.189 $X2=0.513 $Y2=0.1865
r21 63 64 23.2024 $w=1.3e-08 $l=9.95e-08 $layer=M2 $thickness=3.6e-08 $X=0.4135
+ $Y=0.189 $X2=0.513 $Y2=0.189
r22 62 63 23.2024 $w=1.3e-08 $l=9.95e-08 $layer=M2 $thickness=3.6e-08 $X=0.314
+ $Y=0.189 $X2=0.4135 $Y2=0.189
r23 25 62 2.91487 $w=1.3e-08 $l=1.25e-08 $layer=M2 $thickness=3.6e-08 $X=0.3015
+ $Y=0.189 $X2=0.314 $Y2=0.189
r24 60 61 3.61444 $w=1.3e-08 $l=1.55e-08 $layer=M1 $thickness=3.6e-08 $X=0.314
+ $Y=0.162 $X2=0.314 $Y2=0.1465
r25 59 62 70.3248 $a=9e-17 $layer=V1 $X=0.314 $Y=0.1825 $X2=0.314 $Y2=0.189
r26 22 59 1.16595 $w=1.3e-08 $l=5e-09 $layer=M1 $thickness=3.6e-08 $X=0.314
+ $Y=0.1775 $X2=0.314 $Y2=0.1825
r27 22 60 3.61444 $w=1.3e-08 $l=1.55e-08 $layer=M1 $thickness=3.6e-08 $X=0.314
+ $Y=0.1775 $X2=0.314 $Y2=0.162
r28 57 58 0.255111 $w=1.8e-08 $l=2.5e-09 $layer=M1 $thickness=3.6e-08 $X=0.314
+ $Y=0.199 $X2=0.314 $Y2=0.2015
r29 56 57 0.357156 $w=1.8e-08 $l=3.5e-09 $layer=M1 $thickness=3.6e-08 $X=0.314
+ $Y=0.1955 $X2=0.314 $Y2=0.199
r30 15 55 6.12133 $w=1.37018e-08 $l=3.38711e-08 $layer=M1 $thickness=3.6e-08
+ $X=0.314 $Y=0.189 $X2=0.2805 $Y2=0.194
r31 15 56 0.663289 $w=1.8e-08 $l=6.5e-09 $layer=M1 $thickness=3.6e-08 $X=0.314
+ $Y=0.189 $X2=0.314 $Y2=0.1955
r32 15 59 0.991152 $w=1.60769e-08 $l=6.5e-09 $layer=M1 $thickness=3.6e-08
+ $X=0.314 $Y=0.189 $X2=0.314 $Y2=0.1825
r33 15 62 27.048 $a=2.34e-16 $layer=V1 $X=0.314 $Y=0.189 $X2=0.314 $Y2=0.189
r34 55 56 5.96826 $w=1.3463e-08 $l=3.35336e-08 $layer=M1 $thickness=3.6e-08
+ $X=0.2805 $Y=0.194 $X2=0.314 $Y2=0.1955
r35 55 58 5.86622 $w=1.32885e-08 $l=3.43293e-08 $layer=M1 $thickness=3.6e-08
+ $X=0.2805 $Y=0.194 $X2=0.314 $Y2=0.2015
r36 21 55 8.62802 $w=1.3e-08 $l=3.7e-08 $layer=M1 $thickness=3.6e-08 $X=0.2435
+ $Y=0.194 $X2=0.2805 $Y2=0.194
r37 12 20 3.33042 $w=1.5027e-08 $l=1.85e-08 $layer=M1 $thickness=3.6e-08
+ $X=0.222 $Y=0.1955 $X2=0.222 $Y2=0.214
r38 12 21 3.68021 $w=1.4875e-08 $l=2.15523e-08 $layer=M1 $thickness=3.6e-08
+ $X=0.222 $Y=0.1955 $X2=0.2435 $Y2=0.194
r39 13 53 2.89809 $w=1.53077e-08 $l=1.95e-08 $layer=M1 $thickness=3.6e-08
+ $X=0.222 $Y=0.234 $X2=0.2025 $Y2=0.234
r40 13 20 3.01468 $w=1.741e-08 $l=2e-08 $layer=M1 $thickness=3.6e-08 $X=0.222
+ $Y=0.234 $X2=0.222 $Y2=0.214
r41 52 53 4.5472 $w=1.3e-08 $l=1.95e-08 $layer=M1 $thickness=3.6e-08 $X=0.183
+ $Y=0.234 $X2=0.2025 $Y2=0.234
r42 51 52 5.59655 $w=1.3e-08 $l=2.4e-08 $layer=M1 $thickness=3.6e-08 $X=0.159
+ $Y=0.234 $X2=0.183 $Y2=0.234
r43 50 51 5.59655 $w=1.3e-08 $l=2.4e-08 $layer=M1 $thickness=3.6e-08 $X=0.135
+ $Y=0.234 $X2=0.159 $Y2=0.234
r44 49 50 4.31401 $w=1.3e-08 $l=1.85e-08 $layer=M1 $thickness=3.6e-08 $X=0.1165
+ $Y=0.234 $X2=0.135 $Y2=0.234
r45 48 49 3.96423 $w=1.3e-08 $l=1.7e-08 $layer=M1 $thickness=3.6e-08 $X=0.0995
+ $Y=0.234 $X2=0.1165 $Y2=0.234
r46 47 48 3.38125 $w=1.3e-08 $l=1.45e-08 $layer=M1 $thickness=3.6e-08 $X=0.085
+ $Y=0.234 $X2=0.0995 $Y2=0.234
r47 19 47 6.52931 $w=1.3e-08 $l=2.8e-08 $layer=M1 $thickness=3.6e-08 $X=0.057
+ $Y=0.234 $X2=0.085 $Y2=0.234
r48 11 46 4.76361 $w=1.62073e-08 $l=2.75e-08 $layer=M1 $thickness=3.6e-08
+ $X=0.027 $Y=0.234 $X2=0.027 $Y2=0.2065
r49 11 19 5.34658 $w=1.45e-08 $l=3e-08 $layer=M1 $thickness=3.6e-08 $X=0.027
+ $Y=0.234 $X2=0.057 $Y2=0.234
r50 45 46 8.86121 $w=1.3e-08 $l=3.8e-08 $layer=M1 $thickness=3.6e-08 $X=0.027
+ $Y=0.1685 $X2=0.027 $Y2=0.2065
r51 17 45 5.13018 $w=1.3e-08 $l=2.2e-08 $layer=M1 $thickness=3.6e-08 $X=0.027
+ $Y=0.1465 $X2=0.027 $Y2=0.1685
r52 10 18 3.1337 $w=1.54324e-08 $l=1.85e-08 $layer=M1 $thickness=3.6e-08
+ $X=0.027 $Y=0.135 $X2=0.0455 $Y2=0.135
r53 10 16 6.16517 $w=1.44286e-08 $l=3.15e-08 $layer=M1 $thickness=3.6e-08
+ $X=0.027 $Y=0.135 $X2=0.027 $Y2=0.1035
r54 10 17 1.50137 $w=1.6913e-08 $l=1.15e-08 $layer=M1 $thickness=3.6e-08
+ $X=0.027 $Y=0.135 $X2=0.027 $Y2=0.1465
r55 40 18 4.31401 $w=1.3e-08 $l=1.85e-08 $layer=M1 $thickness=3.6e-08 $X=0.06
+ $Y=0.134 $X2=0.0455 $Y2=0.135
r56 40 38 19.3796 $a=3.24e-16 $layer=V0LIG $X=0.06 $Y=0.134 $X2=0.063 $Y2=0.135
r57 1 36 2.6116 $w=2.2e-08 $l=1e-08 $layer=LIG $thickness=4.8e-08 $X=0.072
+ $Y=0.135 $X2=0.082 $Y2=0.135
r58 1 38 4.98695 $w=1.60444e-08 $l=9e-09 $layer=LIG $thickness=4.8e-08 $X=0.072
+ $Y=0.135 $X2=0.063 $Y2=0.135
r59 34 33 14.6259 $w=2.1e-08 $l=4.3e-08 $layer=Gate_1 $thickness=5.6e-08
+ $X=0.081 $Y=0.2025 $X2=0.081 $Y2=0.1595
r60 32 33 2.7211 $w=2.1e-08 $l=8e-09 $layer=Gate_1 $thickness=5.6e-08 $X=0.081
+ $Y=0.1515 $X2=0.081 $Y2=0.1595
r61 31 32 5.79936 $w=2.03333e-08 $l=1.65e-08 $layer=Gate_1 $thickness=5.6e-08
+ $X=0.081 $Y=0.135 $X2=0.081 $Y2=0.1515
r62 31 36 6.27904 $w=2.09e-08 $l=1e-09 $layer=Gate_1 $thickness=5.24e-08
+ $X=0.081 $Y=0.135 $X2=0.082 $Y2=0.135
r63 30 31 5.79936 $w=2.03333e-08 $l=1.65e-08 $layer=Gate_1 $thickness=5.6e-08
+ $X=0.081 $Y=0.1185 $X2=0.081 $Y2=0.135
r64 29 30 2.7211 $w=2.1e-08 $l=8e-09 $layer=Gate_1 $thickness=5.6e-08 $X=0.081
+ $Y=0.1105 $X2=0.081 $Y2=0.1185
r65 28 29 14.6259 $w=2.1e-08 $l=4.3e-08 $layer=Gate_1 $thickness=5.6e-08
+ $X=0.081 $Y=0.0675 $X2=0.081 $Y2=0.1105
r66 28 7 14.6259 $w=2.1e-08 $l=4.3e-08 $layer=Gate_1 $thickness=5.6e-08
+ $X=0.081 $Y=0.0675 $X2=0.081 $Y2=0.0245
.ends

.subckt PM_XOR2x1_ASAP7_75t_R%B vss 45 15 21 31 35 58 62 1 8 10 11 9 2 12 6 5 7
c1 1 vss 0.0198669f $X=0.297 $Y=0.135
c2 2 vss 0.00518489f $X=0.567 $Y=0.135
c3 5 vss 0.0488428f $X=0.135 $Y=0.135
c4 6 vss 0.106159f $X=0.297 $Y=0.0245
c5 7 vss 0.106288f $X=0.567 $Y=0.135
c6 8 vss 0.00187162f $X=0.135 $Y=0.072
c7 9 vss 0.00265388f $X=0.567 $Y=0.072
c8 10 vss 0.00148453f $X=0.135 $Y=0.1265
c9 11 vss 0.00346708f $X=0.567 $Y=0.0855
c10 12 vss 0.022684f $X=0.1235 $Y=0.081
r1 62 61 14.6259 $w=2.1e-08 $l=4.3e-08 $layer=Gate_1 $thickness=5.6e-08
+ $X=0.567 $Y=0.2025 $X2=0.567 $Y2=0.1595
r2 60 61 2.7211 $w=2.1e-08 $l=8e-09 $layer=Gate_1 $thickness=5.6e-08 $X=0.567
+ $Y=0.1515 $X2=0.567 $Y2=0.1595
r3 58 59 14.6259 $w=2.1e-08 $l=4.3e-08 $layer=Gate_1 $thickness=5.6e-08
+ $X=0.567 $Y=0.0675 $X2=0.567 $Y2=0.1105
r4 56 59 2.7211 $w=2.1e-08 $l=8e-09 $layer=Gate_1 $thickness=5.6e-08 $X=0.567
+ $Y=0.1185 $X2=0.567 $Y2=0.1105
r5 7 56 5.79936 $w=2.03333e-08 $l=1.65e-08 $layer=Gate_1 $thickness=5.6e-08
+ $X=0.567 $Y=0.135 $X2=0.567 $Y2=0.1185
r6 7 60 5.79936 $w=2.03333e-08 $l=1.65e-08 $layer=Gate_1 $thickness=5.6e-08
+ $X=0.567 $Y=0.135 $X2=0.567 $Y2=0.1515
r7 2 54 19.3796 $a=3.24e-16 $layer=V0LIG $X=0.567 $Y=0.135 $X2=0.567 $Y2=0.135
r8 2 7 10.4265 $w=1.765e-08 $layer=LIG $thickness=5.2e-08 $X=0.567 $Y=0.135
+ $X2=0.567 $Y2=0.135
r9 53 54 3.03147 $w=1.3e-08 $l=1.3e-08 $layer=M1 $thickness=3.6e-08 $X=0.567
+ $Y=0.122 $X2=0.567 $Y2=0.135
r10 52 53 4.19742 $w=1.3e-08 $l=1.8e-08 $layer=M1 $thickness=3.6e-08 $X=0.567
+ $Y=0.104 $X2=0.567 $Y2=0.122
r11 11 52 4.31401 $w=1.3e-08 $l=1.85e-08 $layer=M1 $thickness=3.6e-08 $X=0.567
+ $Y=0.0855 $X2=0.567 $Y2=0.104
r12 11 49 39.0693 $a=1.62e-16 $layer=V1 $X=0.567 $Y=0.0855 $X2=0.567 $Y2=0.081
r13 9 49 39.0693 $a=1.62e-16 $layer=V1 $X=0.567 $Y=0.072 $X2=0.567 $Y2=0.081
r14 9 11 1.96775 $w=1.63333e-08 $l=1.35e-08 $layer=M1 $thickness=3.6e-08
+ $X=0.567 $Y=0.072 $X2=0.567 $Y2=0.0855
r15 48 49 5.71315 $w=1.3e-08 $l=2.45e-08 $layer=M2 $thickness=3.6e-08 $X=0.5425
+ $Y=0.081 $X2=0.567 $Y2=0.081
r16 47 48 30.3147 $w=1.3e-08 $l=1.3e-07 $layer=M2 $thickness=3.6e-08 $X=0.4125
+ $Y=0.081 $X2=0.5425 $Y2=0.081
r17 46 47 36.3193 $w=1.3e-08 $l=1.558e-07 $layer=M2 $thickness=3.6e-08
+ $X=0.2567 $Y=0.081 $X2=0.4125 $Y2=0.081
r18 45 46 9.73567 $w=1.3e-08 $l=4.17e-08 $layer=M2 $thickness=3.6e-08 $X=0.215
+ $Y=0.081 $X2=0.2567 $Y2=0.081
r19 45 44 8.33653 $w=1.3e-08 $l=3.58e-08 $layer=M2 $thickness=3.6e-08 $X=0.215
+ $Y=0.081 $X2=0.1792 $Y2=0.081
r20 43 44 10.3186 $w=1.3e-08 $l=4.42e-08 $layer=M2 $thickness=3.6e-08 $X=0.135
+ $Y=0.081 $X2=0.1792 $Y2=0.081
r21 12 43 2.68168 $w=1.3e-08 $l=1.15e-08 $layer=M2 $thickness=3.6e-08 $X=0.1235
+ $Y=0.081 $X2=0.135 $Y2=0.081
r22 8 39 1.96775 $w=1.63333e-08 $l=1.35e-08 $layer=M1 $thickness=3.6e-08
+ $X=0.135 $Y=0.072 $X2=0.135 $Y2=0.0855
r23 8 43 39.0693 $a=1.62e-16 $layer=V1 $X=0.135 $Y=0.072 $X2=0.135 $Y2=0.081
r24 39 40 5.24677 $w=1.3e-08 $l=2.25e-08 $layer=M1 $thickness=3.6e-08 $X=0.135
+ $Y=0.0855 $X2=0.135 $Y2=0.108
r25 39 43 39.0693 $a=1.62e-16 $layer=V1 $X=0.135 $Y=0.0855 $X2=0.135 $Y2=0.081
r26 10 37 1.98211 $w=1.3e-08 $l=8.5e-09 $layer=M1 $thickness=3.6e-08 $X=0.135
+ $Y=0.1265 $X2=0.135 $Y2=0.135
r27 10 40 4.31401 $w=1.3e-08 $l=1.85e-08 $layer=M1 $thickness=3.6e-08 $X=0.135
+ $Y=0.1265 $X2=0.135 $Y2=0.108
r28 35 34 14.6259 $w=2.1e-08 $l=4.3e-08 $layer=Gate_1 $thickness=5.6e-08
+ $X=0.135 $Y=0.2025 $X2=0.135 $Y2=0.1595
r29 33 34 3.23131 $w=2.1e-08 $l=9.5e-09 $layer=Gate_1 $thickness=5.6e-08
+ $X=0.135 $Y=0.15 $X2=0.135 $Y2=0.1595
r30 31 32 14.6259 $w=2.1e-08 $l=4.3e-08 $layer=Gate_1 $thickness=5.6e-08
+ $X=0.135 $Y=0.0675 $X2=0.135 $Y2=0.1105
r31 29 32 3.23131 $w=2.1e-08 $l=9.5e-09 $layer=Gate_1 $thickness=5.6e-08
+ $X=0.135 $Y=0.12 $X2=0.135 $Y2=0.1105
r32 5 25 7.11151 $w=1.78824e-08 $layer=LIG $thickness=5.17647e-08 $X=0.135
+ $Y=0.135 $X2=0.135 $Y2=0.135
r33 5 29 5.23813 $w=2.04667e-08 $l=1.5e-08 $layer=Gate_1 $thickness=5.6e-08
+ $X=0.135 $Y=0.135 $X2=0.135 $Y2=0.12
r34 5 33 5.23813 $w=2.04667e-08 $l=1.5e-08 $layer=Gate_1 $thickness=5.6e-08
+ $X=0.135 $Y=0.135 $X2=0.135 $Y2=0.15
r35 25 26 4.49071 $w=1.6e-08 $l=9.5e-09 $layer=LIG $thickness=4.8e-08 $X=0.135
+ $Y=0.135 $X2=0.1445 $Y2=0.135
r36 25 37 28.9687 $a=2.88e-16 $layer=V0LIG $X=0.135 $Y=0.135 $X2=0.135 $Y2=0.135
r37 23 26 165.742 $w=9.34685e-09 $l=7.15e-08 $layer=LIG $thickness=4.8e-08
+ $X=0.216 $Y=0.135 $X2=0.1445 $Y2=0.135
r38 1 18 7.58422 $w=1.77778e-08 $layer=LIG $thickness=5.15556e-08 $X=0.297
+ $Y=0.135 $X2=0.297 $Y2=0.135
r39 1 23 170.233 $w=1.01272e-08 $l=8.1e-08 $layer=LIG $thickness=4.8e-08
+ $X=0.297 $Y=0.135 $X2=0.216 $Y2=0.135
r40 21 20 14.6259 $w=2.1e-08 $l=4.3e-08 $layer=Gate_1 $thickness=5.6e-08
+ $X=0.297 $Y=0.2025 $X2=0.297 $Y2=0.1595
r41 19 20 3.23131 $w=2.1e-08 $l=9.5e-09 $layer=Gate_1 $thickness=5.6e-08
+ $X=0.297 $Y=0.15 $X2=0.297 $Y2=0.1595
r42 18 19 5.23813 $w=2.04667e-08 $l=1.5e-08 $layer=Gate_1 $thickness=5.6e-08
+ $X=0.297 $Y=0.135 $X2=0.297 $Y2=0.15
r43 17 18 5.23813 $w=2.04667e-08 $l=1.5e-08 $layer=Gate_1 $thickness=5.6e-08
+ $X=0.297 $Y=0.12 $X2=0.297 $Y2=0.135
r44 16 17 3.23131 $w=2.1e-08 $l=9.5e-09 $layer=Gate_1 $thickness=5.6e-08
+ $X=0.297 $Y=0.1105 $X2=0.297 $Y2=0.12
r45 15 16 14.6259 $w=2.1e-08 $l=4.3e-08 $layer=Gate_1 $thickness=5.6e-08
+ $X=0.297 $Y=0.0675 $X2=0.297 $Y2=0.1105
r46 15 6 14.6259 $w=2.1e-08 $l=4.3e-08 $layer=Gate_1 $thickness=5.6e-08
+ $X=0.297 $Y=0.0675 $X2=0.297 $Y2=0.0245
.ends

.subckt PM_XOR2x1_ASAP7_75t_R%10 vss 2 3 1
c1 1 vss 0.000807028f $X=0.108 $Y=0.2025
r1 2 1 0.209877 $w=8.1e-08 $l=1.7e-08 $layer=P_src_drn $thickness=1e-09
+ $X=0.0906 $Y=0.2025 $X2=0.108 $Y2=0.2025
r2 3 1 0.209877 $w=8.1e-08 $l=1.7e-08 $layer=P_src_drn $thickness=1e-09
+ $X=0.1253 $Y=0.2025 $X2=0.108 $Y2=0.2025
.ends

* End of included file XOR2x1_ASAP7_75t_R.pex.sp.pex

*
.subckt XOR2x1_ASAP7_75t_CUSTOM_4_25_0_7 VSS VDD A B Y
*
* VSS VSS
* VDD VDD
* A A
* B B
* Y Y
*
*

M0 N_M0_d N_M0_g VSS VSS nmos_rvt L=2e-08 W=8.1e-08 nfin=3 $X=0.071 $Y=0.027
M1 VSS N_M1_g N_M1_s VSS nmos_rvt L=2e-08 W=8.1e-08 nfin=3 $X=0.125 $Y=0.027
M2 N_M2_d N_M2_g noxref_8 VSS nmos_rvt L=2e-08 W=8.1e-08 nfin=3 $X=0.287
+ $Y=0.027
M3 noxref_8 N_M3_g VSS VSS nmos_rvt L=2e-08 W=8.1e-08 nfin=3 $X=0.341 $Y=0.027
M4 N_M4_d N_M4_g VSS VSS nmos_rvt L=2e-08 W=8.1e-08 nfin=3 $X=0.395 $Y=0.027
M5 N_M5_d N_M5_g VSS VSS nmos_rvt L=2e-08 W=8.1e-08 nfin=3 $X=0.449 $Y=0.027
M6 noxref_9 N_M6_g VSS VSS nmos_rvt L=2e-08 W=8.1e-08 nfin=3 $X=0.503 $Y=0.027
M7 N_M7_d N_M7_g noxref_9 VSS nmos_rvt L=2e-08 W=8.1e-08 nfin=3 $X=0.557
+ $Y=0.027
M8 N_M8_d N_M8_g VDD VDD pmos_rvt L=2e-08 W=8.1e-08 nfin=3 $X=0.071 $Y=0.162
M9 N_M9_d N_M9_g N_M9_s VDD pmos_rvt L=2e-08 W=8.1e-08 nfin=3 $X=0.125 $Y=0.162
M10 VDD N_M10_g noxref_6 VDD pmos_rvt L=2e-08 W=8.1e-08 nfin=3 $X=0.287 $Y=0.162
M11 noxref_6 N_M11_g VDD VDD pmos_rvt L=2e-08 W=8.1e-08 nfin=3 $X=0.341 $Y=0.162
M12 N_M12_d N_M12_g noxref_6 VDD pmos_rvt L=2e-08 W=8.1e-08 nfin=3 $X=0.395
+ $Y=0.162
M13 N_M13_d N_M13_g noxref_6 VDD pmos_rvt L=2e-08 W=8.1e-08 nfin=3 $X=0.449
+ $Y=0.162
M14 noxref_6 N_M14_g VDD VDD pmos_rvt L=2e-08 W=8.1e-08 nfin=3 $X=0.503 $Y=0.162
M15 VDD N_M15_g noxref_6 VDD pmos_rvt L=2e-08 W=8.1e-08 nfin=3 $X=0.557 $Y=0.162

* .include "XOR2x1_ASAP7_75t_R.pex.sp.pxi"

* Start of included file XOR2x1_ASAP7_75t_R.pex.sp.pxi
x_PM_XOR2x1_ASAP7_75t_R%5 vss N_M4_g N_M12_g N_M5_g N_M13_g N_M9_d N_M0_d
+ N_M1_s N_5_11 N_5_1 N_5_18 N_5_4 N_5_20 N_5_19 N_5_16 N_5_3 N_5_10 N_5_9
+ N_5_12 N_5_14 N_5_15 PM_XOR2x1_ASAP7_75t_R%5
cc_1 N_5_11 N_A_18 0.000160761f $X=0.0935 $Y=0.0675
cc_2 N_5_11 N_A_1 0.00112622f $X=0.0935 $Y=0.0675
cc_3 N_5_11 N_A_22 0.00026318f $X=0.0935 $Y=0.0675
cc_4 N_5_11 N_A_20 0.000335717f $X=0.0935 $Y=0.0675
cc_5 N_5_1 N_A_23 0.000361299f $X=0.3955 $Y=0.135
cc_6 N_5_1 N_A_3 0.00039407f $X=0.3955 $Y=0.135
cc_7 N_5_18 N_A_21 0.000438309f $X=0.183 $Y=0.1035
cc_8 N_5_4 N_A_12 0.0004651f $X=0.175 $Y=0.2025
cc_9 N_5_20 N_A_25 0.000489054f $X=0.405 $Y=0.135
cc_10 N_5_19 N_A_14 0.000510249f $X=0.3805 $Y=0.072
cc_11 N_5_1 N_A_2 0.00173979f $X=0.3955 $Y=0.135
cc_12 N_5_16 N_A_16 0.000838083f $X=0.159 $Y=0.036
cc_13 N_5_3 N_A_7 0.00094974f $X=0.108 $Y=0.0675
cc_14 N_5_19 N_A_23 0.00198254f $X=0.3805 $Y=0.072
cc_15 N_5_20 N_A_23 0.00225339f $X=0.405 $Y=0.135
cc_16 N_5_18 N_A_12 0.002721f $X=0.183 $Y=0.1035
cc_17 N_5_10 N_A_9 0.00335626f $X=0.459 $Y=0.135
cc_18 N_5_9 N_A_8 0.00343721f $X=0.405 $Y=0.0245
cc_19 N_5_4 N_A_19 0.0038005f $X=0.175 $Y=0.2025
cc_20 N_5_11 N_A_7 0.0351056f $X=0.0935 $Y=0.0675
cc_21 N_5_12 N_B_12 0.000293197f $X=0.1475 $Y=0.2025
cc_22 N_5_12 N_B_8 0.000728404f $X=0.1475 $Y=0.2025
cc_23 N_5_16 N_B_8 0.00504246f $X=0.159 $Y=0.036
cc_24 N_5_4 N_B_1 0.00554015f $X=0.175 $Y=0.2025
cc_25 N_5_20 N_B_12 0.000648031f $X=0.405 $Y=0.135
cc_26 N_5_14 N_B_8 0.000661472f $X=0.1835 $Y=0.072
cc_27 N_5_3 N_B_1 0.000840914f $X=0.108 $Y=0.0675
cc_28 N_5_3 N_B_5 0.00146324f $X=0.108 $Y=0.0675
cc_29 N_5_4 N_B_5 0.00250938f $X=0.175 $Y=0.2025
cc_30 N_5_11 N_B_5 0.0146078f $X=0.0935 $Y=0.0675
cc_31 N_5_18 N_B_10 0.00537305f $X=0.183 $Y=0.1035
cc_32 N_5_19 N_B_12 0.00746051f $X=0.3805 $Y=0.072
cc_33 N_5_12 N_B_5 0.0549547f $X=0.1475 $Y=0.2025
x_PM_XOR2x1_ASAP7_75t_R%Y vss Y N_M2_d N_M4_d N_M5_d N_M7_d N_M12_d N_M13_d
+ N_Y_20 N_Y_17 N_Y_15 N_Y_1 N_Y_4 N_Y_13 N_Y_19 N_Y_21 N_Y_14 N_Y_16 N_Y_3
+ N_Y_2 PM_XOR2x1_ASAP7_75t_R%Y
cc_34 N_Y_20 N_A_2 0.000414191f $X=0.459 $Y=0.054
cc_35 N_Y_20 N_A_3 0.000603551f $X=0.459 $Y=0.054
cc_36 N_Y_20 N_A_9 0.000196491f $X=0.459 $Y=0.054
cc_37 N_Y_20 N_A_23 0.000475032f $X=0.459 $Y=0.054
cc_38 N_Y_20 N_A_8 0.000388608f $X=0.459 $Y=0.054
cc_39 N_Y_17 N_A_24 0.000624573f $X=0.459 $Y=0.184
cc_40 N_Y_17 N_A_25 0.0019479f $X=0.459 $Y=0.184
cc_41 N_Y_20 N_A_24 0.00480483f $X=0.459 $Y=0.054
cc_42 N_Y_15 N_B_9 0.000589956f $X=0.5795 $Y=0.0675
cc_43 N_Y_15 N_B_2 0.00123929f $X=0.5795 $Y=0.0675
cc_44 N_Y_15 N_B_6 0.000422421f $X=0.5795 $Y=0.0675
cc_45 N_Y_15 N_B_11 0.000722663f $X=0.5795 $Y=0.0675
cc_46 N_Y_20 N_B_12 0.00146185f $X=0.459 $Y=0.054
cc_47 N_Y_1 N_B_6 0.00163624f $X=0.27 $Y=0.0675
cc_48 N_Y_4 N_B_7 0.00175559f $X=0.594 $Y=0.0675
cc_49 N_Y_13 N_B_1 0.00216042f $X=0.272 $Y=0.0675
cc_50 N_Y_19 N_B_12 0.0041419f $X=0.2585 $Y=0.036
cc_51 N_Y_21 N_B_9 0.00613399f $X=0.486 $Y=0.036
cc_52 N_Y_13 N_B_6 0.0340056f $X=0.272 $Y=0.0675
cc_53 N_Y_15 N_B_7 0.0345525f $X=0.5795 $Y=0.0675
cc_54 N_Y_14 N_5_19 0.000589977f $X=0.4175 $Y=0.0675
cc_55 N_Y_14 N_5_1 0.00562686f $X=0.4175 $Y=0.0675
cc_56 N_Y_14 N_5_10 0.0374582f $X=0.4175 $Y=0.0675
cc_57 N_Y_16 N_5_9 0.0294765f $X=0.4175 $Y=0.2025
cc_58 N_Y_1 N_5_19 0.00115161f $X=0.27 $Y=0.0675
cc_59 N_Y_3 N_5_9 0.00143339f $X=0.432 $Y=0.2025
cc_60 N_Y_19 N_5_15 0.00151163f $X=0.2585 $Y=0.036
cc_61 N_Y_2 N_5_9 0.0018976f $X=0.432 $Y=0.0675
cc_62 N_Y_20 N_5_20 0.00387703f $X=0.459 $Y=0.054
cc_63 N_Y_19 N_5_19 0.0108475f $X=0.2585 $Y=0.036
cc_64 N_Y_14 N_5_9 0.0670536f $X=0.4175 $Y=0.0675
x_PM_XOR2x1_ASAP7_75t_R%A vss A N_M0_g N_M8_g N_M6_g N_M14_g N_M3_g N_M11_g
+ N_A_9 N_A_2 N_A_17 N_A_1 N_A_24 N_A_22 N_A_18 N_A_23 N_A_16 N_A_14 N_A_21
+ N_A_19 N_A_3 N_A_25 N_A_12 N_A_8 N_A_7 N_A_20 PM_XOR2x1_ASAP7_75t_R%A
x_PM_XOR2x1_ASAP7_75t_R%B vss B N_M2_g N_M10_g N_M1_g N_M9_g N_M7_g N_M15_g
+ N_B_1 N_B_8 N_B_10 N_B_11 N_B_9 N_B_2 N_B_12 N_B_6 N_B_5 N_B_7
+ PM_XOR2x1_ASAP7_75t_R%B
cc_65 N_B_1 N_A_9 0.000128381f $X=0.297 $Y=0.135
cc_66 N_B_8 N_A_9 0.000134429f $X=0.135 $Y=0.072
cc_67 N_B_1 N_A_2 0.000807347f $X=0.297 $Y=0.135
cc_68 N_B_10 N_A_17 0.000184597f $X=0.135 $Y=0.1265
cc_69 N_B_1 N_A_1 0.00158272f $X=0.297 $Y=0.135
cc_70 N_B_11 N_A_24 0.00298209f $X=0.567 $Y=0.0855
cc_71 N_B_1 N_A_22 0.000339273f $X=0.297 $Y=0.135
cc_72 N_B_8 N_A_18 0.000379945f $X=0.135 $Y=0.072
cc_73 N_B_9 N_A_24 0.00038486f $X=0.567 $Y=0.072
cc_74 N_B_1 N_A_23 0.0004219f $X=0.297 $Y=0.135
cc_75 N_B_8 N_A_16 0.000435453f $X=0.135 $Y=0.072
cc_76 N_B_1 N_A_14 0.000484631f $X=0.297 $Y=0.135
cc_77 N_B_1 N_A_21 0.000514815f $X=0.297 $Y=0.135
cc_78 N_B_10 N_A_19 0.00061454f $X=0.135 $Y=0.1265
cc_79 N_B_2 N_A_3 0.00218837f $X=0.567 $Y=0.135
cc_80 N_B_10 N_A_18 0.00161511f $X=0.135 $Y=0.1265
cc_81 N_B_12 N_A_25 0.00215205f $X=0.1235 $Y=0.081
cc_82 N_B_1 N_A_12 0.00224264f $X=0.297 $Y=0.135
cc_83 N_B_12 N_A_14 0.00389896f $X=0.1235 $Y=0.081
cc_84 N_B_6 N_A_8 0.00489556f $X=0.297 $Y=0.0245
cc_85 N_B_5 N_A_7 0.00497672f $X=0.135 $Y=0.135
cc_86 N_B_7 N_A_9 0.00548301f $X=0.567 $Y=0.135
x_PM_XOR2x1_ASAP7_75t_R%10 vss N_M8_d N_M9_s N_10_1 PM_XOR2x1_ASAP7_75t_R%10
cc_87 N_10_1 N_A_7 0.0167478f $X=0.108 $Y=0.2025
cc_88 N_10_1 N_B_5 0.0166373f $X=0.108 $Y=0.2025

* End of included file XOR2x1_ASAP7_75t_R.pex.sp.pxi
.ends

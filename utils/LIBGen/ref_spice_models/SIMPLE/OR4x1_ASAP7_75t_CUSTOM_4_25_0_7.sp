.subckt PM_OR4x1_ASAP7_75t_R%9 vss 2 3 1
c1 1 vss 0.000781511f $X=0.162 $Y=0.2025
r1 2 1 0.209877 $w=8.1e-08 $l=1.7e-08 $layer=P_src_drn $thickness=1e-09
+ $X=0.1446 $Y=0.2025 $X2=0.162 $Y2=0.2025
r2 3 1 0.209877 $w=8.1e-08 $l=1.7e-08 $layer=P_src_drn $thickness=1e-09
+ $X=0.1793 $Y=0.2025 $X2=0.162 $Y2=0.2025
.ends

.subckt PM_OR4x1_ASAP7_75t_R%D vss 13 5 9 3 1 4
c1 1 vss 0.00419767f $X=0.135 $Y=0.135
c2 3 vss 0.0854388f $X=0.135 $Y=0.0245
c3 4 vss 0.012472f $X=0.135 $Y=0.116
r1 13 4 4.43061 $w=1.3e-08 $l=1.9e-08 $layer=M1 $thickness=3.6e-08 $X=0.135
+ $Y=0.132 $X2=0.135 $Y2=0.116
r2 1 7 7.07951 $w=1.89474e-08 $layer=LIG $thickness=5.17895e-08 $X=0.135
+ $Y=0.135 $X2=0.135 $Y2=0.135
r3 13 1 19.3796 $a=3.24e-16 $layer=V0LIG $X=0.135 $Y=0.132 $X2=0.135 $Y2=0.135
r4 9 8 16.8368 $w=2.1e-08 $l=4.95e-08 $layer=Gate_1 $thickness=5.6e-08 $X=0.135
+ $Y=0.2025 $X2=0.135 $Y2=0.153
r5 7 8 6.27555 $w=2.05e-08 $l=1.8e-08 $layer=Gate_1 $thickness=5.6e-08 $X=0.135
+ $Y=0.135 $X2=0.135 $Y2=0.153
r6 6 7 6.27555 $w=2.05e-08 $l=1.8e-08 $layer=Gate_1 $thickness=5.6e-08 $X=0.135
+ $Y=0.117 $X2=0.135 $Y2=0.135
r7 5 6 16.8368 $w=2.1e-08 $l=4.95e-08 $layer=Gate_1 $thickness=5.6e-08 $X=0.135
+ $Y=0.0675 $X2=0.135 $Y2=0.117
r8 5 3 14.6259 $w=2.1e-08 $l=4.3e-08 $layer=Gate_1 $thickness=5.6e-08 $X=0.135
+ $Y=0.0675 $X2=0.135 $Y2=0.0245
.ends

.subckt PM_OR4x1_ASAP7_75t_R%11 vss 2 3 1
c1 1 vss 0.000729011f $X=0.27 $Y=0.2025
r1 2 1 0.209877 $w=8.1e-08 $l=1.7e-08 $layer=P_src_drn $thickness=1e-09
+ $X=0.2526 $Y=0.2025 $X2=0.27 $Y2=0.2025
r2 3 1 0.209877 $w=8.1e-08 $l=1.7e-08 $layer=P_src_drn $thickness=1e-09
+ $X=0.2873 $Y=0.2025 $X2=0.27 $Y2=0.2025
.ends

.subckt PM_OR4x1_ASAP7_75t_R%B vss 13 5 9 3 1 4
c1 1 vss 0.00295828f $X=0.243 $Y=0.135
c2 3 vss 0.0474467f $X=0.243 $Y=0.0245
c3 4 vss 0.0119393f $X=0.243 $Y=0.098
r1 13 4 8.62802 $w=1.3e-08 $l=3.7e-08 $layer=M1 $thickness=3.6e-08 $X=0.243
+ $Y=0.132 $X2=0.243 $Y2=0.098
r2 1 7 6.74717 $w=2e-08 $layer=Gate_1 $thickness=5.2e-08 $X=0.243 $Y=0.135
+ $X2=0.243 $Y2=0.135
r3 13 1 19.3796 $a=3.24e-16 $layer=V0LIG $X=0.243 $Y=0.132 $X2=0.243 $Y2=0.135
r4 9 8 16.6668 $w=2.1e-08 $l=4.9e-08 $layer=Gate_1 $thickness=5.6e-08 $X=0.243
+ $Y=0.2025 $X2=0.243 $Y2=0.1535
r5 7 8 6.46262 $w=2.04595e-08 $l=1.85e-08 $layer=Gate_1 $thickness=5.6e-08
+ $X=0.243 $Y=0.135 $X2=0.243 $Y2=0.1535
r6 6 7 6.46262 $w=2.04595e-08 $l=1.85e-08 $layer=Gate_1 $thickness=5.6e-08
+ $X=0.243 $Y=0.1165 $X2=0.243 $Y2=0.135
r7 5 6 16.6668 $w=2.1e-08 $l=4.9e-08 $layer=Gate_1 $thickness=5.6e-08 $X=0.243
+ $Y=0.0675 $X2=0.243 $Y2=0.1165
r8 5 3 14.6259 $w=2.1e-08 $l=4.3e-08 $layer=Gate_1 $thickness=5.6e-08 $X=0.243
+ $Y=0.0675 $X2=0.243 $Y2=0.0245
.ends

.subckt PM_OR4x1_ASAP7_75t_R%A vss 15 5 11 3 4 1
c1 1 vss 0.00279259f $X=0.297 $Y=0.135
c2 3 vss 0.05332f $X=0.297 $Y=0.0245
c3 4 vss 0.00704274f $X=0.297 $Y=0.098
r1 15 4 8.62802 $w=1.3e-08 $l=3.7e-08 $layer=M1 $thickness=3.6e-08 $X=0.297
+ $Y=0.132 $X2=0.297 $Y2=0.098
r2 1 8 7.07951 $w=1.89474e-08 $layer=LIG $thickness=5.17895e-08 $X=0.297
+ $Y=0.135 $X2=0.297 $Y2=0.135
r3 15 1 19.3796 $a=3.24e-16 $layer=V0LIG $X=0.297 $Y=0.132 $X2=0.297 $Y2=0.135
r4 11 10 14.6259 $w=2.1e-08 $l=4.3e-08 $layer=Gate_1 $thickness=5.6e-08
+ $X=0.297 $Y=0.2025 $X2=0.297 $Y2=0.1595
r5 9 10 3.06124 $w=2.1e-08 $l=9e-09 $layer=Gate_1 $thickness=5.6e-08 $X=0.297
+ $Y=0.1505 $X2=0.297 $Y2=0.1595
r6 8 9 5.4252 $w=2.04194e-08 $l=1.55e-08 $layer=Gate_1 $thickness=5.6e-08
+ $X=0.297 $Y=0.135 $X2=0.297 $Y2=0.1505
r7 7 8 5.4252 $w=2.04194e-08 $l=1.55e-08 $layer=Gate_1 $thickness=5.6e-08
+ $X=0.297 $Y=0.1195 $X2=0.297 $Y2=0.135
r8 6 7 3.06124 $w=2.1e-08 $l=9e-09 $layer=Gate_1 $thickness=5.6e-08 $X=0.297
+ $Y=0.1105 $X2=0.297 $Y2=0.1195
r9 5 6 14.6259 $w=2.1e-08 $l=4.3e-08 $layer=Gate_1 $thickness=5.6e-08 $X=0.297
+ $Y=0.0675 $X2=0.297 $Y2=0.1105
r10 5 3 14.6259 $w=2.1e-08 $l=4.3e-08 $layer=Gate_1 $thickness=5.6e-08 $X=0.297
+ $Y=0.0675 $X2=0.297 $Y2=0.0245
.ends

.subckt PM_OR4x1_ASAP7_75t_R%3 vss 24 30 54 55 58 59 67 1 16 3 13 12 20 22 4 14
+ 18 5 15 23 17
c1 1 vss 0.00352584f $X=0.081 $Y=0.135
c2 3 vss 0.00859612f $X=0.162 $Y=0.0675
c3 4 vss 0.00871547f $X=0.27 $Y=0.0675
c4 5 vss 0.00684038f $X=0.324 $Y=0.2025
c5 12 vss 0.0810785f $X=0.081 $Y=0.0245
c6 13 vss 0.00502286f $X=0.1475 $Y=0.0675
c7 14 vss 0.00506899f $X=0.2555 $Y=0.0675
c8 15 vss 0.0376538f $X=0.3095 $Y=0.2025
c9 16 vss 0.00132621f $X=0.081 $Y=0.075
c10 17 vss 0.00283493f $X=0.108 $Y=0.036
c11 18 vss 0.0059155f $X=0.351 $Y=0.234
c12 19 vss 0.00311659f $X=0.351 $Y=0.036
c13 20 vss 0.00130841f $X=0.081 $Y=0.116
c14 21 vss 0.000769942f $X=0.108 $Y=0.0555
c15 22 vss 0.0199968f $X=0.1215 $Y=0.036
c16 23 vss 0.0070699f $X=0.351 $Y=0.0555
r1 15 5 0.154321 $w=8.1e-08 $l=1.25e-08 $layer=P_src_drn $thickness=1e-09
+ $X=0.3095 $Y=0.2025 $X2=0.324 $Y2=0.2025
r2 67 15 0.0308642 $w=8.1e-08 $l=2.5e-09 $layer=P_src_drn $thickness=1e-09
+ $X=0.3066 $Y=0.2025 $X2=0.3095 $Y2=0.2025
r3 5 64 19.3796 $a=3.24e-16 $layer=V0LISD $X=0.324 $Y=0.2025 $X2=0.324 $Y2=0.234
r4 64 65 3.14806 $w=1.3e-08 $l=1.35e-08 $layer=M1 $thickness=3.6e-08 $X=0.324
+ $Y=0.234 $X2=0.3375 $Y2=0.234
r5 18 62 3.83327 $w=1.5093e-08 $l=2.15e-08 $layer=M1 $thickness=3.6e-08
+ $X=0.351 $Y=0.234 $X2=0.351 $Y2=0.2125
r6 18 65 1.96775 $w=1.63333e-08 $l=1.35e-08 $layer=M1 $thickness=3.6e-08
+ $X=0.351 $Y=0.234 $X2=0.3375 $Y2=0.234
r7 61 62 18.0722 $w=1.3e-08 $l=7.75e-08 $layer=M1 $thickness=3.6e-08 $X=0.351
+ $Y=0.135 $X2=0.351 $Y2=0.2125
r8 60 61 15.6237 $w=1.3e-08 $l=6.7e-08 $layer=M1 $thickness=3.6e-08 $X=0.351
+ $Y=0.068 $X2=0.351 $Y2=0.135
r9 23 60 2.91487 $w=1.3e-08 $l=1.25e-08 $layer=M1 $thickness=3.6e-08 $X=0.351
+ $Y=0.0555 $X2=0.351 $Y2=0.068
r10 59 57 0.0308642 $w=8.1e-08 $l=2.5e-09 $layer=N_src_drn $thickness=1e-09
+ $X=0.2873 $Y=0.0675 $X2=0.2845 $Y2=0.0675
r11 4 57 0.179012 $w=8.1e-08 $l=1.45e-08 $layer=N_src_drn $thickness=1e-09
+ $X=0.27 $Y=0.0675 $X2=0.2845 $Y2=0.0675
r12 14 4 0.179012 $w=8.1e-08 $l=1.45e-08 $layer=N_src_drn $thickness=1e-09
+ $X=0.2555 $Y=0.0675 $X2=0.27 $Y2=0.0675
r13 58 14 0.0308642 $w=8.1e-08 $l=2.5e-09 $layer=N_src_drn $thickness=1e-09
+ $X=0.2526 $Y=0.0675 $X2=0.2555 $Y2=0.0675
r14 55 53 0.0308642 $w=8.1e-08 $l=2.5e-09 $layer=N_src_drn $thickness=1e-09
+ $X=0.1793 $Y=0.0675 $X2=0.1765 $Y2=0.0675
r15 3 53 0.179012 $w=8.1e-08 $l=1.45e-08 $layer=N_src_drn $thickness=1e-09
+ $X=0.162 $Y=0.0675 $X2=0.1765 $Y2=0.0675
r16 13 3 0.179012 $w=8.1e-08 $l=1.45e-08 $layer=N_src_drn $thickness=1e-09
+ $X=0.1475 $Y=0.0675 $X2=0.162 $Y2=0.0675
r17 54 13 0.0308642 $w=8.1e-08 $l=2.5e-09 $layer=N_src_drn $thickness=1e-09
+ $X=0.1446 $Y=0.0675 $X2=0.1475 $Y2=0.0675
r18 19 51 4.18063 $w=1.48e-08 $l=2.5e-08 $layer=M1 $thickness=3.6e-08 $X=0.351
+ $Y=0.036 $X2=0.326 $Y2=0.036
r19 19 23 2.89809 $w=1.75231e-08 $l=1.95e-08 $layer=M1 $thickness=3.6e-08
+ $X=0.351 $Y=0.036 $X2=0.351 $Y2=0.0555
r20 4 47 19.3796 $a=3.24e-16 $layer=V0LISD $X=0.27 $Y=0.0675 $X2=0.27 $Y2=0.036
r21 3 41 19.3796 $a=3.24e-16 $layer=V0LISD $X=0.162 $Y=0.0675 $X2=0.162
+ $Y2=0.036
r22 50 51 4.19742 $w=1.3e-08 $l=1.8e-08 $layer=M1 $thickness=3.6e-08 $X=0.308
+ $Y=0.036 $X2=0.326 $Y2=0.036
r23 49 50 2.56509 $w=1.3e-08 $l=1.1e-08 $layer=M1 $thickness=3.6e-08 $X=0.297
+ $Y=0.036 $X2=0.308 $Y2=0.036
r24 48 49 3.14806 $w=1.3e-08 $l=1.35e-08 $layer=M1 $thickness=3.6e-08 $X=0.2835
+ $Y=0.036 $X2=0.297 $Y2=0.036
r25 47 48 3.14806 $w=1.3e-08 $l=1.35e-08 $layer=M1 $thickness=3.6e-08 $X=0.27
+ $Y=0.036 $X2=0.2835 $Y2=0.036
r26 46 47 3.14806 $w=1.3e-08 $l=1.35e-08 $layer=M1 $thickness=3.6e-08 $X=0.2565
+ $Y=0.036 $X2=0.27 $Y2=0.036
r27 45 46 3.14806 $w=1.3e-08 $l=1.35e-08 $layer=M1 $thickness=3.6e-08 $X=0.243
+ $Y=0.036 $X2=0.2565 $Y2=0.036
r28 44 45 6.29612 $w=1.3e-08 $l=2.7e-08 $layer=M1 $thickness=3.6e-08 $X=0.216
+ $Y=0.036 $X2=0.243 $Y2=0.036
r29 43 44 6.29612 $w=1.3e-08 $l=2.7e-08 $layer=M1 $thickness=3.6e-08 $X=0.189
+ $Y=0.036 $X2=0.216 $Y2=0.036
r30 42 43 3.14806 $w=1.3e-08 $l=1.35e-08 $layer=M1 $thickness=3.6e-08 $X=0.1755
+ $Y=0.036 $X2=0.189 $Y2=0.036
r31 41 42 3.14806 $w=1.3e-08 $l=1.35e-08 $layer=M1 $thickness=3.6e-08 $X=0.162
+ $Y=0.036 $X2=0.1755 $Y2=0.036
r32 40 41 3.14806 $w=1.3e-08 $l=1.35e-08 $layer=M1 $thickness=3.6e-08 $X=0.1485
+ $Y=0.036 $X2=0.162 $Y2=0.036
r33 39 40 3.14806 $w=1.3e-08 $l=1.35e-08 $layer=M1 $thickness=3.6e-08 $X=0.135
+ $Y=0.036 $X2=0.1485 $Y2=0.036
r34 22 39 3.14806 $w=1.3e-08 $l=1.35e-08 $layer=M1 $thickness=3.6e-08 $X=0.1215
+ $Y=0.036 $X2=0.135 $Y2=0.036
r35 17 21 2.89809 $w=1.75231e-08 $l=1.95e-08 $layer=M1 $thickness=3.6e-08
+ $X=0.108 $Y=0.036 $X2=0.108 $Y2=0.0555
r36 17 22 1.49895 $w=1.63333e-08 $l=1.35e-08 $layer=M1 $thickness=3.6e-08
+ $X=0.108 $Y=0.036 $X2=0.1215 $Y2=0.036
r37 21 38 3.36689 $w=1.53077e-08 $l=1.95e-08 $layer=M1 $thickness=3.6e-08
+ $X=0.108 $Y=0.0555 $X2=0.108 $Y2=0.075
r38 37 38 1.96775 $w=1.63333e-08 $l=1.35e-08 $layer=M1 $thickness=3.6e-08
+ $X=0.0945 $Y=0.075 $X2=0.108 $Y2=0.075
r39 16 36 3.48349 $w=1.525e-08 $l=2e-08 $layer=M1 $thickness=3.6e-08 $X=0.081
+ $Y=0.075 $X2=0.081 $Y2=0.095
r40 16 37 1.96775 $w=1.63333e-08 $l=1.35e-08 $layer=M1 $thickness=3.6e-08
+ $X=0.081 $Y=0.075 $X2=0.0945 $Y2=0.075
r41 20 34 4.43061 $w=1.3e-08 $l=1.9e-08 $layer=M1 $thickness=3.6e-08 $X=0.081
+ $Y=0.116 $X2=0.081 $Y2=0.135
r42 20 36 4.89699 $w=1.3e-08 $l=2.1e-08 $layer=M1 $thickness=3.6e-08 $X=0.081
+ $Y=0.116 $X2=0.081 $Y2=0.095
r43 1 27 7.07951 $w=1.89474e-08 $layer=LIG $thickness=5.17895e-08 $X=0.081
+ $Y=0.135 $X2=0.081 $Y2=0.135
r44 1 34 19.3796 $a=3.24e-16 $layer=V0LIG $X=0.081 $Y=0.135 $X2=0.081 $Y2=0.135
r45 30 29 14.6259 $w=2.1e-08 $l=4.3e-08 $layer=Gate_1 $thickness=5.6e-08
+ $X=0.081 $Y=0.2025 $X2=0.081 $Y2=0.1595
r46 28 29 3.06124 $w=2.1e-08 $l=9e-09 $layer=Gate_1 $thickness=5.6e-08 $X=0.081
+ $Y=0.1505 $X2=0.081 $Y2=0.1595
r47 27 28 5.4252 $w=2.04194e-08 $l=1.55e-08 $layer=Gate_1 $thickness=5.6e-08
+ $X=0.081 $Y=0.135 $X2=0.081 $Y2=0.1505
r48 26 27 5.4252 $w=2.04194e-08 $l=1.55e-08 $layer=Gate_1 $thickness=5.6e-08
+ $X=0.081 $Y=0.1195 $X2=0.081 $Y2=0.135
r49 25 26 3.06124 $w=2.1e-08 $l=9e-09 $layer=Gate_1 $thickness=5.6e-08 $X=0.081
+ $Y=0.1105 $X2=0.081 $Y2=0.1195
r50 24 25 14.6259 $w=2.1e-08 $l=4.3e-08 $layer=Gate_1 $thickness=5.6e-08
+ $X=0.081 $Y=0.0675 $X2=0.081 $Y2=0.1105
r51 24 12 14.6259 $w=2.1e-08 $l=4.3e-08 $layer=Gate_1 $thickness=5.6e-08
+ $X=0.081 $Y=0.0675 $X2=0.081 $Y2=0.0245
.ends

.subckt PM_OR4x1_ASAP7_75t_R%Y vss 19 13 26 7 11 8
c1 7 vss 0.0468997f $X=0.056 $Y=0.0675
c2 8 vss 0.0484338f $X=0.056 $Y=0.2025
c3 9 vss 0.00569229f $X=0.0405 $Y=0.036
c4 10 vss 0.00637718f $X=0.027 $Y=0.234
c5 11 vss 0.00594228f $X=0.027 $Y=0.0555
r1 26 25 0.0308642 $w=8.1e-08 $l=2.5e-09 $layer=P_src_drn $thickness=1e-09
+ $X=0.0713 $Y=0.2025 $X2=0.0685 $Y2=0.2025
r2 8 25 0.154321 $w=8.1e-08 $l=1.25e-08 $layer=P_src_drn $thickness=1e-09
+ $X=0.056 $Y=0.2025 $X2=0.0685 $Y2=0.2025
r3 8 23 19.3796 $a=3.24e-16 $layer=V0LISD $X=0.056 $Y=0.2025 $X2=0.054 $Y2=0.234
r4 22 23 3.14806 $w=1.3e-08 $l=1.35e-08 $layer=M1 $thickness=3.6e-08 $X=0.0405
+ $Y=0.234 $X2=0.054 $Y2=0.234
r5 10 21 9.42983 $w=1.3989e-08 $l=4.55e-08 $layer=M1 $thickness=3.6e-08
+ $X=0.027 $Y=0.234 $X2=0.027 $Y2=0.1885
r6 10 22 1.96775 $w=1.63333e-08 $l=1.35e-08 $layer=M1 $thickness=3.6e-08
+ $X=0.027 $Y=0.234 $X2=0.0405 $Y2=0.234
r7 20 21 10.785 $w=1.3e-08 $l=4.63e-08 $layer=M1 $thickness=3.6e-08 $X=0.027
+ $Y=0.1422 $X2=0.027 $Y2=0.1885
r8 19 20 2.3902 $w=1.3e-08 $l=1.02e-08 $layer=M1 $thickness=3.6e-08 $X=0.028
+ $Y=0.132 $X2=0.027 $Y2=0.1422
r9 19 18 5.65485 $w=1.3e-08 $l=2.43e-08 $layer=M1 $thickness=3.6e-08 $X=0.028
+ $Y=0.132 $X2=0.027 $Y2=0.1077
r10 17 18 7.63697 $w=1.3e-08 $l=3.27e-08 $layer=M1 $thickness=3.6e-08 $X=0.027
+ $Y=0.075 $X2=0.027 $Y2=0.1077
r11 11 16 3.36689 $w=1.53077e-08 $l=1.95e-08 $layer=M1 $thickness=3.6e-08
+ $X=0.027 $Y=0.0555 $X2=0.027 $Y2=0.036
r12 11 17 4.5472 $w=1.3e-08 $l=1.95e-08 $layer=M1 $thickness=3.6e-08 $X=0.027
+ $Y=0.0555 $X2=0.027 $Y2=0.075
r13 9 14 3.14806 $w=1.3e-08 $l=1.35e-08 $layer=M1 $thickness=3.6e-08 $X=0.0405
+ $Y=0.036 $X2=0.054 $Y2=0.036
r14 9 16 1.96775 $w=1.63333e-08 $l=1.35e-08 $layer=M1 $thickness=3.6e-08
+ $X=0.0405 $Y=0.036 $X2=0.027 $Y2=0.036
r15 7 14 19.3796 $a=3.24e-16 $layer=V0LISD $X=0.056 $Y=0.0675 $X2=0.054
+ $Y2=0.036
r16 13 12 0.0308642 $w=8.1e-08 $l=2.5e-09 $layer=N_src_drn $thickness=1e-09
+ $X=0.0713 $Y=0.0675 $X2=0.0685 $Y2=0.0675
r17 7 12 0.154321 $w=8.1e-08 $l=1.25e-08 $layer=N_src_drn $thickness=1e-09
+ $X=0.056 $Y=0.0675 $X2=0.0685 $Y2=0.0675
.ends

.subckt PM_OR4x1_ASAP7_75t_R%10 vss 2 3 1
c1 1 vss 0.000699162f $X=0.216 $Y=0.2025
r1 2 1 0.209877 $w=8.1e-08 $l=1.7e-08 $layer=P_src_drn $thickness=1e-09
+ $X=0.1986 $Y=0.2025 $X2=0.216 $Y2=0.2025
r2 3 1 0.209877 $w=8.1e-08 $l=1.7e-08 $layer=P_src_drn $thickness=1e-09
+ $X=0.2333 $Y=0.2025 $X2=0.216 $Y2=0.2025
.ends

.subckt PM_OR4x1_ASAP7_75t_R%C vss 15 5 9 1 3 4
c1 1 vss 0.00286006f $X=0.189 $Y=0.135
c2 3 vss 0.0473371f $X=0.189 $Y=0.0245
c3 4 vss 0.0125067f $X=0.189 $Y=0.095
r1 15 14 4.43061 $w=1.3e-08 $l=1.9e-08 $layer=M1 $thickness=3.6e-08 $X=0.189
+ $Y=0.132 $X2=0.189 $Y2=0.116
r2 4 14 4.89699 $w=1.3e-08 $l=2.1e-08 $layer=M1 $thickness=3.6e-08 $X=0.189
+ $Y=0.095 $X2=0.189 $Y2=0.116
r3 1 7 7.07951 $w=1.89474e-08 $layer=LIG $thickness=5.17895e-08 $X=0.189
+ $Y=0.135 $X2=0.189 $Y2=0.135
r4 15 1 19.3796 $a=3.24e-16 $layer=V0LIG $X=0.189 $Y=0.132 $X2=0.189 $Y2=0.135
r5 9 8 16.8368 $w=2.1e-08 $l=4.95e-08 $layer=Gate_1 $thickness=5.6e-08 $X=0.189
+ $Y=0.2025 $X2=0.189 $Y2=0.153
r6 7 8 6.27555 $w=2.05e-08 $l=1.8e-08 $layer=Gate_1 $thickness=5.6e-08 $X=0.189
+ $Y=0.135 $X2=0.189 $Y2=0.153
r7 6 7 6.27555 $w=2.05e-08 $l=1.8e-08 $layer=Gate_1 $thickness=5.6e-08 $X=0.189
+ $Y=0.117 $X2=0.189 $Y2=0.135
r8 5 6 16.8368 $w=2.1e-08 $l=4.95e-08 $layer=Gate_1 $thickness=5.6e-08 $X=0.189
+ $Y=0.0675 $X2=0.189 $Y2=0.117
r9 5 3 14.6259 $w=2.1e-08 $l=4.3e-08 $layer=Gate_1 $thickness=5.6e-08 $X=0.189
+ $Y=0.0675 $X2=0.189 $Y2=0.0245
.ends

* End of included file OR4x1_ASAP7_75t_R.pex.sp.pex

*
.subckt OR4x1_ASAP7_75t_CUSTOM_4_25_0_7 VSS VDD D C B A Y
*
* VSS VSS
* VDD VDD
* D D
* C C
* B B
* A A
* Y Y
*
*

M0 VSS N_M0_g N_M0_s VSS nmos_rvt L=2e-08 W=8.1e-08 nfin=3 $X=0.071 $Y=0.027
M1 N_M1_d N_M1_g VSS VSS nmos_rvt L=2e-08 W=8.1e-08 nfin=3 $X=0.125 $Y=0.027
M2 VSS N_M2_g N_M2_s VSS nmos_rvt L=2e-08 W=8.1e-08 nfin=3 $X=0.179 $Y=0.027
M3 N_M3_d N_M3_g VSS VSS nmos_rvt L=2e-08 W=8.1e-08 nfin=3 $X=0.233 $Y=0.027
M4 VSS N_M4_g N_M4_s VSS nmos_rvt L=2e-08 W=8.1e-08 nfin=3 $X=0.287 $Y=0.027
M5 VDD N_M5_g N_M5_s VDD pmos_rvt L=2e-08 W=8.1e-08 nfin=3 $X=0.071 $Y=0.162
M6 N_M6_d N_M6_g VDD VDD pmos_rvt L=2e-08 W=8.1e-08 nfin=3 $X=0.125 $Y=0.162
M7 N_M7_d N_M7_g N_M7_s VDD pmos_rvt L=2e-08 W=8.1e-08 nfin=3 $X=0.179 $Y=0.162
M8 N_M8_d N_M8_g N_M8_s VDD pmos_rvt L=2e-08 W=8.1e-08 nfin=3 $X=0.233 $Y=0.162
M9 N_M9_d N_M9_g N_M9_s VDD pmos_rvt L=2e-08 W=8.1e-08 nfin=3 $X=0.287 $Y=0.162

* .include "OR4x1_ASAP7_75t_R.pex.sp.pxi"

* Start of included file OR4x1_ASAP7_75t_R.pex.sp.pxi
x_PM_OR4x1_ASAP7_75t_R%9 vss N_M6_d N_M7_s N_9_1 PM_OR4x1_ASAP7_75t_R%9
cc_1 N_9_1 N_D_3 0.0167737f $X=0.162 $Y=0.2025
cc_2 N_9_1 N_C_3 0.0169153f $X=0.162 $Y=0.2025
x_PM_OR4x1_ASAP7_75t_R%D vss D N_M1_g N_M6_g N_D_3 N_D_1 N_D_4
+ PM_OR4x1_ASAP7_75t_R%D
cc_3 N_D_3 N_3_1 0.000520048f $X=0.135 $Y=0.0245
cc_4 N_D_3 N_3_16 0.000585441f $X=0.135 $Y=0.0245
cc_5 N_D_1 N_3_3 0.000629452f $X=0.135 $Y=0.135
cc_6 N_D_3 N_3_3 0.000835785f $X=0.135 $Y=0.0245
cc_7 N_D_1 N_3_13 0.00121509f $X=0.135 $Y=0.135
cc_8 N_D_3 N_3_12 0.00166943f $X=0.135 $Y=0.0245
cc_9 N_D_4 N_3_20 0.00324689f $X=0.135 $Y=0.116
cc_10 N_D_3 N_3_13 0.0364796f $X=0.135 $Y=0.0245
x_PM_OR4x1_ASAP7_75t_R%11 vss N_M8_d N_M9_s N_11_1 PM_OR4x1_ASAP7_75t_R%11
cc_11 N_11_1 N_B_3 0.0169319f $X=0.27 $Y=0.2025
cc_12 N_11_1 N_A_3 0.016811f $X=0.27 $Y=0.2025
x_PM_OR4x1_ASAP7_75t_R%B vss B N_M3_g N_M8_g N_B_3 N_B_1 N_B_4
+ PM_OR4x1_ASAP7_75t_R%B
cc_13 N_B_3 N_3_4 0.00142444f $X=0.243 $Y=0.0245
cc_14 N_B_1 N_3_14 0.000733835f $X=0.243 $Y=0.135
cc_15 N_B_4 N_3_22 0.00111397f $X=0.243 $Y=0.098
cc_16 N_B_4 N_3_4 0.00233851f $X=0.243 $Y=0.098
cc_17 N_B_3 N_3_14 0.0354159f $X=0.243 $Y=0.0245
cc_18 N_B_1 N_C_1 0.00123721f $X=0.243 $Y=0.135
cc_19 N_B_3 N_C_3 0.00524602f $X=0.243 $Y=0.0245
cc_20 N_B_4 N_C_4 0.00715436f $X=0.243 $Y=0.098
x_PM_OR4x1_ASAP7_75t_R%A vss A N_M4_g N_M9_g N_A_3 N_A_4 N_A_1
+ PM_OR4x1_ASAP7_75t_R%A
cc_21 N_A_3 N_3_18 0.000471426f $X=0.297 $Y=0.0245
cc_22 N_A_3 N_3_5 0.00240047f $X=0.297 $Y=0.0245
cc_23 N_A_4 N_3_22 0.00104119f $X=0.297 $Y=0.098
cc_24 N_A_3 N_3_4 0.00112105f $X=0.297 $Y=0.0245
cc_25 N_A_1 N_3_15 0.00162229f $X=0.297 $Y=0.135
cc_26 N_A_3 N_3_14 0.0146541f $X=0.297 $Y=0.0245
cc_27 N_A_4 N_3_23 0.00775228f $X=0.297 $Y=0.098
cc_28 N_A_3 N_3_15 0.0548746f $X=0.297 $Y=0.0245
cc_29 N_A_4 N_B_1 0.00123829f $X=0.297 $Y=0.098
cc_30 N_A_3 N_B_3 0.00505045f $X=0.297 $Y=0.0245
cc_31 N_A_4 N_B_4 0.00602086f $X=0.297 $Y=0.098
x_PM_OR4x1_ASAP7_75t_R%3 vss N_M0_g N_M5_g N_M1_d N_M2_s N_M3_d N_M4_s N_M9_d
+ N_3_1 N_3_16 N_3_3 N_3_13 N_3_12 N_3_20 N_3_22 N_3_4 N_3_14 N_3_18 N_3_5
+ N_3_15 N_3_23 N_3_17 PM_OR4x1_ASAP7_75t_R%3
x_PM_OR4x1_ASAP7_75t_R%Y vss Y N_M0_s N_M5_s N_Y_7 N_Y_11 N_Y_8
+ PM_OR4x1_ASAP7_75t_R%Y
cc_32 N_Y_7 N_3_17 0.000394654f $X=0.056 $Y=0.0675
cc_33 N_Y_7 N_3_1 0.00239576f $X=0.056 $Y=0.0675
cc_34 N_Y_7 N_3_16 0.00223358f $X=0.056 $Y=0.0675
cc_35 N_Y_11 N_3_20 0.00431712f $X=0.027 $Y=0.0555
cc_36 N_Y_8 N_3_12 0.0148518f $X=0.056 $Y=0.2025
cc_37 N_Y_7 N_3_12 0.0571687f $X=0.056 $Y=0.0675
x_PM_OR4x1_ASAP7_75t_R%10 vss N_M7_d N_M8_s N_10_1 PM_OR4x1_ASAP7_75t_R%10
cc_38 N_10_1 N_C_3 0.0168601f $X=0.216 $Y=0.2025
cc_39 N_10_1 N_B_3 0.0168404f $X=0.216 $Y=0.2025
x_PM_OR4x1_ASAP7_75t_R%C vss C N_M2_g N_M7_g N_C_1 N_C_3 N_C_4
+ PM_OR4x1_ASAP7_75t_R%C
cc_40 N_C_1 N_3_13 0.000674803f $X=0.189 $Y=0.135
cc_41 N_C_3 N_3_3 0.00114616f $X=0.189 $Y=0.0245
cc_42 N_C_4 N_3_22 0.00117775f $X=0.189 $Y=0.095
cc_43 N_C_4 N_3_3 0.00223536f $X=0.189 $Y=0.095
cc_44 N_C_3 N_3_13 0.0353453f $X=0.189 $Y=0.0245
cc_45 N_C_1 N_D_4 0.00117889f $X=0.189 $Y=0.135
cc_46 N_C_3 N_D_3 0.00499003f $X=0.189 $Y=0.0245
cc_47 N_C_4 N_D_4 0.00614817f $X=0.189 $Y=0.095

* End of included file OR4x1_ASAP7_75t_R.pex.sp.pxi
.ends

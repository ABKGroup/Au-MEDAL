.subckt PM_TIELOx1_ASAP7_75t_R%L vss 24 14 31 7 10 1 11 6
c1 1 vss 0.00862998f $X=0.081 $Y=0.191
c2 3 vss 0.00754385f $X=0.108 $Y=0.054
c3 6 vss 0.0285293f $X=0.081 $Y=0.1685
c4 7 vss 0.0292793f $X=0.0935 $Y=0.054
c5 8 vss 0.00677817f $X=0.135 $Y=0.036
c6 9 vss 0.00208465f $X=0.135 $Y=0.191
c7 10 vss 0.00253615f $X=0.0675 $Y=0.191
c8 11 vss 0.00640639f $X=0.135 $Y=0.1485
r1 7 3 0.231482 $w=5.4e-08 $l=1.25e-08 $layer=N_src_drn $thickness=1e-09
+ $X=0.0935 $Y=0.054 $X2=0.108 $Y2=0.054
r2 31 7 0.0462963 $w=5.4e-08 $l=2.5e-09 $layer=N_src_drn $thickness=1e-09
+ $X=0.0906 $Y=0.054 $X2=0.0935 $Y2=0.054
r3 3 27 19.3796 $a=3.24e-16 $layer=V0LISD $X=0.108 $Y=0.054 $X2=0.108 $Y2=0.036
r4 27 28 3.14806 $w=1.3e-08 $l=1.35e-08 $layer=M1 $thickness=3.6e-08 $X=0.108
+ $Y=0.036 $X2=0.1215 $Y2=0.036
r5 8 23 4.53284 $w=1.48367e-08 $l=2.45e-08 $layer=M1 $thickness=3.6e-08
+ $X=0.135 $Y=0.036 $X2=0.135 $Y2=0.0605
r6 8 28 1.96775 $w=1.63333e-08 $l=1.35e-08 $layer=M1 $thickness=3.6e-08
+ $X=0.135 $Y=0.036 $X2=0.1215 $Y2=0.036
r7 24 25 2.44849 $w=1.3e-08 $l=1.05e-08 $layer=M1 $thickness=3.6e-08 $X=0.137
+ $Y=0.0765 $X2=0.135 $Y2=0.087
r8 24 23 3.73104 $w=1.3e-08 $l=1.6e-08 $layer=M1 $thickness=3.6e-08 $X=0.137
+ $Y=0.0765 $X2=0.135 $Y2=0.0605
r9 22 25 4.43061 $w=1.3e-08 $l=1.9e-08 $layer=M1 $thickness=3.6e-08 $X=0.135
+ $Y=0.106 $X2=0.135 $Y2=0.087
r10 11 22 9.91056 $w=1.3e-08 $l=4.25e-08 $layer=M1 $thickness=3.6e-08 $X=0.135
+ $Y=0.1485 $X2=0.135 $Y2=0.106
r11 9 21 4.06404 $w=1.48367e-08 $l=2.45e-08 $layer=M1 $thickness=3.6e-08
+ $X=0.135 $Y=0.191 $X2=0.1105 $Y2=0.191
r12 9 11 8.26145 $w=1.50753e-08 $l=4.25e-08 $layer=M1 $thickness=3.6e-08
+ $X=0.135 $Y=0.191 $X2=0.135 $Y2=0.1485
r13 20 21 4.19742 $w=1.3e-08 $l=1.8e-08 $layer=M1 $thickness=3.6e-08 $X=0.0925
+ $Y=0.191 $X2=0.1105 $Y2=0.191
r14 19 20 2.68168 $w=1.3e-08 $l=1.15e-08 $layer=M1 $thickness=3.6e-08 $X=0.081
+ $Y=0.191 $X2=0.0925 $Y2=0.191
r15 18 19 2.56509 $w=1.3e-08 $l=1.1e-08 $layer=M1 $thickness=3.6e-08 $X=0.07
+ $Y=0.191 $X2=0.081 $Y2=0.191
r16 10 18 0.582974 $w=1.3e-08 $l=2.5e-09 $layer=M1 $thickness=3.6e-08 $X=0.0675
+ $Y=0.191 $X2=0.07 $Y2=0.191
r17 1 12 6.54019 $w=2.09524e-08 $layer=Gate_1 $thickness=5.21905e-08 $X=0.081
+ $Y=0.191 $X2=0.081 $Y2=0.191
r18 1 19 19.3796 $a=3.24e-16 $layer=V0LIG $X=0.081 $Y=0.191 $X2=0.081 $Y2=0.191
r19 14 13 6.97283 $w=2.1e-08 $l=2.05e-08 $layer=Gate_1 $thickness=5.6e-08
+ $X=0.081 $Y=0.2295 $X2=0.081 $Y2=0.209
r20 12 13 6.30956 $w=2.03889e-08 $l=1.8e-08 $layer=Gate_1 $thickness=5.6e-08
+ $X=0.081 $Y=0.191 $X2=0.081 $Y2=0.209
r21 6 12 7.84018 $w=2.05111e-08 $l=2.25e-08 $layer=Gate_1 $thickness=5.6e-08
+ $X=0.081 $Y=0.1685 $X2=0.081 $Y2=0.191
.ends

.subckt PM_TIELOx1_ASAP7_75t_R%3 vss 12 28 10 9 7 1 11 6
c1 1 vss 0.00835834f $X=0.081 $Y=0.106
c2 6 vss 0.0346545f $X=0.081 $Y=0.0245
c3 7 vss 0.0250891f $X=0.056 $Y=0.2295
c4 8 vss 0.00218188f $X=0.027 $Y=0.106
c5 9 vss 0.00690564f $X=0.027 $Y=0.234
c6 10 vss 0.00652135f $X=0.027 $Y=0.1485
c7 11 vss 0.00283196f $X=0.0695 $Y=0.106
r1 28 27 0.0925926 $w=2.7e-08 $l=2.5e-09 $layer=P_src_drn $thickness=1e-09
+ $X=0.0713 $Y=0.2295 $X2=0.0685 $Y2=0.2295
r2 7 27 0.462963 $w=2.7e-08 $l=1.25e-08 $layer=P_src_drn $thickness=1e-09
+ $X=0.056 $Y=0.2295 $X2=0.0685 $Y2=0.2295
r3 7 24 19.3796 $a=3.24e-16 $layer=V0LISD $X=0.056 $Y=0.2295 $X2=0.054 $Y2=0.234
r4 23 24 3.14806 $w=1.3e-08 $l=1.35e-08 $layer=M1 $thickness=3.6e-08 $X=0.0405
+ $Y=0.234 $X2=0.054 $Y2=0.234
r5 9 22 3.83327 $w=1.5093e-08 $l=2.15e-08 $layer=M1 $thickness=3.6e-08 $X=0.027
+ $Y=0.234 $X2=0.027 $Y2=0.2125
r6 9 23 1.96775 $w=1.63333e-08 $l=1.35e-08 $layer=M1 $thickness=3.6e-08
+ $X=0.027 $Y=0.234 $X2=0.0405 $Y2=0.234
r7 21 22 5.01358 $w=1.3e-08 $l=2.15e-08 $layer=M1 $thickness=3.6e-08 $X=0.027
+ $Y=0.191 $X2=0.027 $Y2=0.2125
r8 10 21 9.91056 $w=1.3e-08 $l=4.25e-08 $layer=M1 $thickness=3.6e-08 $X=0.027
+ $Y=0.1485 $X2=0.027 $Y2=0.191
r9 8 19 4.06404 $w=1.48367e-08 $l=2.45e-08 $layer=M1 $thickness=3.6e-08
+ $X=0.027 $Y=0.106 $X2=0.0515 $Y2=0.106
r10 8 10 8.26145 $w=1.50753e-08 $l=4.25e-08 $layer=M1 $thickness=3.6e-08
+ $X=0.027 $Y=0.106 $X2=0.027 $Y2=0.1485
r11 11 17 2.68168 $w=1.3e-08 $l=1.15e-08 $layer=M1 $thickness=3.6e-08 $X=0.0695
+ $Y=0.106 $X2=0.081 $Y2=0.106
r12 11 19 4.19742 $w=1.3e-08 $l=1.8e-08 $layer=M1 $thickness=3.6e-08 $X=0.0695
+ $Y=0.106 $X2=0.0515 $Y2=0.106
r13 1 14 5.82591 $w=2.10526e-08 $l=2e-09 $layer=Gate_1 $thickness=5.17895e-08
+ $X=0.081 $Y=0.106 $X2=0.081 $Y2=0.104
r14 1 17 19.3796 $a=3.24e-16 $layer=V0LIG $X=0.081 $Y=0.106 $X2=0.081 $Y2=0.106
r15 13 14 5.59527 $w=2.04375e-08 $l=1.6e-08 $layer=Gate_1 $thickness=5.6e-08
+ $X=0.081 $Y=0.088 $X2=0.081 $Y2=0.104
r16 12 13 11.5647 $w=2.1e-08 $l=3.4e-08 $layer=Gate_1 $thickness=5.6e-08
+ $X=0.081 $Y=0.054 $X2=0.081 $Y2=0.088
r17 12 6 10.0341 $w=2.1e-08 $l=2.95e-08 $layer=Gate_1 $thickness=5.6e-08
+ $X=0.081 $Y=0.054 $X2=0.081 $Y2=0.0245
.ends

* End of included file TIELOx1_ASAP7_75t_R.pex.sp.pex

*
.subckt TIELOx1_ASAP7_75t_CUSTOM_4_25_0_7 VSS VDD L
*
* VSS VSS
* VDD VDD
* L L
*
*

M0 N_M0_d N_M0_g VSS VSS nmos_rvt L=2e-08 W=5.4e-08 nfin=2 $X=0.071 $Y=0.027
M1 VDD N_M1_g N_M1_s VDD pmos_rvt L=2e-08 W=2.7e-08 nfin=1 $X=0.071 $Y=0.216

* .include "TIELOx1_ASAP7_75t_R.pex.sp.pxi"

* Start of included file TIELOx1_ASAP7_75t_R.pex.sp.pxi
x_PM_TIELOx1_ASAP7_75t_R%L vss L N_M1_g N_M0_d N_L_7 N_L_10 N_L_1 N_L_11 N_L_6
+ PM_TIELOx1_ASAP7_75t_R%L
cc_1 N_L_7 N_3_10 0.00151832f $X=0.0935 $Y=0.054
cc_2 N_L_10 N_3_9 0.0024581f $X=0.0675 $Y=0.191
cc_3 N_L_1 N_3_7 0.00260995f $X=0.081 $Y=0.191
cc_4 N_L_7 N_3_1 0.00337358f $X=0.0935 $Y=0.054
cc_5 N_L_11 N_3_11 0.00344465f $X=0.135 $Y=0.1485
cc_6 N_L_6 N_3_7 0.0156233f $X=0.081 $Y=0.1685
cc_7 N_L_7 N_3_6 0.0308752f $X=0.0935 $Y=0.054
x_PM_TIELOx1_ASAP7_75t_R%3 vss N_M0_g N_M1_s N_3_10 N_3_9 N_3_7 N_3_1 N_3_11
+ N_3_6 PM_TIELOx1_ASAP7_75t_R%3

* End of included file TIELOx1_ASAP7_75t_R.pex.sp.pxi
.ends

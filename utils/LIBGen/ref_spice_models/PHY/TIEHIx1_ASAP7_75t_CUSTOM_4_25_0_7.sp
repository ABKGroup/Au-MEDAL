.subckt PM_TIEHIx1_ASAP7_75t_R%H vss 24 12 31 7 10 1 11 6
c1 1 vss 0.00863021f $X=0.081 $Y=0.079
c2 3 vss 0.00754407f $X=0.108 $Y=0.216
c3 6 vss 0.0285296f $X=0.081 $Y=0.0245
c4 7 vss 0.0292803f $X=0.0935 $Y=0.216
c5 8 vss 0.00674867f $X=0.135 $Y=0.234
c6 9 vss 0.00208507f $X=0.135 $Y=0.079
c7 10 vss 0.00253677f $X=0.0675 $Y=0.079
c8 11 vss 0.00640866f $X=0.135 $Y=0.1215
r1 7 3 0.231482 $w=5.4e-08 $l=1.25e-08 $layer=P_src_drn $thickness=1e-09
+ $X=0.0935 $Y=0.216 $X2=0.108 $Y2=0.216
r2 31 7 0.0462963 $w=5.4e-08 $l=2.5e-09 $layer=P_src_drn $thickness=1e-09
+ $X=0.0906 $Y=0.216 $X2=0.0935 $Y2=0.216
r3 3 27 19.3796 $a=3.24e-16 $layer=V0LISD $X=0.108 $Y=0.216 $X2=0.108 $Y2=0.234
r4 27 28 3.14806 $w=1.3e-08 $l=1.35e-08 $layer=M1 $thickness=3.6e-08 $X=0.108
+ $Y=0.234 $X2=0.1215 $Y2=0.234
r5 8 25 4.53284 $w=1.48367e-08 $l=2.45e-08 $layer=M1 $thickness=3.6e-08
+ $X=0.135 $Y=0.234 $X2=0.135 $Y2=0.2095
r6 8 28 1.96775 $w=1.63333e-08 $l=1.35e-08 $layer=M1 $thickness=3.6e-08
+ $X=0.135 $Y=0.234 $X2=0.1215 $Y2=0.234
r7 24 25 3.73104 $w=1.3e-08 $l=1.6e-08 $layer=M1 $thickness=3.6e-08 $X=0.137
+ $Y=0.1935 $X2=0.135 $Y2=0.2095
r8 24 23 2.44849 $w=1.3e-08 $l=1.05e-08 $layer=M1 $thickness=3.6e-08 $X=0.137
+ $Y=0.1935 $X2=0.135 $Y2=0.183
r9 22 23 4.43061 $w=1.3e-08 $l=1.9e-08 $layer=M1 $thickness=3.6e-08 $X=0.135
+ $Y=0.164 $X2=0.135 $Y2=0.183
r10 11 22 9.91056 $w=1.3e-08 $l=4.25e-08 $layer=M1 $thickness=3.6e-08 $X=0.135
+ $Y=0.1215 $X2=0.135 $Y2=0.164
r11 9 21 4.06404 $w=1.48367e-08 $l=2.45e-08 $layer=M1 $thickness=3.6e-08
+ $X=0.135 $Y=0.079 $X2=0.1105 $Y2=0.079
r12 9 11 8.26145 $w=1.50753e-08 $l=4.25e-08 $layer=M1 $thickness=3.6e-08
+ $X=0.135 $Y=0.079 $X2=0.135 $Y2=0.1215
r13 20 21 4.19742 $w=1.3e-08 $l=1.8e-08 $layer=M1 $thickness=3.6e-08 $X=0.0925
+ $Y=0.079 $X2=0.1105 $Y2=0.079
r14 19 20 2.68168 $w=1.3e-08 $l=1.15e-08 $layer=M1 $thickness=3.6e-08 $X=0.081
+ $Y=0.079 $X2=0.0925 $Y2=0.079
r15 18 19 2.56509 $w=1.3e-08 $l=1.1e-08 $layer=M1 $thickness=3.6e-08 $X=0.07
+ $Y=0.079 $X2=0.081 $Y2=0.079
r16 10 18 0.582974 $w=1.3e-08 $l=2.5e-09 $layer=M1 $thickness=3.6e-08 $X=0.0675
+ $Y=0.079 $X2=0.07 $Y2=0.079
r17 1 14 6.54019 $w=2.09524e-08 $layer=Gate_1 $thickness=5.21905e-08 $X=0.081
+ $Y=0.079 $X2=0.081 $Y2=0.079
r18 1 19 19.3796 $a=3.24e-16 $layer=V0LIG $X=0.081 $Y=0.079 $X2=0.081 $Y2=0.079
r19 13 14 6.30956 $w=2.03889e-08 $l=1.8e-08 $layer=Gate_1 $thickness=5.6e-08
+ $X=0.081 $Y=0.061 $X2=0.081 $Y2=0.079
r20 12 13 6.97283 $w=2.1e-08 $l=2.05e-08 $layer=Gate_1 $thickness=5.6e-08
+ $X=0.081 $Y=0.0405 $X2=0.081 $Y2=0.061
r21 12 6 5.44221 $w=2.1e-08 $l=1.6e-08 $layer=Gate_1 $thickness=5.6e-08
+ $X=0.081 $Y=0.0405 $X2=0.081 $Y2=0.0245
.ends

.subckt PM_TIEHIx1_ASAP7_75t_R%4 vss 13 28 10 8 7 1 11 6
c1 1 vss 0.0083581f $X=0.081 $Y=0.164
c2 6 vss 0.0346537f $X=0.081 $Y=0.166
c3 7 vss 0.0251303f $X=0.056 $Y=0.0405
c4 8 vss 0.00690478f $X=0.027 $Y=0.036
c5 9 vss 0.00218129f $X=0.027 $Y=0.164
c6 10 vss 0.00651911f $X=0.027 $Y=0.1215
c7 11 vss 0.00283116f $X=0.0695 $Y=0.164
r1 28 27 0.0925926 $w=2.7e-08 $l=2.5e-09 $layer=N_src_drn $thickness=1e-09
+ $X=0.0713 $Y=0.0405 $X2=0.0685 $Y2=0.0405
r2 7 27 0.462963 $w=2.7e-08 $l=1.25e-08 $layer=N_src_drn $thickness=1e-09
+ $X=0.056 $Y=0.0405 $X2=0.0685 $Y2=0.0405
r3 7 24 19.3796 $a=3.24e-16 $layer=V0LISD $X=0.056 $Y=0.0405 $X2=0.054 $Y2=0.036
r4 23 24 3.14806 $w=1.3e-08 $l=1.35e-08 $layer=M1 $thickness=3.6e-08 $X=0.0405
+ $Y=0.036 $X2=0.054 $Y2=0.036
r5 8 22 3.83327 $w=1.5093e-08 $l=2.15e-08 $layer=M1 $thickness=3.6e-08 $X=0.027
+ $Y=0.036 $X2=0.027 $Y2=0.0575
r6 8 23 1.96775 $w=1.63333e-08 $l=1.35e-08 $layer=M1 $thickness=3.6e-08
+ $X=0.027 $Y=0.036 $X2=0.0405 $Y2=0.036
r7 21 22 5.01358 $w=1.3e-08 $l=2.15e-08 $layer=M1 $thickness=3.6e-08 $X=0.027
+ $Y=0.079 $X2=0.027 $Y2=0.0575
r8 10 21 9.91056 $w=1.3e-08 $l=4.25e-08 $layer=M1 $thickness=3.6e-08 $X=0.027
+ $Y=0.1215 $X2=0.027 $Y2=0.079
r9 9 19 4.06404 $w=1.48367e-08 $l=2.45e-08 $layer=M1 $thickness=3.6e-08
+ $X=0.027 $Y=0.164 $X2=0.0515 $Y2=0.164
r10 9 10 8.26145 $w=1.50753e-08 $l=4.25e-08 $layer=M1 $thickness=3.6e-08
+ $X=0.027 $Y=0.164 $X2=0.027 $Y2=0.1215
r11 11 17 2.68168 $w=1.3e-08 $l=1.15e-08 $layer=M1 $thickness=3.6e-08 $X=0.0695
+ $Y=0.164 $X2=0.081 $Y2=0.164
r12 11 19 4.19742 $w=1.3e-08 $l=1.8e-08 $layer=M1 $thickness=3.6e-08 $X=0.0695
+ $Y=0.164 $X2=0.0515 $Y2=0.164
r13 1 6 5.82591 $w=2.10526e-08 $l=2e-09 $layer=Gate_1 $thickness=5.17895e-08
+ $X=0.081 $Y=0.164 $X2=0.081 $Y2=0.166
r14 1 17 19.3796 $a=3.24e-16 $layer=V0LIG $X=0.081 $Y=0.164 $X2=0.081 $Y2=0.164
r15 13 12 11.5647 $w=2.1e-08 $l=3.4e-08 $layer=Gate_1 $thickness=5.6e-08
+ $X=0.081 $Y=0.216 $X2=0.081 $Y2=0.182
r16 6 12 5.59527 $w=2.04375e-08 $l=1.6e-08 $layer=Gate_1 $thickness=5.6e-08
+ $X=0.081 $Y=0.166 $X2=0.081 $Y2=0.182
.ends

* End of included file TIEHIx1_ASAP7_75t_R.pex.sp.pex

*
.subckt TIEHIx1_ASAP7_75t_CUSTOM_4_25_0_7 VSS VDD H
*
* VSS VSS
* VDD VDD
* H H
*
*

M0 VSS N_M0_g N_M0_s VSS nmos_rvt L=2e-08 W=2.7e-08 nfin=1 $X=0.071 $Y=0.027
M1 N_M1_d N_M1_g VDD VDD pmos_rvt L=2e-08 W=5.4e-08 nfin=2 $X=0.071 $Y=0.189

* .include "TIEHIx1_ASAP7_75t_R.pex.sp.pxi"

* Start of included file TIEHIx1_ASAP7_75t_R.pex.sp.pxi
x_PM_TIEHIx1_ASAP7_75t_R%H vss H N_M0_g N_M1_d N_H_7 N_H_10 N_H_1 N_H_11 N_H_6
+ PM_TIEHIx1_ASAP7_75t_R%H
x_PM_TIEHIx1_ASAP7_75t_R%4 vss N_M1_g N_M0_s N_4_10 N_4_8 N_4_7 N_4_1 N_4_11
+ N_4_6 PM_TIEHIx1_ASAP7_75t_R%4
cc_1 N_4_10 N_H_7 0.00151832f $X=0.027 $Y=0.1215
cc_2 N_4_8 N_H_10 0.0024581f $X=0.027 $Y=0.036
cc_3 N_4_7 N_H_1 0.00260995f $X=0.056 $Y=0.0405
cc_4 N_4_1 N_H_7 0.00337358f $X=0.081 $Y=0.164
cc_5 N_4_11 N_H_11 0.00344465f $X=0.0695 $Y=0.164
cc_6 N_4_7 N_H_6 0.0156167f $X=0.056 $Y=0.0405
cc_7 N_4_6 N_H_7 0.0308757f $X=0.081 $Y=0.166

* End of included file TIEHIx1_ASAP7_75t_R.pex.sp.pxi
.ends

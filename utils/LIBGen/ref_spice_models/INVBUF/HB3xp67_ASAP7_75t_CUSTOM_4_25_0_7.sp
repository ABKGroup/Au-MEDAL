.subckt PM_HB3xp67_ASAP7_75t_R%Y vss 20 13 27 7 11 8
c1 1 vss 0.00783196f $X=0.27 $Y=0.054
c2 2 vss 0.00789635f $X=0.27 $Y=0.216
c3 7 vss 0.02876f $X=0.2555 $Y=0.054
c4 8 vss 0.0289662f $X=0.2555 $Y=0.216
c5 9 vss 0.00621711f $X=0.2565 $Y=0.036
c6 10 vss 0.00621251f $X=0.297 $Y=0.234
c7 11 vss 0.00668624f $X=0.297 $Y=0.0855
r1 8 2 0.231482 $w=5.4e-08 $l=1.25e-08 $layer=P_src_drn $thickness=1e-09
+ $X=0.2555 $Y=0.216 $X2=0.27 $Y2=0.216
r2 27 8 0.0462963 $w=5.4e-08 $l=2.5e-09 $layer=P_src_drn $thickness=1e-09
+ $X=0.2526 $Y=0.216 $X2=0.2555 $Y2=0.216
r3 2 23 19.3796 $a=3.24e-16 $layer=V0LISD $X=0.27 $Y=0.216 $X2=0.27 $Y2=0.234
r4 23 24 3.14806 $w=1.3e-08 $l=1.35e-08 $layer=M1 $thickness=3.6e-08 $X=0.27
+ $Y=0.234 $X2=0.2835 $Y2=0.234
r5 10 21 8.61366 $w=1.40714e-08 $l=4.2e-08 $layer=M1 $thickness=3.6e-08
+ $X=0.297 $Y=0.234 $X2=0.297 $Y2=0.192
r6 10 24 1.96775 $w=1.63333e-08 $l=1.35e-08 $layer=M1 $thickness=3.6e-08
+ $X=0.297 $Y=0.234 $X2=0.2835 $Y2=0.234
r7 20 21 7.81186 $w=1.3e-08 $l=3.35e-08 $layer=M1 $thickness=3.6e-08 $X=0.296
+ $Y=0.1585 $X2=0.297 $Y2=0.192
r8 20 19 1.74892 $w=1.3e-08 $l=7.5e-09 $layer=M1 $thickness=3.6e-08 $X=0.296
+ $Y=0.1585 $X2=0.297 $Y2=0.151
r9 18 19 3.73104 $w=1.3e-08 $l=1.6e-08 $layer=M1 $thickness=3.6e-08 $X=0.297
+ $Y=0.135 $X2=0.297 $Y2=0.151
r10 11 17 10.3626 $w=1.39091e-08 $l=4.95e-08 $layer=M1 $thickness=3.6e-08
+ $X=0.297 $Y=0.0855 $X2=0.297 $Y2=0.036
r11 11 18 11.5429 $w=1.3e-08 $l=4.95e-08 $layer=M1 $thickness=3.6e-08 $X=0.297
+ $Y=0.0855 $X2=0.297 $Y2=0.135
r12 16 17 1.96775 $w=1.63333e-08 $l=1.35e-08 $layer=M1 $thickness=3.6e-08
+ $X=0.2835 $Y=0.036 $X2=0.297 $Y2=0.036
r13 15 16 3.14806 $w=1.3e-08 $l=1.35e-08 $layer=M1 $thickness=3.6e-08 $X=0.27
+ $Y=0.036 $X2=0.2835 $Y2=0.036
r14 14 15 2.56509 $w=1.3e-08 $l=1.1e-08 $layer=M1 $thickness=3.6e-08 $X=0.259
+ $Y=0.036 $X2=0.27 $Y2=0.036
r15 9 14 0.582974 $w=1.3e-08 $l=2.5e-09 $layer=M1 $thickness=3.6e-08 $X=0.2565
+ $Y=0.036 $X2=0.259 $Y2=0.036
r16 1 15 19.3796 $a=3.24e-16 $layer=V0LISD $X=0.27 $Y=0.054 $X2=0.27 $Y2=0.036
r17 7 1 0.231482 $w=5.4e-08 $l=1.25e-08 $layer=N_src_drn $thickness=1e-09
+ $X=0.2555 $Y=0.054 $X2=0.27 $Y2=0.054
r18 13 7 0.0462963 $w=5.4e-08 $l=2.5e-09 $layer=N_src_drn $thickness=1e-09
+ $X=0.2526 $Y=0.054 $X2=0.2555 $Y2=0.054
.ends

.subckt PM_HB3xp67_ASAP7_75t_R%8 vss 2 3 1
c1 1 vss 0.0021731f $X=0.108 $Y=0.2295
r1 2 1 0.62963 $w=2.7e-08 $l=1.7e-08 $layer=P_src_drn $thickness=1e-09
+ $X=0.0906 $Y=0.2295 $X2=0.108 $Y2=0.2295
r2 3 1 0.62963 $w=2.7e-08 $l=1.7e-08 $layer=P_src_drn $thickness=1e-09
+ $X=0.1253 $Y=0.2295 $X2=0.108 $Y2=0.2295
.ends

.subckt PM_HB3xp67_ASAP7_75t_R%9 vss 2 3 1
c1 1 vss 0.0020863f $X=0.162 $Y=0.2295
r1 2 1 0.62963 $w=2.7e-08 $l=1.7e-08 $layer=P_src_drn $thickness=1e-09
+ $X=0.1446 $Y=0.2295 $X2=0.162 $Y2=0.2295
r2 3 1 0.62963 $w=2.7e-08 $l=1.7e-08 $layer=P_src_drn $thickness=1e-09
+ $X=0.1793 $Y=0.2295 $X2=0.162 $Y2=0.2295
.ends

.subckt PM_HB3xp67_ASAP7_75t_R%4 vss 20 26 44 46 11 1 4 3 16 17 18 9 10 13 15 19
c1 1 vss 0.00224809f $X=0.243 $Y=0.135
c2 3 vss 0.00588553f $X=0.054 $Y=0.0405
c3 4 vss 0.00587321f $X=0.054 $Y=0.2295
c4 9 vss 0.0611596f $X=0.243 $Y=0.0245
c5 10 vss 0.0179367f $X=0.056 $Y=0.0405
c6 11 vss 0.017884f $X=0.056 $Y=0.2295
c7 12 vss 0.00309628f $X=0.189 $Y=0.036
c8 13 vss 6.23761e-20 $X=0.189 $Y=0.135
c9 14 vss 0.00309628f $X=0.189 $Y=0.234
c10 15 vss 0.013239f $X=0.1375 $Y=0.036
c11 16 vss 0.0132363f $X=0.1375 $Y=0.234
c12 17 vss 0.00285104f $X=0.189 $Y=0.1035
c13 18 vss 0.00285104f $X=0.189 $Y=0.1665
c14 19 vss 0.00126263f $X=0.216 $Y=0.135
r1 46 45 0.0925926 $w=2.7e-08 $l=2.5e-09 $layer=P_src_drn $thickness=1e-09
+ $X=0.0713 $Y=0.2295 $X2=0.0685 $Y2=0.2295
r2 11 45 0.462963 $w=2.7e-08 $l=1.25e-08 $layer=P_src_drn $thickness=1e-09
+ $X=0.056 $Y=0.2295 $X2=0.0685 $Y2=0.2295
r3 44 43 0.0925926 $w=2.7e-08 $l=2.5e-09 $layer=N_src_drn $thickness=1e-09
+ $X=0.0713 $Y=0.0405 $X2=0.0685 $Y2=0.0405
r4 10 43 0.462963 $w=2.7e-08 $l=1.25e-08 $layer=N_src_drn $thickness=1e-09
+ $X=0.056 $Y=0.0405 $X2=0.0685 $Y2=0.0405
r5 4 42 19.3796 $a=3.24e-16 $layer=V0LISD $X=0.054 $Y=0.2295 $X2=0.05 $Y2=0.234
r6 3 38 19.3796 $a=3.24e-16 $layer=V0LISD $X=0.054 $Y=0.0405 $X2=0.05 $Y2=0.036
r7 39 40 4.6638 $w=1.3e-08 $l=2e-08 $layer=M1 $thickness=3.6e-08 $X=0.059
+ $Y=0.234 $X2=0.079 $Y2=0.234
r8 39 42 2.09871 $w=1.3e-08 $l=9e-09 $layer=M1 $thickness=3.6e-08 $X=0.059
+ $Y=0.234 $X2=0.05 $Y2=0.234
r9 16 40 13.6416 $w=1.3e-08 $l=5.85e-08 $layer=M1 $thickness=3.6e-08 $X=0.1375
+ $Y=0.234 $X2=0.079 $Y2=0.234
r10 35 36 4.6638 $w=1.3e-08 $l=2e-08 $layer=M1 $thickness=3.6e-08 $X=0.059
+ $Y=0.036 $X2=0.079 $Y2=0.036
r11 35 38 2.09871 $w=1.3e-08 $l=9e-09 $layer=M1 $thickness=3.6e-08 $X=0.059
+ $Y=0.036 $X2=0.05 $Y2=0.036
r12 15 36 13.6416 $w=1.3e-08 $l=5.85e-08 $layer=M1 $thickness=3.6e-08 $X=0.1375
+ $Y=0.036 $X2=0.079 $Y2=0.036
r13 14 34 2.5483 $w=1.79e-08 $l=1.8e-08 $layer=M1 $thickness=3.6e-08 $X=0.189
+ $Y=0.234 $X2=0.189 $Y2=0.216
r14 14 16 10.3602 $w=1.38738e-08 $l=5.15e-08 $layer=M1 $thickness=3.6e-08
+ $X=0.189 $Y=0.234 $X2=0.1375 $Y2=0.234
r15 12 32 2.5483 $w=1.79e-08 $l=1.8e-08 $layer=M1 $thickness=3.6e-08 $X=0.189
+ $Y=0.036 $X2=0.189 $Y2=0.054
r16 12 15 10.3602 $w=1.38738e-08 $l=5.15e-08 $layer=M1 $thickness=3.6e-08
+ $X=0.189 $Y=0.036 $X2=0.1375 $Y2=0.036
r17 33 34 4.19742 $w=1.3e-08 $l=1.8e-08 $layer=M1 $thickness=3.6e-08 $X=0.189
+ $Y=0.198 $X2=0.189 $Y2=0.216
r18 18 33 7.34548 $w=1.3e-08 $l=3.15e-08 $layer=M1 $thickness=3.6e-08 $X=0.189
+ $Y=0.1665 $X2=0.189 $Y2=0.198
r19 31 32 4.19742 $w=1.3e-08 $l=1.8e-08 $layer=M1 $thickness=3.6e-08 $X=0.189
+ $Y=0.072 $X2=0.189 $Y2=0.054
r20 17 31 7.34548 $w=1.3e-08 $l=3.15e-08 $layer=M1 $thickness=3.6e-08 $X=0.189
+ $Y=0.1035 $X2=0.189 $Y2=0.072
r21 13 19 5.11582 $w=1.46667e-08 $l=2.7e-08 $layer=M1 $thickness=3.6e-08
+ $X=0.189 $Y=0.135 $X2=0.216 $Y2=0.135
r22 13 17 6.16517 $w=1.44286e-08 $l=3.15e-08 $layer=M1 $thickness=3.6e-08
+ $X=0.189 $Y=0.135 $X2=0.189 $Y2=0.1035
r23 13 18 6.16517 $w=1.44286e-08 $l=3.15e-08 $layer=M1 $thickness=3.6e-08
+ $X=0.189 $Y=0.135 $X2=0.189 $Y2=0.1665
r24 19 28 6.29612 $w=1.3e-08 $l=2.7e-08 $layer=M1 $thickness=3.6e-08 $X=0.216
+ $Y=0.135 $X2=0.243 $Y2=0.135
r25 1 23 10.4265 $w=1.765e-08 $layer=LIG $thickness=5.2e-08 $X=0.243 $Y=0.135
+ $X2=0.243 $Y2=0.135
r26 1 28 19.3796 $a=3.24e-16 $layer=V0LIG $X=0.243 $Y=0.135 $X2=0.243 $Y2=0.135
r27 26 25 14.6259 $w=2.1e-08 $l=4.3e-08 $layer=Gate_1 $thickness=5.6e-08
+ $X=0.243 $Y=0.216 $X2=0.243 $Y2=0.173
r28 24 25 7.31297 $w=2.1e-08 $l=2.15e-08 $layer=Gate_1 $thickness=5.6e-08
+ $X=0.243 $Y=0.1515 $X2=0.243 $Y2=0.173
r29 23 24 5.79936 $w=2.03333e-08 $l=1.65e-08 $layer=Gate_1 $thickness=5.6e-08
+ $X=0.243 $Y=0.135 $X2=0.243 $Y2=0.1515
r30 22 23 5.79936 $w=2.03333e-08 $l=1.65e-08 $layer=Gate_1 $thickness=5.6e-08
+ $X=0.243 $Y=0.1185 $X2=0.243 $Y2=0.135
r31 21 22 7.31297 $w=2.1e-08 $l=2.15e-08 $layer=Gate_1 $thickness=5.6e-08
+ $X=0.243 $Y=0.097 $X2=0.243 $Y2=0.1185
r32 20 21 14.6259 $w=2.1e-08 $l=4.3e-08 $layer=Gate_1 $thickness=5.6e-08
+ $X=0.243 $Y=0.054 $X2=0.243 $Y2=0.097
r33 20 9 10.0341 $w=2.1e-08 $l=2.95e-08 $layer=Gate_1 $thickness=5.6e-08
+ $X=0.243 $Y=0.054 $X2=0.243 $Y2=0.0245
r34 4 11 1e-05 $l=2e-09 $X=0.054 $Y=0.2295 $X2=0.056 $Y2=0.2295
r35 3 10 1e-05 $l=2e-09 $X=0.054 $Y=0.0405 $X2=0.056 $Y2=0.0405
.ends

.subckt PM_HB3xp67_ASAP7_75t_R%A vss 43 12 18 32 35 38 41 1 9 10 6 8 3 11 4 5
c1 1 vss 0.00367806f $X=0.0715 $Y=0.135
c2 3 vss 0.01837f $X=0.081 $Y=0.0245
c3 4 vss 0.0132887f $X=0.135 $Y=0.135
c4 5 vss 0.0761061f $X=0.189 $Y=0.135
c5 6 vss 0.00360777f $X=0.027 $Y=0.072
c6 7 vss 0.00124288f $X=0.027 $Y=0.135
c7 8 vss 0.00358604f $X=0.027 $Y=0.198
c8 9 vss 0.00349512f $X=0.027 $Y=0.1035
c9 10 vss 0.00349512f $X=0.027 $Y=0.151
c10 11 vss 0.00257328f $X=0.0635 $Y=0.135
r1 8 44 4.41625 $w=1.4875e-08 $l=2.4e-08 $layer=M1 $thickness=3.6e-08 $X=0.027
+ $Y=0.198 $X2=0.027 $Y2=0.174
r2 6 9 6.16517 $w=1.44286e-08 $l=3.15e-08 $layer=M1 $thickness=3.6e-08 $X=0.027
+ $Y=0.072 $X2=0.027 $Y2=0.1035
r3 43 44 3.61444 $w=1.3e-08 $l=1.55e-08 $layer=M1 $thickness=3.6e-08 $X=0.02
+ $Y=0.1585 $X2=0.027 $Y2=0.174
r4 43 10 1.74892 $w=1.3e-08 $l=7.5e-09 $layer=M1 $thickness=3.6e-08 $X=0.02
+ $Y=0.1585 $X2=0.027 $Y2=0.151
r5 7 30 3.1337 $w=1.54324e-08 $l=1.85e-08 $layer=M1 $thickness=3.6e-08 $X=0.027
+ $Y=0.135 $X2=0.0455 $Y2=0.135
r6 7 9 6.16517 $w=1.44286e-08 $l=3.15e-08 $layer=M1 $thickness=3.6e-08 $X=0.027
+ $Y=0.135 $X2=0.027 $Y2=0.1035
r7 7 10 2.55073 $w=1.58125e-08 $l=1.6e-08 $layer=M1 $thickness=3.6e-08 $X=0.027
+ $Y=0.135 $X2=0.027 $Y2=0.151
r8 41 40 16.4967 $w=2.1e-08 $l=4.85e-08 $layer=Gate_1 $thickness=5.6e-08
+ $X=0.189 $Y=0.2295 $X2=0.189 $Y2=0.181
r9 38 39 16.4967 $w=2.1e-08 $l=4.85e-08 $layer=Gate_1 $thickness=5.6e-08
+ $X=0.189 $Y=0.0405 $X2=0.189 $Y2=0.089
r10 5 26 6.54019 $w=2.09524e-08 $layer=Gate_1 $thickness=5.21905e-08 $X=0.189
+ $Y=0.135 $X2=0.189 $Y2=0.135
r11 5 39 15.8334 $w=2.07609e-08 $l=4.6e-08 $layer=Gate_1 $thickness=5.6e-08
+ $X=0.189 $Y=0.135 $X2=0.189 $Y2=0.089
r12 5 40 15.8334 $w=2.07609e-08 $l=4.6e-08 $layer=Gate_1 $thickness=5.6e-08
+ $X=0.189 $Y=0.135 $X2=0.189 $Y2=0.181
r13 35 34 16.4967 $w=2.1e-08 $l=4.85e-08 $layer=Gate_1 $thickness=5.6e-08
+ $X=0.135 $Y=0.2295 $X2=0.135 $Y2=0.181
r14 32 33 16.4967 $w=2.1e-08 $l=4.85e-08 $layer=Gate_1 $thickness=5.6e-08
+ $X=0.135 $Y=0.0405 $X2=0.135 $Y2=0.089
r15 4 24 6.54019 $w=2.09524e-08 $layer=Gate_1 $thickness=5.21905e-08 $X=0.135
+ $Y=0.135 $X2=0.135 $Y2=0.135
r16 4 33 15.8334 $w=2.07609e-08 $l=4.6e-08 $layer=Gate_1 $thickness=5.6e-08
+ $X=0.135 $Y=0.135 $X2=0.135 $Y2=0.089
r17 4 34 15.8334 $w=2.07609e-08 $l=4.6e-08 $layer=Gate_1 $thickness=5.6e-08
+ $X=0.135 $Y=0.135 $X2=0.135 $Y2=0.181
r18 11 28 4.08082 $w=1.3e-08 $l=1.75e-08 $layer=M1 $thickness=3.6e-08 $X=0.0635
+ $Y=0.135 $X2=0.081 $Y2=0.135
r19 11 30 4.19742 $w=1.3e-08 $l=1.8e-08 $layer=M1 $thickness=3.6e-08 $X=0.0635
+ $Y=0.135 $X2=0.0455 $Y2=0.135
r20 25 26 12.6539 $w=1.77815e-08 $l=2.7e-08 $layer=LIG $thickness=4.8e-08
+ $X=0.162 $Y=0.135 $X2=0.189 $Y2=0.135
r21 24 25 12.6539 $w=1.77815e-08 $l=2.7e-08 $layer=LIG $thickness=4.8e-08
+ $X=0.135 $Y=0.135 $X2=0.162 $Y2=0.135
r22 23 24 12.6539 $w=1.77815e-08 $l=2.7e-08 $layer=LIG $thickness=4.8e-08
+ $X=0.108 $Y=0.135 $X2=0.135 $Y2=0.135
r23 21 23 10.1729 $w=1.54914e-08 $l=1.75e-08 $layer=LIG $thickness=4.8e-08
+ $X=0.0905 $Y=0.135 $X2=0.108 $Y2=0.135
r24 20 21 2.48102 $w=2.2e-08 $l=9.5e-09 $layer=LIG $thickness=4.8e-08 $X=0.081
+ $Y=0.135 $X2=0.0905 $Y2=0.135
r25 20 28 19.3796 $a=3.24e-16 $layer=V0LIG $X=0.081 $Y=0.135 $X2=0.081 $Y2=0.135
r26 1 20 2.48102 $w=2.2e-08 $l=9.5e-09 $layer=LIG $thickness=4.8e-08 $X=0.0715
+ $Y=0.135 $X2=0.081 $Y2=0.135
r27 18 17 14.6259 $w=2.1e-08 $l=4.3e-08 $layer=Gate_1 $thickness=5.6e-08
+ $X=0.081 $Y=0.2295 $X2=0.081 $Y2=0.1865
r28 16 17 11.9048 $w=2.1e-08 $l=3.5e-08 $layer=Gate_1 $thickness=5.6e-08
+ $X=0.081 $Y=0.1515 $X2=0.081 $Y2=0.1865
r29 15 16 5.79936 $w=2.03333e-08 $l=1.65e-08 $layer=Gate_1 $thickness=5.6e-08
+ $X=0.081 $Y=0.135 $X2=0.081 $Y2=0.1515
r30 15 21 4.05918 $w=2.0087e-08 $l=9.5e-09 $layer=Gate_1 $thickness=5.56522e-08
+ $X=0.081 $Y=0.135 $X2=0.0905 $Y2=0.135
r31 15 20 6.27904 $w=2.09e-08 $layer=Gate_1 $thickness=5.24e-08 $X=0.081
+ $Y=0.135 $X2=0.081 $Y2=0.135
r32 14 15 5.79936 $w=2.03333e-08 $l=1.65e-08 $layer=Gate_1 $thickness=5.6e-08
+ $X=0.081 $Y=0.1185 $X2=0.081 $Y2=0.135
r33 13 14 11.9048 $w=2.1e-08 $l=3.5e-08 $layer=Gate_1 $thickness=5.6e-08
+ $X=0.081 $Y=0.0835 $X2=0.081 $Y2=0.1185
r34 12 13 14.6259 $w=2.1e-08 $l=4.3e-08 $layer=Gate_1 $thickness=5.6e-08
+ $X=0.081 $Y=0.0405 $X2=0.081 $Y2=0.0835
r35 12 3 5.44221 $w=2.1e-08 $l=1.6e-08 $layer=Gate_1 $thickness=5.6e-08
+ $X=0.081 $Y=0.0405 $X2=0.081 $Y2=0.0245
.ends

.subckt PM_HB3xp67_ASAP7_75t_R%6 vss 2 3 1
c1 1 vss 0.00216694f $X=0.108 $Y=0.0405
r1 2 1 0.62963 $w=2.7e-08 $l=1.7e-08 $layer=N_src_drn $thickness=1e-09
+ $X=0.0906 $Y=0.0405 $X2=0.108 $Y2=0.0405
r2 3 1 0.62963 $w=2.7e-08 $l=1.7e-08 $layer=N_src_drn $thickness=1e-09
+ $X=0.1253 $Y=0.0405 $X2=0.108 $Y2=0.0405
.ends

.subckt PM_HB3xp67_ASAP7_75t_R%7 vss 2 3 1
c1 1 vss 0.00214743f $X=0.162 $Y=0.0405
r1 2 1 0.62963 $w=2.7e-08 $l=1.7e-08 $layer=N_src_drn $thickness=1e-09
+ $X=0.1446 $Y=0.0405 $X2=0.162 $Y2=0.0405
r2 3 1 0.62963 $w=2.7e-08 $l=1.7e-08 $layer=N_src_drn $thickness=1e-09
+ $X=0.1793 $Y=0.0405 $X2=0.162 $Y2=0.0405
.ends

* End of included file HB3xp67_ASAP7_75t_R.pex.sp.pex

*
.subckt HB3xp67_ASAP7_75t_CUSTOM_4_25_0_7 VSS VDD A Y
*
* VSS VSS
* VDD VDD
* A A
* Y Y
*
*

M0 N_M0_d N_M0_g N_M0_s VSS nmos_rvt L=2e-08 W=2.7e-08 nfin=1 $X=0.071 $Y=0.027
M1 N_M1_d N_M1_g N_M1_s VSS nmos_rvt L=2e-08 W=2.7e-08 nfin=1 $X=0.125 $Y=0.027
M2 VSS N_M2_g N_M2_s VSS nmos_rvt L=2e-08 W=2.7e-08 nfin=1 $X=0.179 $Y=0.027
M3 N_M3_d N_M3_g VSS VSS nmos_rvt L=2e-08 W=5.4e-08 nfin=2 $X=0.233 $Y=0.027
M4 N_M4_d N_M4_g N_M4_s VDD pmos_rvt L=2e-08 W=2.7e-08 nfin=1 $X=0.071 $Y=0.216
M5 N_M5_d N_M5_g N_M5_s VDD pmos_rvt L=2e-08 W=2.7e-08 nfin=1 $X=0.125 $Y=0.216
M6 VDD N_M6_g N_M6_s VDD pmos_rvt L=2e-08 W=2.7e-08 nfin=1 $X=0.179 $Y=0.216
M7 N_M7_d N_M7_g VDD VDD pmos_rvt L=2e-08 W=5.4e-08 nfin=2 $X=0.233 $Y=0.189

* .include "HB3xp67_ASAP7_75t_R.pex.sp.pxi"

* Start of included file HB3xp67_ASAP7_75t_R.pex.sp.pxi
x_PM_HB3xp67_ASAP7_75t_R%Y vss Y N_M3_d N_M7_d N_Y_7 N_Y_11 N_Y_8
+ PM_HB3xp67_ASAP7_75t_R%Y
cc_1 N_Y_7 N_4_1 0.00169687f $X=0.2555 $Y=0.054
cc_2 N_Y_11 N_4_19 0.00382949f $X=0.297 $Y=0.0855
cc_3 N_Y_8 N_4_9 0.0107531f $X=0.2555 $Y=0.216
cc_4 N_Y_7 N_4_9 0.0436541f $X=0.2555 $Y=0.054
x_PM_HB3xp67_ASAP7_75t_R%8 vss N_M4_d N_M5_s N_8_1 PM_HB3xp67_ASAP7_75t_R%8
cc_5 N_8_1 N_A_4 0.00227626f $X=0.108 $Y=0.2295
cc_6 N_8_1 N_A_3 0.011324f $X=0.108 $Y=0.2295
x_PM_HB3xp67_ASAP7_75t_R%9 vss N_M5_d N_M6_s N_9_1 PM_HB3xp67_ASAP7_75t_R%9
cc_7 N_9_1 N_A_4 0.00226816f $X=0.162 $Y=0.2295
cc_8 N_9_1 N_A_5 0.0113276f $X=0.162 $Y=0.2295
x_PM_HB3xp67_ASAP7_75t_R%4 vss N_M3_g N_M7_g N_M0_s N_M4_s N_4_11 N_4_1 N_4_4
+ N_4_3 N_4_16 N_4_17 N_4_18 N_4_9 N_4_10 N_4_13 N_4_15 N_4_19
+ PM_HB3xp67_ASAP7_75t_R%4
cc_9 N_4_11 N_A_1 0.000738036f $X=0.056 $Y=0.2295
cc_10 N_4_11 N_A_9 0.000434129f $X=0.056 $Y=0.2295
cc_11 N_4_11 N_A_10 0.000434129f $X=0.056 $Y=0.2295
cc_12 N_4_11 N_A_6 0.000612795f $X=0.056 $Y=0.2295
cc_13 N_4_11 N_A_8 0.000612795f $X=0.056 $Y=0.2295
cc_14 N_4_1 N_A_1 0.000705302f $X=0.243 $Y=0.135
cc_15 N_4_4 N_A_3 0.000756123f $X=0.054 $Y=0.2295
cc_16 N_4_3 N_A_3 0.000759941f $X=0.054 $Y=0.0405
cc_17 N_4_16 N_A_11 0.0009508f $X=0.1375 $Y=0.234
cc_18 N_4_17 N_A_1 0.000952164f $X=0.189 $Y=0.1035
cc_19 N_4_18 N_A_1 0.000952164f $X=0.189 $Y=0.1665
cc_20 N_4_9 N_A_4 0.00235207f $X=0.243 $Y=0.0245
cc_21 N_4_10 N_A_3 0.00673911f $X=0.056 $Y=0.0405
cc_22 N_4_13 N_A_1 0.00397026f $X=0.189 $Y=0.135
cc_23 N_4_15 N_A_6 0.00399671f $X=0.1375 $Y=0.036
cc_24 N_4_16 N_A_8 0.00401962f $X=0.1375 $Y=0.234
cc_25 N_4_9 N_A_5 0.0097988f $X=0.243 $Y=0.0245
cc_26 N_4_11 N_A_3 0.0318336f $X=0.056 $Y=0.2295
x_PM_HB3xp67_ASAP7_75t_R%A vss A N_M0_g N_M4_g N_M1_g N_M5_g N_M2_g N_M6_g
+ N_A_1 N_A_9 N_A_10 N_A_6 N_A_8 N_A_3 N_A_11 N_A_4 N_A_5
+ PM_HB3xp67_ASAP7_75t_R%A
x_PM_HB3xp67_ASAP7_75t_R%6 vss N_M0_d N_M1_s N_6_1 PM_HB3xp67_ASAP7_75t_R%6
cc_27 N_6_1 N_A_4 0.00227719f $X=0.108 $Y=0.0405
cc_28 N_6_1 N_A_3 0.0113253f $X=0.108 $Y=0.0405
x_PM_HB3xp67_ASAP7_75t_R%7 vss N_M1_d N_M2_s N_7_1 PM_HB3xp67_ASAP7_75t_R%7
cc_29 N_7_1 N_A_5 0.00422579f $X=0.162 $Y=0.0405
cc_30 N_7_1 N_A_4 0.00936346f $X=0.162 $Y=0.0405

* End of included file HB3xp67_ASAP7_75t_R.pex.sp.pxi
.ends

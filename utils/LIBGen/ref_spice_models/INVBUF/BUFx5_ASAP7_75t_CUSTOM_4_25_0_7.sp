.subckt PM_BUFx5_ASAP7_75t_R%A vss 22 10 16 3 9 4 6 1
c1 1 vss 0.004579f $X=0.072 $Y=0.135
c2 3 vss 0.086888f $X=0.081 $Y=0.0245
c3 4 vss 0.00330943f $X=0.027 $Y=0.072
c4 5 vss 0.00119798f $X=0.027 $Y=0.135
c5 6 vss 0.00330943f $X=0.027 $Y=0.198
c6 7 vss 0.00335711f $X=0.027 $Y=0.1035
c7 8 vss 0.00335711f $X=0.027 $Y=0.1665
c8 9 vss 0.00112882f $X=0.0455 $Y=0.135
r1 6 8 6.16517 $w=1.44286e-08 $l=3.15e-08 $layer=M1 $thickness=3.6e-08 $X=0.027
+ $Y=0.198 $X2=0.027 $Y2=0.1665
r2 4 7 6.16517 $w=1.44286e-08 $l=3.15e-08 $layer=M1 $thickness=3.6e-08 $X=0.027
+ $Y=0.072 $X2=0.027 $Y2=0.1035
r3 5 9 3.1337 $w=1.54324e-08 $l=1.85e-08 $layer=M1 $thickness=3.6e-08 $X=0.027
+ $Y=0.135 $X2=0.0455 $Y2=0.135
r4 5 7 6.16517 $w=1.44286e-08 $l=3.15e-08 $layer=M1 $thickness=3.6e-08 $X=0.027
+ $Y=0.135 $X2=0.027 $Y2=0.1035
r5 5 8 6.16517 $w=1.44286e-08 $l=3.15e-08 $layer=M1 $thickness=3.6e-08 $X=0.027
+ $Y=0.135 $X2=0.027 $Y2=0.1665
r6 22 9 4.31401 $w=1.3e-08 $l=1.85e-08 $layer=M1 $thickness=3.6e-08 $X=0.061
+ $Y=0.1365 $X2=0.0455 $Y2=0.135
r7 22 20 19.3796 $a=3.24e-16 $layer=V0LIG $X=0.061 $Y=0.1365 $X2=0.063 $Y2=0.135
r8 1 18 2.6116 $w=2.2e-08 $l=1e-08 $layer=LIG $thickness=4.8e-08 $X=0.072
+ $Y=0.135 $X2=0.082 $Y2=0.135
r9 1 20 4.98695 $w=1.60444e-08 $l=9e-09 $layer=LIG $thickness=4.8e-08 $X=0.072
+ $Y=0.135 $X2=0.063 $Y2=0.135
r10 16 15 14.6259 $w=2.1e-08 $l=4.3e-08 $layer=Gate_1 $thickness=5.6e-08
+ $X=0.081 $Y=0.2025 $X2=0.081 $Y2=0.1595
r11 14 15 2.7211 $w=2.1e-08 $l=8e-09 $layer=Gate_1 $thickness=5.6e-08 $X=0.081
+ $Y=0.1515 $X2=0.081 $Y2=0.1595
r12 13 14 5.79936 $w=2.03333e-08 $l=1.65e-08 $layer=Gate_1 $thickness=5.6e-08
+ $X=0.081 $Y=0.135 $X2=0.081 $Y2=0.1515
r13 13 18 6.27904 $w=2.09e-08 $l=1e-09 $layer=Gate_1 $thickness=5.24e-08
+ $X=0.081 $Y=0.135 $X2=0.082 $Y2=0.135
r14 12 13 5.79936 $w=2.03333e-08 $l=1.65e-08 $layer=Gate_1 $thickness=5.6e-08
+ $X=0.081 $Y=0.1185 $X2=0.081 $Y2=0.135
r15 11 12 2.7211 $w=2.1e-08 $l=8e-09 $layer=Gate_1 $thickness=5.6e-08 $X=0.081
+ $Y=0.1105 $X2=0.081 $Y2=0.1185
r16 10 11 14.6259 $w=2.1e-08 $l=4.3e-08 $layer=Gate_1 $thickness=5.6e-08
+ $X=0.081 $Y=0.0675 $X2=0.081 $Y2=0.1105
r17 10 3 14.6259 $w=2.1e-08 $l=4.3e-08 $layer=Gate_1 $thickness=5.6e-08
+ $X=0.081 $Y=0.0675 $X2=0.081 $Y2=0.0245
.ends

.subckt PM_BUFx5_ASAP7_75t_R%Y vss 45 32 33 43 44 50 59 62 63 66 67 22 19 20 23
+ 27 28 5 6 24 3 4 29 1 2 21
c1 1 vss 0.00852447f $X=0.162 $Y=0.0675
c2 2 vss 0.0085631f $X=0.162 $Y=0.2025
c3 3 vss 0.00856124f $X=0.27 $Y=0.0675
c4 4 vss 0.00856124f $X=0.27 $Y=0.2025
c5 5 vss 0.00792578f $X=0.378 $Y=0.0675
c6 6 vss 0.00792578f $X=0.378 $Y=0.2025
c7 19 vss 0.0043806f $X=0.1475 $Y=0.0675
c8 20 vss 0.004383f $X=0.2555 $Y=0.0675
c9 21 vss 0.0367268f $X=0.3635 $Y=0.0675
c10 22 vss 0.00441517f $X=0.1475 $Y=0.2025
c11 23 vss 0.00441523f $X=0.2555 $Y=0.2025
c12 24 vss 0.0367364f $X=0.3635 $Y=0.2025
c13 25 vss 0.00261439f $X=0.405 $Y=0.036
c14 26 vss 0.00261439f $X=0.405 $Y=0.234
c15 27 vss 0.0218429f $X=0.149 $Y=0.036
c16 28 vss 0.0218429f $X=0.3685 $Y=0.234
c17 29 vss 0.00431449f $X=0.405 $Y=0.0795
r1 66 65 0.0308642 $w=8.1e-08 $l=2.5e-09 $layer=P_src_drn $thickness=1e-09
+ $X=0.2873 $Y=0.2025 $X2=0.2845 $Y2=0.2025
r2 4 65 0.179012 $w=8.1e-08 $l=1.45e-08 $layer=P_src_drn $thickness=1e-09
+ $X=0.27 $Y=0.2025 $X2=0.2845 $Y2=0.2025
r3 23 4 0.179012 $w=8.1e-08 $l=1.45e-08 $layer=P_src_drn $thickness=1e-09
+ $X=0.2555 $Y=0.2025 $X2=0.27 $Y2=0.2025
r4 67 23 0.0308642 $w=8.1e-08 $l=2.5e-09 $layer=P_src_drn $thickness=1e-09
+ $X=0.2526 $Y=0.2025 $X2=0.2555 $Y2=0.2025
r5 63 61 0.0308642 $w=8.1e-08 $l=2.5e-09 $layer=P_src_drn $thickness=1e-09
+ $X=0.1793 $Y=0.2025 $X2=0.1765 $Y2=0.2025
r6 2 61 0.179012 $w=8.1e-08 $l=1.45e-08 $layer=P_src_drn $thickness=1e-09
+ $X=0.162 $Y=0.2025 $X2=0.1765 $Y2=0.2025
r7 22 2 0.179012 $w=8.1e-08 $l=1.45e-08 $layer=P_src_drn $thickness=1e-09
+ $X=0.1475 $Y=0.2025 $X2=0.162 $Y2=0.2025
r8 62 22 0.0308642 $w=8.1e-08 $l=2.5e-09 $layer=P_src_drn $thickness=1e-09
+ $X=0.1446 $Y=0.2025 $X2=0.1475 $Y2=0.2025
r9 24 6 0.154321 $w=8.1e-08 $l=1.25e-08 $layer=P_src_drn $thickness=1e-09
+ $X=0.3635 $Y=0.2025 $X2=0.378 $Y2=0.2025
r10 59 24 0.0308642 $w=8.1e-08 $l=2.5e-09 $layer=P_src_drn $thickness=1e-09
+ $X=0.3606 $Y=0.2025 $X2=0.3635 $Y2=0.2025
r11 4 56 19.3796 $a=3.24e-16 $layer=V0LISD $X=0.27 $Y=0.2025 $X2=0.27 $Y2=0.234
r12 2 54 19.3796 $a=3.24e-16 $layer=V0LISD $X=0.162 $Y=0.2025 $X2=0.162
+ $Y2=0.234
r13 6 51 19.3796 $a=3.24e-16 $layer=V0LISD $X=0.378 $Y=0.2025 $X2=0.378
+ $Y2=0.234
r14 56 57 12.4757 $w=1.3e-08 $l=5.35e-08 $layer=M1 $thickness=3.6e-08 $X=0.27
+ $Y=0.234 $X2=0.3235 $Y2=0.234
r15 55 56 12.5922 $w=1.3e-08 $l=5.4e-08 $layer=M1 $thickness=3.6e-08 $X=0.216
+ $Y=0.234 $X2=0.27 $Y2=0.234
r16 54 55 12.5922 $w=1.3e-08 $l=5.4e-08 $layer=M1 $thickness=3.6e-08 $X=0.162
+ $Y=0.234 $X2=0.216 $Y2=0.234
r17 51 52 3.14806 $w=1.3e-08 $l=1.35e-08 $layer=M1 $thickness=3.6e-08 $X=0.378
+ $Y=0.234 $X2=0.3915 $Y2=0.234
r18 28 51 2.2153 $w=1.3e-08 $l=9.5e-09 $layer=M1 $thickness=3.6e-08 $X=0.3685
+ $Y=0.234 $X2=0.378 $Y2=0.234
r19 28 57 10.4935 $w=1.3e-08 $l=4.5e-08 $layer=M1 $thickness=3.6e-08 $X=0.3685
+ $Y=0.234 $X2=0.3235 $Y2=0.234
r20 26 48 9.89378 $w=1.47818e-08 $l=4.95e-08 $layer=M1 $thickness=3.6e-08
+ $X=0.405 $Y=0.234 $X2=0.405 $Y2=0.1845
r21 26 52 1.49895 $w=1.63333e-08 $l=1.35e-08 $layer=M1 $thickness=3.6e-08
+ $X=0.405 $Y=0.234 $X2=0.3915 $Y2=0.234
r22 21 5 0.154321 $w=8.1e-08 $l=1.25e-08 $layer=N_src_drn $thickness=1e-09
+ $X=0.3635 $Y=0.0675 $X2=0.378 $Y2=0.0675
r23 50 21 0.0308642 $w=8.1e-08 $l=2.5e-09 $layer=N_src_drn $thickness=1e-09
+ $X=0.3606 $Y=0.0675 $X2=0.3635 $Y2=0.0675
r24 47 48 11.5429 $w=1.3e-08 $l=4.95e-08 $layer=M1 $thickness=3.6e-08 $X=0.405
+ $Y=0.135 $X2=0.405 $Y2=0.1845
r25 46 47 3.38125 $w=1.3e-08 $l=1.45e-08 $layer=M1 $thickness=3.6e-08 $X=0.405
+ $Y=0.1205 $X2=0.405 $Y2=0.135
r26 45 46 1.39914 $w=1.3e-08 $l=6e-09 $layer=M1 $thickness=3.6e-08 $X=0.4075
+ $Y=0.1145 $X2=0.405 $Y2=0.1205
r27 45 29 8.16164 $w=1.3e-08 $l=3.5e-08 $layer=M1 $thickness=3.6e-08 $X=0.4075
+ $Y=0.1145 $X2=0.405 $Y2=0.0795
r28 44 42 0.0308642 $w=8.1e-08 $l=2.5e-09 $layer=N_src_drn $thickness=1e-09
+ $X=0.2873 $Y=0.0675 $X2=0.2845 $Y2=0.0675
r29 3 42 0.179012 $w=8.1e-08 $l=1.45e-08 $layer=N_src_drn $thickness=1e-09
+ $X=0.27 $Y=0.0675 $X2=0.2845 $Y2=0.0675
r30 20 3 0.179012 $w=8.1e-08 $l=1.45e-08 $layer=N_src_drn $thickness=1e-09
+ $X=0.2555 $Y=0.0675 $X2=0.27 $Y2=0.0675
r31 43 20 0.0308642 $w=8.1e-08 $l=2.5e-09 $layer=N_src_drn $thickness=1e-09
+ $X=0.2526 $Y=0.0675 $X2=0.2555 $Y2=0.0675
r32 5 39 19.3796 $a=3.24e-16 $layer=V0LISD $X=0.378 $Y=0.0675 $X2=0.378
+ $Y2=0.036
r33 25 40 1.49895 $w=1.63333e-08 $l=1.35e-08 $layer=M1 $thickness=3.6e-08
+ $X=0.405 $Y=0.036 $X2=0.3915 $Y2=0.036
r34 25 29 8.49464 $w=1.50276e-08 $l=4.35e-08 $layer=M1 $thickness=3.6e-08
+ $X=0.405 $Y=0.036 $X2=0.405 $Y2=0.0795
r35 3 36 19.3796 $a=3.24e-16 $layer=V0LISD $X=0.27 $Y=0.0675 $X2=0.27 $Y2=0.036
r36 39 40 3.14806 $w=1.3e-08 $l=1.35e-08 $layer=M1 $thickness=3.6e-08 $X=0.378
+ $Y=0.036 $X2=0.3915 $Y2=0.036
r37 38 39 2.2153 $w=1.3e-08 $l=9.5e-09 $layer=M1 $thickness=3.6e-08 $X=0.3685
+ $Y=0.036 $X2=0.378 $Y2=0.036
r38 37 38 10.4935 $w=1.3e-08 $l=4.5e-08 $layer=M1 $thickness=3.6e-08 $X=0.3235
+ $Y=0.036 $X2=0.3685 $Y2=0.036
r39 36 37 12.4757 $w=1.3e-08 $l=5.35e-08 $layer=M1 $thickness=3.6e-08 $X=0.27
+ $Y=0.036 $X2=0.3235 $Y2=0.036
r40 35 36 12.5922 $w=1.3e-08 $l=5.4e-08 $layer=M1 $thickness=3.6e-08 $X=0.216
+ $Y=0.036 $X2=0.27 $Y2=0.036
r41 34 35 12.5922 $w=1.3e-08 $l=5.4e-08 $layer=M1 $thickness=3.6e-08 $X=0.162
+ $Y=0.036 $X2=0.216 $Y2=0.036
r42 27 34 3.03147 $w=1.3e-08 $l=1.3e-08 $layer=M1 $thickness=3.6e-08 $X=0.149
+ $Y=0.036 $X2=0.162 $Y2=0.036
r43 1 34 19.3796 $a=3.24e-16 $layer=V0LISD $X=0.162 $Y=0.0675 $X2=0.162
+ $Y2=0.036
r44 33 31 0.0308642 $w=8.1e-08 $l=2.5e-09 $layer=N_src_drn $thickness=1e-09
+ $X=0.1793 $Y=0.0675 $X2=0.1765 $Y2=0.0675
r45 1 31 0.179012 $w=8.1e-08 $l=1.45e-08 $layer=N_src_drn $thickness=1e-09
+ $X=0.162 $Y=0.0675 $X2=0.1765 $Y2=0.0675
r46 19 1 0.179012 $w=8.1e-08 $l=1.45e-08 $layer=N_src_drn $thickness=1e-09
+ $X=0.1475 $Y=0.0675 $X2=0.162 $Y2=0.0675
r47 32 19 0.0308642 $w=8.1e-08 $l=2.5e-09 $layer=N_src_drn $thickness=1e-09
+ $X=0.1446 $Y=0.0675 $X2=0.1475 $Y2=0.0675
.ends

.subckt PM_BUFx5_ASAP7_75t_R%4 vss 32 36 50 53 56 59 63 67 74 77 88 90 11 12 29
+ 30 17 25 27 28 22 23 26 1 21 24 3 2 4 18 20 5 31 19
c1 1 vss 0.0037145f $X=0.135 $Y=0.135
c2 2 vss 0.00342856f $X=0.189 $Y=0.135
c3 3 vss 0.00367002f $X=0.243 $Y=0.135
c4 4 vss 0.00342856f $X=0.297 $Y=0.135
c5 5 vss 0.00358218f $X=0.351 $Y=0.135
c6 11 vss 0.00989109f $X=0.054 $Y=0.0675
c7 12 vss 0.00989109f $X=0.054 $Y=0.2025
c8 17 vss 0.0813026f $X=0.135 $Y=0.135
c9 18 vss 0.0806024f $X=0.189 $Y=0.135
c10 19 vss 0.0804776f $X=0.243 $Y=0.135
c11 20 vss 0.0806605f $X=0.297 $Y=0.0245
c12 21 vss 0.0924552f $X=0.351 $Y=0.135
c13 22 vss 0.0470438f $X=0.056 $Y=0.0675
c14 23 vss 0.0469264f $X=0.056 $Y=0.2025
c15 24 vss 0.00286467f $X=0.111 $Y=0.036
c16 25 vss 0.000342391f $X=0.111 $Y=0.135
c17 26 vss 0.00286467f $X=0.111 $Y=0.234
c18 27 vss 0.00929908f $X=0.0875 $Y=0.036
c19 28 vss 0.00929908f $X=0.0875 $Y=0.234
c20 29 vss 0.00487921f $X=0.111 $Y=0.1035
c21 30 vss 0.00487921f $X=0.111 $Y=0.1665
c22 31 vss 0.0132339f $X=0.1625 $Y=0.135
r1 90 89 0.0308642 $w=8.1e-08 $l=2.5e-09 $layer=P_src_drn $thickness=1e-09
+ $X=0.0713 $Y=0.2025 $X2=0.0685 $Y2=0.2025
r2 23 89 0.154321 $w=8.1e-08 $l=1.25e-08 $layer=P_src_drn $thickness=1e-09
+ $X=0.056 $Y=0.2025 $X2=0.0685 $Y2=0.2025
r3 88 87 0.0308642 $w=8.1e-08 $l=2.5e-09 $layer=N_src_drn $thickness=1e-09
+ $X=0.0713 $Y=0.0675 $X2=0.0685 $Y2=0.0675
r4 22 87 0.154321 $w=8.1e-08 $l=1.25e-08 $layer=N_src_drn $thickness=1e-09
+ $X=0.056 $Y=0.0675 $X2=0.0685 $Y2=0.0675
r5 12 86 19.3796 $a=3.24e-16 $layer=V0LISD $X=0.054 $Y=0.2025 $X2=0.05 $Y2=0.234
r6 11 82 19.3796 $a=3.24e-16 $layer=V0LISD $X=0.054 $Y=0.0675 $X2=0.05 $Y2=0.036
r7 83 84 2.09871 $w=1.3e-08 $l=9e-09 $layer=M1 $thickness=3.6e-08 $X=0.059
+ $Y=0.234 $X2=0.068 $Y2=0.234
r8 83 86 2.09871 $w=1.3e-08 $l=9e-09 $layer=M1 $thickness=3.6e-08 $X=0.059
+ $Y=0.234 $X2=0.05 $Y2=0.234
r9 28 84 4.5472 $w=1.3e-08 $l=1.95e-08 $layer=M1 $thickness=3.6e-08 $X=0.0875
+ $Y=0.234 $X2=0.068 $Y2=0.234
r10 79 80 2.09871 $w=1.3e-08 $l=9e-09 $layer=M1 $thickness=3.6e-08 $X=0.059
+ $Y=0.036 $X2=0.068 $Y2=0.036
r11 79 82 2.09871 $w=1.3e-08 $l=9e-09 $layer=M1 $thickness=3.6e-08 $X=0.059
+ $Y=0.036 $X2=0.05 $Y2=0.036
r12 27 80 4.5472 $w=1.3e-08 $l=1.95e-08 $layer=M1 $thickness=3.6e-08 $X=0.0875
+ $Y=0.036 $X2=0.068 $Y2=0.036
r13 26 72 2.5483 $w=1.79e-08 $l=1.8e-08 $layer=M1 $thickness=3.6e-08 $X=0.111
+ $Y=0.234 $X2=0.111 $Y2=0.216
r14 26 28 3.83085 $w=1.49149e-08 $l=2.35e-08 $layer=M1 $thickness=3.6e-08
+ $X=0.111 $Y=0.234 $X2=0.0875 $Y2=0.234
r15 24 70 2.5483 $w=1.79e-08 $l=1.8e-08 $layer=M1 $thickness=3.6e-08 $X=0.111
+ $Y=0.036 $X2=0.111 $Y2=0.054
r16 24 27 3.83085 $w=1.49149e-08 $l=2.35e-08 $layer=M1 $thickness=3.6e-08
+ $X=0.111 $Y=0.036 $X2=0.0875 $Y2=0.036
r17 77 76 16.4967 $w=2.1e-08 $l=4.85e-08 $layer=Gate_1 $thickness=5.6e-08
+ $X=0.135 $Y=0.2025 $X2=0.135 $Y2=0.154
r18 74 75 16.4967 $w=2.1e-08 $l=4.85e-08 $layer=Gate_1 $thickness=5.6e-08
+ $X=0.135 $Y=0.0675 $X2=0.135 $Y2=0.116
r19 17 75 6.6497 $w=2.04211e-08 $l=1.9e-08 $layer=Gate_1 $thickness=5.6e-08
+ $X=0.135 $Y=0.135 $X2=0.135 $Y2=0.116
r20 17 76 6.6497 $w=2.04211e-08 $l=1.9e-08 $layer=Gate_1 $thickness=5.6e-08
+ $X=0.135 $Y=0.135 $X2=0.135 $Y2=0.154
r21 71 72 4.19742 $w=1.3e-08 $l=1.8e-08 $layer=M1 $thickness=3.6e-08 $X=0.111
+ $Y=0.198 $X2=0.111 $Y2=0.216
r22 30 71 7.34548 $w=1.3e-08 $l=3.15e-08 $layer=M1 $thickness=3.6e-08 $X=0.111
+ $Y=0.1665 $X2=0.111 $Y2=0.198
r23 69 70 4.19742 $w=1.3e-08 $l=1.8e-08 $layer=M1 $thickness=3.6e-08 $X=0.111
+ $Y=0.072 $X2=0.111 $Y2=0.054
r24 29 69 7.34548 $w=1.3e-08 $l=3.15e-08 $layer=M1 $thickness=3.6e-08 $X=0.111
+ $Y=0.1035 $X2=0.111 $Y2=0.072
r25 67 66 14.6259 $w=2.1e-08 $l=4.3e-08 $layer=Gate_1 $thickness=5.6e-08
+ $X=0.351 $Y=0.2025 $X2=0.351 $Y2=0.1595
r26 65 66 2.7211 $w=2.1e-08 $l=8e-09 $layer=Gate_1 $thickness=5.6e-08 $X=0.351
+ $Y=0.1515 $X2=0.351 $Y2=0.1595
r27 63 64 14.6259 $w=2.1e-08 $l=4.3e-08 $layer=Gate_1 $thickness=5.6e-08
+ $X=0.351 $Y=0.0675 $X2=0.351 $Y2=0.1105
r28 61 64 2.7211 $w=2.1e-08 $l=8e-09 $layer=Gate_1 $thickness=5.6e-08 $X=0.351
+ $Y=0.1185 $X2=0.351 $Y2=0.1105
r29 21 61 5.79936 $w=2.03333e-08 $l=1.65e-08 $layer=Gate_1 $thickness=5.6e-08
+ $X=0.351 $Y=0.135 $X2=0.351 $Y2=0.1185
r30 21 65 5.79936 $w=2.03333e-08 $l=1.65e-08 $layer=Gate_1 $thickness=5.6e-08
+ $X=0.351 $Y=0.135 $X2=0.351 $Y2=0.1515
r31 59 58 16.4967 $w=2.1e-08 $l=4.85e-08 $layer=Gate_1 $thickness=5.6e-08
+ $X=0.243 $Y=0.2025 $X2=0.243 $Y2=0.154
r32 56 57 16.4967 $w=2.1e-08 $l=4.85e-08 $layer=Gate_1 $thickness=5.6e-08
+ $X=0.243 $Y=0.0675 $X2=0.243 $Y2=0.116
r33 19 57 6.6497 $w=2.04211e-08 $l=1.9e-08 $layer=Gate_1 $thickness=5.6e-08
+ $X=0.243 $Y=0.135 $X2=0.243 $Y2=0.116
r34 19 58 6.6497 $w=2.04211e-08 $l=1.9e-08 $layer=Gate_1 $thickness=5.6e-08
+ $X=0.243 $Y=0.135 $X2=0.243 $Y2=0.154
r35 53 52 16.4967 $w=2.1e-08 $l=4.85e-08 $layer=Gate_1 $thickness=5.6e-08
+ $X=0.189 $Y=0.2025 $X2=0.189 $Y2=0.154
r36 50 51 16.4967 $w=2.1e-08 $l=4.85e-08 $layer=Gate_1 $thickness=5.6e-08
+ $X=0.189 $Y=0.0675 $X2=0.189 $Y2=0.116
r37 18 51 6.6497 $w=2.04211e-08 $l=1.9e-08 $layer=Gate_1 $thickness=5.6e-08
+ $X=0.189 $Y=0.135 $X2=0.189 $Y2=0.116
r38 18 52 6.6497 $w=2.04211e-08 $l=1.9e-08 $layer=Gate_1 $thickness=5.6e-08
+ $X=0.189 $Y=0.135 $X2=0.189 $Y2=0.154
r39 1 47 19.3796 $a=3.24e-16 $layer=V0LIG $X=0.135 $Y=0.135 $X2=0.135 $Y2=0.135
r40 1 17 10.4265 $w=1.765e-08 $layer=LIG $thickness=5.2e-08 $X=0.135 $Y=0.135
+ $X2=0.135 $Y2=0.135
r41 25 46 1.61797 $w=1.675e-08 $l=1.2e-08 $layer=M1 $thickness=3.6e-08 $X=0.111
+ $Y=0.135 $X2=0.123 $Y2=0.135
r42 25 29 6.16517 $w=1.44286e-08 $l=3.15e-08 $layer=M1 $thickness=3.6e-08
+ $X=0.111 $Y=0.135 $X2=0.111 $Y2=0.1035
r43 25 30 6.16517 $w=1.44286e-08 $l=3.15e-08 $layer=M1 $thickness=3.6e-08
+ $X=0.111 $Y=0.135 $X2=0.111 $Y2=0.1665
r44 5 44 19.3796 $a=3.24e-16 $layer=V0LIG $X=0.351 $Y=0.135 $X2=0.351 $Y2=0.135
r45 5 21 10.4265 $w=1.765e-08 $layer=LIG $thickness=5.2e-08 $X=0.351 $Y=0.135
+ $X2=0.351 $Y2=0.135
r46 3 40 19.3796 $a=3.24e-16 $layer=V0LIG $X=0.243 $Y=0.135 $X2=0.243 $Y2=0.135
r47 3 19 10.4265 $w=1.765e-08 $layer=LIG $thickness=5.2e-08 $X=0.243 $Y=0.135
+ $X2=0.243 $Y2=0.135
r48 2 38 19.3796 $a=3.24e-16 $layer=V0LIG $X=0.189 $Y=0.135 $X2=0.189 $Y2=0.135
r49 2 18 10.4265 $w=1.765e-08 $layer=LIG $thickness=5.2e-08 $X=0.189 $Y=0.135
+ $X2=0.189 $Y2=0.135
r50 47 48 2.2153 $w=1.3e-08 $l=9.5e-09 $layer=M1 $thickness=3.6e-08 $X=0.135
+ $Y=0.135 $X2=0.1445 $Y2=0.135
r51 46 47 2.79828 $w=1.3e-08 $l=1.2e-08 $layer=M1 $thickness=3.6e-08 $X=0.123
+ $Y=0.135 $X2=0.135 $Y2=0.135
r52 43 44 6.29612 $w=1.3e-08 $l=2.7e-08 $layer=M1 $thickness=3.6e-08 $X=0.324
+ $Y=0.135 $X2=0.351 $Y2=0.135
r53 42 43 6.29612 $w=1.3e-08 $l=2.7e-08 $layer=M1 $thickness=3.6e-08 $X=0.297
+ $Y=0.135 $X2=0.324 $Y2=0.135
r54 41 42 6.29612 $w=1.3e-08 $l=2.7e-08 $layer=M1 $thickness=3.6e-08 $X=0.27
+ $Y=0.135 $X2=0.297 $Y2=0.135
r55 40 41 6.29612 $w=1.3e-08 $l=2.7e-08 $layer=M1 $thickness=3.6e-08 $X=0.243
+ $Y=0.135 $X2=0.27 $Y2=0.135
r56 39 40 6.29612 $w=1.3e-08 $l=2.7e-08 $layer=M1 $thickness=3.6e-08 $X=0.216
+ $Y=0.135 $X2=0.243 $Y2=0.135
r57 38 39 6.29612 $w=1.3e-08 $l=2.7e-08 $layer=M1 $thickness=3.6e-08 $X=0.189
+ $Y=0.135 $X2=0.216 $Y2=0.135
r58 31 38 6.17953 $w=1.3e-08 $l=2.65e-08 $layer=M1 $thickness=3.6e-08 $X=0.1625
+ $Y=0.135 $X2=0.189 $Y2=0.135
r59 31 48 4.19742 $w=1.3e-08 $l=1.8e-08 $layer=M1 $thickness=3.6e-08 $X=0.1625
+ $Y=0.135 $X2=0.1445 $Y2=0.135
r60 4 34 10.4265 $w=1.765e-08 $layer=LIG $thickness=5.2e-08 $X=0.297 $Y=0.135
+ $X2=0.297 $Y2=0.135
r61 4 42 19.3796 $a=3.24e-16 $layer=V0LIG $X=0.297 $Y=0.135 $X2=0.297 $Y2=0.135
r62 36 35 16.4967 $w=2.1e-08 $l=4.85e-08 $layer=Gate_1 $thickness=5.6e-08
+ $X=0.297 $Y=0.2025 $X2=0.297 $Y2=0.154
r63 34 35 6.6497 $w=2.04211e-08 $l=1.9e-08 $layer=Gate_1 $thickness=5.6e-08
+ $X=0.297 $Y=0.135 $X2=0.297 $Y2=0.154
r64 33 34 6.6497 $w=2.04211e-08 $l=1.9e-08 $layer=Gate_1 $thickness=5.6e-08
+ $X=0.297 $Y=0.116 $X2=0.297 $Y2=0.135
r65 32 33 16.4967 $w=2.1e-08 $l=4.85e-08 $layer=Gate_1 $thickness=5.6e-08
+ $X=0.297 $Y=0.0675 $X2=0.297 $Y2=0.116
r66 32 20 14.6259 $w=2.1e-08 $l=4.3e-08 $layer=Gate_1 $thickness=5.6e-08
+ $X=0.297 $Y=0.0675 $X2=0.297 $Y2=0.0245
r67 12 23 1e-05 $l=2e-09 $X=0.054 $Y=0.2025 $X2=0.056 $Y2=0.2025
r68 11 22 1e-05 $l=2e-09 $X=0.054 $Y=0.0675 $X2=0.056 $Y2=0.0675
.ends

* End of included file BUFx5_ASAP7_75t_R.pex.sp.pex

*
.subckt BUFx5_ASAP7_75t_CUSTOM_4_25_0_7 VSS VDD A Y
*
* VSS VSS
* VDD VDD
* A A
* Y Y
*
*

M0 VSS N_M0_g N_M0_s VSS nmos_rvt L=2e-08 W=8.1e-08 nfin=3 $X=0.071 $Y=0.027
M1 N_M1_d N_M1_g VSS VSS nmos_rvt L=2e-08 W=8.1e-08 nfin=3 $X=0.125 $Y=0.027
M2 N_M2_d N_M2_g VSS VSS nmos_rvt L=2e-08 W=8.1e-08 nfin=3 $X=0.179 $Y=0.027
M3 N_M3_d N_M3_g VSS VSS nmos_rvt L=2e-08 W=8.1e-08 nfin=3 $X=0.233 $Y=0.027
M4 N_M4_d N_M4_g VSS VSS nmos_rvt L=2e-08 W=8.1e-08 nfin=3 $X=0.287 $Y=0.027
M5 N_M5_d N_M5_g VSS VSS nmos_rvt L=2e-08 W=8.1e-08 nfin=3 $X=0.341 $Y=0.027
M6 VDD N_M6_g N_M6_s VDD pmos_rvt L=2e-08 W=8.1e-08 nfin=3 $X=0.071 $Y=0.162
M7 N_M7_d N_M7_g VDD VDD pmos_rvt L=2e-08 W=8.1e-08 nfin=3 $X=0.125 $Y=0.162
M8 N_M8_d N_M8_g VDD VDD pmos_rvt L=2e-08 W=8.1e-08 nfin=3 $X=0.179 $Y=0.162
M9 N_M9_d N_M9_g VDD VDD pmos_rvt L=2e-08 W=8.1e-08 nfin=3 $X=0.233 $Y=0.162
M10 N_M10_d N_M10_g VDD VDD pmos_rvt L=2e-08 W=8.1e-08 nfin=3 $X=0.287 $Y=0.162
M11 N_M11_d N_M11_g VDD VDD pmos_rvt L=2e-08 W=8.1e-08 nfin=3 $X=0.341 $Y=0.162

* .include "BUFx5_ASAP7_75t_R.pex.sp.pxi"

* Start of included file BUFx5_ASAP7_75t_R.pex.sp.pxi
x_PM_BUFx5_ASAP7_75t_R%A vss A N_M0_g N_M6_g N_A_3 N_A_9 N_A_4 N_A_6 N_A_1
+ PM_BUFx5_ASAP7_75t_R%A
x_PM_BUFx5_ASAP7_75t_R%Y vss Y N_M1_d N_M2_d N_M3_d N_M4_d N_M5_d N_M11_d
+ N_M7_d N_M8_d N_M10_d N_M9_d N_Y_22 N_Y_19 N_Y_20 N_Y_23 N_Y_27 N_Y_28 N_Y_5
+ N_Y_6 N_Y_24 N_Y_3 N_Y_4 N_Y_29 N_Y_1 N_Y_2 N_Y_21 PM_BUFx5_ASAP7_75t_R%Y
cc_1 N_Y_22 N_4_26 0.000875262f $X=0.1475 $Y=0.2025
cc_2 N_Y_22 N_4_1 0.00207343f $X=0.1475 $Y=0.2025
cc_3 N_Y_22 N_4_21 0.000830196f $X=0.1475 $Y=0.2025
cc_4 N_Y_22 N_4_24 0.000497202f $X=0.1475 $Y=0.2025
cc_5 N_Y_22 N_4_3 0.000543077f $X=0.1475 $Y=0.2025
cc_6 N_Y_22 N_4_2 0.00205363f $X=0.1475 $Y=0.2025
cc_7 N_Y_22 N_4_4 0.000720626f $X=0.1475 $Y=0.2025
cc_8 N_Y_19 N_4_18 0.0189773f $X=0.1475 $Y=0.0675
cc_9 N_Y_20 N_4_20 0.0189724f $X=0.2555 $Y=0.0675
cc_10 N_Y_23 N_4_20 0.0373832f $X=0.2555 $Y=0.2025
cc_11 N_Y_27 N_4_29 0.000949068f $X=0.149 $Y=0.036
cc_12 N_Y_28 N_4_30 0.000949068f $X=0.3685 $Y=0.234
cc_13 N_Y_5 N_4_21 0.000979124f $X=0.378 $Y=0.0675
cc_14 N_Y_6 N_4_21 0.000979124f $X=0.378 $Y=0.2025
cc_15 N_Y_5 N_4_5 0.0010232f $X=0.378 $Y=0.0675
cc_16 N_Y_23 N_4_4 0.001333f $X=0.2555 $Y=0.2025
cc_17 N_Y_23 N_4_3 0.00166881f $X=0.2555 $Y=0.2025
cc_18 N_Y_24 N_4_5 0.00166881f $X=0.3635 $Y=0.2025
cc_19 N_Y_3 N_4_20 0.00170752f $X=0.27 $Y=0.0675
cc_20 N_Y_4 N_4_20 0.00170752f $X=0.27 $Y=0.2025
cc_21 N_Y_29 N_4_31 0.00179504f $X=0.405 $Y=0.0795
cc_22 N_Y_1 N_4_18 0.00192284f $X=0.162 $Y=0.0675
cc_23 N_Y_2 N_4_18 0.00192284f $X=0.162 $Y=0.2025
cc_24 N_Y_27 N_4_31 0.00243288f $X=0.149 $Y=0.036
cc_25 N_Y_28 N_4_31 0.00243288f $X=0.3685 $Y=0.234
cc_26 N_Y_21 N_4_21 0.0144014f $X=0.3635 $Y=0.0675
cc_27 N_Y_4 N_4_31 0.00524182f $X=0.27 $Y=0.2025
cc_28 N_Y_24 N_4_21 0.0513103f $X=0.3635 $Y=0.2025
cc_29 N_Y_19 N_4_17 0.0102738f $X=0.1475 $Y=0.0675
cc_30 N_Y_20 N_4_19 0.0102884f $X=0.2555 $Y=0.0675
cc_31 N_Y_23 N_4_19 0.0653933f $X=0.2555 $Y=0.2025
cc_32 N_Y_22 N_4_17 0.0552722f $X=0.1475 $Y=0.2025
cc_33 N_Y_22 N_4_18 0.0490248f $X=0.1475 $Y=0.2025
x_PM_BUFx5_ASAP7_75t_R%4 vss N_M4_g N_M10_g N_M2_g N_M8_g N_M3_g N_M9_g N_M5_g
+ N_M11_g N_M1_g N_M7_g N_M0_s N_M6_s N_4_11 N_4_12 N_4_29 N_4_30 N_4_17 N_4_25
+ N_4_27 N_4_28 N_4_22 N_4_23 N_4_26 N_4_1 N_4_21 N_4_24 N_4_3 N_4_2 N_4_4
+ N_4_18 N_4_20 N_4_5 N_4_31 N_4_19 PM_BUFx5_ASAP7_75t_R%4
cc_34 N_4_11 N_A_3 0.00342337f $X=0.054 $Y=0.0675
cc_35 N_4_12 N_A_3 0.00462635f $X=0.054 $Y=0.2025
cc_36 N_4_29 N_A_3 0.00100422f $X=0.111 $Y=0.1035
cc_37 N_4_30 N_A_3 0.00100422f $X=0.111 $Y=0.1665
cc_38 N_4_17 N_A_3 0.00166798f $X=0.135 $Y=0.135
cc_39 N_4_25 N_A_9 0.00188061f $X=0.111 $Y=0.135
cc_40 N_4_27 N_A_4 0.00346776f $X=0.0875 $Y=0.036
cc_41 N_4_28 N_A_6 0.00346776f $X=0.0875 $Y=0.234
cc_42 N_4_22 N_A_1 0.00419449f $X=0.056 $Y=0.0675
cc_43 N_4_22 N_A_3 0.0152664f $X=0.056 $Y=0.0675
cc_44 N_4_23 N_A_3 0.056522f $X=0.056 $Y=0.2025

* End of included file BUFx5_ASAP7_75t_R.pex.sp.pxi
.ends

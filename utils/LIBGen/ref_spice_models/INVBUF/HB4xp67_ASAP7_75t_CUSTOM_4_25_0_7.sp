.subckt PM_HB4xp67_ASAP7_75t_R%6 vss 2 3 1
c1 1 vss 0.00194056f $X=0.108 $Y=0.0405
r1 2 1 0.62963 $w=2.7e-08 $l=1.7e-08 $layer=N_src_drn $thickness=1e-09
+ $X=0.0906 $Y=0.0405 $X2=0.108 $Y2=0.0405
r2 3 1 0.62963 $w=2.7e-08 $l=1.7e-08 $layer=N_src_drn $thickness=1e-09
+ $X=0.1253 $Y=0.0405 $X2=0.108 $Y2=0.0405
.ends

.subckt PM_HB4xp67_ASAP7_75t_R%9 vss 2 3 1
c1 1 vss 0.00191835f $X=0.108 $Y=0.2295
r1 2 1 0.62963 $w=2.7e-08 $l=1.7e-08 $layer=P_src_drn $thickness=1e-09
+ $X=0.0906 $Y=0.2295 $X2=0.108 $Y2=0.2295
r2 3 1 0.62963 $w=2.7e-08 $l=1.7e-08 $layer=P_src_drn $thickness=1e-09
+ $X=0.1253 $Y=0.2295 $X2=0.108 $Y2=0.2295
.ends

.subckt PM_HB4xp67_ASAP7_75t_R%10 vss 2 3 1
c1 1 vss 0.00381262f $X=0.162 $Y=0.2295
r1 2 1 0.62963 $w=2.7e-08 $l=1.7e-08 $layer=P_src_drn $thickness=1e-09
+ $X=0.1446 $Y=0.2295 $X2=0.162 $Y2=0.2295
r2 3 1 0.62963 $w=2.7e-08 $l=1.7e-08 $layer=P_src_drn $thickness=1e-09
+ $X=0.1793 $Y=0.2295 $X2=0.162 $Y2=0.2295
.ends

.subckt PM_HB4xp67_ASAP7_75t_R%11 vss 2 3 1
c1 1 vss 0.00214178f $X=0.216 $Y=0.2295
r1 2 1 0.62963 $w=2.7e-08 $l=1.7e-08 $layer=P_src_drn $thickness=1e-09
+ $X=0.1986 $Y=0.2295 $X2=0.216 $Y2=0.2295
r2 3 1 0.62963 $w=2.7e-08 $l=1.7e-08 $layer=P_src_drn $thickness=1e-09
+ $X=0.2333 $Y=0.2295 $X2=0.216 $Y2=0.2295
.ends

.subckt PM_HB4xp67_ASAP7_75t_R%A vss 52 13 19 35 38 41 44 47 50 1 10 11 7 9 3
+ 12 4 5 6
c1 1 vss 0.00515005f $X=0.0715 $Y=0.135
c2 3 vss 0.0182946f $X=0.081 $Y=0.0245
c3 4 vss 0.0128844f $X=0.135 $Y=0.135
c4 5 vss 0.0117646f $X=0.189 $Y=0.135
c5 6 vss 0.0783256f $X=0.243 $Y=0.135
c6 7 vss 0.00295611f $X=0.027 $Y=0.09
c7 8 vss 0.00098492f $X=0.027 $Y=0.135
c8 9 vss 0.00285688f $X=0.027 $Y=0.198
c9 10 vss 0.00170718f $X=0.027 $Y=0.1125
c10 11 vss 0.00272285f $X=0.027 $Y=0.15
c11 12 vss 0.00182428f $X=0.0635 $Y=0.135
r1 9 53 4.64944 $w=1.48e-08 $l=2.5e-08 $layer=M1 $thickness=3.6e-08 $X=0.027
+ $Y=0.198 $X2=0.027 $Y2=0.173
r2 7 10 4.06646 $w=1.5e-08 $l=2.25e-08 $layer=M1 $thickness=3.6e-08 $X=0.027
+ $Y=0.09 $X2=0.027 $Y2=0.1125
r3 52 53 3.84763 $w=1.3e-08 $l=1.65e-08 $layer=M1 $thickness=3.6e-08 $X=0.021
+ $Y=0.1565 $X2=0.027 $Y2=0.173
r4 52 11 1.51573 $w=1.3e-08 $l=6.5e-09 $layer=M1 $thickness=3.6e-08 $X=0.021
+ $Y=0.1565 $X2=0.027 $Y2=0.15
r5 8 33 3.1337 $w=1.54324e-08 $l=1.85e-08 $layer=M1 $thickness=3.6e-08 $X=0.027
+ $Y=0.135 $X2=0.0455 $Y2=0.135
r6 8 10 4.06646 $w=1.5e-08 $l=2.25e-08 $layer=M1 $thickness=3.6e-08 $X=0.027
+ $Y=0.135 $X2=0.027 $Y2=0.1125
r7 8 11 2.31754 $w=1.6e-08 $l=1.5e-08 $layer=M1 $thickness=3.6e-08 $X=0.027
+ $Y=0.135 $X2=0.027 $Y2=0.15
r8 50 49 16.4967 $w=2.1e-08 $l=4.85e-08 $layer=Gate_1 $thickness=5.6e-08
+ $X=0.243 $Y=0.2295 $X2=0.243 $Y2=0.181
r9 47 48 16.4967 $w=2.1e-08 $l=4.85e-08 $layer=Gate_1 $thickness=5.6e-08
+ $X=0.243 $Y=0.0405 $X2=0.243 $Y2=0.089
r10 6 29 6.54019 $w=2.09524e-08 $layer=Gate_1 $thickness=5.21905e-08 $X=0.243
+ $Y=0.135 $X2=0.243 $Y2=0.135
r11 6 48 15.8334 $w=2.07609e-08 $l=4.6e-08 $layer=Gate_1 $thickness=5.6e-08
+ $X=0.243 $Y=0.135 $X2=0.243 $Y2=0.089
r12 6 49 15.8334 $w=2.07609e-08 $l=4.6e-08 $layer=Gate_1 $thickness=5.6e-08
+ $X=0.243 $Y=0.135 $X2=0.243 $Y2=0.181
r13 44 43 16.4967 $w=2.1e-08 $l=4.85e-08 $layer=Gate_1 $thickness=5.6e-08
+ $X=0.189 $Y=0.2295 $X2=0.189 $Y2=0.181
r14 41 42 16.4967 $w=2.1e-08 $l=4.85e-08 $layer=Gate_1 $thickness=5.6e-08
+ $X=0.189 $Y=0.0405 $X2=0.189 $Y2=0.089
r15 5 27 6.54019 $w=2.09524e-08 $layer=Gate_1 $thickness=5.21905e-08 $X=0.189
+ $Y=0.135 $X2=0.189 $Y2=0.135
r16 5 42 15.8334 $w=2.07609e-08 $l=4.6e-08 $layer=Gate_1 $thickness=5.6e-08
+ $X=0.189 $Y=0.135 $X2=0.189 $Y2=0.089
r17 5 43 15.8334 $w=2.07609e-08 $l=4.6e-08 $layer=Gate_1 $thickness=5.6e-08
+ $X=0.189 $Y=0.135 $X2=0.189 $Y2=0.181
r18 38 37 16.4967 $w=2.1e-08 $l=4.85e-08 $layer=Gate_1 $thickness=5.6e-08
+ $X=0.135 $Y=0.2295 $X2=0.135 $Y2=0.181
r19 35 36 16.4967 $w=2.1e-08 $l=4.85e-08 $layer=Gate_1 $thickness=5.6e-08
+ $X=0.135 $Y=0.0405 $X2=0.135 $Y2=0.089
r20 4 25 6.54019 $w=2.09524e-08 $layer=Gate_1 $thickness=5.21905e-08 $X=0.135
+ $Y=0.135 $X2=0.135 $Y2=0.135
r21 4 36 15.8334 $w=2.07609e-08 $l=4.6e-08 $layer=Gate_1 $thickness=5.6e-08
+ $X=0.135 $Y=0.135 $X2=0.135 $Y2=0.089
r22 4 37 15.8334 $w=2.07609e-08 $l=4.6e-08 $layer=Gate_1 $thickness=5.6e-08
+ $X=0.135 $Y=0.135 $X2=0.135 $Y2=0.181
r23 12 31 4.08082 $w=1.3e-08 $l=1.75e-08 $layer=M1 $thickness=3.6e-08 $X=0.0635
+ $Y=0.135 $X2=0.081 $Y2=0.135
r24 12 33 4.19742 $w=1.3e-08 $l=1.8e-08 $layer=M1 $thickness=3.6e-08 $X=0.0635
+ $Y=0.135 $X2=0.0455 $Y2=0.135
r25 28 29 12.6539 $w=1.77815e-08 $l=2.7e-08 $layer=LIG $thickness=4.8e-08
+ $X=0.216 $Y=0.135 $X2=0.243 $Y2=0.135
r26 27 28 12.6539 $w=1.77815e-08 $l=2.7e-08 $layer=LIG $thickness=4.8e-08
+ $X=0.189 $Y=0.135 $X2=0.216 $Y2=0.135
r27 26 27 12.6539 $w=1.77815e-08 $l=2.7e-08 $layer=LIG $thickness=4.8e-08
+ $X=0.162 $Y=0.135 $X2=0.189 $Y2=0.135
r28 25 26 12.6539 $w=1.77815e-08 $l=2.7e-08 $layer=LIG $thickness=4.8e-08
+ $X=0.135 $Y=0.135 $X2=0.162 $Y2=0.135
r29 24 25 12.6539 $w=1.77815e-08 $l=2.7e-08 $layer=LIG $thickness=4.8e-08
+ $X=0.108 $Y=0.135 $X2=0.135 $Y2=0.135
r30 22 24 10.1729 $w=1.54914e-08 $l=1.75e-08 $layer=LIG $thickness=4.8e-08
+ $X=0.0905 $Y=0.135 $X2=0.108 $Y2=0.135
r31 21 22 2.48102 $w=2.2e-08 $l=9.5e-09 $layer=LIG $thickness=4.8e-08 $X=0.081
+ $Y=0.135 $X2=0.0905 $Y2=0.135
r32 21 31 19.3796 $a=3.24e-16 $layer=V0LIG $X=0.081 $Y=0.135 $X2=0.081 $Y2=0.135
r33 1 21 2.48102 $w=2.2e-08 $l=9.5e-09 $layer=LIG $thickness=4.8e-08 $X=0.0715
+ $Y=0.135 $X2=0.081 $Y2=0.135
r34 19 18 14.6259 $w=2.1e-08 $l=4.3e-08 $layer=Gate_1 $thickness=5.6e-08
+ $X=0.081 $Y=0.2295 $X2=0.081 $Y2=0.1865
r35 17 18 11.9048 $w=2.1e-08 $l=3.5e-08 $layer=Gate_1 $thickness=5.6e-08
+ $X=0.081 $Y=0.1515 $X2=0.081 $Y2=0.1865
r36 16 17 5.79936 $w=2.03333e-08 $l=1.65e-08 $layer=Gate_1 $thickness=5.6e-08
+ $X=0.081 $Y=0.135 $X2=0.081 $Y2=0.1515
r37 16 22 4.05918 $w=2.0087e-08 $l=9.5e-09 $layer=Gate_1 $thickness=5.56522e-08
+ $X=0.081 $Y=0.135 $X2=0.0905 $Y2=0.135
r38 16 21 6.27904 $w=2.09e-08 $layer=Gate_1 $thickness=5.24e-08 $X=0.081
+ $Y=0.135 $X2=0.081 $Y2=0.135
r39 15 16 5.79936 $w=2.03333e-08 $l=1.65e-08 $layer=Gate_1 $thickness=5.6e-08
+ $X=0.081 $Y=0.1185 $X2=0.081 $Y2=0.135
r40 14 15 11.9048 $w=2.1e-08 $l=3.5e-08 $layer=Gate_1 $thickness=5.6e-08
+ $X=0.081 $Y=0.0835 $X2=0.081 $Y2=0.1185
r41 13 14 14.6259 $w=2.1e-08 $l=4.3e-08 $layer=Gate_1 $thickness=5.6e-08
+ $X=0.081 $Y=0.0405 $X2=0.081 $Y2=0.0835
r42 13 3 5.44221 $w=2.1e-08 $l=1.6e-08 $layer=Gate_1 $thickness=5.6e-08
+ $X=0.081 $Y=0.0405 $X2=0.081 $Y2=0.0245
.ends

.subckt PM_HB4xp67_ASAP7_75t_R%Y vss 18 13 27 8 7 11
c1 1 vss 0.00812063f $X=0.324 $Y=0.054
c2 2 vss 0.00813715f $X=0.324 $Y=0.216
c3 7 vss 0.0289089f $X=0.3095 $Y=0.054
c4 8 vss 0.028818f $X=0.3095 $Y=0.216
c5 9 vss 0.00644292f $X=0.3105 $Y=0.036
c6 10 vss 0.00648213f $X=0.351 $Y=0.234
c7 11 vss 0.00705873f $X=0.351 $Y=0.0795
r1 8 2 0.231482 $w=5.4e-08 $l=1.25e-08 $layer=P_src_drn $thickness=1e-09
+ $X=0.3095 $Y=0.216 $X2=0.324 $Y2=0.216
r2 27 8 0.0462963 $w=5.4e-08 $l=2.5e-09 $layer=P_src_drn $thickness=1e-09
+ $X=0.3066 $Y=0.216 $X2=0.3095 $Y2=0.216
r3 2 23 19.3796 $a=3.24e-16 $layer=V0LISD $X=0.324 $Y=0.216 $X2=0.324 $Y2=0.234
r4 23 24 3.14806 $w=1.3e-08 $l=1.35e-08 $layer=M1 $thickness=3.6e-08 $X=0.324
+ $Y=0.234 $X2=0.3375 $Y2=0.234
r5 10 21 10.3626 $w=1.39091e-08 $l=4.95e-08 $layer=M1 $thickness=3.6e-08
+ $X=0.351 $Y=0.234 $X2=0.351 $Y2=0.1845
r6 10 24 1.96775 $w=1.63333e-08 $l=1.35e-08 $layer=M1 $thickness=3.6e-08
+ $X=0.351 $Y=0.234 $X2=0.3375 $Y2=0.234
r7 20 21 11.5429 $w=1.3e-08 $l=4.95e-08 $layer=M1 $thickness=3.6e-08 $X=0.351
+ $Y=0.135 $X2=0.351 $Y2=0.1845
r8 19 20 3.38125 $w=1.3e-08 $l=1.45e-08 $layer=M1 $thickness=3.6e-08 $X=0.351
+ $Y=0.1205 $X2=0.351 $Y2=0.135
r9 18 19 1.39914 $w=1.3e-08 $l=6e-09 $layer=M1 $thickness=3.6e-08 $X=0.3515
+ $Y=0.1145 $X2=0.351 $Y2=0.1205
r10 18 11 8.16164 $w=1.3e-08 $l=3.5e-08 $layer=M1 $thickness=3.6e-08 $X=0.3515
+ $Y=0.1145 $X2=0.351 $Y2=0.0795
r11 11 17 8.96345 $w=1.40345e-08 $l=4.35e-08 $layer=M1 $thickness=3.6e-08
+ $X=0.351 $Y=0.0795 $X2=0.351 $Y2=0.036
r12 16 17 1.96775 $w=1.63333e-08 $l=1.35e-08 $layer=M1 $thickness=3.6e-08
+ $X=0.3375 $Y=0.036 $X2=0.351 $Y2=0.036
r13 15 16 3.14806 $w=1.3e-08 $l=1.35e-08 $layer=M1 $thickness=3.6e-08 $X=0.324
+ $Y=0.036 $X2=0.3375 $Y2=0.036
r14 14 15 2.56509 $w=1.3e-08 $l=1.1e-08 $layer=M1 $thickness=3.6e-08 $X=0.313
+ $Y=0.036 $X2=0.324 $Y2=0.036
r15 9 14 0.582974 $w=1.3e-08 $l=2.5e-09 $layer=M1 $thickness=3.6e-08 $X=0.3105
+ $Y=0.036 $X2=0.313 $Y2=0.036
r16 1 15 19.3796 $a=3.24e-16 $layer=V0LISD $X=0.324 $Y=0.054 $X2=0.324 $Y2=0.036
r17 7 1 0.231482 $w=5.4e-08 $l=1.25e-08 $layer=N_src_drn $thickness=1e-09
+ $X=0.3095 $Y=0.054 $X2=0.324 $Y2=0.054
r18 13 7 0.0462963 $w=5.4e-08 $l=2.5e-09 $layer=N_src_drn $thickness=1e-09
+ $X=0.3066 $Y=0.054 $X2=0.3095 $Y2=0.054
.ends

.subckt PM_HB4xp67_ASAP7_75t_R%4 vss 20 26 44 46 11 3 1 4 16 19 17 18 10 9 15 13
c1 1 vss 0.00243757f $X=0.297 $Y=0.135
c2 3 vss 0.00594681f $X=0.054 $Y=0.0405
c3 4 vss 0.00587665f $X=0.054 $Y=0.2295
c4 9 vss 0.0611712f $X=0.297 $Y=0.0245
c5 10 vss 0.0179681f $X=0.056 $Y=0.0405
c6 11 vss 0.0179281f $X=0.056 $Y=0.2295
c7 12 vss 0.00312567f $X=0.189 $Y=0.036
c8 13 vss 6.40691e-20 $X=0.189 $Y=0.135
c9 14 vss 0.00312567f $X=0.189 $Y=0.234
c10 15 vss 0.0134105f $X=0.1375 $Y=0.036
c11 16 vss 0.0131165f $X=0.1375 $Y=0.234
c12 17 vss 0.00264832f $X=0.189 $Y=0.1125
c13 18 vss 0.00264832f $X=0.189 $Y=0.1665
c14 19 vss 0.00314895f $X=0.243 $Y=0.135
r1 46 45 0.0925926 $w=2.7e-08 $l=2.5e-09 $layer=P_src_drn $thickness=1e-09
+ $X=0.0713 $Y=0.2295 $X2=0.0685 $Y2=0.2295
r2 11 45 0.462963 $w=2.7e-08 $l=1.25e-08 $layer=P_src_drn $thickness=1e-09
+ $X=0.056 $Y=0.2295 $X2=0.0685 $Y2=0.2295
r3 44 43 0.0925926 $w=2.7e-08 $l=2.5e-09 $layer=N_src_drn $thickness=1e-09
+ $X=0.0713 $Y=0.0405 $X2=0.0685 $Y2=0.0405
r4 10 43 0.462963 $w=2.7e-08 $l=1.25e-08 $layer=N_src_drn $thickness=1e-09
+ $X=0.056 $Y=0.0405 $X2=0.0685 $Y2=0.0405
r5 4 42 19.3796 $a=3.24e-16 $layer=V0LISD $X=0.054 $Y=0.2295 $X2=0.05 $Y2=0.234
r6 3 38 19.3796 $a=3.24e-16 $layer=V0LISD $X=0.054 $Y=0.0405 $X2=0.05 $Y2=0.036
r7 39 40 4.6638 $w=1.3e-08 $l=2e-08 $layer=M1 $thickness=3.6e-08 $X=0.059
+ $Y=0.234 $X2=0.079 $Y2=0.234
r8 39 42 2.09871 $w=1.3e-08 $l=9e-09 $layer=M1 $thickness=3.6e-08 $X=0.059
+ $Y=0.234 $X2=0.05 $Y2=0.234
r9 16 40 13.6416 $w=1.3e-08 $l=5.85e-08 $layer=M1 $thickness=3.6e-08 $X=0.1375
+ $Y=0.234 $X2=0.079 $Y2=0.234
r10 35 36 4.6638 $w=1.3e-08 $l=2e-08 $layer=M1 $thickness=3.6e-08 $X=0.059
+ $Y=0.036 $X2=0.079 $Y2=0.036
r11 35 38 2.09871 $w=1.3e-08 $l=9e-09 $layer=M1 $thickness=3.6e-08 $X=0.059
+ $Y=0.036 $X2=0.05 $Y2=0.036
r12 15 36 13.6416 $w=1.3e-08 $l=5.85e-08 $layer=M1 $thickness=3.6e-08 $X=0.1375
+ $Y=0.036 $X2=0.079 $Y2=0.036
r13 14 34 2.5483 $w=1.79e-08 $l=1.8e-08 $layer=M1 $thickness=3.6e-08 $X=0.189
+ $Y=0.234 $X2=0.189 $Y2=0.216
r14 14 16 10.3602 $w=1.38738e-08 $l=5.15e-08 $layer=M1 $thickness=3.6e-08
+ $X=0.189 $Y=0.234 $X2=0.1375 $Y2=0.234
r15 12 32 4.64701 $w=1.62667e-08 $l=2.7e-08 $layer=M1 $thickness=3.6e-08
+ $X=0.189 $Y=0.036 $X2=0.189 $Y2=0.063
r16 12 15 10.3602 $w=1.38738e-08 $l=5.15e-08 $layer=M1 $thickness=3.6e-08
+ $X=0.189 $Y=0.036 $X2=0.1375 $Y2=0.036
r17 33 34 4.19742 $w=1.3e-08 $l=1.8e-08 $layer=M1 $thickness=3.6e-08 $X=0.189
+ $Y=0.198 $X2=0.189 $Y2=0.216
r18 18 33 7.34548 $w=1.3e-08 $l=3.15e-08 $layer=M1 $thickness=3.6e-08 $X=0.189
+ $Y=0.1665 $X2=0.189 $Y2=0.198
r19 31 32 6.29612 $w=1.3e-08 $l=2.7e-08 $layer=M1 $thickness=3.6e-08 $X=0.189
+ $Y=0.09 $X2=0.189 $Y2=0.063
r20 17 31 5.24677 $w=1.3e-08 $l=2.25e-08 $layer=M1 $thickness=3.6e-08 $X=0.189
+ $Y=0.1125 $X2=0.189 $Y2=0.09
r21 13 19 11.4119 $w=1.38333e-08 $l=5.4e-08 $layer=M1 $thickness=3.6e-08
+ $X=0.189 $Y=0.135 $X2=0.243 $Y2=0.135
r22 13 17 4.06646 $w=1.5e-08 $l=2.25e-08 $layer=M1 $thickness=3.6e-08 $X=0.189
+ $Y=0.135 $X2=0.189 $Y2=0.1125
r23 13 18 6.16517 $w=1.44286e-08 $l=3.15e-08 $layer=M1 $thickness=3.6e-08
+ $X=0.189 $Y=0.135 $X2=0.189 $Y2=0.1665
r24 19 28 12.5922 $w=1.3e-08 $l=5.4e-08 $layer=M1 $thickness=3.6e-08 $X=0.243
+ $Y=0.135 $X2=0.297 $Y2=0.135
r25 1 23 10.4265 $w=1.765e-08 $layer=LIG $thickness=5.2e-08 $X=0.297 $Y=0.135
+ $X2=0.297 $Y2=0.135
r26 1 28 19.3796 $a=3.24e-16 $layer=V0LIG $X=0.297 $Y=0.135 $X2=0.297 $Y2=0.135
r27 26 25 14.6259 $w=2.1e-08 $l=4.3e-08 $layer=Gate_1 $thickness=5.6e-08
+ $X=0.297 $Y=0.216 $X2=0.297 $Y2=0.173
r28 24 25 7.31297 $w=2.1e-08 $l=2.15e-08 $layer=Gate_1 $thickness=5.6e-08
+ $X=0.297 $Y=0.1515 $X2=0.297 $Y2=0.173
r29 23 24 5.79936 $w=2.03333e-08 $l=1.65e-08 $layer=Gate_1 $thickness=5.6e-08
+ $X=0.297 $Y=0.135 $X2=0.297 $Y2=0.1515
r30 22 23 5.79936 $w=2.03333e-08 $l=1.65e-08 $layer=Gate_1 $thickness=5.6e-08
+ $X=0.297 $Y=0.1185 $X2=0.297 $Y2=0.135
r31 21 22 7.31297 $w=2.1e-08 $l=2.15e-08 $layer=Gate_1 $thickness=5.6e-08
+ $X=0.297 $Y=0.097 $X2=0.297 $Y2=0.1185
r32 20 21 14.6259 $w=2.1e-08 $l=4.3e-08 $layer=Gate_1 $thickness=5.6e-08
+ $X=0.297 $Y=0.054 $X2=0.297 $Y2=0.097
r33 20 9 10.0341 $w=2.1e-08 $l=2.95e-08 $layer=Gate_1 $thickness=5.6e-08
+ $X=0.297 $Y=0.054 $X2=0.297 $Y2=0.0245
r34 4 11 1e-05 $l=2e-09 $X=0.054 $Y=0.2295 $X2=0.056 $Y2=0.2295
r35 3 10 1e-05 $l=2e-09 $X=0.054 $Y=0.0405 $X2=0.056 $Y2=0.0405
.ends

.subckt PM_HB4xp67_ASAP7_75t_R%7 vss 2 3 1
c1 1 vss 0.00381338f $X=0.162 $Y=0.0405
r1 2 1 0.62963 $w=2.7e-08 $l=1.7e-08 $layer=N_src_drn $thickness=1e-09
+ $X=0.1446 $Y=0.0405 $X2=0.162 $Y2=0.0405
r2 3 1 0.62963 $w=2.7e-08 $l=1.7e-08 $layer=N_src_drn $thickness=1e-09
+ $X=0.1793 $Y=0.0405 $X2=0.162 $Y2=0.0405
.ends

.subckt PM_HB4xp67_ASAP7_75t_R%8 vss 2 3 1
c1 1 vss 0.00214911f $X=0.216 $Y=0.0405
r1 2 1 0.62963 $w=2.7e-08 $l=1.7e-08 $layer=N_src_drn $thickness=1e-09
+ $X=0.1986 $Y=0.0405 $X2=0.216 $Y2=0.0405
r2 3 1 0.62963 $w=2.7e-08 $l=1.7e-08 $layer=N_src_drn $thickness=1e-09
+ $X=0.2333 $Y=0.0405 $X2=0.216 $Y2=0.0405
.ends

* End of included file HB4xp67_ASAP7_75t_R.pex.sp.pex

*
.subckt HB4xp67_ASAP7_75t_CUSTOM_4_25_0_7 VSS VDD A Y
*
* VSS VSS
* VDD VDD
* A A
* Y Y
*
*

M0 N_M0_d N_M0_g N_M0_s VSS nmos_rvt L=2e-08 W=2.7e-08 nfin=1 $X=0.071 $Y=0.027
M1 N_M1_d N_M1_g N_M1_s VSS nmos_rvt L=2e-08 W=2.7e-08 nfin=1 $X=0.125 $Y=0.027
M2 N_M2_d N_M2_g N_M2_s VSS nmos_rvt L=2e-08 W=2.7e-08 nfin=1 $X=0.179 $Y=0.027
M3 VSS N_M3_g N_M3_s VSS nmos_rvt L=2e-08 W=2.7e-08 nfin=1 $X=0.233 $Y=0.027
M4 N_M4_d N_M4_g VSS VSS nmos_rvt L=2e-08 W=5.4e-08 nfin=2 $X=0.287 $Y=0.027
M5 N_M5_d N_M5_g N_M5_s VDD pmos_rvt L=2e-08 W=2.7e-08 nfin=1 $X=0.071 $Y=0.216
M6 N_M6_d N_M6_g N_M6_s VDD pmos_rvt L=2e-08 W=2.7e-08 nfin=1 $X=0.125 $Y=0.216
M7 N_M7_d N_M7_g N_M7_s VDD pmos_rvt L=2e-08 W=2.7e-08 nfin=1 $X=0.179 $Y=0.216
M8 VDD N_M8_g N_M8_s VDD pmos_rvt L=2e-08 W=2.7e-08 nfin=1 $X=0.233 $Y=0.216
M9 N_M9_d N_M9_g VDD VDD pmos_rvt L=2e-08 W=5.4e-08 nfin=2 $X=0.287 $Y=0.189

* .include "HB4xp67_ASAP7_75t_R.pex.sp.pxi"

* Start of included file HB4xp67_ASAP7_75t_R.pex.sp.pxi
x_PM_HB4xp67_ASAP7_75t_R%6 vss N_M0_d N_M1_s N_6_1 PM_HB4xp67_ASAP7_75t_R%6
cc_1 N_6_1 N_A_3 0.00421153f $X=0.108 $Y=0.0405
cc_2 N_6_1 N_A_4 0.00960291f $X=0.108 $Y=0.0405
x_PM_HB4xp67_ASAP7_75t_R%9 vss N_M5_d N_M6_s N_9_1 PM_HB4xp67_ASAP7_75t_R%9
cc_3 N_9_1 N_A_4 0.00247003f $X=0.108 $Y=0.2295
cc_4 N_9_1 N_A_3 0.011324f $X=0.108 $Y=0.2295
x_PM_HB4xp67_ASAP7_75t_R%10 vss N_M6_d N_M7_s N_10_1 PM_HB4xp67_ASAP7_75t_R%10
cc_5 N_10_1 N_A_5 0.0022679f $X=0.162 $Y=0.2295
cc_6 N_10_1 N_A_4 0.00959924f $X=0.162 $Y=0.2295
x_PM_HB4xp67_ASAP7_75t_R%11 vss N_M7_d N_M8_s N_11_1 PM_HB4xp67_ASAP7_75t_R%11
cc_7 N_11_1 N_A_6 0.00422038f $X=0.216 $Y=0.2295
cc_8 N_11_1 N_A_5 0.00940212f $X=0.216 $Y=0.2295
x_PM_HB4xp67_ASAP7_75t_R%A vss A N_M0_g N_M5_g N_M1_g N_M6_g N_M2_g N_M7_g
+ N_M3_g N_M8_g N_A_1 N_A_10 N_A_11 N_A_7 N_A_9 N_A_3 N_A_12 N_A_4 N_A_5 N_A_6
+ PM_HB4xp67_ASAP7_75t_R%A
x_PM_HB4xp67_ASAP7_75t_R%Y vss Y N_M4_d N_M9_d N_Y_8 N_Y_7 N_Y_11
+ PM_HB4xp67_ASAP7_75t_R%Y
cc_9 N_Y_8 N_4_1 0.00174324f $X=0.3095 $Y=0.216
cc_10 N_Y_7 N_4_9 0.0106882f $X=0.3095 $Y=0.054
cc_11 N_Y_11 N_4_19 0.00389841f $X=0.351 $Y=0.0795
cc_12 N_Y_8 N_4_9 0.041846f $X=0.3095 $Y=0.216
x_PM_HB4xp67_ASAP7_75t_R%4 vss N_M4_g N_M9_g N_M0_s N_M5_s N_4_11 N_4_3 N_4_1
+ N_4_4 N_4_16 N_4_19 N_4_17 N_4_18 N_4_10 N_4_9 N_4_15 N_4_13
+ PM_HB4xp67_ASAP7_75t_R%4
cc_13 N_4_11 N_A_1 0.000622073f $X=0.056 $Y=0.2295
cc_14 N_4_11 N_A_10 0.00020094f $X=0.056 $Y=0.2295
cc_15 N_4_11 N_A_11 0.000378671f $X=0.056 $Y=0.2295
cc_16 N_4_11 N_A_7 0.000442236f $X=0.056 $Y=0.2295
cc_17 N_4_11 N_A_9 0.000612798f $X=0.056 $Y=0.2295
cc_18 N_4_3 N_A_3 0.000701013f $X=0.054 $Y=0.0405
cc_19 N_4_1 N_A_1 0.000717813f $X=0.297 $Y=0.135
cc_20 N_4_4 N_A_3 0.000801762f $X=0.054 $Y=0.2295
cc_21 N_4_16 N_A_12 0.000947819f $X=0.1375 $Y=0.234
cc_22 N_4_19 N_A_1 0.00119014f $X=0.243 $Y=0.135
cc_23 N_4_17 N_A_1 0.00136836f $X=0.189 $Y=0.1125
cc_24 N_4_18 N_A_1 0.00136836f $X=0.189 $Y=0.1665
cc_25 N_4_10 N_A_4 0.00139067f $X=0.056 $Y=0.0405
cc_26 N_4_9 N_A_5 0.0022708f $X=0.297 $Y=0.0245
cc_27 N_4_10 N_A_3 0.00675252f $X=0.056 $Y=0.0405
cc_28 N_4_15 N_A_7 0.00291831f $X=0.1375 $Y=0.036
cc_29 N_4_16 N_A_9 0.0039349f $X=0.1375 $Y=0.234
cc_30 N_4_13 N_A_1 0.00543701f $X=0.189 $Y=0.135
cc_31 N_4_9 N_A_6 0.00968094f $X=0.297 $Y=0.0245
cc_32 N_4_11 N_A_3 0.0318046f $X=0.056 $Y=0.2295
x_PM_HB4xp67_ASAP7_75t_R%7 vss N_M1_d N_M2_s N_7_1 PM_HB4xp67_ASAP7_75t_R%7
cc_33 N_7_1 N_A_5 0.00226854f $X=0.162 $Y=0.0405
cc_34 N_7_1 N_A_4 0.00959889f $X=0.162 $Y=0.0405
x_PM_HB4xp67_ASAP7_75t_R%8 vss N_M2_d N_M3_s N_8_1 PM_HB4xp67_ASAP7_75t_R%8
cc_35 N_8_1 N_A_5 0.00271743f $X=0.216 $Y=0.0405
cc_36 N_8_1 N_A_6 0.0108979f $X=0.216 $Y=0.0405

* End of included file HB4xp67_ASAP7_75t_R.pex.sp.pxi
.ends

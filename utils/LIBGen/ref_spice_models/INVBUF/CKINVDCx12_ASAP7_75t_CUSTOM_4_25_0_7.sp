.subckt PM_CKINVDCx12_ASAP7_75t_R%9 vss 19 23 33 36 46 47 50 51 18 4 15 1 9 12
+ 16 10 14
c1 1 vss 0.0063199f $X=0.189 $Y=0.135
c2 3 vss 0.00715727f $X=0.216 $Y=0.0675
c3 4 vss 0.00721069f $X=0.324 $Y=0.0675
c4 9 vss 0.0830419f $X=0.189 $Y=0.0245
c5 10 vss 0.0821594f $X=0.243 $Y=0.135
c6 11 vss 0.00641216f $X=0.2015 $Y=0.0675
c7 12 vss 0.00686056f $X=0.3095 $Y=0.0675
c8 13 vss 0.000348713f $X=0.243 $Y=0.099
c9 14 vss 0.000207322f $X=0.243 $Y=0.135
c10 15 vss 0.00134783f $X=0.2015 $Y=0.099
c11 16 vss 0.000638647f $X=0.199 $Y=0.135
c12 17 vss 0.000149605f $X=0.243 $Y=0.117
c13 18 vss 0.00246246f $X=0.27 $Y=0.099
r1 51 49 0.0308642 $w=8.1e-08 $l=2.5e-09 $layer=N_src_drn $thickness=1e-09
+ $X=0.3413 $Y=0.0675 $X2=0.3385 $Y2=0.0675
r2 4 49 0.179012 $w=8.1e-08 $l=1.45e-08 $layer=N_src_drn $thickness=1e-09
+ $X=0.324 $Y=0.0675 $X2=0.3385 $Y2=0.0675
r3 12 4 0.179012 $w=8.1e-08 $l=1.45e-08 $layer=N_src_drn $thickness=1e-09
+ $X=0.3095 $Y=0.0675 $X2=0.324 $Y2=0.0675
r4 50 12 0.0308642 $w=8.1e-08 $l=2.5e-09 $layer=N_src_drn $thickness=1e-09
+ $X=0.3066 $Y=0.0675 $X2=0.3095 $Y2=0.0675
r5 47 45 0.0308642 $w=8.1e-08 $l=2.5e-09 $layer=N_src_drn $thickness=1e-09
+ $X=0.2333 $Y=0.0675 $X2=0.2305 $Y2=0.0675
r6 3 45 0.179012 $w=8.1e-08 $l=1.45e-08 $layer=N_src_drn $thickness=1e-09
+ $X=0.216 $Y=0.0675 $X2=0.2305 $Y2=0.0675
r7 11 3 0.179012 $w=8.1e-08 $l=1.45e-08 $layer=N_src_drn $thickness=1e-09
+ $X=0.2015 $Y=0.0675 $X2=0.216 $Y2=0.0675
r8 46 11 0.0308642 $w=8.1e-08 $l=2.5e-09 $layer=N_src_drn $thickness=1e-09
+ $X=0.1986 $Y=0.0675 $X2=0.2015 $Y2=0.0675
r9 4 42 19.3796 $a=3.24e-16 $layer=V0LISD $X=0.324 $Y=0.0675 $X2=0.324 $Y2=0.099
r10 3 38 19.3796 $a=3.24e-16 $layer=V0LISD $X=0.216 $Y=0.0675 $X2=0.216
+ $Y2=0.099
r11 41 42 5.24677 $w=1.3e-08 $l=2.25e-08 $layer=M1 $thickness=3.6e-08 $X=0.3015
+ $Y=0.099 $X2=0.324 $Y2=0.099
r12 18 41 7.34548 $w=1.3e-08 $l=3.15e-08 $layer=M1 $thickness=3.6e-08 $X=0.27
+ $Y=0.099 $X2=0.3015 $Y2=0.099
r13 38 39 3.14806 $w=1.3e-08 $l=1.35e-08 $layer=M1 $thickness=3.6e-08 $X=0.216
+ $Y=0.099 $X2=0.2295 $Y2=0.099
r14 15 38 3.38125 $w=1.3e-08 $l=1.45e-08 $layer=M1 $thickness=3.6e-08 $X=0.2015
+ $Y=0.099 $X2=0.216 $Y2=0.099
r15 13 17 3.01711 $w=1.55e-08 $l=1.8e-08 $layer=M1 $thickness=3.6e-08 $X=0.243
+ $Y=0.099 $X2=0.243 $Y2=0.117
r16 13 39 1.96775 $w=1.63333e-08 $l=1.35e-08 $layer=M1 $thickness=3.6e-08
+ $X=0.243 $Y=0.099 $X2=0.2295 $Y2=0.099
r17 13 18 5.11582 $w=1.46667e-08 $l=2.7e-08 $layer=M1 $thickness=3.6e-08
+ $X=0.243 $Y=0.099 $X2=0.27 $Y2=0.099
r18 14 31 1.49895 $w=1.63333e-08 $l=1.35e-08 $layer=M1 $thickness=3.6e-08
+ $X=0.243 $Y=0.135 $X2=0.2295 $Y2=0.135
r19 14 17 2.5483 $w=1.79e-08 $l=1.8e-08 $layer=M1 $thickness=3.6e-08 $X=0.243
+ $Y=0.135 $X2=0.243 $Y2=0.117
r20 36 35 16.4967 $w=2.1e-08 $l=4.85e-08 $layer=Gate_1 $thickness=5.6e-08
+ $X=0.243 $Y=0.2025 $X2=0.243 $Y2=0.154
r21 33 34 16.4967 $w=2.1e-08 $l=4.85e-08 $layer=Gate_1 $thickness=5.6e-08
+ $X=0.243 $Y=0.0675 $X2=0.243 $Y2=0.116
r22 10 27 6.54019 $w=2.09524e-08 $layer=Gate_1 $thickness=5.21905e-08 $X=0.243
+ $Y=0.135 $X2=0.243 $Y2=0.135
r23 10 34 6.6497 $w=2.04211e-08 $l=1.9e-08 $layer=Gate_1 $thickness=5.6e-08
+ $X=0.243 $Y=0.135 $X2=0.243 $Y2=0.116
r24 10 35 6.6497 $w=2.04211e-08 $l=1.9e-08 $layer=Gate_1 $thickness=5.6e-08
+ $X=0.243 $Y=0.135 $X2=0.243 $Y2=0.154
r25 30 31 3.14806 $w=1.3e-08 $l=1.35e-08 $layer=M1 $thickness=3.6e-08 $X=0.216
+ $Y=0.135 $X2=0.2295 $Y2=0.135
r26 29 30 2.68168 $w=1.3e-08 $l=1.15e-08 $layer=M1 $thickness=3.6e-08 $X=0.2045
+ $Y=0.135 $X2=0.216 $Y2=0.135
r27 16 29 1.28254 $w=1.3e-08 $l=5.5e-09 $layer=M1 $thickness=3.6e-08 $X=0.199
+ $Y=0.135 $X2=0.2045 $Y2=0.135
r28 26 27 12.6539 $w=1.77815e-08 $l=2.7e-08 $layer=LIG $thickness=4.8e-08
+ $X=0.216 $Y=0.135 $X2=0.243 $Y2=0.135
r29 26 30 19.3796 $a=3.24e-16 $layer=V0LIG $X=0.216 $Y=0.135 $X2=0.216 $Y2=0.135
r30 1 21 6.54019 $w=2.09524e-08 $layer=Gate_1 $thickness=5.21905e-08 $X=0.189
+ $Y=0.135 $X2=0.189 $Y2=0.135
r31 1 26 12.6539 $w=1.77815e-08 $l=2.7e-08 $layer=LIG $thickness=4.8e-08
+ $X=0.189 $Y=0.135 $X2=0.216 $Y2=0.135
r32 23 22 16.4967 $w=2.1e-08 $l=4.85e-08 $layer=Gate_1 $thickness=5.6e-08
+ $X=0.189 $Y=0.2025 $X2=0.189 $Y2=0.154
r33 21 22 6.6497 $w=2.04211e-08 $l=1.9e-08 $layer=Gate_1 $thickness=5.6e-08
+ $X=0.189 $Y=0.135 $X2=0.189 $Y2=0.154
r34 20 21 6.6497 $w=2.04211e-08 $l=1.9e-08 $layer=Gate_1 $thickness=5.6e-08
+ $X=0.189 $Y=0.116 $X2=0.189 $Y2=0.135
r35 19 20 16.4967 $w=2.1e-08 $l=4.85e-08 $layer=Gate_1 $thickness=5.6e-08
+ $X=0.189 $Y=0.0675 $X2=0.189 $Y2=0.116
r36 19 9 14.6259 $w=2.1e-08 $l=4.3e-08 $layer=Gate_1 $thickness=5.6e-08
+ $X=0.189 $Y=0.0675 $X2=0.189 $Y2=0.0245
.ends

.subckt PM_CKINVDCx12_ASAP7_75t_R%5 vss 19 23 33 36 46 47 50 51 9 18 16 4 10 1
+ 12 13 3 15
c1 1 vss 0.00633497f $X=1.053 $Y=0.135
c2 3 vss 0.00716995f $X=1.08 $Y=0.2025
c3 4 vss 0.00722013f $X=1.188 $Y=0.2025
c4 9 vss 0.082394f $X=1.053 $Y=0.0245
c5 10 vss 0.0821854f $X=1.107 $Y=0.135
c6 11 vss 0.00669693f $X=1.0655 $Y=0.2025
c7 12 vss 0.0071678f $X=1.1735 $Y=0.2025
c8 13 vss 0.000209415f $X=1.107 $Y=0.135
c9 14 vss 0.000356263f $X=1.107 $Y=0.171
c10 15 vss 0.00132608f $X=1.0645 $Y=0.171
c11 16 vss 0.000662255f $X=1.062 $Y=0.135
c12 17 vss 0.000149612f $X=1.107 $Y=0.153
c13 18 vss 0.00262786f $X=1.134 $Y=0.171
r1 51 49 0.0308642 $w=8.1e-08 $l=2.5e-09 $layer=P_src_drn $thickness=1e-09
+ $X=1.2053 $Y=0.2025 $X2=1.2025 $Y2=0.2025
r2 4 49 0.179012 $w=8.1e-08 $l=1.45e-08 $layer=P_src_drn $thickness=1e-09
+ $X=1.188 $Y=0.2025 $X2=1.2025 $Y2=0.2025
r3 12 4 0.179012 $w=8.1e-08 $l=1.45e-08 $layer=P_src_drn $thickness=1e-09
+ $X=1.1735 $Y=0.2025 $X2=1.188 $Y2=0.2025
r4 50 12 0.0308642 $w=8.1e-08 $l=2.5e-09 $layer=P_src_drn $thickness=1e-09
+ $X=1.1706 $Y=0.2025 $X2=1.1735 $Y2=0.2025
r5 47 45 0.0308642 $w=8.1e-08 $l=2.5e-09 $layer=P_src_drn $thickness=1e-09
+ $X=1.0973 $Y=0.2025 $X2=1.0945 $Y2=0.2025
r6 3 45 0.179012 $w=8.1e-08 $l=1.45e-08 $layer=P_src_drn $thickness=1e-09
+ $X=1.08 $Y=0.2025 $X2=1.0945 $Y2=0.2025
r7 11 3 0.179012 $w=8.1e-08 $l=1.45e-08 $layer=P_src_drn $thickness=1e-09
+ $X=1.0655 $Y=0.2025 $X2=1.08 $Y2=0.2025
r8 46 11 0.0308642 $w=8.1e-08 $l=2.5e-09 $layer=P_src_drn $thickness=1e-09
+ $X=1.0626 $Y=0.2025 $X2=1.0655 $Y2=0.2025
r9 4 42 19.3796 $a=3.24e-16 $layer=V0LISD $X=1.188 $Y=0.2025 $X2=1.188 $Y2=0.171
r10 3 38 19.3796 $a=3.24e-16 $layer=V0LISD $X=1.08 $Y=0.2025 $X2=1.08 $Y2=0.171
r11 41 42 5.24677 $w=1.3e-08 $l=2.25e-08 $layer=M1 $thickness=3.6e-08 $X=1.1655
+ $Y=0.171 $X2=1.188 $Y2=0.171
r12 18 41 7.34548 $w=1.3e-08 $l=3.15e-08 $layer=M1 $thickness=3.6e-08 $X=1.134
+ $Y=0.171 $X2=1.1655 $Y2=0.171
r13 38 39 3.14806 $w=1.3e-08 $l=1.35e-08 $layer=M1 $thickness=3.6e-08 $X=1.08
+ $Y=0.171 $X2=1.0935 $Y2=0.171
r14 15 38 3.61444 $w=1.3e-08 $l=1.55e-08 $layer=M1 $thickness=3.6e-08 $X=1.0645
+ $Y=0.171 $X2=1.08 $Y2=0.171
r15 14 17 3.01711 $w=1.55e-08 $l=1.8e-08 $layer=M1 $thickness=3.6e-08 $X=1.107
+ $Y=0.171 $X2=1.107 $Y2=0.153
r16 14 39 1.96775 $w=1.63333e-08 $l=1.35e-08 $layer=M1 $thickness=3.6e-08
+ $X=1.107 $Y=0.171 $X2=1.0935 $Y2=0.171
r17 14 18 5.11582 $w=1.46667e-08 $l=2.7e-08 $layer=M1 $thickness=3.6e-08
+ $X=1.107 $Y=0.171 $X2=1.134 $Y2=0.171
r18 13 31 1.49895 $w=1.63333e-08 $l=1.35e-08 $layer=M1 $thickness=3.6e-08
+ $X=1.107 $Y=0.135 $X2=1.0935 $Y2=0.135
r19 13 17 2.5483 $w=1.79e-08 $l=1.8e-08 $layer=M1 $thickness=3.6e-08 $X=1.107
+ $Y=0.135 $X2=1.107 $Y2=0.153
r20 36 35 16.4967 $w=2.1e-08 $l=4.85e-08 $layer=Gate_1 $thickness=5.6e-08
+ $X=1.107 $Y=0.2025 $X2=1.107 $Y2=0.154
r21 33 34 16.4967 $w=2.1e-08 $l=4.85e-08 $layer=Gate_1 $thickness=5.6e-08
+ $X=1.107 $Y=0.0675 $X2=1.107 $Y2=0.116
r22 10 27 6.54019 $w=2.09524e-08 $layer=Gate_1 $thickness=5.21905e-08 $X=1.107
+ $Y=0.135 $X2=1.107 $Y2=0.135
r23 10 34 6.6497 $w=2.04211e-08 $l=1.9e-08 $layer=Gate_1 $thickness=5.6e-08
+ $X=1.107 $Y=0.135 $X2=1.107 $Y2=0.116
r24 10 35 6.6497 $w=2.04211e-08 $l=1.9e-08 $layer=Gate_1 $thickness=5.6e-08
+ $X=1.107 $Y=0.135 $X2=1.107 $Y2=0.154
r25 30 31 3.14806 $w=1.3e-08 $l=1.35e-08 $layer=M1 $thickness=3.6e-08 $X=1.08
+ $Y=0.135 $X2=1.0935 $Y2=0.135
r26 29 30 2.68168 $w=1.3e-08 $l=1.15e-08 $layer=M1 $thickness=3.6e-08 $X=1.0685
+ $Y=0.135 $X2=1.08 $Y2=0.135
r27 16 29 1.51573 $w=1.3e-08 $l=6.5e-09 $layer=M1 $thickness=3.6e-08 $X=1.062
+ $Y=0.135 $X2=1.0685 $Y2=0.135
r28 26 27 12.6539 $w=1.77815e-08 $l=2.7e-08 $layer=LIG $thickness=4.8e-08
+ $X=1.08 $Y=0.135 $X2=1.107 $Y2=0.135
r29 26 30 19.3796 $a=3.24e-16 $layer=V0LIG $X=1.08 $Y=0.135 $X2=1.08 $Y2=0.135
r30 1 21 6.54019 $w=2.09524e-08 $layer=Gate_1 $thickness=5.21905e-08 $X=1.053
+ $Y=0.135 $X2=1.053 $Y2=0.135
r31 1 26 12.6539 $w=1.77815e-08 $l=2.7e-08 $layer=LIG $thickness=4.8e-08
+ $X=1.053 $Y=0.135 $X2=1.08 $Y2=0.135
r32 23 22 16.4967 $w=2.1e-08 $l=4.85e-08 $layer=Gate_1 $thickness=5.6e-08
+ $X=1.053 $Y=0.2025 $X2=1.053 $Y2=0.154
r33 21 22 6.6497 $w=2.04211e-08 $l=1.9e-08 $layer=Gate_1 $thickness=5.6e-08
+ $X=1.053 $Y=0.135 $X2=1.053 $Y2=0.154
r34 20 21 6.6497 $w=2.04211e-08 $l=1.9e-08 $layer=Gate_1 $thickness=5.6e-08
+ $X=1.053 $Y=0.116 $X2=1.053 $Y2=0.135
r35 19 20 16.4967 $w=2.1e-08 $l=4.85e-08 $layer=Gate_1 $thickness=5.6e-08
+ $X=1.053 $Y=0.0675 $X2=1.053 $Y2=0.116
r36 19 9 14.6259 $w=2.1e-08 $l=4.3e-08 $layer=Gate_1 $thickness=5.6e-08
+ $X=1.053 $Y=0.0675 $X2=1.053 $Y2=0.0245
.ends

.subckt PM_CKINVDCx12_ASAP7_75t_R%4 vss 19 23 33 36 46 47 50 51 15 3 17 1 10 11
+ 18 9 14
c1 1 vss 0.00633478f $X=1.161 $Y=0.135
c2 3 vss 0.00721108f $X=1.08 $Y=0.0675
c3 4 vss 0.00715779f $X=1.188 $Y=0.0675
c4 9 vss 0.0821605f $X=1.161 $Y=0.0245
c5 10 vss 0.0830436f $X=1.215 $Y=0.135
c6 11 vss 0.0068729f $X=1.0655 $Y=0.0675
c7 12 vss 0.00642342f $X=1.1735 $Y=0.0675
c8 13 vss 0.00034877f $X=1.161 $Y=0.099
c9 14 vss 0.000207408f $X=1.161 $Y=0.135
c10 15 vss 0.00249536f $X=1.134 $Y=0.099
c11 16 vss 0.000149605f $X=1.161 $Y=0.117
c12 17 vss 0.00134221f $X=1.1745 $Y=0.099
c13 18 vss 0.000638714f $X=1.1745 $Y=0.135
r1 51 49 0.0308642 $w=8.1e-08 $l=2.5e-09 $layer=N_src_drn $thickness=1e-09
+ $X=1.2053 $Y=0.0675 $X2=1.2025 $Y2=0.0675
r2 4 49 0.179012 $w=8.1e-08 $l=1.45e-08 $layer=N_src_drn $thickness=1e-09
+ $X=1.188 $Y=0.0675 $X2=1.2025 $Y2=0.0675
r3 12 4 0.179012 $w=8.1e-08 $l=1.45e-08 $layer=N_src_drn $thickness=1e-09
+ $X=1.1735 $Y=0.0675 $X2=1.188 $Y2=0.0675
r4 50 12 0.0308642 $w=8.1e-08 $l=2.5e-09 $layer=N_src_drn $thickness=1e-09
+ $X=1.1706 $Y=0.0675 $X2=1.1735 $Y2=0.0675
r5 47 45 0.0308642 $w=8.1e-08 $l=2.5e-09 $layer=N_src_drn $thickness=1e-09
+ $X=1.0973 $Y=0.0675 $X2=1.0945 $Y2=0.0675
r6 3 45 0.179012 $w=8.1e-08 $l=1.45e-08 $layer=N_src_drn $thickness=1e-09
+ $X=1.08 $Y=0.0675 $X2=1.0945 $Y2=0.0675
r7 11 3 0.179012 $w=8.1e-08 $l=1.45e-08 $layer=N_src_drn $thickness=1e-09
+ $X=1.0655 $Y=0.0675 $X2=1.08 $Y2=0.0675
r8 46 11 0.0308642 $w=8.1e-08 $l=2.5e-09 $layer=N_src_drn $thickness=1e-09
+ $X=1.0626 $Y=0.0675 $X2=1.0655 $Y2=0.0675
r9 4 41 19.3796 $a=3.24e-16 $layer=V0LISD $X=1.188 $Y=0.0675 $X2=1.188 $Y2=0.099
r10 3 39 19.3796 $a=3.24e-16 $layer=V0LISD $X=1.08 $Y=0.0675 $X2=1.08 $Y2=0.099
r11 17 41 3.14806 $w=1.3e-08 $l=1.35e-08 $layer=M1 $thickness=3.6e-08 $X=1.1745
+ $Y=0.099 $X2=1.188 $Y2=0.099
r12 39 40 5.24677 $w=1.3e-08 $l=2.25e-08 $layer=M1 $thickness=3.6e-08 $X=1.08
+ $Y=0.099 $X2=1.1025 $Y2=0.099
r13 15 40 7.34548 $w=1.3e-08 $l=3.15e-08 $layer=M1 $thickness=3.6e-08 $X=1.134
+ $Y=0.099 $X2=1.1025 $Y2=0.099
r14 13 16 3.01711 $w=1.55e-08 $l=1.8e-08 $layer=M1 $thickness=3.6e-08 $X=1.161
+ $Y=0.099 $X2=1.161 $Y2=0.117
r15 13 15 5.11582 $w=1.46667e-08 $l=2.7e-08 $layer=M1 $thickness=3.6e-08
+ $X=1.161 $Y=0.099 $X2=1.134 $Y2=0.099
r16 13 17 1.96775 $w=1.63333e-08 $l=1.35e-08 $layer=M1 $thickness=3.6e-08
+ $X=1.161 $Y=0.099 $X2=1.1745 $Y2=0.099
r17 14 18 1.49895 $w=1.63333e-08 $l=1.35e-08 $layer=M1 $thickness=3.6e-08
+ $X=1.161 $Y=0.135 $X2=1.1745 $Y2=0.135
r18 14 16 2.5483 $w=1.79e-08 $l=1.8e-08 $layer=M1 $thickness=3.6e-08 $X=1.161
+ $Y=0.135 $X2=1.161 $Y2=0.117
r19 36 35 16.4967 $w=2.1e-08 $l=4.85e-08 $layer=Gate_1 $thickness=5.6e-08
+ $X=1.215 $Y=0.2025 $X2=1.215 $Y2=0.154
r20 33 34 16.4967 $w=2.1e-08 $l=4.85e-08 $layer=Gate_1 $thickness=5.6e-08
+ $X=1.215 $Y=0.0675 $X2=1.215 $Y2=0.116
r21 10 27 6.54019 $w=2.09524e-08 $layer=Gate_1 $thickness=5.21905e-08 $X=1.215
+ $Y=0.135 $X2=1.215 $Y2=0.135
r22 10 34 6.6497 $w=2.04211e-08 $l=1.9e-08 $layer=Gate_1 $thickness=5.6e-08
+ $X=1.215 $Y=0.135 $X2=1.215 $Y2=0.116
r23 10 35 6.6497 $w=2.04211e-08 $l=1.9e-08 $layer=Gate_1 $thickness=5.6e-08
+ $X=1.215 $Y=0.135 $X2=1.215 $Y2=0.154
r24 18 29 3.14806 $w=1.3e-08 $l=1.35e-08 $layer=M1 $thickness=3.6e-08 $X=1.1745
+ $Y=0.135 $X2=1.188 $Y2=0.135
r25 26 27 12.6539 $w=1.77815e-08 $l=2.7e-08 $layer=LIG $thickness=4.8e-08
+ $X=1.188 $Y=0.135 $X2=1.215 $Y2=0.135
r26 26 29 19.3796 $a=3.24e-16 $layer=V0LIG $X=1.188 $Y=0.135 $X2=1.188 $Y2=0.135
r27 1 21 6.54019 $w=2.09524e-08 $layer=Gate_1 $thickness=5.21905e-08 $X=1.161
+ $Y=0.135 $X2=1.161 $Y2=0.135
r28 1 26 12.6539 $w=1.77815e-08 $l=2.7e-08 $layer=LIG $thickness=4.8e-08
+ $X=1.161 $Y=0.135 $X2=1.188 $Y2=0.135
r29 23 22 16.4967 $w=2.1e-08 $l=4.85e-08 $layer=Gate_1 $thickness=5.6e-08
+ $X=1.161 $Y=0.2025 $X2=1.161 $Y2=0.154
r30 21 22 6.6497 $w=2.04211e-08 $l=1.9e-08 $layer=Gate_1 $thickness=5.6e-08
+ $X=1.161 $Y=0.135 $X2=1.161 $Y2=0.154
r31 20 21 6.6497 $w=2.04211e-08 $l=1.9e-08 $layer=Gate_1 $thickness=5.6e-08
+ $X=1.161 $Y=0.116 $X2=1.161 $Y2=0.135
r32 19 20 16.4967 $w=2.1e-08 $l=4.85e-08 $layer=Gate_1 $thickness=5.6e-08
+ $X=1.161 $Y=0.0675 $X2=1.161 $Y2=0.116
r33 19 9 14.6259 $w=2.1e-08 $l=4.3e-08 $layer=Gate_1 $thickness=5.6e-08
+ $X=1.161 $Y=0.0675 $X2=1.161 $Y2=0.0245
.ends

.subckt PM_CKINVDCx12_ASAP7_75t_R%6 vss 19 23 33 36 46 47 50 51 18 1 3 4 15 9
+ 12 16 10 14
c1 1 vss 0.00631987f $X=0.621 $Y=0.135
c2 3 vss 0.00715536f $X=0.648 $Y=0.0675
c3 4 vss 0.00720927f $X=0.756 $Y=0.0675
c4 9 vss 0.082349f $X=0.621 $Y=0.0245
c5 10 vss 0.0821555f $X=0.675 $Y=0.135
c6 11 vss 0.00637097f $X=0.6335 $Y=0.0675
c7 12 vss 0.00681544f $X=0.7415 $Y=0.0675
c8 13 vss 0.000348503f $X=0.675 $Y=0.099
c9 14 vss 0.000207007f $X=0.675 $Y=0.135
c10 15 vss 0.00133162f $X=0.6335 $Y=0.099
c11 16 vss 0.000606936f $X=0.631 $Y=0.135
c12 17 vss 0.000149604f $X=0.675 $Y=0.117
c13 18 vss 0.00245498f $X=0.702 $Y=0.099
r1 51 49 0.0308642 $w=8.1e-08 $l=2.5e-09 $layer=N_src_drn $thickness=1e-09
+ $X=0.7733 $Y=0.0675 $X2=0.7705 $Y2=0.0675
r2 4 49 0.179012 $w=8.1e-08 $l=1.45e-08 $layer=N_src_drn $thickness=1e-09
+ $X=0.756 $Y=0.0675 $X2=0.7705 $Y2=0.0675
r3 12 4 0.179012 $w=8.1e-08 $l=1.45e-08 $layer=N_src_drn $thickness=1e-09
+ $X=0.7415 $Y=0.0675 $X2=0.756 $Y2=0.0675
r4 50 12 0.0308642 $w=8.1e-08 $l=2.5e-09 $layer=N_src_drn $thickness=1e-09
+ $X=0.7386 $Y=0.0675 $X2=0.7415 $Y2=0.0675
r5 47 45 0.0308642 $w=8.1e-08 $l=2.5e-09 $layer=N_src_drn $thickness=1e-09
+ $X=0.6653 $Y=0.0675 $X2=0.6625 $Y2=0.0675
r6 3 45 0.179012 $w=8.1e-08 $l=1.45e-08 $layer=N_src_drn $thickness=1e-09
+ $X=0.648 $Y=0.0675 $X2=0.6625 $Y2=0.0675
r7 11 3 0.179012 $w=8.1e-08 $l=1.45e-08 $layer=N_src_drn $thickness=1e-09
+ $X=0.6335 $Y=0.0675 $X2=0.648 $Y2=0.0675
r8 46 11 0.0308642 $w=8.1e-08 $l=2.5e-09 $layer=N_src_drn $thickness=1e-09
+ $X=0.6306 $Y=0.0675 $X2=0.6335 $Y2=0.0675
r9 4 42 19.3796 $a=3.24e-16 $layer=V0LISD $X=0.756 $Y=0.0675 $X2=0.756 $Y2=0.099
r10 3 38 19.3796 $a=3.24e-16 $layer=V0LISD $X=0.648 $Y=0.0675 $X2=0.648
+ $Y2=0.099
r11 41 42 5.24677 $w=1.3e-08 $l=2.25e-08 $layer=M1 $thickness=3.6e-08 $X=0.7335
+ $Y=0.099 $X2=0.756 $Y2=0.099
r12 18 41 7.34548 $w=1.3e-08 $l=3.15e-08 $layer=M1 $thickness=3.6e-08 $X=0.702
+ $Y=0.099 $X2=0.7335 $Y2=0.099
r13 38 39 3.14806 $w=1.3e-08 $l=1.35e-08 $layer=M1 $thickness=3.6e-08 $X=0.648
+ $Y=0.099 $X2=0.6615 $Y2=0.099
r14 15 38 3.38125 $w=1.3e-08 $l=1.45e-08 $layer=M1 $thickness=3.6e-08 $X=0.6335
+ $Y=0.099 $X2=0.648 $Y2=0.099
r15 13 17 3.01711 $w=1.55e-08 $l=1.8e-08 $layer=M1 $thickness=3.6e-08 $X=0.675
+ $Y=0.099 $X2=0.675 $Y2=0.117
r16 13 39 1.96775 $w=1.63333e-08 $l=1.35e-08 $layer=M1 $thickness=3.6e-08
+ $X=0.675 $Y=0.099 $X2=0.6615 $Y2=0.099
r17 13 18 5.11582 $w=1.46667e-08 $l=2.7e-08 $layer=M1 $thickness=3.6e-08
+ $X=0.675 $Y=0.099 $X2=0.702 $Y2=0.099
r18 14 31 1.49895 $w=1.63333e-08 $l=1.35e-08 $layer=M1 $thickness=3.6e-08
+ $X=0.675 $Y=0.135 $X2=0.6615 $Y2=0.135
r19 14 17 2.5483 $w=1.79e-08 $l=1.8e-08 $layer=M1 $thickness=3.6e-08 $X=0.675
+ $Y=0.135 $X2=0.675 $Y2=0.117
r20 36 35 16.4967 $w=2.1e-08 $l=4.85e-08 $layer=Gate_1 $thickness=5.6e-08
+ $X=0.675 $Y=0.2025 $X2=0.675 $Y2=0.154
r21 33 34 16.4967 $w=2.1e-08 $l=4.85e-08 $layer=Gate_1 $thickness=5.6e-08
+ $X=0.675 $Y=0.0675 $X2=0.675 $Y2=0.116
r22 10 27 6.54019 $w=2.09524e-08 $layer=Gate_1 $thickness=5.21905e-08 $X=0.675
+ $Y=0.135 $X2=0.675 $Y2=0.135
r23 10 34 6.6497 $w=2.04211e-08 $l=1.9e-08 $layer=Gate_1 $thickness=5.6e-08
+ $X=0.675 $Y=0.135 $X2=0.675 $Y2=0.116
r24 10 35 6.6497 $w=2.04211e-08 $l=1.9e-08 $layer=Gate_1 $thickness=5.6e-08
+ $X=0.675 $Y=0.135 $X2=0.675 $Y2=0.154
r25 30 31 3.14806 $w=1.3e-08 $l=1.35e-08 $layer=M1 $thickness=3.6e-08 $X=0.648
+ $Y=0.135 $X2=0.6615 $Y2=0.135
r26 29 30 2.68168 $w=1.3e-08 $l=1.15e-08 $layer=M1 $thickness=3.6e-08 $X=0.6365
+ $Y=0.135 $X2=0.648 $Y2=0.135
r27 16 29 1.28254 $w=1.3e-08 $l=5.5e-09 $layer=M1 $thickness=3.6e-08 $X=0.631
+ $Y=0.135 $X2=0.6365 $Y2=0.135
r28 26 27 12.6539 $w=1.77815e-08 $l=2.7e-08 $layer=LIG $thickness=4.8e-08
+ $X=0.648 $Y=0.135 $X2=0.675 $Y2=0.135
r29 26 30 19.3796 $a=3.24e-16 $layer=V0LIG $X=0.648 $Y=0.135 $X2=0.648 $Y2=0.135
r30 1 21 6.54019 $w=2.09524e-08 $layer=Gate_1 $thickness=5.21905e-08 $X=0.621
+ $Y=0.135 $X2=0.621 $Y2=0.135
r31 1 26 12.6539 $w=1.77815e-08 $l=2.7e-08 $layer=LIG $thickness=4.8e-08
+ $X=0.621 $Y=0.135 $X2=0.648 $Y2=0.135
r32 23 22 16.4967 $w=2.1e-08 $l=4.85e-08 $layer=Gate_1 $thickness=5.6e-08
+ $X=0.621 $Y=0.2025 $X2=0.621 $Y2=0.154
r33 21 22 6.6497 $w=2.04211e-08 $l=1.9e-08 $layer=Gate_1 $thickness=5.6e-08
+ $X=0.621 $Y=0.135 $X2=0.621 $Y2=0.154
r34 20 21 6.6497 $w=2.04211e-08 $l=1.9e-08 $layer=Gate_1 $thickness=5.6e-08
+ $X=0.621 $Y=0.116 $X2=0.621 $Y2=0.135
r35 19 20 16.4967 $w=2.1e-08 $l=4.85e-08 $layer=Gate_1 $thickness=5.6e-08
+ $X=0.621 $Y=0.0675 $X2=0.621 $Y2=0.116
r36 19 9 14.6259 $w=2.1e-08 $l=4.3e-08 $layer=Gate_1 $thickness=5.6e-08
+ $X=0.621 $Y=0.0675 $X2=0.621 $Y2=0.0245
.ends

.subckt PM_CKINVDCx12_ASAP7_75t_R%A vss 67 42 48 60 63 116 119 122 125 128 131
+ 134 137 163 166 169 172 175 178 181 184 194 197 201 205 31 1 32 12 34 2 13 35
+ 16 3 17 38 4 20 39 21 27 25 26 28 30 23 14 24 29 15 18 19 11 22 41 36 37 33 40
c1 1 vss 0.0151115f $X=0.0765 $Y=0.135
c2 2 vss 0.0267159f $X=0.427 $Y=0.135
c3 3 vss 0.0267996f $X=0.8595 $Y=0.135
c4 4 vss 0.0151115f $X=1.2915 $Y=0.135
c5 11 vss 0.0844657f $X=0.081 $Y=0.0245
c6 12 vss 0.0844101f $X=0.135 $Y=0.135
c7 13 vss 0.0842423f $X=0.405 $Y=0.135
c8 14 vss 0.0846535f $X=0.459 $Y=0.135
c9 15 vss 0.0846471f $X=0.513 $Y=0.135
c10 16 vss 0.0843307f $X=0.567 $Y=0.135
c11 17 vss 0.0843307f $X=0.837 $Y=0.135
c12 18 vss 0.0846472f $X=0.891 $Y=0.135
c13 19 vss 0.0846472f $X=0.945 $Y=0.135
c14 20 vss 0.0843307f $X=0.999 $Y=0.135
c15 21 vss 0.0844101f $X=1.269 $Y=0.135
c16 22 vss 0.0844657f $X=1.323 $Y=0.135
c17 23 vss 0.00723743f $X=0.059 $Y=0.036
c18 24 vss 0.00605232f $X=0.075 $Y=0.135
c19 25 vss 0.00624851f $X=0.485 $Y=0.036
c20 26 vss 0.00418463f $X=0.485 $Y=0.135
c21 27 vss 0.00624902f $X=0.918 $Y=0.036
c22 28 vss 0.00417988f $X=0.918 $Y=0.135
c23 29 vss 0.00605232f $X=1.345 $Y=0.135
c24 30 vss 0.00723743f $X=1.345 $Y=0.036
c25 31 vss 0.00806692f $X=0.059 $Y=0.1035
c26 32 vss 0.0408291f $X=0.081 $Y=0.036
c27 33 vss 0.00463598f $X=0.4515 $Y=0.135
c28 34 vss 0.00614067f $X=0.485 $Y=0.054
c29 35 vss 0.0425033f $X=0.51 $Y=0.036
c30 36 vss 0.00464851f $X=0.5035 $Y=0.135
c31 37 vss 0.00465348f $X=0.884 $Y=0.135
c32 38 vss 0.00600062f $X=0.918 $Y=0.054
c33 39 vss 0.0408972f $X=0.9425 $Y=0.036
c34 40 vss 0.00465348f $X=0.9365 $Y=0.135
c35 41 vss 0.00806692f $X=1.345 $Y=0.054
r1 205 204 14.6259 $w=2.1e-08 $l=4.3e-08 $layer=Gate_1 $thickness=5.6e-08
+ $X=1.323 $Y=0.2025 $X2=1.323 $Y2=0.1595
r2 203 204 2.89117 $w=2.1e-08 $l=8.5e-09 $layer=Gate_1 $thickness=5.6e-08
+ $X=1.323 $Y=0.151 $X2=1.323 $Y2=0.1595
r3 201 202 14.6259 $w=2.1e-08 $l=4.3e-08 $layer=Gate_1 $thickness=5.6e-08
+ $X=1.323 $Y=0.0675 $X2=1.323 $Y2=0.1105
r4 199 202 2.89117 $w=2.1e-08 $l=8.5e-09 $layer=Gate_1 $thickness=5.6e-08
+ $X=1.323 $Y=0.119 $X2=1.323 $Y2=0.1105
r5 22 191 3.57145 $w=2e-08 $layer=Gate_1 $thickness=5.6e-08 $X=1.323 $Y=0.135
+ $X2=1.323 $Y2=0.135
r6 22 199 5.61228 $w=2.0375e-08 $l=1.6e-08 $layer=Gate_1 $thickness=5.6e-08
+ $X=1.323 $Y=0.135 $X2=1.323 $Y2=0.119
r7 22 203 5.61228 $w=2.0375e-08 $l=1.6e-08 $layer=Gate_1 $thickness=5.6e-08
+ $X=1.323 $Y=0.135 $X2=1.323 $Y2=0.151
r8 197 196 16.6668 $w=2.1e-08 $l=4.9e-08 $layer=Gate_1 $thickness=5.6e-08
+ $X=1.269 $Y=0.2025 $X2=1.269 $Y2=0.1535
r9 194 195 16.6668 $w=2.1e-08 $l=4.9e-08 $layer=Gate_1 $thickness=5.6e-08
+ $X=1.269 $Y=0.0675 $X2=1.269 $Y2=0.1165
r10 21 187 6.74717 $w=2e-08 $layer=Gate_1 $thickness=5.2e-08 $X=1.269 $Y=0.135
+ $X2=1.269 $Y2=0.135
r11 21 195 6.46262 $w=2.04595e-08 $l=1.85e-08 $layer=Gate_1 $thickness=5.6e-08
+ $X=1.269 $Y=0.135 $X2=1.269 $Y2=0.1165
r12 21 196 6.46262 $w=2.04595e-08 $l=1.85e-08 $layer=Gate_1 $thickness=5.6e-08
+ $X=1.269 $Y=0.135 $X2=1.269 $Y2=0.1535
r13 190 191 1.74665 $w=2e-08 $l=4.5e-09 $layer=LIG $thickness=4.8e-08 $X=1.3275
+ $Y=0.135 $X2=1.323 $Y2=0.135
r14 189 190 3.17572 $w=2e-08 $l=1e-08 $layer=LIG $thickness=4.8e-08 $X=1.3175
+ $Y=0.135 $X2=1.3275 $Y2=0.135
r15 186 189 5.91273 $w=1.665e-08 $l=9e-09 $layer=LIG $thickness=4.8e-08
+ $X=1.3085 $Y=0.135 $X2=1.3175 $Y2=0.135
r16 4 186 16.9382 $w=1.33e-08 $l=1.7e-08 $layer=LIG $thickness=4.8e-08
+ $X=1.2915 $Y=0.135 $X2=1.3085 $Y2=0.135
r17 4 187 15.6303 $w=1.62778e-08 $l=2.25e-08 $layer=LIG $thickness=4.8e-08
+ $X=1.2915 $Y=0.135 $X2=1.269 $Y2=0.135
r18 184 183 16.6668 $w=2.1e-08 $l=4.9e-08 $layer=Gate_1 $thickness=5.6e-08
+ $X=0.999 $Y=0.2025 $X2=0.999 $Y2=0.1535
r19 181 182 16.6668 $w=2.1e-08 $l=4.9e-08 $layer=Gate_1 $thickness=5.6e-08
+ $X=0.999 $Y=0.0675 $X2=0.999 $Y2=0.1165
r20 20 157 6.74717 $w=2e-08 $layer=Gate_1 $thickness=5.2e-08 $X=0.999 $Y=0.135
+ $X2=0.999 $Y2=0.135
r21 20 182 6.46262 $w=2.04595e-08 $l=1.85e-08 $layer=Gate_1 $thickness=5.6e-08
+ $X=0.999 $Y=0.135 $X2=0.999 $Y2=0.1165
r22 20 183 6.46262 $w=2.04595e-08 $l=1.85e-08 $layer=Gate_1 $thickness=5.6e-08
+ $X=0.999 $Y=0.135 $X2=0.999 $Y2=0.1535
r23 178 177 16.6668 $w=2.1e-08 $l=4.9e-08 $layer=Gate_1 $thickness=5.6e-08
+ $X=0.945 $Y=0.2025 $X2=0.945 $Y2=0.1535
r24 175 176 16.6668 $w=2.1e-08 $l=4.9e-08 $layer=Gate_1 $thickness=5.6e-08
+ $X=0.945 $Y=0.0675 $X2=0.945 $Y2=0.1165
r25 19 154 3.57145 $w=2e-08 $layer=Gate_1 $thickness=5.6e-08 $X=0.945 $Y=0.135
+ $X2=0.945 $Y2=0.135
r26 19 176 6.46262 $w=2.04595e-08 $l=1.85e-08 $layer=Gate_1 $thickness=5.6e-08
+ $X=0.945 $Y=0.135 $X2=0.945 $Y2=0.1165
r27 19 177 6.46262 $w=2.04595e-08 $l=1.85e-08 $layer=Gate_1 $thickness=5.6e-08
+ $X=0.945 $Y=0.135 $X2=0.945 $Y2=0.1535
r28 172 171 16.6668 $w=2.1e-08 $l=4.9e-08 $layer=Gate_1 $thickness=5.6e-08
+ $X=0.891 $Y=0.2025 $X2=0.891 $Y2=0.1535
r29 169 170 16.6668 $w=2.1e-08 $l=4.9e-08 $layer=Gate_1 $thickness=5.6e-08
+ $X=0.891 $Y=0.0675 $X2=0.891 $Y2=0.1165
r30 18 150 3.57145 $w=2e-08 $layer=Gate_1 $thickness=5.6e-08 $X=0.891 $Y=0.135
+ $X2=0.891 $Y2=0.135
r31 18 170 6.46262 $w=2.04595e-08 $l=1.85e-08 $layer=Gate_1 $thickness=5.6e-08
+ $X=0.891 $Y=0.135 $X2=0.891 $Y2=0.1165
r32 18 171 6.46262 $w=2.04595e-08 $l=1.85e-08 $layer=Gate_1 $thickness=5.6e-08
+ $X=0.891 $Y=0.135 $X2=0.891 $Y2=0.1535
r33 166 165 16.6668 $w=2.1e-08 $l=4.9e-08 $layer=Gate_1 $thickness=5.6e-08
+ $X=0.837 $Y=0.2025 $X2=0.837 $Y2=0.1535
r34 163 164 16.6668 $w=2.1e-08 $l=4.9e-08 $layer=Gate_1 $thickness=5.6e-08
+ $X=0.837 $Y=0.0675 $X2=0.837 $Y2=0.1165
r35 17 146 6.74717 $w=2e-08 $layer=Gate_1 $thickness=5.2e-08 $X=0.837 $Y=0.135
+ $X2=0.837 $Y2=0.135
r36 17 164 6.46262 $w=2.04595e-08 $l=1.85e-08 $layer=Gate_1 $thickness=5.6e-08
+ $X=0.837 $Y=0.135 $X2=0.837 $Y2=0.1165
r37 17 165 6.46262 $w=2.04595e-08 $l=1.85e-08 $layer=Gate_1 $thickness=5.6e-08
+ $X=0.837 $Y=0.135 $X2=0.837 $Y2=0.1535
r38 159 160 3.03147 $w=1.3e-08 $l=1.3e-08 $layer=M1 $thickness=3.6e-08 $X=1.316
+ $Y=0.135 $X2=1.329 $Y2=0.135
r39 159 186 19.3796 $a=3.24e-16 $layer=V0LIG $X=1.316 $Y=0.135 $X2=1.3085
+ $Y2=0.135
r40 29 144 6.16517 $w=1.44286e-08 $l=3.15e-08 $layer=M1 $thickness=3.6e-08
+ $X=1.345 $Y=0.135 $X2=1.345 $Y2=0.1035
r41 29 160 2.55073 $w=1.58125e-08 $l=1.6e-08 $layer=M1 $thickness=3.6e-08
+ $X=1.345 $Y=0.135 $X2=1.329 $Y2=0.135
r42 156 157 15.6303 $w=1.62778e-08 $l=2.25e-08 $layer=LIG $thickness=4.8e-08
+ $X=0.9765 $Y=0.135 $X2=0.999 $Y2=0.135
r43 155 156 16.9382 $w=1.33e-08 $l=1.7e-08 $layer=LIG $thickness=4.8e-08
+ $X=0.9595 $Y=0.135 $X2=0.9765 $Y2=0.135
r44 153 155 5.91273 $w=1.665e-08 $l=9e-09 $layer=LIG $thickness=4.8e-08
+ $X=0.9505 $Y=0.135 $X2=0.9595 $Y2=0.135
r45 152 153 3.17572 $w=2e-08 $l=1e-08 $layer=LIG $thickness=4.8e-08 $X=0.9405
+ $Y=0.135 $X2=0.9505 $Y2=0.135
r46 152 154 1.74665 $w=2e-08 $l=4.5e-09 $layer=LIG $thickness=4.8e-08 $X=0.9405
+ $Y=0.135 $X2=0.945 $Y2=0.135
r47 151 152 18.6849 $w=1.49378e-08 $l=2.25e-08 $layer=LIG $thickness=4.8e-08
+ $X=0.918 $Y=0.135 $X2=0.9405 $Y2=0.135
r48 149 150 1.74665 $w=2e-08 $l=4.5e-09 $layer=LIG $thickness=4.8e-08 $X=0.8955
+ $Y=0.135 $X2=0.891 $Y2=0.135
r49 149 151 18.6849 $w=1.49378e-08 $l=2.25e-08 $layer=LIG $thickness=4.8e-08
+ $X=0.8955 $Y=0.135 $X2=0.918 $Y2=0.135
r50 148 149 3.17572 $w=2e-08 $l=1e-08 $layer=LIG $thickness=4.8e-08 $X=0.8855
+ $Y=0.135 $X2=0.8955 $Y2=0.135
r51 145 148 5.91273 $w=1.665e-08 $l=9e-09 $layer=LIG $thickness=4.8e-08
+ $X=0.8765 $Y=0.135 $X2=0.8855 $Y2=0.135
r52 3 145 16.9382 $w=1.33e-08 $l=1.7e-08 $layer=LIG $thickness=4.8e-08
+ $X=0.8595 $Y=0.135 $X2=0.8765 $Y2=0.135
r53 3 146 15.6303 $w=1.62778e-08 $l=2.25e-08 $layer=LIG $thickness=4.8e-08
+ $X=0.8595 $Y=0.135 $X2=0.837 $Y2=0.135
r54 143 144 7.34548 $w=1.3e-08 $l=3.15e-08 $layer=M1 $thickness=3.6e-08
+ $X=1.345 $Y=0.072 $X2=1.345 $Y2=0.1035
r55 41 143 4.19742 $w=1.3e-08 $l=1.8e-08 $layer=M1 $thickness=3.6e-08 $X=1.345
+ $Y=0.054 $X2=1.345 $Y2=0.072
r56 141 153 19.3796 $a=3.24e-16 $layer=V0LIG $X=0.952 $Y=0.135 $X2=0.9505
+ $Y2=0.135
r57 40 141 3.61444 $w=1.3e-08 $l=1.55e-08 $layer=M1 $thickness=3.6e-08
+ $X=0.9365 $Y=0.135 $X2=0.952 $Y2=0.135
r58 37 139 3.61444 $w=1.3e-08 $l=1.55e-08 $layer=M1 $thickness=3.6e-08 $X=0.884
+ $Y=0.135 $X2=0.8995 $Y2=0.135
r59 37 145 19.3796 $a=3.24e-16 $layer=V0LIG $X=0.884 $Y=0.135 $X2=0.8765
+ $Y2=0.135
r60 137 136 16.6668 $w=2.1e-08 $l=4.9e-08 $layer=Gate_1 $thickness=5.6e-08
+ $X=0.567 $Y=0.2025 $X2=0.567 $Y2=0.1535
r61 134 135 16.6668 $w=2.1e-08 $l=4.9e-08 $layer=Gate_1 $thickness=5.6e-08
+ $X=0.567 $Y=0.0675 $X2=0.567 $Y2=0.1165
r62 16 113 6.74717 $w=2e-08 $layer=Gate_1 $thickness=5.2e-08 $X=0.567 $Y=0.135
+ $X2=0.567 $Y2=0.135
r63 16 135 6.46262 $w=2.04595e-08 $l=1.85e-08 $layer=Gate_1 $thickness=5.6e-08
+ $X=0.567 $Y=0.135 $X2=0.567 $Y2=0.1165
r64 16 136 6.46262 $w=2.04595e-08 $l=1.85e-08 $layer=Gate_1 $thickness=5.6e-08
+ $X=0.567 $Y=0.135 $X2=0.567 $Y2=0.1535
r65 131 130 16.6668 $w=2.1e-08 $l=4.9e-08 $layer=Gate_1 $thickness=5.6e-08
+ $X=0.513 $Y=0.2025 $X2=0.513 $Y2=0.1535
r66 128 129 16.6668 $w=2.1e-08 $l=4.9e-08 $layer=Gate_1 $thickness=5.6e-08
+ $X=0.513 $Y=0.0675 $X2=0.513 $Y2=0.1165
r67 15 110 3.57145 $w=2e-08 $layer=Gate_1 $thickness=5.6e-08 $X=0.513 $Y=0.135
+ $X2=0.513 $Y2=0.135
r68 15 129 6.46262 $w=2.04595e-08 $l=1.85e-08 $layer=Gate_1 $thickness=5.6e-08
+ $X=0.513 $Y=0.135 $X2=0.513 $Y2=0.1165
r69 15 130 6.46262 $w=2.04595e-08 $l=1.85e-08 $layer=Gate_1 $thickness=5.6e-08
+ $X=0.513 $Y=0.135 $X2=0.513 $Y2=0.1535
r70 125 124 16.6668 $w=2.1e-08 $l=4.9e-08 $layer=Gate_1 $thickness=5.6e-08
+ $X=0.459 $Y=0.2025 $X2=0.459 $Y2=0.1535
r71 122 123 16.6668 $w=2.1e-08 $l=4.9e-08 $layer=Gate_1 $thickness=5.6e-08
+ $X=0.459 $Y=0.0675 $X2=0.459 $Y2=0.1165
r72 14 106 3.57145 $w=2e-08 $layer=Gate_1 $thickness=5.6e-08 $X=0.459 $Y=0.135
+ $X2=0.459 $Y2=0.135
r73 14 123 6.46262 $w=2.04595e-08 $l=1.85e-08 $layer=Gate_1 $thickness=5.6e-08
+ $X=0.459 $Y=0.135 $X2=0.459 $Y2=0.1165
r74 14 124 6.46262 $w=2.04595e-08 $l=1.85e-08 $layer=Gate_1 $thickness=5.6e-08
+ $X=0.459 $Y=0.135 $X2=0.459 $Y2=0.1535
r75 119 118 16.6668 $w=2.1e-08 $l=4.9e-08 $layer=Gate_1 $thickness=5.6e-08
+ $X=0.405 $Y=0.2025 $X2=0.405 $Y2=0.1535
r76 116 117 16.6668 $w=2.1e-08 $l=4.9e-08 $layer=Gate_1 $thickness=5.6e-08
+ $X=0.405 $Y=0.0675 $X2=0.405 $Y2=0.1165
r77 13 102 6.74717 $w=2e-08 $layer=Gate_1 $thickness=5.2e-08 $X=0.405 $Y=0.135
+ $X2=0.405 $Y2=0.135
r78 13 117 6.46262 $w=2.04595e-08 $l=1.85e-08 $layer=Gate_1 $thickness=5.6e-08
+ $X=0.405 $Y=0.135 $X2=0.405 $Y2=0.1165
r79 13 118 6.46262 $w=2.04595e-08 $l=1.85e-08 $layer=Gate_1 $thickness=5.6e-08
+ $X=0.405 $Y=0.135 $X2=0.405 $Y2=0.1535
r80 30 100 3.48106 $w=1.50455e-08 $l=2.2e-08 $layer=M1 $thickness=3.6e-08
+ $X=1.345 $Y=0.036 $X2=1.323 $Y2=0.036
r81 30 41 2.5483 $w=1.79e-08 $l=1.8e-08 $layer=M1 $thickness=3.6e-08 $X=1.345
+ $Y=0.036 $X2=1.345 $Y2=0.054
r82 28 92 6.16517 $w=1.44286e-08 $l=3.15e-08 $layer=M1 $thickness=3.6e-08
+ $X=0.918 $Y=0.135 $X2=0.918 $Y2=0.1035
r83 28 139 3.1337 $w=1.54324e-08 $l=1.85e-08 $layer=M1 $thickness=3.6e-08
+ $X=0.918 $Y=0.135 $X2=0.8995 $Y2=0.135
r84 28 40 3.1337 $w=1.54324e-08 $l=1.85e-08 $layer=M1 $thickness=3.6e-08
+ $X=0.918 $Y=0.135 $X2=0.9365 $Y2=0.135
r85 112 113 16.1285 $w=1.6213e-08 $l=2.3e-08 $layer=LIG $thickness=4.8e-08
+ $X=0.544 $Y=0.135 $X2=0.567 $Y2=0.135
r86 111 112 16.9382 $w=1.33e-08 $l=1.7e-08 $layer=LIG $thickness=4.8e-08
+ $X=0.527 $Y=0.135 $X2=0.544 $Y2=0.135
r87 109 110 1.58786 $w=2e-08 $l=5e-09 $layer=LIG $thickness=4.8e-08 $X=0.518
+ $Y=0.135 $X2=0.513 $Y2=0.135
r88 109 111 5.57333 $w=1.70222e-08 $l=9e-09 $layer=LIG $thickness=4.8e-08
+ $X=0.518 $Y=0.135 $X2=0.527 $Y2=0.135
r89 108 109 3.17572 $w=2e-08 $l=1e-08 $layer=LIG $thickness=4.8e-08 $X=0.508
+ $Y=0.135 $X2=0.518 $Y2=0.135
r90 107 108 18.5261 $w=1.48227e-08 $l=2.2e-08 $layer=LIG $thickness=4.8e-08
+ $X=0.486 $Y=0.135 $X2=0.508 $Y2=0.135
r91 105 106 1.90543 $w=2e-08 $l=4e-09 $layer=LIG $thickness=4.8e-08 $X=0.463
+ $Y=0.135 $X2=0.459 $Y2=0.135
r92 105 107 18.8437 $w=1.50478e-08 $l=2.3e-08 $layer=LIG $thickness=4.8e-08
+ $X=0.463 $Y=0.135 $X2=0.486 $Y2=0.135
r93 104 105 3.17572 $w=2e-08 $l=1e-08 $layer=LIG $thickness=4.8e-08 $X=0.453
+ $Y=0.135 $X2=0.463 $Y2=0.135
r94 101 104 6.25213 $w=1.62778e-08 $l=9e-09 $layer=LIG $thickness=4.8e-08
+ $X=0.444 $Y=0.135 $X2=0.453 $Y2=0.135
r95 2 101 16.9382 $w=1.33e-08 $l=1.7e-08 $layer=LIG $thickness=4.8e-08 $X=0.427
+ $Y=0.135 $X2=0.444 $Y2=0.135
r96 2 102 15.1321 $w=1.63455e-08 $l=2.2e-08 $layer=LIG $thickness=4.8e-08
+ $X=0.427 $Y=0.135 $X2=0.405 $Y2=0.135
r97 99 100 8.86121 $w=1.3e-08 $l=3.8e-08 $layer=M1 $thickness=3.6e-08 $X=1.285
+ $Y=0.036 $X2=1.323 $Y2=0.036
r98 98 99 10.7267 $w=1.3e-08 $l=4.6e-08 $layer=M1 $thickness=3.6e-08 $X=1.239
+ $Y=0.036 $X2=1.285 $Y2=0.036
r99 97 98 22.6194 $w=1.3e-08 $l=9.7e-08 $layer=M1 $thickness=3.6e-08 $X=1.142
+ $Y=0.036 $X2=1.239 $Y2=0.036
r100 96 97 18.6552 $w=1.3e-08 $l=8e-08 $layer=M1 $thickness=3.6e-08 $X=1.062
+ $Y=0.036 $X2=1.142 $Y2=0.036
r101 95 96 2.2153 $w=1.3e-08 $l=9.5e-09 $layer=M1 $thickness=3.6e-08 $X=1.0525
+ $Y=0.036 $X2=1.062 $Y2=0.036
r102 94 95 5.82974 $w=1.3e-08 $l=2.5e-08 $layer=M1 $thickness=3.6e-08 $X=1.0275
+ $Y=0.036 $X2=1.0525 $Y2=0.036
r103 93 94 10.3769 $w=1.3e-08 $l=4.45e-08 $layer=M1 $thickness=3.6e-08 $X=0.983
+ $Y=0.036 $X2=1.0275 $Y2=0.036
r104 39 93 9.44419 $w=1.3e-08 $l=4.05e-08 $layer=M1 $thickness=3.6e-08
+ $X=0.9425 $Y=0.036 $X2=0.983 $Y2=0.036
r105 91 92 7.34548 $w=1.3e-08 $l=3.15e-08 $layer=M1 $thickness=3.6e-08 $X=0.918
+ $Y=0.072 $X2=0.918 $Y2=0.1035
r106 38 91 4.19742 $w=1.3e-08 $l=1.8e-08 $layer=M1 $thickness=3.6e-08 $X=0.918
+ $Y=0.054 $X2=0.918 $Y2=0.072
r107 89 109 19.3796 $a=3.24e-16 $layer=V0LIG $X=0.5195 $Y=0.135 $X2=0.518
+ $Y2=0.135
r108 36 89 3.73104 $w=1.3e-08 $l=1.6e-08 $layer=M1 $thickness=3.6e-08 $X=0.5035
+ $Y=0.135 $X2=0.5195 $Y2=0.135
r109 33 87 3.49785 $w=1.3e-08 $l=1.5e-08 $layer=M1 $thickness=3.6e-08 $X=0.4515
+ $Y=0.135 $X2=0.4665 $Y2=0.135
r110 33 101 19.3796 $a=3.24e-16 $layer=V0LIG $X=0.4515 $Y=0.135 $X2=0.444
+ $Y2=0.135
r111 27 86 4.53284 $w=1.48367e-08 $l=2.45e-08 $layer=M1 $thickness=3.6e-08
+ $X=0.918 $Y=0.036 $X2=0.8935 $Y2=0.036
r112 27 38 3.01711 $w=1.55e-08 $l=1.8e-08 $layer=M1 $thickness=3.6e-08 $X=0.918
+ $Y=0.036 $X2=0.918 $Y2=0.054
r113 27 39 4.53284 $w=1.48367e-08 $l=2.45e-08 $layer=M1 $thickness=3.6e-08
+ $X=0.918 $Y=0.036 $X2=0.9425 $Y2=0.036
r114 26 78 6.16517 $w=1.44286e-08 $l=3.15e-08 $layer=M1 $thickness=3.6e-08
+ $X=0.485 $Y=0.135 $X2=0.485 $Y2=0.1035
r115 26 87 3.1337 $w=1.54324e-08 $l=1.85e-08 $layer=M1 $thickness=3.6e-08
+ $X=0.485 $Y=0.135 $X2=0.4665 $Y2=0.135
r116 26 36 3.1337 $w=1.54324e-08 $l=1.85e-08 $layer=M1 $thickness=3.6e-08
+ $X=0.485 $Y=0.135 $X2=0.5035 $Y2=0.135
r117 85 86 9.44419 $w=1.3e-08 $l=4.05e-08 $layer=M1 $thickness=3.6e-08 $X=0.853
+ $Y=0.036 $X2=0.8935 $Y2=0.036
r118 84 85 10.3769 $w=1.3e-08 $l=4.45e-08 $layer=M1 $thickness=3.6e-08
+ $X=0.8085 $Y=0.036 $X2=0.853 $Y2=0.036
r119 83 84 5.82974 $w=1.3e-08 $l=2.5e-08 $layer=M1 $thickness=3.6e-08 $X=0.7835
+ $Y=0.036 $X2=0.8085 $Y2=0.036
r120 82 83 2.2153 $w=1.3e-08 $l=9.5e-09 $layer=M1 $thickness=3.6e-08 $X=0.774
+ $Y=0.036 $X2=0.7835 $Y2=0.036
r121 81 82 18.6552 $w=1.3e-08 $l=8e-08 $layer=M1 $thickness=3.6e-08 $X=0.694
+ $Y=0.036 $X2=0.774 $Y2=0.036
r122 80 81 22.6194 $w=1.3e-08 $l=9.7e-08 $layer=M1 $thickness=3.6e-08 $X=0.597
+ $Y=0.036 $X2=0.694 $Y2=0.036
r123 79 80 10.7267 $w=1.3e-08 $l=4.6e-08 $layer=M1 $thickness=3.6e-08 $X=0.551
+ $Y=0.036 $X2=0.597 $Y2=0.036
r124 35 79 9.56078 $w=1.3e-08 $l=4.1e-08 $layer=M1 $thickness=3.6e-08 $X=0.51
+ $Y=0.036 $X2=0.551 $Y2=0.036
r125 77 78 7.34548 $w=1.3e-08 $l=3.15e-08 $layer=M1 $thickness=3.6e-08 $X=0.485
+ $Y=0.072 $X2=0.485 $Y2=0.1035
r126 34 77 4.19742 $w=1.3e-08 $l=1.8e-08 $layer=M1 $thickness=3.6e-08 $X=0.485
+ $Y=0.054 $X2=0.485 $Y2=0.072
r127 25 76 4.41625 $w=1.4875e-08 $l=2.4e-08 $layer=M1 $thickness=3.6e-08
+ $X=0.485 $Y=0.036 $X2=0.461 $Y2=0.036
r128 25 34 3.01711 $w=1.55e-08 $l=1.8e-08 $layer=M1 $thickness=3.6e-08 $X=0.485
+ $Y=0.036 $X2=0.485 $Y2=0.054
r129 25 35 4.64944 $w=1.48e-08 $l=2.5e-08 $layer=M1 $thickness=3.6e-08 $X=0.485
+ $Y=0.036 $X2=0.51 $Y2=0.036
r130 75 76 9.32759 $w=1.3e-08 $l=4e-08 $layer=M1 $thickness=3.6e-08 $X=0.421
+ $Y=0.036 $X2=0.461 $Y2=0.036
r131 74 75 10.3769 $w=1.3e-08 $l=4.45e-08 $layer=M1 $thickness=3.6e-08
+ $X=0.3765 $Y=0.036 $X2=0.421 $Y2=0.036
r132 73 74 5.82974 $w=1.3e-08 $l=2.5e-08 $layer=M1 $thickness=3.6e-08 $X=0.3515
+ $Y=0.036 $X2=0.3765 $Y2=0.036
r133 72 73 2.2153 $w=1.3e-08 $l=9.5e-09 $layer=M1 $thickness=3.6e-08 $X=0.342
+ $Y=0.036 $X2=0.3515 $Y2=0.036
r134 71 72 18.6552 $w=1.3e-08 $l=8e-08 $layer=M1 $thickness=3.6e-08 $X=0.262
+ $Y=0.036 $X2=0.342 $Y2=0.036
r135 70 71 22.6194 $w=1.3e-08 $l=9.7e-08 $layer=M1 $thickness=3.6e-08 $X=0.165
+ $Y=0.036 $X2=0.262 $Y2=0.036
r136 69 70 10.7267 $w=1.3e-08 $l=4.6e-08 $layer=M1 $thickness=3.6e-08 $X=0.119
+ $Y=0.036 $X2=0.165 $Y2=0.036
r137 32 69 8.86121 $w=1.3e-08 $l=3.8e-08 $layer=M1 $thickness=3.6e-08 $X=0.081
+ $Y=0.036 $X2=0.119 $Y2=0.036
r138 23 66 1.79044 $w=1.89797e-08 $l=1.47e-08 $layer=M1 $thickness=3.6e-08
+ $X=0.059 $Y=0.036 $X2=0.059 $Y2=0.0507
r139 23 32 3.48106 $w=1.50455e-08 $l=2.2e-08 $layer=M1 $thickness=3.6e-08
+ $X=0.059 $Y=0.036 $X2=0.081 $Y2=0.036
r140 67 68 0.757867 $w=1.3e-08 $l=3.2e-09 $layer=M1 $thickness=3.6e-08 $X=0.06
+ $Y=0.057 $X2=0.059 $Y2=0.0602
r141 67 66 1.45744 $w=1.3e-08 $l=6.3e-09 $layer=M1 $thickness=3.6e-08 $X=0.06
+ $Y=0.057 $X2=0.059 $Y2=0.0507
r142 65 68 2.73998 $w=1.3e-08 $l=1.18e-08 $layer=M1 $thickness=3.6e-08 $X=0.059
+ $Y=0.072 $X2=0.059 $Y2=0.0602
r143 31 57 6.16517 $w=1.44286e-08 $l=3.15e-08 $layer=M1 $thickness=3.6e-08
+ $X=0.059 $Y=0.1035 $X2=0.059 $Y2=0.135
r144 31 65 7.34548 $w=1.3e-08 $l=3.15e-08 $layer=M1 $thickness=3.6e-08 $X=0.059
+ $Y=0.1035 $X2=0.059 $Y2=0.072
r145 63 62 16.6668 $w=2.1e-08 $l=4.9e-08 $layer=Gate_1 $thickness=5.6e-08
+ $X=0.135 $Y=0.2025 $X2=0.135 $Y2=0.1535
r146 60 61 16.6668 $w=2.1e-08 $l=4.9e-08 $layer=Gate_1 $thickness=5.6e-08
+ $X=0.135 $Y=0.0675 $X2=0.135 $Y2=0.1165
r147 12 54 6.74717 $w=2e-08 $layer=Gate_1 $thickness=5.2e-08 $X=0.135 $Y=0.135
+ $X2=0.135 $Y2=0.135
r148 12 61 6.46262 $w=2.04595e-08 $l=1.85e-08 $layer=Gate_1 $thickness=5.6e-08
+ $X=0.135 $Y=0.135 $X2=0.135 $Y2=0.1165
r149 12 62 6.46262 $w=2.04595e-08 $l=1.85e-08 $layer=Gate_1 $thickness=5.6e-08
+ $X=0.135 $Y=0.135 $X2=0.135 $Y2=0.1535
r150 24 56 3.03147 $w=1.3e-08 $l=1.3e-08 $layer=M1 $thickness=3.6e-08 $X=0.075
+ $Y=0.135 $X2=0.088 $Y2=0.135
r151 24 57 2.55073 $w=1.58125e-08 $l=1.6e-08 $layer=M1 $thickness=3.6e-08
+ $X=0.075 $Y=0.135 $X2=0.059 $Y2=0.135
r152 53 54 15.6303 $w=1.62778e-08 $l=2.25e-08 $layer=LIG $thickness=4.8e-08
+ $X=0.1125 $Y=0.135 $X2=0.135 $Y2=0.135
r153 52 53 16.9382 $w=1.33e-08 $l=1.7e-08 $layer=LIG $thickness=4.8e-08
+ $X=0.0955 $Y=0.135 $X2=0.1125 $Y2=0.135
r154 50 52 5.91273 $w=1.665e-08 $l=9e-09 $layer=LIG $thickness=4.8e-08
+ $X=0.0865 $Y=0.135 $X2=0.0955 $Y2=0.135
r155 50 56 19.3796 $a=3.24e-16 $layer=V0LIG $X=0.0865 $Y=0.135 $X2=0.088
+ $Y2=0.135
r156 1 50 3.17572 $w=2e-08 $l=1e-08 $layer=LIG $thickness=4.8e-08 $X=0.0765
+ $Y=0.135 $X2=0.0865 $Y2=0.135
r157 1 45 5.3181 $w=2e-08 $l=4.5e-09 $layer=Gate_1 $thickness=5.31613e-08
+ $X=0.0765 $Y=0.135 $X2=0.081 $Y2=0.135
r158 48 47 14.6259 $w=2.1e-08 $l=4.3e-08 $layer=Gate_1 $thickness=5.6e-08
+ $X=0.081 $Y=0.2025 $X2=0.081 $Y2=0.1595
r159 46 47 2.89117 $w=2.1e-08 $l=8.5e-09 $layer=Gate_1 $thickness=5.6e-08
+ $X=0.081 $Y=0.151 $X2=0.081 $Y2=0.1595
r160 45 46 5.61228 $w=2.0375e-08 $l=1.6e-08 $layer=Gate_1 $thickness=5.6e-08
+ $X=0.081 $Y=0.135 $X2=0.081 $Y2=0.151
r161 45 50 5.00052 $w=2e-08 $l=5.5e-09 $layer=Gate_1 $thickness=5.35172e-08
+ $X=0.081 $Y=0.135 $X2=0.0865 $Y2=0.135
r162 44 45 5.61228 $w=2.0375e-08 $l=1.6e-08 $layer=Gate_1 $thickness=5.6e-08
+ $X=0.081 $Y=0.119 $X2=0.081 $Y2=0.135
r163 43 44 2.89117 $w=2.1e-08 $l=8.5e-09 $layer=Gate_1 $thickness=5.6e-08
+ $X=0.081 $Y=0.1105 $X2=0.081 $Y2=0.119
r164 42 43 14.6259 $w=2.1e-08 $l=4.3e-08 $layer=Gate_1 $thickness=5.6e-08
+ $X=0.081 $Y=0.0675 $X2=0.081 $Y2=0.1105
r165 42 11 14.6259 $w=2.1e-08 $l=4.3e-08 $layer=Gate_1 $thickness=5.6e-08
+ $X=0.081 $Y=0.0675 $X2=0.081 $Y2=0.0245
.ends

.subckt PM_CKINVDCx12_ASAP7_75t_R%Y vss 86 74 75 98 99 117 118 131 132 135 136
+ 154 155 162 163 176 177 180 181 198 199 206 207 210 211 47 53 2 6 8 10 12 57
+ 59 49 63 4 50 60 62 51 55 68 64 44 45 46 37 42 38 39 40 41 43 48 7 9 5 3 1 11
+ 61 71 65 67 69 66 70
c1 1 vss 0.00697111f $X=0.108 $Y=0.0675
c2 2 vss 0.00835744f $X=0.108 $Y=0.2025
c3 3 vss 0.0067973f $X=0.432 $Y=0.0675
c4 4 vss 0.00802583f $X=0.432 $Y=0.2025
c5 5 vss 0.00678974f $X=0.54 $Y=0.0675
c6 6 vss 0.00802243f $X=0.54 $Y=0.2025
c7 7 vss 0.0067959f $X=0.864 $Y=0.0675
c8 8 vss 0.00802583f $X=0.864 $Y=0.2025
c9 9 vss 0.0067959f $X=0.972 $Y=0.0675
c10 10 vss 0.00802583f $X=0.972 $Y=0.2025
c11 11 vss 0.00697111f $X=1.296 $Y=0.0675
c12 12 vss 0.00835744f $X=1.296 $Y=0.2025
c13 37 vss 0.00438603f $X=0.0935 $Y=0.0675
c14 38 vss 0.0043132f $X=0.4175 $Y=0.0675
c15 39 vss 0.00431299f $X=0.5255 $Y=0.0675
c16 40 vss 0.0043132f $X=0.8495 $Y=0.0675
c17 41 vss 0.0043132f $X=0.9575 $Y=0.0675
c18 42 vss 0.00438603f $X=1.2815 $Y=0.0675
c19 43 vss 0.00439866f $X=0.0935 $Y=0.2025
c20 44 vss 0.00433555f $X=0.4175 $Y=0.2025
c21 45 vss 0.00433553f $X=0.5255 $Y=0.2025
c22 46 vss 0.00433555f $X=0.8495 $Y=0.2025
c23 47 vss 0.00433555f $X=0.9575 $Y=0.2025
c24 48 vss 0.00439866f $X=1.2815 $Y=0.2025
c25 49 vss 0.00105766f $X=0.0965 $Y=0.072
c26 50 vss 0.00542943f $X=0.135 $Y=0.234
c27 51 vss 0.00115606f $X=0.405 $Y=0.072
c28 52 vss 0.00202404f $X=0.405 $Y=0.234
c29 53 vss 0.00112384f $X=0.567 $Y=0.072
c30 54 vss 0.00213277f $X=0.567 $Y=0.234
c31 55 vss 0.00113959f $X=0.837 $Y=0.072
c32 56 vss 0.00202404f $X=0.837 $Y=0.234
c33 57 vss 0.00113959f $X=0.999 $Y=0.072
c34 58 vss 0.00202404f $X=0.999 $Y=0.234
c35 59 vss 0.00105766f $X=1.269 $Y=0.072
c36 60 vss 0.00542943f $X=1.269 $Y=0.234
c37 61 vss 0.00338884f $X=0.135 $Y=0.0855
c38 62 vss 0.0226038f $X=0.165 $Y=0.234
c39 63 vss 0.0030318f $X=0.405 $Y=0.2025
c40 64 vss 0.012128f $X=0.4185 $Y=0.234
c41 65 vss 0.00305213f $X=0.567 $Y=0.2025
c42 66 vss 0.0226409f $X=0.597 $Y=0.234
c43 67 vss 0.00299244f $X=0.837 $Y=0.2025
c44 68 vss 0.0119594f $X=0.8505 $Y=0.234
c45 69 vss 0.00299244f $X=0.999 $Y=0.2025
c46 70 vss 0.022605f $X=1.0275 $Y=0.234
c47 71 vss 0.00338884f $X=1.269 $Y=0.2025
r1 211 209 0.0308642 $w=8.1e-08 $l=2.5e-09 $layer=N_src_drn $thickness=1e-09
+ $X=1.3133 $Y=0.0675 $X2=1.3105 $Y2=0.0675
r2 11 209 0.179012 $w=8.1e-08 $l=1.45e-08 $layer=N_src_drn $thickness=1e-09
+ $X=1.296 $Y=0.0675 $X2=1.3105 $Y2=0.0675
r3 42 11 0.179012 $w=8.1e-08 $l=1.45e-08 $layer=N_src_drn $thickness=1e-09
+ $X=1.2815 $Y=0.0675 $X2=1.296 $Y2=0.0675
r4 210 42 0.0308642 $w=8.1e-08 $l=2.5e-09 $layer=N_src_drn $thickness=1e-09
+ $X=1.2786 $Y=0.0675 $X2=1.2815 $Y2=0.0675
r5 11 201 19.3796 $a=3.24e-16 $layer=V0LISD $X=1.296 $Y=0.0675 $X2=1.2955
+ $Y2=0.072
r6 207 205 0.0308642 $w=8.1e-08 $l=2.5e-09 $layer=P_src_drn $thickness=1e-09
+ $X=1.3133 $Y=0.2025 $X2=1.3105 $Y2=0.2025
r7 12 205 0.179012 $w=8.1e-08 $l=1.45e-08 $layer=P_src_drn $thickness=1e-09
+ $X=1.296 $Y=0.2025 $X2=1.3105 $Y2=0.2025
r8 48 12 0.179012 $w=8.1e-08 $l=1.45e-08 $layer=P_src_drn $thickness=1e-09
+ $X=1.2815 $Y=0.2025 $X2=1.296 $Y2=0.2025
r9 206 48 0.0308642 $w=8.1e-08 $l=2.5e-09 $layer=P_src_drn $thickness=1e-09
+ $X=1.2786 $Y=0.2025 $X2=1.2815 $Y2=0.2025
r10 200 201 3.03147 $w=1.3e-08 $l=1.3e-08 $layer=M1 $thickness=3.6e-08
+ $X=1.2825 $Y=0.072 $X2=1.2955 $Y2=0.072
r11 59 195 1.96775 $w=1.63333e-08 $l=1.35e-08 $layer=M1 $thickness=3.6e-08
+ $X=1.269 $Y=0.072 $X2=1.269 $Y2=0.0855
r12 59 200 1.96775 $w=1.63333e-08 $l=1.35e-08 $layer=M1 $thickness=3.6e-08
+ $X=1.269 $Y=0.072 $X2=1.2825 $Y2=0.072
r13 199 197 0.0308642 $w=8.1e-08 $l=2.5e-09 $layer=N_src_drn $thickness=1e-09
+ $X=0.9893 $Y=0.0675 $X2=0.9865 $Y2=0.0675
r14 9 197 0.179012 $w=8.1e-08 $l=1.45e-08 $layer=N_src_drn $thickness=1e-09
+ $X=0.972 $Y=0.0675 $X2=0.9865 $Y2=0.0675
r15 41 9 0.179012 $w=8.1e-08 $l=1.45e-08 $layer=N_src_drn $thickness=1e-09
+ $X=0.9575 $Y=0.0675 $X2=0.972 $Y2=0.0675
r16 198 41 0.0308642 $w=8.1e-08 $l=2.5e-09 $layer=N_src_drn $thickness=1e-09
+ $X=0.9546 $Y=0.0675 $X2=0.9575 $Y2=0.0675
r17 12 187 19.3796 $a=3.24e-16 $layer=V0LISD $X=1.296 $Y=0.2025 $X2=1.2955
+ $Y2=0.234
r18 194 195 3.14806 $w=1.3e-08 $l=1.35e-08 $layer=M1 $thickness=3.6e-08
+ $X=1.269 $Y=0.099 $X2=1.269 $Y2=0.0855
r19 193 194 4.19742 $w=1.3e-08 $l=1.8e-08 $layer=M1 $thickness=3.6e-08 $X=1.269
+ $Y=0.117 $X2=1.269 $Y2=0.099
r20 192 193 4.19742 $w=1.3e-08 $l=1.8e-08 $layer=M1 $thickness=3.6e-08 $X=1.269
+ $Y=0.135 $X2=1.269 $Y2=0.117
r21 191 192 4.19742 $w=1.3e-08 $l=1.8e-08 $layer=M1 $thickness=3.6e-08 $X=1.269
+ $Y=0.153 $X2=1.269 $Y2=0.135
r22 190 191 4.19742 $w=1.3e-08 $l=1.8e-08 $layer=M1 $thickness=3.6e-08 $X=1.269
+ $Y=0.171 $X2=1.269 $Y2=0.153
r23 71 190 7.34548 $w=1.3e-08 $l=3.15e-08 $layer=M1 $thickness=3.6e-08 $X=1.269
+ $Y=0.2025 $X2=1.269 $Y2=0.171
r24 9 182 19.3796 $a=3.24e-16 $layer=V0LISD $X=0.972 $Y=0.0675 $X2=0.9725
+ $Y2=0.072
r25 186 187 3.03147 $w=1.3e-08 $l=1.3e-08 $layer=M1 $thickness=3.6e-08
+ $X=1.2825 $Y=0.234 $X2=1.2955 $Y2=0.234
r26 60 173 5.81538 $w=1.45e-08 $l=3e-08 $layer=M1 $thickness=3.6e-08 $X=1.269
+ $Y=0.234 $X2=1.239 $Y2=0.234
r27 60 186 1.96775 $w=1.63333e-08 $l=1.35e-08 $layer=M1 $thickness=3.6e-08
+ $X=1.269 $Y=0.234 $X2=1.2825 $Y2=0.234
r28 60 71 6.16517 $w=1.44286e-08 $l=3.15e-08 $layer=M1 $thickness=3.6e-08
+ $X=1.269 $Y=0.234 $X2=1.269 $Y2=0.2025
r29 182 183 3.03147 $w=1.3e-08 $l=1.3e-08 $layer=M1 $thickness=3.6e-08
+ $X=0.9725 $Y=0.072 $X2=0.9855 $Y2=0.072
r30 57 169 1.96775 $w=1.63333e-08 $l=1.35e-08 $layer=M1 $thickness=3.6e-08
+ $X=0.999 $Y=0.072 $X2=0.999 $Y2=0.0855
r31 57 183 1.96775 $w=1.63333e-08 $l=1.35e-08 $layer=M1 $thickness=3.6e-08
+ $X=0.999 $Y=0.072 $X2=0.9855 $Y2=0.072
r32 181 179 0.0308642 $w=8.1e-08 $l=2.5e-09 $layer=N_src_drn $thickness=1e-09
+ $X=0.8813 $Y=0.0675 $X2=0.8785 $Y2=0.0675
r33 7 179 0.179012 $w=8.1e-08 $l=1.45e-08 $layer=N_src_drn $thickness=1e-09
+ $X=0.864 $Y=0.0675 $X2=0.8785 $Y2=0.0675
r34 40 7 0.179012 $w=8.1e-08 $l=1.45e-08 $layer=N_src_drn $thickness=1e-09
+ $X=0.8495 $Y=0.0675 $X2=0.864 $Y2=0.0675
r35 180 40 0.0308642 $w=8.1e-08 $l=2.5e-09 $layer=N_src_drn $thickness=1e-09
+ $X=0.8466 $Y=0.0675 $X2=0.8495 $Y2=0.0675
r36 177 175 0.0308642 $w=8.1e-08 $l=2.5e-09 $layer=P_src_drn $thickness=1e-09
+ $X=0.9893 $Y=0.2025 $X2=0.9865 $Y2=0.2025
r37 10 175 0.179012 $w=8.1e-08 $l=1.45e-08 $layer=P_src_drn $thickness=1e-09
+ $X=0.972 $Y=0.2025 $X2=0.9865 $Y2=0.2025
r38 47 10 0.179012 $w=8.1e-08 $l=1.45e-08 $layer=P_src_drn $thickness=1e-09
+ $X=0.9575 $Y=0.2025 $X2=0.972 $Y2=0.2025
r39 176 47 0.0308642 $w=8.1e-08 $l=2.5e-09 $layer=P_src_drn $thickness=1e-09
+ $X=0.9546 $Y=0.2025 $X2=0.9575 $Y2=0.2025
r40 172 173 6.06293 $w=1.3e-08 $l=2.6e-08 $layer=M1 $thickness=3.6e-08 $X=1.213
+ $Y=0.234 $X2=1.239 $Y2=0.234
r41 171 172 1.86552 $w=1.3e-08 $l=8e-09 $layer=M1 $thickness=3.6e-08 $X=1.205
+ $Y=0.234 $X2=1.213 $Y2=0.234
r42 170 171 18.7718 $w=1.3e-08 $l=8.05e-08 $layer=M1 $thickness=3.6e-08
+ $X=1.1245 $Y=0.234 $X2=1.205 $Y2=0.234
r43 70 170 22.6194 $w=1.3e-08 $l=9.7e-08 $layer=M1 $thickness=3.6e-08 $X=1.0275
+ $Y=0.234 $X2=1.1245 $Y2=0.234
r44 168 169 3.14806 $w=1.3e-08 $l=1.35e-08 $layer=M1 $thickness=3.6e-08
+ $X=0.999 $Y=0.099 $X2=0.999 $Y2=0.0855
r45 167 168 4.19742 $w=1.3e-08 $l=1.8e-08 $layer=M1 $thickness=3.6e-08 $X=0.999
+ $Y=0.117 $X2=0.999 $Y2=0.099
r46 166 167 4.19742 $w=1.3e-08 $l=1.8e-08 $layer=M1 $thickness=3.6e-08 $X=0.999
+ $Y=0.135 $X2=0.999 $Y2=0.117
r47 165 166 4.19742 $w=1.3e-08 $l=1.8e-08 $layer=M1 $thickness=3.6e-08 $X=0.999
+ $Y=0.153 $X2=0.999 $Y2=0.135
r48 164 165 4.19742 $w=1.3e-08 $l=1.8e-08 $layer=M1 $thickness=3.6e-08 $X=0.999
+ $Y=0.171 $X2=0.999 $Y2=0.153
r49 69 164 7.34548 $w=1.3e-08 $l=3.15e-08 $layer=M1 $thickness=3.6e-08 $X=0.999
+ $Y=0.2025 $X2=0.999 $Y2=0.171
r50 163 161 0.0308642 $w=8.1e-08 $l=2.5e-09 $layer=P_src_drn $thickness=1e-09
+ $X=0.8813 $Y=0.2025 $X2=0.8785 $Y2=0.2025
r51 8 161 0.179012 $w=8.1e-08 $l=1.45e-08 $layer=P_src_drn $thickness=1e-09
+ $X=0.864 $Y=0.2025 $X2=0.8785 $Y2=0.2025
r52 46 8 0.179012 $w=8.1e-08 $l=1.45e-08 $layer=P_src_drn $thickness=1e-09
+ $X=0.8495 $Y=0.2025 $X2=0.864 $Y2=0.2025
r53 162 46 0.0308642 $w=8.1e-08 $l=2.5e-09 $layer=P_src_drn $thickness=1e-09
+ $X=0.8466 $Y=0.2025 $X2=0.8495 $Y2=0.2025
r54 7 157 19.3796 $a=3.24e-16 $layer=V0LISD $X=0.864 $Y=0.0675 $X2=0.8635
+ $Y2=0.072
r55 10 150 19.3796 $a=3.24e-16 $layer=V0LISD $X=0.972 $Y=0.2025 $X2=0.9725
+ $Y2=0.234
r56 58 151 1.96775 $w=1.63333e-08 $l=1.35e-08 $layer=M1 $thickness=3.6e-08
+ $X=0.999 $Y=0.234 $X2=0.9855 $Y2=0.234
r57 58 69 6.16517 $w=1.44286e-08 $l=3.15e-08 $layer=M1 $thickness=3.6e-08
+ $X=0.999 $Y=0.234 $X2=0.999 $Y2=0.2025
r58 58 70 5.4656 $w=1.45789e-08 $l=2.85e-08 $layer=M1 $thickness=3.6e-08
+ $X=0.999 $Y=0.234 $X2=1.0275 $Y2=0.234
r59 8 146 19.3796 $a=3.24e-16 $layer=V0LISD $X=0.864 $Y=0.2025 $X2=0.8635
+ $Y2=0.234
r60 156 157 3.03147 $w=1.3e-08 $l=1.3e-08 $layer=M1 $thickness=3.6e-08
+ $X=0.8505 $Y=0.072 $X2=0.8635 $Y2=0.072
r61 55 145 1.96775 $w=1.63333e-08 $l=1.35e-08 $layer=M1 $thickness=3.6e-08
+ $X=0.837 $Y=0.072 $X2=0.837 $Y2=0.0855
r62 55 156 1.96775 $w=1.63333e-08 $l=1.35e-08 $layer=M1 $thickness=3.6e-08
+ $X=0.837 $Y=0.072 $X2=0.8505 $Y2=0.072
r63 155 153 0.0308642 $w=8.1e-08 $l=2.5e-09 $layer=N_src_drn $thickness=1e-09
+ $X=0.5573 $Y=0.0675 $X2=0.5545 $Y2=0.0675
r64 5 153 0.179012 $w=8.1e-08 $l=1.45e-08 $layer=N_src_drn $thickness=1e-09
+ $X=0.54 $Y=0.0675 $X2=0.5545 $Y2=0.0675
r65 39 5 0.179012 $w=8.1e-08 $l=1.45e-08 $layer=N_src_drn $thickness=1e-09
+ $X=0.5255 $Y=0.0675 $X2=0.54 $Y2=0.0675
r66 154 39 0.0308642 $w=8.1e-08 $l=2.5e-09 $layer=N_src_drn $thickness=1e-09
+ $X=0.5226 $Y=0.0675 $X2=0.5255 $Y2=0.0675
r67 150 151 3.03147 $w=1.3e-08 $l=1.3e-08 $layer=M1 $thickness=3.6e-08
+ $X=0.9725 $Y=0.234 $X2=0.9855 $Y2=0.234
r68 149 150 2.09871 $w=1.3e-08 $l=9e-09 $layer=M1 $thickness=3.6e-08 $X=0.9635
+ $Y=0.234 $X2=0.9725 $Y2=0.234
r69 148 149 10.6101 $w=1.3e-08 $l=4.55e-08 $layer=M1 $thickness=3.6e-08
+ $X=0.918 $Y=0.234 $X2=0.9635 $Y2=0.234
r70 147 148 10.6101 $w=1.3e-08 $l=4.55e-08 $layer=M1 $thickness=3.6e-08
+ $X=0.8725 $Y=0.234 $X2=0.918 $Y2=0.234
r71 146 147 2.09871 $w=1.3e-08 $l=9e-09 $layer=M1 $thickness=3.6e-08 $X=0.8635
+ $Y=0.234 $X2=0.8725 $Y2=0.234
r72 68 146 3.03147 $w=1.3e-08 $l=1.3e-08 $layer=M1 $thickness=3.6e-08 $X=0.8505
+ $Y=0.234 $X2=0.8635 $Y2=0.234
r73 144 145 3.14806 $w=1.3e-08 $l=1.35e-08 $layer=M1 $thickness=3.6e-08
+ $X=0.837 $Y=0.099 $X2=0.837 $Y2=0.0855
r74 143 144 4.19742 $w=1.3e-08 $l=1.8e-08 $layer=M1 $thickness=3.6e-08 $X=0.837
+ $Y=0.117 $X2=0.837 $Y2=0.099
r75 142 143 4.19742 $w=1.3e-08 $l=1.8e-08 $layer=M1 $thickness=3.6e-08 $X=0.837
+ $Y=0.135 $X2=0.837 $Y2=0.117
r76 141 142 4.19742 $w=1.3e-08 $l=1.8e-08 $layer=M1 $thickness=3.6e-08 $X=0.837
+ $Y=0.153 $X2=0.837 $Y2=0.135
r77 140 141 4.19742 $w=1.3e-08 $l=1.8e-08 $layer=M1 $thickness=3.6e-08 $X=0.837
+ $Y=0.171 $X2=0.837 $Y2=0.153
r78 67 140 7.34548 $w=1.3e-08 $l=3.15e-08 $layer=M1 $thickness=3.6e-08 $X=0.837
+ $Y=0.2025 $X2=0.837 $Y2=0.171
r79 5 137 19.3796 $a=3.24e-16 $layer=V0LISD $X=0.54 $Y=0.0675 $X2=0.54 $Y2=0.072
r80 56 128 5.4656 $w=1.45789e-08 $l=2.85e-08 $layer=M1 $thickness=3.6e-08
+ $X=0.837 $Y=0.234 $X2=0.8085 $Y2=0.234
r81 56 67 6.16517 $w=1.44286e-08 $l=3.15e-08 $layer=M1 $thickness=3.6e-08
+ $X=0.837 $Y=0.234 $X2=0.837 $Y2=0.2025
r82 56 68 1.96775 $w=1.63333e-08 $l=1.35e-08 $layer=M1 $thickness=3.6e-08
+ $X=0.837 $Y=0.234 $X2=0.8505 $Y2=0.234
r83 137 138 3.14806 $w=1.3e-08 $l=1.35e-08 $layer=M1 $thickness=3.6e-08 $X=0.54
+ $Y=0.072 $X2=0.5535 $Y2=0.072
r84 53 124 1.96775 $w=1.63333e-08 $l=1.35e-08 $layer=M1 $thickness=3.6e-08
+ $X=0.567 $Y=0.072 $X2=0.567 $Y2=0.0855
r85 53 138 1.96775 $w=1.63333e-08 $l=1.35e-08 $layer=M1 $thickness=3.6e-08
+ $X=0.567 $Y=0.072 $X2=0.5535 $Y2=0.072
r86 136 134 0.0308642 $w=8.1e-08 $l=2.5e-09 $layer=N_src_drn $thickness=1e-09
+ $X=0.4493 $Y=0.0675 $X2=0.4465 $Y2=0.0675
r87 3 134 0.179012 $w=8.1e-08 $l=1.45e-08 $layer=N_src_drn $thickness=1e-09
+ $X=0.432 $Y=0.0675 $X2=0.4465 $Y2=0.0675
r88 38 3 0.179012 $w=8.1e-08 $l=1.45e-08 $layer=N_src_drn $thickness=1e-09
+ $X=0.4175 $Y=0.0675 $X2=0.432 $Y2=0.0675
r89 135 38 0.0308642 $w=8.1e-08 $l=2.5e-09 $layer=N_src_drn $thickness=1e-09
+ $X=0.4146 $Y=0.0675 $X2=0.4175 $Y2=0.0675
r90 132 130 0.0308642 $w=8.1e-08 $l=2.5e-09 $layer=P_src_drn $thickness=1e-09
+ $X=0.5573 $Y=0.2025 $X2=0.5545 $Y2=0.2025
r91 6 130 0.179012 $w=8.1e-08 $l=1.45e-08 $layer=P_src_drn $thickness=1e-09
+ $X=0.54 $Y=0.2025 $X2=0.5545 $Y2=0.2025
r92 45 6 0.179012 $w=8.1e-08 $l=1.45e-08 $layer=P_src_drn $thickness=1e-09
+ $X=0.5255 $Y=0.2025 $X2=0.54 $Y2=0.2025
r93 131 45 0.0308642 $w=8.1e-08 $l=2.5e-09 $layer=P_src_drn $thickness=1e-09
+ $X=0.5226 $Y=0.2025 $X2=0.5255 $Y2=0.2025
r94 127 128 22.6194 $w=1.3e-08 $l=9.7e-08 $layer=M1 $thickness=3.6e-08
+ $X=0.7115 $Y=0.234 $X2=0.8085 $Y2=0.234
r95 126 127 18.7718 $w=1.3e-08 $l=8.05e-08 $layer=M1 $thickness=3.6e-08
+ $X=0.631 $Y=0.234 $X2=0.7115 $Y2=0.234
r96 125 126 1.86552 $w=1.3e-08 $l=8e-09 $layer=M1 $thickness=3.6e-08 $X=0.623
+ $Y=0.234 $X2=0.631 $Y2=0.234
r97 66 125 6.06293 $w=1.3e-08 $l=2.6e-08 $layer=M1 $thickness=3.6e-08 $X=0.597
+ $Y=0.234 $X2=0.623 $Y2=0.234
r98 123 124 3.14806 $w=1.3e-08 $l=1.35e-08 $layer=M1 $thickness=3.6e-08
+ $X=0.567 $Y=0.099 $X2=0.567 $Y2=0.0855
r99 122 123 4.19742 $w=1.3e-08 $l=1.8e-08 $layer=M1 $thickness=3.6e-08 $X=0.567
+ $Y=0.117 $X2=0.567 $Y2=0.099
r100 121 122 4.19742 $w=1.3e-08 $l=1.8e-08 $layer=M1 $thickness=3.6e-08
+ $X=0.567 $Y=0.135 $X2=0.567 $Y2=0.117
r101 120 121 4.19742 $w=1.3e-08 $l=1.8e-08 $layer=M1 $thickness=3.6e-08
+ $X=0.567 $Y=0.153 $X2=0.567 $Y2=0.135
r102 119 120 4.19742 $w=1.3e-08 $l=1.8e-08 $layer=M1 $thickness=3.6e-08
+ $X=0.567 $Y=0.171 $X2=0.567 $Y2=0.153
r103 65 119 7.34548 $w=1.3e-08 $l=3.15e-08 $layer=M1 $thickness=3.6e-08
+ $X=0.567 $Y=0.2025 $X2=0.567 $Y2=0.171
r104 118 116 0.0308642 $w=8.1e-08 $l=2.5e-09 $layer=P_src_drn $thickness=1e-09
+ $X=0.4493 $Y=0.2025 $X2=0.4465 $Y2=0.2025
r105 4 116 0.179012 $w=8.1e-08 $l=1.45e-08 $layer=P_src_drn $thickness=1e-09
+ $X=0.432 $Y=0.2025 $X2=0.4465 $Y2=0.2025
r106 44 4 0.179012 $w=8.1e-08 $l=1.45e-08 $layer=P_src_drn $thickness=1e-09
+ $X=0.4175 $Y=0.2025 $X2=0.432 $Y2=0.2025
r107 117 44 0.0308642 $w=8.1e-08 $l=2.5e-09 $layer=P_src_drn $thickness=1e-09
+ $X=0.4146 $Y=0.2025 $X2=0.4175 $Y2=0.2025
r108 3 112 19.3796 $a=3.24e-16 $layer=V0LISD $X=0.432 $Y=0.0675 $X2=0.431
+ $Y2=0.072
r109 6 109 19.3796 $a=3.24e-16 $layer=V0LISD $X=0.54 $Y=0.2025 $X2=0.54
+ $Y2=0.234
r110 54 110 1.96775 $w=1.63333e-08 $l=1.35e-08 $layer=M1 $thickness=3.6e-08
+ $X=0.567 $Y=0.234 $X2=0.5535 $Y2=0.234
r111 54 65 6.16517 $w=1.44286e-08 $l=3.15e-08 $layer=M1 $thickness=3.6e-08
+ $X=0.567 $Y=0.234 $X2=0.567 $Y2=0.2025
r112 54 66 5.81538 $w=1.45e-08 $l=3e-08 $layer=M1 $thickness=3.6e-08 $X=0.567
+ $Y=0.234 $X2=0.597 $Y2=0.234
r113 4 106 19.3796 $a=3.24e-16 $layer=V0LISD $X=0.432 $Y=0.2025 $X2=0.431
+ $Y2=0.234
r114 111 112 2.91487 $w=1.3e-08 $l=1.25e-08 $layer=M1 $thickness=3.6e-08
+ $X=0.4185 $Y=0.072 $X2=0.431 $Y2=0.072
r115 51 105 1.96775 $w=1.63333e-08 $l=1.35e-08 $layer=M1 $thickness=3.6e-08
+ $X=0.405 $Y=0.072 $X2=0.405 $Y2=0.0855
r116 51 111 1.96775 $w=1.63333e-08 $l=1.35e-08 $layer=M1 $thickness=3.6e-08
+ $X=0.405 $Y=0.072 $X2=0.4185 $Y2=0.072
r117 109 110 3.14806 $w=1.3e-08 $l=1.35e-08 $layer=M1 $thickness=3.6e-08
+ $X=0.54 $Y=0.234 $X2=0.5535 $Y2=0.234
r118 108 109 12.5922 $w=1.3e-08 $l=5.4e-08 $layer=M1 $thickness=3.6e-08
+ $X=0.486 $Y=0.234 $X2=0.54 $Y2=0.234
r119 107 108 10.7267 $w=1.3e-08 $l=4.6e-08 $layer=M1 $thickness=3.6e-08 $X=0.44
+ $Y=0.234 $X2=0.486 $Y2=0.234
r120 106 107 2.09871 $w=1.3e-08 $l=9e-09 $layer=M1 $thickness=3.6e-08 $X=0.431
+ $Y=0.234 $X2=0.44 $Y2=0.234
r121 64 106 2.91487 $w=1.3e-08 $l=1.25e-08 $layer=M1 $thickness=3.6e-08
+ $X=0.4185 $Y=0.234 $X2=0.431 $Y2=0.234
r122 104 105 3.14806 $w=1.3e-08 $l=1.35e-08 $layer=M1 $thickness=3.6e-08
+ $X=0.405 $Y=0.099 $X2=0.405 $Y2=0.0855
r123 103 104 4.19742 $w=1.3e-08 $l=1.8e-08 $layer=M1 $thickness=3.6e-08
+ $X=0.405 $Y=0.117 $X2=0.405 $Y2=0.099
r124 102 103 4.19742 $w=1.3e-08 $l=1.8e-08 $layer=M1 $thickness=3.6e-08
+ $X=0.405 $Y=0.135 $X2=0.405 $Y2=0.117
r125 101 102 4.19742 $w=1.3e-08 $l=1.8e-08 $layer=M1 $thickness=3.6e-08
+ $X=0.405 $Y=0.153 $X2=0.405 $Y2=0.135
r126 100 101 4.19742 $w=1.3e-08 $l=1.8e-08 $layer=M1 $thickness=3.6e-08
+ $X=0.405 $Y=0.171 $X2=0.405 $Y2=0.153
r127 63 100 7.34548 $w=1.3e-08 $l=3.15e-08 $layer=M1 $thickness=3.6e-08
+ $X=0.405 $Y=0.2025 $X2=0.405 $Y2=0.171
r128 99 97 0.0308642 $w=8.1e-08 $l=2.5e-09 $layer=P_src_drn $thickness=1e-09
+ $X=0.1253 $Y=0.2025 $X2=0.1225 $Y2=0.2025
r129 2 97 0.179012 $w=8.1e-08 $l=1.45e-08 $layer=P_src_drn $thickness=1e-09
+ $X=0.108 $Y=0.2025 $X2=0.1225 $Y2=0.2025
r130 43 2 0.179012 $w=8.1e-08 $l=1.45e-08 $layer=P_src_drn $thickness=1e-09
+ $X=0.0935 $Y=0.2025 $X2=0.108 $Y2=0.2025
r131 98 43 0.0308642 $w=8.1e-08 $l=2.5e-09 $layer=P_src_drn $thickness=1e-09
+ $X=0.0906 $Y=0.2025 $X2=0.0935 $Y2=0.2025
r132 52 95 5.4656 $w=1.45789e-08 $l=2.85e-08 $layer=M1 $thickness=3.6e-08
+ $X=0.405 $Y=0.234 $X2=0.3765 $Y2=0.234
r133 52 63 6.16517 $w=1.44286e-08 $l=3.15e-08 $layer=M1 $thickness=3.6e-08
+ $X=0.405 $Y=0.234 $X2=0.405 $Y2=0.2025
r134 52 64 1.96775 $w=1.63333e-08 $l=1.35e-08 $layer=M1 $thickness=3.6e-08
+ $X=0.405 $Y=0.234 $X2=0.4185 $Y2=0.234
r135 2 88 19.3796 $a=3.24e-16 $layer=V0LISD $X=0.108 $Y=0.2025 $X2=0.1085
+ $Y2=0.234
r136 94 95 22.6194 $w=1.3e-08 $l=9.7e-08 $layer=M1 $thickness=3.6e-08 $X=0.2795
+ $Y=0.234 $X2=0.3765 $Y2=0.234
r137 93 94 18.7718 $w=1.3e-08 $l=8.05e-08 $layer=M1 $thickness=3.6e-08 $X=0.199
+ $Y=0.234 $X2=0.2795 $Y2=0.234
r138 92 93 1.86552 $w=1.3e-08 $l=8e-09 $layer=M1 $thickness=3.6e-08 $X=0.191
+ $Y=0.234 $X2=0.199 $Y2=0.234
r139 62 92 6.06293 $w=1.3e-08 $l=2.6e-08 $layer=M1 $thickness=3.6e-08 $X=0.165
+ $Y=0.234 $X2=0.191 $Y2=0.234
r140 88 89 3.03147 $w=1.3e-08 $l=1.3e-08 $layer=M1 $thickness=3.6e-08 $X=0.1085
+ $Y=0.234 $X2=0.1215 $Y2=0.234
r141 50 87 2.60903 $w=1.57692e-08 $l=1.63e-08 $layer=M1 $thickness=3.6e-08
+ $X=0.135 $Y=0.234 $X2=0.135 $Y2=0.2177
r142 50 89 1.96775 $w=1.63333e-08 $l=1.35e-08 $layer=M1 $thickness=3.6e-08
+ $X=0.135 $Y=0.234 $X2=0.1215 $Y2=0.234
r143 50 62 5.81538 $w=1.45e-08 $l=3e-08 $layer=M1 $thickness=3.6e-08 $X=0.135
+ $Y=0.234 $X2=0.165 $Y2=0.234
r144 86 87 1.80722 $w=1.3e-08 $l=7.7e-09 $layer=M1 $thickness=3.6e-08 $X=0.135
+ $Y=0.21 $X2=0.135 $Y2=0.2177
r145 86 85 3.55614 $w=1.3e-08 $l=1.53e-08 $layer=M1 $thickness=3.6e-08 $X=0.135
+ $Y=0.21 $X2=0.135 $Y2=0.1947
r146 84 85 5.53826 $w=1.3e-08 $l=2.37e-08 $layer=M1 $thickness=3.6e-08 $X=0.135
+ $Y=0.171 $X2=0.135 $Y2=0.1947
r147 83 84 4.19742 $w=1.3e-08 $l=1.8e-08 $layer=M1 $thickness=3.6e-08 $X=0.135
+ $Y=0.153 $X2=0.135 $Y2=0.171
r148 82 83 4.19742 $w=1.3e-08 $l=1.8e-08 $layer=M1 $thickness=3.6e-08 $X=0.135
+ $Y=0.135 $X2=0.135 $Y2=0.153
r149 81 82 4.19742 $w=1.3e-08 $l=1.8e-08 $layer=M1 $thickness=3.6e-08 $X=0.135
+ $Y=0.117 $X2=0.135 $Y2=0.135
r150 80 81 4.19742 $w=1.3e-08 $l=1.8e-08 $layer=M1 $thickness=3.6e-08 $X=0.135
+ $Y=0.099 $X2=0.135 $Y2=0.117
r151 61 79 1.96775 $w=1.63333e-08 $l=1.35e-08 $layer=M1 $thickness=3.6e-08
+ $X=0.135 $Y=0.0855 $X2=0.135 $Y2=0.072
r152 61 80 3.14806 $w=1.3e-08 $l=1.35e-08 $layer=M1 $thickness=3.6e-08 $X=0.135
+ $Y=0.0855 $X2=0.135 $Y2=0.099
r153 78 79 1.96775 $w=1.63333e-08 $l=1.35e-08 $layer=M1 $thickness=3.6e-08
+ $X=0.1215 $Y=0.072 $X2=0.135 $Y2=0.072
r154 77 78 3.03147 $w=1.3e-08 $l=1.3e-08 $layer=M1 $thickness=3.6e-08 $X=0.1085
+ $Y=0.072 $X2=0.1215 $Y2=0.072
r155 76 77 2.09871 $w=1.3e-08 $l=9e-09 $layer=M1 $thickness=3.6e-08 $X=0.0995
+ $Y=0.072 $X2=0.1085 $Y2=0.072
r156 49 76 0.699569 $w=1.3e-08 $l=3e-09 $layer=M1 $thickness=3.6e-08 $X=0.0965
+ $Y=0.072 $X2=0.0995 $Y2=0.072
r157 1 77 19.3796 $a=3.24e-16 $layer=V0LISD $X=0.108 $Y=0.0675 $X2=0.1085
+ $Y2=0.072
r158 75 73 0.0308642 $w=8.1e-08 $l=2.5e-09 $layer=N_src_drn $thickness=1e-09
+ $X=0.1253 $Y=0.0675 $X2=0.1225 $Y2=0.0675
r159 1 73 0.179012 $w=8.1e-08 $l=1.45e-08 $layer=N_src_drn $thickness=1e-09
+ $X=0.108 $Y=0.0675 $X2=0.1225 $Y2=0.0675
r160 37 1 0.179012 $w=8.1e-08 $l=1.45e-08 $layer=N_src_drn $thickness=1e-09
+ $X=0.0935 $Y=0.0675 $X2=0.108 $Y2=0.0675
r161 74 37 0.0308642 $w=8.1e-08 $l=2.5e-09 $layer=N_src_drn $thickness=1e-09
+ $X=0.0906 $Y=0.0675 $X2=0.0935 $Y2=0.0675
.ends

.subckt PM_CKINVDCx12_ASAP7_75t_R%7 vss 19 23 33 36 46 47 50 51 10 15 17 9 3 1
+ 11 13 4 18
c1 1 vss 0.0063201f $X=0.729 $Y=0.135
c2 3 vss 0.00722138f $X=0.648 $Y=0.2025
c3 4 vss 0.00717163f $X=0.756 $Y=0.2025
c4 9 vss 0.0821889f $X=0.729 $Y=0.0245
c5 10 vss 0.0823992f $X=0.783 $Y=0.135
c6 11 vss 0.00720755f $X=0.6335 $Y=0.2025
c7 12 vss 0.00673333f $X=0.7415 $Y=0.2025
c8 13 vss 0.000209692f $X=0.729 $Y=0.135
c9 14 vss 0.00035654f $X=0.729 $Y=0.171
c10 15 vss 0.00263759f $X=0.702 $Y=0.171
c11 16 vss 0.000149613f $X=0.729 $Y=0.153
c12 17 vss 0.0006692f $X=0.7425 $Y=0.135
c13 18 vss 0.0013316f $X=0.7425 $Y=0.171
r1 51 49 0.0308642 $w=8.1e-08 $l=2.5e-09 $layer=P_src_drn $thickness=1e-09
+ $X=0.7733 $Y=0.2025 $X2=0.7705 $Y2=0.2025
r2 4 49 0.179012 $w=8.1e-08 $l=1.45e-08 $layer=P_src_drn $thickness=1e-09
+ $X=0.756 $Y=0.2025 $X2=0.7705 $Y2=0.2025
r3 12 4 0.179012 $w=8.1e-08 $l=1.45e-08 $layer=P_src_drn $thickness=1e-09
+ $X=0.7415 $Y=0.2025 $X2=0.756 $Y2=0.2025
r4 50 12 0.0308642 $w=8.1e-08 $l=2.5e-09 $layer=P_src_drn $thickness=1e-09
+ $X=0.7386 $Y=0.2025 $X2=0.7415 $Y2=0.2025
r5 47 45 0.0308642 $w=8.1e-08 $l=2.5e-09 $layer=P_src_drn $thickness=1e-09
+ $X=0.6653 $Y=0.2025 $X2=0.6625 $Y2=0.2025
r6 3 45 0.179012 $w=8.1e-08 $l=1.45e-08 $layer=P_src_drn $thickness=1e-09
+ $X=0.648 $Y=0.2025 $X2=0.6625 $Y2=0.2025
r7 11 3 0.179012 $w=8.1e-08 $l=1.45e-08 $layer=P_src_drn $thickness=1e-09
+ $X=0.6335 $Y=0.2025 $X2=0.648 $Y2=0.2025
r8 46 11 0.0308642 $w=8.1e-08 $l=2.5e-09 $layer=P_src_drn $thickness=1e-09
+ $X=0.6306 $Y=0.2025 $X2=0.6335 $Y2=0.2025
r9 4 41 19.3796 $a=3.24e-16 $layer=V0LISD $X=0.756 $Y=0.2025 $X2=0.756 $Y2=0.171
r10 3 39 19.3796 $a=3.24e-16 $layer=V0LISD $X=0.648 $Y=0.2025 $X2=0.648
+ $Y2=0.171
r11 18 41 3.14806 $w=1.3e-08 $l=1.35e-08 $layer=M1 $thickness=3.6e-08 $X=0.7425
+ $Y=0.171 $X2=0.756 $Y2=0.171
r12 39 40 5.24677 $w=1.3e-08 $l=2.25e-08 $layer=M1 $thickness=3.6e-08 $X=0.648
+ $Y=0.171 $X2=0.6705 $Y2=0.171
r13 15 40 7.34548 $w=1.3e-08 $l=3.15e-08 $layer=M1 $thickness=3.6e-08 $X=0.702
+ $Y=0.171 $X2=0.6705 $Y2=0.171
r14 14 16 3.01711 $w=1.55e-08 $l=1.8e-08 $layer=M1 $thickness=3.6e-08 $X=0.729
+ $Y=0.171 $X2=0.729 $Y2=0.153
r15 14 15 5.11582 $w=1.46667e-08 $l=2.7e-08 $layer=M1 $thickness=3.6e-08
+ $X=0.729 $Y=0.171 $X2=0.702 $Y2=0.171
r16 14 18 1.96775 $w=1.63333e-08 $l=1.35e-08 $layer=M1 $thickness=3.6e-08
+ $X=0.729 $Y=0.171 $X2=0.7425 $Y2=0.171
r17 13 17 1.49895 $w=1.63333e-08 $l=1.35e-08 $layer=M1 $thickness=3.6e-08
+ $X=0.729 $Y=0.135 $X2=0.7425 $Y2=0.135
r18 13 16 2.5483 $w=1.79e-08 $l=1.8e-08 $layer=M1 $thickness=3.6e-08 $X=0.729
+ $Y=0.135 $X2=0.729 $Y2=0.153
r19 36 35 16.4967 $w=2.1e-08 $l=4.85e-08 $layer=Gate_1 $thickness=5.6e-08
+ $X=0.783 $Y=0.2025 $X2=0.783 $Y2=0.154
r20 33 34 16.4967 $w=2.1e-08 $l=4.85e-08 $layer=Gate_1 $thickness=5.6e-08
+ $X=0.783 $Y=0.0675 $X2=0.783 $Y2=0.116
r21 10 27 6.54019 $w=2.09524e-08 $layer=Gate_1 $thickness=5.21905e-08 $X=0.783
+ $Y=0.135 $X2=0.783 $Y2=0.135
r22 10 34 6.6497 $w=2.04211e-08 $l=1.9e-08 $layer=Gate_1 $thickness=5.6e-08
+ $X=0.783 $Y=0.135 $X2=0.783 $Y2=0.116
r23 10 35 6.6497 $w=2.04211e-08 $l=1.9e-08 $layer=Gate_1 $thickness=5.6e-08
+ $X=0.783 $Y=0.135 $X2=0.783 $Y2=0.154
r24 17 29 3.14806 $w=1.3e-08 $l=1.35e-08 $layer=M1 $thickness=3.6e-08 $X=0.7425
+ $Y=0.135 $X2=0.756 $Y2=0.135
r25 26 27 12.6539 $w=1.77815e-08 $l=2.7e-08 $layer=LIG $thickness=4.8e-08
+ $X=0.756 $Y=0.135 $X2=0.783 $Y2=0.135
r26 26 29 19.3796 $a=3.24e-16 $layer=V0LIG $X=0.756 $Y=0.135 $X2=0.756 $Y2=0.135
r27 1 21 6.54019 $w=2.09524e-08 $layer=Gate_1 $thickness=5.21905e-08 $X=0.729
+ $Y=0.135 $X2=0.729 $Y2=0.135
r28 1 26 12.6539 $w=1.77815e-08 $l=2.7e-08 $layer=LIG $thickness=4.8e-08
+ $X=0.729 $Y=0.135 $X2=0.756 $Y2=0.135
r29 23 22 16.4967 $w=2.1e-08 $l=4.85e-08 $layer=Gate_1 $thickness=5.6e-08
+ $X=0.729 $Y=0.2025 $X2=0.729 $Y2=0.154
r30 21 22 6.6497 $w=2.04211e-08 $l=1.9e-08 $layer=Gate_1 $thickness=5.6e-08
+ $X=0.729 $Y=0.135 $X2=0.729 $Y2=0.154
r31 20 21 6.6497 $w=2.04211e-08 $l=1.9e-08 $layer=Gate_1 $thickness=5.6e-08
+ $X=0.729 $Y=0.116 $X2=0.729 $Y2=0.135
r32 19 20 16.4967 $w=2.1e-08 $l=4.85e-08 $layer=Gate_1 $thickness=5.6e-08
+ $X=0.729 $Y=0.0675 $X2=0.729 $Y2=0.116
r33 19 9 14.6259 $w=2.1e-08 $l=4.3e-08 $layer=Gate_1 $thickness=5.6e-08
+ $X=0.729 $Y=0.0675 $X2=0.729 $Y2=0.0245
.ends

.subckt PM_CKINVDCx12_ASAP7_75t_R%8 vss 19 23 33 36 46 47 50 51 10 15 17 9 3 1
+ 11 13 4 18
c1 1 vss 0.00632f $X=0.297 $Y=0.135
c2 3 vss 0.00721622f $X=0.216 $Y=0.2025
c3 4 vss 0.0071647f $X=0.324 $Y=0.2025
c4 9 vss 0.0821746f $X=0.297 $Y=0.0245
c5 10 vss 0.0823777f $X=0.351 $Y=0.135
c6 11 vss 0.00704355f $X=0.2015 $Y=0.2025
c7 12 vss 0.00658315f $X=0.3095 $Y=0.2025
c8 13 vss 0.000208548f $X=0.297 $Y=0.135
c9 14 vss 0.000355396f $X=0.297 $Y=0.171
c10 15 vss 0.00259443f $X=0.27 $Y=0.171
c11 16 vss 0.000149609f $X=0.297 $Y=0.153
c12 17 vss 0.000691823f $X=0.3105 $Y=0.135
c13 18 vss 0.00133187f $X=0.3105 $Y=0.171
r1 51 49 0.0308642 $w=8.1e-08 $l=2.5e-09 $layer=P_src_drn $thickness=1e-09
+ $X=0.3413 $Y=0.2025 $X2=0.3385 $Y2=0.2025
r2 4 49 0.179012 $w=8.1e-08 $l=1.45e-08 $layer=P_src_drn $thickness=1e-09
+ $X=0.324 $Y=0.2025 $X2=0.3385 $Y2=0.2025
r3 12 4 0.179012 $w=8.1e-08 $l=1.45e-08 $layer=P_src_drn $thickness=1e-09
+ $X=0.3095 $Y=0.2025 $X2=0.324 $Y2=0.2025
r4 50 12 0.0308642 $w=8.1e-08 $l=2.5e-09 $layer=P_src_drn $thickness=1e-09
+ $X=0.3066 $Y=0.2025 $X2=0.3095 $Y2=0.2025
r5 47 45 0.0308642 $w=8.1e-08 $l=2.5e-09 $layer=P_src_drn $thickness=1e-09
+ $X=0.2333 $Y=0.2025 $X2=0.2305 $Y2=0.2025
r6 3 45 0.179012 $w=8.1e-08 $l=1.45e-08 $layer=P_src_drn $thickness=1e-09
+ $X=0.216 $Y=0.2025 $X2=0.2305 $Y2=0.2025
r7 11 3 0.179012 $w=8.1e-08 $l=1.45e-08 $layer=P_src_drn $thickness=1e-09
+ $X=0.2015 $Y=0.2025 $X2=0.216 $Y2=0.2025
r8 46 11 0.0308642 $w=8.1e-08 $l=2.5e-09 $layer=P_src_drn $thickness=1e-09
+ $X=0.1986 $Y=0.2025 $X2=0.2015 $Y2=0.2025
r9 4 41 19.3796 $a=3.24e-16 $layer=V0LISD $X=0.324 $Y=0.2025 $X2=0.324 $Y2=0.171
r10 3 39 19.3796 $a=3.24e-16 $layer=V0LISD $X=0.216 $Y=0.2025 $X2=0.216
+ $Y2=0.171
r11 18 41 3.14806 $w=1.3e-08 $l=1.35e-08 $layer=M1 $thickness=3.6e-08 $X=0.3105
+ $Y=0.171 $X2=0.324 $Y2=0.171
r12 39 40 5.24677 $w=1.3e-08 $l=2.25e-08 $layer=M1 $thickness=3.6e-08 $X=0.216
+ $Y=0.171 $X2=0.2385 $Y2=0.171
r13 15 40 7.34548 $w=1.3e-08 $l=3.15e-08 $layer=M1 $thickness=3.6e-08 $X=0.27
+ $Y=0.171 $X2=0.2385 $Y2=0.171
r14 14 16 3.01711 $w=1.55e-08 $l=1.8e-08 $layer=M1 $thickness=3.6e-08 $X=0.297
+ $Y=0.171 $X2=0.297 $Y2=0.153
r15 14 15 5.11582 $w=1.46667e-08 $l=2.7e-08 $layer=M1 $thickness=3.6e-08
+ $X=0.297 $Y=0.171 $X2=0.27 $Y2=0.171
r16 14 18 1.96775 $w=1.63333e-08 $l=1.35e-08 $layer=M1 $thickness=3.6e-08
+ $X=0.297 $Y=0.171 $X2=0.3105 $Y2=0.171
r17 13 17 1.49895 $w=1.63333e-08 $l=1.35e-08 $layer=M1 $thickness=3.6e-08
+ $X=0.297 $Y=0.135 $X2=0.3105 $Y2=0.135
r18 13 16 2.5483 $w=1.79e-08 $l=1.8e-08 $layer=M1 $thickness=3.6e-08 $X=0.297
+ $Y=0.135 $X2=0.297 $Y2=0.153
r19 36 35 16.4967 $w=2.1e-08 $l=4.85e-08 $layer=Gate_1 $thickness=5.6e-08
+ $X=0.351 $Y=0.2025 $X2=0.351 $Y2=0.154
r20 33 34 16.4967 $w=2.1e-08 $l=4.85e-08 $layer=Gate_1 $thickness=5.6e-08
+ $X=0.351 $Y=0.0675 $X2=0.351 $Y2=0.116
r21 10 27 6.54019 $w=2.09524e-08 $layer=Gate_1 $thickness=5.21905e-08 $X=0.351
+ $Y=0.135 $X2=0.351 $Y2=0.135
r22 10 34 6.6497 $w=2.04211e-08 $l=1.9e-08 $layer=Gate_1 $thickness=5.6e-08
+ $X=0.351 $Y=0.135 $X2=0.351 $Y2=0.116
r23 10 35 6.6497 $w=2.04211e-08 $l=1.9e-08 $layer=Gate_1 $thickness=5.6e-08
+ $X=0.351 $Y=0.135 $X2=0.351 $Y2=0.154
r24 17 29 3.14806 $w=1.3e-08 $l=1.35e-08 $layer=M1 $thickness=3.6e-08 $X=0.3105
+ $Y=0.135 $X2=0.324 $Y2=0.135
r25 26 27 12.6539 $w=1.77815e-08 $l=2.7e-08 $layer=LIG $thickness=4.8e-08
+ $X=0.324 $Y=0.135 $X2=0.351 $Y2=0.135
r26 26 29 19.3796 $a=3.24e-16 $layer=V0LIG $X=0.324 $Y=0.135 $X2=0.324 $Y2=0.135
r27 1 21 6.54019 $w=2.09524e-08 $layer=Gate_1 $thickness=5.21905e-08 $X=0.297
+ $Y=0.135 $X2=0.297 $Y2=0.135
r28 1 26 12.6539 $w=1.77815e-08 $l=2.7e-08 $layer=LIG $thickness=4.8e-08
+ $X=0.297 $Y=0.135 $X2=0.324 $Y2=0.135
r29 23 22 16.4967 $w=2.1e-08 $l=4.85e-08 $layer=Gate_1 $thickness=5.6e-08
+ $X=0.297 $Y=0.2025 $X2=0.297 $Y2=0.154
r30 21 22 6.6497 $w=2.04211e-08 $l=1.9e-08 $layer=Gate_1 $thickness=5.6e-08
+ $X=0.297 $Y=0.135 $X2=0.297 $Y2=0.154
r31 20 21 6.6497 $w=2.04211e-08 $l=1.9e-08 $layer=Gate_1 $thickness=5.6e-08
+ $X=0.297 $Y=0.116 $X2=0.297 $Y2=0.135
r32 19 20 16.4967 $w=2.1e-08 $l=4.85e-08 $layer=Gate_1 $thickness=5.6e-08
+ $X=0.297 $Y=0.0675 $X2=0.297 $Y2=0.116
r33 19 9 14.6259 $w=2.1e-08 $l=4.3e-08 $layer=Gate_1 $thickness=5.6e-08
+ $X=0.297 $Y=0.0675 $X2=0.297 $Y2=0.0245
.ends

* End of included file CKINVDCx12_ASAP7_75t_R.pex.sp.pex

*
.subckt CKINVDCx12_ASAP7_75t_CUSTOM_4_25_0_7 VSS VDD A Y
*
* VSS VSS
* VDD VDD
* A A
* Y Y
*
*

M0 N_M0_d N_M0_g VSS VSS nmos_rvt L=2e-08 W=8.1e-08 nfin=3 $X=0.071 $Y=0.027
M1 N_M1_d N_M1_g VSS VSS nmos_rvt L=2e-08 W=8.1e-08 nfin=3 $X=0.125 $Y=0.027
M20 N_M20_d N_M20_g VSS VSS nmos_rvt L=2e-08 W=8.1e-08 nfin=3 $X=0.179 $Y=0.027
M21 N_M21_d N_M21_g VSS VSS nmos_rvt L=2e-08 W=8.1e-08 nfin=3 $X=0.233 $Y=0.027
M18 N_M18_d N_M18_g VSS VSS nmos_rvt L=2e-08 W=8.1e-08 nfin=3 $X=0.287 $Y=0.027
M19 N_M19_d N_M19_g VSS VSS nmos_rvt L=2e-08 W=8.1e-08 nfin=3 $X=0.341 $Y=0.027
M6 N_M6_d N_M6_g VSS VSS nmos_rvt L=2e-08 W=8.1e-08 nfin=3 $X=0.395 $Y=0.027
M7 N_M7_d N_M7_g VSS VSS nmos_rvt L=2e-08 W=8.1e-08 nfin=3 $X=0.449 $Y=0.027
M8 N_M8_d N_M8_g VSS VSS nmos_rvt L=2e-08 W=8.1e-08 nfin=3 $X=0.503 $Y=0.027
M9 N_M9_d N_M9_g VSS VSS nmos_rvt L=2e-08 W=8.1e-08 nfin=3 $X=0.557 $Y=0.027
M10 N_M10_d N_M10_g VSS VSS nmos_rvt L=2e-08 W=8.1e-08 nfin=3 $X=0.611 $Y=0.027
M11 N_M11_d N_M11_g VSS VSS nmos_rvt L=2e-08 W=8.1e-08 nfin=3 $X=0.665 $Y=0.027
M12 N_M12_d N_M12_g VSS VSS nmos_rvt L=2e-08 W=8.1e-08 nfin=3 $X=0.719 $Y=0.027
M13 N_M13_d N_M13_g VSS VSS nmos_rvt L=2e-08 W=8.1e-08 nfin=3 $X=0.773 $Y=0.027
M14 N_M14_d N_M14_g VSS VSS nmos_rvt L=2e-08 W=8.1e-08 nfin=3 $X=0.827 $Y=0.027
M15 N_M15_d N_M15_g VSS VSS nmos_rvt L=2e-08 W=8.1e-08 nfin=3 $X=0.881 $Y=0.027
M16 N_M16_d N_M16_g VSS VSS nmos_rvt L=2e-08 W=8.1e-08 nfin=3 $X=0.935 $Y=0.027
M17 N_M17_d N_M17_g VSS VSS nmos_rvt L=2e-08 W=8.1e-08 nfin=3 $X=0.989 $Y=0.027
M4 N_M4_d N_M4_g VSS VSS nmos_rvt L=2e-08 W=8.1e-08 nfin=3 $X=1.043 $Y=0.027
M5 N_M5_d N_M5_g VSS VSS nmos_rvt L=2e-08 W=8.1e-08 nfin=3 $X=1.097 $Y=0.027
M2 N_M2_d N_M2_g VSS VSS nmos_rvt L=2e-08 W=8.1e-08 nfin=3 $X=1.151 $Y=0.027
M3 N_M3_d N_M3_g VSS VSS nmos_rvt L=2e-08 W=8.1e-08 nfin=3 $X=1.205 $Y=0.027
M22 N_M22_d N_M22_g VSS VSS nmos_rvt L=2e-08 W=8.1e-08 nfin=3 $X=1.259 $Y=0.027
M23 N_M23_d N_M23_g VSS VSS nmos_rvt L=2e-08 W=8.1e-08 nfin=3 $X=1.313 $Y=0.027
M24 N_M24_d N_M24_g VDD VDD pmos_rvt L=2e-08 W=8.1e-08 nfin=3 $X=0.071 $Y=0.162
M25 N_M25_d N_M25_g VDD VDD pmos_rvt L=2e-08 W=8.1e-08 nfin=3 $X=0.125 $Y=0.162
M44 N_M44_d N_M44_g VDD VDD pmos_rvt L=2e-08 W=8.1e-08 nfin=3 $X=0.179 $Y=0.162
M45 N_M45_d N_M45_g VDD VDD pmos_rvt L=2e-08 W=8.1e-08 nfin=3 $X=0.233 $Y=0.162
M42 N_M42_d N_M42_g VDD VDD pmos_rvt L=2e-08 W=8.1e-08 nfin=3 $X=0.287 $Y=0.162
M43 N_M43_d N_M43_g VDD VDD pmos_rvt L=2e-08 W=8.1e-08 nfin=3 $X=0.341 $Y=0.162
M30 N_M30_d N_M30_g VDD VDD pmos_rvt L=2e-08 W=8.1e-08 nfin=3 $X=0.395 $Y=0.162
M31 N_M31_d N_M31_g VDD VDD pmos_rvt L=2e-08 W=8.1e-08 nfin=3 $X=0.449 $Y=0.162
M32 N_M32_d N_M32_g VDD VDD pmos_rvt L=2e-08 W=8.1e-08 nfin=3 $X=0.503 $Y=0.162
M33 N_M33_d N_M33_g VDD VDD pmos_rvt L=2e-08 W=8.1e-08 nfin=3 $X=0.557 $Y=0.162
M34 N_M34_d N_M34_g VDD VDD pmos_rvt L=2e-08 W=8.1e-08 nfin=3 $X=0.611 $Y=0.162
M35 N_M35_d N_M35_g VDD VDD pmos_rvt L=2e-08 W=8.1e-08 nfin=3 $X=0.665 $Y=0.162
M36 N_M36_d N_M36_g VDD VDD pmos_rvt L=2e-08 W=8.1e-08 nfin=3 $X=0.719 $Y=0.162
M37 N_M37_d N_M37_g VDD VDD pmos_rvt L=2e-08 W=8.1e-08 nfin=3 $X=0.773 $Y=0.162
M38 N_M38_d N_M38_g VDD VDD pmos_rvt L=2e-08 W=8.1e-08 nfin=3 $X=0.827 $Y=0.162
M39 N_M39_d N_M39_g VDD VDD pmos_rvt L=2e-08 W=8.1e-08 nfin=3 $X=0.881 $Y=0.162
M40 N_M40_d N_M40_g VDD VDD pmos_rvt L=2e-08 W=8.1e-08 nfin=3 $X=0.935 $Y=0.162
M41 N_M41_d N_M41_g VDD VDD pmos_rvt L=2e-08 W=8.1e-08 nfin=3 $X=0.989 $Y=0.162
M28 N_M28_d N_M28_g VDD VDD pmos_rvt L=2e-08 W=8.1e-08 nfin=3 $X=1.043 $Y=0.162
M29 N_M29_d N_M29_g VDD VDD pmos_rvt L=2e-08 W=8.1e-08 nfin=3 $X=1.097 $Y=0.162
M26 N_M26_d N_M26_g VDD VDD pmos_rvt L=2e-08 W=8.1e-08 nfin=3 $X=1.151 $Y=0.162
M27 N_M27_d N_M27_g VDD VDD pmos_rvt L=2e-08 W=8.1e-08 nfin=3 $X=1.205 $Y=0.162
M46 N_M46_d N_M46_g VDD VDD pmos_rvt L=2e-08 W=8.1e-08 nfin=3 $X=1.259 $Y=0.162
M47 N_M47_d N_M47_g VDD VDD pmos_rvt L=2e-08 W=8.1e-08 nfin=3 $X=1.313 $Y=0.162

* .include "CKINVDCx12_ASAP7_75t_R.pex.sp.pxi"

* Start of included file CKINVDCx12_ASAP7_75t_R.pex.sp.pxi
x_PM_CKINVDCx12_ASAP7_75t_R%9 vss N_M20_g N_M44_g N_M21_g N_M45_g N_M20_d
+ N_M21_d N_M18_d N_M19_d N_9_18 N_9_4 N_9_15 N_9_1 N_9_9 N_9_12 N_9_16 N_9_10
+ N_9_14 PM_CKINVDCx12_ASAP7_75t_R%9
cc_1 N_9_18 N_A_31 4.97328e-20 $X=0.27 $Y=0.099
cc_2 N_9_18 N_A_1 0.00013096f $X=0.27 $Y=0.099
cc_3 N_9_4 N_A_32 0.000749204f $X=0.324 $Y=0.0675
cc_4 N_9_15 N_A_32 0.000814573f $X=0.2015 $Y=0.099
cc_5 N_9_1 N_A_1 0.00102924f $X=0.189 $Y=0.135
cc_6 N_9_9 N_A_12 0.00346785f $X=0.189 $Y=0.0245
cc_7 N_9_18 N_A_32 0.0073122f $X=0.27 $Y=0.099
x_PM_CKINVDCx12_ASAP7_75t_R%5 vss N_M4_g N_M28_g N_M5_g N_M29_g N_M28_d N_M29_d
+ N_M26_d N_M27_d N_5_9 N_5_18 N_5_16 N_5_4 N_5_10 N_5_1 N_5_12 N_5_13 N_5_3
+ N_5_15 PM_CKINVDCx12_ASAP7_75t_R%5
cc_8 N_5_9 N_A_38 3.85567e-20 $X=1.053 $Y=0.0245
cc_9 N_5_9 N_A_3 0.00145619f $X=1.053 $Y=0.0245
cc_10 N_5_9 N_A_4 0.000114727f $X=1.053 $Y=0.0245
cc_11 N_5_9 N_A_20 0.00360237f $X=1.053 $Y=0.0245
x_PM_CKINVDCx12_ASAP7_75t_R%4 vss N_M2_g N_M26_g N_M3_g N_M27_g N_M4_d N_M5_d
+ N_M2_d N_M3_d N_4_15 N_4_3 N_4_17 N_4_1 N_4_10 N_4_11 N_4_18 N_4_9 N_4_14
+ PM_CKINVDCx12_ASAP7_75t_R%4
cc_12 N_4_15 N_A_4 0.00021178f $X=1.134 $Y=0.099
cc_13 N_4_3 N_A_39 0.000749204f $X=1.08 $Y=0.0675
cc_14 N_4_17 N_A_39 0.000814573f $X=1.1745 $Y=0.099
cc_15 N_4_1 N_A_4 0.00107615f $X=1.161 $Y=0.135
cc_16 N_4_10 N_A_21 0.00346785f $X=1.215 $Y=0.135
cc_17 N_4_15 N_A_39 0.00727153f $X=1.134 $Y=0.099
cc_18 N_4_11 N_5_9 0.0200798f $X=1.0655 $Y=0.0675
cc_19 N_4_18 N_5_18 0.00127705f $X=1.1745 $Y=0.135
cc_20 N_4_15 N_5_16 0.00132246f $X=1.134 $Y=0.099
cc_21 N_4_9 N_5_4 0.00143019f $X=1.161 $Y=0.0245
cc_22 N_4_3 N_5_10 0.00143019f $X=1.08 $Y=0.0675
cc_23 N_4_3 N_5_1 0.00173267f $X=1.08 $Y=0.0675
cc_24 N_4_1 N_5_4 0.00173267f $X=1.161 $Y=0.135
cc_25 N_4_11 N_5_1 0.0029964f $X=1.0655 $Y=0.0675
cc_26 N_4_1 N_5_12 0.0029964f $X=1.161 $Y=0.135
cc_27 N_4_15 N_5_13 0.00381209f $X=1.134 $Y=0.099
cc_28 N_4_14 N_5_18 0.00381581f $X=1.161 $Y=0.135
cc_29 N_4_9 N_5_12 0.0398108f $X=1.161 $Y=0.0245
cc_30 N_4_10 N_5_12 0.0297725f $X=1.215 $Y=0.135
cc_31 N_4_11 N_5_10 0.052385f $X=1.0655 $Y=0.0675
x_PM_CKINVDCx12_ASAP7_75t_R%6 vss N_M10_g N_M34_g N_M11_g N_M35_g N_M10_d
+ N_M11_d N_M12_d N_M13_d N_6_18 N_6_1 N_6_3 N_6_4 N_6_15 N_6_9 N_6_12 N_6_16
+ N_6_10 N_6_14 PM_CKINVDCx12_ASAP7_75t_R%6
cc_32 N_6_18 N_A_34 5.2583e-20 $X=0.702 $Y=0.099
cc_33 N_6_18 N_A_2 0.00061033f $X=0.702 $Y=0.099
cc_34 N_6_1 N_A_2 0.000586929f $X=0.621 $Y=0.135
cc_35 N_6_3 N_A_35 0.00073852f $X=0.648 $Y=0.0675
cc_36 N_6_4 N_A_35 0.000749204f $X=0.756 $Y=0.0675
cc_37 N_6_15 N_A_35 0.000814573f $X=0.6335 $Y=0.099
cc_38 N_6_9 N_A_16 0.00348613f $X=0.621 $Y=0.0245
cc_39 N_6_18 N_A_35 0.00656143f $X=0.702 $Y=0.099
x_PM_CKINVDCx12_ASAP7_75t_R%A vss A N_M0_g N_M24_g N_M1_g N_M25_g N_M6_g
+ N_M30_g N_M7_g N_M31_g N_M8_g N_M32_g N_M9_g N_M33_g N_M14_g N_M38_g N_M15_g
+ N_M39_g N_M16_g N_M40_g N_M17_g N_M41_g N_M22_g N_M46_g N_M23_g N_M47_g
+ N_A_31 N_A_1 N_A_32 N_A_12 N_A_34 N_A_2 N_A_13 N_A_35 N_A_16 N_A_3 N_A_17
+ N_A_38 N_A_4 N_A_20 N_A_39 N_A_21 N_A_27 N_A_25 N_A_26 N_A_28 N_A_30 N_A_23
+ N_A_14 N_A_24 N_A_29 N_A_15 N_A_18 N_A_19 N_A_11 N_A_22 N_A_41 N_A_36 N_A_37
+ N_A_33 N_A_40 PM_CKINVDCx12_ASAP7_75t_R%A
x_PM_CKINVDCx12_ASAP7_75t_R%Y vss Y N_M0_d N_M1_d N_M24_d N_M25_d N_M30_d
+ N_M31_d N_M32_d N_M33_d N_M6_d N_M7_d N_M8_d N_M9_d N_M38_d N_M39_d N_M40_d
+ N_M41_d N_M14_d N_M15_d N_M16_d N_M17_d N_M46_d N_M47_d N_M22_d N_M23_d
+ N_Y_47 N_Y_53 N_Y_2 N_Y_6 N_Y_8 N_Y_10 N_Y_12 N_Y_57 N_Y_59 N_Y_49 N_Y_63
+ N_Y_4 N_Y_50 N_Y_60 N_Y_62 N_Y_51 N_Y_55 N_Y_68 N_Y_64 N_Y_44 N_Y_45 N_Y_46
+ N_Y_37 N_Y_42 N_Y_38 N_Y_39 N_Y_40 N_Y_41 N_Y_43 N_Y_48 N_Y_7 N_Y_9 N_Y_5
+ N_Y_3 N_Y_1 N_Y_11 N_Y_61 N_Y_71 N_Y_65 N_Y_67 N_Y_69 N_Y_66 N_Y_70
+ PM_CKINVDCx12_ASAP7_75t_R%Y
cc_40 N_Y_47 N_A_27 0.000112767f $X=0.9575 $Y=0.2025
cc_41 N_Y_47 N_A_25 8.01265e-20 $X=0.9575 $Y=0.2025
cc_42 N_Y_53 N_A_26 9.96201e-20 $X=0.567 $Y=0.072
cc_43 N_Y_2 N_A_12 0.000104575f $X=0.108 $Y=0.2025
cc_44 N_Y_6 N_A_16 0.00164488f $X=0.54 $Y=0.2025
cc_45 N_Y_8 N_A_17 0.000104575f $X=0.864 $Y=0.2025
cc_46 N_Y_10 N_A_20 0.000104575f $X=0.972 $Y=0.2025
cc_47 N_Y_12 N_A_21 0.000104575f $X=1.296 $Y=0.2025
cc_48 N_Y_57 N_A_28 0.000107338f $X=0.999 $Y=0.072
cc_49 N_Y_59 N_A_30 0.000108396f $X=1.269 $Y=0.072
cc_50 N_Y_49 N_A_23 0.000108418f $X=0.0965 $Y=0.072
cc_51 N_Y_63 N_A_26 0.000114607f $X=0.405 $Y=0.2025
cc_52 N_Y_4 N_A_14 0.00166943f $X=0.432 $Y=0.2025
cc_53 N_Y_50 N_A_24 0.000161372f $X=0.135 $Y=0.234
cc_54 N_Y_60 N_A_29 0.000161372f $X=1.269 $Y=0.234
cc_55 N_Y_62 N_A_13 0.000161939f $X=0.165 $Y=0.234
cc_56 N_Y_49 N_A_24 0.000210173f $X=0.0965 $Y=0.072
cc_57 N_Y_59 N_A_29 0.000246294f $X=1.269 $Y=0.072
cc_58 N_Y_51 N_A_26 0.000251646f $X=0.405 $Y=0.072
cc_59 N_Y_55 N_A_28 0.000367281f $X=0.837 $Y=0.072
cc_60 N_Y_68 N_A_28 0.00051981f $X=0.8505 $Y=0.234
cc_61 N_Y_64 N_A_26 0.000536771f $X=0.4185 $Y=0.234
cc_62 N_Y_44 N_A_14 0.0187163f $X=0.4175 $Y=0.2025
cc_63 N_Y_45 N_A_15 0.0548273f $X=0.5255 $Y=0.2025
cc_64 N_Y_46 N_A_18 0.000805258f $X=0.8495 $Y=0.2025
cc_65 N_Y_47 N_A_19 0.000805258f $X=0.9575 $Y=0.2025
cc_66 N_Y_37 N_A_12 0.0547913f $X=0.0935 $Y=0.0675
cc_67 N_Y_42 N_A_21 0.0547913f $X=1.2815 $Y=0.0675
cc_68 N_Y_38 N_A_13 0.0287144f $X=0.4175 $Y=0.0675
cc_69 N_Y_39 N_A_16 0.0465945f $X=0.5255 $Y=0.0675
cc_70 N_Y_40 N_A_17 0.0287143f $X=0.8495 $Y=0.0675
cc_71 N_Y_41 N_A_20 0.0287143f $X=0.9575 $Y=0.0675
cc_72 N_Y_43 N_A_11 0.0109998f $X=0.0935 $Y=0.2025
cc_73 N_Y_48 N_A_22 0.0109998f $X=1.2815 $Y=0.2025
cc_74 N_Y_7 N_A_35 0.000848853f $X=0.864 $Y=0.0675
cc_75 N_Y_9 N_A_39 0.000848853f $X=0.972 $Y=0.0675
cc_76 N_Y_5 N_A_35 0.000848988f $X=0.54 $Y=0.0675
cc_77 N_Y_3 N_A_32 0.000856337f $X=0.432 $Y=0.0675
cc_78 N_Y_1 N_A_32 0.000862572f $X=0.108 $Y=0.0675
cc_79 N_Y_11 N_A_39 0.000862572f $X=1.296 $Y=0.0675
cc_80 N_Y_2 N_A_1 0.00114729f $X=0.108 $Y=0.2025
cc_81 N_Y_12 N_A_4 0.00114729f $X=1.296 $Y=0.2025
cc_82 N_Y_6 N_A_2 0.00115777f $X=0.54 $Y=0.2025
cc_83 N_Y_7 N_A_3 0.00117353f $X=0.864 $Y=0.0675
cc_84 N_Y_9 N_A_3 0.00117353f $X=0.972 $Y=0.0675
cc_85 N_Y_4 N_A_2 0.00121479f $X=0.432 $Y=0.2025
cc_86 N_Y_49 N_A_31 0.00121696f $X=0.0965 $Y=0.072
cc_87 N_Y_59 N_A_41 0.00121696f $X=1.269 $Y=0.072
cc_88 N_Y_8 N_A_18 0.00154635f $X=0.864 $Y=0.2025
cc_89 N_Y_10 N_A_19 0.00154635f $X=0.972 $Y=0.2025
cc_90 N_Y_2 N_A_11 0.00155016f $X=0.108 $Y=0.2025
cc_91 N_Y_12 N_A_22 0.00155016f $X=1.296 $Y=0.2025
cc_92 N_Y_57 N_A_38 0.00172303f $X=0.999 $Y=0.072
cc_93 N_Y_51 N_A_34 0.00187863f $X=0.405 $Y=0.072
cc_94 N_Y_5 N_A_15 0.00204988f $X=0.54 $Y=0.0675
cc_95 N_Y_3 N_A_14 0.00205492f $X=0.432 $Y=0.0675
cc_96 N_Y_7 N_A_18 0.00205944f $X=0.864 $Y=0.0675
cc_97 N_Y_9 N_A_19 0.00205944f $X=0.972 $Y=0.0675
cc_98 N_Y_1 N_A_12 0.0020749f $X=0.108 $Y=0.0675
cc_99 N_Y_11 N_A_21 0.0020749f $X=1.296 $Y=0.0675
cc_100 N_Y_55 N_A_35 0.00304463f $X=0.837 $Y=0.072
cc_101 N_Y_49 N_A_32 0.00307174f $X=0.0965 $Y=0.072
cc_102 N_Y_59 N_A_39 0.00307174f $X=1.269 $Y=0.072
cc_103 N_Y_61 N_A_24 0.00355582f $X=0.135 $Y=0.0855
cc_104 N_Y_71 N_A_29 0.00355582f $X=1.269 $Y=0.2025
cc_105 N_Y_65 N_A_36 0.00365601f $X=0.567 $Y=0.2025
cc_106 N_Y_67 N_A_37 0.00385318f $X=0.837 $Y=0.2025
cc_107 N_Y_63 N_A_33 0.0038558f $X=0.405 $Y=0.2025
cc_108 N_Y_69 N_A_40 0.00387922f $X=0.999 $Y=0.2025
cc_109 N_Y_43 N_A_1 0.00457603f $X=0.0935 $Y=0.2025
cc_110 N_Y_48 N_A_4 0.00457603f $X=1.2815 $Y=0.2025
cc_111 N_Y_41 N_A_3 0.00819289f $X=0.9575 $Y=0.0675
cc_112 N_Y_44 N_A_2 0.00821905f $X=0.4175 $Y=0.2025
cc_113 N_Y_51 N_A_32 0.00909512f $X=0.405 $Y=0.072
cc_114 N_Y_53 N_A_35 0.0091068f $X=0.567 $Y=0.072
cc_115 N_Y_57 N_A_39 0.00924524f $X=0.999 $Y=0.072
cc_116 N_Y_45 N_A_16 0.0100927f $X=0.5255 $Y=0.2025
cc_117 N_Y_46 N_A_17 0.0638263f $X=0.8495 $Y=0.2025
cc_118 N_Y_39 N_A_15 0.0179424f $X=0.5255 $Y=0.0675
cc_119 N_Y_43 N_A_12 0.0181161f $X=0.0935 $Y=0.2025
cc_120 N_Y_48 N_A_21 0.0181161f $X=1.2815 $Y=0.2025
cc_121 N_Y_38 N_A_14 0.0361082f $X=0.4175 $Y=0.0675
cc_122 N_Y_40 N_A_18 0.0361111f $X=0.8495 $Y=0.0675
cc_123 N_Y_41 N_A_19 0.0361111f $X=0.9575 $Y=0.0675
cc_124 N_Y_37 N_A_11 0.0458458f $X=0.0935 $Y=0.0675
cc_125 N_Y_42 N_A_22 0.0458458f $X=1.2815 $Y=0.0675
cc_126 N_Y_44 N_A_13 0.0459031f $X=0.4175 $Y=0.2025
cc_127 N_Y_47 N_A_20 0.0639734f $X=0.9575 $Y=0.2025
cc_128 N_Y_51 N_9_16 0.000308002f $X=0.405 $Y=0.072
cc_129 N_Y_49 N_9_16 0.000478718f $X=0.0965 $Y=0.072
cc_130 N_Y_63 N_9_16 0.000160507f $X=0.405 $Y=0.2025
cc_131 N_Y_62 N_9_16 0.000435888f $X=0.165 $Y=0.234
cc_132 N_Y_61 N_9_15 0.000659776f $X=0.135 $Y=0.0855
cc_133 N_Y_63 N_9_18 0.000820502f $X=0.405 $Y=0.2025
cc_134 N_Y_61 N_9_16 0.00222244f $X=0.135 $Y=0.0855
cc_135 N_Y_51 N_8_15 0.000102898f $X=0.405 $Y=0.072
cc_136 N_Y_63 N_8_15 0.000352393f $X=0.405 $Y=0.2025
cc_137 N_Y_61 N_8_15 0.000448813f $X=0.135 $Y=0.0855
cc_138 N_Y_63 N_8_17 0.000472721f $X=0.405 $Y=0.2025
cc_139 N_Y_62 N_8_4 0.000859294f $X=0.165 $Y=0.234
cc_140 N_Y_62 N_8_3 0.00089223f $X=0.165 $Y=0.234
cc_141 N_Y_63 N_8_18 0.0012138f $X=0.405 $Y=0.2025
cc_142 N_Y_62 N_8_18 0.00145169f $X=0.165 $Y=0.234
cc_143 N_Y_62 N_8_15 0.00692908f $X=0.165 $Y=0.234
cc_144 N_Y_55 N_6_16 0.000315547f $X=0.837 $Y=0.072
cc_145 N_Y_53 N_6_16 0.000504093f $X=0.567 $Y=0.072
cc_146 N_Y_67 N_6_16 0.000160507f $X=0.837 $Y=0.2025
cc_147 N_Y_66 N_6_14 0.000434794f $X=0.597 $Y=0.234
cc_148 N_Y_65 N_6_15 0.000659776f $X=0.567 $Y=0.2025
cc_149 N_Y_67 N_6_18 0.00081932f $X=0.837 $Y=0.2025
cc_150 N_Y_65 N_6_16 0.00225693f $X=0.567 $Y=0.2025
cc_151 N_Y_55 N_7_15 9.91057e-20 $X=0.837 $Y=0.072
cc_152 N_Y_67 N_7_15 0.000352393f $X=0.837 $Y=0.2025
cc_153 N_Y_65 N_7_15 0.000452864f $X=0.567 $Y=0.2025
cc_154 N_Y_67 N_7_17 0.000499014f $X=0.837 $Y=0.2025
cc_155 N_Y_66 N_7_4 0.000859294f $X=0.597 $Y=0.234
cc_156 N_Y_66 N_7_3 0.00089223f $X=0.597 $Y=0.234
cc_157 N_Y_67 N_7_18 0.00124246f $X=0.837 $Y=0.2025
cc_158 N_Y_66 N_7_18 0.00145169f $X=0.597 $Y=0.234
cc_159 N_Y_66 N_7_15 0.00691925f $X=0.597 $Y=0.234
cc_160 N_Y_10 N_5_18 9.44781e-20 $X=0.972 $Y=0.2025
cc_161 N_Y_57 N_5_18 9.91057e-20 $X=0.999 $Y=0.072
cc_162 N_Y_69 N_5_18 0.000193927f $X=0.999 $Y=0.2025
cc_163 N_Y_71 N_5_18 0.00044877f $X=1.269 $Y=0.2025
cc_164 N_Y_69 N_5_16 0.000499014f $X=0.999 $Y=0.2025
cc_165 N_Y_70 N_5_3 0.000859294f $X=1.0275 $Y=0.234
cc_166 N_Y_70 N_5_4 0.00089223f $X=1.0275 $Y=0.234
cc_167 N_Y_69 N_5_15 0.00124261f $X=0.999 $Y=0.2025
cc_168 N_Y_70 N_5_15 0.00145169f $X=1.0275 $Y=0.234
cc_169 N_Y_70 N_5_18 0.00690585f $X=1.0275 $Y=0.234
cc_170 N_Y_11 N_4_18 8.69411e-20 $X=1.296 $Y=0.0675
cc_171 N_Y_57 N_4_18 0.000315547f $X=0.999 $Y=0.072
cc_172 N_Y_59 N_4_18 0.000480177f $X=1.269 $Y=0.072
cc_173 N_Y_69 N_4_18 0.000160507f $X=0.999 $Y=0.2025
cc_174 N_Y_70 N_4_18 0.000435683f $X=1.0275 $Y=0.234
cc_175 N_Y_71 N_4_17 0.000659776f $X=1.269 $Y=0.2025
cc_176 N_Y_69 N_4_15 0.000819359f $X=0.999 $Y=0.2025
cc_177 N_Y_71 N_4_18 0.00202879f $X=1.269 $Y=0.2025
x_PM_CKINVDCx12_ASAP7_75t_R%7 vss N_M12_g N_M36_g N_M13_g N_M37_g N_M34_d
+ N_M35_d N_M36_d N_M37_d N_7_10 N_7_15 N_7_17 N_7_9 N_7_3 N_7_1 N_7_11 N_7_13
+ N_7_4 N_7_18 PM_CKINVDCx12_ASAP7_75t_R%7
cc_178 N_7_10 N_A_3 0.00133007f $X=0.783 $Y=0.135
cc_179 N_7_10 N_A_2 0.000114927f $X=0.783 $Y=0.135
cc_180 N_7_10 N_A_17 0.003635f $X=0.783 $Y=0.135
cc_181 N_7_10 N_6_12 0.0200798f $X=0.783 $Y=0.135
cc_182 N_7_15 N_6_16 0.00127834f $X=0.702 $Y=0.171
cc_183 N_7_17 N_6_18 0.00132242f $X=0.7425 $Y=0.135
cc_184 N_7_9 N_6_4 0.00143019f $X=0.729 $Y=0.0245
cc_185 N_7_3 N_6_10 0.00143019f $X=0.648 $Y=0.2025
cc_186 N_7_3 N_6_1 0.00174171f $X=0.648 $Y=0.2025
cc_187 N_7_1 N_6_4 0.00174171f $X=0.729 $Y=0.135
cc_188 N_7_11 N_6_1 0.0029712f $X=0.6335 $Y=0.2025
cc_189 N_7_1 N_6_12 0.0029712f $X=0.729 $Y=0.135
cc_190 N_7_13 N_6_18 0.00381209f $X=0.729 $Y=0.135
cc_191 N_7_15 N_6_14 0.00381585f $X=0.702 $Y=0.171
cc_192 N_7_11 N_6_10 0.0398108f $X=0.6335 $Y=0.2025
cc_193 N_7_11 N_6_9 0.029713f $X=0.6335 $Y=0.2025
cc_194 N_7_9 N_6_12 0.052385f $X=0.729 $Y=0.0245
x_PM_CKINVDCx12_ASAP7_75t_R%8 vss N_M18_g N_M42_g N_M19_g N_M43_g N_M44_d
+ N_M45_d N_M42_d N_M43_d N_8_10 N_8_15 N_8_17 N_8_9 N_8_3 N_8_1 N_8_11 N_8_13
+ N_8_4 N_8_18 PM_CKINVDCx12_ASAP7_75t_R%8
cc_195 N_8_10 N_A_34 4.29131e-20 $X=0.351 $Y=0.135
cc_196 N_8_10 N_A_2 0.00133294f $X=0.351 $Y=0.135
cc_197 N_8_10 N_A_1 0.000114927f $X=0.351 $Y=0.135
cc_198 N_8_10 N_A_32 0.00034711f $X=0.351 $Y=0.135
cc_199 N_8_10 N_A_13 0.00360902f $X=0.351 $Y=0.135
cc_200 N_8_10 N_9_12 0.0200798f $X=0.351 $Y=0.135
cc_201 N_8_15 N_9_16 0.00127654f $X=0.27 $Y=0.171
cc_202 N_8_17 N_9_18 0.00132068f $X=0.3105 $Y=0.135
cc_203 N_8_9 N_9_4 0.00143019f $X=0.297 $Y=0.0245
cc_204 N_8_3 N_9_10 0.00143019f $X=0.216 $Y=0.2025
cc_205 N_8_3 N_9_1 0.00174171f $X=0.216 $Y=0.2025
cc_206 N_8_1 N_9_4 0.00174171f $X=0.297 $Y=0.135
cc_207 N_8_11 N_9_1 0.0029712f $X=0.2015 $Y=0.2025
cc_208 N_8_1 N_9_12 0.0029712f $X=0.297 $Y=0.135
cc_209 N_8_13 N_9_18 0.00381209f $X=0.297 $Y=0.135
cc_210 N_8_15 N_9_14 0.00381585f $X=0.27 $Y=0.171
cc_211 N_8_11 N_9_10 0.0398108f $X=0.2015 $Y=0.2025
cc_212 N_8_11 N_9_9 0.0297725f $X=0.2015 $Y=0.2025
cc_213 N_8_9 N_9_12 0.052382f $X=0.297 $Y=0.0245

* End of included file CKINVDCx12_ASAP7_75t_R.pex.sp.pxi
.ends

.subckt PM_BUFx12_ASAP7_75t_R%A vss 25 11 17 28 31 4 7 5 10 3 1
c1 1 vss 0.0124775f $X=0.072 $Y=0.135
c2 3 vss 0.0876231f $X=0.081 $Y=0.0245
c3 4 vss 0.0812516f $X=0.135 $Y=0.135
c4 5 vss 0.0079584f $X=0.027 $Y=0.036
c5 6 vss 0.00164313f $X=0.027 $Y=0.135
c6 7 vss 0.00797406f $X=0.027 $Y=0.234
c7 8 vss 0.00914729f $X=0.027 $Y=0.0855
c8 9 vss 0.00918498f $X=0.027 $Y=0.1845
c9 10 vss 0.00209297f $X=0.0455 $Y=0.135
r1 7 9 10.3626 $w=1.39091e-08 $l=4.95e-08 $layer=M1 $thickness=3.6e-08 $X=0.027
+ $Y=0.234 $X2=0.027 $Y2=0.1845
r2 5 8 10.3626 $w=1.39091e-08 $l=4.95e-08 $layer=M1 $thickness=3.6e-08 $X=0.027
+ $Y=0.036 $X2=0.027 $Y2=0.0855
r3 6 10 3.1337 $w=1.54324e-08 $l=1.85e-08 $layer=M1 $thickness=3.6e-08 $X=0.027
+ $Y=0.135 $X2=0.0455 $Y2=0.135
r4 6 8 10.3626 $w=1.39091e-08 $l=4.95e-08 $layer=M1 $thickness=3.6e-08 $X=0.027
+ $Y=0.135 $X2=0.027 $Y2=0.0855
r5 6 9 10.3626 $w=1.39091e-08 $l=4.95e-08 $layer=M1 $thickness=3.6e-08 $X=0.027
+ $Y=0.135 $X2=0.027 $Y2=0.1845
r6 31 30 16.4967 $w=2.1e-08 $l=4.85e-08 $layer=Gate_1 $thickness=5.6e-08
+ $X=0.135 $Y=0.2025 $X2=0.135 $Y2=0.154
r7 28 29 16.4967 $w=2.1e-08 $l=4.85e-08 $layer=Gate_1 $thickness=5.6e-08
+ $X=0.135 $Y=0.0675 $X2=0.135 $Y2=0.116
r8 4 23 6.54019 $w=2.09524e-08 $layer=Gate_1 $thickness=5.21905e-08 $X=0.135
+ $Y=0.135 $X2=0.135 $Y2=0.135
r9 4 29 6.6497 $w=2.04211e-08 $l=1.9e-08 $layer=Gate_1 $thickness=5.6e-08
+ $X=0.135 $Y=0.135 $X2=0.135 $Y2=0.116
r10 4 30 6.6497 $w=2.04211e-08 $l=1.9e-08 $layer=Gate_1 $thickness=5.6e-08
+ $X=0.135 $Y=0.135 $X2=0.135 $Y2=0.154
r11 25 10 4.31401 $w=1.3e-08 $l=1.85e-08 $layer=M1 $thickness=3.6e-08 $X=0.061
+ $Y=0.1325 $X2=0.0455 $Y2=0.135
r12 22 23 12.6539 $w=1.77815e-08 $l=2.7e-08 $layer=LIG $thickness=4.8e-08
+ $X=0.108 $Y=0.135 $X2=0.135 $Y2=0.135
r13 25 21 19.3796 $a=3.24e-16 $layer=V0LIG $X=0.061 $Y=0.1325 $X2=0.063
+ $Y2=0.135
r14 19 22 12.3927 $w=1.76192e-08 $l=2.6e-08 $layer=LIG $thickness=4.8e-08
+ $X=0.082 $Y=0.135 $X2=0.108 $Y2=0.135
r15 1 19 2.6116 $w=2.2e-08 $l=1e-08 $layer=LIG $thickness=4.8e-08 $X=0.072
+ $Y=0.135 $X2=0.082 $Y2=0.135
r16 1 21 4.98695 $w=1.60444e-08 $l=9e-09 $layer=LIG $thickness=4.8e-08 $X=0.072
+ $Y=0.135 $X2=0.063 $Y2=0.135
r17 17 16 14.6259 $w=2.1e-08 $l=4.3e-08 $layer=Gate_1 $thickness=5.6e-08
+ $X=0.081 $Y=0.2025 $X2=0.081 $Y2=0.1595
r18 15 16 2.7211 $w=2.1e-08 $l=8e-09 $layer=Gate_1 $thickness=5.6e-08 $X=0.081
+ $Y=0.1515 $X2=0.081 $Y2=0.1595
r19 14 15 5.79936 $w=2.03333e-08 $l=1.65e-08 $layer=Gate_1 $thickness=5.6e-08
+ $X=0.081 $Y=0.135 $X2=0.081 $Y2=0.1515
r20 14 19 6.27904 $w=2.09e-08 $l=1e-09 $layer=Gate_1 $thickness=5.24e-08
+ $X=0.081 $Y=0.135 $X2=0.082 $Y2=0.135
r21 13 14 5.79936 $w=2.03333e-08 $l=1.65e-08 $layer=Gate_1 $thickness=5.6e-08
+ $X=0.081 $Y=0.1185 $X2=0.081 $Y2=0.135
r22 12 13 2.7211 $w=2.1e-08 $l=8e-09 $layer=Gate_1 $thickness=5.6e-08 $X=0.081
+ $Y=0.1105 $X2=0.081 $Y2=0.1185
r23 11 12 14.6259 $w=2.1e-08 $l=4.3e-08 $layer=Gate_1 $thickness=5.6e-08
+ $X=0.081 $Y=0.0675 $X2=0.081 $Y2=0.1105
r24 11 3 14.6259 $w=2.1e-08 $l=4.3e-08 $layer=Gate_1 $thickness=5.6e-08
+ $X=0.081 $Y=0.0675 $X2=0.081 $Y2=0.0245
.ends

.subckt PM_BUFx12_ASAP7_75t_R%Y vss 93 56 57 73 74 77 78 81 82 85 86 89 90 110
+ 111 114 115 118 119 122 123 126 127 130 131 42 2 4 6 8 10 3 5 7 9 11 12 43 37
+ 44 45 46 47 38 39 40 41 48 53 1 52 51
c1 1 vss 0.00820506f $X=0.216 $Y=0.0675
c2 2 vss 0.00820506f $X=0.216 $Y=0.2025
c3 3 vss 0.00815376f $X=0.324 $Y=0.0675
c4 4 vss 0.00815376f $X=0.324 $Y=0.2025
c5 5 vss 0.00815376f $X=0.432 $Y=0.0675
c6 6 vss 0.00815376f $X=0.432 $Y=0.2025
c7 7 vss 0.00815376f $X=0.54 $Y=0.0675
c8 8 vss 0.00815376f $X=0.54 $Y=0.2025
c9 9 vss 0.00815376f $X=0.648 $Y=0.0675
c10 10 vss 0.00815376f $X=0.648 $Y=0.2025
c11 11 vss 0.00822916f $X=0.756 $Y=0.0675
c12 12 vss 0.00822916f $X=0.756 $Y=0.2025
c13 37 vss 0.0042935f $X=0.2015 $Y=0.0675
c14 38 vss 0.00406913f $X=0.3095 $Y=0.0675
c15 39 vss 0.00406913f $X=0.4175 $Y=0.0675
c16 40 vss 0.00406913f $X=0.5255 $Y=0.0675
c17 41 vss 0.00406913f $X=0.6335 $Y=0.0675
c18 42 vss 0.00421727f $X=0.7415 $Y=0.0675
c19 43 vss 0.00430892f $X=0.2015 $Y=0.2025
c20 44 vss 0.00406977f $X=0.3095 $Y=0.2025
c21 45 vss 0.00406977f $X=0.4175 $Y=0.2025
c22 46 vss 0.00406977f $X=0.5255 $Y=0.2025
c23 47 vss 0.00406977f $X=0.6335 $Y=0.2025
c24 48 vss 0.00421606f $X=0.7415 $Y=0.2025
c25 49 vss 0.00285499f $X=0.837 $Y=0.036
c26 50 vss 0.00285499f $X=0.837 $Y=0.234
c27 51 vss 0.0539788f $X=0.203 $Y=0.036
c28 52 vss 0.0539732f $X=0.814 $Y=0.234
c29 53 vss 0.00772663f $X=0.837 $Y=0.0855
r1 131 129 0.0308642 $w=8.1e-08 $l=2.5e-09 $layer=P_src_drn $thickness=1e-09
+ $X=0.7733 $Y=0.2025 $X2=0.7705 $Y2=0.2025
r2 12 129 0.179012 $w=8.1e-08 $l=1.45e-08 $layer=P_src_drn $thickness=1e-09
+ $X=0.756 $Y=0.2025 $X2=0.7705 $Y2=0.2025
r3 48 12 0.179012 $w=8.1e-08 $l=1.45e-08 $layer=P_src_drn $thickness=1e-09
+ $X=0.7415 $Y=0.2025 $X2=0.756 $Y2=0.2025
r4 130 48 0.0308642 $w=8.1e-08 $l=2.5e-09 $layer=P_src_drn $thickness=1e-09
+ $X=0.7386 $Y=0.2025 $X2=0.7415 $Y2=0.2025
r5 127 125 0.0308642 $w=8.1e-08 $l=2.5e-09 $layer=P_src_drn $thickness=1e-09
+ $X=0.6653 $Y=0.2025 $X2=0.6625 $Y2=0.2025
r6 10 125 0.179012 $w=8.1e-08 $l=1.45e-08 $layer=P_src_drn $thickness=1e-09
+ $X=0.648 $Y=0.2025 $X2=0.6625 $Y2=0.2025
r7 47 10 0.179012 $w=8.1e-08 $l=1.45e-08 $layer=P_src_drn $thickness=1e-09
+ $X=0.6335 $Y=0.2025 $X2=0.648 $Y2=0.2025
r8 126 47 0.0308642 $w=8.1e-08 $l=2.5e-09 $layer=P_src_drn $thickness=1e-09
+ $X=0.6306 $Y=0.2025 $X2=0.6335 $Y2=0.2025
r9 123 121 0.0308642 $w=8.1e-08 $l=2.5e-09 $layer=P_src_drn $thickness=1e-09
+ $X=0.5573 $Y=0.2025 $X2=0.5545 $Y2=0.2025
r10 8 121 0.179012 $w=8.1e-08 $l=1.45e-08 $layer=P_src_drn $thickness=1e-09
+ $X=0.54 $Y=0.2025 $X2=0.5545 $Y2=0.2025
r11 46 8 0.179012 $w=8.1e-08 $l=1.45e-08 $layer=P_src_drn $thickness=1e-09
+ $X=0.5255 $Y=0.2025 $X2=0.54 $Y2=0.2025
r12 122 46 0.0308642 $w=8.1e-08 $l=2.5e-09 $layer=P_src_drn $thickness=1e-09
+ $X=0.5226 $Y=0.2025 $X2=0.5255 $Y2=0.2025
r13 119 117 0.0308642 $w=8.1e-08 $l=2.5e-09 $layer=P_src_drn $thickness=1e-09
+ $X=0.4493 $Y=0.2025 $X2=0.4465 $Y2=0.2025
r14 6 117 0.179012 $w=8.1e-08 $l=1.45e-08 $layer=P_src_drn $thickness=1e-09
+ $X=0.432 $Y=0.2025 $X2=0.4465 $Y2=0.2025
r15 45 6 0.179012 $w=8.1e-08 $l=1.45e-08 $layer=P_src_drn $thickness=1e-09
+ $X=0.4175 $Y=0.2025 $X2=0.432 $Y2=0.2025
r16 118 45 0.0308642 $w=8.1e-08 $l=2.5e-09 $layer=P_src_drn $thickness=1e-09
+ $X=0.4146 $Y=0.2025 $X2=0.4175 $Y2=0.2025
r17 115 113 0.0308642 $w=8.1e-08 $l=2.5e-09 $layer=P_src_drn $thickness=1e-09
+ $X=0.3413 $Y=0.2025 $X2=0.3385 $Y2=0.2025
r18 4 113 0.179012 $w=8.1e-08 $l=1.45e-08 $layer=P_src_drn $thickness=1e-09
+ $X=0.324 $Y=0.2025 $X2=0.3385 $Y2=0.2025
r19 44 4 0.179012 $w=8.1e-08 $l=1.45e-08 $layer=P_src_drn $thickness=1e-09
+ $X=0.3095 $Y=0.2025 $X2=0.324 $Y2=0.2025
r20 114 44 0.0308642 $w=8.1e-08 $l=2.5e-09 $layer=P_src_drn $thickness=1e-09
+ $X=0.3066 $Y=0.2025 $X2=0.3095 $Y2=0.2025
r21 111 109 0.0308642 $w=8.1e-08 $l=2.5e-09 $layer=P_src_drn $thickness=1e-09
+ $X=0.2333 $Y=0.2025 $X2=0.2305 $Y2=0.2025
r22 2 109 0.179012 $w=8.1e-08 $l=1.45e-08 $layer=P_src_drn $thickness=1e-09
+ $X=0.216 $Y=0.2025 $X2=0.2305 $Y2=0.2025
r23 43 2 0.179012 $w=8.1e-08 $l=1.45e-08 $layer=P_src_drn $thickness=1e-09
+ $X=0.2015 $Y=0.2025 $X2=0.216 $Y2=0.2025
r24 110 43 0.0308642 $w=8.1e-08 $l=2.5e-09 $layer=P_src_drn $thickness=1e-09
+ $X=0.1986 $Y=0.2025 $X2=0.2015 $Y2=0.2025
r25 12 106 19.3796 $a=3.24e-16 $layer=V0LISD $X=0.756 $Y=0.2025 $X2=0.756
+ $Y2=0.234
r26 10 104 19.3796 $a=3.24e-16 $layer=V0LISD $X=0.648 $Y=0.2025 $X2=0.648
+ $Y2=0.234
r27 8 102 19.3796 $a=3.24e-16 $layer=V0LISD $X=0.54 $Y=0.2025 $X2=0.54 $Y2=0.234
r28 6 100 19.3796 $a=3.24e-16 $layer=V0LISD $X=0.432 $Y=0.2025 $X2=0.432
+ $Y2=0.234
r29 4 98 19.3796 $a=3.24e-16 $layer=V0LISD $X=0.324 $Y=0.2025 $X2=0.324
+ $Y2=0.234
r30 2 96 19.3796 $a=3.24e-16 $layer=V0LISD $X=0.216 $Y=0.2025 $X2=0.216
+ $Y2=0.234
r31 106 107 6.17953 $w=1.3e-08 $l=2.65e-08 $layer=M1 $thickness=3.6e-08
+ $X=0.756 $Y=0.234 $X2=0.7825 $Y2=0.234
r32 105 106 12.5922 $w=1.3e-08 $l=5.4e-08 $layer=M1 $thickness=3.6e-08 $X=0.702
+ $Y=0.234 $X2=0.756 $Y2=0.234
r33 104 105 12.5922 $w=1.3e-08 $l=5.4e-08 $layer=M1 $thickness=3.6e-08 $X=0.648
+ $Y=0.234 $X2=0.702 $Y2=0.234
r34 103 104 12.5922 $w=1.3e-08 $l=5.4e-08 $layer=M1 $thickness=3.6e-08 $X=0.594
+ $Y=0.234 $X2=0.648 $Y2=0.234
r35 102 103 12.5922 $w=1.3e-08 $l=5.4e-08 $layer=M1 $thickness=3.6e-08 $X=0.54
+ $Y=0.234 $X2=0.594 $Y2=0.234
r36 101 102 12.5922 $w=1.3e-08 $l=5.4e-08 $layer=M1 $thickness=3.6e-08 $X=0.486
+ $Y=0.234 $X2=0.54 $Y2=0.234
r37 100 101 12.5922 $w=1.3e-08 $l=5.4e-08 $layer=M1 $thickness=3.6e-08 $X=0.432
+ $Y=0.234 $X2=0.486 $Y2=0.234
r38 99 100 12.5922 $w=1.3e-08 $l=5.4e-08 $layer=M1 $thickness=3.6e-08 $X=0.378
+ $Y=0.234 $X2=0.432 $Y2=0.234
r39 98 99 12.5922 $w=1.3e-08 $l=5.4e-08 $layer=M1 $thickness=3.6e-08 $X=0.324
+ $Y=0.234 $X2=0.378 $Y2=0.234
r40 97 98 12.5922 $w=1.3e-08 $l=5.4e-08 $layer=M1 $thickness=3.6e-08 $X=0.27
+ $Y=0.234 $X2=0.324 $Y2=0.234
r41 96 97 12.5922 $w=1.3e-08 $l=5.4e-08 $layer=M1 $thickness=3.6e-08 $X=0.216
+ $Y=0.234 $X2=0.27 $Y2=0.234
r42 52 107 7.34548 $w=1.3e-08 $l=3.15e-08 $layer=M1 $thickness=3.6e-08 $X=0.814
+ $Y=0.234 $X2=0.7825 $Y2=0.234
r43 50 94 9.19421 $w=1.48968e-08 $l=4.65e-08 $layer=M1 $thickness=3.6e-08
+ $X=0.837 $Y=0.234 $X2=0.837 $Y2=0.1875
r44 50 52 3.71425 $w=1.49565e-08 $l=2.3e-08 $layer=M1 $thickness=3.6e-08
+ $X=0.837 $Y=0.234 $X2=0.814 $Y2=0.234
r45 93 94 8.86121 $w=1.3e-08 $l=3.8e-08 $layer=M1 $thickness=3.6e-08 $X=0.839
+ $Y=0.1495 $X2=0.837 $Y2=0.1875
r46 93 92 0.699569 $w=1.3e-08 $l=3e-09 $layer=M1 $thickness=3.6e-08 $X=0.839
+ $Y=0.1495 $X2=0.837 $Y2=0.1465
r47 91 92 2.68168 $w=1.3e-08 $l=1.15e-08 $layer=M1 $thickness=3.6e-08 $X=0.837
+ $Y=0.135 $X2=0.837 $Y2=0.1465
r48 53 91 11.5429 $w=1.3e-08 $l=4.95e-08 $layer=M1 $thickness=3.6e-08 $X=0.837
+ $Y=0.0855 $X2=0.837 $Y2=0.135
r49 90 88 0.0308642 $w=8.1e-08 $l=2.5e-09 $layer=N_src_drn $thickness=1e-09
+ $X=0.7733 $Y=0.0675 $X2=0.7705 $Y2=0.0675
r50 11 88 0.179012 $w=8.1e-08 $l=1.45e-08 $layer=N_src_drn $thickness=1e-09
+ $X=0.756 $Y=0.0675 $X2=0.7705 $Y2=0.0675
r51 42 11 0.179012 $w=8.1e-08 $l=1.45e-08 $layer=N_src_drn $thickness=1e-09
+ $X=0.7415 $Y=0.0675 $X2=0.756 $Y2=0.0675
r52 89 42 0.0308642 $w=8.1e-08 $l=2.5e-09 $layer=N_src_drn $thickness=1e-09
+ $X=0.7386 $Y=0.0675 $X2=0.7415 $Y2=0.0675
r53 86 84 0.0308642 $w=8.1e-08 $l=2.5e-09 $layer=N_src_drn $thickness=1e-09
+ $X=0.5573 $Y=0.0675 $X2=0.5545 $Y2=0.0675
r54 7 84 0.179012 $w=8.1e-08 $l=1.45e-08 $layer=N_src_drn $thickness=1e-09
+ $X=0.54 $Y=0.0675 $X2=0.5545 $Y2=0.0675
r55 40 7 0.179012 $w=8.1e-08 $l=1.45e-08 $layer=N_src_drn $thickness=1e-09
+ $X=0.5255 $Y=0.0675 $X2=0.54 $Y2=0.0675
r56 85 40 0.0308642 $w=8.1e-08 $l=2.5e-09 $layer=N_src_drn $thickness=1e-09
+ $X=0.5226 $Y=0.0675 $X2=0.5255 $Y2=0.0675
r57 82 80 0.0308642 $w=8.1e-08 $l=2.5e-09 $layer=N_src_drn $thickness=1e-09
+ $X=0.4493 $Y=0.0675 $X2=0.4465 $Y2=0.0675
r58 5 80 0.179012 $w=8.1e-08 $l=1.45e-08 $layer=N_src_drn $thickness=1e-09
+ $X=0.432 $Y=0.0675 $X2=0.4465 $Y2=0.0675
r59 39 5 0.179012 $w=8.1e-08 $l=1.45e-08 $layer=N_src_drn $thickness=1e-09
+ $X=0.4175 $Y=0.0675 $X2=0.432 $Y2=0.0675
r60 81 39 0.0308642 $w=8.1e-08 $l=2.5e-09 $layer=N_src_drn $thickness=1e-09
+ $X=0.4146 $Y=0.0675 $X2=0.4175 $Y2=0.0675
r61 78 76 0.0308642 $w=8.1e-08 $l=2.5e-09 $layer=N_src_drn $thickness=1e-09
+ $X=0.3413 $Y=0.0675 $X2=0.3385 $Y2=0.0675
r62 3 76 0.179012 $w=8.1e-08 $l=1.45e-08 $layer=N_src_drn $thickness=1e-09
+ $X=0.324 $Y=0.0675 $X2=0.3385 $Y2=0.0675
r63 38 3 0.179012 $w=8.1e-08 $l=1.45e-08 $layer=N_src_drn $thickness=1e-09
+ $X=0.3095 $Y=0.0675 $X2=0.324 $Y2=0.0675
r64 77 38 0.0308642 $w=8.1e-08 $l=2.5e-09 $layer=N_src_drn $thickness=1e-09
+ $X=0.3066 $Y=0.0675 $X2=0.3095 $Y2=0.0675
r65 74 72 0.0308642 $w=8.1e-08 $l=2.5e-09 $layer=N_src_drn $thickness=1e-09
+ $X=0.2333 $Y=0.0675 $X2=0.2305 $Y2=0.0675
r66 1 72 0.179012 $w=8.1e-08 $l=1.45e-08 $layer=N_src_drn $thickness=1e-09
+ $X=0.216 $Y=0.0675 $X2=0.2305 $Y2=0.0675
r67 37 1 0.179012 $w=8.1e-08 $l=1.45e-08 $layer=N_src_drn $thickness=1e-09
+ $X=0.2015 $Y=0.0675 $X2=0.216 $Y2=0.0675
r68 73 37 0.0308642 $w=8.1e-08 $l=2.5e-09 $layer=N_src_drn $thickness=1e-09
+ $X=0.1986 $Y=0.0675 $X2=0.2015 $Y2=0.0675
r69 49 70 3.71425 $w=1.49565e-08 $l=2.3e-08 $layer=M1 $thickness=3.6e-08
+ $X=0.837 $Y=0.036 $X2=0.814 $Y2=0.036
r70 49 53 9.89378 $w=1.47818e-08 $l=4.95e-08 $layer=M1 $thickness=3.6e-08
+ $X=0.837 $Y=0.036 $X2=0.837 $Y2=0.0855
r71 11 68 19.3796 $a=3.24e-16 $layer=V0LISD $X=0.756 $Y=0.0675 $X2=0.756
+ $Y2=0.036
r72 7 64 19.3796 $a=3.24e-16 $layer=V0LISD $X=0.54 $Y=0.0675 $X2=0.54 $Y2=0.036
r73 5 62 19.3796 $a=3.24e-16 $layer=V0LISD $X=0.432 $Y=0.0675 $X2=0.432
+ $Y2=0.036
r74 3 60 19.3796 $a=3.24e-16 $layer=V0LISD $X=0.324 $Y=0.0675 $X2=0.324
+ $Y2=0.036
r75 1 58 19.3796 $a=3.24e-16 $layer=V0LISD $X=0.216 $Y=0.0675 $X2=0.216
+ $Y2=0.036
r76 69 70 7.34548 $w=1.3e-08 $l=3.15e-08 $layer=M1 $thickness=3.6e-08 $X=0.7825
+ $Y=0.036 $X2=0.814 $Y2=0.036
r77 68 69 6.17953 $w=1.3e-08 $l=2.65e-08 $layer=M1 $thickness=3.6e-08 $X=0.756
+ $Y=0.036 $X2=0.7825 $Y2=0.036
r78 67 68 12.5922 $w=1.3e-08 $l=5.4e-08 $layer=M1 $thickness=3.6e-08 $X=0.702
+ $Y=0.036 $X2=0.756 $Y2=0.036
r79 66 67 12.5922 $w=1.3e-08 $l=5.4e-08 $layer=M1 $thickness=3.6e-08 $X=0.648
+ $Y=0.036 $X2=0.702 $Y2=0.036
r80 65 66 12.5922 $w=1.3e-08 $l=5.4e-08 $layer=M1 $thickness=3.6e-08 $X=0.594
+ $Y=0.036 $X2=0.648 $Y2=0.036
r81 64 65 12.5922 $w=1.3e-08 $l=5.4e-08 $layer=M1 $thickness=3.6e-08 $X=0.54
+ $Y=0.036 $X2=0.594 $Y2=0.036
r82 63 64 12.5922 $w=1.3e-08 $l=5.4e-08 $layer=M1 $thickness=3.6e-08 $X=0.486
+ $Y=0.036 $X2=0.54 $Y2=0.036
r83 62 63 12.5922 $w=1.3e-08 $l=5.4e-08 $layer=M1 $thickness=3.6e-08 $X=0.432
+ $Y=0.036 $X2=0.486 $Y2=0.036
r84 61 62 12.5922 $w=1.3e-08 $l=5.4e-08 $layer=M1 $thickness=3.6e-08 $X=0.378
+ $Y=0.036 $X2=0.432 $Y2=0.036
r85 60 61 12.5922 $w=1.3e-08 $l=5.4e-08 $layer=M1 $thickness=3.6e-08 $X=0.324
+ $Y=0.036 $X2=0.378 $Y2=0.036
r86 59 60 12.5922 $w=1.3e-08 $l=5.4e-08 $layer=M1 $thickness=3.6e-08 $X=0.27
+ $Y=0.036 $X2=0.324 $Y2=0.036
r87 58 59 12.5922 $w=1.3e-08 $l=5.4e-08 $layer=M1 $thickness=3.6e-08 $X=0.216
+ $Y=0.036 $X2=0.27 $Y2=0.036
r88 51 58 3.03147 $w=1.3e-08 $l=1.3e-08 $layer=M1 $thickness=3.6e-08 $X=0.203
+ $Y=0.036 $X2=0.216 $Y2=0.036
r89 9 66 19.3796 $a=3.24e-16 $layer=V0LISD $X=0.648 $Y=0.0675 $X2=0.648
+ $Y2=0.036
r90 57 55 0.0308642 $w=8.1e-08 $l=2.5e-09 $layer=N_src_drn $thickness=1e-09
+ $X=0.6653 $Y=0.0675 $X2=0.6625 $Y2=0.0675
r91 9 55 0.179012 $w=8.1e-08 $l=1.45e-08 $layer=N_src_drn $thickness=1e-09
+ $X=0.648 $Y=0.0675 $X2=0.6625 $Y2=0.0675
r92 41 9 0.179012 $w=8.1e-08 $l=1.45e-08 $layer=N_src_drn $thickness=1e-09
+ $X=0.6335 $Y=0.0675 $X2=0.648 $Y2=0.0675
r93 56 41 0.0308642 $w=8.1e-08 $l=2.5e-09 $layer=N_src_drn $thickness=1e-09
+ $X=0.6306 $Y=0.0675 $X2=0.6335 $Y2=0.0675
.ends

.subckt PM_BUFx12_ASAP7_75t_R%4 vss 40 44 120 123 126 129 132 135 138 141 144
+ 147 150 153 156 159 162 165 168 171 174 177 181 185 195 196 199 200 15 39 14
+ 36 35 34 32 37 38 20 33 22 24 26 28 1 21 23 25 27 29 31 30
c1 1 vss 0.103858f $X=0.6115 $Y=0.135
c2 14 vss 0.0162224f $X=0.108 $Y=0.0675
c3 15 vss 0.0162224f $X=0.108 $Y=0.2025
c4 20 vss 0.0838199f $X=0.189 $Y=0.135
c5 21 vss 0.0841588f $X=0.243 $Y=0.135
c6 22 vss 0.084153f $X=0.297 $Y=0.135
c7 23 vss 0.084153f $X=0.351 $Y=0.135
c8 24 vss 0.084153f $X=0.405 $Y=0.135
c9 25 vss 0.084153f $X=0.459 $Y=0.135
c10 26 vss 0.084153f $X=0.513 $Y=0.135
c11 27 vss 0.084153f $X=0.567 $Y=0.135
c12 28 vss 0.084153f $X=0.621 $Y=0.0245
c13 29 vss 0.0840129f $X=0.675 $Y=0.135
c14 30 vss 0.0844639f $X=0.729 $Y=0.135
c15 31 vss 0.0840596f $X=0.783 $Y=0.135
c16 32 vss 0.0154363f $X=0.0935 $Y=0.0675
c17 33 vss 0.0154374f $X=0.0935 $Y=0.2025
c18 34 vss 0.00997024f $X=0.135 $Y=0.036
c19 35 vss 0.00997024f $X=0.135 $Y=0.234
c20 36 vss 0.00373629f $X=0.135 $Y=0.135
c21 37 vss 0.00624078f $X=0.135 $Y=0.0855
c22 38 vss 0.00624078f $X=0.135 $Y=0.1845
c23 39 vss 0.0168415f $X=0.2165 $Y=0.135
r1 200 198 0.0308642 $w=8.1e-08 $l=2.5e-09 $layer=P_src_drn $thickness=1e-09
+ $X=0.1253 $Y=0.2025 $X2=0.1225 $Y2=0.2025
r2 15 198 0.179012 $w=8.1e-08 $l=1.45e-08 $layer=P_src_drn $thickness=1e-09
+ $X=0.108 $Y=0.2025 $X2=0.1225 $Y2=0.2025
r3 33 15 0.179012 $w=8.1e-08 $l=1.45e-08 $layer=P_src_drn $thickness=1e-09
+ $X=0.0935 $Y=0.2025 $X2=0.108 $Y2=0.2025
r4 199 33 0.0308642 $w=8.1e-08 $l=2.5e-09 $layer=P_src_drn $thickness=1e-09
+ $X=0.0906 $Y=0.2025 $X2=0.0935 $Y2=0.2025
r5 196 194 0.0308642 $w=8.1e-08 $l=2.5e-09 $layer=N_src_drn $thickness=1e-09
+ $X=0.1253 $Y=0.0675 $X2=0.1225 $Y2=0.0675
r6 14 194 0.179012 $w=8.1e-08 $l=1.45e-08 $layer=N_src_drn $thickness=1e-09
+ $X=0.108 $Y=0.0675 $X2=0.1225 $Y2=0.0675
r7 32 14 0.179012 $w=8.1e-08 $l=1.45e-08 $layer=N_src_drn $thickness=1e-09
+ $X=0.0935 $Y=0.0675 $X2=0.108 $Y2=0.0675
r8 195 32 0.0308642 $w=8.1e-08 $l=2.5e-09 $layer=N_src_drn $thickness=1e-09
+ $X=0.0906 $Y=0.0675 $X2=0.0935 $Y2=0.0675
r9 15 191 19.3796 $a=3.24e-16 $layer=V0LISD $X=0.108 $Y=0.2025 $X2=0.108
+ $Y2=0.234
r10 14 188 19.3796 $a=3.24e-16 $layer=V0LISD $X=0.108 $Y=0.0675 $X2=0.108
+ $Y2=0.036
r11 191 192 3.14806 $w=1.3e-08 $l=1.35e-08 $layer=M1 $thickness=3.6e-08
+ $X=0.108 $Y=0.234 $X2=0.1215 $Y2=0.234
r12 35 38 10.3626 $w=1.39091e-08 $l=4.95e-08 $layer=M1 $thickness=3.6e-08
+ $X=0.135 $Y=0.234 $X2=0.135 $Y2=0.1845
r13 35 192 1.96775 $w=1.63333e-08 $l=1.35e-08 $layer=M1 $thickness=3.6e-08
+ $X=0.135 $Y=0.234 $X2=0.1215 $Y2=0.234
r14 188 189 3.14806 $w=1.3e-08 $l=1.35e-08 $layer=M1 $thickness=3.6e-08
+ $X=0.108 $Y=0.036 $X2=0.1215 $Y2=0.036
r15 34 37 10.3626 $w=1.39091e-08 $l=4.95e-08 $layer=M1 $thickness=3.6e-08
+ $X=0.135 $Y=0.036 $X2=0.135 $Y2=0.0855
r16 34 189 1.96775 $w=1.63333e-08 $l=1.35e-08 $layer=M1 $thickness=3.6e-08
+ $X=0.135 $Y=0.036 $X2=0.1215 $Y2=0.036
r17 36 116 5.11582 $w=1.46667e-08 $l=2.7e-08 $layer=M1 $thickness=3.6e-08
+ $X=0.135 $Y=0.135 $X2=0.162 $Y2=0.135
r18 36 37 10.3626 $w=1.39091e-08 $l=4.95e-08 $layer=M1 $thickness=3.6e-08
+ $X=0.135 $Y=0.135 $X2=0.135 $Y2=0.0855
r19 36 38 10.3626 $w=1.39091e-08 $l=4.95e-08 $layer=M1 $thickness=3.6e-08
+ $X=0.135 $Y=0.135 $X2=0.135 $Y2=0.1845
r20 185 184 14.6259 $w=2.1e-08 $l=4.3e-08 $layer=Gate_1 $thickness=5.6e-08
+ $X=0.783 $Y=0.2025 $X2=0.783 $Y2=0.1595
r21 183 184 2.7211 $w=2.1e-08 $l=8e-09 $layer=Gate_1 $thickness=5.6e-08
+ $X=0.783 $Y=0.1515 $X2=0.783 $Y2=0.1595
r22 181 182 14.6259 $w=2.1e-08 $l=4.3e-08 $layer=Gate_1 $thickness=5.6e-08
+ $X=0.783 $Y=0.0675 $X2=0.783 $Y2=0.1105
r23 179 182 2.7211 $w=2.1e-08 $l=8e-09 $layer=Gate_1 $thickness=5.6e-08
+ $X=0.783 $Y=0.1185 $X2=0.783 $Y2=0.1105
r24 31 91 6.27904 $w=2.09e-08 $layer=Gate_1 $thickness=5.24e-08 $X=0.783
+ $Y=0.135 $X2=0.783 $Y2=0.135
r25 31 179 5.79936 $w=2.03333e-08 $l=1.65e-08 $layer=Gate_1 $thickness=5.6e-08
+ $X=0.783 $Y=0.135 $X2=0.783 $Y2=0.1185
r26 31 183 5.79936 $w=2.03333e-08 $l=1.65e-08 $layer=Gate_1 $thickness=5.6e-08
+ $X=0.783 $Y=0.135 $X2=0.783 $Y2=0.1515
r27 177 176 16.4967 $w=2.1e-08 $l=4.85e-08 $layer=Gate_1 $thickness=5.6e-08
+ $X=0.729 $Y=0.2025 $X2=0.729 $Y2=0.154
r28 174 175 16.4967 $w=2.1e-08 $l=4.85e-08 $layer=Gate_1 $thickness=5.6e-08
+ $X=0.729 $Y=0.0675 $X2=0.729 $Y2=0.116
r29 30 87 6.27904 $w=2.09e-08 $layer=Gate_1 $thickness=5.24e-08 $X=0.729
+ $Y=0.135 $X2=0.729 $Y2=0.135
r30 30 175 6.6497 $w=2.04211e-08 $l=1.9e-08 $layer=Gate_1 $thickness=5.6e-08
+ $X=0.729 $Y=0.135 $X2=0.729 $Y2=0.116
r31 30 176 6.6497 $w=2.04211e-08 $l=1.9e-08 $layer=Gate_1 $thickness=5.6e-08
+ $X=0.729 $Y=0.135 $X2=0.729 $Y2=0.154
r32 171 170 16.4967 $w=2.1e-08 $l=4.85e-08 $layer=Gate_1 $thickness=5.6e-08
+ $X=0.675 $Y=0.2025 $X2=0.675 $Y2=0.154
r33 168 169 16.4967 $w=2.1e-08 $l=4.85e-08 $layer=Gate_1 $thickness=5.6e-08
+ $X=0.675 $Y=0.0675 $X2=0.675 $Y2=0.116
r34 29 83 6.27904 $w=2.09e-08 $layer=Gate_1 $thickness=5.24e-08 $X=0.675
+ $Y=0.135 $X2=0.675 $Y2=0.135
r35 29 169 6.6497 $w=2.04211e-08 $l=1.9e-08 $layer=Gate_1 $thickness=5.6e-08
+ $X=0.675 $Y=0.135 $X2=0.675 $Y2=0.116
r36 29 170 6.6497 $w=2.04211e-08 $l=1.9e-08 $layer=Gate_1 $thickness=5.6e-08
+ $X=0.675 $Y=0.135 $X2=0.675 $Y2=0.154
r37 165 164 16.4967 $w=2.1e-08 $l=4.85e-08 $layer=Gate_1 $thickness=5.6e-08
+ $X=0.189 $Y=0.2025 $X2=0.189 $Y2=0.154
r38 162 163 16.4967 $w=2.1e-08 $l=4.85e-08 $layer=Gate_1 $thickness=5.6e-08
+ $X=0.189 $Y=0.0675 $X2=0.189 $Y2=0.116
r39 20 78 6.27904 $w=2.09e-08 $layer=Gate_1 $thickness=5.24e-08 $X=0.189
+ $Y=0.135 $X2=0.189 $Y2=0.135
r40 20 163 6.6497 $w=2.04211e-08 $l=1.9e-08 $layer=Gate_1 $thickness=5.6e-08
+ $X=0.189 $Y=0.135 $X2=0.189 $Y2=0.116
r41 20 164 6.6497 $w=2.04211e-08 $l=1.9e-08 $layer=Gate_1 $thickness=5.6e-08
+ $X=0.189 $Y=0.135 $X2=0.189 $Y2=0.154
r42 159 158 16.4967 $w=2.1e-08 $l=4.85e-08 $layer=Gate_1 $thickness=5.6e-08
+ $X=0.243 $Y=0.2025 $X2=0.243 $Y2=0.154
r43 156 157 16.4967 $w=2.1e-08 $l=4.85e-08 $layer=Gate_1 $thickness=5.6e-08
+ $X=0.243 $Y=0.0675 $X2=0.243 $Y2=0.116
r44 21 74 6.27904 $w=2.09e-08 $layer=Gate_1 $thickness=5.24e-08 $X=0.243
+ $Y=0.135 $X2=0.243 $Y2=0.135
r45 21 157 6.6497 $w=2.04211e-08 $l=1.9e-08 $layer=Gate_1 $thickness=5.6e-08
+ $X=0.243 $Y=0.135 $X2=0.243 $Y2=0.116
r46 21 158 6.6497 $w=2.04211e-08 $l=1.9e-08 $layer=Gate_1 $thickness=5.6e-08
+ $X=0.243 $Y=0.135 $X2=0.243 $Y2=0.154
r47 153 152 16.4967 $w=2.1e-08 $l=4.85e-08 $layer=Gate_1 $thickness=5.6e-08
+ $X=0.297 $Y=0.2025 $X2=0.297 $Y2=0.154
r48 150 151 16.4967 $w=2.1e-08 $l=4.85e-08 $layer=Gate_1 $thickness=5.6e-08
+ $X=0.297 $Y=0.0675 $X2=0.297 $Y2=0.116
r49 22 70 6.27904 $w=2.09e-08 $layer=Gate_1 $thickness=5.24e-08 $X=0.297
+ $Y=0.135 $X2=0.297 $Y2=0.135
r50 22 151 6.6497 $w=2.04211e-08 $l=1.9e-08 $layer=Gate_1 $thickness=5.6e-08
+ $X=0.297 $Y=0.135 $X2=0.297 $Y2=0.116
r51 22 152 6.6497 $w=2.04211e-08 $l=1.9e-08 $layer=Gate_1 $thickness=5.6e-08
+ $X=0.297 $Y=0.135 $X2=0.297 $Y2=0.154
r52 147 146 16.4967 $w=2.1e-08 $l=4.85e-08 $layer=Gate_1 $thickness=5.6e-08
+ $X=0.351 $Y=0.2025 $X2=0.351 $Y2=0.154
r53 144 145 16.4967 $w=2.1e-08 $l=4.85e-08 $layer=Gate_1 $thickness=5.6e-08
+ $X=0.351 $Y=0.0675 $X2=0.351 $Y2=0.116
r54 23 66 6.27904 $w=2.09e-08 $layer=Gate_1 $thickness=5.24e-08 $X=0.351
+ $Y=0.135 $X2=0.351 $Y2=0.135
r55 23 145 6.6497 $w=2.04211e-08 $l=1.9e-08 $layer=Gate_1 $thickness=5.6e-08
+ $X=0.351 $Y=0.135 $X2=0.351 $Y2=0.116
r56 23 146 6.6497 $w=2.04211e-08 $l=1.9e-08 $layer=Gate_1 $thickness=5.6e-08
+ $X=0.351 $Y=0.135 $X2=0.351 $Y2=0.154
r57 141 140 16.4967 $w=2.1e-08 $l=4.85e-08 $layer=Gate_1 $thickness=5.6e-08
+ $X=0.405 $Y=0.2025 $X2=0.405 $Y2=0.154
r58 138 139 16.4967 $w=2.1e-08 $l=4.85e-08 $layer=Gate_1 $thickness=5.6e-08
+ $X=0.405 $Y=0.0675 $X2=0.405 $Y2=0.116
r59 24 62 6.27904 $w=2.09e-08 $layer=Gate_1 $thickness=5.24e-08 $X=0.405
+ $Y=0.135 $X2=0.405 $Y2=0.135
r60 24 139 6.6497 $w=2.04211e-08 $l=1.9e-08 $layer=Gate_1 $thickness=5.6e-08
+ $X=0.405 $Y=0.135 $X2=0.405 $Y2=0.116
r61 24 140 6.6497 $w=2.04211e-08 $l=1.9e-08 $layer=Gate_1 $thickness=5.6e-08
+ $X=0.405 $Y=0.135 $X2=0.405 $Y2=0.154
r62 135 134 16.4967 $w=2.1e-08 $l=4.85e-08 $layer=Gate_1 $thickness=5.6e-08
+ $X=0.459 $Y=0.2025 $X2=0.459 $Y2=0.154
r63 132 133 16.4967 $w=2.1e-08 $l=4.85e-08 $layer=Gate_1 $thickness=5.6e-08
+ $X=0.459 $Y=0.0675 $X2=0.459 $Y2=0.116
r64 25 58 6.27904 $w=2.09e-08 $layer=Gate_1 $thickness=5.24e-08 $X=0.459
+ $Y=0.135 $X2=0.459 $Y2=0.135
r65 25 133 6.6497 $w=2.04211e-08 $l=1.9e-08 $layer=Gate_1 $thickness=5.6e-08
+ $X=0.459 $Y=0.135 $X2=0.459 $Y2=0.116
r66 25 134 6.6497 $w=2.04211e-08 $l=1.9e-08 $layer=Gate_1 $thickness=5.6e-08
+ $X=0.459 $Y=0.135 $X2=0.459 $Y2=0.154
r67 129 128 16.4967 $w=2.1e-08 $l=4.85e-08 $layer=Gate_1 $thickness=5.6e-08
+ $X=0.513 $Y=0.2025 $X2=0.513 $Y2=0.154
r68 126 127 16.4967 $w=2.1e-08 $l=4.85e-08 $layer=Gate_1 $thickness=5.6e-08
+ $X=0.513 $Y=0.0675 $X2=0.513 $Y2=0.116
r69 26 54 6.27904 $w=2.09e-08 $layer=Gate_1 $thickness=5.24e-08 $X=0.513
+ $Y=0.135 $X2=0.513 $Y2=0.135
r70 26 127 6.6497 $w=2.04211e-08 $l=1.9e-08 $layer=Gate_1 $thickness=5.6e-08
+ $X=0.513 $Y=0.135 $X2=0.513 $Y2=0.116
r71 26 128 6.6497 $w=2.04211e-08 $l=1.9e-08 $layer=Gate_1 $thickness=5.6e-08
+ $X=0.513 $Y=0.135 $X2=0.513 $Y2=0.154
r72 123 122 16.4967 $w=2.1e-08 $l=4.85e-08 $layer=Gate_1 $thickness=5.6e-08
+ $X=0.567 $Y=0.2025 $X2=0.567 $Y2=0.154
r73 120 121 16.4967 $w=2.1e-08 $l=4.85e-08 $layer=Gate_1 $thickness=5.6e-08
+ $X=0.567 $Y=0.0675 $X2=0.567 $Y2=0.116
r74 27 50 6.27904 $w=2.09e-08 $layer=Gate_1 $thickness=5.24e-08 $X=0.567
+ $Y=0.135 $X2=0.567 $Y2=0.135
r75 27 121 6.6497 $w=2.04211e-08 $l=1.9e-08 $layer=Gate_1 $thickness=5.6e-08
+ $X=0.567 $Y=0.135 $X2=0.567 $Y2=0.116
r76 27 122 6.6497 $w=2.04211e-08 $l=1.9e-08 $layer=Gate_1 $thickness=5.6e-08
+ $X=0.567 $Y=0.135 $X2=0.567 $Y2=0.154
r77 117 118 2.2153 $w=1.3e-08 $l=9.5e-09 $layer=M1 $thickness=3.6e-08 $X=0.189
+ $Y=0.135 $X2=0.1985 $Y2=0.135
r78 116 117 6.29612 $w=1.3e-08 $l=2.7e-08 $layer=M1 $thickness=3.6e-08 $X=0.162
+ $Y=0.135 $X2=0.189 $Y2=0.135
r79 113 114 6.29612 $w=1.3e-08 $l=2.7e-08 $layer=M1 $thickness=3.6e-08 $X=0.756
+ $Y=0.135 $X2=0.783 $Y2=0.135
r80 112 113 6.29612 $w=1.3e-08 $l=2.7e-08 $layer=M1 $thickness=3.6e-08 $X=0.729
+ $Y=0.135 $X2=0.756 $Y2=0.135
r81 111 112 6.29612 $w=1.3e-08 $l=2.7e-08 $layer=M1 $thickness=3.6e-08 $X=0.702
+ $Y=0.135 $X2=0.729 $Y2=0.135
r82 110 111 6.29612 $w=1.3e-08 $l=2.7e-08 $layer=M1 $thickness=3.6e-08 $X=0.675
+ $Y=0.135 $X2=0.702 $Y2=0.135
r83 109 110 6.29612 $w=1.3e-08 $l=2.7e-08 $layer=M1 $thickness=3.6e-08 $X=0.648
+ $Y=0.135 $X2=0.675 $Y2=0.135
r84 108 109 6.29612 $w=1.3e-08 $l=2.7e-08 $layer=M1 $thickness=3.6e-08 $X=0.621
+ $Y=0.135 $X2=0.648 $Y2=0.135
r85 107 108 6.29612 $w=1.3e-08 $l=2.7e-08 $layer=M1 $thickness=3.6e-08 $X=0.594
+ $Y=0.135 $X2=0.621 $Y2=0.135
r86 106 107 6.29612 $w=1.3e-08 $l=2.7e-08 $layer=M1 $thickness=3.6e-08 $X=0.567
+ $Y=0.135 $X2=0.594 $Y2=0.135
r87 105 106 6.29612 $w=1.3e-08 $l=2.7e-08 $layer=M1 $thickness=3.6e-08 $X=0.54
+ $Y=0.135 $X2=0.567 $Y2=0.135
r88 104 105 6.29612 $w=1.3e-08 $l=2.7e-08 $layer=M1 $thickness=3.6e-08 $X=0.513
+ $Y=0.135 $X2=0.54 $Y2=0.135
r89 103 104 6.29612 $w=1.3e-08 $l=2.7e-08 $layer=M1 $thickness=3.6e-08 $X=0.486
+ $Y=0.135 $X2=0.513 $Y2=0.135
r90 102 103 6.29612 $w=1.3e-08 $l=2.7e-08 $layer=M1 $thickness=3.6e-08 $X=0.459
+ $Y=0.135 $X2=0.486 $Y2=0.135
r91 101 102 6.29612 $w=1.3e-08 $l=2.7e-08 $layer=M1 $thickness=3.6e-08 $X=0.432
+ $Y=0.135 $X2=0.459 $Y2=0.135
r92 100 101 6.29612 $w=1.3e-08 $l=2.7e-08 $layer=M1 $thickness=3.6e-08 $X=0.405
+ $Y=0.135 $X2=0.432 $Y2=0.135
r93 99 100 6.29612 $w=1.3e-08 $l=2.7e-08 $layer=M1 $thickness=3.6e-08 $X=0.378
+ $Y=0.135 $X2=0.405 $Y2=0.135
r94 98 99 6.29612 $w=1.3e-08 $l=2.7e-08 $layer=M1 $thickness=3.6e-08 $X=0.351
+ $Y=0.135 $X2=0.378 $Y2=0.135
r95 97 98 6.29612 $w=1.3e-08 $l=2.7e-08 $layer=M1 $thickness=3.6e-08 $X=0.324
+ $Y=0.135 $X2=0.351 $Y2=0.135
r96 96 97 6.29612 $w=1.3e-08 $l=2.7e-08 $layer=M1 $thickness=3.6e-08 $X=0.297
+ $Y=0.135 $X2=0.324 $Y2=0.135
r97 95 96 6.29612 $w=1.3e-08 $l=2.7e-08 $layer=M1 $thickness=3.6e-08 $X=0.27
+ $Y=0.135 $X2=0.297 $Y2=0.135
r98 94 95 6.29612 $w=1.3e-08 $l=2.7e-08 $layer=M1 $thickness=3.6e-08 $X=0.243
+ $Y=0.135 $X2=0.27 $Y2=0.135
r99 39 94 6.17953 $w=1.3e-08 $l=2.65e-08 $layer=M1 $thickness=3.6e-08 $X=0.2165
+ $Y=0.135 $X2=0.243 $Y2=0.135
r100 39 118 4.19742 $w=1.3e-08 $l=1.8e-08 $layer=M1 $thickness=3.6e-08
+ $X=0.2165 $Y=0.135 $X2=0.1985 $Y2=0.135
r101 91 114 19.3796 $a=3.24e-16 $layer=V0LIG $X=0.783 $Y=0.135 $X2=0.783
+ $Y2=0.135
r102 90 91 2.48102 $w=2.2e-08 $l=9.5e-09 $layer=LIG $thickness=4.8e-08
+ $X=0.7735 $Y=0.135 $X2=0.783 $Y2=0.135
r103 89 90 10.1729 $w=1.54914e-08 $l=1.75e-08 $layer=LIG $thickness=4.8e-08
+ $X=0.756 $Y=0.135 $X2=0.7735 $Y2=0.135
r104 88 89 10.1729 $w=1.54914e-08 $l=1.75e-08 $layer=LIG $thickness=4.8e-08
+ $X=0.7385 $Y=0.135 $X2=0.756 $Y2=0.135
r105 87 88 2.48102 $w=2.2e-08 $l=9.5e-09 $layer=LIG $thickness=4.8e-08 $X=0.729
+ $Y=0.135 $X2=0.7385 $Y2=0.135
r106 87 112 19.3796 $a=3.24e-16 $layer=V0LIG $X=0.729 $Y=0.135 $X2=0.729
+ $Y2=0.135
r107 86 87 2.48102 $w=2.2e-08 $l=9.5e-09 $layer=LIG $thickness=4.8e-08
+ $X=0.7195 $Y=0.135 $X2=0.729 $Y2=0.135
r108 85 86 10.1729 $w=1.54914e-08 $l=1.75e-08 $layer=LIG $thickness=4.8e-08
+ $X=0.702 $Y=0.135 $X2=0.7195 $Y2=0.135
r109 84 85 10.1729 $w=1.54914e-08 $l=1.75e-08 $layer=LIG $thickness=4.8e-08
+ $X=0.6845 $Y=0.135 $X2=0.702 $Y2=0.135
r110 83 84 2.48102 $w=2.2e-08 $l=9.5e-09 $layer=LIG $thickness=4.8e-08 $X=0.675
+ $Y=0.135 $X2=0.6845 $Y2=0.135
r111 83 110 19.3796 $a=3.24e-16 $layer=V0LIG $X=0.675 $Y=0.135 $X2=0.675
+ $Y2=0.135
r112 82 83 2.48102 $w=2.2e-08 $l=9.5e-09 $layer=LIG $thickness=4.8e-08
+ $X=0.6655 $Y=0.135 $X2=0.675 $Y2=0.135
r113 81 82 10.1729 $w=1.54914e-08 $l=1.75e-08 $layer=LIG $thickness=4.8e-08
+ $X=0.648 $Y=0.135 $X2=0.6655 $Y2=0.135
r114 78 79 2.48102 $w=2.2e-08 $l=9.5e-09 $layer=LIG $thickness=4.8e-08 $X=0.189
+ $Y=0.135 $X2=0.1985 $Y2=0.135
r115 78 117 19.3796 $a=3.24e-16 $layer=V0LIG $X=0.189 $Y=0.135 $X2=0.189
+ $Y2=0.135
r116 76 79 10.1729 $w=1.54914e-08 $l=1.75e-08 $layer=LIG $thickness=4.8e-08
+ $X=0.216 $Y=0.135 $X2=0.1985 $Y2=0.135
r117 74 75 2.48102 $w=2.2e-08 $l=9.5e-09 $layer=LIG $thickness=4.8e-08 $X=0.243
+ $Y=0.135 $X2=0.2525 $Y2=0.135
r118 74 94 19.3796 $a=3.24e-16 $layer=V0LIG $X=0.243 $Y=0.135 $X2=0.243
+ $Y2=0.135
r119 73 74 2.48102 $w=2.2e-08 $l=9.5e-09 $layer=LIG $thickness=4.8e-08
+ $X=0.2335 $Y=0.135 $X2=0.243 $Y2=0.135
r120 73 76 10.1729 $w=1.54914e-08 $l=1.75e-08 $layer=LIG $thickness=4.8e-08
+ $X=0.2335 $Y=0.135 $X2=0.216 $Y2=0.135
r121 72 75 10.1729 $w=1.54914e-08 $l=1.75e-08 $layer=LIG $thickness=4.8e-08
+ $X=0.27 $Y=0.135 $X2=0.2525 $Y2=0.135
r122 70 71 2.48102 $w=2.2e-08 $l=9.5e-09 $layer=LIG $thickness=4.8e-08 $X=0.297
+ $Y=0.135 $X2=0.3065 $Y2=0.135
r123 70 96 19.3796 $a=3.24e-16 $layer=V0LIG $X=0.297 $Y=0.135 $X2=0.297
+ $Y2=0.135
r124 69 70 2.48102 $w=2.2e-08 $l=9.5e-09 $layer=LIG $thickness=4.8e-08
+ $X=0.2875 $Y=0.135 $X2=0.297 $Y2=0.135
r125 69 72 10.1729 $w=1.54914e-08 $l=1.75e-08 $layer=LIG $thickness=4.8e-08
+ $X=0.2875 $Y=0.135 $X2=0.27 $Y2=0.135
r126 68 71 10.1729 $w=1.54914e-08 $l=1.75e-08 $layer=LIG $thickness=4.8e-08
+ $X=0.324 $Y=0.135 $X2=0.3065 $Y2=0.135
r127 66 67 2.48102 $w=2.2e-08 $l=9.5e-09 $layer=LIG $thickness=4.8e-08 $X=0.351
+ $Y=0.135 $X2=0.3605 $Y2=0.135
r128 66 98 19.3796 $a=3.24e-16 $layer=V0LIG $X=0.351 $Y=0.135 $X2=0.351
+ $Y2=0.135
r129 65 66 2.48102 $w=2.2e-08 $l=9.5e-09 $layer=LIG $thickness=4.8e-08
+ $X=0.3415 $Y=0.135 $X2=0.351 $Y2=0.135
r130 65 68 10.1729 $w=1.54914e-08 $l=1.75e-08 $layer=LIG $thickness=4.8e-08
+ $X=0.3415 $Y=0.135 $X2=0.324 $Y2=0.135
r131 64 67 10.1729 $w=1.54914e-08 $l=1.75e-08 $layer=LIG $thickness=4.8e-08
+ $X=0.378 $Y=0.135 $X2=0.3605 $Y2=0.135
r132 62 63 2.48102 $w=2.2e-08 $l=9.5e-09 $layer=LIG $thickness=4.8e-08 $X=0.405
+ $Y=0.135 $X2=0.4145 $Y2=0.135
r133 62 100 19.3796 $a=3.24e-16 $layer=V0LIG $X=0.405 $Y=0.135 $X2=0.405
+ $Y2=0.135
r134 61 62 2.48102 $w=2.2e-08 $l=9.5e-09 $layer=LIG $thickness=4.8e-08
+ $X=0.3955 $Y=0.135 $X2=0.405 $Y2=0.135
r135 61 64 10.1729 $w=1.54914e-08 $l=1.75e-08 $layer=LIG $thickness=4.8e-08
+ $X=0.3955 $Y=0.135 $X2=0.378 $Y2=0.135
r136 60 63 10.1729 $w=1.54914e-08 $l=1.75e-08 $layer=LIG $thickness=4.8e-08
+ $X=0.432 $Y=0.135 $X2=0.4145 $Y2=0.135
r137 58 59 2.48102 $w=2.2e-08 $l=9.5e-09 $layer=LIG $thickness=4.8e-08 $X=0.459
+ $Y=0.135 $X2=0.4685 $Y2=0.135
r138 58 102 19.3796 $a=3.24e-16 $layer=V0LIG $X=0.459 $Y=0.135 $X2=0.459
+ $Y2=0.135
r139 57 58 2.48102 $w=2.2e-08 $l=9.5e-09 $layer=LIG $thickness=4.8e-08
+ $X=0.4495 $Y=0.135 $X2=0.459 $Y2=0.135
r140 57 60 10.1729 $w=1.54914e-08 $l=1.75e-08 $layer=LIG $thickness=4.8e-08
+ $X=0.4495 $Y=0.135 $X2=0.432 $Y2=0.135
r141 56 59 10.1729 $w=1.54914e-08 $l=1.75e-08 $layer=LIG $thickness=4.8e-08
+ $X=0.486 $Y=0.135 $X2=0.4685 $Y2=0.135
r142 54 55 2.48102 $w=2.2e-08 $l=9.5e-09 $layer=LIG $thickness=4.8e-08 $X=0.513
+ $Y=0.135 $X2=0.5225 $Y2=0.135
r143 54 104 19.3796 $a=3.24e-16 $layer=V0LIG $X=0.513 $Y=0.135 $X2=0.513
+ $Y2=0.135
r144 53 54 2.48102 $w=2.2e-08 $l=9.5e-09 $layer=LIG $thickness=4.8e-08
+ $X=0.5035 $Y=0.135 $X2=0.513 $Y2=0.135
r145 53 56 10.1729 $w=1.54914e-08 $l=1.75e-08 $layer=LIG $thickness=4.8e-08
+ $X=0.5035 $Y=0.135 $X2=0.486 $Y2=0.135
r146 52 55 10.1729 $w=1.54914e-08 $l=1.75e-08 $layer=LIG $thickness=4.8e-08
+ $X=0.54 $Y=0.135 $X2=0.5225 $Y2=0.135
r147 50 51 2.48102 $w=2.2e-08 $l=9.5e-09 $layer=LIG $thickness=4.8e-08 $X=0.567
+ $Y=0.135 $X2=0.5765 $Y2=0.135
r148 50 106 19.3796 $a=3.24e-16 $layer=V0LIG $X=0.567 $Y=0.135 $X2=0.567
+ $Y2=0.135
r149 49 50 2.48102 $w=2.2e-08 $l=9.5e-09 $layer=LIG $thickness=4.8e-08
+ $X=0.5575 $Y=0.135 $X2=0.567 $Y2=0.135
r150 49 52 10.1729 $w=1.54914e-08 $l=1.75e-08 $layer=LIG $thickness=4.8e-08
+ $X=0.5575 $Y=0.135 $X2=0.54 $Y2=0.135
r151 48 51 10.1729 $w=1.54914e-08 $l=1.75e-08 $layer=LIG $thickness=4.8e-08
+ $X=0.594 $Y=0.135 $X2=0.5765 $Y2=0.135
r152 47 81 10.1729 $w=1.54914e-08 $l=1.75e-08 $layer=LIG $thickness=4.8e-08
+ $X=0.6305 $Y=0.135 $X2=0.648 $Y2=0.135
r153 46 47 2.48102 $w=2.2e-08 $l=9.5e-09 $layer=LIG $thickness=4.8e-08 $X=0.621
+ $Y=0.135 $X2=0.6305 $Y2=0.135
r154 46 108 19.3796 $a=3.24e-16 $layer=V0LIG $X=0.621 $Y=0.135 $X2=0.621
+ $Y2=0.135
r155 1 46 2.48102 $w=2.2e-08 $l=9.5e-09 $layer=LIG $thickness=4.8e-08 $X=0.6115
+ $Y=0.135 $X2=0.621 $Y2=0.135
r156 1 48 10.1729 $w=1.54914e-08 $l=1.75e-08 $layer=LIG $thickness=4.8e-08
+ $X=0.6115 $Y=0.135 $X2=0.594 $Y2=0.135
r157 44 43 16.4967 $w=2.1e-08 $l=4.85e-08 $layer=Gate_1 $thickness=5.6e-08
+ $X=0.621 $Y=0.2025 $X2=0.621 $Y2=0.154
r158 42 43 6.6497 $w=2.04211e-08 $l=1.9e-08 $layer=Gate_1 $thickness=5.6e-08
+ $X=0.621 $Y=0.135 $X2=0.621 $Y2=0.154
r159 42 47 4.05918 $w=2.0087e-08 $l=9.5e-09 $layer=Gate_1
+ $thickness=5.56522e-08 $X=0.621 $Y=0.135 $X2=0.6305 $Y2=0.135
r160 42 46 6.27904 $w=2.09e-08 $layer=Gate_1 $thickness=5.24e-08 $X=0.621
+ $Y=0.135 $X2=0.621 $Y2=0.135
r161 41 42 6.6497 $w=2.04211e-08 $l=1.9e-08 $layer=Gate_1 $thickness=5.6e-08
+ $X=0.621 $Y=0.116 $X2=0.621 $Y2=0.135
r162 40 41 16.4967 $w=2.1e-08 $l=4.85e-08 $layer=Gate_1 $thickness=5.6e-08
+ $X=0.621 $Y=0.0675 $X2=0.621 $Y2=0.116
r163 40 28 14.6259 $w=2.1e-08 $l=4.3e-08 $layer=Gate_1 $thickness=5.6e-08
+ $X=0.621 $Y=0.0675 $X2=0.621 $Y2=0.0245
.ends

* End of included file BUFx12_ASAP7_75t_R.pex.sp.pex

*
.subckt BUFx12_ASAP7_75t_CUSTOM_4_25_0_7 VSS VDD A Y
*
* VSS VSS
* VDD VDD
* A A
* Y Y
*
*

M0 N_M0_d N_M0_g VSS VSS nmos_rvt L=2e-08 W=8.1e-08 nfin=3 $X=0.071 $Y=0.027
M1 N_M1_d N_M1_g VSS VSS nmos_rvt L=2e-08 W=8.1e-08 nfin=3 $X=0.125 $Y=0.027
M2 N_M2_d N_M2_g VSS VSS nmos_rvt L=2e-08 W=8.1e-08 nfin=3 $X=0.179 $Y=0.027
M3 N_M3_d N_M3_g VSS VSS nmos_rvt L=2e-08 W=8.1e-08 nfin=3 $X=0.233 $Y=0.027
M4 N_M4_d N_M4_g VSS VSS nmos_rvt L=2e-08 W=8.1e-08 nfin=3 $X=0.287 $Y=0.027
M5 N_M5_d N_M5_g VSS VSS nmos_rvt L=2e-08 W=8.1e-08 nfin=3 $X=0.341 $Y=0.027
M6 N_M6_d N_M6_g VSS VSS nmos_rvt L=2e-08 W=8.1e-08 nfin=3 $X=0.395 $Y=0.027
M7 N_M7_d N_M7_g VSS VSS nmos_rvt L=2e-08 W=8.1e-08 nfin=3 $X=0.449 $Y=0.027
M8 N_M8_d N_M8_g VSS VSS nmos_rvt L=2e-08 W=8.1e-08 nfin=3 $X=0.503 $Y=0.027
M9 N_M9_d N_M9_g VSS VSS nmos_rvt L=2e-08 W=8.1e-08 nfin=3 $X=0.557 $Y=0.027
M10 N_M10_d N_M10_g VSS VSS nmos_rvt L=2e-08 W=8.1e-08 nfin=3 $X=0.611 $Y=0.027
M11 N_M11_d N_M11_g VSS VSS nmos_rvt L=2e-08 W=8.1e-08 nfin=3 $X=0.665 $Y=0.027
M12 N_M12_d N_M12_g VSS VSS nmos_rvt L=2e-08 W=8.1e-08 nfin=3 $X=0.719 $Y=0.027
M13 N_M13_d N_M13_g VSS VSS nmos_rvt L=2e-08 W=8.1e-08 nfin=3 $X=0.773 $Y=0.027
M14 N_M14_d N_M14_g VDD VDD pmos_rvt L=2e-08 W=8.1e-08 nfin=3 $X=0.071 $Y=0.162
M15 N_M15_d N_M15_g VDD VDD pmos_rvt L=2e-08 W=8.1e-08 nfin=3 $X=0.125 $Y=0.162
M16 N_M16_d N_M16_g VDD VDD pmos_rvt L=2e-08 W=8.1e-08 nfin=3 $X=0.179 $Y=0.162
M17 N_M17_d N_M17_g VDD VDD pmos_rvt L=2e-08 W=8.1e-08 nfin=3 $X=0.233 $Y=0.162
M18 N_M18_d N_M18_g VDD VDD pmos_rvt L=2e-08 W=8.1e-08 nfin=3 $X=0.287 $Y=0.162
M19 N_M19_d N_M19_g VDD VDD pmos_rvt L=2e-08 W=8.1e-08 nfin=3 $X=0.341 $Y=0.162
M20 N_M20_d N_M20_g VDD VDD pmos_rvt L=2e-08 W=8.1e-08 nfin=3 $X=0.395 $Y=0.162
M21 N_M21_d N_M21_g VDD VDD pmos_rvt L=2e-08 W=8.1e-08 nfin=3 $X=0.449 $Y=0.162
M22 N_M22_d N_M22_g VDD VDD pmos_rvt L=2e-08 W=8.1e-08 nfin=3 $X=0.503 $Y=0.162
M23 N_M23_d N_M23_g VDD VDD pmos_rvt L=2e-08 W=8.1e-08 nfin=3 $X=0.557 $Y=0.162
M24 N_M24_d N_M24_g VDD VDD pmos_rvt L=2e-08 W=8.1e-08 nfin=3 $X=0.611 $Y=0.162
M25 N_M25_d N_M25_g VDD VDD pmos_rvt L=2e-08 W=8.1e-08 nfin=3 $X=0.665 $Y=0.162
M26 N_M26_d N_M26_g VDD VDD pmos_rvt L=2e-08 W=8.1e-08 nfin=3 $X=0.719 $Y=0.162
M27 N_M27_d N_M27_g VDD VDD pmos_rvt L=2e-08 W=8.1e-08 nfin=3 $X=0.773 $Y=0.162

* .include "BUFx12_ASAP7_75t_R.pex.sp.pxi"

* Start of included file BUFx12_ASAP7_75t_R.pex.sp.pxi
x_PM_BUFx12_ASAP7_75t_R%A vss A N_M0_g N_M14_g N_M1_g N_M15_g N_A_4 N_A_7 N_A_5
+ N_A_10 N_A_3 N_A_1 PM_BUFx12_ASAP7_75t_R%A
x_PM_BUFx12_ASAP7_75t_R%Y vss Y N_M10_d N_M11_d N_M2_d N_M3_d N_M4_d N_M5_d
+ N_M6_d N_M7_d N_M8_d N_M9_d N_M12_d N_M13_d N_M16_d N_M17_d N_M18_d N_M19_d
+ N_M20_d N_M21_d N_M22_d N_M23_d N_M24_d N_M25_d N_M26_d N_M27_d N_Y_42 N_Y_2
+ N_Y_4 N_Y_6 N_Y_8 N_Y_10 N_Y_3 N_Y_5 N_Y_7 N_Y_9 N_Y_11 N_Y_12 N_Y_43 N_Y_37
+ N_Y_44 N_Y_45 N_Y_46 N_Y_47 N_Y_38 N_Y_39 N_Y_40 N_Y_41 N_Y_48 N_Y_53 N_Y_1
+ N_Y_52 N_Y_51 PM_BUFx12_ASAP7_75t_R%Y
cc_1 N_Y_42 N_4_20 9.39204e-20 $X=0.7415 $Y=0.0675
cc_2 N_Y_42 N_4_22 0.000187841f $X=0.7415 $Y=0.0675
cc_3 N_Y_42 N_4_24 0.000187841f $X=0.7415 $Y=0.0675
cc_4 N_Y_42 N_4_26 0.000187841f $X=0.7415 $Y=0.0675
cc_5 N_Y_42 N_4_28 0.000187841f $X=0.7415 $Y=0.0675
cc_6 N_Y_42 N_4_34 0.000200387f $X=0.7415 $Y=0.0675
cc_7 N_Y_42 N_4_35 0.000200387f $X=0.7415 $Y=0.0675
cc_8 N_Y_42 N_4_1 0.000365414f $X=0.7415 $Y=0.0675
cc_9 N_Y_42 N_4_37 0.000449966f $X=0.7415 $Y=0.0675
cc_10 N_Y_42 N_4_38 0.000449966f $X=0.7415 $Y=0.0675
cc_11 N_Y_2 N_4_1 0.000452395f $X=0.216 $Y=0.2025
cc_12 N_Y_4 N_4_1 0.000452648f $X=0.324 $Y=0.2025
cc_13 N_Y_6 N_4_1 0.000452648f $X=0.432 $Y=0.2025
cc_14 N_Y_8 N_4_1 0.000452648f $X=0.54 $Y=0.2025
cc_15 N_Y_10 N_4_1 0.000452648f $X=0.648 $Y=0.2025
cc_16 N_Y_3 N_4_1 0.000677248f $X=0.324 $Y=0.0675
cc_17 N_Y_5 N_4_1 0.000677248f $X=0.432 $Y=0.0675
cc_18 N_Y_7 N_4_1 0.000677248f $X=0.54 $Y=0.0675
cc_19 N_Y_9 N_4_1 0.000677248f $X=0.648 $Y=0.0675
cc_20 N_Y_11 N_4_1 0.000677248f $X=0.756 $Y=0.0675
cc_21 N_Y_12 N_4_1 0.000700652f $X=0.756 $Y=0.2025
cc_22 N_Y_43 N_4_21 0.0644815f $X=0.2015 $Y=0.2025
cc_23 N_Y_37 N_4_21 0.000807032f $X=0.2015 $Y=0.0675
cc_24 N_Y_44 N_4_23 0.0186827f $X=0.3095 $Y=0.2025
cc_25 N_Y_45 N_4_25 0.0186827f $X=0.4175 $Y=0.2025
cc_26 N_Y_46 N_4_27 0.0186827f $X=0.5255 $Y=0.2025
cc_27 N_Y_47 N_4_29 0.0186827f $X=0.6335 $Y=0.2025
cc_28 N_Y_38 N_4_22 0.0107313f $X=0.3095 $Y=0.0675
cc_29 N_Y_39 N_4_24 0.0107313f $X=0.4175 $Y=0.0675
cc_30 N_Y_40 N_4_26 0.0107313f $X=0.5255 $Y=0.0675
cc_31 N_Y_41 N_4_28 0.0107313f $X=0.6335 $Y=0.0675
cc_32 N_Y_42 N_4_31 0.0364942f $X=0.7415 $Y=0.0675
cc_33 N_Y_48 N_4_30 0.000828533f $X=0.7415 $Y=0.2025
cc_34 N_Y_53 N_4_39 0.0017345f $X=0.837 $Y=0.0855
cc_35 N_Y_11 N_4_30 0.00183884f $X=0.756 $Y=0.0675
cc_36 N_Y_12 N_4_30 0.00183884f $X=0.756 $Y=0.2025
cc_37 N_Y_4 N_4_22 0.00190241f $X=0.324 $Y=0.2025
cc_38 N_Y_3 N_4_23 0.00190241f $X=0.324 $Y=0.0675
cc_39 N_Y_6 N_4_24 0.00190241f $X=0.432 $Y=0.2025
cc_40 N_Y_5 N_4_25 0.00190241f $X=0.432 $Y=0.0675
cc_41 N_Y_8 N_4_26 0.00190241f $X=0.54 $Y=0.2025
cc_42 N_Y_7 N_4_27 0.00190241f $X=0.54 $Y=0.0675
cc_43 N_Y_10 N_4_28 0.00190241f $X=0.648 $Y=0.2025
cc_44 N_Y_9 N_4_29 0.00190241f $X=0.648 $Y=0.0675
cc_45 N_Y_1 N_4_21 0.00205349f $X=0.216 $Y=0.0675
cc_46 N_Y_2 N_4_21 0.00205349f $X=0.216 $Y=0.2025
cc_47 N_Y_52 N_4_39 0.00480645f $X=0.814 $Y=0.234
cc_48 N_Y_51 N_4_39 0.00480661f $X=0.203 $Y=0.036
cc_49 N_Y_4 N_4_39 0.00525337f $X=0.324 $Y=0.2025
cc_50 N_Y_10 N_4_39 0.00699939f $X=0.648 $Y=0.2025
cc_51 N_Y_48 N_4_31 0.0279237f $X=0.7415 $Y=0.2025
cc_52 N_Y_37 N_4_20 0.0631819f $X=0.2015 $Y=0.0675
cc_53 N_Y_38 N_4_23 0.0536863f $X=0.3095 $Y=0.0675
cc_54 N_Y_39 N_4_25 0.0536863f $X=0.4175 $Y=0.0675
cc_55 N_Y_40 N_4_27 0.0536863f $X=0.5255 $Y=0.0675
cc_56 N_Y_41 N_4_29 0.053609f $X=0.6335 $Y=0.0675
cc_57 N_Y_40 N_4_1 0.0246453f $X=0.5255 $Y=0.0675
cc_58 N_Y_44 N_4_22 0.0457264f $X=0.3095 $Y=0.2025
cc_59 N_Y_45 N_4_24 0.0457278f $X=0.4175 $Y=0.2025
cc_60 N_Y_46 N_4_26 0.0457278f $X=0.5255 $Y=0.2025
cc_61 N_Y_47 N_4_28 0.0457278f $X=0.6335 $Y=0.2025
cc_62 N_Y_42 N_4_30 0.0645754f $X=0.7415 $Y=0.0675
x_PM_BUFx12_ASAP7_75t_R%4 vss N_M10_g N_M24_g N_M9_g N_M23_g N_M8_g N_M22_g
+ N_M7_g N_M21_g N_M6_g N_M20_g N_M5_g N_M19_g N_M4_g N_M18_g N_M3_g N_M17_g
+ N_M2_g N_M16_g N_M11_g N_M25_g N_M12_g N_M26_g N_M13_g N_M27_g N_M0_d N_M1_d
+ N_M14_d N_M15_d N_4_15 N_4_39 N_4_14 N_4_36 N_4_35 N_4_34 N_4_32 N_4_37
+ N_4_38 N_4_20 N_4_33 N_4_22 N_4_24 N_4_26 N_4_28 N_4_1 N_4_21 N_4_23 N_4_25
+ N_4_27 N_4_29 N_4_31 N_4_30 PM_BUFx12_ASAP7_75t_R%4
cc_63 N_4_15 N_A_4 0.000189564f $X=0.108 $Y=0.2025
cc_64 N_4_39 N_A_4 0.000327879f $X=0.2165 $Y=0.135
cc_65 N_4_14 N_A_4 0.0004665f $X=0.108 $Y=0.0675
cc_66 N_4_36 N_A_4 0.000474367f $X=0.135 $Y=0.135
cc_67 N_4_35 N_A_4 0.000525279f $X=0.135 $Y=0.234
cc_68 N_4_34 N_A_4 0.000565241f $X=0.135 $Y=0.036
cc_69 N_4_32 N_A_4 0.0114577f $X=0.0935 $Y=0.0675
cc_70 N_4_37 N_A_4 0.000929368f $X=0.135 $Y=0.0855
cc_71 N_4_38 N_A_4 0.000929368f $X=0.135 $Y=0.1845
cc_72 N_4_35 N_A_7 0.000936812f $X=0.135 $Y=0.234
cc_73 N_4_34 N_A_5 0.000953419f $X=0.135 $Y=0.036
cc_74 N_4_36 N_A_10 0.000967042f $X=0.135 $Y=0.135
cc_75 N_4_20 N_A_4 0.00174596f $X=0.189 $Y=0.135
cc_76 N_4_14 N_A_3 0.0018339f $X=0.108 $Y=0.0675
cc_77 N_4_15 N_A_3 0.0018339f $X=0.108 $Y=0.2025
cc_78 N_4_32 N_A_1 0.00634552f $X=0.0935 $Y=0.0675
cc_79 N_4_33 N_A_3 0.0189446f $X=0.0935 $Y=0.2025
cc_80 N_4_32 N_A_3 0.0567798f $X=0.0935 $Y=0.0675
cc_81 N_4_33 N_A_4 0.051287f $X=0.0935 $Y=0.2025

* End of included file BUFx12_ASAP7_75t_R.pex.sp.pxi
.ends

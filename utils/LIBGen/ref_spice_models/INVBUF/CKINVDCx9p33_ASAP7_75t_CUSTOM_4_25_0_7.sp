.subckt PM_CKINVDCx9p33_ASAP7_75t_R%8 vss 19 23 33 36 46 47 50 51 10 9 15 17 3
+ 1 11 13 4 18
c1 1 vss 0.00633496f $X=0.297 $Y=0.135
c2 3 vss 0.00721826f $X=0.216 $Y=0.2025
c3 4 vss 0.00716121f $X=0.324 $Y=0.2025
c4 9 vss 0.0822598f $X=0.297 $Y=0.0245
c5 10 vss 0.0996477f $X=0.351 $Y=0.135
c6 11 vss 0.00705822f $X=0.2015 $Y=0.2025
c7 12 vss 0.00657796f $X=0.3095 $Y=0.2025
c8 13 vss 0.000208535f $X=0.297 $Y=0.135
c9 14 vss 0.000355383f $X=0.297 $Y=0.171
c10 15 vss 0.00259293f $X=0.27 $Y=0.171
c11 16 vss 0.000149609f $X=0.297 $Y=0.153
c12 17 vss 0.000692048f $X=0.3105 $Y=0.135
c13 18 vss 0.00132762f $X=0.3105 $Y=0.171
r1 51 49 0.0308642 $w=8.1e-08 $l=2.5e-09 $layer=P_src_drn $thickness=1e-09
+ $X=0.3413 $Y=0.2025 $X2=0.3385 $Y2=0.2025
r2 4 49 0.179012 $w=8.1e-08 $l=1.45e-08 $layer=P_src_drn $thickness=1e-09
+ $X=0.324 $Y=0.2025 $X2=0.3385 $Y2=0.2025
r3 12 4 0.179012 $w=8.1e-08 $l=1.45e-08 $layer=P_src_drn $thickness=1e-09
+ $X=0.3095 $Y=0.2025 $X2=0.324 $Y2=0.2025
r4 50 12 0.0308642 $w=8.1e-08 $l=2.5e-09 $layer=P_src_drn $thickness=1e-09
+ $X=0.3066 $Y=0.2025 $X2=0.3095 $Y2=0.2025
r5 47 45 0.0308642 $w=8.1e-08 $l=2.5e-09 $layer=P_src_drn $thickness=1e-09
+ $X=0.2333 $Y=0.2025 $X2=0.2305 $Y2=0.2025
r6 3 45 0.179012 $w=8.1e-08 $l=1.45e-08 $layer=P_src_drn $thickness=1e-09
+ $X=0.216 $Y=0.2025 $X2=0.2305 $Y2=0.2025
r7 11 3 0.179012 $w=8.1e-08 $l=1.45e-08 $layer=P_src_drn $thickness=1e-09
+ $X=0.2015 $Y=0.2025 $X2=0.216 $Y2=0.2025
r8 46 11 0.0308642 $w=8.1e-08 $l=2.5e-09 $layer=P_src_drn $thickness=1e-09
+ $X=0.1986 $Y=0.2025 $X2=0.2015 $Y2=0.2025
r9 4 41 19.3796 $a=3.24e-16 $layer=V0LISD $X=0.324 $Y=0.2025 $X2=0.324 $Y2=0.171
r10 3 39 19.3796 $a=3.24e-16 $layer=V0LISD $X=0.216 $Y=0.2025 $X2=0.216
+ $Y2=0.171
r11 18 41 3.14806 $w=1.3e-08 $l=1.35e-08 $layer=M1 $thickness=3.6e-08 $X=0.3105
+ $Y=0.171 $X2=0.324 $Y2=0.171
r12 39 40 5.24677 $w=1.3e-08 $l=2.25e-08 $layer=M1 $thickness=3.6e-08 $X=0.216
+ $Y=0.171 $X2=0.2385 $Y2=0.171
r13 15 40 7.34548 $w=1.3e-08 $l=3.15e-08 $layer=M1 $thickness=3.6e-08 $X=0.27
+ $Y=0.171 $X2=0.2385 $Y2=0.171
r14 14 16 3.01711 $w=1.55e-08 $l=1.8e-08 $layer=M1 $thickness=3.6e-08 $X=0.297
+ $Y=0.171 $X2=0.297 $Y2=0.153
r15 14 15 5.11582 $w=1.46667e-08 $l=2.7e-08 $layer=M1 $thickness=3.6e-08
+ $X=0.297 $Y=0.171 $X2=0.27 $Y2=0.171
r16 14 18 1.96775 $w=1.63333e-08 $l=1.35e-08 $layer=M1 $thickness=3.6e-08
+ $X=0.297 $Y=0.171 $X2=0.3105 $Y2=0.171
r17 13 17 1.49895 $w=1.63333e-08 $l=1.35e-08 $layer=M1 $thickness=3.6e-08
+ $X=0.297 $Y=0.135 $X2=0.3105 $Y2=0.135
r18 13 16 2.5483 $w=1.79e-08 $l=1.8e-08 $layer=M1 $thickness=3.6e-08 $X=0.297
+ $Y=0.135 $X2=0.297 $Y2=0.153
r19 36 35 16.4967 $w=2.1e-08 $l=4.85e-08 $layer=Gate_1 $thickness=5.6e-08
+ $X=0.351 $Y=0.2025 $X2=0.351 $Y2=0.154
r20 33 34 16.4967 $w=2.1e-08 $l=4.85e-08 $layer=Gate_1 $thickness=5.6e-08
+ $X=0.351 $Y=0.0675 $X2=0.351 $Y2=0.116
r21 10 27 6.54019 $w=2.09524e-08 $layer=Gate_1 $thickness=5.21905e-08 $X=0.351
+ $Y=0.135 $X2=0.351 $Y2=0.135
r22 10 34 6.6497 $w=2.04211e-08 $l=1.9e-08 $layer=Gate_1 $thickness=5.6e-08
+ $X=0.351 $Y=0.135 $X2=0.351 $Y2=0.116
r23 10 35 6.6497 $w=2.04211e-08 $l=1.9e-08 $layer=Gate_1 $thickness=5.6e-08
+ $X=0.351 $Y=0.135 $X2=0.351 $Y2=0.154
r24 17 29 3.14806 $w=1.3e-08 $l=1.35e-08 $layer=M1 $thickness=3.6e-08 $X=0.3105
+ $Y=0.135 $X2=0.324 $Y2=0.135
r25 26 27 12.6539 $w=1.77815e-08 $l=2.7e-08 $layer=LIG $thickness=4.8e-08
+ $X=0.324 $Y=0.135 $X2=0.351 $Y2=0.135
r26 26 29 19.3796 $a=3.24e-16 $layer=V0LIG $X=0.324 $Y=0.135 $X2=0.324 $Y2=0.135
r27 1 21 6.54019 $w=2.09524e-08 $layer=Gate_1 $thickness=5.21905e-08 $X=0.297
+ $Y=0.135 $X2=0.297 $Y2=0.135
r28 1 26 12.6539 $w=1.77815e-08 $l=2.7e-08 $layer=LIG $thickness=4.8e-08
+ $X=0.297 $Y=0.135 $X2=0.324 $Y2=0.135
r29 23 22 16.4967 $w=2.1e-08 $l=4.85e-08 $layer=Gate_1 $thickness=5.6e-08
+ $X=0.297 $Y=0.2025 $X2=0.297 $Y2=0.154
r30 21 22 6.6497 $w=2.04211e-08 $l=1.9e-08 $layer=Gate_1 $thickness=5.6e-08
+ $X=0.297 $Y=0.135 $X2=0.297 $Y2=0.154
r31 20 21 6.6497 $w=2.04211e-08 $l=1.9e-08 $layer=Gate_1 $thickness=5.6e-08
+ $X=0.297 $Y=0.116 $X2=0.297 $Y2=0.135
r32 19 20 16.4967 $w=2.1e-08 $l=4.85e-08 $layer=Gate_1 $thickness=5.6e-08
+ $X=0.297 $Y=0.0675 $X2=0.297 $Y2=0.116
r33 19 9 14.6259 $w=2.1e-08 $l=4.3e-08 $layer=Gate_1 $thickness=5.6e-08
+ $X=0.297 $Y=0.0675 $X2=0.297 $Y2=0.0245
.ends

.subckt PM_CKINVDCx9p33_ASAP7_75t_R%5 vss 19 23 33 36 46 47 50 51 9 10 18 16 4
+ 1 12 13 3 15
c1 1 vss 0.00633107f $X=1.053 $Y=0.135
c2 3 vss 0.00716032f $X=1.08 $Y=0.2025
c3 4 vss 0.00721758f $X=1.188 $Y=0.2025
c4 9 vss 0.0996471f $X=1.053 $Y=0.0245
c5 10 vss 0.0822581f $X=1.107 $Y=0.135
c6 11 vss 0.0065584f $X=1.0655 $Y=0.2025
c7 12 vss 0.00703683f $X=1.1735 $Y=0.2025
c8 13 vss 0.000208385f $X=1.107 $Y=0.135
c9 14 vss 0.000355233f $X=1.107 $Y=0.171
c10 15 vss 0.00130085f $X=1.0645 $Y=0.171
c11 16 vss 0.000682174f $X=1.062 $Y=0.135
c12 17 vss 0.000149608f $X=1.107 $Y=0.153
c13 18 vss 0.00258679f $X=1.134 $Y=0.171
r1 51 49 0.0308642 $w=8.1e-08 $l=2.5e-09 $layer=P_src_drn $thickness=1e-09
+ $X=1.2053 $Y=0.2025 $X2=1.2025 $Y2=0.2025
r2 4 49 0.179012 $w=8.1e-08 $l=1.45e-08 $layer=P_src_drn $thickness=1e-09
+ $X=1.188 $Y=0.2025 $X2=1.2025 $Y2=0.2025
r3 12 4 0.179012 $w=8.1e-08 $l=1.45e-08 $layer=P_src_drn $thickness=1e-09
+ $X=1.1735 $Y=0.2025 $X2=1.188 $Y2=0.2025
r4 50 12 0.0308642 $w=8.1e-08 $l=2.5e-09 $layer=P_src_drn $thickness=1e-09
+ $X=1.1706 $Y=0.2025 $X2=1.1735 $Y2=0.2025
r5 47 45 0.0308642 $w=8.1e-08 $l=2.5e-09 $layer=P_src_drn $thickness=1e-09
+ $X=1.0973 $Y=0.2025 $X2=1.0945 $Y2=0.2025
r6 3 45 0.179012 $w=8.1e-08 $l=1.45e-08 $layer=P_src_drn $thickness=1e-09
+ $X=1.08 $Y=0.2025 $X2=1.0945 $Y2=0.2025
r7 11 3 0.179012 $w=8.1e-08 $l=1.45e-08 $layer=P_src_drn $thickness=1e-09
+ $X=1.0655 $Y=0.2025 $X2=1.08 $Y2=0.2025
r8 46 11 0.0308642 $w=8.1e-08 $l=2.5e-09 $layer=P_src_drn $thickness=1e-09
+ $X=1.0626 $Y=0.2025 $X2=1.0655 $Y2=0.2025
r9 4 42 19.3796 $a=3.24e-16 $layer=V0LISD $X=1.188 $Y=0.2025 $X2=1.188 $Y2=0.171
r10 3 38 19.3796 $a=3.24e-16 $layer=V0LISD $X=1.08 $Y=0.2025 $X2=1.08 $Y2=0.171
r11 41 42 5.24677 $w=1.3e-08 $l=2.25e-08 $layer=M1 $thickness=3.6e-08 $X=1.1655
+ $Y=0.171 $X2=1.188 $Y2=0.171
r12 18 41 7.34548 $w=1.3e-08 $l=3.15e-08 $layer=M1 $thickness=3.6e-08 $X=1.134
+ $Y=0.171 $X2=1.1655 $Y2=0.171
r13 38 39 3.14806 $w=1.3e-08 $l=1.35e-08 $layer=M1 $thickness=3.6e-08 $X=1.08
+ $Y=0.171 $X2=1.0935 $Y2=0.171
r14 15 38 3.61444 $w=1.3e-08 $l=1.55e-08 $layer=M1 $thickness=3.6e-08 $X=1.0645
+ $Y=0.171 $X2=1.08 $Y2=0.171
r15 14 17 3.01711 $w=1.55e-08 $l=1.8e-08 $layer=M1 $thickness=3.6e-08 $X=1.107
+ $Y=0.171 $X2=1.107 $Y2=0.153
r16 14 39 1.96775 $w=1.63333e-08 $l=1.35e-08 $layer=M1 $thickness=3.6e-08
+ $X=1.107 $Y=0.171 $X2=1.0935 $Y2=0.171
r17 14 18 5.11582 $w=1.46667e-08 $l=2.7e-08 $layer=M1 $thickness=3.6e-08
+ $X=1.107 $Y=0.171 $X2=1.134 $Y2=0.171
r18 13 31 1.49895 $w=1.63333e-08 $l=1.35e-08 $layer=M1 $thickness=3.6e-08
+ $X=1.107 $Y=0.135 $X2=1.0935 $Y2=0.135
r19 13 17 2.5483 $w=1.79e-08 $l=1.8e-08 $layer=M1 $thickness=3.6e-08 $X=1.107
+ $Y=0.135 $X2=1.107 $Y2=0.153
r20 36 35 16.4967 $w=2.1e-08 $l=4.85e-08 $layer=Gate_1 $thickness=5.6e-08
+ $X=1.107 $Y=0.2025 $X2=1.107 $Y2=0.154
r21 33 34 16.4967 $w=2.1e-08 $l=4.85e-08 $layer=Gate_1 $thickness=5.6e-08
+ $X=1.107 $Y=0.0675 $X2=1.107 $Y2=0.116
r22 10 27 6.54019 $w=2.09524e-08 $layer=Gate_1 $thickness=5.21905e-08 $X=1.107
+ $Y=0.135 $X2=1.107 $Y2=0.135
r23 10 34 6.6497 $w=2.04211e-08 $l=1.9e-08 $layer=Gate_1 $thickness=5.6e-08
+ $X=1.107 $Y=0.135 $X2=1.107 $Y2=0.116
r24 10 35 6.6497 $w=2.04211e-08 $l=1.9e-08 $layer=Gate_1 $thickness=5.6e-08
+ $X=1.107 $Y=0.135 $X2=1.107 $Y2=0.154
r25 30 31 3.14806 $w=1.3e-08 $l=1.35e-08 $layer=M1 $thickness=3.6e-08 $X=1.08
+ $Y=0.135 $X2=1.0935 $Y2=0.135
r26 29 30 2.68168 $w=1.3e-08 $l=1.15e-08 $layer=M1 $thickness=3.6e-08 $X=1.0685
+ $Y=0.135 $X2=1.08 $Y2=0.135
r27 16 29 1.51573 $w=1.3e-08 $l=6.5e-09 $layer=M1 $thickness=3.6e-08 $X=1.062
+ $Y=0.135 $X2=1.0685 $Y2=0.135
r28 26 27 12.6539 $w=1.77815e-08 $l=2.7e-08 $layer=LIG $thickness=4.8e-08
+ $X=1.08 $Y=0.135 $X2=1.107 $Y2=0.135
r29 26 30 19.3796 $a=3.24e-16 $layer=V0LIG $X=1.08 $Y=0.135 $X2=1.08 $Y2=0.135
r30 1 21 6.54019 $w=2.09524e-08 $layer=Gate_1 $thickness=5.21905e-08 $X=1.053
+ $Y=0.135 $X2=1.053 $Y2=0.135
r31 1 26 12.6539 $w=1.77815e-08 $l=2.7e-08 $layer=LIG $thickness=4.8e-08
+ $X=1.053 $Y=0.135 $X2=1.08 $Y2=0.135
r32 23 22 16.4967 $w=2.1e-08 $l=4.85e-08 $layer=Gate_1 $thickness=5.6e-08
+ $X=1.053 $Y=0.2025 $X2=1.053 $Y2=0.154
r33 21 22 6.6497 $w=2.04211e-08 $l=1.9e-08 $layer=Gate_1 $thickness=5.6e-08
+ $X=1.053 $Y=0.135 $X2=1.053 $Y2=0.154
r34 20 21 6.6497 $w=2.04211e-08 $l=1.9e-08 $layer=Gate_1 $thickness=5.6e-08
+ $X=1.053 $Y=0.116 $X2=1.053 $Y2=0.135
r35 19 20 16.4967 $w=2.1e-08 $l=4.85e-08 $layer=Gate_1 $thickness=5.6e-08
+ $X=1.053 $Y=0.0675 $X2=1.053 $Y2=0.116
r36 19 9 14.6259 $w=2.1e-08 $l=4.3e-08 $layer=Gate_1 $thickness=5.6e-08
+ $X=1.053 $Y=0.0675 $X2=1.053 $Y2=0.0245
.ends

.subckt PM_CKINVDCx9p33_ASAP7_75t_R%6 vss 19 23 33 36 46 47 50 51 18 3 4 15 9
+ 12 16 1 14 10
c1 1 vss 0.00633485f $X=0.621 $Y=0.135
c2 3 vss 0.00715466f $X=0.648 $Y=0.0675
c3 4 vss 0.00721332f $X=0.756 $Y=0.0675
c4 9 vss 0.084623f $X=0.621 $Y=0.0245
c5 10 vss 0.0822475f $X=0.675 $Y=0.135
c6 11 vss 0.0064465f $X=0.6335 $Y=0.0675
c7 12 vss 0.00689924f $X=0.7415 $Y=0.0675
c8 13 vss 0.00034879f $X=0.675 $Y=0.099
c9 14 vss 0.000207439f $X=0.675 $Y=0.135
c10 15 vss 0.00128906f $X=0.6335 $Y=0.099
c11 16 vss 0.00060509f $X=0.631 $Y=0.135
c12 17 vss 0.000149605f $X=0.675 $Y=0.117
c13 18 vss 0.0024627f $X=0.702 $Y=0.099
r1 51 49 0.0308642 $w=8.1e-08 $l=2.5e-09 $layer=N_src_drn $thickness=1e-09
+ $X=0.7733 $Y=0.0675 $X2=0.7705 $Y2=0.0675
r2 4 49 0.179012 $w=8.1e-08 $l=1.45e-08 $layer=N_src_drn $thickness=1e-09
+ $X=0.756 $Y=0.0675 $X2=0.7705 $Y2=0.0675
r3 12 4 0.179012 $w=8.1e-08 $l=1.45e-08 $layer=N_src_drn $thickness=1e-09
+ $X=0.7415 $Y=0.0675 $X2=0.756 $Y2=0.0675
r4 50 12 0.0308642 $w=8.1e-08 $l=2.5e-09 $layer=N_src_drn $thickness=1e-09
+ $X=0.7386 $Y=0.0675 $X2=0.7415 $Y2=0.0675
r5 47 45 0.0308642 $w=8.1e-08 $l=2.5e-09 $layer=N_src_drn $thickness=1e-09
+ $X=0.6653 $Y=0.0675 $X2=0.6625 $Y2=0.0675
r6 3 45 0.179012 $w=8.1e-08 $l=1.45e-08 $layer=N_src_drn $thickness=1e-09
+ $X=0.648 $Y=0.0675 $X2=0.6625 $Y2=0.0675
r7 11 3 0.179012 $w=8.1e-08 $l=1.45e-08 $layer=N_src_drn $thickness=1e-09
+ $X=0.6335 $Y=0.0675 $X2=0.648 $Y2=0.0675
r8 46 11 0.0308642 $w=8.1e-08 $l=2.5e-09 $layer=N_src_drn $thickness=1e-09
+ $X=0.6306 $Y=0.0675 $X2=0.6335 $Y2=0.0675
r9 4 42 19.3796 $a=3.24e-16 $layer=V0LISD $X=0.756 $Y=0.0675 $X2=0.756 $Y2=0.099
r10 3 38 19.3796 $a=3.24e-16 $layer=V0LISD $X=0.648 $Y=0.0675 $X2=0.648
+ $Y2=0.099
r11 41 42 5.24677 $w=1.3e-08 $l=2.25e-08 $layer=M1 $thickness=3.6e-08 $X=0.7335
+ $Y=0.099 $X2=0.756 $Y2=0.099
r12 18 41 7.34548 $w=1.3e-08 $l=3.15e-08 $layer=M1 $thickness=3.6e-08 $X=0.702
+ $Y=0.099 $X2=0.7335 $Y2=0.099
r13 38 39 3.14806 $w=1.3e-08 $l=1.35e-08 $layer=M1 $thickness=3.6e-08 $X=0.648
+ $Y=0.099 $X2=0.6615 $Y2=0.099
r14 15 38 3.38125 $w=1.3e-08 $l=1.45e-08 $layer=M1 $thickness=3.6e-08 $X=0.6335
+ $Y=0.099 $X2=0.648 $Y2=0.099
r15 13 17 3.01711 $w=1.55e-08 $l=1.8e-08 $layer=M1 $thickness=3.6e-08 $X=0.675
+ $Y=0.099 $X2=0.675 $Y2=0.117
r16 13 39 1.96775 $w=1.63333e-08 $l=1.35e-08 $layer=M1 $thickness=3.6e-08
+ $X=0.675 $Y=0.099 $X2=0.6615 $Y2=0.099
r17 13 18 5.11582 $w=1.46667e-08 $l=2.7e-08 $layer=M1 $thickness=3.6e-08
+ $X=0.675 $Y=0.099 $X2=0.702 $Y2=0.099
r18 14 31 1.49895 $w=1.63333e-08 $l=1.35e-08 $layer=M1 $thickness=3.6e-08
+ $X=0.675 $Y=0.135 $X2=0.6615 $Y2=0.135
r19 14 17 2.5483 $w=1.79e-08 $l=1.8e-08 $layer=M1 $thickness=3.6e-08 $X=0.675
+ $Y=0.135 $X2=0.675 $Y2=0.117
r20 36 35 16.4967 $w=2.1e-08 $l=4.85e-08 $layer=Gate_1 $thickness=5.6e-08
+ $X=0.675 $Y=0.2025 $X2=0.675 $Y2=0.154
r21 33 34 16.4967 $w=2.1e-08 $l=4.85e-08 $layer=Gate_1 $thickness=5.6e-08
+ $X=0.675 $Y=0.0675 $X2=0.675 $Y2=0.116
r22 10 27 6.54019 $w=2.09524e-08 $layer=Gate_1 $thickness=5.21905e-08 $X=0.675
+ $Y=0.135 $X2=0.675 $Y2=0.135
r23 10 34 6.6497 $w=2.04211e-08 $l=1.9e-08 $layer=Gate_1 $thickness=5.6e-08
+ $X=0.675 $Y=0.135 $X2=0.675 $Y2=0.116
r24 10 35 6.6497 $w=2.04211e-08 $l=1.9e-08 $layer=Gate_1 $thickness=5.6e-08
+ $X=0.675 $Y=0.135 $X2=0.675 $Y2=0.154
r25 30 31 3.14806 $w=1.3e-08 $l=1.35e-08 $layer=M1 $thickness=3.6e-08 $X=0.648
+ $Y=0.135 $X2=0.6615 $Y2=0.135
r26 29 30 2.68168 $w=1.3e-08 $l=1.15e-08 $layer=M1 $thickness=3.6e-08 $X=0.6365
+ $Y=0.135 $X2=0.648 $Y2=0.135
r27 16 29 1.28254 $w=1.3e-08 $l=5.5e-09 $layer=M1 $thickness=3.6e-08 $X=0.631
+ $Y=0.135 $X2=0.6365 $Y2=0.135
r28 26 27 12.6539 $w=1.77815e-08 $l=2.7e-08 $layer=LIG $thickness=4.8e-08
+ $X=0.648 $Y=0.135 $X2=0.675 $Y2=0.135
r29 26 30 19.3796 $a=3.24e-16 $layer=V0LIG $X=0.648 $Y=0.135 $X2=0.648 $Y2=0.135
r30 1 21 6.54019 $w=2.09524e-08 $layer=Gate_1 $thickness=5.21905e-08 $X=0.621
+ $Y=0.135 $X2=0.621 $Y2=0.135
r31 1 26 12.6539 $w=1.77815e-08 $l=2.7e-08 $layer=LIG $thickness=4.8e-08
+ $X=0.621 $Y=0.135 $X2=0.648 $Y2=0.135
r32 23 22 16.4967 $w=2.1e-08 $l=4.85e-08 $layer=Gate_1 $thickness=5.6e-08
+ $X=0.621 $Y=0.2025 $X2=0.621 $Y2=0.154
r33 21 22 6.6497 $w=2.04211e-08 $l=1.9e-08 $layer=Gate_1 $thickness=5.6e-08
+ $X=0.621 $Y=0.135 $X2=0.621 $Y2=0.154
r34 20 21 6.6497 $w=2.04211e-08 $l=1.9e-08 $layer=Gate_1 $thickness=5.6e-08
+ $X=0.621 $Y=0.116 $X2=0.621 $Y2=0.135
r35 19 20 16.4967 $w=2.1e-08 $l=4.85e-08 $layer=Gate_1 $thickness=5.6e-08
+ $X=0.621 $Y=0.0675 $X2=0.621 $Y2=0.116
r36 19 9 14.6259 $w=2.1e-08 $l=4.3e-08 $layer=Gate_1 $thickness=5.6e-08
+ $X=0.621 $Y=0.0675 $X2=0.621 $Y2=0.0245
.ends

.subckt PM_CKINVDCx9p33_ASAP7_75t_R%7 vss 19 23 33 36 46 47 50 51 10 9 15 17 3
+ 1 11 13 4 18
c1 1 vss 0.00633493f $X=0.729 $Y=0.135
c2 3 vss 0.00721715f $X=0.648 $Y=0.2025
c3 4 vss 0.00715973f $X=0.756 $Y=0.2025
c4 9 vss 0.082257f $X=0.729 $Y=0.0245
c5 10 vss 0.0996467f $X=0.783 $Y=0.135
c6 11 vss 0.0070229f $X=0.6335 $Y=0.2025
c7 12 vss 0.00654566f $X=0.7415 $Y=0.2025
c8 13 vss 0.000208288f $X=0.729 $Y=0.135
c9 14 vss 0.000355136f $X=0.729 $Y=0.171
c10 15 vss 0.00258314f $X=0.702 $Y=0.171
c11 16 vss 0.000149608f $X=0.729 $Y=0.153
c12 17 vss 0.000662255f $X=0.7425 $Y=0.135
c13 18 vss 0.00129894f $X=0.7425 $Y=0.171
r1 51 49 0.0308642 $w=8.1e-08 $l=2.5e-09 $layer=P_src_drn $thickness=1e-09
+ $X=0.7733 $Y=0.2025 $X2=0.7705 $Y2=0.2025
r2 4 49 0.179012 $w=8.1e-08 $l=1.45e-08 $layer=P_src_drn $thickness=1e-09
+ $X=0.756 $Y=0.2025 $X2=0.7705 $Y2=0.2025
r3 12 4 0.179012 $w=8.1e-08 $l=1.45e-08 $layer=P_src_drn $thickness=1e-09
+ $X=0.7415 $Y=0.2025 $X2=0.756 $Y2=0.2025
r4 50 12 0.0308642 $w=8.1e-08 $l=2.5e-09 $layer=P_src_drn $thickness=1e-09
+ $X=0.7386 $Y=0.2025 $X2=0.7415 $Y2=0.2025
r5 47 45 0.0308642 $w=8.1e-08 $l=2.5e-09 $layer=P_src_drn $thickness=1e-09
+ $X=0.6653 $Y=0.2025 $X2=0.6625 $Y2=0.2025
r6 3 45 0.179012 $w=8.1e-08 $l=1.45e-08 $layer=P_src_drn $thickness=1e-09
+ $X=0.648 $Y=0.2025 $X2=0.6625 $Y2=0.2025
r7 11 3 0.179012 $w=8.1e-08 $l=1.45e-08 $layer=P_src_drn $thickness=1e-09
+ $X=0.6335 $Y=0.2025 $X2=0.648 $Y2=0.2025
r8 46 11 0.0308642 $w=8.1e-08 $l=2.5e-09 $layer=P_src_drn $thickness=1e-09
+ $X=0.6306 $Y=0.2025 $X2=0.6335 $Y2=0.2025
r9 4 41 19.3796 $a=3.24e-16 $layer=V0LISD $X=0.756 $Y=0.2025 $X2=0.756 $Y2=0.171
r10 3 39 19.3796 $a=3.24e-16 $layer=V0LISD $X=0.648 $Y=0.2025 $X2=0.648
+ $Y2=0.171
r11 18 41 3.14806 $w=1.3e-08 $l=1.35e-08 $layer=M1 $thickness=3.6e-08 $X=0.7425
+ $Y=0.171 $X2=0.756 $Y2=0.171
r12 39 40 5.24677 $w=1.3e-08 $l=2.25e-08 $layer=M1 $thickness=3.6e-08 $X=0.648
+ $Y=0.171 $X2=0.6705 $Y2=0.171
r13 15 40 7.34548 $w=1.3e-08 $l=3.15e-08 $layer=M1 $thickness=3.6e-08 $X=0.702
+ $Y=0.171 $X2=0.6705 $Y2=0.171
r14 14 16 3.01711 $w=1.55e-08 $l=1.8e-08 $layer=M1 $thickness=3.6e-08 $X=0.729
+ $Y=0.171 $X2=0.729 $Y2=0.153
r15 14 15 5.11582 $w=1.46667e-08 $l=2.7e-08 $layer=M1 $thickness=3.6e-08
+ $X=0.729 $Y=0.171 $X2=0.702 $Y2=0.171
r16 14 18 1.96775 $w=1.63333e-08 $l=1.35e-08 $layer=M1 $thickness=3.6e-08
+ $X=0.729 $Y=0.171 $X2=0.7425 $Y2=0.171
r17 13 17 1.49895 $w=1.63333e-08 $l=1.35e-08 $layer=M1 $thickness=3.6e-08
+ $X=0.729 $Y=0.135 $X2=0.7425 $Y2=0.135
r18 13 16 2.5483 $w=1.79e-08 $l=1.8e-08 $layer=M1 $thickness=3.6e-08 $X=0.729
+ $Y=0.135 $X2=0.729 $Y2=0.153
r19 36 35 16.4967 $w=2.1e-08 $l=4.85e-08 $layer=Gate_1 $thickness=5.6e-08
+ $X=0.783 $Y=0.2025 $X2=0.783 $Y2=0.154
r20 33 34 16.4967 $w=2.1e-08 $l=4.85e-08 $layer=Gate_1 $thickness=5.6e-08
+ $X=0.783 $Y=0.0675 $X2=0.783 $Y2=0.116
r21 10 27 6.54019 $w=2.09524e-08 $layer=Gate_1 $thickness=5.21905e-08 $X=0.783
+ $Y=0.135 $X2=0.783 $Y2=0.135
r22 10 34 6.6497 $w=2.04211e-08 $l=1.9e-08 $layer=Gate_1 $thickness=5.6e-08
+ $X=0.783 $Y=0.135 $X2=0.783 $Y2=0.116
r23 10 35 6.6497 $w=2.04211e-08 $l=1.9e-08 $layer=Gate_1 $thickness=5.6e-08
+ $X=0.783 $Y=0.135 $X2=0.783 $Y2=0.154
r24 17 29 3.14806 $w=1.3e-08 $l=1.35e-08 $layer=M1 $thickness=3.6e-08 $X=0.7425
+ $Y=0.135 $X2=0.756 $Y2=0.135
r25 26 27 12.6539 $w=1.77815e-08 $l=2.7e-08 $layer=LIG $thickness=4.8e-08
+ $X=0.756 $Y=0.135 $X2=0.783 $Y2=0.135
r26 26 29 19.3796 $a=3.24e-16 $layer=V0LIG $X=0.756 $Y=0.135 $X2=0.756 $Y2=0.135
r27 1 21 6.54019 $w=2.09524e-08 $layer=Gate_1 $thickness=5.21905e-08 $X=0.729
+ $Y=0.135 $X2=0.729 $Y2=0.135
r28 1 26 12.6539 $w=1.77815e-08 $l=2.7e-08 $layer=LIG $thickness=4.8e-08
+ $X=0.729 $Y=0.135 $X2=0.756 $Y2=0.135
r29 23 22 16.4967 $w=2.1e-08 $l=4.85e-08 $layer=Gate_1 $thickness=5.6e-08
+ $X=0.729 $Y=0.2025 $X2=0.729 $Y2=0.154
r30 21 22 6.6497 $w=2.04211e-08 $l=1.9e-08 $layer=Gate_1 $thickness=5.6e-08
+ $X=0.729 $Y=0.135 $X2=0.729 $Y2=0.154
r31 20 21 6.6497 $w=2.04211e-08 $l=1.9e-08 $layer=Gate_1 $thickness=5.6e-08
+ $X=0.729 $Y=0.116 $X2=0.729 $Y2=0.135
r32 19 20 16.4967 $w=2.1e-08 $l=4.85e-08 $layer=Gate_1 $thickness=5.6e-08
+ $X=0.729 $Y=0.0675 $X2=0.729 $Y2=0.116
r33 19 9 14.6259 $w=2.1e-08 $l=4.3e-08 $layer=Gate_1 $thickness=5.6e-08
+ $X=0.729 $Y=0.0675 $X2=0.729 $Y2=0.0245
.ends

.subckt PM_CKINVDCx9p33_ASAP7_75t_R%4 vss 19 23 33 36 46 47 50 51 15 4 3 17 10
+ 11 18 1 14 9
c1 1 vss 0.00633096f $X=1.161 $Y=0.135
c2 3 vss 0.00721157f $X=1.08 $Y=0.0675
c3 4 vss 0.00715235f $X=1.188 $Y=0.0675
c4 9 vss 0.0822431f $X=1.161 $Y=0.0245
c5 10 vss 0.0846212f $X=1.215 $Y=0.135
c6 11 vss 0.00684402f $X=1.0655 $Y=0.0675
c7 12 vss 0.00639617f $X=1.1735 $Y=0.0675
c8 13 vss 0.000348533f $X=1.161 $Y=0.099
c9 14 vss 0.000207052f $X=1.161 $Y=0.135
c10 15 vss 0.0024295f $X=1.134 $Y=0.099
c11 16 vss 0.000149604f $X=1.161 $Y=0.117
c12 17 vss 0.00128629f $X=1.1745 $Y=0.099
c13 18 vss 0.000608275f $X=1.1745 $Y=0.135
r1 51 49 0.0308642 $w=8.1e-08 $l=2.5e-09 $layer=N_src_drn $thickness=1e-09
+ $X=1.2053 $Y=0.0675 $X2=1.2025 $Y2=0.0675
r2 4 49 0.179012 $w=8.1e-08 $l=1.45e-08 $layer=N_src_drn $thickness=1e-09
+ $X=1.188 $Y=0.0675 $X2=1.2025 $Y2=0.0675
r3 12 4 0.179012 $w=8.1e-08 $l=1.45e-08 $layer=N_src_drn $thickness=1e-09
+ $X=1.1735 $Y=0.0675 $X2=1.188 $Y2=0.0675
r4 50 12 0.0308642 $w=8.1e-08 $l=2.5e-09 $layer=N_src_drn $thickness=1e-09
+ $X=1.1706 $Y=0.0675 $X2=1.1735 $Y2=0.0675
r5 47 45 0.0308642 $w=8.1e-08 $l=2.5e-09 $layer=N_src_drn $thickness=1e-09
+ $X=1.0973 $Y=0.0675 $X2=1.0945 $Y2=0.0675
r6 3 45 0.179012 $w=8.1e-08 $l=1.45e-08 $layer=N_src_drn $thickness=1e-09
+ $X=1.08 $Y=0.0675 $X2=1.0945 $Y2=0.0675
r7 11 3 0.179012 $w=8.1e-08 $l=1.45e-08 $layer=N_src_drn $thickness=1e-09
+ $X=1.0655 $Y=0.0675 $X2=1.08 $Y2=0.0675
r8 46 11 0.0308642 $w=8.1e-08 $l=2.5e-09 $layer=N_src_drn $thickness=1e-09
+ $X=1.0626 $Y=0.0675 $X2=1.0655 $Y2=0.0675
r9 4 41 19.3796 $a=3.24e-16 $layer=V0LISD $X=1.188 $Y=0.0675 $X2=1.188 $Y2=0.099
r10 3 39 19.3796 $a=3.24e-16 $layer=V0LISD $X=1.08 $Y=0.0675 $X2=1.08 $Y2=0.099
r11 17 41 3.14806 $w=1.3e-08 $l=1.35e-08 $layer=M1 $thickness=3.6e-08 $X=1.1745
+ $Y=0.099 $X2=1.188 $Y2=0.099
r12 39 40 5.24677 $w=1.3e-08 $l=2.25e-08 $layer=M1 $thickness=3.6e-08 $X=1.08
+ $Y=0.099 $X2=1.1025 $Y2=0.099
r13 15 40 7.34548 $w=1.3e-08 $l=3.15e-08 $layer=M1 $thickness=3.6e-08 $X=1.134
+ $Y=0.099 $X2=1.1025 $Y2=0.099
r14 13 16 3.01711 $w=1.55e-08 $l=1.8e-08 $layer=M1 $thickness=3.6e-08 $X=1.161
+ $Y=0.099 $X2=1.161 $Y2=0.117
r15 13 15 5.11582 $w=1.46667e-08 $l=2.7e-08 $layer=M1 $thickness=3.6e-08
+ $X=1.161 $Y=0.099 $X2=1.134 $Y2=0.099
r16 13 17 1.96775 $w=1.63333e-08 $l=1.35e-08 $layer=M1 $thickness=3.6e-08
+ $X=1.161 $Y=0.099 $X2=1.1745 $Y2=0.099
r17 14 18 1.49895 $w=1.63333e-08 $l=1.35e-08 $layer=M1 $thickness=3.6e-08
+ $X=1.161 $Y=0.135 $X2=1.1745 $Y2=0.135
r18 14 16 2.5483 $w=1.79e-08 $l=1.8e-08 $layer=M1 $thickness=3.6e-08 $X=1.161
+ $Y=0.135 $X2=1.161 $Y2=0.117
r19 36 35 16.4967 $w=2.1e-08 $l=4.85e-08 $layer=Gate_1 $thickness=5.6e-08
+ $X=1.215 $Y=0.2025 $X2=1.215 $Y2=0.154
r20 33 34 16.4967 $w=2.1e-08 $l=4.85e-08 $layer=Gate_1 $thickness=5.6e-08
+ $X=1.215 $Y=0.0675 $X2=1.215 $Y2=0.116
r21 10 27 6.54019 $w=2.09524e-08 $layer=Gate_1 $thickness=5.21905e-08 $X=1.215
+ $Y=0.135 $X2=1.215 $Y2=0.135
r22 10 34 6.6497 $w=2.04211e-08 $l=1.9e-08 $layer=Gate_1 $thickness=5.6e-08
+ $X=1.215 $Y=0.135 $X2=1.215 $Y2=0.116
r23 10 35 6.6497 $w=2.04211e-08 $l=1.9e-08 $layer=Gate_1 $thickness=5.6e-08
+ $X=1.215 $Y=0.135 $X2=1.215 $Y2=0.154
r24 18 29 3.14806 $w=1.3e-08 $l=1.35e-08 $layer=M1 $thickness=3.6e-08 $X=1.1745
+ $Y=0.135 $X2=1.188 $Y2=0.135
r25 26 27 12.6539 $w=1.77815e-08 $l=2.7e-08 $layer=LIG $thickness=4.8e-08
+ $X=1.188 $Y=0.135 $X2=1.215 $Y2=0.135
r26 26 29 19.3796 $a=3.24e-16 $layer=V0LIG $X=1.188 $Y=0.135 $X2=1.188 $Y2=0.135
r27 1 21 6.54019 $w=2.09524e-08 $layer=Gate_1 $thickness=5.21905e-08 $X=1.161
+ $Y=0.135 $X2=1.161 $Y2=0.135
r28 1 26 12.6539 $w=1.77815e-08 $l=2.7e-08 $layer=LIG $thickness=4.8e-08
+ $X=1.161 $Y=0.135 $X2=1.188 $Y2=0.135
r29 23 22 16.4967 $w=2.1e-08 $l=4.85e-08 $layer=Gate_1 $thickness=5.6e-08
+ $X=1.161 $Y=0.2025 $X2=1.161 $Y2=0.154
r30 21 22 6.6497 $w=2.04211e-08 $l=1.9e-08 $layer=Gate_1 $thickness=5.6e-08
+ $X=1.161 $Y=0.135 $X2=1.161 $Y2=0.154
r31 20 21 6.6497 $w=2.04211e-08 $l=1.9e-08 $layer=Gate_1 $thickness=5.6e-08
+ $X=1.161 $Y=0.116 $X2=1.161 $Y2=0.135
r32 19 20 16.4967 $w=2.1e-08 $l=4.85e-08 $layer=Gate_1 $thickness=5.6e-08
+ $X=1.161 $Y=0.0675 $X2=1.161 $Y2=0.116
r33 19 9 14.6259 $w=2.1e-08 $l=4.3e-08 $layer=Gate_1 $thickness=5.6e-08
+ $X=1.161 $Y=0.0675 $X2=1.161 $Y2=0.0245
.ends

.subckt PM_CKINVDCx9p33_ASAP7_75t_R%Y vss 99 86 87 112 113 134 135 148 149 152
+ 153 172 173 183 184 197 198 201 202 222 223 233 234 239 240 243 244 252 253
+ 48 70 59 63 69 61 2 8 10 12 57 73 4 6 14 58 67 65 13 78 74 82 50 43 44 45 46
+ 47 52 54 51 53 55 49 56 5 7 9 3 1 11 71 75 81 79 83 77 72 76 80
c1 1 vss 0.00742173f $X=0.108 $Y=0.054
c2 2 vss 0.00890891f $X=0.108 $Y=0.1755
c3 3 vss 0.00725551f $X=0.432 $Y=0.054
c4 4 vss 0.00855819f $X=0.432 $Y=0.1755
c5 5 vss 0.00725005f $X=0.54 $Y=0.054
c6 6 vss 0.00855681f $X=0.54 $Y=0.1755
c7 7 vss 0.00734434f $X=0.864 $Y=0.054
c8 8 vss 0.00855838f $X=0.864 $Y=0.1755
c9 9 vss 0.00734434f $X=0.972 $Y=0.054
c10 10 vss 0.00855838f $X=0.972 $Y=0.1755
c11 11 vss 0.00733684f $X=1.296 $Y=0.054
c12 12 vss 0.00855838f $X=1.296 $Y=0.1755
c13 13 vss 0.0083024f $X=1.404 $Y=0.054
c14 14 vss 0.00866521f $X=1.404 $Y=0.1755
c15 43 vss 0.00356715f $X=0.0935 $Y=0.054
c16 44 vss 0.00352676f $X=0.4175 $Y=0.054
c17 45 vss 0.00352675f $X=0.5255 $Y=0.054
c18 46 vss 0.00352676f $X=0.8495 $Y=0.054
c19 47 vss 0.0035267f $X=0.9575 $Y=0.054
c20 48 vss 0.00351381f $X=1.2815 $Y=0.054
c21 49 vss 0.0035059f $X=1.3895 $Y=0.054
c22 50 vss 0.00358456f $X=0.0935 $Y=0.216
c23 51 vss 0.00349124f $X=0.4175 $Y=0.216
c24 52 vss 0.00349127f $X=0.5255 $Y=0.216
c25 53 vss 0.00349124f $X=0.8495 $Y=0.216
c26 54 vss 0.00349127f $X=0.9575 $Y=0.216
c27 55 vss 0.00349124f $X=1.2815 $Y=0.216
c28 56 vss 0.00349039f $X=1.3895 $Y=0.216
c29 57 vss 0.00105997f $X=0.0965 $Y=0.072
c30 58 vss 0.00538053f $X=0.135 $Y=0.234
c31 59 vss 0.00116708f $X=0.405 $Y=0.072
c32 60 vss 0.00207342f $X=0.405 $Y=0.234
c33 61 vss 0.00113512f $X=0.567 $Y=0.072
c34 62 vss 0.00207351f $X=0.567 $Y=0.234
c35 63 vss 0.0011512f $X=0.837 $Y=0.072
c36 64 vss 0.00207342f $X=0.837 $Y=0.234
c37 65 vss 0.0011512f $X=0.999 $Y=0.072
c38 66 vss 0.00207342f $X=0.999 $Y=0.234
c39 67 vss 0.00104332f $X=1.269 $Y=0.072
c40 68 vss 0.00207351f $X=1.269 $Y=0.234
c41 69 vss 0.00323885f $X=1.431 $Y=0.072
c42 70 vss 0.0030319f $X=1.431 $Y=0.234
c43 71 vss 0.00342742f $X=0.135 $Y=0.0855
c44 72 vss 0.0229341f $X=0.165 $Y=0.234
c45 73 vss 0.00306809f $X=0.405 $Y=0.2025
c46 74 vss 0.0122949f $X=0.4185 $Y=0.234
c47 75 vss 0.00308729f $X=0.567 $Y=0.2025
c48 76 vss 0.0229635f $X=0.597 $Y=0.234
c49 77 vss 0.00306709f $X=0.837 $Y=0.2025
c50 78 vss 0.0121203f $X=0.8505 $Y=0.234
c51 79 vss 0.00306709f $X=0.999 $Y=0.2025
c52 80 vss 0.0229385f $X=1.0275 $Y=0.234
c53 81 vss 0.00312915f $X=1.269 $Y=0.2025
c54 82 vss 0.0119701f $X=1.2825 $Y=0.234
c55 83 vss 0.00574895f $X=1.431 $Y=0.1845
r1 253 251 0.0462963 $w=5.4e-08 $l=2.5e-09 $layer=N_src_drn $thickness=1e-09
+ $X=1.4213 $Y=0.054 $X2=1.4185 $Y2=0.054
r2 13 251 0.268519 $w=5.4e-08 $l=1.45e-08 $layer=N_src_drn $thickness=1e-09
+ $X=1.404 $Y=0.054 $X2=1.4185 $Y2=0.054
r3 49 13 0.268519 $w=5.4e-08 $l=1.45e-08 $layer=N_src_drn $thickness=1e-09
+ $X=1.3895 $Y=0.054 $X2=1.404 $Y2=0.054
r4 252 49 0.0462963 $w=5.4e-08 $l=2.5e-09 $layer=N_src_drn $thickness=1e-09
+ $X=1.3866 $Y=0.054 $X2=1.3895 $Y2=0.054
r5 13 245 19.3796 $a=3.24e-16 $layer=V0LISD $X=1.404 $Y=0.054 $X2=1.405
+ $Y2=0.072
r6 245 246 2.91487 $w=1.3e-08 $l=1.25e-08 $layer=M1 $thickness=3.6e-08 $X=1.405
+ $Y=0.072 $X2=1.4175 $Y2=0.072
r7 69 236 6.16517 $w=1.44286e-08 $l=3.15e-08 $layer=M1 $thickness=3.6e-08
+ $X=1.431 $Y=0.072 $X2=1.431 $Y2=0.1035
r8 69 246 1.96775 $w=1.63333e-08 $l=1.35e-08 $layer=M1 $thickness=3.6e-08
+ $X=1.431 $Y=0.072 $X2=1.4175 $Y2=0.072
r9 244 242 0.0462963 $w=5.4e-08 $l=2.5e-09 $layer=N_src_drn $thickness=1e-09
+ $X=1.3133 $Y=0.054 $X2=1.3105 $Y2=0.054
r10 11 242 0.268519 $w=5.4e-08 $l=1.45e-08 $layer=N_src_drn $thickness=1e-09
+ $X=1.296 $Y=0.054 $X2=1.3105 $Y2=0.054
r11 48 11 0.268519 $w=5.4e-08 $l=1.45e-08 $layer=N_src_drn $thickness=1e-09
+ $X=1.2815 $Y=0.054 $X2=1.296 $Y2=0.054
r12 243 48 0.0462963 $w=5.4e-08 $l=2.5e-09 $layer=N_src_drn $thickness=1e-09
+ $X=1.2786 $Y=0.054 $X2=1.2815 $Y2=0.054
r13 240 238 0.0462963 $w=5.4e-08 $l=2.5e-09 $layer=P_src_drn $thickness=1e-09
+ $X=1.4213 $Y=0.216 $X2=1.4185 $Y2=0.216
r14 229 238 0.268519 $w=5.4e-08 $l=1.45e-08 $layer=P_src_drn $thickness=1e-09
+ $X=1.404 $Y=0.216 $X2=1.4185 $Y2=0.216
r15 56 229 0.268519 $w=5.4e-08 $l=1.45e-08 $layer=P_src_drn $thickness=1e-09
+ $X=1.3895 $Y=0.216 $X2=1.404 $Y2=0.216
r16 239 56 0.0462963 $w=5.4e-08 $l=2.5e-09 $layer=P_src_drn $thickness=1e-09
+ $X=1.3866 $Y=0.216 $X2=1.3895 $Y2=0.216
r17 235 236 7.34548 $w=1.3e-08 $l=3.15e-08 $layer=M1 $thickness=3.6e-08
+ $X=1.431 $Y=0.135 $X2=1.431 $Y2=0.1035
r18 83 235 11.5429 $w=1.3e-08 $l=4.95e-08 $layer=M1 $thickness=3.6e-08 $X=1.431
+ $Y=0.1845 $X2=1.431 $Y2=0.135
r19 234 232 0.0462963 $w=5.4e-08 $l=2.5e-09 $layer=P_src_drn $thickness=1e-09
+ $X=1.3133 $Y=0.216 $X2=1.3105 $Y2=0.216
r20 228 232 0.268519 $w=5.4e-08 $l=1.45e-08 $layer=P_src_drn $thickness=1e-09
+ $X=1.296 $Y=0.216 $X2=1.3105 $Y2=0.216
r21 55 228 0.268519 $w=5.4e-08 $l=1.45e-08 $layer=P_src_drn $thickness=1e-09
+ $X=1.2815 $Y=0.216 $X2=1.296 $Y2=0.216
r22 233 55 0.0462963 $w=5.4e-08 $l=2.5e-09 $layer=P_src_drn $thickness=1e-09
+ $X=1.2786 $Y=0.216 $X2=1.2815 $Y2=0.216
r23 11 225 19.3796 $a=3.24e-16 $layer=V0LISD $X=1.296 $Y=0.054 $X2=1.2955
+ $Y2=0.072
r24 14 229 23.8708 $w=2.02e-08 $l=4.05e-08 $layer=LISD $thickness=2.7e-08
+ $X=1.404 $Y=0.1755 $X2=1.404 $Y2=0.216
r25 70 219 1.49895 $w=1.63333e-08 $l=1.35e-08 $layer=M1 $thickness=3.6e-08
+ $X=1.431 $Y=0.234 $X2=1.4175 $Y2=0.234
r26 70 83 9.89378 $w=1.47818e-08 $l=4.95e-08 $layer=M1 $thickness=3.6e-08
+ $X=1.431 $Y=0.234 $X2=1.431 $Y2=0.1845
r27 12 228 23.8708 $w=2.02e-08 $l=4.05e-08 $layer=LISD $thickness=2.7e-08
+ $X=1.296 $Y=0.1755 $X2=1.296 $Y2=0.216
r28 224 225 3.03147 $w=1.3e-08 $l=1.3e-08 $layer=M1 $thickness=3.6e-08
+ $X=1.2825 $Y=0.072 $X2=1.2955 $Y2=0.072
r29 67 213 1.96775 $w=1.63333e-08 $l=1.35e-08 $layer=M1 $thickness=3.6e-08
+ $X=1.269 $Y=0.072 $X2=1.269 $Y2=0.0855
r30 67 224 1.96775 $w=1.63333e-08 $l=1.35e-08 $layer=M1 $thickness=3.6e-08
+ $X=1.269 $Y=0.072 $X2=1.2825 $Y2=0.072
r31 223 221 0.0462963 $w=5.4e-08 $l=2.5e-09 $layer=N_src_drn $thickness=1e-09
+ $X=0.9893 $Y=0.054 $X2=0.9865 $Y2=0.054
r32 9 221 0.268519 $w=5.4e-08 $l=1.45e-08 $layer=N_src_drn $thickness=1e-09
+ $X=0.972 $Y=0.054 $X2=0.9865 $Y2=0.054
r33 47 9 0.268519 $w=5.4e-08 $l=1.45e-08 $layer=N_src_drn $thickness=1e-09
+ $X=0.9575 $Y=0.054 $X2=0.972 $Y2=0.054
r34 222 47 0.0462963 $w=5.4e-08 $l=2.5e-09 $layer=N_src_drn $thickness=1e-09
+ $X=0.9546 $Y=0.054 $X2=0.9575 $Y2=0.054
r35 218 219 2.91487 $w=1.3e-08 $l=1.25e-08 $layer=M1 $thickness=3.6e-08
+ $X=1.405 $Y=0.234 $X2=1.4175 $Y2=0.234
r36 218 229 19.3796 $a=3.24e-16 $layer=V0LISD $X=1.405 $Y=0.234 $X2=1.404
+ $Y2=0.216
r37 217 218 2.09871 $w=1.3e-08 $l=9e-09 $layer=M1 $thickness=3.6e-08 $X=1.396
+ $Y=0.234 $X2=1.405 $Y2=0.234
r38 216 217 10.7267 $w=1.3e-08 $l=4.6e-08 $layer=M1 $thickness=3.6e-08 $X=1.35
+ $Y=0.234 $X2=1.396 $Y2=0.234
r39 215 216 10.6101 $w=1.3e-08 $l=4.55e-08 $layer=M1 $thickness=3.6e-08
+ $X=1.3045 $Y=0.234 $X2=1.35 $Y2=0.234
r40 214 215 2.09871 $w=1.3e-08 $l=9e-09 $layer=M1 $thickness=3.6e-08 $X=1.2955
+ $Y=0.234 $X2=1.3045 $Y2=0.234
r41 214 228 19.3796 $a=3.24e-16 $layer=V0LISD $X=1.2955 $Y=0.234 $X2=1.296
+ $Y2=0.216
r42 82 214 3.03147 $w=1.3e-08 $l=1.3e-08 $layer=M1 $thickness=3.6e-08 $X=1.2825
+ $Y=0.234 $X2=1.2955 $Y2=0.234
r43 212 213 3.14806 $w=1.3e-08 $l=1.35e-08 $layer=M1 $thickness=3.6e-08
+ $X=1.269 $Y=0.099 $X2=1.269 $Y2=0.0855
r44 211 212 4.19742 $w=1.3e-08 $l=1.8e-08 $layer=M1 $thickness=3.6e-08 $X=1.269
+ $Y=0.117 $X2=1.269 $Y2=0.099
r45 210 211 4.19742 $w=1.3e-08 $l=1.8e-08 $layer=M1 $thickness=3.6e-08 $X=1.269
+ $Y=0.135 $X2=1.269 $Y2=0.117
r46 209 210 4.19742 $w=1.3e-08 $l=1.8e-08 $layer=M1 $thickness=3.6e-08 $X=1.269
+ $Y=0.153 $X2=1.269 $Y2=0.135
r47 208 209 4.19742 $w=1.3e-08 $l=1.8e-08 $layer=M1 $thickness=3.6e-08 $X=1.269
+ $Y=0.171 $X2=1.269 $Y2=0.153
r48 81 208 7.34548 $w=1.3e-08 $l=3.15e-08 $layer=M1 $thickness=3.6e-08 $X=1.269
+ $Y=0.2025 $X2=1.269 $Y2=0.171
r49 9 203 19.3796 $a=3.24e-16 $layer=V0LISD $X=0.972 $Y=0.054 $X2=0.9725
+ $Y2=0.072
r50 68 194 5.81538 $w=1.45e-08 $l=3e-08 $layer=M1 $thickness=3.6e-08 $X=1.269
+ $Y=0.234 $X2=1.239 $Y2=0.234
r51 68 81 6.16517 $w=1.44286e-08 $l=3.15e-08 $layer=M1 $thickness=3.6e-08
+ $X=1.269 $Y=0.234 $X2=1.269 $Y2=0.2025
r52 68 82 1.96775 $w=1.63333e-08 $l=1.35e-08 $layer=M1 $thickness=3.6e-08
+ $X=1.269 $Y=0.234 $X2=1.2825 $Y2=0.234
r53 203 204 3.03147 $w=1.3e-08 $l=1.3e-08 $layer=M1 $thickness=3.6e-08
+ $X=0.9725 $Y=0.072 $X2=0.9855 $Y2=0.072
r54 65 190 1.96775 $w=1.63333e-08 $l=1.35e-08 $layer=M1 $thickness=3.6e-08
+ $X=0.999 $Y=0.072 $X2=0.999 $Y2=0.0855
r55 65 204 1.96775 $w=1.63333e-08 $l=1.35e-08 $layer=M1 $thickness=3.6e-08
+ $X=0.999 $Y=0.072 $X2=0.9855 $Y2=0.072
r56 202 200 0.0462963 $w=5.4e-08 $l=2.5e-09 $layer=N_src_drn $thickness=1e-09
+ $X=0.8813 $Y=0.054 $X2=0.8785 $Y2=0.054
r57 7 200 0.268519 $w=5.4e-08 $l=1.45e-08 $layer=N_src_drn $thickness=1e-09
+ $X=0.864 $Y=0.054 $X2=0.8785 $Y2=0.054
r58 46 7 0.268519 $w=5.4e-08 $l=1.45e-08 $layer=N_src_drn $thickness=1e-09
+ $X=0.8495 $Y=0.054 $X2=0.864 $Y2=0.054
r59 201 46 0.0462963 $w=5.4e-08 $l=2.5e-09 $layer=N_src_drn $thickness=1e-09
+ $X=0.8466 $Y=0.054 $X2=0.8495 $Y2=0.054
r60 198 196 0.0462963 $w=5.4e-08 $l=2.5e-09 $layer=P_src_drn $thickness=1e-09
+ $X=0.9893 $Y=0.216 $X2=0.9865 $Y2=0.216
r61 179 196 0.268519 $w=5.4e-08 $l=1.45e-08 $layer=P_src_drn $thickness=1e-09
+ $X=0.972 $Y=0.216 $X2=0.9865 $Y2=0.216
r62 54 179 0.268519 $w=5.4e-08 $l=1.45e-08 $layer=P_src_drn $thickness=1e-09
+ $X=0.9575 $Y=0.216 $X2=0.972 $Y2=0.216
r63 197 54 0.0462963 $w=5.4e-08 $l=2.5e-09 $layer=P_src_drn $thickness=1e-09
+ $X=0.9546 $Y=0.216 $X2=0.9575 $Y2=0.216
r64 193 194 6.06293 $w=1.3e-08 $l=2.6e-08 $layer=M1 $thickness=3.6e-08 $X=1.213
+ $Y=0.234 $X2=1.239 $Y2=0.234
r65 192 193 1.86552 $w=1.3e-08 $l=8e-09 $layer=M1 $thickness=3.6e-08 $X=1.205
+ $Y=0.234 $X2=1.213 $Y2=0.234
r66 191 192 18.7718 $w=1.3e-08 $l=8.05e-08 $layer=M1 $thickness=3.6e-08
+ $X=1.1245 $Y=0.234 $X2=1.205 $Y2=0.234
r67 80 191 22.6194 $w=1.3e-08 $l=9.7e-08 $layer=M1 $thickness=3.6e-08 $X=1.0275
+ $Y=0.234 $X2=1.1245 $Y2=0.234
r68 189 190 3.14806 $w=1.3e-08 $l=1.35e-08 $layer=M1 $thickness=3.6e-08
+ $X=0.999 $Y=0.099 $X2=0.999 $Y2=0.0855
r69 188 189 4.19742 $w=1.3e-08 $l=1.8e-08 $layer=M1 $thickness=3.6e-08 $X=0.999
+ $Y=0.117 $X2=0.999 $Y2=0.099
r70 187 188 4.19742 $w=1.3e-08 $l=1.8e-08 $layer=M1 $thickness=3.6e-08 $X=0.999
+ $Y=0.135 $X2=0.999 $Y2=0.117
r71 186 187 4.19742 $w=1.3e-08 $l=1.8e-08 $layer=M1 $thickness=3.6e-08 $X=0.999
+ $Y=0.153 $X2=0.999 $Y2=0.135
r72 185 186 4.19742 $w=1.3e-08 $l=1.8e-08 $layer=M1 $thickness=3.6e-08 $X=0.999
+ $Y=0.171 $X2=0.999 $Y2=0.153
r73 79 185 7.34548 $w=1.3e-08 $l=3.15e-08 $layer=M1 $thickness=3.6e-08 $X=0.999
+ $Y=0.2025 $X2=0.999 $Y2=0.171
r74 184 182 0.0462963 $w=5.4e-08 $l=2.5e-09 $layer=P_src_drn $thickness=1e-09
+ $X=0.8813 $Y=0.216 $X2=0.8785 $Y2=0.216
r75 178 182 0.268519 $w=5.4e-08 $l=1.45e-08 $layer=P_src_drn $thickness=1e-09
+ $X=0.864 $Y=0.216 $X2=0.8785 $Y2=0.216
r76 53 178 0.268519 $w=5.4e-08 $l=1.45e-08 $layer=P_src_drn $thickness=1e-09
+ $X=0.8495 $Y=0.216 $X2=0.864 $Y2=0.216
r77 183 53 0.0462963 $w=5.4e-08 $l=2.5e-09 $layer=P_src_drn $thickness=1e-09
+ $X=0.8466 $Y=0.216 $X2=0.8495 $Y2=0.216
r78 7 175 19.3796 $a=3.24e-16 $layer=V0LISD $X=0.864 $Y=0.054 $X2=0.8635
+ $Y2=0.072
r79 10 179 23.8708 $w=2.02e-08 $l=4.05e-08 $layer=LISD $thickness=2.7e-08
+ $X=0.972 $Y=0.1755 $X2=0.972 $Y2=0.216
r80 66 169 1.96775 $w=1.63333e-08 $l=1.35e-08 $layer=M1 $thickness=3.6e-08
+ $X=0.999 $Y=0.234 $X2=0.9855 $Y2=0.234
r81 66 79 6.16517 $w=1.44286e-08 $l=3.15e-08 $layer=M1 $thickness=3.6e-08
+ $X=0.999 $Y=0.234 $X2=0.999 $Y2=0.2025
r82 66 80 5.4656 $w=1.45789e-08 $l=2.85e-08 $layer=M1 $thickness=3.6e-08
+ $X=0.999 $Y=0.234 $X2=1.0275 $Y2=0.234
r83 8 178 23.8708 $w=2.02e-08 $l=4.05e-08 $layer=LISD $thickness=2.7e-08
+ $X=0.864 $Y=0.1755 $X2=0.864 $Y2=0.216
r84 174 175 3.03147 $w=1.3e-08 $l=1.3e-08 $layer=M1 $thickness=3.6e-08
+ $X=0.8505 $Y=0.072 $X2=0.8635 $Y2=0.072
r85 63 163 1.96775 $w=1.63333e-08 $l=1.35e-08 $layer=M1 $thickness=3.6e-08
+ $X=0.837 $Y=0.072 $X2=0.837 $Y2=0.0855
r86 63 174 1.96775 $w=1.63333e-08 $l=1.35e-08 $layer=M1 $thickness=3.6e-08
+ $X=0.837 $Y=0.072 $X2=0.8505 $Y2=0.072
r87 173 171 0.0462963 $w=5.4e-08 $l=2.5e-09 $layer=N_src_drn $thickness=1e-09
+ $X=0.5573 $Y=0.054 $X2=0.5545 $Y2=0.054
r88 5 171 0.268519 $w=5.4e-08 $l=1.45e-08 $layer=N_src_drn $thickness=1e-09
+ $X=0.54 $Y=0.054 $X2=0.5545 $Y2=0.054
r89 45 5 0.268519 $w=5.4e-08 $l=1.45e-08 $layer=N_src_drn $thickness=1e-09
+ $X=0.5255 $Y=0.054 $X2=0.54 $Y2=0.054
r90 172 45 0.0462963 $w=5.4e-08 $l=2.5e-09 $layer=N_src_drn $thickness=1e-09
+ $X=0.5226 $Y=0.054 $X2=0.5255 $Y2=0.054
r91 168 169 3.03147 $w=1.3e-08 $l=1.3e-08 $layer=M1 $thickness=3.6e-08
+ $X=0.9725 $Y=0.234 $X2=0.9855 $Y2=0.234
r92 168 179 19.3796 $a=3.24e-16 $layer=V0LISD $X=0.9725 $Y=0.234 $X2=0.972
+ $Y2=0.216
r93 167 168 2.09871 $w=1.3e-08 $l=9e-09 $layer=M1 $thickness=3.6e-08 $X=0.9635
+ $Y=0.234 $X2=0.9725 $Y2=0.234
r94 166 167 10.6101 $w=1.3e-08 $l=4.55e-08 $layer=M1 $thickness=3.6e-08
+ $X=0.918 $Y=0.234 $X2=0.9635 $Y2=0.234
r95 165 166 10.6101 $w=1.3e-08 $l=4.55e-08 $layer=M1 $thickness=3.6e-08
+ $X=0.8725 $Y=0.234 $X2=0.918 $Y2=0.234
r96 164 165 2.09871 $w=1.3e-08 $l=9e-09 $layer=M1 $thickness=3.6e-08 $X=0.8635
+ $Y=0.234 $X2=0.8725 $Y2=0.234
r97 164 178 19.3796 $a=3.24e-16 $layer=V0LISD $X=0.8635 $Y=0.234 $X2=0.864
+ $Y2=0.216
r98 78 164 3.03147 $w=1.3e-08 $l=1.3e-08 $layer=M1 $thickness=3.6e-08 $X=0.8505
+ $Y=0.234 $X2=0.8635 $Y2=0.234
r99 162 163 3.14806 $w=1.3e-08 $l=1.35e-08 $layer=M1 $thickness=3.6e-08
+ $X=0.837 $Y=0.099 $X2=0.837 $Y2=0.0855
r100 161 162 4.19742 $w=1.3e-08 $l=1.8e-08 $layer=M1 $thickness=3.6e-08
+ $X=0.837 $Y=0.117 $X2=0.837 $Y2=0.099
r101 160 161 4.19742 $w=1.3e-08 $l=1.8e-08 $layer=M1 $thickness=3.6e-08
+ $X=0.837 $Y=0.135 $X2=0.837 $Y2=0.117
r102 159 160 4.19742 $w=1.3e-08 $l=1.8e-08 $layer=M1 $thickness=3.6e-08
+ $X=0.837 $Y=0.153 $X2=0.837 $Y2=0.135
r103 158 159 4.19742 $w=1.3e-08 $l=1.8e-08 $layer=M1 $thickness=3.6e-08
+ $X=0.837 $Y=0.171 $X2=0.837 $Y2=0.153
r104 77 158 7.34548 $w=1.3e-08 $l=3.15e-08 $layer=M1 $thickness=3.6e-08
+ $X=0.837 $Y=0.2025 $X2=0.837 $Y2=0.171
r105 5 154 19.3796 $a=3.24e-16 $layer=V0LISD $X=0.54 $Y=0.054 $X2=0.54 $Y2=0.072
r106 64 145 5.4656 $w=1.45789e-08 $l=2.85e-08 $layer=M1 $thickness=3.6e-08
+ $X=0.837 $Y=0.234 $X2=0.8085 $Y2=0.234
r107 64 77 6.16517 $w=1.44286e-08 $l=3.15e-08 $layer=M1 $thickness=3.6e-08
+ $X=0.837 $Y=0.234 $X2=0.837 $Y2=0.2025
r108 64 78 1.96775 $w=1.63333e-08 $l=1.35e-08 $layer=M1 $thickness=3.6e-08
+ $X=0.837 $Y=0.234 $X2=0.8505 $Y2=0.234
r109 154 155 3.14806 $w=1.3e-08 $l=1.35e-08 $layer=M1 $thickness=3.6e-08
+ $X=0.54 $Y=0.072 $X2=0.5535 $Y2=0.072
r110 61 141 1.96775 $w=1.63333e-08 $l=1.35e-08 $layer=M1 $thickness=3.6e-08
+ $X=0.567 $Y=0.072 $X2=0.567 $Y2=0.0855
r111 61 155 1.96775 $w=1.63333e-08 $l=1.35e-08 $layer=M1 $thickness=3.6e-08
+ $X=0.567 $Y=0.072 $X2=0.5535 $Y2=0.072
r112 153 151 0.0462963 $w=5.4e-08 $l=2.5e-09 $layer=N_src_drn $thickness=1e-09
+ $X=0.4493 $Y=0.054 $X2=0.4465 $Y2=0.054
r113 3 151 0.268519 $w=5.4e-08 $l=1.45e-08 $layer=N_src_drn $thickness=1e-09
+ $X=0.432 $Y=0.054 $X2=0.4465 $Y2=0.054
r114 44 3 0.268519 $w=5.4e-08 $l=1.45e-08 $layer=N_src_drn $thickness=1e-09
+ $X=0.4175 $Y=0.054 $X2=0.432 $Y2=0.054
r115 152 44 0.0462963 $w=5.4e-08 $l=2.5e-09 $layer=N_src_drn $thickness=1e-09
+ $X=0.4146 $Y=0.054 $X2=0.4175 $Y2=0.054
r116 149 147 0.0462963 $w=5.4e-08 $l=2.5e-09 $layer=P_src_drn $thickness=1e-09
+ $X=0.5573 $Y=0.216 $X2=0.5545 $Y2=0.216
r117 130 147 0.268519 $w=5.4e-08 $l=1.45e-08 $layer=P_src_drn $thickness=1e-09
+ $X=0.54 $Y=0.216 $X2=0.5545 $Y2=0.216
r118 52 130 0.268519 $w=5.4e-08 $l=1.45e-08 $layer=P_src_drn $thickness=1e-09
+ $X=0.5255 $Y=0.216 $X2=0.54 $Y2=0.216
r119 148 52 0.0462963 $w=5.4e-08 $l=2.5e-09 $layer=P_src_drn $thickness=1e-09
+ $X=0.5226 $Y=0.216 $X2=0.5255 $Y2=0.216
r120 144 145 22.6194 $w=1.3e-08 $l=9.7e-08 $layer=M1 $thickness=3.6e-08
+ $X=0.7115 $Y=0.234 $X2=0.8085 $Y2=0.234
r121 143 144 18.7718 $w=1.3e-08 $l=8.05e-08 $layer=M1 $thickness=3.6e-08
+ $X=0.631 $Y=0.234 $X2=0.7115 $Y2=0.234
r122 142 143 1.86552 $w=1.3e-08 $l=8e-09 $layer=M1 $thickness=3.6e-08 $X=0.623
+ $Y=0.234 $X2=0.631 $Y2=0.234
r123 76 142 6.06293 $w=1.3e-08 $l=2.6e-08 $layer=M1 $thickness=3.6e-08 $X=0.597
+ $Y=0.234 $X2=0.623 $Y2=0.234
r124 140 141 3.14806 $w=1.3e-08 $l=1.35e-08 $layer=M1 $thickness=3.6e-08
+ $X=0.567 $Y=0.099 $X2=0.567 $Y2=0.0855
r125 139 140 4.19742 $w=1.3e-08 $l=1.8e-08 $layer=M1 $thickness=3.6e-08
+ $X=0.567 $Y=0.117 $X2=0.567 $Y2=0.099
r126 138 139 4.19742 $w=1.3e-08 $l=1.8e-08 $layer=M1 $thickness=3.6e-08
+ $X=0.567 $Y=0.135 $X2=0.567 $Y2=0.117
r127 137 138 4.19742 $w=1.3e-08 $l=1.8e-08 $layer=M1 $thickness=3.6e-08
+ $X=0.567 $Y=0.153 $X2=0.567 $Y2=0.135
r128 136 137 4.19742 $w=1.3e-08 $l=1.8e-08 $layer=M1 $thickness=3.6e-08
+ $X=0.567 $Y=0.171 $X2=0.567 $Y2=0.153
r129 75 136 7.34548 $w=1.3e-08 $l=3.15e-08 $layer=M1 $thickness=3.6e-08
+ $X=0.567 $Y=0.2025 $X2=0.567 $Y2=0.171
r130 135 133 0.0462963 $w=5.4e-08 $l=2.5e-09 $layer=P_src_drn $thickness=1e-09
+ $X=0.4493 $Y=0.216 $X2=0.4465 $Y2=0.216
r131 129 133 0.268519 $w=5.4e-08 $l=1.45e-08 $layer=P_src_drn $thickness=1e-09
+ $X=0.432 $Y=0.216 $X2=0.4465 $Y2=0.216
r132 51 129 0.268519 $w=5.4e-08 $l=1.45e-08 $layer=P_src_drn $thickness=1e-09
+ $X=0.4175 $Y=0.216 $X2=0.432 $Y2=0.216
r133 134 51 0.0462963 $w=5.4e-08 $l=2.5e-09 $layer=P_src_drn $thickness=1e-09
+ $X=0.4146 $Y=0.216 $X2=0.4175 $Y2=0.216
r134 3 126 19.3796 $a=3.24e-16 $layer=V0LISD $X=0.432 $Y=0.054 $X2=0.431
+ $Y2=0.072
r135 6 130 23.8708 $w=2.02e-08 $l=4.05e-08 $layer=LISD $thickness=2.7e-08
+ $X=0.54 $Y=0.1755 $X2=0.54 $Y2=0.216
r136 62 124 1.96775 $w=1.63333e-08 $l=1.35e-08 $layer=M1 $thickness=3.6e-08
+ $X=0.567 $Y=0.234 $X2=0.5535 $Y2=0.234
r137 62 75 6.16517 $w=1.44286e-08 $l=3.15e-08 $layer=M1 $thickness=3.6e-08
+ $X=0.567 $Y=0.234 $X2=0.567 $Y2=0.2025
r138 62 76 5.81538 $w=1.45e-08 $l=3e-08 $layer=M1 $thickness=3.6e-08 $X=0.567
+ $Y=0.234 $X2=0.597 $Y2=0.234
r139 4 129 23.8708 $w=2.02e-08 $l=4.05e-08 $layer=LISD $thickness=2.7e-08
+ $X=0.432 $Y=0.1755 $X2=0.432 $Y2=0.216
r140 125 126 2.91487 $w=1.3e-08 $l=1.25e-08 $layer=M1 $thickness=3.6e-08
+ $X=0.4185 $Y=0.072 $X2=0.431 $Y2=0.072
r141 59 119 1.96775 $w=1.63333e-08 $l=1.35e-08 $layer=M1 $thickness=3.6e-08
+ $X=0.405 $Y=0.072 $X2=0.405 $Y2=0.0855
r142 59 125 1.96775 $w=1.63333e-08 $l=1.35e-08 $layer=M1 $thickness=3.6e-08
+ $X=0.405 $Y=0.072 $X2=0.4185 $Y2=0.072
r143 123 124 3.14806 $w=1.3e-08 $l=1.35e-08 $layer=M1 $thickness=3.6e-08
+ $X=0.54 $Y=0.234 $X2=0.5535 $Y2=0.234
r144 123 130 19.3796 $a=3.24e-16 $layer=V0LISD $X=0.54 $Y=0.234 $X2=0.54
+ $Y2=0.216
r145 122 123 12.5922 $w=1.3e-08 $l=5.4e-08 $layer=M1 $thickness=3.6e-08
+ $X=0.486 $Y=0.234 $X2=0.54 $Y2=0.234
r146 121 122 10.7267 $w=1.3e-08 $l=4.6e-08 $layer=M1 $thickness=3.6e-08 $X=0.44
+ $Y=0.234 $X2=0.486 $Y2=0.234
r147 120 121 2.09871 $w=1.3e-08 $l=9e-09 $layer=M1 $thickness=3.6e-08 $X=0.431
+ $Y=0.234 $X2=0.44 $Y2=0.234
r148 120 129 19.3796 $a=3.24e-16 $layer=V0LISD $X=0.431 $Y=0.234 $X2=0.432
+ $Y2=0.216
r149 74 120 2.91487 $w=1.3e-08 $l=1.25e-08 $layer=M1 $thickness=3.6e-08
+ $X=0.4185 $Y=0.234 $X2=0.431 $Y2=0.234
r150 118 119 3.14806 $w=1.3e-08 $l=1.35e-08 $layer=M1 $thickness=3.6e-08
+ $X=0.405 $Y=0.099 $X2=0.405 $Y2=0.0855
r151 117 118 4.19742 $w=1.3e-08 $l=1.8e-08 $layer=M1 $thickness=3.6e-08
+ $X=0.405 $Y=0.117 $X2=0.405 $Y2=0.099
r152 116 117 4.19742 $w=1.3e-08 $l=1.8e-08 $layer=M1 $thickness=3.6e-08
+ $X=0.405 $Y=0.135 $X2=0.405 $Y2=0.117
r153 115 116 4.19742 $w=1.3e-08 $l=1.8e-08 $layer=M1 $thickness=3.6e-08
+ $X=0.405 $Y=0.153 $X2=0.405 $Y2=0.135
r154 114 115 4.19742 $w=1.3e-08 $l=1.8e-08 $layer=M1 $thickness=3.6e-08
+ $X=0.405 $Y=0.171 $X2=0.405 $Y2=0.153
r155 73 114 7.34548 $w=1.3e-08 $l=3.15e-08 $layer=M1 $thickness=3.6e-08
+ $X=0.405 $Y=0.2025 $X2=0.405 $Y2=0.171
r156 113 111 0.0462963 $w=5.4e-08 $l=2.5e-09 $layer=P_src_drn $thickness=1e-09
+ $X=0.1253 $Y=0.216 $X2=0.1225 $Y2=0.216
r157 109 111 0.268519 $w=5.4e-08 $l=1.45e-08 $layer=P_src_drn $thickness=1e-09
+ $X=0.108 $Y=0.216 $X2=0.1225 $Y2=0.216
r158 50 109 0.268519 $w=5.4e-08 $l=1.45e-08 $layer=P_src_drn $thickness=1e-09
+ $X=0.0935 $Y=0.216 $X2=0.108 $Y2=0.216
r159 112 50 0.0462963 $w=5.4e-08 $l=2.5e-09 $layer=P_src_drn $thickness=1e-09
+ $X=0.0906 $Y=0.216 $X2=0.0935 $Y2=0.216
r160 60 108 5.4656 $w=1.45789e-08 $l=2.85e-08 $layer=M1 $thickness=3.6e-08
+ $X=0.405 $Y=0.234 $X2=0.3765 $Y2=0.234
r161 60 73 6.16517 $w=1.44286e-08 $l=3.15e-08 $layer=M1 $thickness=3.6e-08
+ $X=0.405 $Y=0.234 $X2=0.405 $Y2=0.2025
r162 60 74 1.96775 $w=1.63333e-08 $l=1.35e-08 $layer=M1 $thickness=3.6e-08
+ $X=0.405 $Y=0.234 $X2=0.4185 $Y2=0.234
r163 2 109 23.8708 $w=2.02e-08 $l=4.05e-08 $layer=LISD $thickness=2.7e-08
+ $X=0.108 $Y=0.1755 $X2=0.108 $Y2=0.216
r164 107 108 22.6194 $w=1.3e-08 $l=9.7e-08 $layer=M1 $thickness=3.6e-08
+ $X=0.2795 $Y=0.234 $X2=0.3765 $Y2=0.234
r165 106 107 18.7718 $w=1.3e-08 $l=8.05e-08 $layer=M1 $thickness=3.6e-08
+ $X=0.199 $Y=0.234 $X2=0.2795 $Y2=0.234
r166 105 106 1.86552 $w=1.3e-08 $l=8e-09 $layer=M1 $thickness=3.6e-08 $X=0.191
+ $Y=0.234 $X2=0.199 $Y2=0.234
r167 72 105 6.06293 $w=1.3e-08 $l=2.6e-08 $layer=M1 $thickness=3.6e-08 $X=0.165
+ $Y=0.234 $X2=0.191 $Y2=0.234
r168 101 102 3.03147 $w=1.3e-08 $l=1.3e-08 $layer=M1 $thickness=3.6e-08
+ $X=0.1085 $Y=0.234 $X2=0.1215 $Y2=0.234
r169 101 109 19.3796 $a=3.24e-16 $layer=V0LISD $X=0.1085 $Y=0.234 $X2=0.108
+ $Y2=0.216
r170 58 100 2.60903 $w=1.57692e-08 $l=1.63e-08 $layer=M1 $thickness=3.6e-08
+ $X=0.135 $Y=0.234 $X2=0.135 $Y2=0.2177
r171 58 102 1.96775 $w=1.63333e-08 $l=1.35e-08 $layer=M1 $thickness=3.6e-08
+ $X=0.135 $Y=0.234 $X2=0.1215 $Y2=0.234
r172 58 72 5.81538 $w=1.45e-08 $l=3e-08 $layer=M1 $thickness=3.6e-08 $X=0.135
+ $Y=0.234 $X2=0.165 $Y2=0.234
r173 99 100 1.80722 $w=1.3e-08 $l=7.7e-09 $layer=M1 $thickness=3.6e-08 $X=0.135
+ $Y=0.21 $X2=0.135 $Y2=0.2177
r174 99 98 3.55614 $w=1.3e-08 $l=1.53e-08 $layer=M1 $thickness=3.6e-08 $X=0.135
+ $Y=0.21 $X2=0.135 $Y2=0.1947
r175 97 98 5.53826 $w=1.3e-08 $l=2.37e-08 $layer=M1 $thickness=3.6e-08 $X=0.135
+ $Y=0.171 $X2=0.135 $Y2=0.1947
r176 96 97 4.19742 $w=1.3e-08 $l=1.8e-08 $layer=M1 $thickness=3.6e-08 $X=0.135
+ $Y=0.153 $X2=0.135 $Y2=0.171
r177 95 96 4.19742 $w=1.3e-08 $l=1.8e-08 $layer=M1 $thickness=3.6e-08 $X=0.135
+ $Y=0.135 $X2=0.135 $Y2=0.153
r178 94 95 4.19742 $w=1.3e-08 $l=1.8e-08 $layer=M1 $thickness=3.6e-08 $X=0.135
+ $Y=0.117 $X2=0.135 $Y2=0.135
r179 93 94 4.19742 $w=1.3e-08 $l=1.8e-08 $layer=M1 $thickness=3.6e-08 $X=0.135
+ $Y=0.099 $X2=0.135 $Y2=0.117
r180 71 92 1.96775 $w=1.63333e-08 $l=1.35e-08 $layer=M1 $thickness=3.6e-08
+ $X=0.135 $Y=0.0855 $X2=0.135 $Y2=0.072
r181 71 93 3.14806 $w=1.3e-08 $l=1.35e-08 $layer=M1 $thickness=3.6e-08 $X=0.135
+ $Y=0.0855 $X2=0.135 $Y2=0.099
r182 91 92 1.96775 $w=1.63333e-08 $l=1.35e-08 $layer=M1 $thickness=3.6e-08
+ $X=0.1215 $Y=0.072 $X2=0.135 $Y2=0.072
r183 90 91 3.03147 $w=1.3e-08 $l=1.3e-08 $layer=M1 $thickness=3.6e-08 $X=0.1085
+ $Y=0.072 $X2=0.1215 $Y2=0.072
r184 89 90 2.09871 $w=1.3e-08 $l=9e-09 $layer=M1 $thickness=3.6e-08 $X=0.0995
+ $Y=0.072 $X2=0.1085 $Y2=0.072
r185 57 89 0.699569 $w=1.3e-08 $l=3e-09 $layer=M1 $thickness=3.6e-08 $X=0.0965
+ $Y=0.072 $X2=0.0995 $Y2=0.072
r186 1 90 19.3796 $a=3.24e-16 $layer=V0LISD $X=0.108 $Y=0.054 $X2=0.1085
+ $Y2=0.072
r187 87 85 0.0462963 $w=5.4e-08 $l=2.5e-09 $layer=N_src_drn $thickness=1e-09
+ $X=0.1253 $Y=0.054 $X2=0.1225 $Y2=0.054
r188 1 85 0.268519 $w=5.4e-08 $l=1.45e-08 $layer=N_src_drn $thickness=1e-09
+ $X=0.108 $Y=0.054 $X2=0.1225 $Y2=0.054
r189 43 1 0.268519 $w=5.4e-08 $l=1.45e-08 $layer=N_src_drn $thickness=1e-09
+ $X=0.0935 $Y=0.054 $X2=0.108 $Y2=0.054
r190 86 43 0.0462963 $w=5.4e-08 $l=2.5e-09 $layer=N_src_drn $thickness=1e-09
+ $X=0.0906 $Y=0.054 $X2=0.0935 $Y2=0.054
.ends

.subckt PM_CKINVDCx9p33_ASAP7_75t_R%9 vss 19 23 33 36 46 47 50 51 18 4 15 1 9
+ 12 16 14 10
c1 1 vss 0.00633493f $X=0.189 $Y=0.135
c2 3 vss 0.00715958f $X=0.216 $Y=0.0675
c3 4 vss 0.00721703f $X=0.324 $Y=0.0675
c4 9 vss 0.0843575f $X=0.189 $Y=0.0245
c5 10 vss 0.0822568f $X=0.243 $Y=0.135
c6 11 vss 0.00655378f $X=0.2015 $Y=0.0675
c7 12 vss 0.00701698f $X=0.3095 $Y=0.0675
c8 13 vss 0.000349338f $X=0.243 $Y=0.099
c9 14 vss 0.000208263f $X=0.243 $Y=0.135
c10 15 vss 0.00130851f $X=0.2015 $Y=0.099
c11 16 vss 0.000624933f $X=0.199 $Y=0.135
c12 17 vss 0.000149608f $X=0.243 $Y=0.117
c13 18 vss 0.00245465f $X=0.27 $Y=0.099
r1 51 49 0.0308642 $w=8.1e-08 $l=2.5e-09 $layer=N_src_drn $thickness=1e-09
+ $X=0.3413 $Y=0.0675 $X2=0.3385 $Y2=0.0675
r2 4 49 0.179012 $w=8.1e-08 $l=1.45e-08 $layer=N_src_drn $thickness=1e-09
+ $X=0.324 $Y=0.0675 $X2=0.3385 $Y2=0.0675
r3 12 4 0.179012 $w=8.1e-08 $l=1.45e-08 $layer=N_src_drn $thickness=1e-09
+ $X=0.3095 $Y=0.0675 $X2=0.324 $Y2=0.0675
r4 50 12 0.0308642 $w=8.1e-08 $l=2.5e-09 $layer=N_src_drn $thickness=1e-09
+ $X=0.3066 $Y=0.0675 $X2=0.3095 $Y2=0.0675
r5 47 45 0.0308642 $w=8.1e-08 $l=2.5e-09 $layer=N_src_drn $thickness=1e-09
+ $X=0.2333 $Y=0.0675 $X2=0.2305 $Y2=0.0675
r6 3 45 0.179012 $w=8.1e-08 $l=1.45e-08 $layer=N_src_drn $thickness=1e-09
+ $X=0.216 $Y=0.0675 $X2=0.2305 $Y2=0.0675
r7 11 3 0.179012 $w=8.1e-08 $l=1.45e-08 $layer=N_src_drn $thickness=1e-09
+ $X=0.2015 $Y=0.0675 $X2=0.216 $Y2=0.0675
r8 46 11 0.0308642 $w=8.1e-08 $l=2.5e-09 $layer=N_src_drn $thickness=1e-09
+ $X=0.1986 $Y=0.0675 $X2=0.2015 $Y2=0.0675
r9 4 42 19.3796 $a=3.24e-16 $layer=V0LISD $X=0.324 $Y=0.0675 $X2=0.324 $Y2=0.099
r10 3 38 19.3796 $a=3.24e-16 $layer=V0LISD $X=0.216 $Y=0.0675 $X2=0.216
+ $Y2=0.099
r11 41 42 5.24677 $w=1.3e-08 $l=2.25e-08 $layer=M1 $thickness=3.6e-08 $X=0.3015
+ $Y=0.099 $X2=0.324 $Y2=0.099
r12 18 41 7.34548 $w=1.3e-08 $l=3.15e-08 $layer=M1 $thickness=3.6e-08 $X=0.27
+ $Y=0.099 $X2=0.3015 $Y2=0.099
r13 38 39 3.14806 $w=1.3e-08 $l=1.35e-08 $layer=M1 $thickness=3.6e-08 $X=0.216
+ $Y=0.099 $X2=0.2295 $Y2=0.099
r14 15 38 3.38125 $w=1.3e-08 $l=1.45e-08 $layer=M1 $thickness=3.6e-08 $X=0.2015
+ $Y=0.099 $X2=0.216 $Y2=0.099
r15 13 17 3.01711 $w=1.55e-08 $l=1.8e-08 $layer=M1 $thickness=3.6e-08 $X=0.243
+ $Y=0.099 $X2=0.243 $Y2=0.117
r16 13 39 1.96775 $w=1.63333e-08 $l=1.35e-08 $layer=M1 $thickness=3.6e-08
+ $X=0.243 $Y=0.099 $X2=0.2295 $Y2=0.099
r17 13 18 5.11582 $w=1.46667e-08 $l=2.7e-08 $layer=M1 $thickness=3.6e-08
+ $X=0.243 $Y=0.099 $X2=0.27 $Y2=0.099
r18 14 31 1.49895 $w=1.63333e-08 $l=1.35e-08 $layer=M1 $thickness=3.6e-08
+ $X=0.243 $Y=0.135 $X2=0.2295 $Y2=0.135
r19 14 17 2.5483 $w=1.79e-08 $l=1.8e-08 $layer=M1 $thickness=3.6e-08 $X=0.243
+ $Y=0.135 $X2=0.243 $Y2=0.117
r20 36 35 16.4967 $w=2.1e-08 $l=4.85e-08 $layer=Gate_1 $thickness=5.6e-08
+ $X=0.243 $Y=0.2025 $X2=0.243 $Y2=0.154
r21 33 34 16.4967 $w=2.1e-08 $l=4.85e-08 $layer=Gate_1 $thickness=5.6e-08
+ $X=0.243 $Y=0.0675 $X2=0.243 $Y2=0.116
r22 10 27 6.54019 $w=2.09524e-08 $layer=Gate_1 $thickness=5.21905e-08 $X=0.243
+ $Y=0.135 $X2=0.243 $Y2=0.135
r23 10 34 6.6497 $w=2.04211e-08 $l=1.9e-08 $layer=Gate_1 $thickness=5.6e-08
+ $X=0.243 $Y=0.135 $X2=0.243 $Y2=0.116
r24 10 35 6.6497 $w=2.04211e-08 $l=1.9e-08 $layer=Gate_1 $thickness=5.6e-08
+ $X=0.243 $Y=0.135 $X2=0.243 $Y2=0.154
r25 30 31 3.14806 $w=1.3e-08 $l=1.35e-08 $layer=M1 $thickness=3.6e-08 $X=0.216
+ $Y=0.135 $X2=0.2295 $Y2=0.135
r26 29 30 2.68168 $w=1.3e-08 $l=1.15e-08 $layer=M1 $thickness=3.6e-08 $X=0.2045
+ $Y=0.135 $X2=0.216 $Y2=0.135
r27 16 29 1.28254 $w=1.3e-08 $l=5.5e-09 $layer=M1 $thickness=3.6e-08 $X=0.199
+ $Y=0.135 $X2=0.2045 $Y2=0.135
r28 26 27 12.6539 $w=1.77815e-08 $l=2.7e-08 $layer=LIG $thickness=4.8e-08
+ $X=0.216 $Y=0.135 $X2=0.243 $Y2=0.135
r29 26 30 19.3796 $a=3.24e-16 $layer=V0LIG $X=0.216 $Y=0.135 $X2=0.216 $Y2=0.135
r30 1 21 6.54019 $w=2.09524e-08 $layer=Gate_1 $thickness=5.21905e-08 $X=0.189
+ $Y=0.135 $X2=0.189 $Y2=0.135
r31 1 26 12.6539 $w=1.77815e-08 $l=2.7e-08 $layer=LIG $thickness=4.8e-08
+ $X=0.189 $Y=0.135 $X2=0.216 $Y2=0.135
r32 23 22 16.4967 $w=2.1e-08 $l=4.85e-08 $layer=Gate_1 $thickness=5.6e-08
+ $X=0.189 $Y=0.2025 $X2=0.189 $Y2=0.154
r33 21 22 6.6497 $w=2.04211e-08 $l=1.9e-08 $layer=Gate_1 $thickness=5.6e-08
+ $X=0.189 $Y=0.135 $X2=0.189 $Y2=0.154
r34 20 21 6.6497 $w=2.04211e-08 $l=1.9e-08 $layer=Gate_1 $thickness=5.6e-08
+ $X=0.189 $Y=0.116 $X2=0.189 $Y2=0.135
r35 19 20 16.4967 $w=2.1e-08 $l=4.85e-08 $layer=Gate_1 $thickness=5.6e-08
+ $X=0.189 $Y=0.0675 $X2=0.189 $Y2=0.116
r36 19 9 14.6259 $w=2.1e-08 $l=4.3e-08 $layer=Gate_1 $thickness=5.6e-08
+ $X=0.189 $Y=0.0675 $X2=0.189 $Y2=0.0245
.ends

.subckt PM_CKINVDCx9p33_ASAP7_75t_R%A vss 71 46 52 64 67 120 123 126 129 132
+ 135 138 141 167 170 173 176 179 182 185 188 207 210 213 216 219 222 226 230
+ 27 1 35 13 37 2 14 38 17 41 3 18 42 4 21 22 39 28 30 45 29 32 31 26 15 16 24
+ 33 44 12 20 19 23 25 34 36 43 40
c1 1 vss 0.0130952f $X=0.0765 $Y=0.135
c2 2 vss 0.0222239f $X=0.427 $Y=0.135
c3 3 vss 0.0223678f $X=0.8595 $Y=0.135
c4 4 vss 0.0228347f $X=1.2915 $Y=0.135
c5 12 vss 0.0845153f $X=0.081 $Y=0.0245
c6 13 vss 0.0862546f $X=0.135 $Y=0.135
c7 14 vss 0.0879026f $X=0.405 $Y=0.135
c8 15 vss 0.0640449f $X=0.459 $Y=0.135
c9 16 vss 0.0640372f $X=0.513 $Y=0.135
c10 17 vss 0.0864429f $X=0.567 $Y=0.135
c11 18 vss 0.0878202f $X=0.837 $Y=0.135
c12 19 vss 0.0640372f $X=0.891 $Y=0.135
c13 20 vss 0.0640372f $X=0.945 $Y=0.135
c14 21 vss 0.0878202f $X=0.999 $Y=0.135
c15 22 vss 0.0878202f $X=1.269 $Y=0.135
c16 23 vss 0.0635144f $X=1.323 $Y=0.135
c17 24 vss 0.0634506f $X=1.377 $Y=0.135
c18 25 vss 0.069674f $X=1.431 $Y=0.135
c19 26 vss 0.00610003f $X=0.059 $Y=0.036
c20 27 vss 0.00491737f $X=0.075 $Y=0.135
c21 28 vss 0.00511301f $X=0.485 $Y=0.036
c22 29 vss 0.00304833f $X=0.485 $Y=0.135
c23 30 vss 0.00511371f $X=0.918 $Y=0.036
c24 31 vss 0.00304353f $X=0.918 $Y=0.135
c25 32 vss 0.00351557f $X=1.345 $Y=0.135
c26 33 vss 0.005985f $X=1.345 $Y=0.036
c27 34 vss 0.00693231f $X=0.059 $Y=0.1035
c28 35 vss 0.0396586f $X=0.081 $Y=0.036
c29 36 vss 0.00350239f $X=0.4515 $Y=0.135
c30 37 vss 0.00499912f $X=0.485 $Y=0.054
c31 38 vss 0.0412779f $X=0.51 $Y=0.036
c32 39 vss 0.0035128f $X=0.5035 $Y=0.135
c33 40 vss 0.00351962f $X=0.884 $Y=0.135
c34 41 vss 0.00486141f $X=0.918 $Y=0.054
c35 42 vss 0.0407701f $X=0.9425 $Y=0.036
c36 43 vss 0.00351962f $X=0.9365 $Y=0.135
c37 44 vss 0.00541401f $X=1.345 $Y=0.054
c38 45 vss 0.00355858f $X=1.3665 $Y=0.135
r1 230 229 14.6259 $w=2.1e-08 $l=4.3e-08 $layer=Gate_1 $thickness=5.6e-08
+ $X=1.431 $Y=0.216 $X2=1.431 $Y2=0.173
r2 228 229 7.48304 $w=2.1e-08 $l=2.2e-08 $layer=Gate_1 $thickness=5.6e-08
+ $X=1.431 $Y=0.151 $X2=1.431 $Y2=0.173
r3 226 227 14.6259 $w=2.1e-08 $l=4.3e-08 $layer=Gate_1 $thickness=5.6e-08
+ $X=1.431 $Y=0.054 $X2=1.431 $Y2=0.097
r4 224 227 7.48304 $w=2.1e-08 $l=2.2e-08 $layer=Gate_1 $thickness=5.6e-08
+ $X=1.431 $Y=0.119 $X2=1.431 $Y2=0.097
r5 25 204 6.74717 $w=2e-08 $layer=Gate_1 $thickness=5.2e-08 $X=1.431 $Y=0.135
+ $X2=1.431 $Y2=0.135
r6 25 224 5.61228 $w=2.0375e-08 $l=1.6e-08 $layer=Gate_1 $thickness=5.6e-08
+ $X=1.431 $Y=0.135 $X2=1.431 $Y2=0.119
r7 25 228 5.61228 $w=2.0375e-08 $l=1.6e-08 $layer=Gate_1 $thickness=5.6e-08
+ $X=1.431 $Y=0.135 $X2=1.431 $Y2=0.151
r8 222 221 16.6668 $w=2.1e-08 $l=4.9e-08 $layer=Gate_1 $thickness=5.6e-08
+ $X=1.377 $Y=0.216 $X2=1.377 $Y2=0.167
r9 219 220 16.6668 $w=2.1e-08 $l=4.9e-08 $layer=Gate_1 $thickness=5.6e-08
+ $X=1.377 $Y=0.054 $X2=1.377 $Y2=0.103
r10 24 201 3.57145 $w=2e-08 $layer=Gate_1 $thickness=5.6e-08 $X=1.377 $Y=0.135
+ $X2=1.377 $Y2=0.135
r11 24 220 11.0545 $w=2.06875e-08 $l=3.2e-08 $layer=Gate_1 $thickness=5.6e-08
+ $X=1.377 $Y=0.135 $X2=1.377 $Y2=0.103
r12 24 221 11.0545 $w=2.06875e-08 $l=3.2e-08 $layer=Gate_1 $thickness=5.6e-08
+ $X=1.377 $Y=0.135 $X2=1.377 $Y2=0.167
r13 216 215 16.6668 $w=2.1e-08 $l=4.9e-08 $layer=Gate_1 $thickness=5.6e-08
+ $X=1.323 $Y=0.216 $X2=1.323 $Y2=0.167
r14 213 214 16.6668 $w=2.1e-08 $l=4.9e-08 $layer=Gate_1 $thickness=5.6e-08
+ $X=1.323 $Y=0.054 $X2=1.323 $Y2=0.103
r15 23 197 3.57145 $w=2e-08 $layer=Gate_1 $thickness=5.6e-08 $X=1.323 $Y=0.135
+ $X2=1.323 $Y2=0.135
r16 23 214 11.0545 $w=2.06875e-08 $l=3.2e-08 $layer=Gate_1 $thickness=5.6e-08
+ $X=1.323 $Y=0.135 $X2=1.323 $Y2=0.103
r17 23 215 11.0545 $w=2.06875e-08 $l=3.2e-08 $layer=Gate_1 $thickness=5.6e-08
+ $X=1.323 $Y=0.135 $X2=1.323 $Y2=0.167
r18 210 209 16.6668 $w=2.1e-08 $l=4.9e-08 $layer=Gate_1 $thickness=5.6e-08
+ $X=1.269 $Y=0.216 $X2=1.269 $Y2=0.167
r19 207 208 16.6668 $w=2.1e-08 $l=4.9e-08 $layer=Gate_1 $thickness=5.6e-08
+ $X=1.269 $Y=0.054 $X2=1.269 $Y2=0.103
r20 22 193 6.74717 $w=2e-08 $layer=Gate_1 $thickness=5.2e-08 $X=1.269 $Y=0.135
+ $X2=1.269 $Y2=0.135
r21 22 208 11.0545 $w=2.06875e-08 $l=3.2e-08 $layer=Gate_1 $thickness=5.6e-08
+ $X=1.269 $Y=0.135 $X2=1.269 $Y2=0.103
r22 22 209 11.0545 $w=2.06875e-08 $l=3.2e-08 $layer=Gate_1 $thickness=5.6e-08
+ $X=1.269 $Y=0.135 $X2=1.269 $Y2=0.167
r23 203 204 15.1321 $w=1.63455e-08 $l=2.2e-08 $layer=LIG $thickness=4.8e-08
+ $X=1.409 $Y=0.135 $X2=1.431 $Y2=0.135
r24 202 203 16.9382 $w=1.33e-08 $l=1.7e-08 $layer=LIG $thickness=4.8e-08
+ $X=1.392 $Y=0.135 $X2=1.409 $Y2=0.135
r25 200 202 6.25213 $w=1.62778e-08 $l=9e-09 $layer=LIG $thickness=4.8e-08
+ $X=1.383 $Y=0.135 $X2=1.392 $Y2=0.135
r26 199 200 3.17572 $w=2e-08 $l=1e-08 $layer=LIG $thickness=4.8e-08 $X=1.373
+ $Y=0.135 $X2=1.383 $Y2=0.135
r27 199 201 1.90543 $w=2e-08 $l=4e-09 $layer=LIG $thickness=4.8e-08 $X=1.373
+ $Y=0.135 $X2=1.377 $Y2=0.135
r28 198 199 18.8437 $w=1.50478e-08 $l=2.3e-08 $layer=LIG $thickness=4.8e-08
+ $X=1.35 $Y=0.135 $X2=1.373 $Y2=0.135
r29 196 197 1.74665 $w=2e-08 $l=4.5e-09 $layer=LIG $thickness=4.8e-08 $X=1.3275
+ $Y=0.135 $X2=1.323 $Y2=0.135
r30 196 198 18.6849 $w=1.49378e-08 $l=2.25e-08 $layer=LIG $thickness=4.8e-08
+ $X=1.3275 $Y=0.135 $X2=1.35 $Y2=0.135
r31 195 196 3.17572 $w=2e-08 $l=1e-08 $layer=LIG $thickness=4.8e-08 $X=1.3175
+ $Y=0.135 $X2=1.3275 $Y2=0.135
r32 192 195 5.91273 $w=1.665e-08 $l=9e-09 $layer=LIG $thickness=4.8e-08
+ $X=1.3085 $Y=0.135 $X2=1.3175 $Y2=0.135
r33 4 192 16.9382 $w=1.33e-08 $l=1.7e-08 $layer=LIG $thickness=4.8e-08
+ $X=1.2915 $Y=0.135 $X2=1.3085 $Y2=0.135
r34 4 193 15.6303 $w=1.62778e-08 $l=2.25e-08 $layer=LIG $thickness=4.8e-08
+ $X=1.2915 $Y=0.135 $X2=1.269 $Y2=0.135
r35 190 202 19.3796 $a=3.24e-16 $layer=V0LIG $X=1.3845 $Y=0.135 $X2=1.392
+ $Y2=0.135
r36 45 190 4.19742 $w=1.3e-08 $l=1.8e-08 $layer=M1 $thickness=3.6e-08 $X=1.3665
+ $Y=0.135 $X2=1.3845 $Y2=0.135
r37 188 187 16.6668 $w=2.1e-08 $l=4.9e-08 $layer=Gate_1 $thickness=5.6e-08
+ $X=0.999 $Y=0.216 $X2=0.999 $Y2=0.167
r38 185 186 16.6668 $w=2.1e-08 $l=4.9e-08 $layer=Gate_1 $thickness=5.6e-08
+ $X=0.999 $Y=0.054 $X2=0.999 $Y2=0.103
r39 21 161 6.74717 $w=2e-08 $layer=Gate_1 $thickness=5.2e-08 $X=0.999 $Y=0.135
+ $X2=0.999 $Y2=0.135
r40 21 186 11.0545 $w=2.06875e-08 $l=3.2e-08 $layer=Gate_1 $thickness=5.6e-08
+ $X=0.999 $Y=0.135 $X2=0.999 $Y2=0.103
r41 21 187 11.0545 $w=2.06875e-08 $l=3.2e-08 $layer=Gate_1 $thickness=5.6e-08
+ $X=0.999 $Y=0.135 $X2=0.999 $Y2=0.167
r42 182 181 16.6668 $w=2.1e-08 $l=4.9e-08 $layer=Gate_1 $thickness=5.6e-08
+ $X=0.945 $Y=0.216 $X2=0.945 $Y2=0.167
r43 179 180 16.6668 $w=2.1e-08 $l=4.9e-08 $layer=Gate_1 $thickness=5.6e-08
+ $X=0.945 $Y=0.054 $X2=0.945 $Y2=0.103
r44 20 158 3.57145 $w=2e-08 $layer=Gate_1 $thickness=5.6e-08 $X=0.945 $Y=0.135
+ $X2=0.945 $Y2=0.135
r45 20 180 11.0545 $w=2.06875e-08 $l=3.2e-08 $layer=Gate_1 $thickness=5.6e-08
+ $X=0.945 $Y=0.135 $X2=0.945 $Y2=0.103
r46 20 181 11.0545 $w=2.06875e-08 $l=3.2e-08 $layer=Gate_1 $thickness=5.6e-08
+ $X=0.945 $Y=0.135 $X2=0.945 $Y2=0.167
r47 176 175 16.6668 $w=2.1e-08 $l=4.9e-08 $layer=Gate_1 $thickness=5.6e-08
+ $X=0.891 $Y=0.216 $X2=0.891 $Y2=0.167
r48 173 174 16.6668 $w=2.1e-08 $l=4.9e-08 $layer=Gate_1 $thickness=5.6e-08
+ $X=0.891 $Y=0.054 $X2=0.891 $Y2=0.103
r49 19 154 3.57145 $w=2e-08 $layer=Gate_1 $thickness=5.6e-08 $X=0.891 $Y=0.135
+ $X2=0.891 $Y2=0.135
r50 19 174 11.0545 $w=2.06875e-08 $l=3.2e-08 $layer=Gate_1 $thickness=5.6e-08
+ $X=0.891 $Y=0.135 $X2=0.891 $Y2=0.103
r51 19 175 11.0545 $w=2.06875e-08 $l=3.2e-08 $layer=Gate_1 $thickness=5.6e-08
+ $X=0.891 $Y=0.135 $X2=0.891 $Y2=0.167
r52 170 169 16.6668 $w=2.1e-08 $l=4.9e-08 $layer=Gate_1 $thickness=5.6e-08
+ $X=0.837 $Y=0.216 $X2=0.837 $Y2=0.167
r53 167 168 16.6668 $w=2.1e-08 $l=4.9e-08 $layer=Gate_1 $thickness=5.6e-08
+ $X=0.837 $Y=0.054 $X2=0.837 $Y2=0.103
r54 18 150 6.74717 $w=2e-08 $layer=Gate_1 $thickness=5.2e-08 $X=0.837 $Y=0.135
+ $X2=0.837 $Y2=0.135
r55 18 168 11.0545 $w=2.06875e-08 $l=3.2e-08 $layer=Gate_1 $thickness=5.6e-08
+ $X=0.837 $Y=0.135 $X2=0.837 $Y2=0.103
r56 18 169 11.0545 $w=2.06875e-08 $l=3.2e-08 $layer=Gate_1 $thickness=5.6e-08
+ $X=0.837 $Y=0.135 $X2=0.837 $Y2=0.167
r57 163 164 3.03147 $w=1.3e-08 $l=1.3e-08 $layer=M1 $thickness=3.6e-08 $X=1.316
+ $Y=0.135 $X2=1.329 $Y2=0.135
r58 163 192 19.3796 $a=3.24e-16 $layer=V0LIG $X=1.316 $Y=0.135 $X2=1.3085
+ $Y2=0.135
r59 32 148 6.16517 $w=1.44286e-08 $l=3.15e-08 $layer=M1 $thickness=3.6e-08
+ $X=1.345 $Y=0.135 $X2=1.345 $Y2=0.1035
r60 32 164 2.55073 $w=1.58125e-08 $l=1.6e-08 $layer=M1 $thickness=3.6e-08
+ $X=1.345 $Y=0.135 $X2=1.329 $Y2=0.135
r61 32 45 3.83327 $w=1.5093e-08 $l=2.15e-08 $layer=M1 $thickness=3.6e-08
+ $X=1.345 $Y=0.135 $X2=1.3665 $Y2=0.135
r62 160 161 15.6303 $w=1.62778e-08 $l=2.25e-08 $layer=LIG $thickness=4.8e-08
+ $X=0.9765 $Y=0.135 $X2=0.999 $Y2=0.135
r63 159 160 16.9382 $w=1.33e-08 $l=1.7e-08 $layer=LIG $thickness=4.8e-08
+ $X=0.9595 $Y=0.135 $X2=0.9765 $Y2=0.135
r64 157 159 5.91273 $w=1.665e-08 $l=9e-09 $layer=LIG $thickness=4.8e-08
+ $X=0.9505 $Y=0.135 $X2=0.9595 $Y2=0.135
r65 156 157 3.17572 $w=2e-08 $l=1e-08 $layer=LIG $thickness=4.8e-08 $X=0.9405
+ $Y=0.135 $X2=0.9505 $Y2=0.135
r66 156 158 1.74665 $w=2e-08 $l=4.5e-09 $layer=LIG $thickness=4.8e-08 $X=0.9405
+ $Y=0.135 $X2=0.945 $Y2=0.135
r67 155 156 18.6849 $w=1.49378e-08 $l=2.25e-08 $layer=LIG $thickness=4.8e-08
+ $X=0.918 $Y=0.135 $X2=0.9405 $Y2=0.135
r68 153 154 1.74665 $w=2e-08 $l=4.5e-09 $layer=LIG $thickness=4.8e-08 $X=0.8955
+ $Y=0.135 $X2=0.891 $Y2=0.135
r69 153 155 18.6849 $w=1.49378e-08 $l=2.25e-08 $layer=LIG $thickness=4.8e-08
+ $X=0.8955 $Y=0.135 $X2=0.918 $Y2=0.135
r70 152 153 3.17572 $w=2e-08 $l=1e-08 $layer=LIG $thickness=4.8e-08 $X=0.8855
+ $Y=0.135 $X2=0.8955 $Y2=0.135
r71 149 152 5.91273 $w=1.665e-08 $l=9e-09 $layer=LIG $thickness=4.8e-08
+ $X=0.8765 $Y=0.135 $X2=0.8855 $Y2=0.135
r72 3 149 16.9382 $w=1.33e-08 $l=1.7e-08 $layer=LIG $thickness=4.8e-08
+ $X=0.8595 $Y=0.135 $X2=0.8765 $Y2=0.135
r73 3 150 15.6303 $w=1.62778e-08 $l=2.25e-08 $layer=LIG $thickness=4.8e-08
+ $X=0.8595 $Y=0.135 $X2=0.837 $Y2=0.135
r74 147 148 7.34548 $w=1.3e-08 $l=3.15e-08 $layer=M1 $thickness=3.6e-08
+ $X=1.345 $Y=0.072 $X2=1.345 $Y2=0.1035
r75 44 147 4.19742 $w=1.3e-08 $l=1.8e-08 $layer=M1 $thickness=3.6e-08 $X=1.345
+ $Y=0.054 $X2=1.345 $Y2=0.072
r76 145 157 19.3796 $a=3.24e-16 $layer=V0LIG $X=0.952 $Y=0.135 $X2=0.9505
+ $Y2=0.135
r77 43 145 3.61444 $w=1.3e-08 $l=1.55e-08 $layer=M1 $thickness=3.6e-08
+ $X=0.9365 $Y=0.135 $X2=0.952 $Y2=0.135
r78 40 143 3.61444 $w=1.3e-08 $l=1.55e-08 $layer=M1 $thickness=3.6e-08 $X=0.884
+ $Y=0.135 $X2=0.8995 $Y2=0.135
r79 40 149 19.3796 $a=3.24e-16 $layer=V0LIG $X=0.884 $Y=0.135 $X2=0.8765
+ $Y2=0.135
r80 141 140 16.6668 $w=2.1e-08 $l=4.9e-08 $layer=Gate_1 $thickness=5.6e-08
+ $X=0.567 $Y=0.216 $X2=0.567 $Y2=0.167
r81 138 139 16.6668 $w=2.1e-08 $l=4.9e-08 $layer=Gate_1 $thickness=5.6e-08
+ $X=0.567 $Y=0.054 $X2=0.567 $Y2=0.103
r82 17 117 6.74717 $w=2e-08 $layer=Gate_1 $thickness=5.2e-08 $X=0.567 $Y=0.135
+ $X2=0.567 $Y2=0.135
r83 17 139 11.0545 $w=2.06875e-08 $l=3.2e-08 $layer=Gate_1 $thickness=5.6e-08
+ $X=0.567 $Y=0.135 $X2=0.567 $Y2=0.103
r84 17 140 11.0545 $w=2.06875e-08 $l=3.2e-08 $layer=Gate_1 $thickness=5.6e-08
+ $X=0.567 $Y=0.135 $X2=0.567 $Y2=0.167
r85 135 134 16.6668 $w=2.1e-08 $l=4.9e-08 $layer=Gate_1 $thickness=5.6e-08
+ $X=0.513 $Y=0.216 $X2=0.513 $Y2=0.167
r86 132 133 16.6668 $w=2.1e-08 $l=4.9e-08 $layer=Gate_1 $thickness=5.6e-08
+ $X=0.513 $Y=0.054 $X2=0.513 $Y2=0.103
r87 16 114 3.57145 $w=2e-08 $layer=Gate_1 $thickness=5.6e-08 $X=0.513 $Y=0.135
+ $X2=0.513 $Y2=0.135
r88 16 133 11.0545 $w=2.06875e-08 $l=3.2e-08 $layer=Gate_1 $thickness=5.6e-08
+ $X=0.513 $Y=0.135 $X2=0.513 $Y2=0.103
r89 16 134 11.0545 $w=2.06875e-08 $l=3.2e-08 $layer=Gate_1 $thickness=5.6e-08
+ $X=0.513 $Y=0.135 $X2=0.513 $Y2=0.167
r90 129 128 16.6668 $w=2.1e-08 $l=4.9e-08 $layer=Gate_1 $thickness=5.6e-08
+ $X=0.459 $Y=0.216 $X2=0.459 $Y2=0.167
r91 126 127 16.6668 $w=2.1e-08 $l=4.9e-08 $layer=Gate_1 $thickness=5.6e-08
+ $X=0.459 $Y=0.054 $X2=0.459 $Y2=0.103
r92 15 110 3.57145 $w=2e-08 $layer=Gate_1 $thickness=5.6e-08 $X=0.459 $Y=0.135
+ $X2=0.459 $Y2=0.135
r93 15 127 11.0545 $w=2.06875e-08 $l=3.2e-08 $layer=Gate_1 $thickness=5.6e-08
+ $X=0.459 $Y=0.135 $X2=0.459 $Y2=0.103
r94 15 128 11.0545 $w=2.06875e-08 $l=3.2e-08 $layer=Gate_1 $thickness=5.6e-08
+ $X=0.459 $Y=0.135 $X2=0.459 $Y2=0.167
r95 123 122 16.6668 $w=2.1e-08 $l=4.9e-08 $layer=Gate_1 $thickness=5.6e-08
+ $X=0.405 $Y=0.216 $X2=0.405 $Y2=0.167
r96 120 121 16.6668 $w=2.1e-08 $l=4.9e-08 $layer=Gate_1 $thickness=5.6e-08
+ $X=0.405 $Y=0.054 $X2=0.405 $Y2=0.103
r97 14 106 6.74717 $w=2e-08 $layer=Gate_1 $thickness=5.2e-08 $X=0.405 $Y=0.135
+ $X2=0.405 $Y2=0.135
r98 14 121 11.0545 $w=2.06875e-08 $l=3.2e-08 $layer=Gate_1 $thickness=5.6e-08
+ $X=0.405 $Y=0.135 $X2=0.405 $Y2=0.103
r99 14 122 11.0545 $w=2.06875e-08 $l=3.2e-08 $layer=Gate_1 $thickness=5.6e-08
+ $X=0.405 $Y=0.135 $X2=0.405 $Y2=0.167
r100 33 104 3.48106 $w=1.50455e-08 $l=2.2e-08 $layer=M1 $thickness=3.6e-08
+ $X=1.345 $Y=0.036 $X2=1.323 $Y2=0.036
r101 33 44 2.5483 $w=1.79e-08 $l=1.8e-08 $layer=M1 $thickness=3.6e-08 $X=1.345
+ $Y=0.036 $X2=1.345 $Y2=0.054
r102 31 96 6.16517 $w=1.44286e-08 $l=3.15e-08 $layer=M1 $thickness=3.6e-08
+ $X=0.918 $Y=0.135 $X2=0.918 $Y2=0.1035
r103 31 143 3.1337 $w=1.54324e-08 $l=1.85e-08 $layer=M1 $thickness=3.6e-08
+ $X=0.918 $Y=0.135 $X2=0.8995 $Y2=0.135
r104 31 43 3.1337 $w=1.54324e-08 $l=1.85e-08 $layer=M1 $thickness=3.6e-08
+ $X=0.918 $Y=0.135 $X2=0.9365 $Y2=0.135
r105 116 117 16.1285 $w=1.6213e-08 $l=2.3e-08 $layer=LIG $thickness=4.8e-08
+ $X=0.544 $Y=0.135 $X2=0.567 $Y2=0.135
r106 115 116 16.9382 $w=1.33e-08 $l=1.7e-08 $layer=LIG $thickness=4.8e-08
+ $X=0.527 $Y=0.135 $X2=0.544 $Y2=0.135
r107 113 114 1.58786 $w=2e-08 $l=5e-09 $layer=LIG $thickness=4.8e-08 $X=0.518
+ $Y=0.135 $X2=0.513 $Y2=0.135
r108 113 115 5.57333 $w=1.70222e-08 $l=9e-09 $layer=LIG $thickness=4.8e-08
+ $X=0.518 $Y=0.135 $X2=0.527 $Y2=0.135
r109 112 113 3.17572 $w=2e-08 $l=1e-08 $layer=LIG $thickness=4.8e-08 $X=0.508
+ $Y=0.135 $X2=0.518 $Y2=0.135
r110 111 112 18.5261 $w=1.48227e-08 $l=2.2e-08 $layer=LIG $thickness=4.8e-08
+ $X=0.486 $Y=0.135 $X2=0.508 $Y2=0.135
r111 109 110 1.90543 $w=2e-08 $l=4e-09 $layer=LIG $thickness=4.8e-08 $X=0.463
+ $Y=0.135 $X2=0.459 $Y2=0.135
r112 109 111 18.8437 $w=1.50478e-08 $l=2.3e-08 $layer=LIG $thickness=4.8e-08
+ $X=0.463 $Y=0.135 $X2=0.486 $Y2=0.135
r113 108 109 3.17572 $w=2e-08 $l=1e-08 $layer=LIG $thickness=4.8e-08 $X=0.453
+ $Y=0.135 $X2=0.463 $Y2=0.135
r114 105 108 6.25213 $w=1.62778e-08 $l=9e-09 $layer=LIG $thickness=4.8e-08
+ $X=0.444 $Y=0.135 $X2=0.453 $Y2=0.135
r115 2 105 16.9382 $w=1.33e-08 $l=1.7e-08 $layer=LIG $thickness=4.8e-08
+ $X=0.427 $Y=0.135 $X2=0.444 $Y2=0.135
r116 2 106 15.1321 $w=1.63455e-08 $l=2.2e-08 $layer=LIG $thickness=4.8e-08
+ $X=0.427 $Y=0.135 $X2=0.405 $Y2=0.135
r117 103 104 8.86121 $w=1.3e-08 $l=3.8e-08 $layer=M1 $thickness=3.6e-08
+ $X=1.285 $Y=0.036 $X2=1.323 $Y2=0.036
r118 102 103 10.7267 $w=1.3e-08 $l=4.6e-08 $layer=M1 $thickness=3.6e-08
+ $X=1.239 $Y=0.036 $X2=1.285 $Y2=0.036
r119 101 102 22.6194 $w=1.3e-08 $l=9.7e-08 $layer=M1 $thickness=3.6e-08
+ $X=1.142 $Y=0.036 $X2=1.239 $Y2=0.036
r120 100 101 18.6552 $w=1.3e-08 $l=8e-08 $layer=M1 $thickness=3.6e-08 $X=1.062
+ $Y=0.036 $X2=1.142 $Y2=0.036
r121 99 100 2.2153 $w=1.3e-08 $l=9.5e-09 $layer=M1 $thickness=3.6e-08 $X=1.0525
+ $Y=0.036 $X2=1.062 $Y2=0.036
r122 98 99 5.82974 $w=1.3e-08 $l=2.5e-08 $layer=M1 $thickness=3.6e-08 $X=1.0275
+ $Y=0.036 $X2=1.0525 $Y2=0.036
r123 97 98 10.3769 $w=1.3e-08 $l=4.45e-08 $layer=M1 $thickness=3.6e-08 $X=0.983
+ $Y=0.036 $X2=1.0275 $Y2=0.036
r124 42 97 9.44419 $w=1.3e-08 $l=4.05e-08 $layer=M1 $thickness=3.6e-08
+ $X=0.9425 $Y=0.036 $X2=0.983 $Y2=0.036
r125 95 96 7.34548 $w=1.3e-08 $l=3.15e-08 $layer=M1 $thickness=3.6e-08 $X=0.918
+ $Y=0.072 $X2=0.918 $Y2=0.1035
r126 41 95 4.19742 $w=1.3e-08 $l=1.8e-08 $layer=M1 $thickness=3.6e-08 $X=0.918
+ $Y=0.054 $X2=0.918 $Y2=0.072
r127 93 113 19.3796 $a=3.24e-16 $layer=V0LIG $X=0.5195 $Y=0.135 $X2=0.518
+ $Y2=0.135
r128 39 93 3.73104 $w=1.3e-08 $l=1.6e-08 $layer=M1 $thickness=3.6e-08 $X=0.5035
+ $Y=0.135 $X2=0.5195 $Y2=0.135
r129 36 91 3.49785 $w=1.3e-08 $l=1.5e-08 $layer=M1 $thickness=3.6e-08 $X=0.4515
+ $Y=0.135 $X2=0.4665 $Y2=0.135
r130 36 105 19.3796 $a=3.24e-16 $layer=V0LIG $X=0.4515 $Y=0.135 $X2=0.444
+ $Y2=0.135
r131 30 90 4.53284 $w=1.48367e-08 $l=2.45e-08 $layer=M1 $thickness=3.6e-08
+ $X=0.918 $Y=0.036 $X2=0.8935 $Y2=0.036
r132 30 41 3.01711 $w=1.55e-08 $l=1.8e-08 $layer=M1 $thickness=3.6e-08 $X=0.918
+ $Y=0.036 $X2=0.918 $Y2=0.054
r133 30 42 4.53284 $w=1.48367e-08 $l=2.45e-08 $layer=M1 $thickness=3.6e-08
+ $X=0.918 $Y=0.036 $X2=0.9425 $Y2=0.036
r134 29 82 6.16517 $w=1.44286e-08 $l=3.15e-08 $layer=M1 $thickness=3.6e-08
+ $X=0.485 $Y=0.135 $X2=0.485 $Y2=0.1035
r135 29 91 3.1337 $w=1.54324e-08 $l=1.85e-08 $layer=M1 $thickness=3.6e-08
+ $X=0.485 $Y=0.135 $X2=0.4665 $Y2=0.135
r136 29 39 3.1337 $w=1.54324e-08 $l=1.85e-08 $layer=M1 $thickness=3.6e-08
+ $X=0.485 $Y=0.135 $X2=0.5035 $Y2=0.135
r137 89 90 9.44419 $w=1.3e-08 $l=4.05e-08 $layer=M1 $thickness=3.6e-08 $X=0.853
+ $Y=0.036 $X2=0.8935 $Y2=0.036
r138 88 89 10.3769 $w=1.3e-08 $l=4.45e-08 $layer=M1 $thickness=3.6e-08
+ $X=0.8085 $Y=0.036 $X2=0.853 $Y2=0.036
r139 87 88 5.82974 $w=1.3e-08 $l=2.5e-08 $layer=M1 $thickness=3.6e-08 $X=0.7835
+ $Y=0.036 $X2=0.8085 $Y2=0.036
r140 86 87 2.2153 $w=1.3e-08 $l=9.5e-09 $layer=M1 $thickness=3.6e-08 $X=0.774
+ $Y=0.036 $X2=0.7835 $Y2=0.036
r141 85 86 18.6552 $w=1.3e-08 $l=8e-08 $layer=M1 $thickness=3.6e-08 $X=0.694
+ $Y=0.036 $X2=0.774 $Y2=0.036
r142 84 85 22.6194 $w=1.3e-08 $l=9.7e-08 $layer=M1 $thickness=3.6e-08 $X=0.597
+ $Y=0.036 $X2=0.694 $Y2=0.036
r143 83 84 10.7267 $w=1.3e-08 $l=4.6e-08 $layer=M1 $thickness=3.6e-08 $X=0.551
+ $Y=0.036 $X2=0.597 $Y2=0.036
r144 38 83 9.56078 $w=1.3e-08 $l=4.1e-08 $layer=M1 $thickness=3.6e-08 $X=0.51
+ $Y=0.036 $X2=0.551 $Y2=0.036
r145 81 82 7.34548 $w=1.3e-08 $l=3.15e-08 $layer=M1 $thickness=3.6e-08 $X=0.485
+ $Y=0.072 $X2=0.485 $Y2=0.1035
r146 37 81 4.19742 $w=1.3e-08 $l=1.8e-08 $layer=M1 $thickness=3.6e-08 $X=0.485
+ $Y=0.054 $X2=0.485 $Y2=0.072
r147 28 80 4.41625 $w=1.4875e-08 $l=2.4e-08 $layer=M1 $thickness=3.6e-08
+ $X=0.485 $Y=0.036 $X2=0.461 $Y2=0.036
r148 28 37 3.01711 $w=1.55e-08 $l=1.8e-08 $layer=M1 $thickness=3.6e-08 $X=0.485
+ $Y=0.036 $X2=0.485 $Y2=0.054
r149 28 38 4.64944 $w=1.48e-08 $l=2.5e-08 $layer=M1 $thickness=3.6e-08 $X=0.485
+ $Y=0.036 $X2=0.51 $Y2=0.036
r150 79 80 9.32759 $w=1.3e-08 $l=4e-08 $layer=M1 $thickness=3.6e-08 $X=0.421
+ $Y=0.036 $X2=0.461 $Y2=0.036
r151 78 79 10.3769 $w=1.3e-08 $l=4.45e-08 $layer=M1 $thickness=3.6e-08
+ $X=0.3765 $Y=0.036 $X2=0.421 $Y2=0.036
r152 77 78 5.82974 $w=1.3e-08 $l=2.5e-08 $layer=M1 $thickness=3.6e-08 $X=0.3515
+ $Y=0.036 $X2=0.3765 $Y2=0.036
r153 76 77 2.2153 $w=1.3e-08 $l=9.5e-09 $layer=M1 $thickness=3.6e-08 $X=0.342
+ $Y=0.036 $X2=0.3515 $Y2=0.036
r154 75 76 18.6552 $w=1.3e-08 $l=8e-08 $layer=M1 $thickness=3.6e-08 $X=0.262
+ $Y=0.036 $X2=0.342 $Y2=0.036
r155 74 75 22.6194 $w=1.3e-08 $l=9.7e-08 $layer=M1 $thickness=3.6e-08 $X=0.165
+ $Y=0.036 $X2=0.262 $Y2=0.036
r156 73 74 10.7267 $w=1.3e-08 $l=4.6e-08 $layer=M1 $thickness=3.6e-08 $X=0.119
+ $Y=0.036 $X2=0.165 $Y2=0.036
r157 35 73 8.86121 $w=1.3e-08 $l=3.8e-08 $layer=M1 $thickness=3.6e-08 $X=0.081
+ $Y=0.036 $X2=0.119 $Y2=0.036
r158 26 70 1.79044 $w=1.89797e-08 $l=1.47e-08 $layer=M1 $thickness=3.6e-08
+ $X=0.059 $Y=0.036 $X2=0.059 $Y2=0.0507
r159 26 35 3.48106 $w=1.50455e-08 $l=2.2e-08 $layer=M1 $thickness=3.6e-08
+ $X=0.059 $Y=0.036 $X2=0.081 $Y2=0.036
r160 71 72 0.757867 $w=1.3e-08 $l=3.2e-09 $layer=M1 $thickness=3.6e-08 $X=0.06
+ $Y=0.057 $X2=0.059 $Y2=0.0602
r161 71 70 1.45744 $w=1.3e-08 $l=6.3e-09 $layer=M1 $thickness=3.6e-08 $X=0.06
+ $Y=0.057 $X2=0.059 $Y2=0.0507
r162 69 72 2.73998 $w=1.3e-08 $l=1.18e-08 $layer=M1 $thickness=3.6e-08 $X=0.059
+ $Y=0.072 $X2=0.059 $Y2=0.0602
r163 34 61 6.16517 $w=1.44286e-08 $l=3.15e-08 $layer=M1 $thickness=3.6e-08
+ $X=0.059 $Y=0.1035 $X2=0.059 $Y2=0.135
r164 34 69 7.34548 $w=1.3e-08 $l=3.15e-08 $layer=M1 $thickness=3.6e-08 $X=0.059
+ $Y=0.1035 $X2=0.059 $Y2=0.072
r165 67 66 16.6668 $w=2.1e-08 $l=4.9e-08 $layer=Gate_1 $thickness=5.6e-08
+ $X=0.135 $Y=0.216 $X2=0.135 $Y2=0.167
r166 64 65 16.6668 $w=2.1e-08 $l=4.9e-08 $layer=Gate_1 $thickness=5.6e-08
+ $X=0.135 $Y=0.054 $X2=0.135 $Y2=0.103
r167 13 58 6.74717 $w=2e-08 $layer=Gate_1 $thickness=5.2e-08 $X=0.135 $Y=0.135
+ $X2=0.135 $Y2=0.135
r168 13 65 11.0545 $w=2.06875e-08 $l=3.2e-08 $layer=Gate_1 $thickness=5.6e-08
+ $X=0.135 $Y=0.135 $X2=0.135 $Y2=0.103
r169 13 66 11.0545 $w=2.06875e-08 $l=3.2e-08 $layer=Gate_1 $thickness=5.6e-08
+ $X=0.135 $Y=0.135 $X2=0.135 $Y2=0.167
r170 27 60 3.03147 $w=1.3e-08 $l=1.3e-08 $layer=M1 $thickness=3.6e-08 $X=0.075
+ $Y=0.135 $X2=0.088 $Y2=0.135
r171 27 61 2.55073 $w=1.58125e-08 $l=1.6e-08 $layer=M1 $thickness=3.6e-08
+ $X=0.075 $Y=0.135 $X2=0.059 $Y2=0.135
r172 57 58 15.6303 $w=1.62778e-08 $l=2.25e-08 $layer=LIG $thickness=4.8e-08
+ $X=0.1125 $Y=0.135 $X2=0.135 $Y2=0.135
r173 56 57 16.9382 $w=1.33e-08 $l=1.7e-08 $layer=LIG $thickness=4.8e-08
+ $X=0.0955 $Y=0.135 $X2=0.1125 $Y2=0.135
r174 54 56 5.91273 $w=1.665e-08 $l=9e-09 $layer=LIG $thickness=4.8e-08
+ $X=0.0865 $Y=0.135 $X2=0.0955 $Y2=0.135
r175 54 60 19.3796 $a=3.24e-16 $layer=V0LIG $X=0.0865 $Y=0.135 $X2=0.088
+ $Y2=0.135
r176 1 54 3.17572 $w=2e-08 $l=1e-08 $layer=LIG $thickness=4.8e-08 $X=0.0765
+ $Y=0.135 $X2=0.0865 $Y2=0.135
r177 1 49 5.3181 $w=2e-08 $l=4.5e-09 $layer=Gate_1 $thickness=5.31613e-08
+ $X=0.0765 $Y=0.135 $X2=0.081 $Y2=0.135
r178 52 51 14.6259 $w=2.1e-08 $l=4.3e-08 $layer=Gate_1 $thickness=5.6e-08
+ $X=0.081 $Y=0.216 $X2=0.081 $Y2=0.173
r179 50 51 7.48304 $w=2.1e-08 $l=2.2e-08 $layer=Gate_1 $thickness=5.6e-08
+ $X=0.081 $Y=0.151 $X2=0.081 $Y2=0.173
r180 49 50 5.61228 $w=2.0375e-08 $l=1.6e-08 $layer=Gate_1 $thickness=5.6e-08
+ $X=0.081 $Y=0.135 $X2=0.081 $Y2=0.151
r181 49 54 5.00052 $w=2e-08 $l=5.5e-09 $layer=Gate_1 $thickness=5.35172e-08
+ $X=0.081 $Y=0.135 $X2=0.0865 $Y2=0.135
r182 48 49 5.61228 $w=2.0375e-08 $l=1.6e-08 $layer=Gate_1 $thickness=5.6e-08
+ $X=0.081 $Y=0.119 $X2=0.081 $Y2=0.135
r183 47 48 7.48304 $w=2.1e-08 $l=2.2e-08 $layer=Gate_1 $thickness=5.6e-08
+ $X=0.081 $Y=0.097 $X2=0.081 $Y2=0.119
r184 46 47 14.6259 $w=2.1e-08 $l=4.3e-08 $layer=Gate_1 $thickness=5.6e-08
+ $X=0.081 $Y=0.054 $X2=0.081 $Y2=0.097
r185 46 12 10.0341 $w=2.1e-08 $l=2.95e-08 $layer=Gate_1 $thickness=5.6e-08
+ $X=0.081 $Y=0.054 $X2=0.081 $Y2=0.0245
.ends

* End of included file CKINVDCx9p33_ASAP7_75t_R.pex.sp.pex

*
.subckt CKINVDCx9p33_ASAP7_75t_CUSTOM_4_25_0_7 VSS VDD A Y
*
* VSS VSS
* VDD VDD
* A A
* Y Y
*
*

M0 N_M0_d N_M0_g VSS VSS nmos_rvt L=2e-08 W=5.4e-08 nfin=2 $X=0.071 $Y=0.027
M1 N_M1_d N_M1_g VSS VSS nmos_rvt L=2e-08 W=5.4e-08 nfin=2 $X=0.125 $Y=0.027
M20 N_M20_d N_M20_g VSS VSS nmos_rvt L=2e-08 W=8.1e-08 nfin=3 $X=0.179 $Y=0.027
M21 N_M21_d N_M21_g VSS VSS nmos_rvt L=2e-08 W=8.1e-08 nfin=3 $X=0.233 $Y=0.027
M18 N_M18_d N_M18_g VSS VSS nmos_rvt L=2e-08 W=8.1e-08 nfin=3 $X=0.287 $Y=0.027
M19 N_M19_d N_M19_g VSS VSS nmos_rvt L=2e-08 W=8.1e-08 nfin=3 $X=0.341 $Y=0.027
M6 N_M6_d N_M6_g VSS VSS nmos_rvt L=2e-08 W=5.4e-08 nfin=2 $X=0.395 $Y=0.027
M7 N_M7_d N_M7_g VSS VSS nmos_rvt L=2e-08 W=5.4e-08 nfin=2 $X=0.449 $Y=0.027
M8 N_M8_d N_M8_g VSS VSS nmos_rvt L=2e-08 W=5.4e-08 nfin=2 $X=0.503 $Y=0.027
M9 N_M9_d N_M9_g VSS VSS nmos_rvt L=2e-08 W=5.4e-08 nfin=2 $X=0.557 $Y=0.027
M10 N_M10_d N_M10_g VSS VSS nmos_rvt L=2e-08 W=8.1e-08 nfin=3 $X=0.611 $Y=0.027
M11 N_M11_d N_M11_g VSS VSS nmos_rvt L=2e-08 W=8.1e-08 nfin=3 $X=0.665 $Y=0.027
M12 N_M12_d N_M12_g VSS VSS nmos_rvt L=2e-08 W=8.1e-08 nfin=3 $X=0.719 $Y=0.027
M13 N_M13_d N_M13_g VSS VSS nmos_rvt L=2e-08 W=8.1e-08 nfin=3 $X=0.773 $Y=0.027
M14 N_M14_d N_M14_g VSS VSS nmos_rvt L=2e-08 W=5.4e-08 nfin=2 $X=0.827 $Y=0.027
M15 N_M15_d N_M15_g VSS VSS nmos_rvt L=2e-08 W=5.4e-08 nfin=2 $X=0.881 $Y=0.027
M16 N_M16_d N_M16_g VSS VSS nmos_rvt L=2e-08 W=5.4e-08 nfin=2 $X=0.935 $Y=0.027
M17 N_M17_d N_M17_g VSS VSS nmos_rvt L=2e-08 W=5.4e-08 nfin=2 $X=0.989 $Y=0.027
M4 N_M4_d N_M4_g VSS VSS nmos_rvt L=2e-08 W=8.1e-08 nfin=3 $X=1.043 $Y=0.027
M5 N_M5_d N_M5_g VSS VSS nmos_rvt L=2e-08 W=8.1e-08 nfin=3 $X=1.097 $Y=0.027
M2 N_M2_d N_M2_g VSS VSS nmos_rvt L=2e-08 W=8.1e-08 nfin=3 $X=1.151 $Y=0.027
M3 N_M3_d N_M3_g VSS VSS nmos_rvt L=2e-08 W=8.1e-08 nfin=3 $X=1.205 $Y=0.027
M22 N_M22_d N_M22_g VSS VSS nmos_rvt L=2e-08 W=5.4e-08 nfin=2 $X=1.259 $Y=0.027
M23 N_M23_d N_M23_g VSS VSS nmos_rvt L=2e-08 W=5.4e-08 nfin=2 $X=1.313 $Y=0.027
M24 N_M24_d N_M24_g VSS VSS nmos_rvt L=2e-08 W=5.4e-08 nfin=2 $X=1.367 $Y=0.027
M25 N_M25_d N_M25_g VSS VSS nmos_rvt L=2e-08 W=5.4e-08 nfin=2 $X=1.421 $Y=0.027
M26 N_M26_d N_M26_g VDD VDD pmos_rvt L=2e-08 W=5.4e-08 nfin=2 $X=0.071 $Y=0.189
M27 N_M27_d N_M27_g VDD VDD pmos_rvt L=2e-08 W=5.4e-08 nfin=2 $X=0.125 $Y=0.189
M46 N_M46_d N_M46_g VDD VDD pmos_rvt L=2e-08 W=8.1e-08 nfin=3 $X=0.179 $Y=0.162
M47 N_M47_d N_M47_g VDD VDD pmos_rvt L=2e-08 W=8.1e-08 nfin=3 $X=0.233 $Y=0.162
M44 N_M44_d N_M44_g VDD VDD pmos_rvt L=2e-08 W=8.1e-08 nfin=3 $X=0.287 $Y=0.162
M45 N_M45_d N_M45_g VDD VDD pmos_rvt L=2e-08 W=8.1e-08 nfin=3 $X=0.341 $Y=0.162
M32 N_M32_d N_M32_g VDD VDD pmos_rvt L=2e-08 W=5.4e-08 nfin=2 $X=0.395 $Y=0.189
M33 N_M33_d N_M33_g VDD VDD pmos_rvt L=2e-08 W=5.4e-08 nfin=2 $X=0.449 $Y=0.189
M34 N_M34_d N_M34_g VDD VDD pmos_rvt L=2e-08 W=5.4e-08 nfin=2 $X=0.503 $Y=0.189
M35 N_M35_d N_M35_g VDD VDD pmos_rvt L=2e-08 W=5.4e-08 nfin=2 $X=0.557 $Y=0.189
M36 N_M36_d N_M36_g VDD VDD pmos_rvt L=2e-08 W=8.1e-08 nfin=3 $X=0.611 $Y=0.162
M37 N_M37_d N_M37_g VDD VDD pmos_rvt L=2e-08 W=8.1e-08 nfin=3 $X=0.665 $Y=0.162
M38 N_M38_d N_M38_g VDD VDD pmos_rvt L=2e-08 W=8.1e-08 nfin=3 $X=0.719 $Y=0.162
M39 N_M39_d N_M39_g VDD VDD pmos_rvt L=2e-08 W=8.1e-08 nfin=3 $X=0.773 $Y=0.162
M40 N_M40_d N_M40_g VDD VDD pmos_rvt L=2e-08 W=5.4e-08 nfin=2 $X=0.827 $Y=0.189
M41 N_M41_d N_M41_g VDD VDD pmos_rvt L=2e-08 W=5.4e-08 nfin=2 $X=0.881 $Y=0.189
M42 N_M42_d N_M42_g VDD VDD pmos_rvt L=2e-08 W=5.4e-08 nfin=2 $X=0.935 $Y=0.189
M43 N_M43_d N_M43_g VDD VDD pmos_rvt L=2e-08 W=5.4e-08 nfin=2 $X=0.989 $Y=0.189
M30 N_M30_d N_M30_g VDD VDD pmos_rvt L=2e-08 W=8.1e-08 nfin=3 $X=1.043 $Y=0.162
M31 N_M31_d N_M31_g VDD VDD pmos_rvt L=2e-08 W=8.1e-08 nfin=3 $X=1.097 $Y=0.162
M28 N_M28_d N_M28_g VDD VDD pmos_rvt L=2e-08 W=8.1e-08 nfin=3 $X=1.151 $Y=0.162
M29 N_M29_d N_M29_g VDD VDD pmos_rvt L=2e-08 W=8.1e-08 nfin=3 $X=1.205 $Y=0.162
M48 N_M48_d N_M48_g VDD VDD pmos_rvt L=2e-08 W=5.4e-08 nfin=2 $X=1.259 $Y=0.189
M49 N_M49_d N_M49_g VDD VDD pmos_rvt L=2e-08 W=5.4e-08 nfin=2 $X=1.313 $Y=0.189
M50 N_M50_d N_M50_g VDD VDD pmos_rvt L=2e-08 W=5.4e-08 nfin=2 $X=1.367 $Y=0.189
M51 N_M51_d N_M51_g VDD VDD pmos_rvt L=2e-08 W=5.4e-08 nfin=2 $X=1.421 $Y=0.189

* .include "CKINVDCx9p33_ASAP7_75t_R.pex.sp.pxi"

* Start of included file CKINVDCx9p33_ASAP7_75t_R.pex.sp.pxi
x_PM_CKINVDCx9p33_ASAP7_75t_R%8 vss N_M18_g N_M44_g N_M19_g N_M45_g N_M46_d
+ N_M47_d N_M44_d N_M45_d N_8_10 N_8_9 N_8_15 N_8_17 N_8_3 N_8_1 N_8_11 N_8_13
+ N_8_4 N_8_18 PM_CKINVDCx9p33_ASAP7_75t_R%8
cc_1 N_8_10 N_A_27 3.92976e-20 $X=0.351 $Y=0.135
cc_2 N_8_10 N_A_37 4.28969e-20 $X=0.351 $Y=0.135
cc_3 N_8_10 N_A_2 0.00178646f $X=0.351 $Y=0.135
cc_4 N_8_10 N_A_1 0.000114633f $X=0.351 $Y=0.135
cc_5 N_8_10 N_A_14 0.00337968f $X=0.351 $Y=0.135
cc_6 N_8_9 N_9_12 0.0322846f $X=0.297 $Y=0.0245
cc_7 N_8_15 N_9_16 0.00127925f $X=0.27 $Y=0.171
cc_8 N_8_17 N_9_18 0.00131965f $X=0.3105 $Y=0.135
cc_9 N_8_10 N_9_4 0.00143019f $X=0.351 $Y=0.135
cc_10 N_8_3 N_9_9 0.00143019f $X=0.216 $Y=0.2025
cc_11 N_8_3 N_9_1 0.00173267f $X=0.216 $Y=0.2025
cc_12 N_8_1 N_9_4 0.00173267f $X=0.297 $Y=0.135
cc_13 N_8_11 N_9_1 0.0029965f $X=0.2015 $Y=0.2025
cc_14 N_8_1 N_9_12 0.0029965f $X=0.297 $Y=0.135
cc_15 N_8_13 N_9_18 0.00381287f $X=0.297 $Y=0.135
cc_16 N_8_15 N_9_14 0.00381584f $X=0.27 $Y=0.171
cc_17 N_8_11 N_9_9 0.0425911f $X=0.2015 $Y=0.2025
cc_18 N_8_11 N_9_10 0.0209155f $X=0.2015 $Y=0.2025
cc_19 N_8_10 N_9_12 0.0342056f $X=0.351 $Y=0.135
x_PM_CKINVDCx9p33_ASAP7_75t_R%5 vss N_M4_g N_M30_g N_M5_g N_M31_g N_M30_d
+ N_M31_d N_M28_d N_M29_d N_5_9 N_5_10 N_5_18 N_5_16 N_5_4 N_5_1 N_5_12 N_5_13
+ N_5_3 N_5_15 PM_CKINVDCx9p33_ASAP7_75t_R%5
cc_20 N_5_9 N_A_42 3.38505e-20 $X=1.053 $Y=0.0245
cc_21 N_5_9 N_A_41 3.84918e-20 $X=1.053 $Y=0.0245
cc_22 N_5_9 N_A_3 0.00171142f $X=1.053 $Y=0.0245
cc_23 N_5_9 N_A_4 0.000114663f $X=1.053 $Y=0.0245
cc_24 N_5_9 N_A_21 0.00340421f $X=1.053 $Y=0.0245
x_PM_CKINVDCx9p33_ASAP7_75t_R%6 vss N_M10_g N_M36_g N_M11_g N_M37_g N_M10_d
+ N_M11_d N_M12_d N_M13_d N_6_18 N_6_3 N_6_4 N_6_15 N_6_9 N_6_12 N_6_16 N_6_1
+ N_6_14 N_6_10 PM_CKINVDCx9p33_ASAP7_75t_R%6
cc_25 N_6_18 N_A_37 5.26091e-20 $X=0.702 $Y=0.099
cc_26 N_6_18 N_A_2 0.000797522f $X=0.702 $Y=0.099
cc_27 N_6_3 N_A_38 0.000743172f $X=0.648 $Y=0.0675
cc_28 N_6_4 N_A_38 0.000749205f $X=0.756 $Y=0.0675
cc_29 N_6_15 N_A_38 0.000802744f $X=0.6335 $Y=0.099
cc_30 N_6_9 N_A_2 0.000849292f $X=0.621 $Y=0.0245
cc_31 N_6_9 N_A_17 0.00331389f $X=0.621 $Y=0.0245
cc_32 N_6_18 N_A_38 0.00652788f $X=0.702 $Y=0.099
x_PM_CKINVDCx9p33_ASAP7_75t_R%7 vss N_M12_g N_M38_g N_M13_g N_M39_g N_M36_d
+ N_M37_d N_M38_d N_M39_d N_7_10 N_7_9 N_7_15 N_7_17 N_7_3 N_7_1 N_7_11 N_7_13
+ N_7_4 N_7_18 PM_CKINVDCx9p33_ASAP7_75t_R%7
cc_33 N_7_10 N_A_41 3.85567e-20 $X=0.783 $Y=0.135
cc_34 N_7_10 N_A_3 0.00179631f $X=0.783 $Y=0.135
cc_35 N_7_10 N_A_2 0.000114663f $X=0.783 $Y=0.135
cc_36 N_7_10 N_A_18 0.00339991f $X=0.783 $Y=0.135
cc_37 N_7_9 N_6_12 0.0322846f $X=0.729 $Y=0.0245
cc_38 N_7_15 N_6_16 0.0012623f $X=0.702 $Y=0.171
cc_39 N_7_17 N_6_18 0.00131967f $X=0.7425 $Y=0.135
cc_40 N_7_10 N_6_4 0.00143019f $X=0.783 $Y=0.135
cc_41 N_7_3 N_6_9 0.00143019f $X=0.648 $Y=0.2025
cc_42 N_7_3 N_6_1 0.00173267f $X=0.648 $Y=0.2025
cc_43 N_7_1 N_6_4 0.00173267f $X=0.729 $Y=0.135
cc_44 N_7_11 N_6_1 0.0029965f $X=0.6335 $Y=0.2025
cc_45 N_7_1 N_6_12 0.0029965f $X=0.729 $Y=0.135
cc_46 N_7_13 N_6_18 0.00381287f $X=0.729 $Y=0.135
cc_47 N_7_15 N_6_14 0.00381599f $X=0.702 $Y=0.171
cc_48 N_7_11 N_6_9 0.0426167f $X=0.6335 $Y=0.2025
cc_49 N_7_11 N_6_10 0.0209155f $X=0.6335 $Y=0.2025
cc_50 N_7_10 N_6_12 0.0342056f $X=0.783 $Y=0.135
x_PM_CKINVDCx9p33_ASAP7_75t_R%4 vss N_M2_g N_M28_g N_M3_g N_M29_g N_M4_d N_M5_d
+ N_M2_d N_M3_d N_4_15 N_4_4 N_4_3 N_4_17 N_4_10 N_4_11 N_4_18 N_4_1 N_4_14
+ N_4_9 PM_CKINVDCx9p33_ASAP7_75t_R%4
cc_51 N_4_15 N_A_22 3.94023e-20 $X=1.134 $Y=0.099
cc_52 N_4_15 N_A_4 0.000718377f $X=1.134 $Y=0.099
cc_53 N_4_4 N_A_42 0.000743172f $X=1.188 $Y=0.0675
cc_54 N_4_3 N_A_42 0.000749205f $X=1.08 $Y=0.0675
cc_55 N_4_17 N_A_42 0.000802744f $X=1.1745 $Y=0.099
cc_56 N_4_10 N_A_4 0.00084705f $X=1.215 $Y=0.135
cc_57 N_4_10 N_A_22 0.00333062f $X=1.215 $Y=0.135
cc_58 N_4_15 N_A_42 0.00655856f $X=1.134 $Y=0.099
cc_59 N_4_11 N_5_10 0.0322846f $X=1.0655 $Y=0.0675
cc_60 N_4_18 N_5_18 0.00127874f $X=1.1745 $Y=0.135
cc_61 N_4_15 N_5_16 0.00131967f $X=1.134 $Y=0.099
cc_62 N_4_10 N_5_4 0.00143019f $X=1.215 $Y=0.135
cc_63 N_4_3 N_5_9 0.00143019f $X=1.08 $Y=0.0675
cc_64 N_4_3 N_5_1 0.00174171f $X=1.08 $Y=0.0675
cc_65 N_4_1 N_5_4 0.00174171f $X=1.161 $Y=0.135
cc_66 N_4_11 N_5_1 0.00297262f $X=1.0655 $Y=0.0675
cc_67 N_4_1 N_5_12 0.00297262f $X=1.161 $Y=0.135
cc_68 N_4_15 N_5_13 0.00381287f $X=1.134 $Y=0.099
cc_69 N_4_14 N_5_18 0.00381599f $X=1.161 $Y=0.135
cc_70 N_4_10 N_5_12 0.0426167f $X=1.215 $Y=0.135
cc_71 N_4_9 N_5_12 0.0209155f $X=1.161 $Y=0.0245
cc_72 N_4_11 N_5_9 0.0342031f $X=1.0655 $Y=0.0675
x_PM_CKINVDCx9p33_ASAP7_75t_R%Y vss Y N_M0_d N_M1_d N_M26_d N_M27_d N_M32_d
+ N_M33_d N_M34_d N_M35_d N_M6_d N_M7_d N_M8_d N_M9_d N_M40_d N_M41_d N_M42_d
+ N_M43_d N_M14_d N_M15_d N_M16_d N_M17_d N_M48_d N_M49_d N_M50_d N_M51_d
+ N_M22_d N_M23_d N_M24_d N_M25_d N_Y_48 N_Y_70 N_Y_59 N_Y_63 N_Y_69 N_Y_61
+ N_Y_2 N_Y_8 N_Y_10 N_Y_12 N_Y_57 N_Y_73 N_Y_4 N_Y_6 N_Y_14 N_Y_58 N_Y_67
+ N_Y_65 N_Y_13 N_Y_78 N_Y_74 N_Y_82 N_Y_50 N_Y_43 N_Y_44 N_Y_45 N_Y_46 N_Y_47
+ N_Y_52 N_Y_54 N_Y_51 N_Y_53 N_Y_55 N_Y_49 N_Y_56 N_Y_5 N_Y_7 N_Y_9 N_Y_3
+ N_Y_1 N_Y_11 N_Y_71 N_Y_75 N_Y_81 N_Y_79 N_Y_83 N_Y_77 N_Y_72 N_Y_76 N_Y_80
+ PM_CKINVDCx9p33_ASAP7_75t_R%Y
cc_73 N_Y_48 N_A_39 2.58878e-20 $X=1.2815 $Y=0.054
cc_74 N_Y_48 N_A_28 2.66378e-20 $X=1.2815 $Y=0.054
cc_75 N_Y_48 N_A_30 2.78207e-20 $X=1.2815 $Y=0.054
cc_76 N_Y_70 N_A_45 4.52345e-20 $X=1.431 $Y=0.234
cc_77 N_Y_59 N_A_28 8.09086e-20 $X=0.405 $Y=0.072
cc_78 N_Y_63 N_A_30 8.6111e-20 $X=0.837 $Y=0.072
cc_79 N_Y_69 N_A_45 8.61182e-20 $X=1.431 $Y=0.072
cc_80 N_Y_61 N_A_29 0.000100269f $X=0.567 $Y=0.072
cc_81 N_Y_69 N_A_32 0.000103528f $X=1.431 $Y=0.072
cc_82 N_Y_2 N_A_13 0.000105792f $X=0.108 $Y=0.1755
cc_83 N_Y_8 N_A_18 0.000105792f $X=0.864 $Y=0.1755
cc_84 N_Y_10 N_A_21 0.000105792f $X=0.972 $Y=0.1755
cc_85 N_Y_12 N_A_22 0.000105792f $X=1.296 $Y=0.1755
cc_86 N_Y_63 N_A_31 0.000108083f $X=0.837 $Y=0.072
cc_87 N_Y_57 N_A_26 0.000109454f $X=0.0965 $Y=0.072
cc_88 N_Y_73 N_A_29 0.000115474f $X=0.405 $Y=0.2025
cc_89 N_Y_4 N_A_15 0.00012449f $X=0.432 $Y=0.1755
cc_90 N_Y_6 N_A_16 0.00254093f $X=0.54 $Y=0.1755
cc_91 N_Y_14 N_A_24 0.00012449f $X=1.404 $Y=0.1755
cc_92 N_Y_58 N_A_27 0.000157903f $X=0.135 $Y=0.234
cc_93 N_Y_57 N_A_27 0.000211891f $X=0.0965 $Y=0.072
cc_94 N_Y_59 N_A_29 0.000254309f $X=0.405 $Y=0.072
cc_95 N_Y_67 N_A_32 0.000297696f $X=1.269 $Y=0.072
cc_96 N_Y_67 N_A_33 0.000358503f $X=1.269 $Y=0.072
cc_97 N_Y_65 N_A_31 0.000370771f $X=0.999 $Y=0.072
cc_98 N_Y_13 N_A_44 0.000446591f $X=1.404 $Y=0.054
cc_99 N_Y_78 N_A_31 0.000526763f $X=0.8505 $Y=0.234
cc_100 N_Y_74 N_A_29 0.000551347f $X=0.4185 $Y=0.234
cc_101 N_Y_82 N_A_32 0.000552547f $X=1.2825 $Y=0.234
cc_102 N_Y_50 N_A_12 0.0390987f $X=0.0935 $Y=0.216
cc_103 N_Y_43 N_A_12 0.0206688f $X=0.0935 $Y=0.054
cc_104 N_Y_44 N_A_14 0.0484241f $X=0.4175 $Y=0.054
cc_105 N_Y_45 N_A_17 0.047967f $X=0.5255 $Y=0.054
cc_106 N_Y_46 N_A_18 0.0359891f $X=0.8495 $Y=0.054
cc_107 N_Y_47 N_A_20 0.0130908f $X=0.9575 $Y=0.054
cc_108 N_Y_52 N_A_17 0.0206433f $X=0.5255 $Y=0.216
cc_109 N_Y_54 N_A_21 0.0206433f $X=0.9575 $Y=0.216
cc_110 N_Y_51 N_A_15 0.0277698f $X=0.4175 $Y=0.216
cc_111 N_Y_53 N_A_19 0.0277709f $X=0.8495 $Y=0.216
cc_112 N_Y_55 N_A_23 0.027462f $X=1.2815 $Y=0.216
cc_113 N_Y_49 N_A_25 0.039774f $X=1.3895 $Y=0.054
cc_114 N_Y_56 N_A_24 0.0130736f $X=1.3895 $Y=0.216
cc_115 N_Y_5 N_A_38 0.000859731f $X=0.54 $Y=0.054
cc_116 N_Y_7 N_A_38 0.000859849f $X=0.864 $Y=0.054
cc_117 N_Y_9 N_A_42 0.000859849f $X=0.972 $Y=0.054
cc_118 N_Y_3 N_A_35 0.000867401f $X=0.432 $Y=0.054
cc_119 N_Y_1 N_A_35 0.000879983f $X=0.108 $Y=0.054
cc_120 N_Y_11 N_A_42 0.000879983f $X=1.296 $Y=0.054
cc_121 N_Y_69 N_A_44 0.000947497f $X=1.431 $Y=0.072
cc_122 N_Y_1 N_A_1 0.00496551f $X=0.108 $Y=0.054
cc_123 N_Y_12 N_A_4 0.0091836f $X=1.296 $Y=0.1755
cc_124 N_Y_8 N_A_3 0.00118433f $X=0.864 $Y=0.1755
cc_125 N_Y_10 N_A_3 0.00118433f $X=0.972 $Y=0.1755
cc_126 N_Y_5 N_A_2 0.00119758f $X=0.54 $Y=0.054
cc_127 N_Y_3 N_A_2 0.00918804f $X=0.432 $Y=0.054
cc_128 N_Y_57 N_A_34 0.00122662f $X=0.0965 $Y=0.072
cc_129 N_Y_14 N_A_4 0.00123342f $X=1.404 $Y=0.1755
cc_130 N_Y_63 N_A_41 0.00174014f $X=0.837 $Y=0.072
cc_131 N_Y_59 N_A_37 0.00189595f $X=0.405 $Y=0.072
cc_132 N_Y_67 N_A_44 0.00210808f $X=1.269 $Y=0.072
cc_133 N_Y_2 N_A_12 0.00235842f $X=0.108 $Y=0.1755
cc_134 N_Y_14 N_A_25 0.00236829f $X=1.404 $Y=0.1755
cc_135 N_Y_4 N_A_14 0.00242311f $X=0.432 $Y=0.1755
cc_136 N_Y_8 N_A_19 0.00242317f $X=0.864 $Y=0.1755
cc_137 N_Y_10 N_A_20 0.00242317f $X=0.972 $Y=0.1755
cc_138 N_Y_12 N_A_23 0.00242495f $X=1.296 $Y=0.1755
cc_139 N_Y_13 N_A_24 0.00258018f $X=1.404 $Y=0.054
cc_140 N_Y_5 N_A_17 0.00290495f $X=0.54 $Y=0.054
cc_141 N_Y_3 N_A_14 0.00291465f $X=0.432 $Y=0.054
cc_142 N_Y_1 N_A_12 0.00294864f $X=0.108 $Y=0.054
cc_143 N_Y_7 N_A_18 0.00296104f $X=0.864 $Y=0.054
cc_144 N_Y_9 N_A_21 0.00296104f $X=0.972 $Y=0.054
cc_145 N_Y_11 N_A_22 0.00296104f $X=1.296 $Y=0.054
cc_146 N_Y_63 N_A_38 0.0030548f $X=0.837 $Y=0.072
cc_147 N_Y_67 N_A_42 0.00307589f $X=1.269 $Y=0.072
cc_148 N_Y_57 N_A_35 0.00308191f $X=0.0965 $Y=0.072
cc_149 N_Y_71 N_A_27 0.0035976f $X=0.135 $Y=0.0855
cc_150 N_Y_75 N_A_39 0.00369726f $X=0.567 $Y=0.2025
cc_151 N_Y_81 N_A_32 0.00382455f $X=1.269 $Y=0.2025
cc_152 N_Y_73 N_A_36 0.0038907f $X=0.405 $Y=0.2025
cc_153 N_Y_79 N_A_43 0.00390805f $X=0.999 $Y=0.2025
cc_154 N_Y_83 N_A_45 0.0039268f $X=1.431 $Y=0.1845
cc_155 N_Y_77 N_A_40 0.00393456f $X=0.837 $Y=0.2025
cc_156 N_Y_56 N_A_25 0.00735567f $X=1.3895 $Y=0.216
cc_157 N_Y_51 N_A_14 0.02f $X=0.4175 $Y=0.216
cc_158 N_Y_53 N_A_18 0.02f $X=0.8495 $Y=0.216
cc_159 N_Y_55 N_A_22 0.02f $X=1.2815 $Y=0.216
cc_160 N_Y_9 N_A_3 0.00786027f $X=0.972 $Y=0.054
cc_161 N_Y_61 N_A_38 0.00920655f $X=0.567 $Y=0.072
cc_162 N_Y_59 N_A_35 0.00928946f $X=0.405 $Y=0.072
cc_163 N_Y_65 N_A_42 0.0092928f $X=0.999 $Y=0.072
cc_164 N_Y_46 N_A_19 0.0124545f $X=0.8495 $Y=0.054
cc_165 N_Y_48 N_A_23 0.0124545f $X=1.2815 $Y=0.054
cc_166 N_Y_54 N_A_20 0.0271276f $X=0.9575 $Y=0.216
cc_167 N_Y_45 N_A_16 0.0271276f $X=0.5255 $Y=0.054
cc_168 N_Y_43 N_A_13 0.0272785f $X=0.0935 $Y=0.054
cc_169 N_Y_49 N_A_24 0.0341877f $X=1.3895 $Y=0.054
cc_170 N_Y_47 N_A_21 0.0353528f $X=0.9575 $Y=0.054
cc_171 N_Y_48 N_A_22 0.036129f $X=1.2815 $Y=0.054
cc_172 N_Y_3 N_9_16 7.21906e-20 $X=0.432 $Y=0.054
cc_173 N_Y_1 N_9_16 9.42376e-20 $X=0.108 $Y=0.054
cc_174 N_Y_59 N_9_16 0.000310574f $X=0.405 $Y=0.072
cc_175 N_Y_73 N_9_16 0.000161931f $X=0.405 $Y=0.2025
cc_176 N_Y_57 N_9_16 0.00048707f $X=0.0965 $Y=0.072
cc_177 N_Y_72 N_9_16 0.000217455f $X=0.165 $Y=0.234
cc_178 N_Y_71 N_9_15 0.000682118f $X=0.135 $Y=0.0855
cc_179 N_Y_73 N_9_18 0.000837677f $X=0.405 $Y=0.2025
cc_180 N_Y_71 N_9_16 0.00204587f $X=0.135 $Y=0.0855
cc_181 N_Y_2 N_8_15 8.20667e-20 $X=0.108 $Y=0.1755
cc_182 N_Y_4 N_8_15 0.000102092f $X=0.432 $Y=0.1755
cc_183 N_Y_59 N_8_15 0.000104011f $X=0.405 $Y=0.072
cc_184 N_Y_73 N_8_15 0.000242034f $X=0.405 $Y=0.2025
cc_185 N_Y_71 N_8_15 0.000453448f $X=0.135 $Y=0.0855
cc_186 N_Y_73 N_8_17 0.00047705f $X=0.405 $Y=0.2025
cc_187 N_Y_72 N_8_4 0.00087488f $X=0.165 $Y=0.234
cc_188 N_Y_72 N_8_3 0.000900913f $X=0.165 $Y=0.234
cc_189 N_Y_73 N_8_18 0.00122657f $X=0.405 $Y=0.2025
cc_190 N_Y_72 N_8_18 0.00146628f $X=0.165 $Y=0.234
cc_191 N_Y_72 N_8_15 0.00702381f $X=0.165 $Y=0.234
cc_192 N_Y_5 N_6_16 9.02069e-20 $X=0.54 $Y=0.054
cc_193 N_Y_63 N_6_16 0.000315982f $X=0.837 $Y=0.072
cc_194 N_Y_77 N_6_16 0.000161931f $X=0.837 $Y=0.2025
cc_195 N_Y_61 N_6_16 0.000510937f $X=0.567 $Y=0.072
cc_196 N_Y_76 N_6_16 0.000216867f $X=0.597 $Y=0.234
cc_197 N_Y_75 N_6_15 0.000682118f $X=0.567 $Y=0.2025
cc_198 N_Y_77 N_6_18 0.000836005f $X=0.837 $Y=0.2025
cc_199 N_Y_75 N_6_16 0.00206494f $X=0.567 $Y=0.2025
cc_200 N_Y_6 N_7_15 8.25411e-20 $X=0.54 $Y=0.1755
cc_201 N_Y_7 N_7_15 9.70605e-20 $X=0.864 $Y=0.054
cc_202 N_Y_8 N_7_15 0.000102032f $X=0.864 $Y=0.1755
cc_203 N_Y_63 N_7_15 0.000131351f $X=0.837 $Y=0.072
cc_204 N_Y_77 N_7_15 0.000242034f $X=0.837 $Y=0.2025
cc_205 N_Y_75 N_7_15 0.000457535f $X=0.567 $Y=0.2025
cc_206 N_Y_77 N_7_17 0.000479917f $X=0.837 $Y=0.2025
cc_207 N_Y_76 N_7_4 0.00087488f $X=0.597 $Y=0.234
cc_208 N_Y_76 N_7_3 0.000900913f $X=0.597 $Y=0.234
cc_209 N_Y_77 N_7_18 0.0012588f $X=0.837 $Y=0.2025
cc_210 N_Y_76 N_7_18 0.00146628f $X=0.597 $Y=0.234
cc_211 N_Y_76 N_7_15 0.00701086f $X=0.597 $Y=0.234
cc_212 N_Y_10 N_5_18 0.000102032f $X=0.972 $Y=0.1755
cc_213 N_Y_79 N_5_18 0.000357779f $X=0.999 $Y=0.2025
cc_214 N_Y_65 N_5_18 0.000132451f $X=0.999 $Y=0.072
cc_215 N_Y_81 N_5_18 0.000462204f $X=1.269 $Y=0.2025
cc_216 N_Y_79 N_5_16 0.000479917f $X=0.999 $Y=0.2025
cc_217 N_Y_80 N_5_3 0.00087488f $X=1.0275 $Y=0.234
cc_218 N_Y_80 N_5_4 0.000900913f $X=1.0275 $Y=0.234
cc_219 N_Y_79 N_5_15 0.0012588f $X=0.999 $Y=0.2025
cc_220 N_Y_80 N_5_15 0.00146628f $X=1.0275 $Y=0.234
cc_221 N_Y_80 N_5_18 0.00705599f $X=1.0275 $Y=0.234
cc_222 N_Y_11 N_4_18 9.41541e-20 $X=1.296 $Y=0.054
cc_223 N_Y_12 N_4_18 0.000104993f $X=1.296 $Y=0.1755
cc_224 N_Y_65 N_4_18 0.000316742f $X=0.999 $Y=0.072
cc_225 N_Y_79 N_4_18 0.000161931f $X=0.999 $Y=0.2025
cc_226 N_Y_67 N_4_18 0.00050464f $X=1.269 $Y=0.072
cc_227 N_Y_80 N_4_18 0.00021706f $X=1.0275 $Y=0.234
cc_228 N_Y_81 N_4_17 0.000682118f $X=1.269 $Y=0.2025
cc_229 N_Y_79 N_4_15 0.000837832f $X=0.999 $Y=0.2025
cc_230 N_Y_81 N_4_18 0.00211403f $X=1.269 $Y=0.2025
x_PM_CKINVDCx9p33_ASAP7_75t_R%9 vss N_M20_g N_M46_g N_M21_g N_M47_g N_M20_d
+ N_M21_d N_M18_d N_M19_d N_9_18 N_9_4 N_9_15 N_9_1 N_9_9 N_9_12 N_9_16 N_9_14
+ N_9_10 PM_CKINVDCx9p33_ASAP7_75t_R%9
cc_231 N_9_18 N_A_27 4.88304e-20 $X=0.27 $Y=0.099
cc_232 N_9_18 N_A_1 0.000210369f $X=0.27 $Y=0.099
cc_233 N_9_4 N_A_35 0.000749205f $X=0.324 $Y=0.0675
cc_234 N_9_15 N_A_35 0.000802744f $X=0.2015 $Y=0.099
cc_235 N_9_1 N_A_1 0.00104426f $X=0.189 $Y=0.135
cc_236 N_9_9 N_A_13 0.0033358f $X=0.189 $Y=0.0245
cc_237 N_9_18 N_A_35 0.00725515f $X=0.27 $Y=0.099
x_PM_CKINVDCx9p33_ASAP7_75t_R%A vss A N_M0_g N_M26_g N_M1_g N_M27_g N_M6_g
+ N_M32_g N_M7_g N_M33_g N_M8_g N_M34_g N_M9_g N_M35_g N_M14_g N_M40_g N_M15_g
+ N_M41_g N_M16_g N_M42_g N_M17_g N_M43_g N_M22_g N_M48_g N_M23_g N_M49_g
+ N_M24_g N_M50_g N_M25_g N_M51_g N_A_27 N_A_1 N_A_35 N_A_13 N_A_37 N_A_2
+ N_A_14 N_A_38 N_A_17 N_A_41 N_A_3 N_A_18 N_A_42 N_A_4 N_A_21 N_A_22 N_A_39
+ N_A_28 N_A_30 N_A_45 N_A_29 N_A_32 N_A_31 N_A_26 N_A_15 N_A_16 N_A_24 N_A_33
+ N_A_44 N_A_12 N_A_20 N_A_19 N_A_23 N_A_25 N_A_34 N_A_36 N_A_43 N_A_40
+ PM_CKINVDCx9p33_ASAP7_75t_R%A

* End of included file CKINVDCx9p33_ASAP7_75t_R.pex.sp.pxi
.ends

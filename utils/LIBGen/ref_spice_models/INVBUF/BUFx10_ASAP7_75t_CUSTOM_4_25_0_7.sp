.subckt PM_BUFx10_ASAP7_75t_R%A vss 25 11 17 32 35 4 7 5 10 1 3
c1 1 vss 0.00833049f $X=0.0715 $Y=0.135
c2 3 vss 0.0882863f $X=0.081 $Y=0.0245
c3 4 vss 0.081113f $X=0.135 $Y=0.135
c4 5 vss 0.00780732f $X=0.027 $Y=0.036
c5 6 vss 0.00157018f $X=0.027 $Y=0.135
c6 7 vss 0.00793942f $X=0.027 $Y=0.234
c7 8 vss 0.00884011f $X=0.027 $Y=0.0855
c8 9 vss 0.00880545f $X=0.027 $Y=0.1845
c9 10 vss 0.00299069f $X=0.0555 $Y=0.135
r1 7 9 10.3626 $w=1.39091e-08 $l=4.95e-08 $layer=M1 $thickness=3.6e-08 $X=0.027
+ $Y=0.234 $X2=0.027 $Y2=0.1845
r2 5 8 10.3626 $w=1.39091e-08 $l=4.95e-08 $layer=M1 $thickness=3.6e-08 $X=0.027
+ $Y=0.036 $X2=0.027 $Y2=0.0855
r3 6 29 3.1337 $w=1.54324e-08 $l=1.85e-08 $layer=M1 $thickness=3.6e-08 $X=0.027
+ $Y=0.135 $X2=0.0455 $Y2=0.135
r4 6 8 10.3626 $w=1.39091e-08 $l=4.95e-08 $layer=M1 $thickness=3.6e-08 $X=0.027
+ $Y=0.135 $X2=0.027 $Y2=0.0855
r5 6 9 10.3626 $w=1.39091e-08 $l=4.95e-08 $layer=M1 $thickness=3.6e-08 $X=0.027
+ $Y=0.135 $X2=0.027 $Y2=0.1845
r6 35 34 16.4967 $w=2.1e-08 $l=4.85e-08 $layer=Gate_1 $thickness=5.6e-08
+ $X=0.135 $Y=0.2025 $X2=0.135 $Y2=0.154
r7 32 33 16.4967 $w=2.1e-08 $l=4.85e-08 $layer=Gate_1 $thickness=5.6e-08
+ $X=0.135 $Y=0.0675 $X2=0.135 $Y2=0.116
r8 4 23 6.54019 $w=2.09524e-08 $layer=Gate_1 $thickness=5.21905e-08 $X=0.135
+ $Y=0.135 $X2=0.135 $Y2=0.135
r9 4 33 6.6497 $w=2.04211e-08 $l=1.9e-08 $layer=Gate_1 $thickness=5.6e-08
+ $X=0.135 $Y=0.135 $X2=0.135 $Y2=0.116
r10 4 34 6.6497 $w=2.04211e-08 $l=1.9e-08 $layer=Gate_1 $thickness=5.6e-08
+ $X=0.135 $Y=0.135 $X2=0.135 $Y2=0.154
r11 26 27 3.84763 $w=1.3e-08 $l=1.65e-08 $layer=M1 $thickness=3.6e-08 $X=0.0645
+ $Y=0.135 $X2=0.081 $Y2=0.135
r12 25 26 1.86552 $w=1.3e-08 $l=8e-09 $layer=M1 $thickness=3.6e-08 $X=0.0565
+ $Y=0.1325 $X2=0.0645 $Y2=0.135
r13 25 10 0.23319 $w=1.3e-08 $l=1e-09 $layer=M1 $thickness=3.6e-08 $X=0.0565
+ $Y=0.1325 $X2=0.0555 $Y2=0.135
r14 10 29 2.3319 $w=1.3e-08 $l=1e-08 $layer=M1 $thickness=3.6e-08 $X=0.0555
+ $Y=0.135 $X2=0.0455 $Y2=0.135
r15 22 23 12.6539 $w=1.77815e-08 $l=2.7e-08 $layer=LIG $thickness=4.8e-08
+ $X=0.108 $Y=0.135 $X2=0.135 $Y2=0.135
r16 20 22 10.1729 $w=1.54914e-08 $l=1.75e-08 $layer=LIG $thickness=4.8e-08
+ $X=0.0905 $Y=0.135 $X2=0.108 $Y2=0.135
r17 19 20 2.48102 $w=2.2e-08 $l=9.5e-09 $layer=LIG $thickness=4.8e-08 $X=0.081
+ $Y=0.135 $X2=0.0905 $Y2=0.135
r18 19 27 19.3796 $a=3.24e-16 $layer=V0LIG $X=0.081 $Y=0.135 $X2=0.081 $Y2=0.135
r19 1 19 2.48102 $w=2.2e-08 $l=9.5e-09 $layer=LIG $thickness=4.8e-08 $X=0.0715
+ $Y=0.135 $X2=0.081 $Y2=0.135
r20 17 16 14.6259 $w=2.1e-08 $l=4.3e-08 $layer=Gate_1 $thickness=5.6e-08
+ $X=0.081 $Y=0.2025 $X2=0.081 $Y2=0.1595
r21 15 16 2.7211 $w=2.1e-08 $l=8e-09 $layer=Gate_1 $thickness=5.6e-08 $X=0.081
+ $Y=0.1515 $X2=0.081 $Y2=0.1595
r22 14 15 5.79936 $w=2.03333e-08 $l=1.65e-08 $layer=Gate_1 $thickness=5.6e-08
+ $X=0.081 $Y=0.135 $X2=0.081 $Y2=0.1515
r23 14 20 4.05918 $w=2.0087e-08 $l=9.5e-09 $layer=Gate_1 $thickness=5.56522e-08
+ $X=0.081 $Y=0.135 $X2=0.0905 $Y2=0.135
r24 14 19 6.27904 $w=2.09e-08 $layer=Gate_1 $thickness=5.24e-08 $X=0.081
+ $Y=0.135 $X2=0.081 $Y2=0.135
r25 13 14 5.79936 $w=2.03333e-08 $l=1.65e-08 $layer=Gate_1 $thickness=5.6e-08
+ $X=0.081 $Y=0.1185 $X2=0.081 $Y2=0.135
r26 12 13 2.7211 $w=2.1e-08 $l=8e-09 $layer=Gate_1 $thickness=5.6e-08 $X=0.081
+ $Y=0.1105 $X2=0.081 $Y2=0.1185
r27 11 12 14.6259 $w=2.1e-08 $l=4.3e-08 $layer=Gate_1 $thickness=5.6e-08
+ $X=0.081 $Y=0.0675 $X2=0.081 $Y2=0.1105
r28 11 3 14.6259 $w=2.1e-08 $l=4.3e-08 $layer=Gate_1 $thickness=5.6e-08
+ $X=0.081 $Y=0.0675 $X2=0.081 $Y2=0.0245
.ends

.subckt PM_BUFx10_ASAP7_75t_R%Y vss 78 48 49 63 64 67 68 71 72 75 76 94 95 98
+ 99 102 103 106 107 110 111 33 7 1 4 6 8 10 36 31 37 38 39 32 34 35 40 45 9 3
+ 5 2 43 44
c1 1 vss 0.00826758f $X=0.216 $Y=0.0675
c2 2 vss 0.00822338f $X=0.216 $Y=0.2025
c3 3 vss 0.00817321f $X=0.324 $Y=0.0675
c4 4 vss 0.00817321f $X=0.324 $Y=0.2025
c5 5 vss 0.00817321f $X=0.432 $Y=0.0675
c6 6 vss 0.00817321f $X=0.432 $Y=0.2025
c7 7 vss 0.00817321f $X=0.54 $Y=0.0675
c8 8 vss 0.00817321f $X=0.54 $Y=0.2025
c9 9 vss 0.00826383f $X=0.648 $Y=0.0675
c10 10 vss 0.00826383f $X=0.648 $Y=0.2025
c11 31 vss 0.00432077f $X=0.2015 $Y=0.0675
c12 32 vss 0.00409573f $X=0.3095 $Y=0.0675
c13 33 vss 0.00409573f $X=0.4175 $Y=0.0675
c14 34 vss 0.00409573f $X=0.5255 $Y=0.0675
c15 35 vss 0.0042259f $X=0.6335 $Y=0.0675
c16 36 vss 0.00432083f $X=0.2015 $Y=0.2025
c17 37 vss 0.00407754f $X=0.3095 $Y=0.2025
c18 38 vss 0.00407754f $X=0.4175 $Y=0.2025
c19 39 vss 0.00407754f $X=0.5255 $Y=0.2025
c20 40 vss 0.00422484f $X=0.6335 $Y=0.2025
c21 41 vss 0.00286188f $X=0.729 $Y=0.036
c22 42 vss 0.00286188f $X=0.729 $Y=0.234
c23 43 vss 0.0453468f $X=0.203 $Y=0.036
c24 44 vss 0.0453273f $X=0.7045 $Y=0.234
c25 45 vss 0.00783652f $X=0.729 $Y=0.0855
r1 111 109 0.0308642 $w=8.1e-08 $l=2.5e-09 $layer=P_src_drn $thickness=1e-09
+ $X=0.6653 $Y=0.2025 $X2=0.6625 $Y2=0.2025
r2 10 109 0.179012 $w=8.1e-08 $l=1.45e-08 $layer=P_src_drn $thickness=1e-09
+ $X=0.648 $Y=0.2025 $X2=0.6625 $Y2=0.2025
r3 40 10 0.179012 $w=8.1e-08 $l=1.45e-08 $layer=P_src_drn $thickness=1e-09
+ $X=0.6335 $Y=0.2025 $X2=0.648 $Y2=0.2025
r4 110 40 0.0308642 $w=8.1e-08 $l=2.5e-09 $layer=P_src_drn $thickness=1e-09
+ $X=0.6306 $Y=0.2025 $X2=0.6335 $Y2=0.2025
r5 107 105 0.0308642 $w=8.1e-08 $l=2.5e-09 $layer=P_src_drn $thickness=1e-09
+ $X=0.5573 $Y=0.2025 $X2=0.5545 $Y2=0.2025
r6 8 105 0.179012 $w=8.1e-08 $l=1.45e-08 $layer=P_src_drn $thickness=1e-09
+ $X=0.54 $Y=0.2025 $X2=0.5545 $Y2=0.2025
r7 39 8 0.179012 $w=8.1e-08 $l=1.45e-08 $layer=P_src_drn $thickness=1e-09
+ $X=0.5255 $Y=0.2025 $X2=0.54 $Y2=0.2025
r8 106 39 0.0308642 $w=8.1e-08 $l=2.5e-09 $layer=P_src_drn $thickness=1e-09
+ $X=0.5226 $Y=0.2025 $X2=0.5255 $Y2=0.2025
r9 103 101 0.0308642 $w=8.1e-08 $l=2.5e-09 $layer=P_src_drn $thickness=1e-09
+ $X=0.4493 $Y=0.2025 $X2=0.4465 $Y2=0.2025
r10 6 101 0.179012 $w=8.1e-08 $l=1.45e-08 $layer=P_src_drn $thickness=1e-09
+ $X=0.432 $Y=0.2025 $X2=0.4465 $Y2=0.2025
r11 38 6 0.179012 $w=8.1e-08 $l=1.45e-08 $layer=P_src_drn $thickness=1e-09
+ $X=0.4175 $Y=0.2025 $X2=0.432 $Y2=0.2025
r12 102 38 0.0308642 $w=8.1e-08 $l=2.5e-09 $layer=P_src_drn $thickness=1e-09
+ $X=0.4146 $Y=0.2025 $X2=0.4175 $Y2=0.2025
r13 99 97 0.0308642 $w=8.1e-08 $l=2.5e-09 $layer=P_src_drn $thickness=1e-09
+ $X=0.3413 $Y=0.2025 $X2=0.3385 $Y2=0.2025
r14 4 97 0.179012 $w=8.1e-08 $l=1.45e-08 $layer=P_src_drn $thickness=1e-09
+ $X=0.324 $Y=0.2025 $X2=0.3385 $Y2=0.2025
r15 37 4 0.179012 $w=8.1e-08 $l=1.45e-08 $layer=P_src_drn $thickness=1e-09
+ $X=0.3095 $Y=0.2025 $X2=0.324 $Y2=0.2025
r16 98 37 0.0308642 $w=8.1e-08 $l=2.5e-09 $layer=P_src_drn $thickness=1e-09
+ $X=0.3066 $Y=0.2025 $X2=0.3095 $Y2=0.2025
r17 95 93 0.0308642 $w=8.1e-08 $l=2.5e-09 $layer=P_src_drn $thickness=1e-09
+ $X=0.2333 $Y=0.2025 $X2=0.2305 $Y2=0.2025
r18 2 93 0.179012 $w=8.1e-08 $l=1.45e-08 $layer=P_src_drn $thickness=1e-09
+ $X=0.216 $Y=0.2025 $X2=0.2305 $Y2=0.2025
r19 36 2 0.179012 $w=8.1e-08 $l=1.45e-08 $layer=P_src_drn $thickness=1e-09
+ $X=0.2015 $Y=0.2025 $X2=0.216 $Y2=0.2025
r20 94 36 0.0308642 $w=8.1e-08 $l=2.5e-09 $layer=P_src_drn $thickness=1e-09
+ $X=0.1986 $Y=0.2025 $X2=0.2015 $Y2=0.2025
r21 10 90 19.3796 $a=3.24e-16 $layer=V0LISD $X=0.648 $Y=0.2025 $X2=0.648
+ $Y2=0.234
r22 8 88 19.3796 $a=3.24e-16 $layer=V0LISD $X=0.54 $Y=0.2025 $X2=0.54 $Y2=0.234
r23 6 86 19.3796 $a=3.24e-16 $layer=V0LISD $X=0.432 $Y=0.2025 $X2=0.432
+ $Y2=0.234
r24 4 84 19.3796 $a=3.24e-16 $layer=V0LISD $X=0.324 $Y=0.2025 $X2=0.324
+ $Y2=0.234
r25 2 82 19.3796 $a=3.24e-16 $layer=V0LISD $X=0.216 $Y=0.2025 $X2=0.216
+ $Y2=0.234
r26 90 91 5.82974 $w=1.3e-08 $l=2.5e-08 $layer=M1 $thickness=3.6e-08 $X=0.648
+ $Y=0.234 $X2=0.673 $Y2=0.234
r27 89 90 12.5922 $w=1.3e-08 $l=5.4e-08 $layer=M1 $thickness=3.6e-08 $X=0.594
+ $Y=0.234 $X2=0.648 $Y2=0.234
r28 88 89 12.5922 $w=1.3e-08 $l=5.4e-08 $layer=M1 $thickness=3.6e-08 $X=0.54
+ $Y=0.234 $X2=0.594 $Y2=0.234
r29 87 88 12.5922 $w=1.3e-08 $l=5.4e-08 $layer=M1 $thickness=3.6e-08 $X=0.486
+ $Y=0.234 $X2=0.54 $Y2=0.234
r30 86 87 12.5922 $w=1.3e-08 $l=5.4e-08 $layer=M1 $thickness=3.6e-08 $X=0.432
+ $Y=0.234 $X2=0.486 $Y2=0.234
r31 85 86 12.5922 $w=1.3e-08 $l=5.4e-08 $layer=M1 $thickness=3.6e-08 $X=0.378
+ $Y=0.234 $X2=0.432 $Y2=0.234
r32 84 85 12.5922 $w=1.3e-08 $l=5.4e-08 $layer=M1 $thickness=3.6e-08 $X=0.324
+ $Y=0.234 $X2=0.378 $Y2=0.234
r33 83 84 12.5922 $w=1.3e-08 $l=5.4e-08 $layer=M1 $thickness=3.6e-08 $X=0.27
+ $Y=0.234 $X2=0.324 $Y2=0.234
r34 82 83 12.5922 $w=1.3e-08 $l=5.4e-08 $layer=M1 $thickness=3.6e-08 $X=0.216
+ $Y=0.234 $X2=0.27 $Y2=0.234
r35 44 91 7.34548 $w=1.3e-08 $l=3.15e-08 $layer=M1 $thickness=3.6e-08 $X=0.7045
+ $Y=0.234 $X2=0.673 $Y2=0.234
r36 42 80 9.89378 $w=1.47818e-08 $l=4.95e-08 $layer=M1 $thickness=3.6e-08
+ $X=0.729 $Y=0.234 $X2=0.729 $Y2=0.1845
r37 42 44 4.06404 $w=1.48367e-08 $l=2.45e-08 $layer=M1 $thickness=3.6e-08
+ $X=0.729 $Y=0.234 $X2=0.7045 $Y2=0.234
r38 79 80 9.91056 $w=1.3e-08 $l=4.25e-08 $layer=M1 $thickness=3.6e-08 $X=0.729
+ $Y=0.142 $X2=0.729 $Y2=0.1845
r39 78 79 0.582974 $w=1.3e-08 $l=2.5e-09 $layer=M1 $thickness=3.6e-08 $X=0.7295
+ $Y=0.1395 $X2=0.729 $Y2=0.142
r40 78 77 1.63233 $w=1.3e-08 $l=7e-09 $layer=M1 $thickness=3.6e-08 $X=0.7295
+ $Y=0.1395 $X2=0.729 $Y2=0.1325
r41 45 77 10.9599 $w=1.3e-08 $l=4.7e-08 $layer=M1 $thickness=3.6e-08 $X=0.729
+ $Y=0.0855 $X2=0.729 $Y2=0.1325
r42 76 74 0.0308642 $w=8.1e-08 $l=2.5e-09 $layer=N_src_drn $thickness=1e-09
+ $X=0.5573 $Y=0.0675 $X2=0.5545 $Y2=0.0675
r43 7 74 0.179012 $w=8.1e-08 $l=1.45e-08 $layer=N_src_drn $thickness=1e-09
+ $X=0.54 $Y=0.0675 $X2=0.5545 $Y2=0.0675
r44 34 7 0.179012 $w=8.1e-08 $l=1.45e-08 $layer=N_src_drn $thickness=1e-09
+ $X=0.5255 $Y=0.0675 $X2=0.54 $Y2=0.0675
r45 75 34 0.0308642 $w=8.1e-08 $l=2.5e-09 $layer=N_src_drn $thickness=1e-09
+ $X=0.5226 $Y=0.0675 $X2=0.5255 $Y2=0.0675
r46 72 70 0.0308642 $w=8.1e-08 $l=2.5e-09 $layer=N_src_drn $thickness=1e-09
+ $X=0.4493 $Y=0.0675 $X2=0.4465 $Y2=0.0675
r47 5 70 0.179012 $w=8.1e-08 $l=1.45e-08 $layer=N_src_drn $thickness=1e-09
+ $X=0.432 $Y=0.0675 $X2=0.4465 $Y2=0.0675
r48 33 5 0.179012 $w=8.1e-08 $l=1.45e-08 $layer=N_src_drn $thickness=1e-09
+ $X=0.4175 $Y=0.0675 $X2=0.432 $Y2=0.0675
r49 71 33 0.0308642 $w=8.1e-08 $l=2.5e-09 $layer=N_src_drn $thickness=1e-09
+ $X=0.4146 $Y=0.0675 $X2=0.4175 $Y2=0.0675
r50 68 66 0.0308642 $w=8.1e-08 $l=2.5e-09 $layer=N_src_drn $thickness=1e-09
+ $X=0.3413 $Y=0.0675 $X2=0.3385 $Y2=0.0675
r51 3 66 0.179012 $w=8.1e-08 $l=1.45e-08 $layer=N_src_drn $thickness=1e-09
+ $X=0.324 $Y=0.0675 $X2=0.3385 $Y2=0.0675
r52 32 3 0.179012 $w=8.1e-08 $l=1.45e-08 $layer=N_src_drn $thickness=1e-09
+ $X=0.3095 $Y=0.0675 $X2=0.324 $Y2=0.0675
r53 67 32 0.0308642 $w=8.1e-08 $l=2.5e-09 $layer=N_src_drn $thickness=1e-09
+ $X=0.3066 $Y=0.0675 $X2=0.3095 $Y2=0.0675
r54 64 62 0.0308642 $w=8.1e-08 $l=2.5e-09 $layer=N_src_drn $thickness=1e-09
+ $X=0.2333 $Y=0.0675 $X2=0.2305 $Y2=0.0675
r55 1 62 0.179012 $w=8.1e-08 $l=1.45e-08 $layer=N_src_drn $thickness=1e-09
+ $X=0.216 $Y=0.0675 $X2=0.2305 $Y2=0.0675
r56 31 1 0.179012 $w=8.1e-08 $l=1.45e-08 $layer=N_src_drn $thickness=1e-09
+ $X=0.2015 $Y=0.0675 $X2=0.216 $Y2=0.0675
r57 63 31 0.0308642 $w=8.1e-08 $l=2.5e-09 $layer=N_src_drn $thickness=1e-09
+ $X=0.1986 $Y=0.0675 $X2=0.2015 $Y2=0.0675
r58 41 60 4.06404 $w=1.48367e-08 $l=2.45e-08 $layer=M1 $thickness=3.6e-08
+ $X=0.729 $Y=0.036 $X2=0.7045 $Y2=0.036
r59 41 45 9.89378 $w=1.47818e-08 $l=4.95e-08 $layer=M1 $thickness=3.6e-08
+ $X=0.729 $Y=0.036 $X2=0.729 $Y2=0.0855
r60 7 56 19.3796 $a=3.24e-16 $layer=V0LISD $X=0.54 $Y=0.0675 $X2=0.54 $Y2=0.036
r61 5 54 19.3796 $a=3.24e-16 $layer=V0LISD $X=0.432 $Y=0.0675 $X2=0.432
+ $Y2=0.036
r62 3 52 19.3796 $a=3.24e-16 $layer=V0LISD $X=0.324 $Y=0.0675 $X2=0.324
+ $Y2=0.036
r63 1 50 19.3796 $a=3.24e-16 $layer=V0LISD $X=0.216 $Y=0.0675 $X2=0.216
+ $Y2=0.036
r64 59 60 7.34548 $w=1.3e-08 $l=3.15e-08 $layer=M1 $thickness=3.6e-08 $X=0.673
+ $Y=0.036 $X2=0.7045 $Y2=0.036
r65 58 59 5.82974 $w=1.3e-08 $l=2.5e-08 $layer=M1 $thickness=3.6e-08 $X=0.648
+ $Y=0.036 $X2=0.673 $Y2=0.036
r66 57 58 12.5922 $w=1.3e-08 $l=5.4e-08 $layer=M1 $thickness=3.6e-08 $X=0.594
+ $Y=0.036 $X2=0.648 $Y2=0.036
r67 56 57 12.5922 $w=1.3e-08 $l=5.4e-08 $layer=M1 $thickness=3.6e-08 $X=0.54
+ $Y=0.036 $X2=0.594 $Y2=0.036
r68 55 56 12.5922 $w=1.3e-08 $l=5.4e-08 $layer=M1 $thickness=3.6e-08 $X=0.486
+ $Y=0.036 $X2=0.54 $Y2=0.036
r69 54 55 12.5922 $w=1.3e-08 $l=5.4e-08 $layer=M1 $thickness=3.6e-08 $X=0.432
+ $Y=0.036 $X2=0.486 $Y2=0.036
r70 53 54 12.5922 $w=1.3e-08 $l=5.4e-08 $layer=M1 $thickness=3.6e-08 $X=0.378
+ $Y=0.036 $X2=0.432 $Y2=0.036
r71 52 53 12.5922 $w=1.3e-08 $l=5.4e-08 $layer=M1 $thickness=3.6e-08 $X=0.324
+ $Y=0.036 $X2=0.378 $Y2=0.036
r72 51 52 12.5922 $w=1.3e-08 $l=5.4e-08 $layer=M1 $thickness=3.6e-08 $X=0.27
+ $Y=0.036 $X2=0.324 $Y2=0.036
r73 50 51 12.5922 $w=1.3e-08 $l=5.4e-08 $layer=M1 $thickness=3.6e-08 $X=0.216
+ $Y=0.036 $X2=0.27 $Y2=0.036
r74 43 50 3.03147 $w=1.3e-08 $l=1.3e-08 $layer=M1 $thickness=3.6e-08 $X=0.203
+ $Y=0.036 $X2=0.216 $Y2=0.036
r75 9 58 19.3796 $a=3.24e-16 $layer=V0LISD $X=0.648 $Y=0.0675 $X2=0.648
+ $Y2=0.036
r76 49 47 0.0308642 $w=8.1e-08 $l=2.5e-09 $layer=N_src_drn $thickness=1e-09
+ $X=0.6653 $Y=0.0675 $X2=0.6625 $Y2=0.0675
r77 9 47 0.179012 $w=8.1e-08 $l=1.45e-08 $layer=N_src_drn $thickness=1e-09
+ $X=0.648 $Y=0.0675 $X2=0.6625 $Y2=0.0675
r78 35 9 0.179012 $w=8.1e-08 $l=1.45e-08 $layer=N_src_drn $thickness=1e-09
+ $X=0.6335 $Y=0.0675 $X2=0.648 $Y2=0.0675
r79 48 35 0.0308642 $w=8.1e-08 $l=2.5e-09 $layer=N_src_drn $thickness=1e-09
+ $X=0.6306 $Y=0.0675 $X2=0.6335 $Y2=0.0675
.ends

.subckt PM_BUFx10_ASAP7_75t_R%4 vss 36 40 104 107 110 113 116 119 122 125 128
+ 131 134 137 140 143 146 149 153 157 169 170 173 174 35 1 30 31 12 29 33 34 18
+ 13 32 28 20 22 24 26 19 21 23 25 27
c1 1 vss 0.0823196f $X=0.6115 $Y=0.135
c2 12 vss 0.0154256f $X=0.108 $Y=0.0675
c3 13 vss 0.0154256f $X=0.108 $Y=0.2025
c4 18 vss 0.0834506f $X=0.189 $Y=0.135
c5 19 vss 0.0837895f $X=0.243 $Y=0.135
c6 20 vss 0.0837838f $X=0.297 $Y=0.135
c7 21 vss 0.0837838f $X=0.351 $Y=0.135
c8 22 vss 0.0837838f $X=0.405 $Y=0.135
c9 23 vss 0.0837838f $X=0.459 $Y=0.135
c10 24 vss 0.0837838f $X=0.513 $Y=0.135
c11 25 vss 0.0836437f $X=0.567 $Y=0.135
c12 26 vss 0.0840946f $X=0.621 $Y=0.0245
c13 27 vss 0.0840848f $X=0.675 $Y=0.135
c14 28 vss 0.0143327f $X=0.0935 $Y=0.0675
c15 29 vss 0.0143366f $X=0.0935 $Y=0.2025
c16 30 vss 0.00963801f $X=0.135 $Y=0.036
c17 31 vss 0.00963801f $X=0.135 $Y=0.234
c18 32 vss 0.00338313f $X=0.135 $Y=0.135
c19 33 vss 0.00610713f $X=0.135 $Y=0.0855
c20 34 vss 0.00610713f $X=0.135 $Y=0.1845
c21 35 vss 0.0139737f $X=0.2165 $Y=0.135
r1 174 172 0.0308642 $w=8.1e-08 $l=2.5e-09 $layer=P_src_drn $thickness=1e-09
+ $X=0.1253 $Y=0.2025 $X2=0.1225 $Y2=0.2025
r2 13 172 0.179012 $w=8.1e-08 $l=1.45e-08 $layer=P_src_drn $thickness=1e-09
+ $X=0.108 $Y=0.2025 $X2=0.1225 $Y2=0.2025
r3 29 13 0.179012 $w=8.1e-08 $l=1.45e-08 $layer=P_src_drn $thickness=1e-09
+ $X=0.0935 $Y=0.2025 $X2=0.108 $Y2=0.2025
r4 173 29 0.0308642 $w=8.1e-08 $l=2.5e-09 $layer=P_src_drn $thickness=1e-09
+ $X=0.0906 $Y=0.2025 $X2=0.0935 $Y2=0.2025
r5 170 168 0.0308642 $w=8.1e-08 $l=2.5e-09 $layer=N_src_drn $thickness=1e-09
+ $X=0.1253 $Y=0.0675 $X2=0.1225 $Y2=0.0675
r6 12 168 0.179012 $w=8.1e-08 $l=1.45e-08 $layer=N_src_drn $thickness=1e-09
+ $X=0.108 $Y=0.0675 $X2=0.1225 $Y2=0.0675
r7 28 12 0.179012 $w=8.1e-08 $l=1.45e-08 $layer=N_src_drn $thickness=1e-09
+ $X=0.0935 $Y=0.0675 $X2=0.108 $Y2=0.0675
r8 169 28 0.0308642 $w=8.1e-08 $l=2.5e-09 $layer=N_src_drn $thickness=1e-09
+ $X=0.0906 $Y=0.0675 $X2=0.0935 $Y2=0.0675
r9 13 164 19.3796 $a=3.24e-16 $layer=V0LISD $X=0.108 $Y=0.2025 $X2=0.108
+ $Y2=0.234
r10 12 160 19.3796 $a=3.24e-16 $layer=V0LISD $X=0.108 $Y=0.0675 $X2=0.108
+ $Y2=0.036
r11 164 165 3.14806 $w=1.3e-08 $l=1.35e-08 $layer=M1 $thickness=3.6e-08
+ $X=0.108 $Y=0.234 $X2=0.1215 $Y2=0.234
r12 31 34 10.3626 $w=1.39091e-08 $l=4.95e-08 $layer=M1 $thickness=3.6e-08
+ $X=0.135 $Y=0.234 $X2=0.135 $Y2=0.1845
r13 31 165 1.96775 $w=1.63333e-08 $l=1.35e-08 $layer=M1 $thickness=3.6e-08
+ $X=0.135 $Y=0.234 $X2=0.1215 $Y2=0.234
r14 160 161 3.14806 $w=1.3e-08 $l=1.35e-08 $layer=M1 $thickness=3.6e-08
+ $X=0.108 $Y=0.036 $X2=0.1215 $Y2=0.036
r15 30 33 10.3626 $w=1.39091e-08 $l=4.95e-08 $layer=M1 $thickness=3.6e-08
+ $X=0.135 $Y=0.036 $X2=0.135 $Y2=0.0855
r16 30 161 1.96775 $w=1.63333e-08 $l=1.35e-08 $layer=M1 $thickness=3.6e-08
+ $X=0.135 $Y=0.036 $X2=0.1215 $Y2=0.036
r17 32 100 5.11582 $w=1.46667e-08 $l=2.7e-08 $layer=M1 $thickness=3.6e-08
+ $X=0.135 $Y=0.135 $X2=0.162 $Y2=0.135
r18 32 33 10.3626 $w=1.39091e-08 $l=4.95e-08 $layer=M1 $thickness=3.6e-08
+ $X=0.135 $Y=0.135 $X2=0.135 $Y2=0.0855
r19 32 34 10.3626 $w=1.39091e-08 $l=4.95e-08 $layer=M1 $thickness=3.6e-08
+ $X=0.135 $Y=0.135 $X2=0.135 $Y2=0.1845
r20 157 156 14.6259 $w=2.1e-08 $l=4.3e-08 $layer=Gate_1 $thickness=5.6e-08
+ $X=0.675 $Y=0.2025 $X2=0.675 $Y2=0.1595
r21 155 156 2.7211 $w=2.1e-08 $l=8e-09 $layer=Gate_1 $thickness=5.6e-08
+ $X=0.675 $Y=0.1515 $X2=0.675 $Y2=0.1595
r22 153 154 14.6259 $w=2.1e-08 $l=4.3e-08 $layer=Gate_1 $thickness=5.6e-08
+ $X=0.675 $Y=0.0675 $X2=0.675 $Y2=0.1105
r23 151 154 2.7211 $w=2.1e-08 $l=8e-09 $layer=Gate_1 $thickness=5.6e-08
+ $X=0.675 $Y=0.1185 $X2=0.675 $Y2=0.1105
r24 27 79 6.27904 $w=2.09e-08 $layer=Gate_1 $thickness=5.24e-08 $X=0.675
+ $Y=0.135 $X2=0.675 $Y2=0.135
r25 27 151 5.79936 $w=2.03333e-08 $l=1.65e-08 $layer=Gate_1 $thickness=5.6e-08
+ $X=0.675 $Y=0.135 $X2=0.675 $Y2=0.1185
r26 27 155 5.79936 $w=2.03333e-08 $l=1.65e-08 $layer=Gate_1 $thickness=5.6e-08
+ $X=0.675 $Y=0.135 $X2=0.675 $Y2=0.1515
r27 149 148 16.4967 $w=2.1e-08 $l=4.85e-08 $layer=Gate_1 $thickness=5.6e-08
+ $X=0.189 $Y=0.2025 $X2=0.189 $Y2=0.154
r28 146 147 16.4967 $w=2.1e-08 $l=4.85e-08 $layer=Gate_1 $thickness=5.6e-08
+ $X=0.189 $Y=0.0675 $X2=0.189 $Y2=0.116
r29 18 74 6.27904 $w=2.09e-08 $layer=Gate_1 $thickness=5.24e-08 $X=0.189
+ $Y=0.135 $X2=0.189 $Y2=0.135
r30 18 147 6.6497 $w=2.04211e-08 $l=1.9e-08 $layer=Gate_1 $thickness=5.6e-08
+ $X=0.189 $Y=0.135 $X2=0.189 $Y2=0.116
r31 18 148 6.6497 $w=2.04211e-08 $l=1.9e-08 $layer=Gate_1 $thickness=5.6e-08
+ $X=0.189 $Y=0.135 $X2=0.189 $Y2=0.154
r32 143 142 16.4967 $w=2.1e-08 $l=4.85e-08 $layer=Gate_1 $thickness=5.6e-08
+ $X=0.243 $Y=0.2025 $X2=0.243 $Y2=0.154
r33 140 141 16.4967 $w=2.1e-08 $l=4.85e-08 $layer=Gate_1 $thickness=5.6e-08
+ $X=0.243 $Y=0.0675 $X2=0.243 $Y2=0.116
r34 19 70 6.27904 $w=2.09e-08 $layer=Gate_1 $thickness=5.24e-08 $X=0.243
+ $Y=0.135 $X2=0.243 $Y2=0.135
r35 19 141 6.6497 $w=2.04211e-08 $l=1.9e-08 $layer=Gate_1 $thickness=5.6e-08
+ $X=0.243 $Y=0.135 $X2=0.243 $Y2=0.116
r36 19 142 6.6497 $w=2.04211e-08 $l=1.9e-08 $layer=Gate_1 $thickness=5.6e-08
+ $X=0.243 $Y=0.135 $X2=0.243 $Y2=0.154
r37 137 136 16.4967 $w=2.1e-08 $l=4.85e-08 $layer=Gate_1 $thickness=5.6e-08
+ $X=0.297 $Y=0.2025 $X2=0.297 $Y2=0.154
r38 134 135 16.4967 $w=2.1e-08 $l=4.85e-08 $layer=Gate_1 $thickness=5.6e-08
+ $X=0.297 $Y=0.0675 $X2=0.297 $Y2=0.116
r39 20 66 6.27904 $w=2.09e-08 $layer=Gate_1 $thickness=5.24e-08 $X=0.297
+ $Y=0.135 $X2=0.297 $Y2=0.135
r40 20 135 6.6497 $w=2.04211e-08 $l=1.9e-08 $layer=Gate_1 $thickness=5.6e-08
+ $X=0.297 $Y=0.135 $X2=0.297 $Y2=0.116
r41 20 136 6.6497 $w=2.04211e-08 $l=1.9e-08 $layer=Gate_1 $thickness=5.6e-08
+ $X=0.297 $Y=0.135 $X2=0.297 $Y2=0.154
r42 131 130 16.4967 $w=2.1e-08 $l=4.85e-08 $layer=Gate_1 $thickness=5.6e-08
+ $X=0.351 $Y=0.2025 $X2=0.351 $Y2=0.154
r43 128 129 16.4967 $w=2.1e-08 $l=4.85e-08 $layer=Gate_1 $thickness=5.6e-08
+ $X=0.351 $Y=0.0675 $X2=0.351 $Y2=0.116
r44 21 62 6.27904 $w=2.09e-08 $layer=Gate_1 $thickness=5.24e-08 $X=0.351
+ $Y=0.135 $X2=0.351 $Y2=0.135
r45 21 129 6.6497 $w=2.04211e-08 $l=1.9e-08 $layer=Gate_1 $thickness=5.6e-08
+ $X=0.351 $Y=0.135 $X2=0.351 $Y2=0.116
r46 21 130 6.6497 $w=2.04211e-08 $l=1.9e-08 $layer=Gate_1 $thickness=5.6e-08
+ $X=0.351 $Y=0.135 $X2=0.351 $Y2=0.154
r47 125 124 16.4967 $w=2.1e-08 $l=4.85e-08 $layer=Gate_1 $thickness=5.6e-08
+ $X=0.405 $Y=0.2025 $X2=0.405 $Y2=0.154
r48 122 123 16.4967 $w=2.1e-08 $l=4.85e-08 $layer=Gate_1 $thickness=5.6e-08
+ $X=0.405 $Y=0.0675 $X2=0.405 $Y2=0.116
r49 22 58 6.27904 $w=2.09e-08 $layer=Gate_1 $thickness=5.24e-08 $X=0.405
+ $Y=0.135 $X2=0.405 $Y2=0.135
r50 22 123 6.6497 $w=2.04211e-08 $l=1.9e-08 $layer=Gate_1 $thickness=5.6e-08
+ $X=0.405 $Y=0.135 $X2=0.405 $Y2=0.116
r51 22 124 6.6497 $w=2.04211e-08 $l=1.9e-08 $layer=Gate_1 $thickness=5.6e-08
+ $X=0.405 $Y=0.135 $X2=0.405 $Y2=0.154
r52 119 118 16.4967 $w=2.1e-08 $l=4.85e-08 $layer=Gate_1 $thickness=5.6e-08
+ $X=0.459 $Y=0.2025 $X2=0.459 $Y2=0.154
r53 116 117 16.4967 $w=2.1e-08 $l=4.85e-08 $layer=Gate_1 $thickness=5.6e-08
+ $X=0.459 $Y=0.0675 $X2=0.459 $Y2=0.116
r54 23 54 6.27904 $w=2.09e-08 $layer=Gate_1 $thickness=5.24e-08 $X=0.459
+ $Y=0.135 $X2=0.459 $Y2=0.135
r55 23 117 6.6497 $w=2.04211e-08 $l=1.9e-08 $layer=Gate_1 $thickness=5.6e-08
+ $X=0.459 $Y=0.135 $X2=0.459 $Y2=0.116
r56 23 118 6.6497 $w=2.04211e-08 $l=1.9e-08 $layer=Gate_1 $thickness=5.6e-08
+ $X=0.459 $Y=0.135 $X2=0.459 $Y2=0.154
r57 113 112 16.4967 $w=2.1e-08 $l=4.85e-08 $layer=Gate_1 $thickness=5.6e-08
+ $X=0.513 $Y=0.2025 $X2=0.513 $Y2=0.154
r58 110 111 16.4967 $w=2.1e-08 $l=4.85e-08 $layer=Gate_1 $thickness=5.6e-08
+ $X=0.513 $Y=0.0675 $X2=0.513 $Y2=0.116
r59 24 50 6.27904 $w=2.09e-08 $layer=Gate_1 $thickness=5.24e-08 $X=0.513
+ $Y=0.135 $X2=0.513 $Y2=0.135
r60 24 111 6.6497 $w=2.04211e-08 $l=1.9e-08 $layer=Gate_1 $thickness=5.6e-08
+ $X=0.513 $Y=0.135 $X2=0.513 $Y2=0.116
r61 24 112 6.6497 $w=2.04211e-08 $l=1.9e-08 $layer=Gate_1 $thickness=5.6e-08
+ $X=0.513 $Y=0.135 $X2=0.513 $Y2=0.154
r62 107 106 16.4967 $w=2.1e-08 $l=4.85e-08 $layer=Gate_1 $thickness=5.6e-08
+ $X=0.567 $Y=0.2025 $X2=0.567 $Y2=0.154
r63 104 105 16.4967 $w=2.1e-08 $l=4.85e-08 $layer=Gate_1 $thickness=5.6e-08
+ $X=0.567 $Y=0.0675 $X2=0.567 $Y2=0.116
r64 25 46 6.27904 $w=2.09e-08 $layer=Gate_1 $thickness=5.24e-08 $X=0.567
+ $Y=0.135 $X2=0.567 $Y2=0.135
r65 25 105 6.6497 $w=2.04211e-08 $l=1.9e-08 $layer=Gate_1 $thickness=5.6e-08
+ $X=0.567 $Y=0.135 $X2=0.567 $Y2=0.116
r66 25 106 6.6497 $w=2.04211e-08 $l=1.9e-08 $layer=Gate_1 $thickness=5.6e-08
+ $X=0.567 $Y=0.135 $X2=0.567 $Y2=0.154
r67 101 102 2.2153 $w=1.3e-08 $l=9.5e-09 $layer=M1 $thickness=3.6e-08 $X=0.189
+ $Y=0.135 $X2=0.1985 $Y2=0.135
r68 100 101 6.29612 $w=1.3e-08 $l=2.7e-08 $layer=M1 $thickness=3.6e-08 $X=0.162
+ $Y=0.135 $X2=0.189 $Y2=0.135
r69 97 98 6.29612 $w=1.3e-08 $l=2.7e-08 $layer=M1 $thickness=3.6e-08 $X=0.648
+ $Y=0.135 $X2=0.675 $Y2=0.135
r70 96 97 6.29612 $w=1.3e-08 $l=2.7e-08 $layer=M1 $thickness=3.6e-08 $X=0.621
+ $Y=0.135 $X2=0.648 $Y2=0.135
r71 95 96 6.29612 $w=1.3e-08 $l=2.7e-08 $layer=M1 $thickness=3.6e-08 $X=0.594
+ $Y=0.135 $X2=0.621 $Y2=0.135
r72 94 95 6.29612 $w=1.3e-08 $l=2.7e-08 $layer=M1 $thickness=3.6e-08 $X=0.567
+ $Y=0.135 $X2=0.594 $Y2=0.135
r73 93 94 6.29612 $w=1.3e-08 $l=2.7e-08 $layer=M1 $thickness=3.6e-08 $X=0.54
+ $Y=0.135 $X2=0.567 $Y2=0.135
r74 92 93 6.29612 $w=1.3e-08 $l=2.7e-08 $layer=M1 $thickness=3.6e-08 $X=0.513
+ $Y=0.135 $X2=0.54 $Y2=0.135
r75 91 92 6.29612 $w=1.3e-08 $l=2.7e-08 $layer=M1 $thickness=3.6e-08 $X=0.486
+ $Y=0.135 $X2=0.513 $Y2=0.135
r76 90 91 6.29612 $w=1.3e-08 $l=2.7e-08 $layer=M1 $thickness=3.6e-08 $X=0.459
+ $Y=0.135 $X2=0.486 $Y2=0.135
r77 89 90 6.29612 $w=1.3e-08 $l=2.7e-08 $layer=M1 $thickness=3.6e-08 $X=0.432
+ $Y=0.135 $X2=0.459 $Y2=0.135
r78 88 89 6.29612 $w=1.3e-08 $l=2.7e-08 $layer=M1 $thickness=3.6e-08 $X=0.405
+ $Y=0.135 $X2=0.432 $Y2=0.135
r79 87 88 6.29612 $w=1.3e-08 $l=2.7e-08 $layer=M1 $thickness=3.6e-08 $X=0.378
+ $Y=0.135 $X2=0.405 $Y2=0.135
r80 86 87 6.29612 $w=1.3e-08 $l=2.7e-08 $layer=M1 $thickness=3.6e-08 $X=0.351
+ $Y=0.135 $X2=0.378 $Y2=0.135
r81 85 86 6.29612 $w=1.3e-08 $l=2.7e-08 $layer=M1 $thickness=3.6e-08 $X=0.324
+ $Y=0.135 $X2=0.351 $Y2=0.135
r82 84 85 6.29612 $w=1.3e-08 $l=2.7e-08 $layer=M1 $thickness=3.6e-08 $X=0.297
+ $Y=0.135 $X2=0.324 $Y2=0.135
r83 83 84 6.29612 $w=1.3e-08 $l=2.7e-08 $layer=M1 $thickness=3.6e-08 $X=0.27
+ $Y=0.135 $X2=0.297 $Y2=0.135
r84 82 83 6.29612 $w=1.3e-08 $l=2.7e-08 $layer=M1 $thickness=3.6e-08 $X=0.243
+ $Y=0.135 $X2=0.27 $Y2=0.135
r85 35 82 6.17953 $w=1.3e-08 $l=2.65e-08 $layer=M1 $thickness=3.6e-08 $X=0.2165
+ $Y=0.135 $X2=0.243 $Y2=0.135
r86 35 102 4.19742 $w=1.3e-08 $l=1.8e-08 $layer=M1 $thickness=3.6e-08 $X=0.2165
+ $Y=0.135 $X2=0.1985 $Y2=0.135
r87 79 98 19.3796 $a=3.24e-16 $layer=V0LIG $X=0.675 $Y=0.135 $X2=0.675 $Y2=0.135
r88 78 79 2.48102 $w=2.2e-08 $l=9.5e-09 $layer=LIG $thickness=4.8e-08 $X=0.6655
+ $Y=0.135 $X2=0.675 $Y2=0.135
r89 77 78 10.1729 $w=1.54914e-08 $l=1.75e-08 $layer=LIG $thickness=4.8e-08
+ $X=0.648 $Y=0.135 $X2=0.6655 $Y2=0.135
r90 74 75 2.48102 $w=2.2e-08 $l=9.5e-09 $layer=LIG $thickness=4.8e-08 $X=0.189
+ $Y=0.135 $X2=0.1985 $Y2=0.135
r91 74 101 19.3796 $a=3.24e-16 $layer=V0LIG $X=0.189 $Y=0.135 $X2=0.189
+ $Y2=0.135
r92 72 75 10.1729 $w=1.54914e-08 $l=1.75e-08 $layer=LIG $thickness=4.8e-08
+ $X=0.216 $Y=0.135 $X2=0.1985 $Y2=0.135
r93 70 71 2.48102 $w=2.2e-08 $l=9.5e-09 $layer=LIG $thickness=4.8e-08 $X=0.243
+ $Y=0.135 $X2=0.2525 $Y2=0.135
r94 70 82 19.3796 $a=3.24e-16 $layer=V0LIG $X=0.243 $Y=0.135 $X2=0.243 $Y2=0.135
r95 69 70 2.48102 $w=2.2e-08 $l=9.5e-09 $layer=LIG $thickness=4.8e-08 $X=0.2335
+ $Y=0.135 $X2=0.243 $Y2=0.135
r96 69 72 10.1729 $w=1.54914e-08 $l=1.75e-08 $layer=LIG $thickness=4.8e-08
+ $X=0.2335 $Y=0.135 $X2=0.216 $Y2=0.135
r97 68 71 10.1729 $w=1.54914e-08 $l=1.75e-08 $layer=LIG $thickness=4.8e-08
+ $X=0.27 $Y=0.135 $X2=0.2525 $Y2=0.135
r98 66 67 2.48102 $w=2.2e-08 $l=9.5e-09 $layer=LIG $thickness=4.8e-08 $X=0.297
+ $Y=0.135 $X2=0.3065 $Y2=0.135
r99 66 84 19.3796 $a=3.24e-16 $layer=V0LIG $X=0.297 $Y=0.135 $X2=0.297 $Y2=0.135
r100 65 66 2.48102 $w=2.2e-08 $l=9.5e-09 $layer=LIG $thickness=4.8e-08
+ $X=0.2875 $Y=0.135 $X2=0.297 $Y2=0.135
r101 65 68 10.1729 $w=1.54914e-08 $l=1.75e-08 $layer=LIG $thickness=4.8e-08
+ $X=0.2875 $Y=0.135 $X2=0.27 $Y2=0.135
r102 64 67 10.1729 $w=1.54914e-08 $l=1.75e-08 $layer=LIG $thickness=4.8e-08
+ $X=0.324 $Y=0.135 $X2=0.3065 $Y2=0.135
r103 62 63 2.48102 $w=2.2e-08 $l=9.5e-09 $layer=LIG $thickness=4.8e-08 $X=0.351
+ $Y=0.135 $X2=0.3605 $Y2=0.135
r104 62 86 19.3796 $a=3.24e-16 $layer=V0LIG $X=0.351 $Y=0.135 $X2=0.351
+ $Y2=0.135
r105 61 62 2.48102 $w=2.2e-08 $l=9.5e-09 $layer=LIG $thickness=4.8e-08
+ $X=0.3415 $Y=0.135 $X2=0.351 $Y2=0.135
r106 61 64 10.1729 $w=1.54914e-08 $l=1.75e-08 $layer=LIG $thickness=4.8e-08
+ $X=0.3415 $Y=0.135 $X2=0.324 $Y2=0.135
r107 60 63 10.1729 $w=1.54914e-08 $l=1.75e-08 $layer=LIG $thickness=4.8e-08
+ $X=0.378 $Y=0.135 $X2=0.3605 $Y2=0.135
r108 58 59 2.48102 $w=2.2e-08 $l=9.5e-09 $layer=LIG $thickness=4.8e-08 $X=0.405
+ $Y=0.135 $X2=0.4145 $Y2=0.135
r109 58 88 19.3796 $a=3.24e-16 $layer=V0LIG $X=0.405 $Y=0.135 $X2=0.405
+ $Y2=0.135
r110 57 58 2.48102 $w=2.2e-08 $l=9.5e-09 $layer=LIG $thickness=4.8e-08
+ $X=0.3955 $Y=0.135 $X2=0.405 $Y2=0.135
r111 57 60 10.1729 $w=1.54914e-08 $l=1.75e-08 $layer=LIG $thickness=4.8e-08
+ $X=0.3955 $Y=0.135 $X2=0.378 $Y2=0.135
r112 56 59 10.1729 $w=1.54914e-08 $l=1.75e-08 $layer=LIG $thickness=4.8e-08
+ $X=0.432 $Y=0.135 $X2=0.4145 $Y2=0.135
r113 54 55 2.48102 $w=2.2e-08 $l=9.5e-09 $layer=LIG $thickness=4.8e-08 $X=0.459
+ $Y=0.135 $X2=0.4685 $Y2=0.135
r114 54 90 19.3796 $a=3.24e-16 $layer=V0LIG $X=0.459 $Y=0.135 $X2=0.459
+ $Y2=0.135
r115 53 54 2.48102 $w=2.2e-08 $l=9.5e-09 $layer=LIG $thickness=4.8e-08
+ $X=0.4495 $Y=0.135 $X2=0.459 $Y2=0.135
r116 53 56 10.1729 $w=1.54914e-08 $l=1.75e-08 $layer=LIG $thickness=4.8e-08
+ $X=0.4495 $Y=0.135 $X2=0.432 $Y2=0.135
r117 52 55 10.1729 $w=1.54914e-08 $l=1.75e-08 $layer=LIG $thickness=4.8e-08
+ $X=0.486 $Y=0.135 $X2=0.4685 $Y2=0.135
r118 50 51 2.48102 $w=2.2e-08 $l=9.5e-09 $layer=LIG $thickness=4.8e-08 $X=0.513
+ $Y=0.135 $X2=0.5225 $Y2=0.135
r119 50 92 19.3796 $a=3.24e-16 $layer=V0LIG $X=0.513 $Y=0.135 $X2=0.513
+ $Y2=0.135
r120 49 50 2.48102 $w=2.2e-08 $l=9.5e-09 $layer=LIG $thickness=4.8e-08
+ $X=0.5035 $Y=0.135 $X2=0.513 $Y2=0.135
r121 49 52 10.1729 $w=1.54914e-08 $l=1.75e-08 $layer=LIG $thickness=4.8e-08
+ $X=0.5035 $Y=0.135 $X2=0.486 $Y2=0.135
r122 48 51 10.1729 $w=1.54914e-08 $l=1.75e-08 $layer=LIG $thickness=4.8e-08
+ $X=0.54 $Y=0.135 $X2=0.5225 $Y2=0.135
r123 46 47 2.48102 $w=2.2e-08 $l=9.5e-09 $layer=LIG $thickness=4.8e-08 $X=0.567
+ $Y=0.135 $X2=0.5765 $Y2=0.135
r124 46 94 19.3796 $a=3.24e-16 $layer=V0LIG $X=0.567 $Y=0.135 $X2=0.567
+ $Y2=0.135
r125 45 46 2.48102 $w=2.2e-08 $l=9.5e-09 $layer=LIG $thickness=4.8e-08
+ $X=0.5575 $Y=0.135 $X2=0.567 $Y2=0.135
r126 45 48 10.1729 $w=1.54914e-08 $l=1.75e-08 $layer=LIG $thickness=4.8e-08
+ $X=0.5575 $Y=0.135 $X2=0.54 $Y2=0.135
r127 44 47 10.1729 $w=1.54914e-08 $l=1.75e-08 $layer=LIG $thickness=4.8e-08
+ $X=0.594 $Y=0.135 $X2=0.5765 $Y2=0.135
r128 43 77 10.1729 $w=1.54914e-08 $l=1.75e-08 $layer=LIG $thickness=4.8e-08
+ $X=0.6305 $Y=0.135 $X2=0.648 $Y2=0.135
r129 42 43 2.48102 $w=2.2e-08 $l=9.5e-09 $layer=LIG $thickness=4.8e-08 $X=0.621
+ $Y=0.135 $X2=0.6305 $Y2=0.135
r130 42 96 19.3796 $a=3.24e-16 $layer=V0LIG $X=0.621 $Y=0.135 $X2=0.621
+ $Y2=0.135
r131 1 42 2.48102 $w=2.2e-08 $l=9.5e-09 $layer=LIG $thickness=4.8e-08 $X=0.6115
+ $Y=0.135 $X2=0.621 $Y2=0.135
r132 1 44 10.1729 $w=1.54914e-08 $l=1.75e-08 $layer=LIG $thickness=4.8e-08
+ $X=0.6115 $Y=0.135 $X2=0.594 $Y2=0.135
r133 40 39 16.4967 $w=2.1e-08 $l=4.85e-08 $layer=Gate_1 $thickness=5.6e-08
+ $X=0.621 $Y=0.2025 $X2=0.621 $Y2=0.154
r134 38 39 6.6497 $w=2.04211e-08 $l=1.9e-08 $layer=Gate_1 $thickness=5.6e-08
+ $X=0.621 $Y=0.135 $X2=0.621 $Y2=0.154
r135 38 43 4.05918 $w=2.0087e-08 $l=9.5e-09 $layer=Gate_1
+ $thickness=5.56522e-08 $X=0.621 $Y=0.135 $X2=0.6305 $Y2=0.135
r136 38 42 6.27904 $w=2.09e-08 $layer=Gate_1 $thickness=5.24e-08 $X=0.621
+ $Y=0.135 $X2=0.621 $Y2=0.135
r137 37 38 6.6497 $w=2.04211e-08 $l=1.9e-08 $layer=Gate_1 $thickness=5.6e-08
+ $X=0.621 $Y=0.116 $X2=0.621 $Y2=0.135
r138 36 37 16.4967 $w=2.1e-08 $l=4.85e-08 $layer=Gate_1 $thickness=5.6e-08
+ $X=0.621 $Y=0.0675 $X2=0.621 $Y2=0.116
r139 36 26 14.6259 $w=2.1e-08 $l=4.3e-08 $layer=Gate_1 $thickness=5.6e-08
+ $X=0.621 $Y=0.0675 $X2=0.621 $Y2=0.0245
.ends

* End of included file BUFx10_ASAP7_75t_R.pex.sp.pex

*
.subckt BUFx10_ASAP7_75t_CUSTOM_4_25_0_7 VSS VDD A Y
*
* VSS VSS
* VDD VDD
* A A
* Y Y
*
*

M0 N_M0_d N_M0_g VSS VSS nmos_rvt L=2e-08 W=8.1e-08 nfin=3 $X=0.071 $Y=0.027
M1 N_M1_d N_M1_g VSS VSS nmos_rvt L=2e-08 W=8.1e-08 nfin=3 $X=0.125 $Y=0.027
M2 N_M2_d N_M2_g VSS VSS nmos_rvt L=2e-08 W=8.1e-08 nfin=3 $X=0.179 $Y=0.027
M3 N_M3_d N_M3_g VSS VSS nmos_rvt L=2e-08 W=8.1e-08 nfin=3 $X=0.233 $Y=0.027
M4 N_M4_d N_M4_g VSS VSS nmos_rvt L=2e-08 W=8.1e-08 nfin=3 $X=0.287 $Y=0.027
M5 N_M5_d N_M5_g VSS VSS nmos_rvt L=2e-08 W=8.1e-08 nfin=3 $X=0.341 $Y=0.027
M6 N_M6_d N_M6_g VSS VSS nmos_rvt L=2e-08 W=8.1e-08 nfin=3 $X=0.395 $Y=0.027
M7 N_M7_d N_M7_g VSS VSS nmos_rvt L=2e-08 W=8.1e-08 nfin=3 $X=0.449 $Y=0.027
M8 N_M8_d N_M8_g VSS VSS nmos_rvt L=2e-08 W=8.1e-08 nfin=3 $X=0.503 $Y=0.027
M9 N_M9_d N_M9_g VSS VSS nmos_rvt L=2e-08 W=8.1e-08 nfin=3 $X=0.557 $Y=0.027
M10 N_M10_d N_M10_g VSS VSS nmos_rvt L=2e-08 W=8.1e-08 nfin=3 $X=0.611 $Y=0.027
M11 N_M11_d N_M11_g VSS VSS nmos_rvt L=2e-08 W=8.1e-08 nfin=3 $X=0.665 $Y=0.027
M12 N_M12_d N_M12_g VDD VDD pmos_rvt L=2e-08 W=8.1e-08 nfin=3 $X=0.071 $Y=0.162
M13 N_M13_d N_M13_g VDD VDD pmos_rvt L=2e-08 W=8.1e-08 nfin=3 $X=0.125 $Y=0.162
M14 N_M14_d N_M14_g VDD VDD pmos_rvt L=2e-08 W=8.1e-08 nfin=3 $X=0.179 $Y=0.162
M15 N_M15_d N_M15_g VDD VDD pmos_rvt L=2e-08 W=8.1e-08 nfin=3 $X=0.233 $Y=0.162
M16 N_M16_d N_M16_g VDD VDD pmos_rvt L=2e-08 W=8.1e-08 nfin=3 $X=0.287 $Y=0.162
M17 N_M17_d N_M17_g VDD VDD pmos_rvt L=2e-08 W=8.1e-08 nfin=3 $X=0.341 $Y=0.162
M18 N_M18_d N_M18_g VDD VDD pmos_rvt L=2e-08 W=8.1e-08 nfin=3 $X=0.395 $Y=0.162
M19 N_M19_d N_M19_g VDD VDD pmos_rvt L=2e-08 W=8.1e-08 nfin=3 $X=0.449 $Y=0.162
M20 N_M20_d N_M20_g VDD VDD pmos_rvt L=2e-08 W=8.1e-08 nfin=3 $X=0.503 $Y=0.162
M21 N_M21_d N_M21_g VDD VDD pmos_rvt L=2e-08 W=8.1e-08 nfin=3 $X=0.557 $Y=0.162
M22 N_M22_d N_M22_g VDD VDD pmos_rvt L=2e-08 W=8.1e-08 nfin=3 $X=0.611 $Y=0.162
M23 N_M23_d N_M23_g VDD VDD pmos_rvt L=2e-08 W=8.1e-08 nfin=3 $X=0.665 $Y=0.162

* .include "BUFx10_ASAP7_75t_R.pex.sp.pxi"

* Start of included file BUFx10_ASAP7_75t_R.pex.sp.pxi
x_PM_BUFx10_ASAP7_75t_R%A vss A N_M0_g N_M12_g N_M1_g N_M13_g N_A_4 N_A_7 N_A_5
+ N_A_10 N_A_1 N_A_3 PM_BUFx10_ASAP7_75t_R%A
x_PM_BUFx10_ASAP7_75t_R%Y vss Y N_M10_d N_M11_d N_M2_d N_M3_d N_M4_d N_M5_d
+ N_M6_d N_M7_d N_M8_d N_M9_d N_M14_d N_M15_d N_M16_d N_M17_d N_M18_d N_M19_d
+ N_M20_d N_M21_d N_M22_d N_M23_d N_Y_33 N_Y_7 N_Y_1 N_Y_4 N_Y_6 N_Y_8 N_Y_10
+ N_Y_36 N_Y_31 N_Y_37 N_Y_38 N_Y_39 N_Y_32 N_Y_34 N_Y_35 N_Y_40 N_Y_45 N_Y_9
+ N_Y_3 N_Y_5 N_Y_2 N_Y_43 N_Y_44 PM_BUFx10_ASAP7_75t_R%Y
cc_1 N_Y_33 N_4_20 9.44826e-20 $X=0.4175 $Y=0.0675
cc_2 N_Y_33 N_4_22 0.000188965f $X=0.4175 $Y=0.0675
cc_3 N_Y_33 N_4_24 0.000188965f $X=0.4175 $Y=0.0675
cc_4 N_Y_33 N_4_26 0.000188965f $X=0.4175 $Y=0.0675
cc_5 N_Y_33 N_4_30 0.000194041f $X=0.4175 $Y=0.0675
cc_6 N_Y_33 N_4_31 0.000194041f $X=0.4175 $Y=0.0675
cc_7 N_Y_33 N_4_1 0.0218878f $X=0.4175 $Y=0.0675
cc_8 N_Y_33 N_4_33 0.000398952f $X=0.4175 $Y=0.0675
cc_9 N_Y_33 N_4_34 0.000398952f $X=0.4175 $Y=0.0675
cc_10 N_Y_7 N_4_1 0.00050143f $X=0.54 $Y=0.0675
cc_11 N_Y_1 N_4_1 0.000678766f $X=0.216 $Y=0.0675
cc_12 N_Y_4 N_4_1 0.000678766f $X=0.324 $Y=0.2025
cc_13 N_Y_6 N_4_1 0.000678766f $X=0.432 $Y=0.2025
cc_14 N_Y_8 N_4_1 0.000678766f $X=0.54 $Y=0.2025
cc_15 N_Y_10 N_4_1 0.00144518f $X=0.648 $Y=0.2025
cc_16 N_Y_36 N_4_19 0.0287386f $X=0.2015 $Y=0.2025
cc_17 N_Y_31 N_4_18 0.0463669f $X=0.2015 $Y=0.0675
cc_18 N_Y_37 N_4_21 0.000817115f $X=0.3095 $Y=0.2025
cc_19 N_Y_38 N_4_23 0.000817115f $X=0.4175 $Y=0.2025
cc_20 N_Y_39 N_4_25 0.0366323f $X=0.5255 $Y=0.2025
cc_21 N_Y_32 N_4_21 0.0646843f $X=0.3095 $Y=0.0675
cc_22 N_Y_34 N_4_25 0.0287915f $X=0.5255 $Y=0.0675
cc_23 N_Y_35 N_4_26 0.0547967f $X=0.6335 $Y=0.0675
cc_24 N_Y_40 N_4_26 0.0288168f $X=0.6335 $Y=0.2025
cc_25 N_Y_45 N_4_35 0.00157893f $X=0.729 $Y=0.0855
cc_26 N_Y_9 N_4_26 0.00183394f $X=0.648 $Y=0.0675
cc_27 N_Y_10 N_4_26 0.00183394f $X=0.648 $Y=0.2025
cc_28 N_Y_3 N_4_20 0.00190642f $X=0.324 $Y=0.0675
cc_29 N_Y_4 N_4_21 0.00190642f $X=0.324 $Y=0.2025
cc_30 N_Y_5 N_4_22 0.00190642f $X=0.432 $Y=0.0675
cc_31 N_Y_6 N_4_23 0.00190642f $X=0.432 $Y=0.2025
cc_32 N_Y_7 N_4_24 0.00190642f $X=0.54 $Y=0.0675
cc_33 N_Y_8 N_4_25 0.00190642f $X=0.54 $Y=0.2025
cc_34 N_Y_1 N_4_19 0.00205831f $X=0.216 $Y=0.0675
cc_35 N_Y_2 N_4_19 0.00205831f $X=0.216 $Y=0.2025
cc_36 N_Y_43 N_4_35 0.00398462f $X=0.203 $Y=0.036
cc_37 N_Y_44 N_4_35 0.00398462f $X=0.7045 $Y=0.234
cc_38 N_Y_4 N_4_35 0.00417045f $X=0.324 $Y=0.2025
cc_39 N_Y_8 N_4_35 0.00598378f $X=0.54 $Y=0.2025
cc_40 N_Y_37 N_4_20 0.0278494f $X=0.3095 $Y=0.2025
cc_41 N_Y_35 N_4_27 0.0100442f $X=0.6335 $Y=0.0675
cc_42 N_Y_31 N_4_19 0.0537675f $X=0.2015 $Y=0.0675
cc_43 N_Y_38 N_4_22 0.0637421f $X=0.4175 $Y=0.2025
cc_44 N_Y_39 N_4_24 0.0637421f $X=0.5255 $Y=0.2025
cc_45 N_Y_40 N_4_27 0.0358283f $X=0.6335 $Y=0.2025
cc_46 N_Y_32 N_4_20 0.0358914f $X=0.3095 $Y=0.0675
cc_47 N_Y_33 N_4_23 0.0653587f $X=0.4175 $Y=0.0675
x_PM_BUFx10_ASAP7_75t_R%4 vss N_M10_g N_M22_g N_M9_g N_M21_g N_M8_g N_M20_g
+ N_M7_g N_M19_g N_M6_g N_M18_g N_M5_g N_M17_g N_M4_g N_M16_g N_M3_g N_M15_g
+ N_M2_g N_M14_g N_M11_g N_M23_g N_M0_d N_M1_d N_M12_d N_M13_d N_4_35 N_4_1
+ N_4_30 N_4_31 N_4_12 N_4_29 N_4_33 N_4_34 N_4_18 N_4_13 N_4_32 N_4_28 N_4_20
+ N_4_22 N_4_24 N_4_26 N_4_19 N_4_21 N_4_23 N_4_25 N_4_27
+ PM_BUFx10_ASAP7_75t_R%4
cc_48 N_4_35 N_A_4 0.000319397f $X=0.2165 $Y=0.135
cc_49 N_4_1 N_A_4 0.000438514f $X=0.6115 $Y=0.135
cc_50 N_4_30 N_A_4 0.000521117f $X=0.135 $Y=0.036
cc_51 N_4_31 N_A_4 0.00055778f $X=0.135 $Y=0.234
cc_52 N_4_12 N_A_4 0.00258514f $X=0.108 $Y=0.0675
cc_53 N_4_29 N_A_4 0.0304142f $X=0.0935 $Y=0.2025
cc_54 N_4_33 N_A_4 0.00100719f $X=0.135 $Y=0.0855
cc_55 N_4_34 N_A_4 0.00100719f $X=0.135 $Y=0.1845
cc_56 N_4_31 N_A_7 0.00102134f $X=0.135 $Y=0.234
cc_57 N_4_30 N_A_5 0.00105889f $X=0.135 $Y=0.036
cc_58 N_4_18 N_A_4 0.00174596f $X=0.189 $Y=0.135
cc_59 N_4_13 N_A_4 0.00181441f $X=0.108 $Y=0.2025
cc_60 N_4_32 N_A_10 0.00218928f $X=0.135 $Y=0.135
cc_61 N_4_29 N_A_1 0.00562919f $X=0.0935 $Y=0.2025
cc_62 N_4_28 N_A_3 0.0295802f $X=0.0935 $Y=0.0675
cc_63 N_4_29 N_A_3 0.0379072f $X=0.0935 $Y=0.2025
cc_64 N_4_28 N_A_4 0.0408629f $X=0.0935 $Y=0.0675

* End of included file BUFx10_ASAP7_75t_R.pex.sp.pxi
.ends

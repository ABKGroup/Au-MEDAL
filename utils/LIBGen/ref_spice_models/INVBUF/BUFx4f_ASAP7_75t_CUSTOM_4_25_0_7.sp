.subckt PM_BUFx4f_ASAP7_75t_R%A vss 25 11 17 30 33 3 10 5 7 4 1
c1 1 vss 0.0121609f $X=0.0715 $Y=0.135
c2 3 vss 0.0752563f $X=0.081 $Y=0.0245
c3 4 vss 0.0844054f $X=0.135 $Y=0.135
c4 5 vss 0.00970643f $X=0.027 $Y=0.036
c5 6 vss 0.00217732f $X=0.027 $Y=0.135
c6 7 vss 0.00941012f $X=0.027 $Y=0.234
c7 8 vss 0.0120205f $X=0.027 $Y=0.0855
c8 9 vss 0.0119709f $X=0.027 $Y=0.1845
c9 10 vss 0.00393662f $X=0.0635 $Y=0.135
r1 7 9 10.3626 $w=1.39091e-08 $l=4.95e-08 $layer=M1 $thickness=3.6e-08 $X=0.027
+ $Y=0.234 $X2=0.027 $Y2=0.1845
r2 5 8 10.3626 $w=1.39091e-08 $l=4.95e-08 $layer=M1 $thickness=3.6e-08 $X=0.027
+ $Y=0.036 $X2=0.027 $Y2=0.0855
r3 6 27 3.1337 $w=1.54324e-08 $l=1.85e-08 $layer=M1 $thickness=3.6e-08 $X=0.027
+ $Y=0.135 $X2=0.0455 $Y2=0.135
r4 6 8 10.3626 $w=1.39091e-08 $l=4.95e-08 $layer=M1 $thickness=3.6e-08 $X=0.027
+ $Y=0.135 $X2=0.027 $Y2=0.0855
r5 6 9 10.3626 $w=1.39091e-08 $l=4.95e-08 $layer=M1 $thickness=3.6e-08 $X=0.027
+ $Y=0.135 $X2=0.027 $Y2=0.1845
r6 33 32 16.4967 $w=2.1e-08 $l=4.85e-08 $layer=Gate_1 $thickness=5.6e-08
+ $X=0.135 $Y=0.2025 $X2=0.135 $Y2=0.154
r7 30 31 16.4967 $w=2.1e-08 $l=4.85e-08 $layer=Gate_1 $thickness=5.6e-08
+ $X=0.135 $Y=0.0675 $X2=0.135 $Y2=0.116
r8 4 23 6.54019 $w=2.09524e-08 $layer=Gate_1 $thickness=5.21905e-08 $X=0.135
+ $Y=0.135 $X2=0.135 $Y2=0.135
r9 4 31 6.6497 $w=2.04211e-08 $l=1.9e-08 $layer=Gate_1 $thickness=5.6e-08
+ $X=0.135 $Y=0.135 $X2=0.135 $Y2=0.116
r10 4 32 6.6497 $w=2.04211e-08 $l=1.9e-08 $layer=Gate_1 $thickness=5.6e-08
+ $X=0.135 $Y=0.135 $X2=0.135 $Y2=0.154
r11 25 10 4.08082 $w=1.3e-08 $l=1.75e-08 $layer=M1 $thickness=3.6e-08 $X=0.081
+ $Y=0.135 $X2=0.0635 $Y2=0.135
r12 10 27 4.19742 $w=1.3e-08 $l=1.8e-08 $layer=M1 $thickness=3.6e-08 $X=0.0635
+ $Y=0.135 $X2=0.0455 $Y2=0.135
r13 22 23 12.6539 $w=1.77815e-08 $l=2.7e-08 $layer=LIG $thickness=4.8e-08
+ $X=0.108 $Y=0.135 $X2=0.135 $Y2=0.135
r14 20 22 10.1729 $w=1.54914e-08 $l=1.75e-08 $layer=LIG $thickness=4.8e-08
+ $X=0.0905 $Y=0.135 $X2=0.108 $Y2=0.135
r15 19 20 2.48102 $w=2.2e-08 $l=9.5e-09 $layer=LIG $thickness=4.8e-08 $X=0.081
+ $Y=0.135 $X2=0.0905 $Y2=0.135
r16 25 19 19.3796 $a=3.24e-16 $layer=V0LIG $X=0.081 $Y=0.135 $X2=0.081 $Y2=0.135
r17 1 19 2.48102 $w=2.2e-08 $l=9.5e-09 $layer=LIG $thickness=4.8e-08 $X=0.0715
+ $Y=0.135 $X2=0.081 $Y2=0.135
r18 17 16 14.6259 $w=2.1e-08 $l=4.3e-08 $layer=Gate_1 $thickness=5.6e-08
+ $X=0.081 $Y=0.2295 $X2=0.081 $Y2=0.1865
r19 15 16 11.9048 $w=2.1e-08 $l=3.5e-08 $layer=Gate_1 $thickness=5.6e-08
+ $X=0.081 $Y=0.1515 $X2=0.081 $Y2=0.1865
r20 14 15 5.79936 $w=2.03333e-08 $l=1.65e-08 $layer=Gate_1 $thickness=5.6e-08
+ $X=0.081 $Y=0.135 $X2=0.081 $Y2=0.1515
r21 14 20 4.05918 $w=2.0087e-08 $l=9.5e-09 $layer=Gate_1 $thickness=5.56522e-08
+ $X=0.081 $Y=0.135 $X2=0.0905 $Y2=0.135
r22 14 19 6.27904 $w=2.09e-08 $layer=Gate_1 $thickness=5.24e-08 $X=0.081
+ $Y=0.135 $X2=0.081 $Y2=0.135
r23 13 14 5.79936 $w=2.03333e-08 $l=1.65e-08 $layer=Gate_1 $thickness=5.6e-08
+ $X=0.081 $Y=0.1185 $X2=0.081 $Y2=0.135
r24 12 13 11.9048 $w=2.1e-08 $l=3.5e-08 $layer=Gate_1 $thickness=5.6e-08
+ $X=0.081 $Y=0.0835 $X2=0.081 $Y2=0.1185
r25 11 12 14.6259 $w=2.1e-08 $l=4.3e-08 $layer=Gate_1 $thickness=5.6e-08
+ $X=0.081 $Y=0.0405 $X2=0.081 $Y2=0.0835
r26 11 3 5.44221 $w=2.1e-08 $l=1.6e-08 $layer=Gate_1 $thickness=5.6e-08
+ $X=0.081 $Y=0.0405 $X2=0.081 $Y2=0.0245
.ends

.subckt PM_BUFx4f_ASAP7_75t_R%4 vss 26 30 58 61 64 67 71 75 86 89 92 95 25 20
+ 21 19 17 7 23 24 12 6 22 18 16 1 14 15 13
c1 1 vss 0.0189732f $X=0.2875 $Y=0.135
c2 6 vss 0.00901642f $X=0.108 $Y=0.0675
c3 7 vss 0.00901642f $X=0.108 $Y=0.2025
c4 12 vss 0.0802343f $X=0.189 $Y=0.135
c5 13 vss 0.0805752f $X=0.243 $Y=0.135
c6 14 vss 0.0811489f $X=0.297 $Y=0.0245
c7 15 vss 0.0898123f $X=0.351 $Y=0.135
c8 16 vss 0.00599848f $X=0.0935 $Y=0.0405
c9 17 vss 0.00403927f $X=0.11 $Y=0.081
c10 18 vss 0.00604364f $X=0.0935 $Y=0.2295
c11 19 vss 0.00407877f $X=0.11 $Y=0.189
c12 20 vss 0.00762312f $X=0.135 $Y=0.036
c13 21 vss 0.00762312f $X=0.135 $Y=0.234
c14 22 vss 0.000165677f $X=0.135 $Y=0.135
c15 23 vss 0.00448929f $X=0.135 $Y=0.0855
c16 24 vss 0.00448929f $X=0.135 $Y=0.1845
c17 25 vss 0.00982726f $X=0.2165 $Y=0.135
r1 19 7 0.555556 $w=4.05e-08 $l=4.05e-08 $layer=P_src_drn $thickness=1e-09
+ $X=0.11 $Y=0.189 $X2=0.108 $Y2=0.2025
r2 95 94 0.0925926 $w=2.7e-08 $l=2.5e-09 $layer=P_src_drn $thickness=1e-09
+ $X=0.1253 $Y=0.2025 $X2=0.1225 $Y2=0.2295
r3 7 94 0.462963 $w=2.7e-08 $l=1.25e-08 $layer=P_src_drn $thickness=1e-09
+ $X=0.108 $Y=0.2025 $X2=0.1225 $Y2=0.2295
r4 91 7 0.444445 $w=2.7e-08 $l=1.2e-08 $layer=P_src_drn $thickness=1e-09
+ $X=0.098 $Y=0.2295 $X2=0.108 $Y2=0.2025
r5 18 91 0.166667 $w=2.7e-08 $l=4.5e-09 $layer=P_src_drn $thickness=1e-09
+ $X=0.0935 $Y=0.2295 $X2=0.098 $Y2=0.2295
r6 92 18 0.0925926 $w=2.7e-08 $l=2.5e-09 $layer=P_src_drn $thickness=1e-09
+ $X=0.0906 $Y=0.2295 $X2=0.0935 $Y2=0.2295
r7 17 6 0.555556 $w=4.05e-08 $l=4.05e-08 $layer=N_src_drn $thickness=1e-09
+ $X=0.11 $Y=0.081 $X2=0.108 $Y2=0.0675
r8 89 88 0.0925926 $w=2.7e-08 $l=2.5e-09 $layer=N_src_drn $thickness=1e-09
+ $X=0.1253 $Y=0.0675 $X2=0.1225 $Y2=0.0405
r9 6 88 0.462963 $w=2.7e-08 $l=1.25e-08 $layer=N_src_drn $thickness=1e-09
+ $X=0.108 $Y=0.0675 $X2=0.1225 $Y2=0.0405
r10 85 6 0.444445 $w=2.7e-08 $l=1.2e-08 $layer=N_src_drn $thickness=1e-09
+ $X=0.098 $Y=0.0405 $X2=0.108 $Y2=0.0675
r11 16 85 0.166667 $w=2.7e-08 $l=4.5e-09 $layer=N_src_drn $thickness=1e-09
+ $X=0.0935 $Y=0.0405 $X2=0.098 $Y2=0.0405
r12 86 16 0.0925926 $w=2.7e-08 $l=2.5e-09 $layer=N_src_drn $thickness=1e-09
+ $X=0.0906 $Y=0.0405 $X2=0.0935 $Y2=0.0405
r13 7 82 19.3796 $a=3.24e-16 $layer=V0LISD $X=0.108 $Y=0.2025 $X2=0.108
+ $Y2=0.234
r14 6 78 19.3796 $a=3.24e-16 $layer=V0LISD $X=0.108 $Y=0.0675 $X2=0.108
+ $Y2=0.036
r15 82 83 3.14806 $w=1.3e-08 $l=1.35e-08 $layer=M1 $thickness=3.6e-08 $X=0.108
+ $Y=0.234 $X2=0.1215 $Y2=0.234
r16 21 24 10.3626 $w=1.39091e-08 $l=4.95e-08 $layer=M1 $thickness=3.6e-08
+ $X=0.135 $Y=0.234 $X2=0.135 $Y2=0.1845
r17 21 83 1.96775 $w=1.63333e-08 $l=1.35e-08 $layer=M1 $thickness=3.6e-08
+ $X=0.135 $Y=0.234 $X2=0.1215 $Y2=0.234
r18 78 79 3.14806 $w=1.3e-08 $l=1.35e-08 $layer=M1 $thickness=3.6e-08 $X=0.108
+ $Y=0.036 $X2=0.1215 $Y2=0.036
r19 20 23 10.3626 $w=1.39091e-08 $l=4.95e-08 $layer=M1 $thickness=3.6e-08
+ $X=0.135 $Y=0.036 $X2=0.135 $Y2=0.0855
r20 20 79 1.96775 $w=1.63333e-08 $l=1.35e-08 $layer=M1 $thickness=3.6e-08
+ $X=0.135 $Y=0.036 $X2=0.1215 $Y2=0.036
r21 22 54 5.11582 $w=1.46667e-08 $l=2.7e-08 $layer=M1 $thickness=3.6e-08
+ $X=0.135 $Y=0.135 $X2=0.162 $Y2=0.135
r22 22 23 10.3626 $w=1.39091e-08 $l=4.95e-08 $layer=M1 $thickness=3.6e-08
+ $X=0.135 $Y=0.135 $X2=0.135 $Y2=0.0855
r23 22 24 10.3626 $w=1.39091e-08 $l=4.95e-08 $layer=M1 $thickness=3.6e-08
+ $X=0.135 $Y=0.135 $X2=0.135 $Y2=0.1845
r24 75 74 14.6259 $w=2.1e-08 $l=4.3e-08 $layer=Gate_1 $thickness=5.6e-08
+ $X=0.351 $Y=0.2025 $X2=0.351 $Y2=0.1595
r25 73 74 2.7211 $w=2.1e-08 $l=8e-09 $layer=Gate_1 $thickness=5.6e-08 $X=0.351
+ $Y=0.1515 $X2=0.351 $Y2=0.1595
r26 71 72 14.6259 $w=2.1e-08 $l=4.3e-08 $layer=Gate_1 $thickness=5.6e-08
+ $X=0.351 $Y=0.0675 $X2=0.351 $Y2=0.1105
r27 69 72 2.7211 $w=2.1e-08 $l=8e-09 $layer=Gate_1 $thickness=5.6e-08 $X=0.351
+ $Y=0.1185 $X2=0.351 $Y2=0.1105
r28 15 45 6.27904 $w=2.09e-08 $layer=Gate_1 $thickness=5.24e-08 $X=0.351
+ $Y=0.135 $X2=0.351 $Y2=0.135
r29 15 69 5.79936 $w=2.03333e-08 $l=1.65e-08 $layer=Gate_1 $thickness=5.6e-08
+ $X=0.351 $Y=0.135 $X2=0.351 $Y2=0.1185
r30 15 73 5.79936 $w=2.03333e-08 $l=1.65e-08 $layer=Gate_1 $thickness=5.6e-08
+ $X=0.351 $Y=0.135 $X2=0.351 $Y2=0.1515
r31 67 66 16.4967 $w=2.1e-08 $l=4.85e-08 $layer=Gate_1 $thickness=5.6e-08
+ $X=0.189 $Y=0.2025 $X2=0.189 $Y2=0.154
r32 64 65 16.4967 $w=2.1e-08 $l=4.85e-08 $layer=Gate_1 $thickness=5.6e-08
+ $X=0.189 $Y=0.0675 $X2=0.189 $Y2=0.116
r33 12 40 6.27904 $w=2.09e-08 $layer=Gate_1 $thickness=5.24e-08 $X=0.189
+ $Y=0.135 $X2=0.189 $Y2=0.135
r34 12 65 6.6497 $w=2.04211e-08 $l=1.9e-08 $layer=Gate_1 $thickness=5.6e-08
+ $X=0.189 $Y=0.135 $X2=0.189 $Y2=0.116
r35 12 66 6.6497 $w=2.04211e-08 $l=1.9e-08 $layer=Gate_1 $thickness=5.6e-08
+ $X=0.189 $Y=0.135 $X2=0.189 $Y2=0.154
r36 61 60 16.4967 $w=2.1e-08 $l=4.85e-08 $layer=Gate_1 $thickness=5.6e-08
+ $X=0.243 $Y=0.2025 $X2=0.243 $Y2=0.154
r37 58 59 16.4967 $w=2.1e-08 $l=4.85e-08 $layer=Gate_1 $thickness=5.6e-08
+ $X=0.243 $Y=0.0675 $X2=0.243 $Y2=0.116
r38 13 36 6.27904 $w=2.09e-08 $layer=Gate_1 $thickness=5.24e-08 $X=0.243
+ $Y=0.135 $X2=0.243 $Y2=0.135
r39 13 59 6.6497 $w=2.04211e-08 $l=1.9e-08 $layer=Gate_1 $thickness=5.6e-08
+ $X=0.243 $Y=0.135 $X2=0.243 $Y2=0.116
r40 13 60 6.6497 $w=2.04211e-08 $l=1.9e-08 $layer=Gate_1 $thickness=5.6e-08
+ $X=0.243 $Y=0.135 $X2=0.243 $Y2=0.154
r41 55 56 2.2153 $w=1.3e-08 $l=9.5e-09 $layer=M1 $thickness=3.6e-08 $X=0.189
+ $Y=0.135 $X2=0.1985 $Y2=0.135
r42 54 55 6.29612 $w=1.3e-08 $l=2.7e-08 $layer=M1 $thickness=3.6e-08 $X=0.162
+ $Y=0.135 $X2=0.189 $Y2=0.135
r43 51 52 6.29612 $w=1.3e-08 $l=2.7e-08 $layer=M1 $thickness=3.6e-08 $X=0.324
+ $Y=0.135 $X2=0.351 $Y2=0.135
r44 50 51 6.29612 $w=1.3e-08 $l=2.7e-08 $layer=M1 $thickness=3.6e-08 $X=0.297
+ $Y=0.135 $X2=0.324 $Y2=0.135
r45 49 50 6.29612 $w=1.3e-08 $l=2.7e-08 $layer=M1 $thickness=3.6e-08 $X=0.27
+ $Y=0.135 $X2=0.297 $Y2=0.135
r46 48 49 6.29612 $w=1.3e-08 $l=2.7e-08 $layer=M1 $thickness=3.6e-08 $X=0.243
+ $Y=0.135 $X2=0.27 $Y2=0.135
r47 25 48 6.17953 $w=1.3e-08 $l=2.65e-08 $layer=M1 $thickness=3.6e-08 $X=0.2165
+ $Y=0.135 $X2=0.243 $Y2=0.135
r48 25 56 4.19742 $w=1.3e-08 $l=1.8e-08 $layer=M1 $thickness=3.6e-08 $X=0.2165
+ $Y=0.135 $X2=0.1985 $Y2=0.135
r49 45 52 19.3796 $a=3.24e-16 $layer=V0LIG $X=0.351 $Y=0.135 $X2=0.351 $Y2=0.135
r50 44 45 2.48102 $w=2.2e-08 $l=9.5e-09 $layer=LIG $thickness=4.8e-08 $X=0.3415
+ $Y=0.135 $X2=0.351 $Y2=0.135
r51 43 44 10.1729 $w=1.54914e-08 $l=1.75e-08 $layer=LIG $thickness=4.8e-08
+ $X=0.324 $Y=0.135 $X2=0.3415 $Y2=0.135
r52 40 41 2.48102 $w=2.2e-08 $l=9.5e-09 $layer=LIG $thickness=4.8e-08 $X=0.189
+ $Y=0.135 $X2=0.1985 $Y2=0.135
r53 40 55 19.3796 $a=3.24e-16 $layer=V0LIG $X=0.189 $Y=0.135 $X2=0.189 $Y2=0.135
r54 38 41 10.1729 $w=1.54914e-08 $l=1.75e-08 $layer=LIG $thickness=4.8e-08
+ $X=0.216 $Y=0.135 $X2=0.1985 $Y2=0.135
r55 36 37 2.48102 $w=2.2e-08 $l=9.5e-09 $layer=LIG $thickness=4.8e-08 $X=0.243
+ $Y=0.135 $X2=0.2525 $Y2=0.135
r56 36 48 19.3796 $a=3.24e-16 $layer=V0LIG $X=0.243 $Y=0.135 $X2=0.243 $Y2=0.135
r57 35 36 2.48102 $w=2.2e-08 $l=9.5e-09 $layer=LIG $thickness=4.8e-08 $X=0.2335
+ $Y=0.135 $X2=0.243 $Y2=0.135
r58 35 38 10.1729 $w=1.54914e-08 $l=1.75e-08 $layer=LIG $thickness=4.8e-08
+ $X=0.2335 $Y=0.135 $X2=0.216 $Y2=0.135
r59 34 37 10.1729 $w=1.54914e-08 $l=1.75e-08 $layer=LIG $thickness=4.8e-08
+ $X=0.27 $Y=0.135 $X2=0.2525 $Y2=0.135
r60 33 43 10.1729 $w=1.54914e-08 $l=1.75e-08 $layer=LIG $thickness=4.8e-08
+ $X=0.3065 $Y=0.135 $X2=0.324 $Y2=0.135
r61 32 33 2.48102 $w=2.2e-08 $l=9.5e-09 $layer=LIG $thickness=4.8e-08 $X=0.297
+ $Y=0.135 $X2=0.3065 $Y2=0.135
r62 32 50 19.3796 $a=3.24e-16 $layer=V0LIG $X=0.297 $Y=0.135 $X2=0.297 $Y2=0.135
r63 1 32 2.48102 $w=2.2e-08 $l=9.5e-09 $layer=LIG $thickness=4.8e-08 $X=0.2875
+ $Y=0.135 $X2=0.297 $Y2=0.135
r64 1 34 10.1729 $w=1.54914e-08 $l=1.75e-08 $layer=LIG $thickness=4.8e-08
+ $X=0.2875 $Y=0.135 $X2=0.27 $Y2=0.135
r65 30 29 16.4967 $w=2.1e-08 $l=4.85e-08 $layer=Gate_1 $thickness=5.6e-08
+ $X=0.297 $Y=0.2025 $X2=0.297 $Y2=0.154
r66 28 29 6.6497 $w=2.04211e-08 $l=1.9e-08 $layer=Gate_1 $thickness=5.6e-08
+ $X=0.297 $Y=0.135 $X2=0.297 $Y2=0.154
r67 28 33 4.05918 $w=2.0087e-08 $l=9.5e-09 $layer=Gate_1 $thickness=5.56522e-08
+ $X=0.297 $Y=0.135 $X2=0.3065 $Y2=0.135
r68 28 32 6.27904 $w=2.09e-08 $layer=Gate_1 $thickness=5.24e-08 $X=0.297
+ $Y=0.135 $X2=0.297 $Y2=0.135
r69 27 28 6.6497 $w=2.04211e-08 $l=1.9e-08 $layer=Gate_1 $thickness=5.6e-08
+ $X=0.297 $Y=0.116 $X2=0.297 $Y2=0.135
r70 26 27 16.4967 $w=2.1e-08 $l=4.85e-08 $layer=Gate_1 $thickness=5.6e-08
+ $X=0.297 $Y=0.0675 $X2=0.297 $Y2=0.116
r71 26 14 14.6259 $w=2.1e-08 $l=4.3e-08 $layer=Gate_1 $thickness=5.6e-08
+ $X=0.297 $Y=0.0675 $X2=0.297 $Y2=0.0245
r72 7 19 1e-05 $l=1.36473e-08 $X=0.108 $Y=0.2025 $X2=0.11 $Y2=0.189
r73 6 17 1e-05 $l=1.36473e-08 $X=0.108 $Y=0.0675 $X2=0.11 $Y2=0.081
.ends

.subckt PM_BUFx4f_ASAP7_75t_R%Y vss 37 24 25 33 34 46 47 50 51 15 20 21 3 4 1 2
+ 16 13 14
c1 1 vss 0.0083797f $X=0.216 $Y=0.0675
c2 2 vss 0.00833282f $X=0.216 $Y=0.2025
c3 3 vss 0.00836894f $X=0.324 $Y=0.0675
c4 4 vss 0.00836894f $X=0.324 $Y=0.2025
c5 13 vss 0.00435126f $X=0.2015 $Y=0.0675
c6 14 vss 0.00431511f $X=0.3095 $Y=0.0675
c7 15 vss 0.00435323f $X=0.2015 $Y=0.2025
c8 16 vss 0.00431835f $X=0.3095 $Y=0.2025
c9 17 vss 0.0028685f $X=0.405 $Y=0.036
c10 18 vss 0.0028685f $X=0.405 $Y=0.234
c11 19 vss 0.0177481f $X=0.203 $Y=0.036
c12 20 vss 0.0176985f $X=0.3815 $Y=0.234
c13 21 vss 0.00781994f $X=0.405 $Y=0.0855
r1 51 49 0.0308642 $w=8.1e-08 $l=2.5e-09 $layer=P_src_drn $thickness=1e-09
+ $X=0.3413 $Y=0.2025 $X2=0.3385 $Y2=0.2025
r2 4 49 0.179012 $w=8.1e-08 $l=1.45e-08 $layer=P_src_drn $thickness=1e-09
+ $X=0.324 $Y=0.2025 $X2=0.3385 $Y2=0.2025
r3 16 4 0.179012 $w=8.1e-08 $l=1.45e-08 $layer=P_src_drn $thickness=1e-09
+ $X=0.3095 $Y=0.2025 $X2=0.324 $Y2=0.2025
r4 50 16 0.0308642 $w=8.1e-08 $l=2.5e-09 $layer=P_src_drn $thickness=1e-09
+ $X=0.3066 $Y=0.2025 $X2=0.3095 $Y2=0.2025
r5 47 45 0.0308642 $w=8.1e-08 $l=2.5e-09 $layer=P_src_drn $thickness=1e-09
+ $X=0.2333 $Y=0.2025 $X2=0.2305 $Y2=0.2025
r6 2 45 0.179012 $w=8.1e-08 $l=1.45e-08 $layer=P_src_drn $thickness=1e-09
+ $X=0.216 $Y=0.2025 $X2=0.2305 $Y2=0.2025
r7 15 2 0.179012 $w=8.1e-08 $l=1.45e-08 $layer=P_src_drn $thickness=1e-09
+ $X=0.2015 $Y=0.2025 $X2=0.216 $Y2=0.2025
r8 46 15 0.0308642 $w=8.1e-08 $l=2.5e-09 $layer=P_src_drn $thickness=1e-09
+ $X=0.1986 $Y=0.2025 $X2=0.2015 $Y2=0.2025
r9 4 42 19.3796 $a=3.24e-16 $layer=V0LISD $X=0.324 $Y=0.2025 $X2=0.324 $Y2=0.234
r10 2 40 19.3796 $a=3.24e-16 $layer=V0LISD $X=0.216 $Y=0.2025 $X2=0.216
+ $Y2=0.234
r11 42 43 6.06293 $w=1.3e-08 $l=2.6e-08 $layer=M1 $thickness=3.6e-08 $X=0.324
+ $Y=0.234 $X2=0.35 $Y2=0.234
r12 41 42 12.5922 $w=1.3e-08 $l=5.4e-08 $layer=M1 $thickness=3.6e-08 $X=0.27
+ $Y=0.234 $X2=0.324 $Y2=0.234
r13 40 41 12.5922 $w=1.3e-08 $l=5.4e-08 $layer=M1 $thickness=3.6e-08 $X=0.216
+ $Y=0.234 $X2=0.27 $Y2=0.234
r14 20 43 7.34548 $w=1.3e-08 $l=3.15e-08 $layer=M1 $thickness=3.6e-08 $X=0.3815
+ $Y=0.234 $X2=0.35 $Y2=0.234
r15 18 38 8.78613 $w=1.49709e-08 $l=4.48e-08 $layer=M1 $thickness=3.6e-08
+ $X=0.405 $Y=0.234 $X2=0.405 $Y2=0.1892
r16 18 20 3.83085 $w=1.49149e-08 $l=2.35e-08 $layer=M1 $thickness=3.6e-08
+ $X=0.405 $Y=0.234 $X2=0.3815 $Y2=0.234
r17 37 38 8.45313 $w=1.3e-08 $l=3.62e-08 $layer=M1 $thickness=3.6e-08 $X=0.406
+ $Y=0.153 $X2=0.405 $Y2=0.1892
r18 37 36 1.10765 $w=1.3e-08 $l=4.8e-09 $layer=M1 $thickness=3.6e-08 $X=0.406
+ $Y=0.153 $X2=0.405 $Y2=0.1482
r19 35 36 3.08976 $w=1.3e-08 $l=1.32e-08 $layer=M1 $thickness=3.6e-08 $X=0.405
+ $Y=0.135 $X2=0.405 $Y2=0.1482
r20 21 35 11.5429 $w=1.3e-08 $l=4.95e-08 $layer=M1 $thickness=3.6e-08 $X=0.405
+ $Y=0.0855 $X2=0.405 $Y2=0.135
r21 34 32 0.0308642 $w=8.1e-08 $l=2.5e-09 $layer=N_src_drn $thickness=1e-09
+ $X=0.3413 $Y=0.0675 $X2=0.3385 $Y2=0.0675
r22 3 32 0.179012 $w=8.1e-08 $l=1.45e-08 $layer=N_src_drn $thickness=1e-09
+ $X=0.324 $Y=0.0675 $X2=0.3385 $Y2=0.0675
r23 14 3 0.179012 $w=8.1e-08 $l=1.45e-08 $layer=N_src_drn $thickness=1e-09
+ $X=0.3095 $Y=0.0675 $X2=0.324 $Y2=0.0675
r24 33 14 0.0308642 $w=8.1e-08 $l=2.5e-09 $layer=N_src_drn $thickness=1e-09
+ $X=0.3066 $Y=0.0675 $X2=0.3095 $Y2=0.0675
r25 17 30 3.83085 $w=1.49149e-08 $l=2.35e-08 $layer=M1 $thickness=3.6e-08
+ $X=0.405 $Y=0.036 $X2=0.3815 $Y2=0.036
r26 17 21 9.89378 $w=1.47818e-08 $l=4.95e-08 $layer=M1 $thickness=3.6e-08
+ $X=0.405 $Y=0.036 $X2=0.405 $Y2=0.0855
r27 3 28 19.3796 $a=3.24e-16 $layer=V0LISD $X=0.324 $Y=0.0675 $X2=0.324
+ $Y2=0.036
r28 29 30 7.34548 $w=1.3e-08 $l=3.15e-08 $layer=M1 $thickness=3.6e-08 $X=0.35
+ $Y=0.036 $X2=0.3815 $Y2=0.036
r29 28 29 6.06293 $w=1.3e-08 $l=2.6e-08 $layer=M1 $thickness=3.6e-08 $X=0.324
+ $Y=0.036 $X2=0.35 $Y2=0.036
r30 27 28 12.5922 $w=1.3e-08 $l=5.4e-08 $layer=M1 $thickness=3.6e-08 $X=0.27
+ $Y=0.036 $X2=0.324 $Y2=0.036
r31 26 27 12.5922 $w=1.3e-08 $l=5.4e-08 $layer=M1 $thickness=3.6e-08 $X=0.216
+ $Y=0.036 $X2=0.27 $Y2=0.036
r32 19 26 3.03147 $w=1.3e-08 $l=1.3e-08 $layer=M1 $thickness=3.6e-08 $X=0.203
+ $Y=0.036 $X2=0.216 $Y2=0.036
r33 1 26 19.3796 $a=3.24e-16 $layer=V0LISD $X=0.216 $Y=0.0675 $X2=0.216
+ $Y2=0.036
r34 25 23 0.0308642 $w=8.1e-08 $l=2.5e-09 $layer=N_src_drn $thickness=1e-09
+ $X=0.2333 $Y=0.0675 $X2=0.2305 $Y2=0.0675
r35 1 23 0.179012 $w=8.1e-08 $l=1.45e-08 $layer=N_src_drn $thickness=1e-09
+ $X=0.216 $Y=0.0675 $X2=0.2305 $Y2=0.0675
r36 13 1 0.179012 $w=8.1e-08 $l=1.45e-08 $layer=N_src_drn $thickness=1e-09
+ $X=0.2015 $Y=0.0675 $X2=0.216 $Y2=0.0675
r37 24 13 0.0308642 $w=8.1e-08 $l=2.5e-09 $layer=N_src_drn $thickness=1e-09
+ $X=0.1986 $Y=0.0675 $X2=0.2015 $Y2=0.0675
.ends

* End of included file BUFx4f_ASAP7_75t_R.pex.sp.pex

*
.subckt BUFx4f_ASAP7_75t_CUSTOM_4_25_0_7 VSS VDD A Y
*
* VSS VSS
* VDD VDD
* A A
* Y Y
*
*

M0 N_M0_d N_M0_g VSS VSS nmos_rvt L=2e-08 W=2.7e-08 nfin=1 $X=0.071 $Y=0.027
M1 N_M1_d N_M1_g VSS VSS nmos_rvt L=2e-08 W=8.1e-08 nfin=3 $X=0.125 $Y=0.027
M2 N_M2_d N_M2_g VSS VSS nmos_rvt L=2e-08 W=8.1e-08 nfin=3 $X=0.179 $Y=0.027
M3 N_M3_d N_M3_g VSS VSS nmos_rvt L=2e-08 W=8.1e-08 nfin=3 $X=0.233 $Y=0.027
M4 N_M4_d N_M4_g VSS VSS nmos_rvt L=2e-08 W=8.1e-08 nfin=3 $X=0.287 $Y=0.027
M5 N_M5_d N_M5_g VSS VSS nmos_rvt L=2e-08 W=8.1e-08 nfin=3 $X=0.341 $Y=0.027
M6 N_M6_d N_M6_g VDD VDD pmos_rvt L=2e-08 W=2.7e-08 nfin=1 $X=0.071 $Y=0.216
M7 N_M7_d N_M7_g VDD VDD pmos_rvt L=2e-08 W=8.1e-08 nfin=3 $X=0.125 $Y=0.162
M8 N_M8_d N_M8_g VDD VDD pmos_rvt L=2e-08 W=8.1e-08 nfin=3 $X=0.179 $Y=0.162
M9 N_M9_d N_M9_g VDD VDD pmos_rvt L=2e-08 W=8.1e-08 nfin=3 $X=0.233 $Y=0.162
M10 N_M10_d N_M10_g VDD VDD pmos_rvt L=2e-08 W=8.1e-08 nfin=3 $X=0.287 $Y=0.162
M11 N_M11_d N_M11_g VDD VDD pmos_rvt L=2e-08 W=8.1e-08 nfin=3 $X=0.341 $Y=0.162

* .include "BUFx4f_ASAP7_75t_R.pex.sp.pxi"

* Start of included file BUFx4f_ASAP7_75t_R.pex.sp.pxi
x_PM_BUFx4f_ASAP7_75t_R%A vss A N_M0_g N_M6_g N_M1_g N_M7_g N_A_3 N_A_10 N_A_5
+ N_A_7 N_A_4 N_A_1 PM_BUFx4f_ASAP7_75t_R%A
x_PM_BUFx4f_ASAP7_75t_R%4 vss N_M4_g N_M10_g N_M3_g N_M9_g N_M2_g N_M8_g N_M5_g
+ N_M11_g N_M0_d N_M1_d N_M6_d N_M7_d N_4_25 N_4_20 N_4_21 N_4_19 N_4_17 N_4_7
+ N_4_23 N_4_24 N_4_12 N_4_6 N_4_22 N_4_18 N_4_16 N_4_1 N_4_14 N_4_15 N_4_13
+ PM_BUFx4f_ASAP7_75t_R%4
cc_1 N_4_25 N_A_3 0.0003342f $X=0.2165 $Y=0.135
cc_2 N_4_20 N_A_3 0.000508203f $X=0.135 $Y=0.036
cc_3 N_4_21 N_A_3 0.00056004f $X=0.135 $Y=0.234
cc_4 N_4_19 N_A_3 0.000711413f $X=0.11 $Y=0.189
cc_5 N_4_17 N_A_3 0.000711427f $X=0.11 $Y=0.081
cc_6 N_4_7 N_A_3 0.00255256f $X=0.108 $Y=0.2025
cc_7 N_4_23 N_A_3 0.00100527f $X=0.135 $Y=0.0855
cc_8 N_4_24 N_A_10 0.00100527f $X=0.135 $Y=0.1845
cc_9 N_4_20 N_A_5 0.00102663f $X=0.135 $Y=0.036
cc_10 N_4_21 N_A_7 0.00105983f $X=0.135 $Y=0.234
cc_11 N_4_12 N_A_4 0.00174596f $X=0.189 $Y=0.135
cc_12 N_4_6 N_A_3 0.0018307f $X=0.108 $Y=0.0675
cc_13 N_4_22 N_A_10 0.00229099f $X=0.135 $Y=0.135
cc_14 N_4_18 N_A_1 0.00613008f $X=0.0935 $Y=0.2295
cc_15 N_4_17 N_A_4 0.00984605f $X=0.11 $Y=0.081
cc_16 N_4_16 N_A_3 0.0202626f $X=0.0935 $Y=0.0405
cc_17 N_4_19 N_A_4 0.049874f $X=0.11 $Y=0.189
cc_18 N_4_18 N_A_3 0.0665385f $X=0.0935 $Y=0.2295
x_PM_BUFx4f_ASAP7_75t_R%Y vss Y N_M2_d N_M3_d N_M4_d N_M5_d N_M8_d N_M9_d
+ N_M10_d N_M11_d N_Y_15 N_Y_20 N_Y_21 N_Y_3 N_Y_4 N_Y_1 N_Y_2 N_Y_16 N_Y_13
+ N_Y_14 PM_BUFx4f_ASAP7_75t_R%Y
cc_19 N_Y_15 N_4_23 0.000365082f $X=0.2015 $Y=0.2025
cc_20 N_Y_15 N_4_24 0.000365082f $X=0.2015 $Y=0.2025
cc_21 N_Y_15 N_4_1 0.00224919f $X=0.2015 $Y=0.2025
cc_22 N_Y_15 N_4_12 0.0367395f $X=0.2015 $Y=0.2025
cc_23 N_Y_15 N_4_14 0.000823842f $X=0.2015 $Y=0.2025
cc_24 N_Y_15 N_4_15 0.000839853f $X=0.2015 $Y=0.2025
cc_25 N_Y_15 N_4_25 0.00158337f $X=0.2015 $Y=0.2025
cc_26 N_Y_20 N_4_25 0.00158337f $X=0.3815 $Y=0.234
cc_27 N_Y_21 N_4_25 0.00174338f $X=0.405 $Y=0.0855
cc_28 N_Y_3 N_4_14 0.00187037f $X=0.324 $Y=0.0675
cc_29 N_Y_4 N_4_14 0.00187037f $X=0.324 $Y=0.2025
cc_30 N_Y_1 N_4_12 0.00206898f $X=0.216 $Y=0.0675
cc_31 N_Y_2 N_4_12 0.00206898f $X=0.216 $Y=0.2025
cc_32 N_Y_1 N_4_25 0.00428694f $X=0.216 $Y=0.0675
cc_33 N_Y_16 N_4_1 0.00861466f $X=0.3095 $Y=0.2025
cc_34 N_Y_13 N_4_12 0.0281263f $X=0.2015 $Y=0.0675
cc_35 N_Y_16 N_4_15 0.028307f $X=0.3095 $Y=0.2025
cc_36 N_Y_14 N_4_14 0.0181444f $X=0.3095 $Y=0.0675
cc_37 N_Y_16 N_4_14 0.0364329f $X=0.3095 $Y=0.2025
cc_38 N_Y_14 N_4_15 0.0462527f $X=0.3095 $Y=0.0675
cc_39 N_Y_15 N_4_13 0.0664261f $X=0.2015 $Y=0.2025

* End of included file BUFx4f_ASAP7_75t_R.pex.sp.pxi
.ends

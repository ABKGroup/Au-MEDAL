.subckt PM_BUFx24_ASAP7_75t_R%A vss 31 13 19 34 37 40 43 46 49 6 7 12 5 3 4 1
c1 1 vss 0.0239575f $X=0.072 $Y=0.135
c2 3 vss 0.0921507f $X=0.081 $Y=0.0245
c3 4 vss 0.0812497f $X=0.135 $Y=0.135
c4 5 vss 0.0804668f $X=0.189 $Y=0.135
c5 6 vss 0.0813085f $X=0.243 $Y=0.135
c6 7 vss 0.00901338f $X=0.027 $Y=0.036
c7 8 vss 0.00229902f $X=0.027 $Y=0.135
c8 9 vss 0.00901599f $X=0.027 $Y=0.234
c9 10 vss 0.0123263f $X=0.027 $Y=0.0855
c10 11 vss 0.0123931f $X=0.027 $Y=0.1845
c11 12 vss 0.0031769f $X=0.0455 $Y=0.135
r1 9 11 10.3626 $w=1.39091e-08 $l=4.95e-08 $layer=M1 $thickness=3.6e-08
+ $X=0.027 $Y=0.234 $X2=0.027 $Y2=0.1845
r2 7 10 10.3626 $w=1.39091e-08 $l=4.95e-08 $layer=M1 $thickness=3.6e-08
+ $X=0.027 $Y=0.036 $X2=0.027 $Y2=0.0855
r3 8 12 3.1337 $w=1.54324e-08 $l=1.85e-08 $layer=M1 $thickness=3.6e-08 $X=0.027
+ $Y=0.135 $X2=0.0455 $Y2=0.135
r4 8 10 10.3626 $w=1.39091e-08 $l=4.95e-08 $layer=M1 $thickness=3.6e-08
+ $X=0.027 $Y=0.135 $X2=0.027 $Y2=0.0855
r5 8 11 10.3626 $w=1.39091e-08 $l=4.95e-08 $layer=M1 $thickness=3.6e-08
+ $X=0.027 $Y=0.135 $X2=0.027 $Y2=0.1845
r6 49 48 16.4967 $w=2.1e-08 $l=4.85e-08 $layer=Gate_1 $thickness=5.6e-08
+ $X=0.243 $Y=0.2025 $X2=0.243 $Y2=0.154
r7 46 47 16.4967 $w=2.1e-08 $l=4.85e-08 $layer=Gate_1 $thickness=5.6e-08
+ $X=0.243 $Y=0.0675 $X2=0.243 $Y2=0.116
r8 6 29 6.54019 $w=2.09524e-08 $layer=Gate_1 $thickness=5.21905e-08 $X=0.243
+ $Y=0.135 $X2=0.243 $Y2=0.135
r9 6 47 6.6497 $w=2.04211e-08 $l=1.9e-08 $layer=Gate_1 $thickness=5.6e-08
+ $X=0.243 $Y=0.135 $X2=0.243 $Y2=0.116
r10 6 48 6.6497 $w=2.04211e-08 $l=1.9e-08 $layer=Gate_1 $thickness=5.6e-08
+ $X=0.243 $Y=0.135 $X2=0.243 $Y2=0.154
r11 43 42 16.4967 $w=2.1e-08 $l=4.85e-08 $layer=Gate_1 $thickness=5.6e-08
+ $X=0.189 $Y=0.2025 $X2=0.189 $Y2=0.154
r12 40 41 16.4967 $w=2.1e-08 $l=4.85e-08 $layer=Gate_1 $thickness=5.6e-08
+ $X=0.189 $Y=0.0675 $X2=0.189 $Y2=0.116
r13 5 27 6.54019 $w=2.09524e-08 $layer=Gate_1 $thickness=5.21905e-08 $X=0.189
+ $Y=0.135 $X2=0.189 $Y2=0.135
r14 5 41 6.6497 $w=2.04211e-08 $l=1.9e-08 $layer=Gate_1 $thickness=5.6e-08
+ $X=0.189 $Y=0.135 $X2=0.189 $Y2=0.116
r15 5 42 6.6497 $w=2.04211e-08 $l=1.9e-08 $layer=Gate_1 $thickness=5.6e-08
+ $X=0.189 $Y=0.135 $X2=0.189 $Y2=0.154
r16 37 36 16.4967 $w=2.1e-08 $l=4.85e-08 $layer=Gate_1 $thickness=5.6e-08
+ $X=0.135 $Y=0.2025 $X2=0.135 $Y2=0.154
r17 34 35 16.4967 $w=2.1e-08 $l=4.85e-08 $layer=Gate_1 $thickness=5.6e-08
+ $X=0.135 $Y=0.0675 $X2=0.135 $Y2=0.116
r18 4 25 6.54019 $w=2.09524e-08 $layer=Gate_1 $thickness=5.21905e-08 $X=0.135
+ $Y=0.135 $X2=0.135 $Y2=0.135
r19 4 35 6.6497 $w=2.04211e-08 $l=1.9e-08 $layer=Gate_1 $thickness=5.6e-08
+ $X=0.135 $Y=0.135 $X2=0.135 $Y2=0.116
r20 4 36 6.6497 $w=2.04211e-08 $l=1.9e-08 $layer=Gate_1 $thickness=5.6e-08
+ $X=0.135 $Y=0.135 $X2=0.135 $Y2=0.154
r21 31 12 4.31401 $w=1.3e-08 $l=1.85e-08 $layer=M1 $thickness=3.6e-08 $X=0.061
+ $Y=0.1335 $X2=0.0455 $Y2=0.135
r22 28 29 12.6539 $w=1.77815e-08 $l=2.7e-08 $layer=LIG $thickness=4.8e-08
+ $X=0.216 $Y=0.135 $X2=0.243 $Y2=0.135
r23 27 28 12.6539 $w=1.77815e-08 $l=2.7e-08 $layer=LIG $thickness=4.8e-08
+ $X=0.189 $Y=0.135 $X2=0.216 $Y2=0.135
r24 26 27 12.6539 $w=1.77815e-08 $l=2.7e-08 $layer=LIG $thickness=4.8e-08
+ $X=0.162 $Y=0.135 $X2=0.189 $Y2=0.135
r25 25 26 12.6539 $w=1.77815e-08 $l=2.7e-08 $layer=LIG $thickness=4.8e-08
+ $X=0.135 $Y=0.135 $X2=0.162 $Y2=0.135
r26 24 25 12.6539 $w=1.77815e-08 $l=2.7e-08 $layer=LIG $thickness=4.8e-08
+ $X=0.108 $Y=0.135 $X2=0.135 $Y2=0.135
r27 31 23 19.3796 $a=3.24e-16 $layer=V0LIG $X=0.061 $Y=0.1335 $X2=0.063
+ $Y2=0.135
r28 21 24 12.3927 $w=1.76192e-08 $l=2.6e-08 $layer=LIG $thickness=4.8e-08
+ $X=0.082 $Y=0.135 $X2=0.108 $Y2=0.135
r29 1 21 2.6116 $w=2.2e-08 $l=1e-08 $layer=LIG $thickness=4.8e-08 $X=0.072
+ $Y=0.135 $X2=0.082 $Y2=0.135
r30 1 23 4.98695 $w=1.60444e-08 $l=9e-09 $layer=LIG $thickness=4.8e-08 $X=0.072
+ $Y=0.135 $X2=0.063 $Y2=0.135
r31 19 18 14.6259 $w=2.1e-08 $l=4.3e-08 $layer=Gate_1 $thickness=5.6e-08
+ $X=0.081 $Y=0.2025 $X2=0.081 $Y2=0.1595
r32 17 18 2.7211 $w=2.1e-08 $l=8e-09 $layer=Gate_1 $thickness=5.6e-08 $X=0.081
+ $Y=0.1515 $X2=0.081 $Y2=0.1595
r33 16 17 5.79936 $w=2.03333e-08 $l=1.65e-08 $layer=Gate_1 $thickness=5.6e-08
+ $X=0.081 $Y=0.135 $X2=0.081 $Y2=0.1515
r34 16 21 6.27904 $w=2.09e-08 $l=1e-09 $layer=Gate_1 $thickness=5.24e-08
+ $X=0.081 $Y=0.135 $X2=0.082 $Y2=0.135
r35 15 16 5.79936 $w=2.03333e-08 $l=1.65e-08 $layer=Gate_1 $thickness=5.6e-08
+ $X=0.081 $Y=0.1185 $X2=0.081 $Y2=0.135
r36 14 15 2.7211 $w=2.1e-08 $l=8e-09 $layer=Gate_1 $thickness=5.6e-08 $X=0.081
+ $Y=0.1105 $X2=0.081 $Y2=0.1185
r37 13 14 14.6259 $w=2.1e-08 $l=4.3e-08 $layer=Gate_1 $thickness=5.6e-08
+ $X=0.081 $Y=0.0675 $X2=0.081 $Y2=0.1105
r38 13 3 14.6259 $w=2.1e-08 $l=4.3e-08 $layer=Gate_1 $thickness=5.6e-08
+ $X=0.081 $Y=0.0675 $X2=0.081 $Y2=0.0245
.ends

.subckt PM_BUFx24_ASAP7_75t_R%4 vss 74 78 226 229 232 235 238 241 244 247 250
+ 253 256 259 262 265 268 271 274 277 280 283 286 289 292 295 298 301 304 307
+ 310 313 316 319 322 325 328 331 334 337 340 343 346 349 352 355 359 363 375
+ 376 379 380 383 384 387 388 1 67 73 26 27 71 72 70 69 65 63 64 62 28 29 38 40
+ 42 44 46 48 50 52 54 56 58 60 66 68 61 41 43 45 47 49 51 53 55 57 59 39
c1 1 vss 0.209895f $X=0.6115 $Y=0.135
c2 26 vss 0.0169957f $X=0.108 $Y=0.0675
c3 27 vss 0.0169957f $X=0.108 $Y=0.2025
c4 28 vss 0.0162335f $X=0.216 $Y=0.0675
c5 29 vss 0.0162335f $X=0.216 $Y=0.2025
c6 38 vss 0.0841615f $X=0.297 $Y=0.135
c7 39 vss 0.0843361f $X=0.351 $Y=0.135
c8 40 vss 0.0843303f $X=0.405 $Y=0.135
c9 41 vss 0.0843303f $X=0.459 $Y=0.135
c10 42 vss 0.0843303f $X=0.513 $Y=0.135
c11 43 vss 0.0843303f $X=0.567 $Y=0.135
c12 44 vss 0.0843303f $X=0.621 $Y=0.0245
c13 45 vss 0.0843303f $X=0.675 $Y=0.135
c14 46 vss 0.0843303f $X=0.729 $Y=0.135
c15 47 vss 0.0843303f $X=0.783 $Y=0.135
c16 48 vss 0.0843303f $X=0.837 $Y=0.135
c17 49 vss 0.0843303f $X=0.891 $Y=0.135
c18 50 vss 0.0843303f $X=0.945 $Y=0.135
c19 51 vss 0.0843303f $X=0.999 $Y=0.135
c20 52 vss 0.0843303f $X=1.053 $Y=0.135
c21 53 vss 0.0843303f $X=1.107 $Y=0.135
c22 54 vss 0.0843303f $X=1.161 $Y=0.135
c23 55 vss 0.0843303f $X=1.215 $Y=0.135
c24 56 vss 0.0843303f $X=1.269 $Y=0.135
c25 57 vss 0.0843303f $X=1.323 $Y=0.135
c26 58 vss 0.0843303f $X=1.377 $Y=0.135
c27 59 vss 0.0841902f $X=1.431 $Y=0.135
c28 60 vss 0.0846412f $X=1.485 $Y=0.135
c29 61 vss 0.0847238f $X=1.539 $Y=0.135
c30 62 vss 0.0159749f $X=0.0935 $Y=0.0675
c31 63 vss 0.0159987f $X=0.2015 $Y=0.0675
c32 64 vss 0.0159717f $X=0.0935 $Y=0.2025
c33 65 vss 0.0159966f $X=0.2015 $Y=0.2025
c34 66 vss 0.00690059f $X=0.243 $Y=0.036
c35 67 vss 0.0040008f $X=0.243 $Y=0.135
c36 68 vss 0.00690059f $X=0.243 $Y=0.234
c37 69 vss 0.017016f $X=0.0965 $Y=0.036
c38 70 vss 0.017016f $X=0.0965 $Y=0.234
c39 71 vss 0.00645824f $X=0.243 $Y=0.0855
c40 72 vss 0.00645824f $X=0.243 $Y=0.1845
c41 73 vss 0.0300914f $X=0.27 $Y=0.135
r1 388 386 0.0308642 $w=8.1e-08 $l=2.5e-09 $layer=P_src_drn $thickness=1e-09
+ $X=0.2333 $Y=0.2025 $X2=0.2305 $Y2=0.2025
r2 29 386 0.179012 $w=8.1e-08 $l=1.45e-08 $layer=P_src_drn $thickness=1e-09
+ $X=0.216 $Y=0.2025 $X2=0.2305 $Y2=0.2025
r3 65 29 0.179012 $w=8.1e-08 $l=1.45e-08 $layer=P_src_drn $thickness=1e-09
+ $X=0.2015 $Y=0.2025 $X2=0.216 $Y2=0.2025
r4 387 65 0.0308642 $w=8.1e-08 $l=2.5e-09 $layer=P_src_drn $thickness=1e-09
+ $X=0.1986 $Y=0.2025 $X2=0.2015 $Y2=0.2025
r5 384 382 0.0308642 $w=8.1e-08 $l=2.5e-09 $layer=P_src_drn $thickness=1e-09
+ $X=0.1253 $Y=0.2025 $X2=0.1225 $Y2=0.2025
r6 27 382 0.179012 $w=8.1e-08 $l=1.45e-08 $layer=P_src_drn $thickness=1e-09
+ $X=0.108 $Y=0.2025 $X2=0.1225 $Y2=0.2025
r7 64 27 0.179012 $w=8.1e-08 $l=1.45e-08 $layer=P_src_drn $thickness=1e-09
+ $X=0.0935 $Y=0.2025 $X2=0.108 $Y2=0.2025
r8 383 64 0.0308642 $w=8.1e-08 $l=2.5e-09 $layer=P_src_drn $thickness=1e-09
+ $X=0.0906 $Y=0.2025 $X2=0.0935 $Y2=0.2025
r9 380 378 0.0308642 $w=8.1e-08 $l=2.5e-09 $layer=N_src_drn $thickness=1e-09
+ $X=0.2333 $Y=0.0675 $X2=0.2305 $Y2=0.0675
r10 28 378 0.179012 $w=8.1e-08 $l=1.45e-08 $layer=N_src_drn $thickness=1e-09
+ $X=0.216 $Y=0.0675 $X2=0.2305 $Y2=0.0675
r11 63 28 0.179012 $w=8.1e-08 $l=1.45e-08 $layer=N_src_drn $thickness=1e-09
+ $X=0.2015 $Y=0.0675 $X2=0.216 $Y2=0.0675
r12 379 63 0.0308642 $w=8.1e-08 $l=2.5e-09 $layer=N_src_drn $thickness=1e-09
+ $X=0.1986 $Y=0.0675 $X2=0.2015 $Y2=0.0675
r13 376 374 0.0308642 $w=8.1e-08 $l=2.5e-09 $layer=N_src_drn $thickness=1e-09
+ $X=0.1253 $Y=0.0675 $X2=0.1225 $Y2=0.0675
r14 26 374 0.179012 $w=8.1e-08 $l=1.45e-08 $layer=N_src_drn $thickness=1e-09
+ $X=0.108 $Y=0.0675 $X2=0.1225 $Y2=0.0675
r15 62 26 0.179012 $w=8.1e-08 $l=1.45e-08 $layer=N_src_drn $thickness=1e-09
+ $X=0.0935 $Y=0.0675 $X2=0.108 $Y2=0.0675
r16 375 62 0.0308642 $w=8.1e-08 $l=2.5e-09 $layer=N_src_drn $thickness=1e-09
+ $X=0.0906 $Y=0.0675 $X2=0.0935 $Y2=0.0675
r17 29 371 19.3796 $a=3.24e-16 $layer=V0LISD $X=0.216 $Y=0.2025 $X2=0.216
+ $Y2=0.234
r18 27 369 19.3796 $a=3.24e-16 $layer=V0LISD $X=0.108 $Y=0.2025 $X2=0.108
+ $Y2=0.234
r19 28 367 19.3796 $a=3.24e-16 $layer=V0LISD $X=0.216 $Y=0.0675 $X2=0.216
+ $Y2=0.036
r20 26 365 19.3796 $a=3.24e-16 $layer=V0LISD $X=0.108 $Y=0.0675 $X2=0.108
+ $Y2=0.036
r21 371 372 3.14806 $w=1.3e-08 $l=1.35e-08 $layer=M1 $thickness=3.6e-08
+ $X=0.216 $Y=0.234 $X2=0.2295 $Y2=0.234
r22 370 371 12.5922 $w=1.3e-08 $l=5.4e-08 $layer=M1 $thickness=3.6e-08 $X=0.162
+ $Y=0.234 $X2=0.216 $Y2=0.234
r23 369 370 12.5922 $w=1.3e-08 $l=5.4e-08 $layer=M1 $thickness=3.6e-08 $X=0.108
+ $Y=0.234 $X2=0.162 $Y2=0.234
r24 70 369 2.68168 $w=1.3e-08 $l=1.15e-08 $layer=M1 $thickness=3.6e-08
+ $X=0.0965 $Y=0.234 $X2=0.108 $Y2=0.234
r25 367 368 3.14806 $w=1.3e-08 $l=1.35e-08 $layer=M1 $thickness=3.6e-08
+ $X=0.216 $Y=0.036 $X2=0.2295 $Y2=0.036
r26 366 367 12.5922 $w=1.3e-08 $l=5.4e-08 $layer=M1 $thickness=3.6e-08 $X=0.162
+ $Y=0.036 $X2=0.216 $Y2=0.036
r27 365 366 12.5922 $w=1.3e-08 $l=5.4e-08 $layer=M1 $thickness=3.6e-08 $X=0.108
+ $Y=0.036 $X2=0.162 $Y2=0.036
r28 69 365 2.68168 $w=1.3e-08 $l=1.15e-08 $layer=M1 $thickness=3.6e-08
+ $X=0.0965 $Y=0.036 $X2=0.108 $Y2=0.036
r29 68 72 9.89378 $w=1.47818e-08 $l=4.95e-08 $layer=M1 $thickness=3.6e-08
+ $X=0.243 $Y=0.234 $X2=0.243 $Y2=0.1845
r30 68 372 1.49895 $w=1.63333e-08 $l=1.35e-08 $layer=M1 $thickness=3.6e-08
+ $X=0.243 $Y=0.234 $X2=0.2295 $Y2=0.234
r31 66 71 9.89378 $w=1.47818e-08 $l=4.95e-08 $layer=M1 $thickness=3.6e-08
+ $X=0.243 $Y=0.036 $X2=0.243 $Y2=0.0855
r32 66 368 1.49895 $w=1.63333e-08 $l=1.35e-08 $layer=M1 $thickness=3.6e-08
+ $X=0.243 $Y=0.036 $X2=0.2295 $Y2=0.036
r33 67 73 5.11582 $w=1.46667e-08 $l=2.7e-08 $layer=M1 $thickness=3.6e-08
+ $X=0.243 $Y=0.135 $X2=0.27 $Y2=0.135
r34 67 71 10.3626 $w=1.39091e-08 $l=4.95e-08 $layer=M1 $thickness=3.6e-08
+ $X=0.243 $Y=0.135 $X2=0.243 $Y2=0.0855
r35 67 72 10.3626 $w=1.39091e-08 $l=4.95e-08 $layer=M1 $thickness=3.6e-08
+ $X=0.243 $Y=0.135 $X2=0.243 $Y2=0.1845
r36 363 362 14.6259 $w=2.1e-08 $l=4.3e-08 $layer=Gate_1 $thickness=5.6e-08
+ $X=1.539 $Y=0.2025 $X2=1.539 $Y2=0.1595
r37 361 362 2.7211 $w=2.1e-08 $l=8e-09 $layer=Gate_1 $thickness=5.6e-08
+ $X=1.539 $Y=0.1515 $X2=1.539 $Y2=0.1595
r38 359 360 14.6259 $w=2.1e-08 $l=4.3e-08 $layer=Gate_1 $thickness=5.6e-08
+ $X=1.539 $Y=0.0675 $X2=1.539 $Y2=0.1105
r39 357 360 2.7211 $w=2.1e-08 $l=8e-09 $layer=Gate_1 $thickness=5.6e-08
+ $X=1.539 $Y=0.1185 $X2=1.539 $Y2=0.1105
r40 61 173 6.27904 $w=2.09e-08 $layer=Gate_1 $thickness=5.24e-08 $X=1.539
+ $Y=0.135 $X2=1.539 $Y2=0.135
r41 61 357 5.79936 $w=2.03333e-08 $l=1.65e-08 $layer=Gate_1 $thickness=5.6e-08
+ $X=1.539 $Y=0.135 $X2=1.539 $Y2=0.1185
r42 61 361 5.79936 $w=2.03333e-08 $l=1.65e-08 $layer=Gate_1 $thickness=5.6e-08
+ $X=1.539 $Y=0.135 $X2=1.539 $Y2=0.1515
r43 355 354 16.4967 $w=2.1e-08 $l=4.85e-08 $layer=Gate_1 $thickness=5.6e-08
+ $X=1.485 $Y=0.2025 $X2=1.485 $Y2=0.154
r44 352 353 16.4967 $w=2.1e-08 $l=4.85e-08 $layer=Gate_1 $thickness=5.6e-08
+ $X=1.485 $Y=0.0675 $X2=1.485 $Y2=0.116
r45 60 169 6.27904 $w=2.09e-08 $layer=Gate_1 $thickness=5.24e-08 $X=1.485
+ $Y=0.135 $X2=1.485 $Y2=0.135
r46 60 353 6.6497 $w=2.04211e-08 $l=1.9e-08 $layer=Gate_1 $thickness=5.6e-08
+ $X=1.485 $Y=0.135 $X2=1.485 $Y2=0.116
r47 60 354 6.6497 $w=2.04211e-08 $l=1.9e-08 $layer=Gate_1 $thickness=5.6e-08
+ $X=1.485 $Y=0.135 $X2=1.485 $Y2=0.154
r48 349 348 16.4967 $w=2.1e-08 $l=4.85e-08 $layer=Gate_1 $thickness=5.6e-08
+ $X=1.431 $Y=0.2025 $X2=1.431 $Y2=0.154
r49 346 347 16.4967 $w=2.1e-08 $l=4.85e-08 $layer=Gate_1 $thickness=5.6e-08
+ $X=1.431 $Y=0.0675 $X2=1.431 $Y2=0.116
r50 59 165 6.27904 $w=2.09e-08 $layer=Gate_1 $thickness=5.24e-08 $X=1.431
+ $Y=0.135 $X2=1.431 $Y2=0.135
r51 59 347 6.6497 $w=2.04211e-08 $l=1.9e-08 $layer=Gate_1 $thickness=5.6e-08
+ $X=1.431 $Y=0.135 $X2=1.431 $Y2=0.116
r52 59 348 6.6497 $w=2.04211e-08 $l=1.9e-08 $layer=Gate_1 $thickness=5.6e-08
+ $X=1.431 $Y=0.135 $X2=1.431 $Y2=0.154
r53 343 342 16.4967 $w=2.1e-08 $l=4.85e-08 $layer=Gate_1 $thickness=5.6e-08
+ $X=1.377 $Y=0.2025 $X2=1.377 $Y2=0.154
r54 340 341 16.4967 $w=2.1e-08 $l=4.85e-08 $layer=Gate_1 $thickness=5.6e-08
+ $X=1.377 $Y=0.0675 $X2=1.377 $Y2=0.116
r55 58 161 6.27904 $w=2.09e-08 $layer=Gate_1 $thickness=5.24e-08 $X=1.377
+ $Y=0.135 $X2=1.377 $Y2=0.135
r56 58 341 6.6497 $w=2.04211e-08 $l=1.9e-08 $layer=Gate_1 $thickness=5.6e-08
+ $X=1.377 $Y=0.135 $X2=1.377 $Y2=0.116
r57 58 342 6.6497 $w=2.04211e-08 $l=1.9e-08 $layer=Gate_1 $thickness=5.6e-08
+ $X=1.377 $Y=0.135 $X2=1.377 $Y2=0.154
r58 337 336 16.4967 $w=2.1e-08 $l=4.85e-08 $layer=Gate_1 $thickness=5.6e-08
+ $X=1.323 $Y=0.2025 $X2=1.323 $Y2=0.154
r59 334 335 16.4967 $w=2.1e-08 $l=4.85e-08 $layer=Gate_1 $thickness=5.6e-08
+ $X=1.323 $Y=0.0675 $X2=1.323 $Y2=0.116
r60 57 157 6.27904 $w=2.09e-08 $layer=Gate_1 $thickness=5.24e-08 $X=1.323
+ $Y=0.135 $X2=1.323 $Y2=0.135
r61 57 335 6.6497 $w=2.04211e-08 $l=1.9e-08 $layer=Gate_1 $thickness=5.6e-08
+ $X=1.323 $Y=0.135 $X2=1.323 $Y2=0.116
r62 57 336 6.6497 $w=2.04211e-08 $l=1.9e-08 $layer=Gate_1 $thickness=5.6e-08
+ $X=1.323 $Y=0.135 $X2=1.323 $Y2=0.154
r63 331 330 16.4967 $w=2.1e-08 $l=4.85e-08 $layer=Gate_1 $thickness=5.6e-08
+ $X=1.269 $Y=0.2025 $X2=1.269 $Y2=0.154
r64 328 329 16.4967 $w=2.1e-08 $l=4.85e-08 $layer=Gate_1 $thickness=5.6e-08
+ $X=1.269 $Y=0.0675 $X2=1.269 $Y2=0.116
r65 56 153 6.27904 $w=2.09e-08 $layer=Gate_1 $thickness=5.24e-08 $X=1.269
+ $Y=0.135 $X2=1.269 $Y2=0.135
r66 56 329 6.6497 $w=2.04211e-08 $l=1.9e-08 $layer=Gate_1 $thickness=5.6e-08
+ $X=1.269 $Y=0.135 $X2=1.269 $Y2=0.116
r67 56 330 6.6497 $w=2.04211e-08 $l=1.9e-08 $layer=Gate_1 $thickness=5.6e-08
+ $X=1.269 $Y=0.135 $X2=1.269 $Y2=0.154
r68 325 324 16.4967 $w=2.1e-08 $l=4.85e-08 $layer=Gate_1 $thickness=5.6e-08
+ $X=1.215 $Y=0.2025 $X2=1.215 $Y2=0.154
r69 322 323 16.4967 $w=2.1e-08 $l=4.85e-08 $layer=Gate_1 $thickness=5.6e-08
+ $X=1.215 $Y=0.0675 $X2=1.215 $Y2=0.116
r70 55 149 6.27904 $w=2.09e-08 $layer=Gate_1 $thickness=5.24e-08 $X=1.215
+ $Y=0.135 $X2=1.215 $Y2=0.135
r71 55 323 6.6497 $w=2.04211e-08 $l=1.9e-08 $layer=Gate_1 $thickness=5.6e-08
+ $X=1.215 $Y=0.135 $X2=1.215 $Y2=0.116
r72 55 324 6.6497 $w=2.04211e-08 $l=1.9e-08 $layer=Gate_1 $thickness=5.6e-08
+ $X=1.215 $Y=0.135 $X2=1.215 $Y2=0.154
r73 319 318 16.4967 $w=2.1e-08 $l=4.85e-08 $layer=Gate_1 $thickness=5.6e-08
+ $X=1.161 $Y=0.2025 $X2=1.161 $Y2=0.154
r74 316 317 16.4967 $w=2.1e-08 $l=4.85e-08 $layer=Gate_1 $thickness=5.6e-08
+ $X=1.161 $Y=0.0675 $X2=1.161 $Y2=0.116
r75 54 145 6.27904 $w=2.09e-08 $layer=Gate_1 $thickness=5.24e-08 $X=1.161
+ $Y=0.135 $X2=1.161 $Y2=0.135
r76 54 317 6.6497 $w=2.04211e-08 $l=1.9e-08 $layer=Gate_1 $thickness=5.6e-08
+ $X=1.161 $Y=0.135 $X2=1.161 $Y2=0.116
r77 54 318 6.6497 $w=2.04211e-08 $l=1.9e-08 $layer=Gate_1 $thickness=5.6e-08
+ $X=1.161 $Y=0.135 $X2=1.161 $Y2=0.154
r78 313 312 16.4967 $w=2.1e-08 $l=4.85e-08 $layer=Gate_1 $thickness=5.6e-08
+ $X=1.107 $Y=0.2025 $X2=1.107 $Y2=0.154
r79 310 311 16.4967 $w=2.1e-08 $l=4.85e-08 $layer=Gate_1 $thickness=5.6e-08
+ $X=1.107 $Y=0.0675 $X2=1.107 $Y2=0.116
r80 53 141 6.27904 $w=2.09e-08 $layer=Gate_1 $thickness=5.24e-08 $X=1.107
+ $Y=0.135 $X2=1.107 $Y2=0.135
r81 53 311 6.6497 $w=2.04211e-08 $l=1.9e-08 $layer=Gate_1 $thickness=5.6e-08
+ $X=1.107 $Y=0.135 $X2=1.107 $Y2=0.116
r82 53 312 6.6497 $w=2.04211e-08 $l=1.9e-08 $layer=Gate_1 $thickness=5.6e-08
+ $X=1.107 $Y=0.135 $X2=1.107 $Y2=0.154
r83 307 306 16.4967 $w=2.1e-08 $l=4.85e-08 $layer=Gate_1 $thickness=5.6e-08
+ $X=1.053 $Y=0.2025 $X2=1.053 $Y2=0.154
r84 304 305 16.4967 $w=2.1e-08 $l=4.85e-08 $layer=Gate_1 $thickness=5.6e-08
+ $X=1.053 $Y=0.0675 $X2=1.053 $Y2=0.116
r85 52 137 6.27904 $w=2.09e-08 $layer=Gate_1 $thickness=5.24e-08 $X=1.053
+ $Y=0.135 $X2=1.053 $Y2=0.135
r86 52 305 6.6497 $w=2.04211e-08 $l=1.9e-08 $layer=Gate_1 $thickness=5.6e-08
+ $X=1.053 $Y=0.135 $X2=1.053 $Y2=0.116
r87 52 306 6.6497 $w=2.04211e-08 $l=1.9e-08 $layer=Gate_1 $thickness=5.6e-08
+ $X=1.053 $Y=0.135 $X2=1.053 $Y2=0.154
r88 301 300 16.4967 $w=2.1e-08 $l=4.85e-08 $layer=Gate_1 $thickness=5.6e-08
+ $X=0.999 $Y=0.2025 $X2=0.999 $Y2=0.154
r89 298 299 16.4967 $w=2.1e-08 $l=4.85e-08 $layer=Gate_1 $thickness=5.6e-08
+ $X=0.999 $Y=0.0675 $X2=0.999 $Y2=0.116
r90 51 133 6.27904 $w=2.09e-08 $layer=Gate_1 $thickness=5.24e-08 $X=0.999
+ $Y=0.135 $X2=0.999 $Y2=0.135
r91 51 299 6.6497 $w=2.04211e-08 $l=1.9e-08 $layer=Gate_1 $thickness=5.6e-08
+ $X=0.999 $Y=0.135 $X2=0.999 $Y2=0.116
r92 51 300 6.6497 $w=2.04211e-08 $l=1.9e-08 $layer=Gate_1 $thickness=5.6e-08
+ $X=0.999 $Y=0.135 $X2=0.999 $Y2=0.154
r93 295 294 16.4967 $w=2.1e-08 $l=4.85e-08 $layer=Gate_1 $thickness=5.6e-08
+ $X=0.945 $Y=0.2025 $X2=0.945 $Y2=0.154
r94 292 293 16.4967 $w=2.1e-08 $l=4.85e-08 $layer=Gate_1 $thickness=5.6e-08
+ $X=0.945 $Y=0.0675 $X2=0.945 $Y2=0.116
r95 50 129 6.27904 $w=2.09e-08 $layer=Gate_1 $thickness=5.24e-08 $X=0.945
+ $Y=0.135 $X2=0.945 $Y2=0.135
r96 50 293 6.6497 $w=2.04211e-08 $l=1.9e-08 $layer=Gate_1 $thickness=5.6e-08
+ $X=0.945 $Y=0.135 $X2=0.945 $Y2=0.116
r97 50 294 6.6497 $w=2.04211e-08 $l=1.9e-08 $layer=Gate_1 $thickness=5.6e-08
+ $X=0.945 $Y=0.135 $X2=0.945 $Y2=0.154
r98 289 288 16.4967 $w=2.1e-08 $l=4.85e-08 $layer=Gate_1 $thickness=5.6e-08
+ $X=0.891 $Y=0.2025 $X2=0.891 $Y2=0.154
r99 286 287 16.4967 $w=2.1e-08 $l=4.85e-08 $layer=Gate_1 $thickness=5.6e-08
+ $X=0.891 $Y=0.0675 $X2=0.891 $Y2=0.116
r100 49 125 6.27904 $w=2.09e-08 $layer=Gate_1 $thickness=5.24e-08 $X=0.891
+ $Y=0.135 $X2=0.891 $Y2=0.135
r101 49 287 6.6497 $w=2.04211e-08 $l=1.9e-08 $layer=Gate_1 $thickness=5.6e-08
+ $X=0.891 $Y=0.135 $X2=0.891 $Y2=0.116
r102 49 288 6.6497 $w=2.04211e-08 $l=1.9e-08 $layer=Gate_1 $thickness=5.6e-08
+ $X=0.891 $Y=0.135 $X2=0.891 $Y2=0.154
r103 283 282 16.4967 $w=2.1e-08 $l=4.85e-08 $layer=Gate_1 $thickness=5.6e-08
+ $X=0.837 $Y=0.2025 $X2=0.837 $Y2=0.154
r104 280 281 16.4967 $w=2.1e-08 $l=4.85e-08 $layer=Gate_1 $thickness=5.6e-08
+ $X=0.837 $Y=0.0675 $X2=0.837 $Y2=0.116
r105 48 121 6.27904 $w=2.09e-08 $layer=Gate_1 $thickness=5.24e-08 $X=0.837
+ $Y=0.135 $X2=0.837 $Y2=0.135
r106 48 281 6.6497 $w=2.04211e-08 $l=1.9e-08 $layer=Gate_1 $thickness=5.6e-08
+ $X=0.837 $Y=0.135 $X2=0.837 $Y2=0.116
r107 48 282 6.6497 $w=2.04211e-08 $l=1.9e-08 $layer=Gate_1 $thickness=5.6e-08
+ $X=0.837 $Y=0.135 $X2=0.837 $Y2=0.154
r108 277 276 16.4967 $w=2.1e-08 $l=4.85e-08 $layer=Gate_1 $thickness=5.6e-08
+ $X=0.783 $Y=0.2025 $X2=0.783 $Y2=0.154
r109 274 275 16.4967 $w=2.1e-08 $l=4.85e-08 $layer=Gate_1 $thickness=5.6e-08
+ $X=0.783 $Y=0.0675 $X2=0.783 $Y2=0.116
r110 47 117 6.27904 $w=2.09e-08 $layer=Gate_1 $thickness=5.24e-08 $X=0.783
+ $Y=0.135 $X2=0.783 $Y2=0.135
r111 47 275 6.6497 $w=2.04211e-08 $l=1.9e-08 $layer=Gate_1 $thickness=5.6e-08
+ $X=0.783 $Y=0.135 $X2=0.783 $Y2=0.116
r112 47 276 6.6497 $w=2.04211e-08 $l=1.9e-08 $layer=Gate_1 $thickness=5.6e-08
+ $X=0.783 $Y=0.135 $X2=0.783 $Y2=0.154
r113 271 270 16.4967 $w=2.1e-08 $l=4.85e-08 $layer=Gate_1 $thickness=5.6e-08
+ $X=0.729 $Y=0.2025 $X2=0.729 $Y2=0.154
r114 268 269 16.4967 $w=2.1e-08 $l=4.85e-08 $layer=Gate_1 $thickness=5.6e-08
+ $X=0.729 $Y=0.0675 $X2=0.729 $Y2=0.116
r115 46 113 6.27904 $w=2.09e-08 $layer=Gate_1 $thickness=5.24e-08 $X=0.729
+ $Y=0.135 $X2=0.729 $Y2=0.135
r116 46 269 6.6497 $w=2.04211e-08 $l=1.9e-08 $layer=Gate_1 $thickness=5.6e-08
+ $X=0.729 $Y=0.135 $X2=0.729 $Y2=0.116
r117 46 270 6.6497 $w=2.04211e-08 $l=1.9e-08 $layer=Gate_1 $thickness=5.6e-08
+ $X=0.729 $Y=0.135 $X2=0.729 $Y2=0.154
r118 265 264 16.4967 $w=2.1e-08 $l=4.85e-08 $layer=Gate_1 $thickness=5.6e-08
+ $X=0.675 $Y=0.2025 $X2=0.675 $Y2=0.154
r119 262 263 16.4967 $w=2.1e-08 $l=4.85e-08 $layer=Gate_1 $thickness=5.6e-08
+ $X=0.675 $Y=0.0675 $X2=0.675 $Y2=0.116
r120 45 109 6.27904 $w=2.09e-08 $layer=Gate_1 $thickness=5.24e-08 $X=0.675
+ $Y=0.135 $X2=0.675 $Y2=0.135
r121 45 263 6.6497 $w=2.04211e-08 $l=1.9e-08 $layer=Gate_1 $thickness=5.6e-08
+ $X=0.675 $Y=0.135 $X2=0.675 $Y2=0.116
r122 45 264 6.6497 $w=2.04211e-08 $l=1.9e-08 $layer=Gate_1 $thickness=5.6e-08
+ $X=0.675 $Y=0.135 $X2=0.675 $Y2=0.154
r123 259 258 16.4967 $w=2.1e-08 $l=4.85e-08 $layer=Gate_1 $thickness=5.6e-08
+ $X=0.297 $Y=0.2025 $X2=0.297 $Y2=0.154
r124 256 257 16.4967 $w=2.1e-08 $l=4.85e-08 $layer=Gate_1 $thickness=5.6e-08
+ $X=0.297 $Y=0.0675 $X2=0.297 $Y2=0.116
r125 38 104 6.27904 $w=2.09e-08 $layer=Gate_1 $thickness=5.24e-08 $X=0.297
+ $Y=0.135 $X2=0.297 $Y2=0.135
r126 38 257 6.6497 $w=2.04211e-08 $l=1.9e-08 $layer=Gate_1 $thickness=5.6e-08
+ $X=0.297 $Y=0.135 $X2=0.297 $Y2=0.116
r127 38 258 6.6497 $w=2.04211e-08 $l=1.9e-08 $layer=Gate_1 $thickness=5.6e-08
+ $X=0.297 $Y=0.135 $X2=0.297 $Y2=0.154
r128 253 252 16.4967 $w=2.1e-08 $l=4.85e-08 $layer=Gate_1 $thickness=5.6e-08
+ $X=0.351 $Y=0.2025 $X2=0.351 $Y2=0.154
r129 250 251 16.4967 $w=2.1e-08 $l=4.85e-08 $layer=Gate_1 $thickness=5.6e-08
+ $X=0.351 $Y=0.0675 $X2=0.351 $Y2=0.116
r130 39 100 6.27904 $w=2.09e-08 $layer=Gate_1 $thickness=5.24e-08 $X=0.351
+ $Y=0.135 $X2=0.351 $Y2=0.135
r131 39 251 6.6497 $w=2.04211e-08 $l=1.9e-08 $layer=Gate_1 $thickness=5.6e-08
+ $X=0.351 $Y=0.135 $X2=0.351 $Y2=0.116
r132 39 252 6.6497 $w=2.04211e-08 $l=1.9e-08 $layer=Gate_1 $thickness=5.6e-08
+ $X=0.351 $Y=0.135 $X2=0.351 $Y2=0.154
r133 247 246 16.4967 $w=2.1e-08 $l=4.85e-08 $layer=Gate_1 $thickness=5.6e-08
+ $X=0.405 $Y=0.2025 $X2=0.405 $Y2=0.154
r134 244 245 16.4967 $w=2.1e-08 $l=4.85e-08 $layer=Gate_1 $thickness=5.6e-08
+ $X=0.405 $Y=0.0675 $X2=0.405 $Y2=0.116
r135 40 96 6.27904 $w=2.09e-08 $layer=Gate_1 $thickness=5.24e-08 $X=0.405
+ $Y=0.135 $X2=0.405 $Y2=0.135
r136 40 245 6.6497 $w=2.04211e-08 $l=1.9e-08 $layer=Gate_1 $thickness=5.6e-08
+ $X=0.405 $Y=0.135 $X2=0.405 $Y2=0.116
r137 40 246 6.6497 $w=2.04211e-08 $l=1.9e-08 $layer=Gate_1 $thickness=5.6e-08
+ $X=0.405 $Y=0.135 $X2=0.405 $Y2=0.154
r138 241 240 16.4967 $w=2.1e-08 $l=4.85e-08 $layer=Gate_1 $thickness=5.6e-08
+ $X=0.459 $Y=0.2025 $X2=0.459 $Y2=0.154
r139 238 239 16.4967 $w=2.1e-08 $l=4.85e-08 $layer=Gate_1 $thickness=5.6e-08
+ $X=0.459 $Y=0.0675 $X2=0.459 $Y2=0.116
r140 41 92 6.27904 $w=2.09e-08 $layer=Gate_1 $thickness=5.24e-08 $X=0.459
+ $Y=0.135 $X2=0.459 $Y2=0.135
r141 41 239 6.6497 $w=2.04211e-08 $l=1.9e-08 $layer=Gate_1 $thickness=5.6e-08
+ $X=0.459 $Y=0.135 $X2=0.459 $Y2=0.116
r142 41 240 6.6497 $w=2.04211e-08 $l=1.9e-08 $layer=Gate_1 $thickness=5.6e-08
+ $X=0.459 $Y=0.135 $X2=0.459 $Y2=0.154
r143 235 234 16.4967 $w=2.1e-08 $l=4.85e-08 $layer=Gate_1 $thickness=5.6e-08
+ $X=0.513 $Y=0.2025 $X2=0.513 $Y2=0.154
r144 232 233 16.4967 $w=2.1e-08 $l=4.85e-08 $layer=Gate_1 $thickness=5.6e-08
+ $X=0.513 $Y=0.0675 $X2=0.513 $Y2=0.116
r145 42 88 6.27904 $w=2.09e-08 $layer=Gate_1 $thickness=5.24e-08 $X=0.513
+ $Y=0.135 $X2=0.513 $Y2=0.135
r146 42 233 6.6497 $w=2.04211e-08 $l=1.9e-08 $layer=Gate_1 $thickness=5.6e-08
+ $X=0.513 $Y=0.135 $X2=0.513 $Y2=0.116
r147 42 234 6.6497 $w=2.04211e-08 $l=1.9e-08 $layer=Gate_1 $thickness=5.6e-08
+ $X=0.513 $Y=0.135 $X2=0.513 $Y2=0.154
r148 229 228 16.4967 $w=2.1e-08 $l=4.85e-08 $layer=Gate_1 $thickness=5.6e-08
+ $X=0.567 $Y=0.2025 $X2=0.567 $Y2=0.154
r149 226 227 16.4967 $w=2.1e-08 $l=4.85e-08 $layer=Gate_1 $thickness=5.6e-08
+ $X=0.567 $Y=0.0675 $X2=0.567 $Y2=0.116
r150 43 84 6.27904 $w=2.09e-08 $layer=Gate_1 $thickness=5.24e-08 $X=0.567
+ $Y=0.135 $X2=0.567 $Y2=0.135
r151 43 227 6.6497 $w=2.04211e-08 $l=1.9e-08 $layer=Gate_1 $thickness=5.6e-08
+ $X=0.567 $Y=0.135 $X2=0.567 $Y2=0.116
r152 43 228 6.6497 $w=2.04211e-08 $l=1.9e-08 $layer=Gate_1 $thickness=5.6e-08
+ $X=0.567 $Y=0.135 $X2=0.567 $Y2=0.154
r153 222 223 6.29612 $w=1.3e-08 $l=2.7e-08 $layer=M1 $thickness=3.6e-08
+ $X=1.512 $Y=0.135 $X2=1.539 $Y2=0.135
r154 221 222 6.29612 $w=1.3e-08 $l=2.7e-08 $layer=M1 $thickness=3.6e-08
+ $X=1.485 $Y=0.135 $X2=1.512 $Y2=0.135
r155 220 221 6.29612 $w=1.3e-08 $l=2.7e-08 $layer=M1 $thickness=3.6e-08
+ $X=1.458 $Y=0.135 $X2=1.485 $Y2=0.135
r156 219 220 6.29612 $w=1.3e-08 $l=2.7e-08 $layer=M1 $thickness=3.6e-08
+ $X=1.431 $Y=0.135 $X2=1.458 $Y2=0.135
r157 218 219 6.29612 $w=1.3e-08 $l=2.7e-08 $layer=M1 $thickness=3.6e-08
+ $X=1.404 $Y=0.135 $X2=1.431 $Y2=0.135
r158 217 218 6.29612 $w=1.3e-08 $l=2.7e-08 $layer=M1 $thickness=3.6e-08
+ $X=1.377 $Y=0.135 $X2=1.404 $Y2=0.135
r159 216 217 6.29612 $w=1.3e-08 $l=2.7e-08 $layer=M1 $thickness=3.6e-08 $X=1.35
+ $Y=0.135 $X2=1.377 $Y2=0.135
r160 215 216 6.29612 $w=1.3e-08 $l=2.7e-08 $layer=M1 $thickness=3.6e-08
+ $X=1.323 $Y=0.135 $X2=1.35 $Y2=0.135
r161 214 215 6.29612 $w=1.3e-08 $l=2.7e-08 $layer=M1 $thickness=3.6e-08
+ $X=1.296 $Y=0.135 $X2=1.323 $Y2=0.135
r162 213 214 6.29612 $w=1.3e-08 $l=2.7e-08 $layer=M1 $thickness=3.6e-08
+ $X=1.269 $Y=0.135 $X2=1.296 $Y2=0.135
r163 212 213 6.29612 $w=1.3e-08 $l=2.7e-08 $layer=M1 $thickness=3.6e-08
+ $X=1.242 $Y=0.135 $X2=1.269 $Y2=0.135
r164 211 212 6.29612 $w=1.3e-08 $l=2.7e-08 $layer=M1 $thickness=3.6e-08
+ $X=1.215 $Y=0.135 $X2=1.242 $Y2=0.135
r165 210 211 6.29612 $w=1.3e-08 $l=2.7e-08 $layer=M1 $thickness=3.6e-08
+ $X=1.188 $Y=0.135 $X2=1.215 $Y2=0.135
r166 209 210 6.29612 $w=1.3e-08 $l=2.7e-08 $layer=M1 $thickness=3.6e-08
+ $X=1.161 $Y=0.135 $X2=1.188 $Y2=0.135
r167 208 209 6.29612 $w=1.3e-08 $l=2.7e-08 $layer=M1 $thickness=3.6e-08
+ $X=1.134 $Y=0.135 $X2=1.161 $Y2=0.135
r168 207 208 6.29612 $w=1.3e-08 $l=2.7e-08 $layer=M1 $thickness=3.6e-08
+ $X=1.107 $Y=0.135 $X2=1.134 $Y2=0.135
r169 206 207 6.29612 $w=1.3e-08 $l=2.7e-08 $layer=M1 $thickness=3.6e-08 $X=1.08
+ $Y=0.135 $X2=1.107 $Y2=0.135
r170 205 206 6.29612 $w=1.3e-08 $l=2.7e-08 $layer=M1 $thickness=3.6e-08
+ $X=1.053 $Y=0.135 $X2=1.08 $Y2=0.135
r171 204 205 6.29612 $w=1.3e-08 $l=2.7e-08 $layer=M1 $thickness=3.6e-08
+ $X=1.026 $Y=0.135 $X2=1.053 $Y2=0.135
r172 203 204 6.29612 $w=1.3e-08 $l=2.7e-08 $layer=M1 $thickness=3.6e-08
+ $X=0.999 $Y=0.135 $X2=1.026 $Y2=0.135
r173 202 203 6.29612 $w=1.3e-08 $l=2.7e-08 $layer=M1 $thickness=3.6e-08
+ $X=0.972 $Y=0.135 $X2=0.999 $Y2=0.135
r174 201 202 6.29612 $w=1.3e-08 $l=2.7e-08 $layer=M1 $thickness=3.6e-08
+ $X=0.945 $Y=0.135 $X2=0.972 $Y2=0.135
r175 200 201 6.29612 $w=1.3e-08 $l=2.7e-08 $layer=M1 $thickness=3.6e-08
+ $X=0.918 $Y=0.135 $X2=0.945 $Y2=0.135
r176 199 200 6.29612 $w=1.3e-08 $l=2.7e-08 $layer=M1 $thickness=3.6e-08
+ $X=0.891 $Y=0.135 $X2=0.918 $Y2=0.135
r177 198 199 6.29612 $w=1.3e-08 $l=2.7e-08 $layer=M1 $thickness=3.6e-08
+ $X=0.864 $Y=0.135 $X2=0.891 $Y2=0.135
r178 197 198 6.29612 $w=1.3e-08 $l=2.7e-08 $layer=M1 $thickness=3.6e-08
+ $X=0.837 $Y=0.135 $X2=0.864 $Y2=0.135
r179 196 197 6.29612 $w=1.3e-08 $l=2.7e-08 $layer=M1 $thickness=3.6e-08 $X=0.81
+ $Y=0.135 $X2=0.837 $Y2=0.135
r180 195 196 6.29612 $w=1.3e-08 $l=2.7e-08 $layer=M1 $thickness=3.6e-08
+ $X=0.783 $Y=0.135 $X2=0.81 $Y2=0.135
r181 194 195 6.29612 $w=1.3e-08 $l=2.7e-08 $layer=M1 $thickness=3.6e-08
+ $X=0.756 $Y=0.135 $X2=0.783 $Y2=0.135
r182 193 194 6.29612 $w=1.3e-08 $l=2.7e-08 $layer=M1 $thickness=3.6e-08
+ $X=0.729 $Y=0.135 $X2=0.756 $Y2=0.135
r183 192 193 6.29612 $w=1.3e-08 $l=2.7e-08 $layer=M1 $thickness=3.6e-08
+ $X=0.702 $Y=0.135 $X2=0.729 $Y2=0.135
r184 191 192 6.29612 $w=1.3e-08 $l=2.7e-08 $layer=M1 $thickness=3.6e-08
+ $X=0.675 $Y=0.135 $X2=0.702 $Y2=0.135
r185 190 191 6.29612 $w=1.3e-08 $l=2.7e-08 $layer=M1 $thickness=3.6e-08
+ $X=0.648 $Y=0.135 $X2=0.675 $Y2=0.135
r186 189 190 6.29612 $w=1.3e-08 $l=2.7e-08 $layer=M1 $thickness=3.6e-08
+ $X=0.621 $Y=0.135 $X2=0.648 $Y2=0.135
r187 188 189 6.29612 $w=1.3e-08 $l=2.7e-08 $layer=M1 $thickness=3.6e-08
+ $X=0.594 $Y=0.135 $X2=0.621 $Y2=0.135
r188 187 188 6.29612 $w=1.3e-08 $l=2.7e-08 $layer=M1 $thickness=3.6e-08
+ $X=0.567 $Y=0.135 $X2=0.594 $Y2=0.135
r189 186 187 6.29612 $w=1.3e-08 $l=2.7e-08 $layer=M1 $thickness=3.6e-08 $X=0.54
+ $Y=0.135 $X2=0.567 $Y2=0.135
r190 185 186 6.29612 $w=1.3e-08 $l=2.7e-08 $layer=M1 $thickness=3.6e-08
+ $X=0.513 $Y=0.135 $X2=0.54 $Y2=0.135
r191 184 185 6.29612 $w=1.3e-08 $l=2.7e-08 $layer=M1 $thickness=3.6e-08
+ $X=0.486 $Y=0.135 $X2=0.513 $Y2=0.135
r192 183 184 6.29612 $w=1.3e-08 $l=2.7e-08 $layer=M1 $thickness=3.6e-08
+ $X=0.459 $Y=0.135 $X2=0.486 $Y2=0.135
r193 182 183 6.29612 $w=1.3e-08 $l=2.7e-08 $layer=M1 $thickness=3.6e-08
+ $X=0.432 $Y=0.135 $X2=0.459 $Y2=0.135
r194 181 182 6.29612 $w=1.3e-08 $l=2.7e-08 $layer=M1 $thickness=3.6e-08
+ $X=0.405 $Y=0.135 $X2=0.432 $Y2=0.135
r195 180 181 6.29612 $w=1.3e-08 $l=2.7e-08 $layer=M1 $thickness=3.6e-08
+ $X=0.378 $Y=0.135 $X2=0.405 $Y2=0.135
r196 179 180 6.29612 $w=1.3e-08 $l=2.7e-08 $layer=M1 $thickness=3.6e-08
+ $X=0.351 $Y=0.135 $X2=0.378 $Y2=0.135
r197 178 179 5.82974 $w=1.3e-08 $l=2.5e-08 $layer=M1 $thickness=3.6e-08
+ $X=0.326 $Y=0.135 $X2=0.351 $Y2=0.135
r198 177 178 4.19742 $w=1.3e-08 $l=1.8e-08 $layer=M1 $thickness=3.6e-08
+ $X=0.308 $Y=0.135 $X2=0.326 $Y2=0.135
r199 176 177 2.56509 $w=1.3e-08 $l=1.1e-08 $layer=M1 $thickness=3.6e-08
+ $X=0.297 $Y=0.135 $X2=0.308 $Y2=0.135
r200 73 176 6.29612 $w=1.3e-08 $l=2.7e-08 $layer=M1 $thickness=3.6e-08 $X=0.27
+ $Y=0.135 $X2=0.297 $Y2=0.135
r201 173 223 19.3796 $a=3.24e-16 $layer=V0LIG $X=1.539 $Y=0.135 $X2=1.539
+ $Y2=0.135
r202 172 173 2.48102 $w=2.2e-08 $l=9.5e-09 $layer=LIG $thickness=4.8e-08
+ $X=1.5295 $Y=0.135 $X2=1.539 $Y2=0.135
r203 171 172 10.1729 $w=1.54914e-08 $l=1.75e-08 $layer=LIG $thickness=4.8e-08
+ $X=1.512 $Y=0.135 $X2=1.5295 $Y2=0.135
r204 170 171 10.1729 $w=1.54914e-08 $l=1.75e-08 $layer=LIG $thickness=4.8e-08
+ $X=1.4945 $Y=0.135 $X2=1.512 $Y2=0.135
r205 169 170 2.48102 $w=2.2e-08 $l=9.5e-09 $layer=LIG $thickness=4.8e-08
+ $X=1.485 $Y=0.135 $X2=1.4945 $Y2=0.135
r206 169 221 19.3796 $a=3.24e-16 $layer=V0LIG $X=1.485 $Y=0.135 $X2=1.485
+ $Y2=0.135
r207 168 169 2.48102 $w=2.2e-08 $l=9.5e-09 $layer=LIG $thickness=4.8e-08
+ $X=1.4755 $Y=0.135 $X2=1.485 $Y2=0.135
r208 167 168 10.1729 $w=1.54914e-08 $l=1.75e-08 $layer=LIG $thickness=4.8e-08
+ $X=1.458 $Y=0.135 $X2=1.4755 $Y2=0.135
r209 166 167 10.1729 $w=1.54914e-08 $l=1.75e-08 $layer=LIG $thickness=4.8e-08
+ $X=1.4405 $Y=0.135 $X2=1.458 $Y2=0.135
r210 165 166 2.48102 $w=2.2e-08 $l=9.5e-09 $layer=LIG $thickness=4.8e-08
+ $X=1.431 $Y=0.135 $X2=1.4405 $Y2=0.135
r211 165 219 19.3796 $a=3.24e-16 $layer=V0LIG $X=1.431 $Y=0.135 $X2=1.431
+ $Y2=0.135
r212 164 165 2.48102 $w=2.2e-08 $l=9.5e-09 $layer=LIG $thickness=4.8e-08
+ $X=1.4215 $Y=0.135 $X2=1.431 $Y2=0.135
r213 163 164 10.1729 $w=1.54914e-08 $l=1.75e-08 $layer=LIG $thickness=4.8e-08
+ $X=1.404 $Y=0.135 $X2=1.4215 $Y2=0.135
r214 162 163 10.1729 $w=1.54914e-08 $l=1.75e-08 $layer=LIG $thickness=4.8e-08
+ $X=1.3865 $Y=0.135 $X2=1.404 $Y2=0.135
r215 161 162 2.48102 $w=2.2e-08 $l=9.5e-09 $layer=LIG $thickness=4.8e-08
+ $X=1.377 $Y=0.135 $X2=1.3865 $Y2=0.135
r216 161 217 19.3796 $a=3.24e-16 $layer=V0LIG $X=1.377 $Y=0.135 $X2=1.377
+ $Y2=0.135
r217 160 161 2.48102 $w=2.2e-08 $l=9.5e-09 $layer=LIG $thickness=4.8e-08
+ $X=1.3675 $Y=0.135 $X2=1.377 $Y2=0.135
r218 159 160 10.1729 $w=1.54914e-08 $l=1.75e-08 $layer=LIG $thickness=4.8e-08
+ $X=1.35 $Y=0.135 $X2=1.3675 $Y2=0.135
r219 158 159 10.1729 $w=1.54914e-08 $l=1.75e-08 $layer=LIG $thickness=4.8e-08
+ $X=1.3325 $Y=0.135 $X2=1.35 $Y2=0.135
r220 157 158 2.48102 $w=2.2e-08 $l=9.5e-09 $layer=LIG $thickness=4.8e-08
+ $X=1.323 $Y=0.135 $X2=1.3325 $Y2=0.135
r221 157 215 19.3796 $a=3.24e-16 $layer=V0LIG $X=1.323 $Y=0.135 $X2=1.323
+ $Y2=0.135
r222 156 157 2.48102 $w=2.2e-08 $l=9.5e-09 $layer=LIG $thickness=4.8e-08
+ $X=1.3135 $Y=0.135 $X2=1.323 $Y2=0.135
r223 155 156 10.1729 $w=1.54914e-08 $l=1.75e-08 $layer=LIG $thickness=4.8e-08
+ $X=1.296 $Y=0.135 $X2=1.3135 $Y2=0.135
r224 154 155 10.1729 $w=1.54914e-08 $l=1.75e-08 $layer=LIG $thickness=4.8e-08
+ $X=1.2785 $Y=0.135 $X2=1.296 $Y2=0.135
r225 153 154 2.48102 $w=2.2e-08 $l=9.5e-09 $layer=LIG $thickness=4.8e-08
+ $X=1.269 $Y=0.135 $X2=1.2785 $Y2=0.135
r226 153 213 19.3796 $a=3.24e-16 $layer=V0LIG $X=1.269 $Y=0.135 $X2=1.269
+ $Y2=0.135
r227 152 153 2.48102 $w=2.2e-08 $l=9.5e-09 $layer=LIG $thickness=4.8e-08
+ $X=1.2595 $Y=0.135 $X2=1.269 $Y2=0.135
r228 151 152 10.1729 $w=1.54914e-08 $l=1.75e-08 $layer=LIG $thickness=4.8e-08
+ $X=1.242 $Y=0.135 $X2=1.2595 $Y2=0.135
r229 150 151 10.1729 $w=1.54914e-08 $l=1.75e-08 $layer=LIG $thickness=4.8e-08
+ $X=1.2245 $Y=0.135 $X2=1.242 $Y2=0.135
r230 149 150 2.48102 $w=2.2e-08 $l=9.5e-09 $layer=LIG $thickness=4.8e-08
+ $X=1.215 $Y=0.135 $X2=1.2245 $Y2=0.135
r231 149 211 19.3796 $a=3.24e-16 $layer=V0LIG $X=1.215 $Y=0.135 $X2=1.215
+ $Y2=0.135
r232 148 149 2.48102 $w=2.2e-08 $l=9.5e-09 $layer=LIG $thickness=4.8e-08
+ $X=1.2055 $Y=0.135 $X2=1.215 $Y2=0.135
r233 147 148 10.1729 $w=1.54914e-08 $l=1.75e-08 $layer=LIG $thickness=4.8e-08
+ $X=1.188 $Y=0.135 $X2=1.2055 $Y2=0.135
r234 146 147 10.1729 $w=1.54914e-08 $l=1.75e-08 $layer=LIG $thickness=4.8e-08
+ $X=1.1705 $Y=0.135 $X2=1.188 $Y2=0.135
r235 145 146 2.48102 $w=2.2e-08 $l=9.5e-09 $layer=LIG $thickness=4.8e-08
+ $X=1.161 $Y=0.135 $X2=1.1705 $Y2=0.135
r236 145 209 19.3796 $a=3.24e-16 $layer=V0LIG $X=1.161 $Y=0.135 $X2=1.161
+ $Y2=0.135
r237 144 145 2.48102 $w=2.2e-08 $l=9.5e-09 $layer=LIG $thickness=4.8e-08
+ $X=1.1515 $Y=0.135 $X2=1.161 $Y2=0.135
r238 143 144 10.1729 $w=1.54914e-08 $l=1.75e-08 $layer=LIG $thickness=4.8e-08
+ $X=1.134 $Y=0.135 $X2=1.1515 $Y2=0.135
r239 142 143 10.1729 $w=1.54914e-08 $l=1.75e-08 $layer=LIG $thickness=4.8e-08
+ $X=1.1165 $Y=0.135 $X2=1.134 $Y2=0.135
r240 141 142 2.48102 $w=2.2e-08 $l=9.5e-09 $layer=LIG $thickness=4.8e-08
+ $X=1.107 $Y=0.135 $X2=1.1165 $Y2=0.135
r241 141 207 19.3796 $a=3.24e-16 $layer=V0LIG $X=1.107 $Y=0.135 $X2=1.107
+ $Y2=0.135
r242 140 141 2.48102 $w=2.2e-08 $l=9.5e-09 $layer=LIG $thickness=4.8e-08
+ $X=1.0975 $Y=0.135 $X2=1.107 $Y2=0.135
r243 139 140 10.1729 $w=1.54914e-08 $l=1.75e-08 $layer=LIG $thickness=4.8e-08
+ $X=1.08 $Y=0.135 $X2=1.0975 $Y2=0.135
r244 138 139 10.1729 $w=1.54914e-08 $l=1.75e-08 $layer=LIG $thickness=4.8e-08
+ $X=1.0625 $Y=0.135 $X2=1.08 $Y2=0.135
r245 137 138 2.48102 $w=2.2e-08 $l=9.5e-09 $layer=LIG $thickness=4.8e-08
+ $X=1.053 $Y=0.135 $X2=1.0625 $Y2=0.135
r246 137 205 19.3796 $a=3.24e-16 $layer=V0LIG $X=1.053 $Y=0.135 $X2=1.053
+ $Y2=0.135
r247 136 137 2.48102 $w=2.2e-08 $l=9.5e-09 $layer=LIG $thickness=4.8e-08
+ $X=1.0435 $Y=0.135 $X2=1.053 $Y2=0.135
r248 135 136 10.1729 $w=1.54914e-08 $l=1.75e-08 $layer=LIG $thickness=4.8e-08
+ $X=1.026 $Y=0.135 $X2=1.0435 $Y2=0.135
r249 134 135 10.1729 $w=1.54914e-08 $l=1.75e-08 $layer=LIG $thickness=4.8e-08
+ $X=1.0085 $Y=0.135 $X2=1.026 $Y2=0.135
r250 133 134 2.48102 $w=2.2e-08 $l=9.5e-09 $layer=LIG $thickness=4.8e-08
+ $X=0.999 $Y=0.135 $X2=1.0085 $Y2=0.135
r251 133 203 19.3796 $a=3.24e-16 $layer=V0LIG $X=0.999 $Y=0.135 $X2=0.999
+ $Y2=0.135
r252 132 133 2.48102 $w=2.2e-08 $l=9.5e-09 $layer=LIG $thickness=4.8e-08
+ $X=0.9895 $Y=0.135 $X2=0.999 $Y2=0.135
r253 131 132 10.1729 $w=1.54914e-08 $l=1.75e-08 $layer=LIG $thickness=4.8e-08
+ $X=0.972 $Y=0.135 $X2=0.9895 $Y2=0.135
r254 130 131 10.1729 $w=1.54914e-08 $l=1.75e-08 $layer=LIG $thickness=4.8e-08
+ $X=0.9545 $Y=0.135 $X2=0.972 $Y2=0.135
r255 129 130 2.48102 $w=2.2e-08 $l=9.5e-09 $layer=LIG $thickness=4.8e-08
+ $X=0.945 $Y=0.135 $X2=0.9545 $Y2=0.135
r256 129 201 19.3796 $a=3.24e-16 $layer=V0LIG $X=0.945 $Y=0.135 $X2=0.945
+ $Y2=0.135
r257 128 129 2.48102 $w=2.2e-08 $l=9.5e-09 $layer=LIG $thickness=4.8e-08
+ $X=0.9355 $Y=0.135 $X2=0.945 $Y2=0.135
r258 127 128 10.1729 $w=1.54914e-08 $l=1.75e-08 $layer=LIG $thickness=4.8e-08
+ $X=0.918 $Y=0.135 $X2=0.9355 $Y2=0.135
r259 126 127 10.1729 $w=1.54914e-08 $l=1.75e-08 $layer=LIG $thickness=4.8e-08
+ $X=0.9005 $Y=0.135 $X2=0.918 $Y2=0.135
r260 125 126 2.48102 $w=2.2e-08 $l=9.5e-09 $layer=LIG $thickness=4.8e-08
+ $X=0.891 $Y=0.135 $X2=0.9005 $Y2=0.135
r261 125 199 19.3796 $a=3.24e-16 $layer=V0LIG $X=0.891 $Y=0.135 $X2=0.891
+ $Y2=0.135
r262 124 125 2.48102 $w=2.2e-08 $l=9.5e-09 $layer=LIG $thickness=4.8e-08
+ $X=0.8815 $Y=0.135 $X2=0.891 $Y2=0.135
r263 123 124 10.1729 $w=1.54914e-08 $l=1.75e-08 $layer=LIG $thickness=4.8e-08
+ $X=0.864 $Y=0.135 $X2=0.8815 $Y2=0.135
r264 122 123 10.1729 $w=1.54914e-08 $l=1.75e-08 $layer=LIG $thickness=4.8e-08
+ $X=0.8465 $Y=0.135 $X2=0.864 $Y2=0.135
r265 121 122 2.48102 $w=2.2e-08 $l=9.5e-09 $layer=LIG $thickness=4.8e-08
+ $X=0.837 $Y=0.135 $X2=0.8465 $Y2=0.135
r266 121 197 19.3796 $a=3.24e-16 $layer=V0LIG $X=0.837 $Y=0.135 $X2=0.837
+ $Y2=0.135
r267 120 121 2.48102 $w=2.2e-08 $l=9.5e-09 $layer=LIG $thickness=4.8e-08
+ $X=0.8275 $Y=0.135 $X2=0.837 $Y2=0.135
r268 119 120 10.1729 $w=1.54914e-08 $l=1.75e-08 $layer=LIG $thickness=4.8e-08
+ $X=0.81 $Y=0.135 $X2=0.8275 $Y2=0.135
r269 118 119 10.1729 $w=1.54914e-08 $l=1.75e-08 $layer=LIG $thickness=4.8e-08
+ $X=0.7925 $Y=0.135 $X2=0.81 $Y2=0.135
r270 117 118 2.48102 $w=2.2e-08 $l=9.5e-09 $layer=LIG $thickness=4.8e-08
+ $X=0.783 $Y=0.135 $X2=0.7925 $Y2=0.135
r271 117 195 19.3796 $a=3.24e-16 $layer=V0LIG $X=0.783 $Y=0.135 $X2=0.783
+ $Y2=0.135
r272 116 117 2.48102 $w=2.2e-08 $l=9.5e-09 $layer=LIG $thickness=4.8e-08
+ $X=0.7735 $Y=0.135 $X2=0.783 $Y2=0.135
r273 115 116 10.1729 $w=1.54914e-08 $l=1.75e-08 $layer=LIG $thickness=4.8e-08
+ $X=0.756 $Y=0.135 $X2=0.7735 $Y2=0.135
r274 114 115 10.1729 $w=1.54914e-08 $l=1.75e-08 $layer=LIG $thickness=4.8e-08
+ $X=0.7385 $Y=0.135 $X2=0.756 $Y2=0.135
r275 113 114 2.48102 $w=2.2e-08 $l=9.5e-09 $layer=LIG $thickness=4.8e-08
+ $X=0.729 $Y=0.135 $X2=0.7385 $Y2=0.135
r276 113 193 19.3796 $a=3.24e-16 $layer=V0LIG $X=0.729 $Y=0.135 $X2=0.729
+ $Y2=0.135
r277 112 113 2.48102 $w=2.2e-08 $l=9.5e-09 $layer=LIG $thickness=4.8e-08
+ $X=0.7195 $Y=0.135 $X2=0.729 $Y2=0.135
r278 111 112 10.1729 $w=1.54914e-08 $l=1.75e-08 $layer=LIG $thickness=4.8e-08
+ $X=0.702 $Y=0.135 $X2=0.7195 $Y2=0.135
r279 110 111 10.1729 $w=1.54914e-08 $l=1.75e-08 $layer=LIG $thickness=4.8e-08
+ $X=0.6845 $Y=0.135 $X2=0.702 $Y2=0.135
r280 109 110 2.48102 $w=2.2e-08 $l=9.5e-09 $layer=LIG $thickness=4.8e-08
+ $X=0.675 $Y=0.135 $X2=0.6845 $Y2=0.135
r281 109 191 19.3796 $a=3.24e-16 $layer=V0LIG $X=0.675 $Y=0.135 $X2=0.675
+ $Y2=0.135
r282 108 109 2.48102 $w=2.2e-08 $l=9.5e-09 $layer=LIG $thickness=4.8e-08
+ $X=0.6655 $Y=0.135 $X2=0.675 $Y2=0.135
r283 107 108 10.1729 $w=1.54914e-08 $l=1.75e-08 $layer=LIG $thickness=4.8e-08
+ $X=0.648 $Y=0.135 $X2=0.6655 $Y2=0.135
r284 104 105 2.48102 $w=2.2e-08 $l=9.5e-09 $layer=LIG $thickness=4.8e-08
+ $X=0.297 $Y=0.135 $X2=0.3065 $Y2=0.135
r285 104 176 19.3796 $a=3.24e-16 $layer=V0LIG $X=0.297 $Y=0.135 $X2=0.297
+ $Y2=0.135
r286 102 105 10.1729 $w=1.54914e-08 $l=1.75e-08 $layer=LIG $thickness=4.8e-08
+ $X=0.324 $Y=0.135 $X2=0.3065 $Y2=0.135
r287 100 101 2.48102 $w=2.2e-08 $l=9.5e-09 $layer=LIG $thickness=4.8e-08
+ $X=0.351 $Y=0.135 $X2=0.3605 $Y2=0.135
r288 100 179 19.3796 $a=3.24e-16 $layer=V0LIG $X=0.351 $Y=0.135 $X2=0.351
+ $Y2=0.135
r289 99 100 2.48102 $w=2.2e-08 $l=9.5e-09 $layer=LIG $thickness=4.8e-08
+ $X=0.3415 $Y=0.135 $X2=0.351 $Y2=0.135
r290 99 102 10.1729 $w=1.54914e-08 $l=1.75e-08 $layer=LIG $thickness=4.8e-08
+ $X=0.3415 $Y=0.135 $X2=0.324 $Y2=0.135
r291 98 101 10.1729 $w=1.54914e-08 $l=1.75e-08 $layer=LIG $thickness=4.8e-08
+ $X=0.378 $Y=0.135 $X2=0.3605 $Y2=0.135
r292 96 97 2.48102 $w=2.2e-08 $l=9.5e-09 $layer=LIG $thickness=4.8e-08 $X=0.405
+ $Y=0.135 $X2=0.4145 $Y2=0.135
r293 96 181 19.3796 $a=3.24e-16 $layer=V0LIG $X=0.405 $Y=0.135 $X2=0.405
+ $Y2=0.135
r294 95 96 2.48102 $w=2.2e-08 $l=9.5e-09 $layer=LIG $thickness=4.8e-08
+ $X=0.3955 $Y=0.135 $X2=0.405 $Y2=0.135
r295 95 98 10.1729 $w=1.54914e-08 $l=1.75e-08 $layer=LIG $thickness=4.8e-08
+ $X=0.3955 $Y=0.135 $X2=0.378 $Y2=0.135
r296 94 97 10.1729 $w=1.54914e-08 $l=1.75e-08 $layer=LIG $thickness=4.8e-08
+ $X=0.432 $Y=0.135 $X2=0.4145 $Y2=0.135
r297 92 93 2.48102 $w=2.2e-08 $l=9.5e-09 $layer=LIG $thickness=4.8e-08 $X=0.459
+ $Y=0.135 $X2=0.4685 $Y2=0.135
r298 92 183 19.3796 $a=3.24e-16 $layer=V0LIG $X=0.459 $Y=0.135 $X2=0.459
+ $Y2=0.135
r299 91 92 2.48102 $w=2.2e-08 $l=9.5e-09 $layer=LIG $thickness=4.8e-08
+ $X=0.4495 $Y=0.135 $X2=0.459 $Y2=0.135
r300 91 94 10.1729 $w=1.54914e-08 $l=1.75e-08 $layer=LIG $thickness=4.8e-08
+ $X=0.4495 $Y=0.135 $X2=0.432 $Y2=0.135
r301 90 93 10.1729 $w=1.54914e-08 $l=1.75e-08 $layer=LIG $thickness=4.8e-08
+ $X=0.486 $Y=0.135 $X2=0.4685 $Y2=0.135
r302 88 89 2.48102 $w=2.2e-08 $l=9.5e-09 $layer=LIG $thickness=4.8e-08 $X=0.513
+ $Y=0.135 $X2=0.5225 $Y2=0.135
r303 88 185 19.3796 $a=3.24e-16 $layer=V0LIG $X=0.513 $Y=0.135 $X2=0.513
+ $Y2=0.135
r304 87 88 2.48102 $w=2.2e-08 $l=9.5e-09 $layer=LIG $thickness=4.8e-08
+ $X=0.5035 $Y=0.135 $X2=0.513 $Y2=0.135
r305 87 90 10.1729 $w=1.54914e-08 $l=1.75e-08 $layer=LIG $thickness=4.8e-08
+ $X=0.5035 $Y=0.135 $X2=0.486 $Y2=0.135
r306 86 89 10.1729 $w=1.54914e-08 $l=1.75e-08 $layer=LIG $thickness=4.8e-08
+ $X=0.54 $Y=0.135 $X2=0.5225 $Y2=0.135
r307 84 85 2.48102 $w=2.2e-08 $l=9.5e-09 $layer=LIG $thickness=4.8e-08 $X=0.567
+ $Y=0.135 $X2=0.5765 $Y2=0.135
r308 84 187 19.3796 $a=3.24e-16 $layer=V0LIG $X=0.567 $Y=0.135 $X2=0.567
+ $Y2=0.135
r309 83 84 2.48102 $w=2.2e-08 $l=9.5e-09 $layer=LIG $thickness=4.8e-08
+ $X=0.5575 $Y=0.135 $X2=0.567 $Y2=0.135
r310 83 86 10.1729 $w=1.54914e-08 $l=1.75e-08 $layer=LIG $thickness=4.8e-08
+ $X=0.5575 $Y=0.135 $X2=0.54 $Y2=0.135
r311 82 85 10.1729 $w=1.54914e-08 $l=1.75e-08 $layer=LIG $thickness=4.8e-08
+ $X=0.594 $Y=0.135 $X2=0.5765 $Y2=0.135
r312 81 107 10.1729 $w=1.54914e-08 $l=1.75e-08 $layer=LIG $thickness=4.8e-08
+ $X=0.6305 $Y=0.135 $X2=0.648 $Y2=0.135
r313 80 81 2.48102 $w=2.2e-08 $l=9.5e-09 $layer=LIG $thickness=4.8e-08 $X=0.621
+ $Y=0.135 $X2=0.6305 $Y2=0.135
r314 80 189 19.3796 $a=3.24e-16 $layer=V0LIG $X=0.621 $Y=0.135 $X2=0.621
+ $Y2=0.135
r315 1 80 2.48102 $w=2.2e-08 $l=9.5e-09 $layer=LIG $thickness=4.8e-08 $X=0.6115
+ $Y=0.135 $X2=0.621 $Y2=0.135
r316 1 82 10.1729 $w=1.54914e-08 $l=1.75e-08 $layer=LIG $thickness=4.8e-08
+ $X=0.6115 $Y=0.135 $X2=0.594 $Y2=0.135
r317 78 77 16.4967 $w=2.1e-08 $l=4.85e-08 $layer=Gate_1 $thickness=5.6e-08
+ $X=0.621 $Y=0.2025 $X2=0.621 $Y2=0.154
r318 76 77 6.6497 $w=2.04211e-08 $l=1.9e-08 $layer=Gate_1 $thickness=5.6e-08
+ $X=0.621 $Y=0.135 $X2=0.621 $Y2=0.154
r319 76 81 4.05918 $w=2.0087e-08 $l=9.5e-09 $layer=Gate_1
+ $thickness=5.56522e-08 $X=0.621 $Y=0.135 $X2=0.6305 $Y2=0.135
r320 76 80 6.27904 $w=2.09e-08 $layer=Gate_1 $thickness=5.24e-08 $X=0.621
+ $Y=0.135 $X2=0.621 $Y2=0.135
r321 75 76 6.6497 $w=2.04211e-08 $l=1.9e-08 $layer=Gate_1 $thickness=5.6e-08
+ $X=0.621 $Y=0.116 $X2=0.621 $Y2=0.135
r322 74 75 16.4967 $w=2.1e-08 $l=4.85e-08 $layer=Gate_1 $thickness=5.6e-08
+ $X=0.621 $Y=0.0675 $X2=0.621 $Y2=0.116
r323 74 44 14.6259 $w=2.1e-08 $l=4.3e-08 $layer=Gate_1 $thickness=5.6e-08
+ $X=0.621 $Y=0.0675 $X2=0.621 $Y2=0.0245
.ends

.subckt PM_BUFx24_ASAP7_75t_R%Y vss 177 104 105 133 134 137 138 141 142 145 146
+ 149 150 153 154 157 158 161 162 165 166 169 170 173 174 206 207 210 211 214
+ 215 218 219 222 223 226 227 230 231 234 235 238 239 242 243 246 247 250 251
+ 84 15 16 17 18 19 20 21 22 23 24 99 100 1 3 5 7 9 11 13 85 73 96 86 87 88 89
+ 90 91 92 93 94 95 74 75 76 77 78 79 80 81 82 83 101 4 6 8 10 12 14 2
c1 1 vss 0.00819959f $X=0.324 $Y=0.0675
c2 2 vss 0.00819458f $X=0.324 $Y=0.2025
c3 3 vss 0.00813832f $X=0.432 $Y=0.0675
c4 4 vss 0.00813832f $X=0.432 $Y=0.2025
c5 5 vss 0.00813832f $X=0.54 $Y=0.0675
c6 6 vss 0.00813832f $X=0.54 $Y=0.2025
c7 7 vss 0.00813832f $X=0.648 $Y=0.0675
c8 8 vss 0.00813832f $X=0.648 $Y=0.2025
c9 9 vss 0.00813832f $X=0.756 $Y=0.0675
c10 10 vss 0.00813832f $X=0.756 $Y=0.2025
c11 11 vss 0.00813832f $X=0.864 $Y=0.0675
c12 12 vss 0.00813832f $X=0.864 $Y=0.2025
c13 13 vss 0.00813832f $X=0.972 $Y=0.0675
c14 14 vss 0.00813832f $X=0.972 $Y=0.2025
c15 15 vss 0.00813832f $X=1.08 $Y=0.0675
c16 16 vss 0.00813832f $X=1.08 $Y=0.2025
c17 17 vss 0.00813832f $X=1.188 $Y=0.0675
c18 18 vss 0.00813832f $X=1.188 $Y=0.2025
c19 19 vss 0.00813832f $X=1.296 $Y=0.0675
c20 20 vss 0.00813832f $X=1.296 $Y=0.2025
c21 21 vss 0.00813832f $X=1.404 $Y=0.0675
c22 22 vss 0.00813832f $X=1.404 $Y=0.2025
c23 23 vss 0.00823527f $X=1.512 $Y=0.0675
c24 24 vss 0.00823527f $X=1.512 $Y=0.2025
c25 73 vss 0.00428605f $X=0.3095 $Y=0.0675
c26 74 vss 0.00407805f $X=0.4175 $Y=0.0675
c27 75 vss 0.00407805f $X=0.5255 $Y=0.0675
c28 76 vss 0.00407805f $X=0.6335 $Y=0.0675
c29 77 vss 0.00407805f $X=0.7415 $Y=0.0675
c30 78 vss 0.00407805f $X=0.8495 $Y=0.0675
c31 79 vss 0.00407805f $X=0.9575 $Y=0.0675
c32 80 vss 0.00407805f $X=1.0655 $Y=0.0675
c33 81 vss 0.00407805f $X=1.1735 $Y=0.0675
c34 82 vss 0.00407805f $X=1.2815 $Y=0.0675
c35 83 vss 0.00407805f $X=1.3895 $Y=0.0675
c36 84 vss 0.00420894f $X=1.4975 $Y=0.0675
c37 85 vss 0.00430367f $X=0.3095 $Y=0.2025
c38 86 vss 0.00407731f $X=0.4175 $Y=0.2025
c39 87 vss 0.00407731f $X=0.5255 $Y=0.2025
c40 88 vss 0.00407731f $X=0.6335 $Y=0.2025
c41 89 vss 0.00407731f $X=0.7415 $Y=0.2025
c42 90 vss 0.00407731f $X=0.8495 $Y=0.2025
c43 91 vss 0.00407731f $X=0.9575 $Y=0.2025
c44 92 vss 0.00407731f $X=1.0655 $Y=0.2025
c45 93 vss 0.00407731f $X=1.1735 $Y=0.2025
c46 94 vss 0.00407731f $X=1.2815 $Y=0.2025
c47 95 vss 0.00407731f $X=1.3895 $Y=0.2025
c48 96 vss 0.00409983f $X=1.4975 $Y=0.2025
c49 97 vss 0.00285334f $X=1.593 $Y=0.036
c50 98 vss 0.00285334f $X=1.593 $Y=0.234
c51 99 vss 0.108786f $X=0.3125 $Y=0.036
c52 100 vss 0.108786f $X=1.5685 $Y=0.234
c53 101 vss 0.00781256f $X=1.593 $Y=0.0855
r1 251 249 0.0308642 $w=8.1e-08 $l=2.5e-09 $layer=P_src_drn $thickness=1e-09
+ $X=1.5293 $Y=0.2025 $X2=1.5265 $Y2=0.2025
r2 24 249 0.179012 $w=8.1e-08 $l=1.45e-08 $layer=P_src_drn $thickness=1e-09
+ $X=1.512 $Y=0.2025 $X2=1.5265 $Y2=0.2025
r3 96 24 0.179012 $w=8.1e-08 $l=1.45e-08 $layer=P_src_drn $thickness=1e-09
+ $X=1.4975 $Y=0.2025 $X2=1.512 $Y2=0.2025
r4 250 96 0.0308642 $w=8.1e-08 $l=2.5e-09 $layer=P_src_drn $thickness=1e-09
+ $X=1.4946 $Y=0.2025 $X2=1.4975 $Y2=0.2025
r5 247 245 0.0308642 $w=8.1e-08 $l=2.5e-09 $layer=P_src_drn $thickness=1e-09
+ $X=1.4213 $Y=0.2025 $X2=1.4185 $Y2=0.2025
r6 22 245 0.179012 $w=8.1e-08 $l=1.45e-08 $layer=P_src_drn $thickness=1e-09
+ $X=1.404 $Y=0.2025 $X2=1.4185 $Y2=0.2025
r7 95 22 0.179012 $w=8.1e-08 $l=1.45e-08 $layer=P_src_drn $thickness=1e-09
+ $X=1.3895 $Y=0.2025 $X2=1.404 $Y2=0.2025
r8 246 95 0.0308642 $w=8.1e-08 $l=2.5e-09 $layer=P_src_drn $thickness=1e-09
+ $X=1.3866 $Y=0.2025 $X2=1.3895 $Y2=0.2025
r9 243 241 0.0308642 $w=8.1e-08 $l=2.5e-09 $layer=P_src_drn $thickness=1e-09
+ $X=1.3133 $Y=0.2025 $X2=1.3105 $Y2=0.2025
r10 20 241 0.179012 $w=8.1e-08 $l=1.45e-08 $layer=P_src_drn $thickness=1e-09
+ $X=1.296 $Y=0.2025 $X2=1.3105 $Y2=0.2025
r11 94 20 0.179012 $w=8.1e-08 $l=1.45e-08 $layer=P_src_drn $thickness=1e-09
+ $X=1.2815 $Y=0.2025 $X2=1.296 $Y2=0.2025
r12 242 94 0.0308642 $w=8.1e-08 $l=2.5e-09 $layer=P_src_drn $thickness=1e-09
+ $X=1.2786 $Y=0.2025 $X2=1.2815 $Y2=0.2025
r13 239 237 0.0308642 $w=8.1e-08 $l=2.5e-09 $layer=P_src_drn $thickness=1e-09
+ $X=1.2053 $Y=0.2025 $X2=1.2025 $Y2=0.2025
r14 18 237 0.179012 $w=8.1e-08 $l=1.45e-08 $layer=P_src_drn $thickness=1e-09
+ $X=1.188 $Y=0.2025 $X2=1.2025 $Y2=0.2025
r15 93 18 0.179012 $w=8.1e-08 $l=1.45e-08 $layer=P_src_drn $thickness=1e-09
+ $X=1.1735 $Y=0.2025 $X2=1.188 $Y2=0.2025
r16 238 93 0.0308642 $w=8.1e-08 $l=2.5e-09 $layer=P_src_drn $thickness=1e-09
+ $X=1.1706 $Y=0.2025 $X2=1.1735 $Y2=0.2025
r17 235 233 0.0308642 $w=8.1e-08 $l=2.5e-09 $layer=P_src_drn $thickness=1e-09
+ $X=1.0973 $Y=0.2025 $X2=1.0945 $Y2=0.2025
r18 16 233 0.179012 $w=8.1e-08 $l=1.45e-08 $layer=P_src_drn $thickness=1e-09
+ $X=1.08 $Y=0.2025 $X2=1.0945 $Y2=0.2025
r19 92 16 0.179012 $w=8.1e-08 $l=1.45e-08 $layer=P_src_drn $thickness=1e-09
+ $X=1.0655 $Y=0.2025 $X2=1.08 $Y2=0.2025
r20 234 92 0.0308642 $w=8.1e-08 $l=2.5e-09 $layer=P_src_drn $thickness=1e-09
+ $X=1.0626 $Y=0.2025 $X2=1.0655 $Y2=0.2025
r21 231 229 0.0308642 $w=8.1e-08 $l=2.5e-09 $layer=P_src_drn $thickness=1e-09
+ $X=0.9893 $Y=0.2025 $X2=0.9865 $Y2=0.2025
r22 14 229 0.179012 $w=8.1e-08 $l=1.45e-08 $layer=P_src_drn $thickness=1e-09
+ $X=0.972 $Y=0.2025 $X2=0.9865 $Y2=0.2025
r23 91 14 0.179012 $w=8.1e-08 $l=1.45e-08 $layer=P_src_drn $thickness=1e-09
+ $X=0.9575 $Y=0.2025 $X2=0.972 $Y2=0.2025
r24 230 91 0.0308642 $w=8.1e-08 $l=2.5e-09 $layer=P_src_drn $thickness=1e-09
+ $X=0.9546 $Y=0.2025 $X2=0.9575 $Y2=0.2025
r25 227 225 0.0308642 $w=8.1e-08 $l=2.5e-09 $layer=P_src_drn $thickness=1e-09
+ $X=0.8813 $Y=0.2025 $X2=0.8785 $Y2=0.2025
r26 12 225 0.179012 $w=8.1e-08 $l=1.45e-08 $layer=P_src_drn $thickness=1e-09
+ $X=0.864 $Y=0.2025 $X2=0.8785 $Y2=0.2025
r27 90 12 0.179012 $w=8.1e-08 $l=1.45e-08 $layer=P_src_drn $thickness=1e-09
+ $X=0.8495 $Y=0.2025 $X2=0.864 $Y2=0.2025
r28 226 90 0.0308642 $w=8.1e-08 $l=2.5e-09 $layer=P_src_drn $thickness=1e-09
+ $X=0.8466 $Y=0.2025 $X2=0.8495 $Y2=0.2025
r29 223 221 0.0308642 $w=8.1e-08 $l=2.5e-09 $layer=P_src_drn $thickness=1e-09
+ $X=0.7733 $Y=0.2025 $X2=0.7705 $Y2=0.2025
r30 10 221 0.179012 $w=8.1e-08 $l=1.45e-08 $layer=P_src_drn $thickness=1e-09
+ $X=0.756 $Y=0.2025 $X2=0.7705 $Y2=0.2025
r31 89 10 0.179012 $w=8.1e-08 $l=1.45e-08 $layer=P_src_drn $thickness=1e-09
+ $X=0.7415 $Y=0.2025 $X2=0.756 $Y2=0.2025
r32 222 89 0.0308642 $w=8.1e-08 $l=2.5e-09 $layer=P_src_drn $thickness=1e-09
+ $X=0.7386 $Y=0.2025 $X2=0.7415 $Y2=0.2025
r33 219 217 0.0308642 $w=8.1e-08 $l=2.5e-09 $layer=P_src_drn $thickness=1e-09
+ $X=0.6653 $Y=0.2025 $X2=0.6625 $Y2=0.2025
r34 8 217 0.179012 $w=8.1e-08 $l=1.45e-08 $layer=P_src_drn $thickness=1e-09
+ $X=0.648 $Y=0.2025 $X2=0.6625 $Y2=0.2025
r35 88 8 0.179012 $w=8.1e-08 $l=1.45e-08 $layer=P_src_drn $thickness=1e-09
+ $X=0.6335 $Y=0.2025 $X2=0.648 $Y2=0.2025
r36 218 88 0.0308642 $w=8.1e-08 $l=2.5e-09 $layer=P_src_drn $thickness=1e-09
+ $X=0.6306 $Y=0.2025 $X2=0.6335 $Y2=0.2025
r37 215 213 0.0308642 $w=8.1e-08 $l=2.5e-09 $layer=P_src_drn $thickness=1e-09
+ $X=0.5573 $Y=0.2025 $X2=0.5545 $Y2=0.2025
r38 6 213 0.179012 $w=8.1e-08 $l=1.45e-08 $layer=P_src_drn $thickness=1e-09
+ $X=0.54 $Y=0.2025 $X2=0.5545 $Y2=0.2025
r39 87 6 0.179012 $w=8.1e-08 $l=1.45e-08 $layer=P_src_drn $thickness=1e-09
+ $X=0.5255 $Y=0.2025 $X2=0.54 $Y2=0.2025
r40 214 87 0.0308642 $w=8.1e-08 $l=2.5e-09 $layer=P_src_drn $thickness=1e-09
+ $X=0.5226 $Y=0.2025 $X2=0.5255 $Y2=0.2025
r41 211 209 0.0308642 $w=8.1e-08 $l=2.5e-09 $layer=P_src_drn $thickness=1e-09
+ $X=0.4493 $Y=0.2025 $X2=0.4465 $Y2=0.2025
r42 4 209 0.179012 $w=8.1e-08 $l=1.45e-08 $layer=P_src_drn $thickness=1e-09
+ $X=0.432 $Y=0.2025 $X2=0.4465 $Y2=0.2025
r43 86 4 0.179012 $w=8.1e-08 $l=1.45e-08 $layer=P_src_drn $thickness=1e-09
+ $X=0.4175 $Y=0.2025 $X2=0.432 $Y2=0.2025
r44 210 86 0.0308642 $w=8.1e-08 $l=2.5e-09 $layer=P_src_drn $thickness=1e-09
+ $X=0.4146 $Y=0.2025 $X2=0.4175 $Y2=0.2025
r45 207 205 0.0308642 $w=8.1e-08 $l=2.5e-09 $layer=P_src_drn $thickness=1e-09
+ $X=0.3413 $Y=0.2025 $X2=0.3385 $Y2=0.2025
r46 2 205 0.179012 $w=8.1e-08 $l=1.45e-08 $layer=P_src_drn $thickness=1e-09
+ $X=0.324 $Y=0.2025 $X2=0.3385 $Y2=0.2025
r47 85 2 0.179012 $w=8.1e-08 $l=1.45e-08 $layer=P_src_drn $thickness=1e-09
+ $X=0.3095 $Y=0.2025 $X2=0.324 $Y2=0.2025
r48 206 85 0.0308642 $w=8.1e-08 $l=2.5e-09 $layer=P_src_drn $thickness=1e-09
+ $X=0.3066 $Y=0.2025 $X2=0.3095 $Y2=0.2025
r49 24 202 19.3796 $a=3.24e-16 $layer=V0LISD $X=1.512 $Y=0.2025 $X2=1.512
+ $Y2=0.234
r50 22 200 19.3796 $a=3.24e-16 $layer=V0LISD $X=1.404 $Y=0.2025 $X2=1.404
+ $Y2=0.234
r51 20 198 19.3796 $a=3.24e-16 $layer=V0LISD $X=1.296 $Y=0.2025 $X2=1.296
+ $Y2=0.234
r52 18 196 19.3796 $a=3.24e-16 $layer=V0LISD $X=1.188 $Y=0.2025 $X2=1.188
+ $Y2=0.234
r53 16 194 19.3796 $a=3.24e-16 $layer=V0LISD $X=1.08 $Y=0.2025 $X2=1.08
+ $Y2=0.234
r54 14 192 19.3796 $a=3.24e-16 $layer=V0LISD $X=0.972 $Y=0.2025 $X2=0.972
+ $Y2=0.234
r55 12 190 19.3796 $a=3.24e-16 $layer=V0LISD $X=0.864 $Y=0.2025 $X2=0.864
+ $Y2=0.234
r56 10 188 19.3796 $a=3.24e-16 $layer=V0LISD $X=0.756 $Y=0.2025 $X2=0.756
+ $Y2=0.234
r57 8 186 19.3796 $a=3.24e-16 $layer=V0LISD $X=0.648 $Y=0.2025 $X2=0.648
+ $Y2=0.234
r58 6 184 19.3796 $a=3.24e-16 $layer=V0LISD $X=0.54 $Y=0.2025 $X2=0.54 $Y2=0.234
r59 4 182 19.3796 $a=3.24e-16 $layer=V0LISD $X=0.432 $Y=0.2025 $X2=0.432
+ $Y2=0.234
r60 2 180 19.3796 $a=3.24e-16 $layer=V0LISD $X=0.324 $Y=0.2025 $X2=0.324
+ $Y2=0.234
r61 202 203 5.82974 $w=1.3e-08 $l=2.5e-08 $layer=M1 $thickness=3.6e-08 $X=1.512
+ $Y=0.234 $X2=1.537 $Y2=0.234
r62 201 202 12.5922 $w=1.3e-08 $l=5.4e-08 $layer=M1 $thickness=3.6e-08 $X=1.458
+ $Y=0.234 $X2=1.512 $Y2=0.234
r63 200 201 12.5922 $w=1.3e-08 $l=5.4e-08 $layer=M1 $thickness=3.6e-08 $X=1.404
+ $Y=0.234 $X2=1.458 $Y2=0.234
r64 199 200 12.5922 $w=1.3e-08 $l=5.4e-08 $layer=M1 $thickness=3.6e-08 $X=1.35
+ $Y=0.234 $X2=1.404 $Y2=0.234
r65 198 199 12.5922 $w=1.3e-08 $l=5.4e-08 $layer=M1 $thickness=3.6e-08 $X=1.296
+ $Y=0.234 $X2=1.35 $Y2=0.234
r66 197 198 12.5922 $w=1.3e-08 $l=5.4e-08 $layer=M1 $thickness=3.6e-08 $X=1.242
+ $Y=0.234 $X2=1.296 $Y2=0.234
r67 196 197 12.5922 $w=1.3e-08 $l=5.4e-08 $layer=M1 $thickness=3.6e-08 $X=1.188
+ $Y=0.234 $X2=1.242 $Y2=0.234
r68 195 196 12.5922 $w=1.3e-08 $l=5.4e-08 $layer=M1 $thickness=3.6e-08 $X=1.134
+ $Y=0.234 $X2=1.188 $Y2=0.234
r69 194 195 12.5922 $w=1.3e-08 $l=5.4e-08 $layer=M1 $thickness=3.6e-08 $X=1.08
+ $Y=0.234 $X2=1.134 $Y2=0.234
r70 193 194 12.5922 $w=1.3e-08 $l=5.4e-08 $layer=M1 $thickness=3.6e-08 $X=1.026
+ $Y=0.234 $X2=1.08 $Y2=0.234
r71 192 193 12.5922 $w=1.3e-08 $l=5.4e-08 $layer=M1 $thickness=3.6e-08 $X=0.972
+ $Y=0.234 $X2=1.026 $Y2=0.234
r72 191 192 12.5922 $w=1.3e-08 $l=5.4e-08 $layer=M1 $thickness=3.6e-08 $X=0.918
+ $Y=0.234 $X2=0.972 $Y2=0.234
r73 190 191 12.5922 $w=1.3e-08 $l=5.4e-08 $layer=M1 $thickness=3.6e-08 $X=0.864
+ $Y=0.234 $X2=0.918 $Y2=0.234
r74 189 190 12.5922 $w=1.3e-08 $l=5.4e-08 $layer=M1 $thickness=3.6e-08 $X=0.81
+ $Y=0.234 $X2=0.864 $Y2=0.234
r75 188 189 12.5922 $w=1.3e-08 $l=5.4e-08 $layer=M1 $thickness=3.6e-08 $X=0.756
+ $Y=0.234 $X2=0.81 $Y2=0.234
r76 187 188 12.5922 $w=1.3e-08 $l=5.4e-08 $layer=M1 $thickness=3.6e-08 $X=0.702
+ $Y=0.234 $X2=0.756 $Y2=0.234
r77 186 187 12.5922 $w=1.3e-08 $l=5.4e-08 $layer=M1 $thickness=3.6e-08 $X=0.648
+ $Y=0.234 $X2=0.702 $Y2=0.234
r78 185 186 12.5922 $w=1.3e-08 $l=5.4e-08 $layer=M1 $thickness=3.6e-08 $X=0.594
+ $Y=0.234 $X2=0.648 $Y2=0.234
r79 184 185 12.5922 $w=1.3e-08 $l=5.4e-08 $layer=M1 $thickness=3.6e-08 $X=0.54
+ $Y=0.234 $X2=0.594 $Y2=0.234
r80 183 184 12.5922 $w=1.3e-08 $l=5.4e-08 $layer=M1 $thickness=3.6e-08 $X=0.486
+ $Y=0.234 $X2=0.54 $Y2=0.234
r81 182 183 12.5922 $w=1.3e-08 $l=5.4e-08 $layer=M1 $thickness=3.6e-08 $X=0.432
+ $Y=0.234 $X2=0.486 $Y2=0.234
r82 181 182 12.5922 $w=1.3e-08 $l=5.4e-08 $layer=M1 $thickness=3.6e-08 $X=0.378
+ $Y=0.234 $X2=0.432 $Y2=0.234
r83 180 181 12.5922 $w=1.3e-08 $l=5.4e-08 $layer=M1 $thickness=3.6e-08 $X=0.324
+ $Y=0.234 $X2=0.378 $Y2=0.234
r84 100 203 7.34548 $w=1.3e-08 $l=3.15e-08 $layer=M1 $thickness=3.6e-08
+ $X=1.5685 $Y=0.234 $X2=1.537 $Y2=0.234
r85 98 178 9.19421 $w=1.48968e-08 $l=4.65e-08 $layer=M1 $thickness=3.6e-08
+ $X=1.593 $Y=0.234 $X2=1.593 $Y2=0.1875
r86 98 100 4.06404 $w=1.48367e-08 $l=2.45e-08 $layer=M1 $thickness=3.6e-08
+ $X=1.593 $Y=0.234 $X2=1.5685 $Y2=0.234
r87 177 178 8.86121 $w=1.3e-08 $l=3.8e-08 $layer=M1 $thickness=3.6e-08 $X=1.595
+ $Y=0.1495 $X2=1.593 $Y2=0.1875
r88 177 176 0.699569 $w=1.3e-08 $l=3e-09 $layer=M1 $thickness=3.6e-08 $X=1.595
+ $Y=0.1495 $X2=1.593 $Y2=0.1465
r89 175 176 2.68168 $w=1.3e-08 $l=1.15e-08 $layer=M1 $thickness=3.6e-08
+ $X=1.593 $Y=0.135 $X2=1.593 $Y2=0.1465
r90 101 175 11.5429 $w=1.3e-08 $l=4.95e-08 $layer=M1 $thickness=3.6e-08
+ $X=1.593 $Y=0.0855 $X2=1.593 $Y2=0.135
r91 174 172 0.0308642 $w=8.1e-08 $l=2.5e-09 $layer=N_src_drn $thickness=1e-09
+ $X=1.5293 $Y=0.0675 $X2=1.5265 $Y2=0.0675
r92 23 172 0.179012 $w=8.1e-08 $l=1.45e-08 $layer=N_src_drn $thickness=1e-09
+ $X=1.512 $Y=0.0675 $X2=1.5265 $Y2=0.0675
r93 84 23 0.179012 $w=8.1e-08 $l=1.45e-08 $layer=N_src_drn $thickness=1e-09
+ $X=1.4975 $Y=0.0675 $X2=1.512 $Y2=0.0675
r94 173 84 0.0308642 $w=8.1e-08 $l=2.5e-09 $layer=N_src_drn $thickness=1e-09
+ $X=1.4946 $Y=0.0675 $X2=1.4975 $Y2=0.0675
r95 170 168 0.0308642 $w=8.1e-08 $l=2.5e-09 $layer=N_src_drn $thickness=1e-09
+ $X=1.4213 $Y=0.0675 $X2=1.4185 $Y2=0.0675
r96 21 168 0.179012 $w=8.1e-08 $l=1.45e-08 $layer=N_src_drn $thickness=1e-09
+ $X=1.404 $Y=0.0675 $X2=1.4185 $Y2=0.0675
r97 83 21 0.179012 $w=8.1e-08 $l=1.45e-08 $layer=N_src_drn $thickness=1e-09
+ $X=1.3895 $Y=0.0675 $X2=1.404 $Y2=0.0675
r98 169 83 0.0308642 $w=8.1e-08 $l=2.5e-09 $layer=N_src_drn $thickness=1e-09
+ $X=1.3866 $Y=0.0675 $X2=1.3895 $Y2=0.0675
r99 166 164 0.0308642 $w=8.1e-08 $l=2.5e-09 $layer=N_src_drn $thickness=1e-09
+ $X=1.3133 $Y=0.0675 $X2=1.3105 $Y2=0.0675
r100 19 164 0.179012 $w=8.1e-08 $l=1.45e-08 $layer=N_src_drn $thickness=1e-09
+ $X=1.296 $Y=0.0675 $X2=1.3105 $Y2=0.0675
r101 82 19 0.179012 $w=8.1e-08 $l=1.45e-08 $layer=N_src_drn $thickness=1e-09
+ $X=1.2815 $Y=0.0675 $X2=1.296 $Y2=0.0675
r102 165 82 0.0308642 $w=8.1e-08 $l=2.5e-09 $layer=N_src_drn $thickness=1e-09
+ $X=1.2786 $Y=0.0675 $X2=1.2815 $Y2=0.0675
r103 162 160 0.0308642 $w=8.1e-08 $l=2.5e-09 $layer=N_src_drn $thickness=1e-09
+ $X=1.2053 $Y=0.0675 $X2=1.2025 $Y2=0.0675
r104 17 160 0.179012 $w=8.1e-08 $l=1.45e-08 $layer=N_src_drn $thickness=1e-09
+ $X=1.188 $Y=0.0675 $X2=1.2025 $Y2=0.0675
r105 81 17 0.179012 $w=8.1e-08 $l=1.45e-08 $layer=N_src_drn $thickness=1e-09
+ $X=1.1735 $Y=0.0675 $X2=1.188 $Y2=0.0675
r106 161 81 0.0308642 $w=8.1e-08 $l=2.5e-09 $layer=N_src_drn $thickness=1e-09
+ $X=1.1706 $Y=0.0675 $X2=1.1735 $Y2=0.0675
r107 158 156 0.0308642 $w=8.1e-08 $l=2.5e-09 $layer=N_src_drn $thickness=1e-09
+ $X=1.0973 $Y=0.0675 $X2=1.0945 $Y2=0.0675
r108 15 156 0.179012 $w=8.1e-08 $l=1.45e-08 $layer=N_src_drn $thickness=1e-09
+ $X=1.08 $Y=0.0675 $X2=1.0945 $Y2=0.0675
r109 80 15 0.179012 $w=8.1e-08 $l=1.45e-08 $layer=N_src_drn $thickness=1e-09
+ $X=1.0655 $Y=0.0675 $X2=1.08 $Y2=0.0675
r110 157 80 0.0308642 $w=8.1e-08 $l=2.5e-09 $layer=N_src_drn $thickness=1e-09
+ $X=1.0626 $Y=0.0675 $X2=1.0655 $Y2=0.0675
r111 154 152 0.0308642 $w=8.1e-08 $l=2.5e-09 $layer=N_src_drn $thickness=1e-09
+ $X=0.9893 $Y=0.0675 $X2=0.9865 $Y2=0.0675
r112 13 152 0.179012 $w=8.1e-08 $l=1.45e-08 $layer=N_src_drn $thickness=1e-09
+ $X=0.972 $Y=0.0675 $X2=0.9865 $Y2=0.0675
r113 79 13 0.179012 $w=8.1e-08 $l=1.45e-08 $layer=N_src_drn $thickness=1e-09
+ $X=0.9575 $Y=0.0675 $X2=0.972 $Y2=0.0675
r114 153 79 0.0308642 $w=8.1e-08 $l=2.5e-09 $layer=N_src_drn $thickness=1e-09
+ $X=0.9546 $Y=0.0675 $X2=0.9575 $Y2=0.0675
r115 150 148 0.0308642 $w=8.1e-08 $l=2.5e-09 $layer=N_src_drn $thickness=1e-09
+ $X=0.8813 $Y=0.0675 $X2=0.8785 $Y2=0.0675
r116 11 148 0.179012 $w=8.1e-08 $l=1.45e-08 $layer=N_src_drn $thickness=1e-09
+ $X=0.864 $Y=0.0675 $X2=0.8785 $Y2=0.0675
r117 78 11 0.179012 $w=8.1e-08 $l=1.45e-08 $layer=N_src_drn $thickness=1e-09
+ $X=0.8495 $Y=0.0675 $X2=0.864 $Y2=0.0675
r118 149 78 0.0308642 $w=8.1e-08 $l=2.5e-09 $layer=N_src_drn $thickness=1e-09
+ $X=0.8466 $Y=0.0675 $X2=0.8495 $Y2=0.0675
r119 146 144 0.0308642 $w=8.1e-08 $l=2.5e-09 $layer=N_src_drn $thickness=1e-09
+ $X=0.7733 $Y=0.0675 $X2=0.7705 $Y2=0.0675
r120 9 144 0.179012 $w=8.1e-08 $l=1.45e-08 $layer=N_src_drn $thickness=1e-09
+ $X=0.756 $Y=0.0675 $X2=0.7705 $Y2=0.0675
r121 77 9 0.179012 $w=8.1e-08 $l=1.45e-08 $layer=N_src_drn $thickness=1e-09
+ $X=0.7415 $Y=0.0675 $X2=0.756 $Y2=0.0675
r122 145 77 0.0308642 $w=8.1e-08 $l=2.5e-09 $layer=N_src_drn $thickness=1e-09
+ $X=0.7386 $Y=0.0675 $X2=0.7415 $Y2=0.0675
r123 142 140 0.0308642 $w=8.1e-08 $l=2.5e-09 $layer=N_src_drn $thickness=1e-09
+ $X=0.5573 $Y=0.0675 $X2=0.5545 $Y2=0.0675
r124 5 140 0.179012 $w=8.1e-08 $l=1.45e-08 $layer=N_src_drn $thickness=1e-09
+ $X=0.54 $Y=0.0675 $X2=0.5545 $Y2=0.0675
r125 75 5 0.179012 $w=8.1e-08 $l=1.45e-08 $layer=N_src_drn $thickness=1e-09
+ $X=0.5255 $Y=0.0675 $X2=0.54 $Y2=0.0675
r126 141 75 0.0308642 $w=8.1e-08 $l=2.5e-09 $layer=N_src_drn $thickness=1e-09
+ $X=0.5226 $Y=0.0675 $X2=0.5255 $Y2=0.0675
r127 138 136 0.0308642 $w=8.1e-08 $l=2.5e-09 $layer=N_src_drn $thickness=1e-09
+ $X=0.4493 $Y=0.0675 $X2=0.4465 $Y2=0.0675
r128 3 136 0.179012 $w=8.1e-08 $l=1.45e-08 $layer=N_src_drn $thickness=1e-09
+ $X=0.432 $Y=0.0675 $X2=0.4465 $Y2=0.0675
r129 74 3 0.179012 $w=8.1e-08 $l=1.45e-08 $layer=N_src_drn $thickness=1e-09
+ $X=0.4175 $Y=0.0675 $X2=0.432 $Y2=0.0675
r130 137 74 0.0308642 $w=8.1e-08 $l=2.5e-09 $layer=N_src_drn $thickness=1e-09
+ $X=0.4146 $Y=0.0675 $X2=0.4175 $Y2=0.0675
r131 134 132 0.0308642 $w=8.1e-08 $l=2.5e-09 $layer=N_src_drn $thickness=1e-09
+ $X=0.3413 $Y=0.0675 $X2=0.3385 $Y2=0.0675
r132 1 132 0.179012 $w=8.1e-08 $l=1.45e-08 $layer=N_src_drn $thickness=1e-09
+ $X=0.324 $Y=0.0675 $X2=0.3385 $Y2=0.0675
r133 73 1 0.179012 $w=8.1e-08 $l=1.45e-08 $layer=N_src_drn $thickness=1e-09
+ $X=0.3095 $Y=0.0675 $X2=0.324 $Y2=0.0675
r134 133 73 0.0308642 $w=8.1e-08 $l=2.5e-09 $layer=N_src_drn $thickness=1e-09
+ $X=0.3066 $Y=0.0675 $X2=0.3095 $Y2=0.0675
r135 97 130 4.06404 $w=1.48367e-08 $l=2.45e-08 $layer=M1 $thickness=3.6e-08
+ $X=1.593 $Y=0.036 $X2=1.5685 $Y2=0.036
r136 97 101 9.89378 $w=1.47818e-08 $l=4.95e-08 $layer=M1 $thickness=3.6e-08
+ $X=1.593 $Y=0.036 $X2=1.593 $Y2=0.0855
r137 23 128 19.3796 $a=3.24e-16 $layer=V0LISD $X=1.512 $Y=0.0675 $X2=1.512
+ $Y2=0.036
r138 21 126 19.3796 $a=3.24e-16 $layer=V0LISD $X=1.404 $Y=0.0675 $X2=1.404
+ $Y2=0.036
r139 19 124 19.3796 $a=3.24e-16 $layer=V0LISD $X=1.296 $Y=0.0675 $X2=1.296
+ $Y2=0.036
r140 17 122 19.3796 $a=3.24e-16 $layer=V0LISD $X=1.188 $Y=0.0675 $X2=1.188
+ $Y2=0.036
r141 15 120 19.3796 $a=3.24e-16 $layer=V0LISD $X=1.08 $Y=0.0675 $X2=1.08
+ $Y2=0.036
r142 13 118 19.3796 $a=3.24e-16 $layer=V0LISD $X=0.972 $Y=0.0675 $X2=0.972
+ $Y2=0.036
r143 11 116 19.3796 $a=3.24e-16 $layer=V0LISD $X=0.864 $Y=0.0675 $X2=0.864
+ $Y2=0.036
r144 9 114 19.3796 $a=3.24e-16 $layer=V0LISD $X=0.756 $Y=0.0675 $X2=0.756
+ $Y2=0.036
r145 5 110 19.3796 $a=3.24e-16 $layer=V0LISD $X=0.54 $Y=0.0675 $X2=0.54
+ $Y2=0.036
r146 3 108 19.3796 $a=3.24e-16 $layer=V0LISD $X=0.432 $Y=0.0675 $X2=0.432
+ $Y2=0.036
r147 1 106 19.3796 $a=3.24e-16 $layer=V0LISD $X=0.324 $Y=0.0675 $X2=0.324
+ $Y2=0.036
r148 129 130 7.34548 $w=1.3e-08 $l=3.15e-08 $layer=M1 $thickness=3.6e-08
+ $X=1.537 $Y=0.036 $X2=1.5685 $Y2=0.036
r149 128 129 5.82974 $w=1.3e-08 $l=2.5e-08 $layer=M1 $thickness=3.6e-08
+ $X=1.512 $Y=0.036 $X2=1.537 $Y2=0.036
r150 127 128 12.5922 $w=1.3e-08 $l=5.4e-08 $layer=M1 $thickness=3.6e-08
+ $X=1.458 $Y=0.036 $X2=1.512 $Y2=0.036
r151 126 127 12.5922 $w=1.3e-08 $l=5.4e-08 $layer=M1 $thickness=3.6e-08
+ $X=1.404 $Y=0.036 $X2=1.458 $Y2=0.036
r152 125 126 12.5922 $w=1.3e-08 $l=5.4e-08 $layer=M1 $thickness=3.6e-08 $X=1.35
+ $Y=0.036 $X2=1.404 $Y2=0.036
r153 124 125 12.5922 $w=1.3e-08 $l=5.4e-08 $layer=M1 $thickness=3.6e-08
+ $X=1.296 $Y=0.036 $X2=1.35 $Y2=0.036
r154 123 124 12.5922 $w=1.3e-08 $l=5.4e-08 $layer=M1 $thickness=3.6e-08
+ $X=1.242 $Y=0.036 $X2=1.296 $Y2=0.036
r155 122 123 12.5922 $w=1.3e-08 $l=5.4e-08 $layer=M1 $thickness=3.6e-08
+ $X=1.188 $Y=0.036 $X2=1.242 $Y2=0.036
r156 121 122 12.5922 $w=1.3e-08 $l=5.4e-08 $layer=M1 $thickness=3.6e-08
+ $X=1.134 $Y=0.036 $X2=1.188 $Y2=0.036
r157 120 121 12.5922 $w=1.3e-08 $l=5.4e-08 $layer=M1 $thickness=3.6e-08 $X=1.08
+ $Y=0.036 $X2=1.134 $Y2=0.036
r158 119 120 12.5922 $w=1.3e-08 $l=5.4e-08 $layer=M1 $thickness=3.6e-08
+ $X=1.026 $Y=0.036 $X2=1.08 $Y2=0.036
r159 118 119 12.5922 $w=1.3e-08 $l=5.4e-08 $layer=M1 $thickness=3.6e-08
+ $X=0.972 $Y=0.036 $X2=1.026 $Y2=0.036
r160 117 118 12.5922 $w=1.3e-08 $l=5.4e-08 $layer=M1 $thickness=3.6e-08
+ $X=0.918 $Y=0.036 $X2=0.972 $Y2=0.036
r161 116 117 12.5922 $w=1.3e-08 $l=5.4e-08 $layer=M1 $thickness=3.6e-08
+ $X=0.864 $Y=0.036 $X2=0.918 $Y2=0.036
r162 115 116 12.5922 $w=1.3e-08 $l=5.4e-08 $layer=M1 $thickness=3.6e-08 $X=0.81
+ $Y=0.036 $X2=0.864 $Y2=0.036
r163 114 115 12.5922 $w=1.3e-08 $l=5.4e-08 $layer=M1 $thickness=3.6e-08
+ $X=0.756 $Y=0.036 $X2=0.81 $Y2=0.036
r164 113 114 12.5922 $w=1.3e-08 $l=5.4e-08 $layer=M1 $thickness=3.6e-08
+ $X=0.702 $Y=0.036 $X2=0.756 $Y2=0.036
r165 112 113 12.5922 $w=1.3e-08 $l=5.4e-08 $layer=M1 $thickness=3.6e-08
+ $X=0.648 $Y=0.036 $X2=0.702 $Y2=0.036
r166 111 112 12.5922 $w=1.3e-08 $l=5.4e-08 $layer=M1 $thickness=3.6e-08
+ $X=0.594 $Y=0.036 $X2=0.648 $Y2=0.036
r167 110 111 12.5922 $w=1.3e-08 $l=5.4e-08 $layer=M1 $thickness=3.6e-08 $X=0.54
+ $Y=0.036 $X2=0.594 $Y2=0.036
r168 109 110 12.5922 $w=1.3e-08 $l=5.4e-08 $layer=M1 $thickness=3.6e-08
+ $X=0.486 $Y=0.036 $X2=0.54 $Y2=0.036
r169 108 109 12.5922 $w=1.3e-08 $l=5.4e-08 $layer=M1 $thickness=3.6e-08
+ $X=0.432 $Y=0.036 $X2=0.486 $Y2=0.036
r170 107 108 12.5922 $w=1.3e-08 $l=5.4e-08 $layer=M1 $thickness=3.6e-08
+ $X=0.378 $Y=0.036 $X2=0.432 $Y2=0.036
r171 106 107 12.5922 $w=1.3e-08 $l=5.4e-08 $layer=M1 $thickness=3.6e-08
+ $X=0.324 $Y=0.036 $X2=0.378 $Y2=0.036
r172 99 106 2.68168 $w=1.3e-08 $l=1.15e-08 $layer=M1 $thickness=3.6e-08
+ $X=0.3125 $Y=0.036 $X2=0.324 $Y2=0.036
r173 7 112 19.3796 $a=3.24e-16 $layer=V0LISD $X=0.648 $Y=0.0675 $X2=0.648
+ $Y2=0.036
r174 105 103 0.0308642 $w=8.1e-08 $l=2.5e-09 $layer=N_src_drn $thickness=1e-09
+ $X=0.6653 $Y=0.0675 $X2=0.6625 $Y2=0.0675
r175 7 103 0.179012 $w=8.1e-08 $l=1.45e-08 $layer=N_src_drn $thickness=1e-09
+ $X=0.648 $Y=0.0675 $X2=0.6625 $Y2=0.0675
r176 76 7 0.179012 $w=8.1e-08 $l=1.45e-08 $layer=N_src_drn $thickness=1e-09
+ $X=0.6335 $Y=0.0675 $X2=0.648 $Y2=0.0675
r177 104 76 0.0308642 $w=8.1e-08 $l=2.5e-09 $layer=N_src_drn $thickness=1e-09
+ $X=0.6306 $Y=0.0675 $X2=0.6335 $Y2=0.0675
.ends

* End of included file BUFx24_ASAP7_75t_R.pex.sp.pex

*
.subckt BUFx24_ASAP7_75t_CUSTOM_4_25_0_7 VSS VDD A Y
*
* VSS VSS
* VDD VDD
* A A
* Y Y
*
*

M0 N_M0_d N_M0_g VSS VSS nmos_rvt L=2e-08 W=8.1e-08 nfin=3 $X=0.071 $Y=0.027
M1 N_M1_d N_M1_g VSS VSS nmos_rvt L=2e-08 W=8.1e-08 nfin=3 $X=0.125 $Y=0.027
M2 N_M2_d N_M2_g VSS VSS nmos_rvt L=2e-08 W=8.1e-08 nfin=3 $X=0.179 $Y=0.027
M3 N_M3_d N_M3_g VSS VSS nmos_rvt L=2e-08 W=8.1e-08 nfin=3 $X=0.233 $Y=0.027
M4 N_M4_d N_M4_g VSS VSS nmos_rvt L=2e-08 W=8.1e-08 nfin=3 $X=0.287 $Y=0.027
M5 N_M5_d N_M5_g VSS VSS nmos_rvt L=2e-08 W=8.1e-08 nfin=3 $X=0.341 $Y=0.027
M6 N_M6_d N_M6_g VSS VSS nmos_rvt L=2e-08 W=8.1e-08 nfin=3 $X=0.395 $Y=0.027
M7 N_M7_d N_M7_g VSS VSS nmos_rvt L=2e-08 W=8.1e-08 nfin=3 $X=0.449 $Y=0.027
M8 N_M8_d N_M8_g VSS VSS nmos_rvt L=2e-08 W=8.1e-08 nfin=3 $X=0.503 $Y=0.027
M9 N_M9_d N_M9_g VSS VSS nmos_rvt L=2e-08 W=8.1e-08 nfin=3 $X=0.557 $Y=0.027
M10 N_M10_d N_M10_g VSS VSS nmos_rvt L=2e-08 W=8.1e-08 nfin=3 $X=0.611 $Y=0.027
M11 N_M11_d N_M11_g VSS VSS nmos_rvt L=2e-08 W=8.1e-08 nfin=3 $X=0.665 $Y=0.027
M12 N_M12_d N_M12_g VSS VSS nmos_rvt L=2e-08 W=8.1e-08 nfin=3 $X=0.719 $Y=0.027
M13 N_M13_d N_M13_g VSS VSS nmos_rvt L=2e-08 W=8.1e-08 nfin=3 $X=0.773 $Y=0.027
M14 N_M14_d N_M14_g VSS VSS nmos_rvt L=2e-08 W=8.1e-08 nfin=3 $X=0.827 $Y=0.027
M15 N_M15_d N_M15_g VSS VSS nmos_rvt L=2e-08 W=8.1e-08 nfin=3 $X=0.881 $Y=0.027
M16 N_M16_d N_M16_g VSS VSS nmos_rvt L=2e-08 W=8.1e-08 nfin=3 $X=0.935 $Y=0.027
M17 N_M17_d N_M17_g VSS VSS nmos_rvt L=2e-08 W=8.1e-08 nfin=3 $X=0.989 $Y=0.027
M18 N_M18_d N_M18_g VSS VSS nmos_rvt L=2e-08 W=8.1e-08 nfin=3 $X=1.043 $Y=0.027
M19 N_M19_d N_M19_g VSS VSS nmos_rvt L=2e-08 W=8.1e-08 nfin=3 $X=1.097 $Y=0.027
M20 N_M20_d N_M20_g VSS VSS nmos_rvt L=2e-08 W=8.1e-08 nfin=3 $X=1.151 $Y=0.027
M21 N_M21_d N_M21_g VSS VSS nmos_rvt L=2e-08 W=8.1e-08 nfin=3 $X=1.205 $Y=0.027
M22 N_M22_d N_M22_g VSS VSS nmos_rvt L=2e-08 W=8.1e-08 nfin=3 $X=1.259 $Y=0.027
M23 N_M23_d N_M23_g VSS VSS nmos_rvt L=2e-08 W=8.1e-08 nfin=3 $X=1.313 $Y=0.027
M24 N_M24_d N_M24_g VSS VSS nmos_rvt L=2e-08 W=8.1e-08 nfin=3 $X=1.367 $Y=0.027
M25 N_M25_d N_M25_g VSS VSS nmos_rvt L=2e-08 W=8.1e-08 nfin=3 $X=1.421 $Y=0.027
M26 N_M26_d N_M26_g VSS VSS nmos_rvt L=2e-08 W=8.1e-08 nfin=3 $X=1.475 $Y=0.027
M27 N_M27_d N_M27_g VSS VSS nmos_rvt L=2e-08 W=8.1e-08 nfin=3 $X=1.529 $Y=0.027
M28 N_M28_d N_M28_g VDD VDD pmos_rvt L=2e-08 W=8.1e-08 nfin=3 $X=0.071 $Y=0.162
M29 N_M29_d N_M29_g VDD VDD pmos_rvt L=2e-08 W=8.1e-08 nfin=3 $X=0.125 $Y=0.162
M30 N_M30_d N_M30_g VDD VDD pmos_rvt L=2e-08 W=8.1e-08 nfin=3 $X=0.179 $Y=0.162
M31 N_M31_d N_M31_g VDD VDD pmos_rvt L=2e-08 W=8.1e-08 nfin=3 $X=0.233 $Y=0.162
M32 N_M32_d N_M32_g VDD VDD pmos_rvt L=2e-08 W=8.1e-08 nfin=3 $X=0.287 $Y=0.162
M33 N_M33_d N_M33_g VDD VDD pmos_rvt L=2e-08 W=8.1e-08 nfin=3 $X=0.341 $Y=0.162
M34 N_M34_d N_M34_g VDD VDD pmos_rvt L=2e-08 W=8.1e-08 nfin=3 $X=0.395 $Y=0.162
M35 N_M35_d N_M35_g VDD VDD pmos_rvt L=2e-08 W=8.1e-08 nfin=3 $X=0.449 $Y=0.162
M36 N_M36_d N_M36_g VDD VDD pmos_rvt L=2e-08 W=8.1e-08 nfin=3 $X=0.503 $Y=0.162
M37 N_M37_d N_M37_g VDD VDD pmos_rvt L=2e-08 W=8.1e-08 nfin=3 $X=0.557 $Y=0.162
M38 N_M38_d N_M38_g VDD VDD pmos_rvt L=2e-08 W=8.1e-08 nfin=3 $X=0.611 $Y=0.162
M39 N_M39_d N_M39_g VDD VDD pmos_rvt L=2e-08 W=8.1e-08 nfin=3 $X=0.665 $Y=0.162
M40 N_M40_d N_M40_g VDD VDD pmos_rvt L=2e-08 W=8.1e-08 nfin=3 $X=0.719 $Y=0.162
M41 N_M41_d N_M41_g VDD VDD pmos_rvt L=2e-08 W=8.1e-08 nfin=3 $X=0.773 $Y=0.162
M42 N_M42_d N_M42_g VDD VDD pmos_rvt L=2e-08 W=8.1e-08 nfin=3 $X=0.827 $Y=0.162
M43 N_M43_d N_M43_g VDD VDD pmos_rvt L=2e-08 W=8.1e-08 nfin=3 $X=0.881 $Y=0.162
M44 N_M44_d N_M44_g VDD VDD pmos_rvt L=2e-08 W=8.1e-08 nfin=3 $X=0.935 $Y=0.162
M45 N_M45_d N_M45_g VDD VDD pmos_rvt L=2e-08 W=8.1e-08 nfin=3 $X=0.989 $Y=0.162
M46 N_M46_d N_M46_g VDD VDD pmos_rvt L=2e-08 W=8.1e-08 nfin=3 $X=1.043 $Y=0.162
M47 N_M47_d N_M47_g VDD VDD pmos_rvt L=2e-08 W=8.1e-08 nfin=3 $X=1.097 $Y=0.162
M48 N_M48_d N_M48_g VDD VDD pmos_rvt L=2e-08 W=8.1e-08 nfin=3 $X=1.151 $Y=0.162
M49 N_M49_d N_M49_g VDD VDD pmos_rvt L=2e-08 W=8.1e-08 nfin=3 $X=1.205 $Y=0.162
M50 N_M50_d N_M50_g VDD VDD pmos_rvt L=2e-08 W=8.1e-08 nfin=3 $X=1.259 $Y=0.162
M51 N_M51_d N_M51_g VDD VDD pmos_rvt L=2e-08 W=8.1e-08 nfin=3 $X=1.313 $Y=0.162
M52 N_M52_d N_M52_g VDD VDD pmos_rvt L=2e-08 W=8.1e-08 nfin=3 $X=1.367 $Y=0.162
M53 N_M53_d N_M53_g VDD VDD pmos_rvt L=2e-08 W=8.1e-08 nfin=3 $X=1.421 $Y=0.162
M54 N_M54_d N_M54_g VDD VDD pmos_rvt L=2e-08 W=8.1e-08 nfin=3 $X=1.475 $Y=0.162
M55 N_M55_d N_M55_g VDD VDD pmos_rvt L=2e-08 W=8.1e-08 nfin=3 $X=1.529 $Y=0.162

* .include "BUFx24_ASAP7_75t_R.pex.sp.pxi"

* Start of included file BUFx24_ASAP7_75t_R.pex.sp.pxi
x_PM_BUFx24_ASAP7_75t_R%A vss A N_M0_g N_M28_g N_M1_g N_M29_g N_M2_g N_M30_g
+ N_M3_g N_M31_g N_A_6 N_A_7 N_A_12 N_A_5 N_A_3 N_A_4 N_A_1
+ PM_BUFx24_ASAP7_75t_R%A
x_PM_BUFx24_ASAP7_75t_R%4 vss N_M10_g N_M38_g N_M9_g N_M37_g N_M8_g N_M36_g
+ N_M7_g N_M35_g N_M6_g N_M34_g N_M5_g N_M33_g N_M4_g N_M32_g N_M11_g N_M39_g
+ N_M12_g N_M40_g N_M13_g N_M41_g N_M14_g N_M42_g N_M15_g N_M43_g N_M16_g
+ N_M44_g N_M17_g N_M45_g N_M18_g N_M46_g N_M19_g N_M47_g N_M20_g N_M48_g
+ N_M21_g N_M49_g N_M22_g N_M50_g N_M23_g N_M51_g N_M24_g N_M52_g N_M25_g
+ N_M53_g N_M26_g N_M54_g N_M27_g N_M55_g N_M0_d N_M1_d N_M2_d N_M3_d N_M28_d
+ N_M29_d N_M30_d N_M31_d N_4_1 N_4_67 N_4_73 N_4_26 N_4_27 N_4_71 N_4_72
+ N_4_70 N_4_69 N_4_65 N_4_63 N_4_64 N_4_62 N_4_28 N_4_29 N_4_38 N_4_40 N_4_42
+ N_4_44 N_4_46 N_4_48 N_4_50 N_4_52 N_4_54 N_4_56 N_4_58 N_4_60 N_4_66 N_4_68
+ N_4_61 N_4_41 N_4_43 N_4_45 N_4_47 N_4_49 N_4_51 N_4_53 N_4_55 N_4_57 N_4_59
+ N_4_39 PM_BUFx24_ASAP7_75t_R%4
cc_1 N_4_1 N_A_6 8.89152e-20 $X=0.6115 $Y=0.135
cc_2 N_4_67 N_A_6 0.000194401f $X=0.243 $Y=0.135
cc_3 N_4_73 N_A_6 0.000235871f $X=0.27 $Y=0.135
cc_4 N_4_26 N_A_6 0.000678135f $X=0.108 $Y=0.0675
cc_5 N_4_27 N_A_6 0.000270868f $X=0.108 $Y=0.2025
cc_6 N_4_71 N_A_6 0.00039413f $X=0.243 $Y=0.0855
cc_7 N_4_72 N_A_6 0.00039413f $X=0.243 $Y=0.1845
cc_8 N_4_70 N_A_6 0.000956969f $X=0.0965 $Y=0.234
cc_9 N_4_69 N_A_6 0.000479525f $X=0.0965 $Y=0.036
cc_10 N_4_69 N_A_7 0.00048479f $X=0.0965 $Y=0.036
cc_11 N_4_26 N_A_12 0.000682159f $X=0.108 $Y=0.0675
cc_12 N_4_69 N_A_5 0.000715928f $X=0.0965 $Y=0.036
cc_13 N_4_70 N_A_5 0.000715928f $X=0.0965 $Y=0.234
cc_14 N_4_65 N_A_5 0.0576592f $X=0.2015 $Y=0.2025
cc_15 N_4_63 N_A_6 0.000853152f $X=0.2015 $Y=0.0675
cc_16 N_4_64 N_A_3 0.0304771f $X=0.0935 $Y=0.2025
cc_17 N_4_62 N_A_4 0.0304946f $X=0.0935 $Y=0.0675
cc_18 N_4_28 N_A_5 0.00161271f $X=0.216 $Y=0.0675
cc_19 N_4_29 N_A_5 0.00161271f $X=0.216 $Y=0.2025
cc_20 N_4_38 N_A_6 0.00175223f $X=0.297 $Y=0.135
cc_21 N_4_26 N_A_3 0.0019005f $X=0.108 $Y=0.0675
cc_22 N_4_27 N_A_3 0.0019005f $X=0.108 $Y=0.2025
cc_23 N_4_63 N_A_5 0.0293916f $X=0.2015 $Y=0.0675
cc_24 N_4_64 N_A_1 0.011178f $X=0.0935 $Y=0.2025
cc_25 N_4_62 N_A_3 0.0377538f $X=0.0935 $Y=0.0675
cc_26 N_4_64 N_A_4 0.0381114f $X=0.0935 $Y=0.2025
cc_27 N_4_65 N_A_6 0.0502666f $X=0.2015 $Y=0.2025
x_PM_BUFx24_ASAP7_75t_R%Y vss Y N_M10_d N_M11_d N_M4_d N_M5_d N_M6_d N_M7_d
+ N_M8_d N_M9_d N_M12_d N_M13_d N_M14_d N_M15_d N_M16_d N_M17_d N_M18_d N_M19_d
+ N_M20_d N_M21_d N_M22_d N_M23_d N_M24_d N_M25_d N_M26_d N_M27_d N_M32_d
+ N_M33_d N_M34_d N_M35_d N_M36_d N_M37_d N_M38_d N_M39_d N_M40_d N_M41_d
+ N_M42_d N_M43_d N_M44_d N_M45_d N_M46_d N_M47_d N_M48_d N_M49_d N_M50_d
+ N_M51_d N_M52_d N_M53_d N_M54_d N_M55_d N_Y_84 N_Y_15 N_Y_16 N_Y_17 N_Y_18
+ N_Y_19 N_Y_20 N_Y_21 N_Y_22 N_Y_23 N_Y_24 N_Y_99 N_Y_100 N_Y_1 N_Y_3 N_Y_5
+ N_Y_7 N_Y_9 N_Y_11 N_Y_13 N_Y_85 N_Y_73 N_Y_96 N_Y_86 N_Y_87 N_Y_88 N_Y_89
+ N_Y_90 N_Y_91 N_Y_92 N_Y_93 N_Y_94 N_Y_95 N_Y_74 N_Y_75 N_Y_76 N_Y_77 N_Y_78
+ N_Y_79 N_Y_80 N_Y_81 N_Y_82 N_Y_83 N_Y_101 N_Y_4 N_Y_6 N_Y_8 N_Y_10 N_Y_12
+ N_Y_14 N_Y_2 PM_BUFx24_ASAP7_75t_R%Y
cc_28 N_Y_84 N_4_28 8.46074e-20 $X=1.4975 $Y=0.0675
cc_29 N_Y_84 N_4_29 8.46074e-20 $X=1.4975 $Y=0.0675
cc_30 N_Y_84 N_4_38 0.000188152f $X=1.4975 $Y=0.0675
cc_31 N_Y_84 N_4_40 0.000188152f $X=1.4975 $Y=0.0675
cc_32 N_Y_84 N_4_42 0.000188152f $X=1.4975 $Y=0.0675
cc_33 N_Y_84 N_4_44 0.000188152f $X=1.4975 $Y=0.0675
cc_34 N_Y_84 N_4_46 0.000188152f $X=1.4975 $Y=0.0675
cc_35 N_Y_84 N_4_48 0.000188152f $X=1.4975 $Y=0.0675
cc_36 N_Y_84 N_4_50 0.000188152f $X=1.4975 $Y=0.0675
cc_37 N_Y_15 N_4_52 9.40758e-20 $X=1.08 $Y=0.0675
cc_38 N_Y_16 N_4_52 0.00199222f $X=1.08 $Y=0.2025
cc_39 N_Y_17 N_4_54 9.40758e-20 $X=1.188 $Y=0.0675
cc_40 N_Y_18 N_4_54 0.00199222f $X=1.188 $Y=0.2025
cc_41 N_Y_19 N_4_56 9.40758e-20 $X=1.296 $Y=0.0675
cc_42 N_Y_20 N_4_56 0.00199222f $X=1.296 $Y=0.2025
cc_43 N_Y_21 N_4_58 9.40758e-20 $X=1.404 $Y=0.0675
cc_44 N_Y_22 N_4_58 0.00199222f $X=1.404 $Y=0.2025
cc_45 N_Y_23 N_4_60 0.00191837f $X=1.512 $Y=0.0675
cc_46 N_Y_24 N_4_60 0.00191837f $X=1.512 $Y=0.2025
cc_47 N_Y_99 N_4_69 0.000130613f $X=0.3125 $Y=0.036
cc_48 N_Y_100 N_4_70 0.000130613f $X=1.5685 $Y=0.234
cc_49 N_Y_99 N_4_66 0.000141876f $X=0.3125 $Y=0.036
cc_50 N_Y_100 N_4_68 0.000141876f $X=1.5685 $Y=0.234
cc_51 N_Y_99 N_4_71 0.000409416f $X=0.3125 $Y=0.036
cc_52 N_Y_100 N_4_72 0.000409416f $X=1.5685 $Y=0.234
cc_53 N_Y_1 N_4_1 0.000851355f $X=0.324 $Y=0.0675
cc_54 N_Y_3 N_4_1 0.00110767f $X=0.432 $Y=0.0675
cc_55 N_Y_5 N_4_1 0.00110767f $X=0.54 $Y=0.0675
cc_56 N_Y_7 N_4_1 0.00110767f $X=0.648 $Y=0.0675
cc_57 N_Y_9 N_4_1 0.00110767f $X=0.756 $Y=0.0675
cc_58 N_Y_11 N_4_1 0.00110767f $X=0.864 $Y=0.0675
cc_59 N_Y_13 N_4_1 0.00110767f $X=0.972 $Y=0.0675
cc_60 N_Y_15 N_4_1 0.00110767f $X=1.08 $Y=0.0675
cc_61 N_Y_17 N_4_1 0.00110767f $X=1.188 $Y=0.0675
cc_62 N_Y_19 N_4_1 0.00110767f $X=1.296 $Y=0.0675
cc_63 N_Y_21 N_4_1 0.00110767f $X=1.404 $Y=0.0675
cc_64 N_Y_23 N_4_1 0.000675844f $X=1.512 $Y=0.0675
cc_65 N_Y_24 N_4_1 0.000763117f $X=1.512 $Y=0.2025
cc_66 N_Y_85 N_4_38 0.0286153f $X=0.3095 $Y=0.2025
cc_67 N_Y_73 N_4_38 0.0640603f $X=0.3095 $Y=0.0675
cc_68 N_Y_96 N_4_61 0.0286325f $X=1.4975 $Y=0.2025
cc_69 N_Y_86 N_4_41 0.0286728f $X=0.4175 $Y=0.2025
cc_70 N_Y_87 N_4_43 0.0286728f $X=0.5255 $Y=0.2025
cc_71 N_Y_88 N_4_45 0.0286728f $X=0.6335 $Y=0.2025
cc_72 N_Y_89 N_4_47 0.0286728f $X=0.7415 $Y=0.2025
cc_73 N_Y_90 N_4_49 0.0286728f $X=0.8495 $Y=0.2025
cc_74 N_Y_91 N_4_51 0.0286728f $X=0.9575 $Y=0.2025
cc_75 N_Y_92 N_4_53 0.0286728f $X=1.0655 $Y=0.2025
cc_76 N_Y_93 N_4_55 0.0286728f $X=1.1735 $Y=0.2025
cc_77 N_Y_94 N_4_57 0.0286728f $X=1.2815 $Y=0.2025
cc_78 N_Y_95 N_4_59 0.0286728f $X=1.3895 $Y=0.2025
cc_79 N_Y_74 N_4_41 0.0644059f $X=0.4175 $Y=0.0675
cc_80 N_Y_75 N_4_43 0.0644059f $X=0.5255 $Y=0.0675
cc_81 N_Y_76 N_4_45 0.0644059f $X=0.6335 $Y=0.0675
cc_82 N_Y_77 N_4_47 0.0644059f $X=0.7415 $Y=0.0675
cc_83 N_Y_78 N_4_49 0.0644059f $X=0.8495 $Y=0.0675
cc_84 N_Y_79 N_4_51 0.0644059f $X=0.9575 $Y=0.0675
cc_85 N_Y_80 N_4_53 0.0644059f $X=1.0655 $Y=0.0675
cc_86 N_Y_81 N_4_55 0.0644059f $X=1.1735 $Y=0.0675
cc_87 N_Y_82 N_4_57 0.0644059f $X=1.2815 $Y=0.0675
cc_88 N_Y_83 N_4_59 0.0643286f $X=1.3895 $Y=0.0675
cc_89 N_Y_101 N_4_73 0.0015825f $X=1.593 $Y=0.0855
cc_90 N_Y_4 N_4_40 0.00189814f $X=0.432 $Y=0.2025
cc_91 N_Y_3 N_4_41 0.00189814f $X=0.432 $Y=0.0675
cc_92 N_Y_6 N_4_42 0.00189814f $X=0.54 $Y=0.2025
cc_93 N_Y_5 N_4_43 0.00189814f $X=0.54 $Y=0.0675
cc_94 N_Y_8 N_4_44 0.00189814f $X=0.648 $Y=0.2025
cc_95 N_Y_7 N_4_45 0.00189814f $X=0.648 $Y=0.0675
cc_96 N_Y_10 N_4_46 0.00189814f $X=0.756 $Y=0.2025
cc_97 N_Y_9 N_4_47 0.00189814f $X=0.756 $Y=0.0675
cc_98 N_Y_12 N_4_48 0.00189814f $X=0.864 $Y=0.2025
cc_99 N_Y_11 N_4_49 0.00189814f $X=0.864 $Y=0.0675
cc_100 N_Y_14 N_4_50 0.00189814f $X=0.972 $Y=0.2025
cc_101 N_Y_13 N_4_51 0.00189814f $X=0.972 $Y=0.0675
cc_102 N_Y_15 N_4_53 0.00189814f $X=1.08 $Y=0.0675
cc_103 N_Y_17 N_4_55 0.00189814f $X=1.188 $Y=0.0675
cc_104 N_Y_19 N_4_57 0.00189814f $X=1.296 $Y=0.0675
cc_105 N_Y_21 N_4_59 0.00189814f $X=1.404 $Y=0.0675
cc_106 N_Y_1 N_4_39 0.00206441f $X=0.324 $Y=0.0675
cc_107 N_Y_2 N_4_39 0.00206441f $X=0.324 $Y=0.2025
cc_108 N_Y_4 N_4_73 0.00717632f $X=0.432 $Y=0.2025
cc_109 N_Y_12 N_4_73 0.00809259f $X=0.864 $Y=0.2025
cc_110 N_Y_20 N_4_73 0.00886698f $X=1.296 $Y=0.2025
cc_111 N_Y_100 N_4_73 0.00988674f $X=1.5685 $Y=0.234
cc_112 N_Y_99 N_4_73 0.00989474f $X=0.3125 $Y=0.036
cc_113 N_Y_76 N_4_1 0.0241889f $X=0.6335 $Y=0.0675
cc_114 N_Y_81 N_4_1 0.0249675f $X=1.1735 $Y=0.0675
cc_115 N_Y_84 N_4_61 0.0356786f $X=1.4975 $Y=0.0675
cc_116 N_Y_85 N_4_39 0.0357286f $X=0.3095 $Y=0.2025
cc_117 N_Y_86 N_4_40 0.0357369f $X=0.4175 $Y=0.2025
cc_118 N_Y_87 N_4_42 0.0357382f $X=0.5255 $Y=0.2025
cc_119 N_Y_88 N_4_44 0.0357382f $X=0.6335 $Y=0.2025
cc_120 N_Y_89 N_4_46 0.0357382f $X=0.7415 $Y=0.2025
cc_121 N_Y_90 N_4_48 0.0357382f $X=0.8495 $Y=0.2025
cc_122 N_Y_91 N_4_50 0.0357382f $X=0.9575 $Y=0.2025
cc_123 N_Y_92 N_4_52 0.0357382f $X=1.0655 $Y=0.2025
cc_124 N_Y_93 N_4_54 0.0357382f $X=1.1735 $Y=0.2025
cc_125 N_Y_94 N_4_56 0.0357382f $X=1.2815 $Y=0.2025
cc_126 N_Y_95 N_4_58 0.0357382f $X=1.3895 $Y=0.2025
cc_127 N_Y_84 N_4_60 0.0648128f $X=1.4975 $Y=0.0675

* End of included file BUFx24_ASAP7_75t_R.pex.sp.pxi
.ends

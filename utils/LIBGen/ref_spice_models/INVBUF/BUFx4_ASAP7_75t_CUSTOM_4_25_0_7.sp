.subckt PM_BUFx4_ASAP7_75t_R%A vss 22 10 16 3 4 6 1
c1 1 vss 0.00464195f $X=0.072 $Y=0.135
c2 3 vss 0.11472f $X=0.081 $Y=0.0245
c3 4 vss 0.0035371f $X=0.027 $Y=0.072
c4 5 vss 0.00130327f $X=0.027 $Y=0.135
c5 6 vss 0.0035371f $X=0.027 $Y=0.198
c6 7 vss 0.00365977f $X=0.027 $Y=0.1035
c7 8 vss 0.00365977f $X=0.027 $Y=0.1665
c8 9 vss 0.00119936f $X=0.0455 $Y=0.135
r1 6 8 6.16517 $w=1.44286e-08 $l=3.15e-08 $layer=M1 $thickness=3.6e-08 $X=0.027
+ $Y=0.198 $X2=0.027 $Y2=0.1665
r2 4 7 6.16517 $w=1.44286e-08 $l=3.15e-08 $layer=M1 $thickness=3.6e-08 $X=0.027
+ $Y=0.072 $X2=0.027 $Y2=0.1035
r3 5 9 3.1337 $w=1.54324e-08 $l=1.85e-08 $layer=M1 $thickness=3.6e-08 $X=0.027
+ $Y=0.135 $X2=0.0455 $Y2=0.135
r4 5 7 6.16517 $w=1.44286e-08 $l=3.15e-08 $layer=M1 $thickness=3.6e-08 $X=0.027
+ $Y=0.135 $X2=0.027 $Y2=0.1035
r5 5 8 6.16517 $w=1.44286e-08 $l=3.15e-08 $layer=M1 $thickness=3.6e-08 $X=0.027
+ $Y=0.135 $X2=0.027 $Y2=0.1665
r6 22 9 4.31401 $w=1.3e-08 $l=1.85e-08 $layer=M1 $thickness=3.6e-08 $X=0.061
+ $Y=0.1355 $X2=0.0455 $Y2=0.135
r7 22 20 19.3796 $a=3.24e-16 $layer=V0LIG $X=0.061 $Y=0.1355 $X2=0.063 $Y2=0.135
r8 1 18 2.6116 $w=2.2e-08 $l=1e-08 $layer=LIG $thickness=4.8e-08 $X=0.072
+ $Y=0.135 $X2=0.082 $Y2=0.135
r9 1 20 4.98695 $w=1.60444e-08 $l=9e-09 $layer=LIG $thickness=4.8e-08 $X=0.072
+ $Y=0.135 $X2=0.063 $Y2=0.135
r10 16 15 14.6259 $w=2.1e-08 $l=4.3e-08 $layer=Gate_1 $thickness=5.6e-08
+ $X=0.081 $Y=0.216 $X2=0.081 $Y2=0.173
r11 14 15 7.31297 $w=2.1e-08 $l=2.15e-08 $layer=Gate_1 $thickness=5.6e-08
+ $X=0.081 $Y=0.1515 $X2=0.081 $Y2=0.173
r12 13 14 5.79936 $w=2.03333e-08 $l=1.65e-08 $layer=Gate_1 $thickness=5.6e-08
+ $X=0.081 $Y=0.135 $X2=0.081 $Y2=0.1515
r13 13 18 6.27904 $w=2.09e-08 $l=1e-09 $layer=Gate_1 $thickness=5.24e-08
+ $X=0.081 $Y=0.135 $X2=0.082 $Y2=0.135
r14 12 13 5.79936 $w=2.03333e-08 $l=1.65e-08 $layer=Gate_1 $thickness=5.6e-08
+ $X=0.081 $Y=0.1185 $X2=0.081 $Y2=0.135
r15 11 12 7.31297 $w=2.1e-08 $l=2.15e-08 $layer=Gate_1 $thickness=5.6e-08
+ $X=0.081 $Y=0.097 $X2=0.081 $Y2=0.1185
r16 10 11 14.6259 $w=2.1e-08 $l=4.3e-08 $layer=Gate_1 $thickness=5.6e-08
+ $X=0.081 $Y=0.054 $X2=0.081 $Y2=0.097
r17 10 3 10.0341 $w=2.1e-08 $l=2.95e-08 $layer=Gate_1 $thickness=5.6e-08
+ $X=0.081 $Y=0.054 $X2=0.081 $Y2=0.0245
.ends

.subckt PM_BUFx4_ASAP7_75t_R%4 vss 29 33 49 52 55 58 62 66 77 79 9 10 26 27 15
+ 22 24 25 19 20 1 21 23 2 3 4 16 18 28 17
c1 1 vss 0.00352484f $X=0.135 $Y=0.135
c2 2 vss 0.00400429f $X=0.189 $Y=0.135
c3 3 vss 0.00339927f $X=0.243 $Y=0.135
c4 4 vss 0.00449794f $X=0.297 $Y=0.135
c5 9 vss 0.00916198f $X=0.054 $Y=0.0675
c6 10 vss 0.00916198f $X=0.054 $Y=0.2025
c7 15 vss 0.0982037f $X=0.135 $Y=0.0245
c8 16 vss 0.0805976f $X=0.189 $Y=0.135
c9 17 vss 0.0804476f $X=0.243 $Y=0.135
c10 18 vss 0.0873233f $X=0.297 $Y=0.135
c11 19 vss 0.0392847f $X=0.056 $Y=0.054
c12 20 vss 0.0393776f $X=0.056 $Y=0.216
c13 21 vss 0.00284024f $X=0.111 $Y=0.036
c14 22 vss 0.000260434f $X=0.111 $Y=0.135
c15 23 vss 0.00284024f $X=0.111 $Y=0.234
c16 24 vss 0.00771435f $X=0.0875 $Y=0.036
c17 25 vss 0.00771435f $X=0.0875 $Y=0.234
c18 26 vss 0.00390514f $X=0.111 $Y=0.1035
c19 27 vss 0.00390514f $X=0.111 $Y=0.1665
c20 28 vss 0.00719531f $X=0.123 $Y=0.135
r1 79 78 0.0462963 $w=5.4e-08 $l=2.5e-09 $layer=P_src_drn $thickness=1e-09
+ $X=0.0713 $Y=0.216 $X2=0.0685 $Y2=0.216
r2 20 78 0.231482 $w=5.4e-08 $l=1.25e-08 $layer=P_src_drn $thickness=1e-09
+ $X=0.056 $Y=0.216 $X2=0.0685 $Y2=0.216
r3 77 76 0.0462963 $w=5.4e-08 $l=2.5e-09 $layer=N_src_drn $thickness=1e-09
+ $X=0.0713 $Y=0.054 $X2=0.0685 $Y2=0.054
r4 19 76 0.231482 $w=5.4e-08 $l=1.25e-08 $layer=N_src_drn $thickness=1e-09
+ $X=0.056 $Y=0.054 $X2=0.0685 $Y2=0.054
r5 10 75 19.3796 $a=3.24e-16 $layer=V0LISD $X=0.054 $Y=0.2025 $X2=0.05 $Y2=0.234
r6 9 71 19.3796 $a=3.24e-16 $layer=V0LISD $X=0.054 $Y=0.0675 $X2=0.05 $Y2=0.036
r7 72 73 2.09871 $w=1.3e-08 $l=9e-09 $layer=M1 $thickness=3.6e-08 $X=0.059
+ $Y=0.234 $X2=0.068 $Y2=0.234
r8 72 75 2.09871 $w=1.3e-08 $l=9e-09 $layer=M1 $thickness=3.6e-08 $X=0.059
+ $Y=0.234 $X2=0.05 $Y2=0.234
r9 25 73 4.5472 $w=1.3e-08 $l=1.95e-08 $layer=M1 $thickness=3.6e-08 $X=0.0875
+ $Y=0.234 $X2=0.068 $Y2=0.234
r10 68 69 2.09871 $w=1.3e-08 $l=9e-09 $layer=M1 $thickness=3.6e-08 $X=0.059
+ $Y=0.036 $X2=0.068 $Y2=0.036
r11 68 71 2.09871 $w=1.3e-08 $l=9e-09 $layer=M1 $thickness=3.6e-08 $X=0.059
+ $Y=0.036 $X2=0.05 $Y2=0.036
r12 24 69 4.5472 $w=1.3e-08 $l=1.95e-08 $layer=M1 $thickness=3.6e-08 $X=0.0875
+ $Y=0.036 $X2=0.068 $Y2=0.036
r13 23 47 2.5483 $w=1.79e-08 $l=1.8e-08 $layer=M1 $thickness=3.6e-08 $X=0.111
+ $Y=0.234 $X2=0.111 $Y2=0.216
r14 23 25 3.83085 $w=1.49149e-08 $l=2.35e-08 $layer=M1 $thickness=3.6e-08
+ $X=0.111 $Y=0.234 $X2=0.0875 $Y2=0.234
r15 21 45 2.5483 $w=1.79e-08 $l=1.8e-08 $layer=M1 $thickness=3.6e-08 $X=0.111
+ $Y=0.036 $X2=0.111 $Y2=0.054
r16 21 24 3.83085 $w=1.49149e-08 $l=2.35e-08 $layer=M1 $thickness=3.6e-08
+ $X=0.111 $Y=0.036 $X2=0.0875 $Y2=0.036
r17 66 65 14.6259 $w=2.1e-08 $l=4.3e-08 $layer=Gate_1 $thickness=5.6e-08
+ $X=0.297 $Y=0.2025 $X2=0.297 $Y2=0.1595
r18 64 65 2.7211 $w=2.1e-08 $l=8e-09 $layer=Gate_1 $thickness=5.6e-08 $X=0.297
+ $Y=0.1515 $X2=0.297 $Y2=0.1595
r19 62 63 14.6259 $w=2.1e-08 $l=4.3e-08 $layer=Gate_1 $thickness=5.6e-08
+ $X=0.297 $Y=0.0675 $X2=0.297 $Y2=0.1105
r20 60 63 2.7211 $w=2.1e-08 $l=8e-09 $layer=Gate_1 $thickness=5.6e-08 $X=0.297
+ $Y=0.1185 $X2=0.297 $Y2=0.1105
r21 18 60 5.79936 $w=2.03333e-08 $l=1.65e-08 $layer=Gate_1 $thickness=5.6e-08
+ $X=0.297 $Y=0.135 $X2=0.297 $Y2=0.1185
r22 18 64 5.79936 $w=2.03333e-08 $l=1.65e-08 $layer=Gate_1 $thickness=5.6e-08
+ $X=0.297 $Y=0.135 $X2=0.297 $Y2=0.1515
r23 58 57 16.4967 $w=2.1e-08 $l=4.85e-08 $layer=Gate_1 $thickness=5.6e-08
+ $X=0.243 $Y=0.2025 $X2=0.243 $Y2=0.154
r24 55 56 16.4967 $w=2.1e-08 $l=4.85e-08 $layer=Gate_1 $thickness=5.6e-08
+ $X=0.243 $Y=0.0675 $X2=0.243 $Y2=0.116
r25 17 56 6.6497 $w=2.04211e-08 $l=1.9e-08 $layer=Gate_1 $thickness=5.6e-08
+ $X=0.243 $Y=0.135 $X2=0.243 $Y2=0.116
r26 17 57 6.6497 $w=2.04211e-08 $l=1.9e-08 $layer=Gate_1 $thickness=5.6e-08
+ $X=0.243 $Y=0.135 $X2=0.243 $Y2=0.154
r27 52 51 16.4967 $w=2.1e-08 $l=4.85e-08 $layer=Gate_1 $thickness=5.6e-08
+ $X=0.189 $Y=0.2025 $X2=0.189 $Y2=0.154
r28 49 50 16.4967 $w=2.1e-08 $l=4.85e-08 $layer=Gate_1 $thickness=5.6e-08
+ $X=0.189 $Y=0.0675 $X2=0.189 $Y2=0.116
r29 16 50 6.6497 $w=2.04211e-08 $l=1.9e-08 $layer=Gate_1 $thickness=5.6e-08
+ $X=0.189 $Y=0.135 $X2=0.189 $Y2=0.116
r30 16 51 6.6497 $w=2.04211e-08 $l=1.9e-08 $layer=Gate_1 $thickness=5.6e-08
+ $X=0.189 $Y=0.135 $X2=0.189 $Y2=0.154
r31 46 47 4.19742 $w=1.3e-08 $l=1.8e-08 $layer=M1 $thickness=3.6e-08 $X=0.111
+ $Y=0.198 $X2=0.111 $Y2=0.216
r32 27 46 7.34548 $w=1.3e-08 $l=3.15e-08 $layer=M1 $thickness=3.6e-08 $X=0.111
+ $Y=0.1665 $X2=0.111 $Y2=0.198
r33 44 45 4.19742 $w=1.3e-08 $l=1.8e-08 $layer=M1 $thickness=3.6e-08 $X=0.111
+ $Y=0.072 $X2=0.111 $Y2=0.054
r34 26 44 7.34548 $w=1.3e-08 $l=3.15e-08 $layer=M1 $thickness=3.6e-08 $X=0.111
+ $Y=0.1035 $X2=0.111 $Y2=0.072
r35 4 42 19.3796 $a=3.24e-16 $layer=V0LIG $X=0.297 $Y=0.135 $X2=0.297 $Y2=0.135
r36 4 18 10.4265 $w=1.765e-08 $layer=LIG $thickness=5.2e-08 $X=0.297 $Y=0.135
+ $X2=0.297 $Y2=0.135
r37 3 40 19.3796 $a=3.24e-16 $layer=V0LIG $X=0.243 $Y=0.135 $X2=0.243 $Y2=0.135
r38 3 17 10.4265 $w=1.765e-08 $layer=LIG $thickness=5.2e-08 $X=0.243 $Y=0.135
+ $X2=0.243 $Y2=0.135
r39 2 38 19.3796 $a=3.24e-16 $layer=V0LIG $X=0.189 $Y=0.135 $X2=0.189 $Y2=0.135
r40 2 16 10.4265 $w=1.765e-08 $layer=LIG $thickness=5.2e-08 $X=0.189 $Y=0.135
+ $X2=0.189 $Y2=0.135
r41 22 28 1.61797 $w=1.675e-08 $l=1.2e-08 $layer=M1 $thickness=3.6e-08 $X=0.111
+ $Y=0.135 $X2=0.123 $Y2=0.135
r42 22 26 6.16517 $w=1.44286e-08 $l=3.15e-08 $layer=M1 $thickness=3.6e-08
+ $X=0.111 $Y=0.135 $X2=0.111 $Y2=0.1035
r43 22 27 6.16517 $w=1.44286e-08 $l=3.15e-08 $layer=M1 $thickness=3.6e-08
+ $X=0.111 $Y=0.135 $X2=0.111 $Y2=0.1665
r44 41 42 6.29612 $w=1.3e-08 $l=2.7e-08 $layer=M1 $thickness=3.6e-08 $X=0.27
+ $Y=0.135 $X2=0.297 $Y2=0.135
r45 40 41 6.29612 $w=1.3e-08 $l=2.7e-08 $layer=M1 $thickness=3.6e-08 $X=0.243
+ $Y=0.135 $X2=0.27 $Y2=0.135
r46 39 40 6.29612 $w=1.3e-08 $l=2.7e-08 $layer=M1 $thickness=3.6e-08 $X=0.216
+ $Y=0.135 $X2=0.243 $Y2=0.135
r47 38 39 6.29612 $w=1.3e-08 $l=2.7e-08 $layer=M1 $thickness=3.6e-08 $X=0.189
+ $Y=0.135 $X2=0.216 $Y2=0.135
r48 37 38 6.17953 $w=1.3e-08 $l=2.65e-08 $layer=M1 $thickness=3.6e-08 $X=0.1625
+ $Y=0.135 $X2=0.189 $Y2=0.135
r49 36 37 4.19742 $w=1.3e-08 $l=1.8e-08 $layer=M1 $thickness=3.6e-08 $X=0.1445
+ $Y=0.135 $X2=0.1625 $Y2=0.135
r50 35 36 2.2153 $w=1.3e-08 $l=9.5e-09 $layer=M1 $thickness=3.6e-08 $X=0.135
+ $Y=0.135 $X2=0.1445 $Y2=0.135
r51 28 35 2.79828 $w=1.3e-08 $l=1.2e-08 $layer=M1 $thickness=3.6e-08 $X=0.123
+ $Y=0.135 $X2=0.135 $Y2=0.135
r52 1 31 10.4265 $w=1.765e-08 $layer=LIG $thickness=5.2e-08 $X=0.135 $Y=0.135
+ $X2=0.135 $Y2=0.135
r53 1 35 19.3796 $a=3.24e-16 $layer=V0LIG $X=0.135 $Y=0.135 $X2=0.135 $Y2=0.135
r54 33 32 16.4967 $w=2.1e-08 $l=4.85e-08 $layer=Gate_1 $thickness=5.6e-08
+ $X=0.135 $Y=0.2025 $X2=0.135 $Y2=0.154
r55 31 32 6.6497 $w=2.04211e-08 $l=1.9e-08 $layer=Gate_1 $thickness=5.6e-08
+ $X=0.135 $Y=0.135 $X2=0.135 $Y2=0.154
r56 30 31 6.6497 $w=2.04211e-08 $l=1.9e-08 $layer=Gate_1 $thickness=5.6e-08
+ $X=0.135 $Y=0.116 $X2=0.135 $Y2=0.135
r57 29 30 16.4967 $w=2.1e-08 $l=4.85e-08 $layer=Gate_1 $thickness=5.6e-08
+ $X=0.135 $Y=0.0675 $X2=0.135 $Y2=0.116
r58 29 15 14.6259 $w=2.1e-08 $l=4.3e-08 $layer=Gate_1 $thickness=5.6e-08
+ $X=0.135 $Y=0.0675 $X2=0.135 $Y2=0.0245
r59 10 20 1e-05 $l=1.36473e-08 $X=0.054 $Y=0.2025 $X2=0.056 $Y2=0.216
r60 9 19 1e-05 $l=1.36473e-08 $X=0.054 $Y=0.0675 $X2=0.056 $Y2=0.054
.ends

.subckt PM_BUFx4_ASAP7_75t_R%Y vss 35 24 25 33 34 46 47 50 51 14 20 15 16 3 4 1
+ 2 21 19 13
c1 1 vss 0.00872102f $X=0.162 $Y=0.0675
c2 2 vss 0.00868154f $X=0.162 $Y=0.2025
c3 3 vss 0.00886197f $X=0.27 $Y=0.0675
c4 4 vss 0.00886197f $X=0.27 $Y=0.2025
c5 13 vss 0.00449062f $X=0.1475 $Y=0.0675
c6 14 vss 0.00445093f $X=0.2555 $Y=0.0675
c7 15 vss 0.00452586f $X=0.1475 $Y=0.2025
c8 16 vss 0.00453052f $X=0.2555 $Y=0.2025
c9 17 vss 0.00303103f $X=0.348 $Y=0.036
c10 18 vss 0.00303103f $X=0.348 $Y=0.234
c11 19 vss 0.0176231f $X=0.149 $Y=0.036
c12 20 vss 0.0176231f $X=0.3265 $Y=0.234
c13 21 vss 0.0081307f $X=0.348 $Y=0.0795
r1 51 49 0.0308642 $w=8.1e-08 $l=2.5e-09 $layer=P_src_drn $thickness=1e-09
+ $X=0.2873 $Y=0.2025 $X2=0.2845 $Y2=0.2025
r2 4 49 0.179012 $w=8.1e-08 $l=1.45e-08 $layer=P_src_drn $thickness=1e-09
+ $X=0.27 $Y=0.2025 $X2=0.2845 $Y2=0.2025
r3 16 4 0.179012 $w=8.1e-08 $l=1.45e-08 $layer=P_src_drn $thickness=1e-09
+ $X=0.2555 $Y=0.2025 $X2=0.27 $Y2=0.2025
r4 50 16 0.0308642 $w=8.1e-08 $l=2.5e-09 $layer=P_src_drn $thickness=1e-09
+ $X=0.2526 $Y=0.2025 $X2=0.2555 $Y2=0.2025
r5 47 45 0.0308642 $w=8.1e-08 $l=2.5e-09 $layer=P_src_drn $thickness=1e-09
+ $X=0.1793 $Y=0.2025 $X2=0.1765 $Y2=0.2025
r6 2 45 0.179012 $w=8.1e-08 $l=1.45e-08 $layer=P_src_drn $thickness=1e-09
+ $X=0.162 $Y=0.2025 $X2=0.1765 $Y2=0.2025
r7 15 2 0.179012 $w=8.1e-08 $l=1.45e-08 $layer=P_src_drn $thickness=1e-09
+ $X=0.1475 $Y=0.2025 $X2=0.162 $Y2=0.2025
r8 46 15 0.0308642 $w=8.1e-08 $l=2.5e-09 $layer=P_src_drn $thickness=1e-09
+ $X=0.1446 $Y=0.2025 $X2=0.1475 $Y2=0.2025
r9 4 42 19.3796 $a=3.24e-16 $layer=V0LISD $X=0.27 $Y=0.2025 $X2=0.27 $Y2=0.234
r10 2 40 19.3796 $a=3.24e-16 $layer=V0LISD $X=0.162 $Y=0.2025 $X2=0.162
+ $Y2=0.234
r11 42 43 6.17953 $w=1.3e-08 $l=2.65e-08 $layer=M1 $thickness=3.6e-08 $X=0.27
+ $Y=0.234 $X2=0.2965 $Y2=0.234
r12 41 42 12.5922 $w=1.3e-08 $l=5.4e-08 $layer=M1 $thickness=3.6e-08 $X=0.216
+ $Y=0.234 $X2=0.27 $Y2=0.234
r13 40 41 12.5922 $w=1.3e-08 $l=5.4e-08 $layer=M1 $thickness=3.6e-08 $X=0.162
+ $Y=0.234 $X2=0.216 $Y2=0.234
r14 20 43 6.99569 $w=1.3e-08 $l=3e-08 $layer=M1 $thickness=3.6e-08 $X=0.3265
+ $Y=0.234 $X2=0.2965 $Y2=0.234
r15 18 38 9.89378 $w=1.47818e-08 $l=4.95e-08 $layer=M1 $thickness=3.6e-08
+ $X=0.348 $Y=0.234 $X2=0.348 $Y2=0.1845
r16 18 20 3.36447 $w=1.5093e-08 $l=2.15e-08 $layer=M1 $thickness=3.6e-08
+ $X=0.348 $Y=0.234 $X2=0.3265 $Y2=0.234
r17 37 38 11.5429 $w=1.3e-08 $l=4.95e-08 $layer=M1 $thickness=3.6e-08 $X=0.348
+ $Y=0.135 $X2=0.348 $Y2=0.1845
r18 36 37 3.38125 $w=1.3e-08 $l=1.45e-08 $layer=M1 $thickness=3.6e-08 $X=0.348
+ $Y=0.1205 $X2=0.348 $Y2=0.135
r19 35 36 1.39914 $w=1.3e-08 $l=6e-09 $layer=M1 $thickness=3.6e-08 $X=0.3515
+ $Y=0.1145 $X2=0.348 $Y2=0.1205
r20 35 21 8.16164 $w=1.3e-08 $l=3.5e-08 $layer=M1 $thickness=3.6e-08 $X=0.3515
+ $Y=0.1145 $X2=0.348 $Y2=0.0795
r21 34 32 0.0308642 $w=8.1e-08 $l=2.5e-09 $layer=N_src_drn $thickness=1e-09
+ $X=0.2873 $Y=0.0675 $X2=0.2845 $Y2=0.0675
r22 3 32 0.179012 $w=8.1e-08 $l=1.45e-08 $layer=N_src_drn $thickness=1e-09
+ $X=0.27 $Y=0.0675 $X2=0.2845 $Y2=0.0675
r23 14 3 0.179012 $w=8.1e-08 $l=1.45e-08 $layer=N_src_drn $thickness=1e-09
+ $X=0.2555 $Y=0.0675 $X2=0.27 $Y2=0.0675
r24 33 14 0.0308642 $w=8.1e-08 $l=2.5e-09 $layer=N_src_drn $thickness=1e-09
+ $X=0.2526 $Y=0.0675 $X2=0.2555 $Y2=0.0675
r25 17 30 3.36447 $w=1.5093e-08 $l=2.15e-08 $layer=M1 $thickness=3.6e-08
+ $X=0.348 $Y=0.036 $X2=0.3265 $Y2=0.036
r26 17 21 8.49464 $w=1.50276e-08 $l=4.35e-08 $layer=M1 $thickness=3.6e-08
+ $X=0.348 $Y=0.036 $X2=0.348 $Y2=0.0795
r27 3 28 19.3796 $a=3.24e-16 $layer=V0LISD $X=0.27 $Y=0.0675 $X2=0.27 $Y2=0.036
r28 29 30 6.99569 $w=1.3e-08 $l=3e-08 $layer=M1 $thickness=3.6e-08 $X=0.2965
+ $Y=0.036 $X2=0.3265 $Y2=0.036
r29 28 29 6.17953 $w=1.3e-08 $l=2.65e-08 $layer=M1 $thickness=3.6e-08 $X=0.27
+ $Y=0.036 $X2=0.2965 $Y2=0.036
r30 27 28 12.5922 $w=1.3e-08 $l=5.4e-08 $layer=M1 $thickness=3.6e-08 $X=0.216
+ $Y=0.036 $X2=0.27 $Y2=0.036
r31 26 27 12.5922 $w=1.3e-08 $l=5.4e-08 $layer=M1 $thickness=3.6e-08 $X=0.162
+ $Y=0.036 $X2=0.216 $Y2=0.036
r32 19 26 3.03147 $w=1.3e-08 $l=1.3e-08 $layer=M1 $thickness=3.6e-08 $X=0.149
+ $Y=0.036 $X2=0.162 $Y2=0.036
r33 1 26 19.3796 $a=3.24e-16 $layer=V0LISD $X=0.162 $Y=0.0675 $X2=0.162
+ $Y2=0.036
r34 25 23 0.0308642 $w=8.1e-08 $l=2.5e-09 $layer=N_src_drn $thickness=1e-09
+ $X=0.1793 $Y=0.0675 $X2=0.1765 $Y2=0.0675
r35 1 23 0.179012 $w=8.1e-08 $l=1.45e-08 $layer=N_src_drn $thickness=1e-09
+ $X=0.162 $Y=0.0675 $X2=0.1765 $Y2=0.0675
r36 13 1 0.179012 $w=8.1e-08 $l=1.45e-08 $layer=N_src_drn $thickness=1e-09
+ $X=0.1475 $Y=0.0675 $X2=0.162 $Y2=0.0675
r37 24 13 0.0308642 $w=8.1e-08 $l=2.5e-09 $layer=N_src_drn $thickness=1e-09
+ $X=0.1446 $Y=0.0675 $X2=0.1475 $Y2=0.0675
.ends

* End of included file BUFx4_ASAP7_75t_R.pex.sp.pex

*
.subckt BUFx4_ASAP7_75t_CUSTOM_4_25_0_7 VSS VDD A Y
*
* VSS VSS
* VDD VDD
* A A
* Y Y
*
*

M0 VSS N_M0_g N_M0_s VSS nmos_rvt L=2e-08 W=5.4e-08 nfin=2 $X=0.071 $Y=0.027
M1 N_M1_d N_M1_g VSS VSS nmos_rvt L=2e-08 W=8.1e-08 nfin=3 $X=0.125 $Y=0.027
M2 N_M2_d N_M2_g VSS VSS nmos_rvt L=2e-08 W=8.1e-08 nfin=3 $X=0.179 $Y=0.027
M3 N_M3_d N_M3_g VSS VSS nmos_rvt L=2e-08 W=8.1e-08 nfin=3 $X=0.233 $Y=0.027
M4 N_M4_d N_M4_g VSS VSS nmos_rvt L=2e-08 W=8.1e-08 nfin=3 $X=0.287 $Y=0.027
M5 VDD N_M5_g N_M5_s VDD pmos_rvt L=2e-08 W=5.4e-08 nfin=2 $X=0.071 $Y=0.189
M6 N_M6_d N_M6_g VDD VDD pmos_rvt L=2e-08 W=8.1e-08 nfin=3 $X=0.125 $Y=0.162
M7 N_M7_d N_M7_g VDD VDD pmos_rvt L=2e-08 W=8.1e-08 nfin=3 $X=0.179 $Y=0.162
M8 N_M8_d N_M8_g VDD VDD pmos_rvt L=2e-08 W=8.1e-08 nfin=3 $X=0.233 $Y=0.162
M9 N_M9_d N_M9_g VDD VDD pmos_rvt L=2e-08 W=8.1e-08 nfin=3 $X=0.287 $Y=0.162

* .include "BUFx4_ASAP7_75t_R.pex.sp.pxi"

* Start of included file BUFx4_ASAP7_75t_R.pex.sp.pxi
x_PM_BUFx4_ASAP7_75t_R%A vss A N_M0_g N_M5_g N_A_3 N_A_4 N_A_6 N_A_1
+ PM_BUFx4_ASAP7_75t_R%A
x_PM_BUFx4_ASAP7_75t_R%4 vss N_M1_g N_M6_g N_M2_g N_M7_g N_M3_g N_M8_g N_M4_g
+ N_M9_g N_M0_s N_M5_s N_4_9 N_4_10 N_4_26 N_4_27 N_4_15 N_4_22 N_4_24 N_4_25
+ N_4_19 N_4_20 N_4_1 N_4_21 N_4_23 N_4_2 N_4_3 N_4_4 N_4_16 N_4_18 N_4_28
+ N_4_17 PM_BUFx4_ASAP7_75t_R%4
cc_1 N_4_9 N_A_3 0.0034202f $X=0.054 $Y=0.0675
cc_2 N_4_10 N_A_3 0.00462301f $X=0.054 $Y=0.2025
cc_3 N_4_26 N_A_3 0.00100423f $X=0.111 $Y=0.1035
cc_4 N_4_27 N_A_3 0.00100423f $X=0.111 $Y=0.1665
cc_5 N_4_15 N_A_3 0.00155403f $X=0.135 $Y=0.0245
cc_6 N_4_22 N_A_3 0.00188009f $X=0.111 $Y=0.135
cc_7 N_4_24 N_A_4 0.00343047f $X=0.0875 $Y=0.036
cc_8 N_4_25 N_A_6 0.00343047f $X=0.0875 $Y=0.234
cc_9 N_4_19 N_A_3 0.0147093f $X=0.056 $Y=0.054
cc_10 N_4_20 N_A_1 0.0041625f $X=0.056 $Y=0.216
cc_11 N_4_20 N_A_3 0.0524684f $X=0.056 $Y=0.216
x_PM_BUFx4_ASAP7_75t_R%Y vss Y N_M1_d N_M2_d N_M3_d N_M4_d N_M6_d N_M7_d N_M8_d
+ N_M9_d N_Y_14 N_Y_20 N_Y_15 N_Y_16 N_Y_3 N_Y_4 N_Y_1 N_Y_2 N_Y_21 N_Y_19
+ N_Y_13 PM_BUFx4_ASAP7_75t_R%Y
cc_12 N_Y_14 N_4_1 0.000413612f $X=0.2555 $Y=0.0675
cc_13 N_Y_14 N_4_21 0.000508253f $X=0.2555 $Y=0.0675
cc_14 N_Y_14 N_4_23 0.000508253f $X=0.2555 $Y=0.0675
cc_15 N_Y_14 N_4_2 0.000532006f $X=0.2555 $Y=0.0675
cc_16 N_Y_14 N_4_3 0.000746818f $X=0.2555 $Y=0.0675
cc_17 N_Y_14 N_4_4 0.000819478f $X=0.2555 $Y=0.0675
cc_18 N_Y_14 N_4_15 0.000842706f $X=0.2555 $Y=0.0675
cc_19 N_Y_14 N_4_16 0.000842813f $X=0.2555 $Y=0.0675
cc_20 N_Y_14 N_4_26 0.000968269f $X=0.2555 $Y=0.0675
cc_21 N_Y_20 N_4_27 0.000968269f $X=0.3265 $Y=0.234
cc_22 N_Y_15 N_4_1 0.00136085f $X=0.1475 $Y=0.2025
cc_23 N_Y_16 N_4_3 0.00136085f $X=0.2555 $Y=0.2025
cc_24 N_Y_15 N_4_2 0.00147629f $X=0.1475 $Y=0.2025
cc_25 N_Y_16 N_4_4 0.00147629f $X=0.2555 $Y=0.2025
cc_26 N_Y_3 N_4_18 0.00172485f $X=0.27 $Y=0.0675
cc_27 N_Y_4 N_4_18 0.00172485f $X=0.27 $Y=0.2025
cc_28 N_Y_1 N_4_15 0.00193893f $X=0.162 $Y=0.0675
cc_29 N_Y_2 N_4_15 0.00193893f $X=0.162 $Y=0.2025
cc_30 N_Y_21 N_4_28 0.00195472f $X=0.348 $Y=0.0795
cc_31 N_Y_19 N_4_28 0.00203252f $X=0.149 $Y=0.036
cc_32 N_Y_20 N_4_28 0.00203252f $X=0.3265 $Y=0.234
cc_33 N_Y_2 N_4_28 0.00448714f $X=0.162 $Y=0.2025
cc_34 N_Y_13 N_4_15 0.0552789f $X=0.1475 $Y=0.0675
cc_35 N_Y_15 N_4_15 0.0105106f $X=0.1475 $Y=0.2025
cc_36 N_Y_16 N_4_17 0.0106151f $X=0.2555 $Y=0.2025
cc_37 N_Y_16 N_4_18 0.0188984f $X=0.2555 $Y=0.2025
cc_38 N_Y_15 N_4_16 0.01891f $X=0.1475 $Y=0.2025
cc_39 N_Y_14 N_4_17 0.0562877f $X=0.2555 $Y=0.0675
cc_40 N_Y_13 N_4_16 0.037484f $X=0.1475 $Y=0.0675
cc_41 N_Y_14 N_4_18 0.0512163f $X=0.2555 $Y=0.0675

* End of included file BUFx4_ASAP7_75t_R.pex.sp.pxi
.ends

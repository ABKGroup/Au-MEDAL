.subckt PM_CKINVDCx11_ASAP7_75t_R%8 vss 19 23 33 36 46 47 50 51 10 11 15 17 9 3
+ 1 13 4 18
c1 1 vss 0.00633348f $X=0.297 $Y=0.135
c2 3 vss 0.00714877f $X=0.216 $Y=0.2025
c3 4 vss 0.00707404f $X=0.324 $Y=0.2025
c4 9 vss 0.0819992f $X=0.297 $Y=0.0245
c5 10 vss 0.0846631f $X=0.351 $Y=0.135
c6 11 vss 0.00489598f $X=0.2015 $Y=0.2025
c7 12 vss 0.00464221f $X=0.3095 $Y=0.2025
c8 13 vss 0.000193584f $X=0.297 $Y=0.135
c9 14 vss 0.000340426f $X=0.297 $Y=0.171
c10 15 vss 0.00203006f $X=0.27 $Y=0.171
c11 16 vss 0.00014956f $X=0.297 $Y=0.153
c12 17 vss 0.000442992f $X=0.3105 $Y=0.135
c13 18 vss 0.00101266f $X=0.3105 $Y=0.171
r1 51 49 0.0308642 $w=8.1e-08 $l=2.5e-09 $layer=P_src_drn $thickness=1e-09
+ $X=0.3413 $Y=0.2025 $X2=0.3385 $Y2=0.2025
r2 4 49 0.179012 $w=8.1e-08 $l=1.45e-08 $layer=P_src_drn $thickness=1e-09
+ $X=0.324 $Y=0.2025 $X2=0.3385 $Y2=0.2025
r3 12 4 0.179012 $w=8.1e-08 $l=1.45e-08 $layer=P_src_drn $thickness=1e-09
+ $X=0.3095 $Y=0.2025 $X2=0.324 $Y2=0.2025
r4 50 12 0.0308642 $w=8.1e-08 $l=2.5e-09 $layer=P_src_drn $thickness=1e-09
+ $X=0.3066 $Y=0.2025 $X2=0.3095 $Y2=0.2025
r5 47 45 0.0308642 $w=8.1e-08 $l=2.5e-09 $layer=P_src_drn $thickness=1e-09
+ $X=0.2333 $Y=0.2025 $X2=0.2305 $Y2=0.2025
r6 3 45 0.179012 $w=8.1e-08 $l=1.45e-08 $layer=P_src_drn $thickness=1e-09
+ $X=0.216 $Y=0.2025 $X2=0.2305 $Y2=0.2025
r7 11 3 0.179012 $w=8.1e-08 $l=1.45e-08 $layer=P_src_drn $thickness=1e-09
+ $X=0.2015 $Y=0.2025 $X2=0.216 $Y2=0.2025
r8 46 11 0.0308642 $w=8.1e-08 $l=2.5e-09 $layer=P_src_drn $thickness=1e-09
+ $X=0.1986 $Y=0.2025 $X2=0.2015 $Y2=0.2025
r9 4 41 19.3796 $a=3.24e-16 $layer=V0LISD $X=0.324 $Y=0.2025 $X2=0.324 $Y2=0.171
r10 3 39 19.3796 $a=3.24e-16 $layer=V0LISD $X=0.216 $Y=0.2025 $X2=0.216
+ $Y2=0.171
r11 18 41 3.14806 $w=1.3e-08 $l=1.35e-08 $layer=M1 $thickness=3.6e-08 $X=0.3105
+ $Y=0.171 $X2=0.324 $Y2=0.171
r12 39 40 5.24677 $w=1.3e-08 $l=2.25e-08 $layer=M1 $thickness=3.6e-08 $X=0.216
+ $Y=0.171 $X2=0.2385 $Y2=0.171
r13 15 40 7.34548 $w=1.3e-08 $l=3.15e-08 $layer=M1 $thickness=3.6e-08 $X=0.27
+ $Y=0.171 $X2=0.2385 $Y2=0.171
r14 14 16 3.01711 $w=1.55e-08 $l=1.8e-08 $layer=M1 $thickness=3.6e-08 $X=0.297
+ $Y=0.171 $X2=0.297 $Y2=0.153
r15 14 15 5.11582 $w=1.46667e-08 $l=2.7e-08 $layer=M1 $thickness=3.6e-08
+ $X=0.297 $Y=0.171 $X2=0.27 $Y2=0.171
r16 14 18 1.96775 $w=1.63333e-08 $l=1.35e-08 $layer=M1 $thickness=3.6e-08
+ $X=0.297 $Y=0.171 $X2=0.3105 $Y2=0.171
r17 13 17 1.49895 $w=1.63333e-08 $l=1.35e-08 $layer=M1 $thickness=3.6e-08
+ $X=0.297 $Y=0.135 $X2=0.3105 $Y2=0.135
r18 13 16 2.5483 $w=1.79e-08 $l=1.8e-08 $layer=M1 $thickness=3.6e-08 $X=0.297
+ $Y=0.135 $X2=0.297 $Y2=0.153
r19 36 35 16.4967 $w=2.1e-08 $l=4.85e-08 $layer=Gate_1 $thickness=5.6e-08
+ $X=0.351 $Y=0.2025 $X2=0.351 $Y2=0.154
r20 33 34 16.4967 $w=2.1e-08 $l=4.85e-08 $layer=Gate_1 $thickness=5.6e-08
+ $X=0.351 $Y=0.0675 $X2=0.351 $Y2=0.116
r21 10 27 6.54019 $w=2.09524e-08 $layer=Gate_1 $thickness=5.21905e-08 $X=0.351
+ $Y=0.135 $X2=0.351 $Y2=0.135
r22 10 34 6.6497 $w=2.04211e-08 $l=1.9e-08 $layer=Gate_1 $thickness=5.6e-08
+ $X=0.351 $Y=0.135 $X2=0.351 $Y2=0.116
r23 10 35 6.6497 $w=2.04211e-08 $l=1.9e-08 $layer=Gate_1 $thickness=5.6e-08
+ $X=0.351 $Y=0.135 $X2=0.351 $Y2=0.154
r24 17 29 3.14806 $w=1.3e-08 $l=1.35e-08 $layer=M1 $thickness=3.6e-08 $X=0.3105
+ $Y=0.135 $X2=0.324 $Y2=0.135
r25 26 27 12.6539 $w=1.77815e-08 $l=2.7e-08 $layer=LIG $thickness=4.8e-08
+ $X=0.324 $Y=0.135 $X2=0.351 $Y2=0.135
r26 26 29 19.3796 $a=3.24e-16 $layer=V0LIG $X=0.324 $Y=0.135 $X2=0.324 $Y2=0.135
r27 1 21 6.54019 $w=2.09524e-08 $layer=Gate_1 $thickness=5.21905e-08 $X=0.297
+ $Y=0.135 $X2=0.297 $Y2=0.135
r28 1 26 12.6539 $w=1.77815e-08 $l=2.7e-08 $layer=LIG $thickness=4.8e-08
+ $X=0.297 $Y=0.135 $X2=0.324 $Y2=0.135
r29 23 22 16.4967 $w=2.1e-08 $l=4.85e-08 $layer=Gate_1 $thickness=5.6e-08
+ $X=0.297 $Y=0.2025 $X2=0.297 $Y2=0.154
r30 21 22 6.6497 $w=2.04211e-08 $l=1.9e-08 $layer=Gate_1 $thickness=5.6e-08
+ $X=0.297 $Y=0.135 $X2=0.297 $Y2=0.154
r31 20 21 6.6497 $w=2.04211e-08 $l=1.9e-08 $layer=Gate_1 $thickness=5.6e-08
+ $X=0.297 $Y=0.116 $X2=0.297 $Y2=0.135
r32 19 20 16.4967 $w=2.1e-08 $l=4.85e-08 $layer=Gate_1 $thickness=5.6e-08
+ $X=0.297 $Y=0.0675 $X2=0.297 $Y2=0.116
r33 19 9 14.6259 $w=2.1e-08 $l=4.3e-08 $layer=Gate_1 $thickness=5.6e-08
+ $X=0.297 $Y=0.0675 $X2=0.297 $Y2=0.0245
.ends

.subckt PM_CKINVDCx11_ASAP7_75t_R%7 vss 19 23 33 36 46 47 50 51 10 15 17 9 3 1
+ 11 13 4 18
c1 1 vss 0.00633496f $X=0.729 $Y=0.135
c2 3 vss 0.00721978f $X=0.648 $Y=0.2025
c3 4 vss 0.00716948f $X=0.756 $Y=0.2025
c4 9 vss 0.0821845f $X=0.729 $Y=0.0245
c5 10 vss 0.0823026f $X=0.783 $Y=0.135
c6 11 vss 0.00715665f $X=0.6335 $Y=0.2025
c7 12 vss 0.00668679f $X=0.7415 $Y=0.2025
c8 13 vss 0.000209338f $X=0.729 $Y=0.135
c9 14 vss 0.000356186f $X=0.729 $Y=0.171
c10 15 vss 0.00262421f $X=0.702 $Y=0.171
c11 16 vss 0.000149611f $X=0.729 $Y=0.153
c12 17 vss 0.000685476f $X=0.7425 $Y=0.135
c13 18 vss 0.00132086f $X=0.7425 $Y=0.171
r1 51 49 0.0308642 $w=8.1e-08 $l=2.5e-09 $layer=P_src_drn $thickness=1e-09
+ $X=0.7733 $Y=0.2025 $X2=0.7705 $Y2=0.2025
r2 4 49 0.179012 $w=8.1e-08 $l=1.45e-08 $layer=P_src_drn $thickness=1e-09
+ $X=0.756 $Y=0.2025 $X2=0.7705 $Y2=0.2025
r3 12 4 0.179012 $w=8.1e-08 $l=1.45e-08 $layer=P_src_drn $thickness=1e-09
+ $X=0.7415 $Y=0.2025 $X2=0.756 $Y2=0.2025
r4 50 12 0.0308642 $w=8.1e-08 $l=2.5e-09 $layer=P_src_drn $thickness=1e-09
+ $X=0.7386 $Y=0.2025 $X2=0.7415 $Y2=0.2025
r5 47 45 0.0308642 $w=8.1e-08 $l=2.5e-09 $layer=P_src_drn $thickness=1e-09
+ $X=0.6653 $Y=0.2025 $X2=0.6625 $Y2=0.2025
r6 3 45 0.179012 $w=8.1e-08 $l=1.45e-08 $layer=P_src_drn $thickness=1e-09
+ $X=0.648 $Y=0.2025 $X2=0.6625 $Y2=0.2025
r7 11 3 0.179012 $w=8.1e-08 $l=1.45e-08 $layer=P_src_drn $thickness=1e-09
+ $X=0.6335 $Y=0.2025 $X2=0.648 $Y2=0.2025
r8 46 11 0.0308642 $w=8.1e-08 $l=2.5e-09 $layer=P_src_drn $thickness=1e-09
+ $X=0.6306 $Y=0.2025 $X2=0.6335 $Y2=0.2025
r9 4 41 19.3796 $a=3.24e-16 $layer=V0LISD $X=0.756 $Y=0.2025 $X2=0.756 $Y2=0.171
r10 3 39 19.3796 $a=3.24e-16 $layer=V0LISD $X=0.648 $Y=0.2025 $X2=0.648
+ $Y2=0.171
r11 18 41 3.14806 $w=1.3e-08 $l=1.35e-08 $layer=M1 $thickness=3.6e-08 $X=0.7425
+ $Y=0.171 $X2=0.756 $Y2=0.171
r12 39 40 5.24677 $w=1.3e-08 $l=2.25e-08 $layer=M1 $thickness=3.6e-08 $X=0.648
+ $Y=0.171 $X2=0.6705 $Y2=0.171
r13 15 40 7.34548 $w=1.3e-08 $l=3.15e-08 $layer=M1 $thickness=3.6e-08 $X=0.702
+ $Y=0.171 $X2=0.6705 $Y2=0.171
r14 14 16 3.01711 $w=1.55e-08 $l=1.8e-08 $layer=M1 $thickness=3.6e-08 $X=0.729
+ $Y=0.171 $X2=0.729 $Y2=0.153
r15 14 15 5.11582 $w=1.46667e-08 $l=2.7e-08 $layer=M1 $thickness=3.6e-08
+ $X=0.729 $Y=0.171 $X2=0.702 $Y2=0.171
r16 14 18 1.96775 $w=1.63333e-08 $l=1.35e-08 $layer=M1 $thickness=3.6e-08
+ $X=0.729 $Y=0.171 $X2=0.7425 $Y2=0.171
r17 13 17 1.49895 $w=1.63333e-08 $l=1.35e-08 $layer=M1 $thickness=3.6e-08
+ $X=0.729 $Y=0.135 $X2=0.7425 $Y2=0.135
r18 13 16 2.5483 $w=1.79e-08 $l=1.8e-08 $layer=M1 $thickness=3.6e-08 $X=0.729
+ $Y=0.135 $X2=0.729 $Y2=0.153
r19 36 35 16.4967 $w=2.1e-08 $l=4.85e-08 $layer=Gate_1 $thickness=5.6e-08
+ $X=0.783 $Y=0.2025 $X2=0.783 $Y2=0.154
r20 33 34 16.4967 $w=2.1e-08 $l=4.85e-08 $layer=Gate_1 $thickness=5.6e-08
+ $X=0.783 $Y=0.0675 $X2=0.783 $Y2=0.116
r21 10 27 6.54019 $w=2.09524e-08 $layer=Gate_1 $thickness=5.21905e-08 $X=0.783
+ $Y=0.135 $X2=0.783 $Y2=0.135
r22 10 34 6.6497 $w=2.04211e-08 $l=1.9e-08 $layer=Gate_1 $thickness=5.6e-08
+ $X=0.783 $Y=0.135 $X2=0.783 $Y2=0.116
r23 10 35 6.6497 $w=2.04211e-08 $l=1.9e-08 $layer=Gate_1 $thickness=5.6e-08
+ $X=0.783 $Y=0.135 $X2=0.783 $Y2=0.154
r24 17 29 3.14806 $w=1.3e-08 $l=1.35e-08 $layer=M1 $thickness=3.6e-08 $X=0.7425
+ $Y=0.135 $X2=0.756 $Y2=0.135
r25 26 27 12.6539 $w=1.77815e-08 $l=2.7e-08 $layer=LIG $thickness=4.8e-08
+ $X=0.756 $Y=0.135 $X2=0.783 $Y2=0.135
r26 26 29 19.3796 $a=3.24e-16 $layer=V0LIG $X=0.756 $Y=0.135 $X2=0.756 $Y2=0.135
r27 1 21 6.54019 $w=2.09524e-08 $layer=Gate_1 $thickness=5.21905e-08 $X=0.729
+ $Y=0.135 $X2=0.729 $Y2=0.135
r28 1 26 12.6539 $w=1.77815e-08 $l=2.7e-08 $layer=LIG $thickness=4.8e-08
+ $X=0.729 $Y=0.135 $X2=0.756 $Y2=0.135
r29 23 22 16.4967 $w=2.1e-08 $l=4.85e-08 $layer=Gate_1 $thickness=5.6e-08
+ $X=0.729 $Y=0.2025 $X2=0.729 $Y2=0.154
r30 21 22 6.6497 $w=2.04211e-08 $l=1.9e-08 $layer=Gate_1 $thickness=5.6e-08
+ $X=0.729 $Y=0.135 $X2=0.729 $Y2=0.154
r31 20 21 6.6497 $w=2.04211e-08 $l=1.9e-08 $layer=Gate_1 $thickness=5.6e-08
+ $X=0.729 $Y=0.116 $X2=0.729 $Y2=0.135
r32 19 20 16.4967 $w=2.1e-08 $l=4.85e-08 $layer=Gate_1 $thickness=5.6e-08
+ $X=0.729 $Y=0.0675 $X2=0.729 $Y2=0.116
r33 19 9 14.6259 $w=2.1e-08 $l=4.3e-08 $layer=Gate_1 $thickness=5.6e-08
+ $X=0.729 $Y=0.0675 $X2=0.729 $Y2=0.0245
.ends

.subckt PM_CKINVDCx11_ASAP7_75t_R%5 vss 19 23 33 36 46 47 50 51 9 18 16 4 10 1
+ 12 13 3 15
c1 1 vss 0.00632008f $X=1.053 $Y=0.135
c2 3 vss 0.00717043f $X=1.08 $Y=0.2025
c3 4 vss 0.00722049f $X=1.188 $Y=0.2025
c4 9 vss 0.0823056f $X=1.053 $Y=0.0245
c5 10 vss 0.0822777f $X=1.107 $Y=0.135
c6 11 vss 0.00670733f $X=1.0655 $Y=0.2025
c7 12 vss 0.00717366f $X=1.1735 $Y=0.2025
c8 13 vss 0.000209494f $X=1.107 $Y=0.135
c9 14 vss 0.000356342f $X=1.107 $Y=0.171
c10 15 vss 0.00132395f $X=1.0645 $Y=0.171
c11 16 vss 0.000707511f $X=1.062 $Y=0.135
c12 17 vss 0.000149612f $X=1.107 $Y=0.153
c13 18 vss 0.00263012f $X=1.134 $Y=0.171
r1 51 49 0.0308642 $w=8.1e-08 $l=2.5e-09 $layer=P_src_drn $thickness=1e-09
+ $X=1.2053 $Y=0.2025 $X2=1.2025 $Y2=0.2025
r2 4 49 0.179012 $w=8.1e-08 $l=1.45e-08 $layer=P_src_drn $thickness=1e-09
+ $X=1.188 $Y=0.2025 $X2=1.2025 $Y2=0.2025
r3 12 4 0.179012 $w=8.1e-08 $l=1.45e-08 $layer=P_src_drn $thickness=1e-09
+ $X=1.1735 $Y=0.2025 $X2=1.188 $Y2=0.2025
r4 50 12 0.0308642 $w=8.1e-08 $l=2.5e-09 $layer=P_src_drn $thickness=1e-09
+ $X=1.1706 $Y=0.2025 $X2=1.1735 $Y2=0.2025
r5 47 45 0.0308642 $w=8.1e-08 $l=2.5e-09 $layer=P_src_drn $thickness=1e-09
+ $X=1.0973 $Y=0.2025 $X2=1.0945 $Y2=0.2025
r6 3 45 0.179012 $w=8.1e-08 $l=1.45e-08 $layer=P_src_drn $thickness=1e-09
+ $X=1.08 $Y=0.2025 $X2=1.0945 $Y2=0.2025
r7 11 3 0.179012 $w=8.1e-08 $l=1.45e-08 $layer=P_src_drn $thickness=1e-09
+ $X=1.0655 $Y=0.2025 $X2=1.08 $Y2=0.2025
r8 46 11 0.0308642 $w=8.1e-08 $l=2.5e-09 $layer=P_src_drn $thickness=1e-09
+ $X=1.0626 $Y=0.2025 $X2=1.0655 $Y2=0.2025
r9 4 42 19.3796 $a=3.24e-16 $layer=V0LISD $X=1.188 $Y=0.2025 $X2=1.188 $Y2=0.171
r10 3 38 19.3796 $a=3.24e-16 $layer=V0LISD $X=1.08 $Y=0.2025 $X2=1.08 $Y2=0.171
r11 41 42 5.24677 $w=1.3e-08 $l=2.25e-08 $layer=M1 $thickness=3.6e-08 $X=1.1655
+ $Y=0.171 $X2=1.188 $Y2=0.171
r12 18 41 7.34548 $w=1.3e-08 $l=3.15e-08 $layer=M1 $thickness=3.6e-08 $X=1.134
+ $Y=0.171 $X2=1.1655 $Y2=0.171
r13 38 39 3.14806 $w=1.3e-08 $l=1.35e-08 $layer=M1 $thickness=3.6e-08 $X=1.08
+ $Y=0.171 $X2=1.0935 $Y2=0.171
r14 15 38 3.61444 $w=1.3e-08 $l=1.55e-08 $layer=M1 $thickness=3.6e-08 $X=1.0645
+ $Y=0.171 $X2=1.08 $Y2=0.171
r15 14 17 3.01711 $w=1.55e-08 $l=1.8e-08 $layer=M1 $thickness=3.6e-08 $X=1.107
+ $Y=0.171 $X2=1.107 $Y2=0.153
r16 14 39 1.96775 $w=1.63333e-08 $l=1.35e-08 $layer=M1 $thickness=3.6e-08
+ $X=1.107 $Y=0.171 $X2=1.0935 $Y2=0.171
r17 14 18 5.11582 $w=1.46667e-08 $l=2.7e-08 $layer=M1 $thickness=3.6e-08
+ $X=1.107 $Y=0.171 $X2=1.134 $Y2=0.171
r18 13 31 1.49895 $w=1.63333e-08 $l=1.35e-08 $layer=M1 $thickness=3.6e-08
+ $X=1.107 $Y=0.135 $X2=1.0935 $Y2=0.135
r19 13 17 2.5483 $w=1.79e-08 $l=1.8e-08 $layer=M1 $thickness=3.6e-08 $X=1.107
+ $Y=0.135 $X2=1.107 $Y2=0.153
r20 36 35 16.4967 $w=2.1e-08 $l=4.85e-08 $layer=Gate_1 $thickness=5.6e-08
+ $X=1.107 $Y=0.2025 $X2=1.107 $Y2=0.154
r21 33 34 16.4967 $w=2.1e-08 $l=4.85e-08 $layer=Gate_1 $thickness=5.6e-08
+ $X=1.107 $Y=0.0675 $X2=1.107 $Y2=0.116
r22 10 27 6.54019 $w=2.09524e-08 $layer=Gate_1 $thickness=5.21905e-08 $X=1.107
+ $Y=0.135 $X2=1.107 $Y2=0.135
r23 10 34 6.6497 $w=2.04211e-08 $l=1.9e-08 $layer=Gate_1 $thickness=5.6e-08
+ $X=1.107 $Y=0.135 $X2=1.107 $Y2=0.116
r24 10 35 6.6497 $w=2.04211e-08 $l=1.9e-08 $layer=Gate_1 $thickness=5.6e-08
+ $X=1.107 $Y=0.135 $X2=1.107 $Y2=0.154
r25 30 31 3.14806 $w=1.3e-08 $l=1.35e-08 $layer=M1 $thickness=3.6e-08 $X=1.08
+ $Y=0.135 $X2=1.0935 $Y2=0.135
r26 29 30 2.68168 $w=1.3e-08 $l=1.15e-08 $layer=M1 $thickness=3.6e-08 $X=1.0685
+ $Y=0.135 $X2=1.08 $Y2=0.135
r27 16 29 1.51573 $w=1.3e-08 $l=6.5e-09 $layer=M1 $thickness=3.6e-08 $X=1.062
+ $Y=0.135 $X2=1.0685 $Y2=0.135
r28 26 27 12.6539 $w=1.77815e-08 $l=2.7e-08 $layer=LIG $thickness=4.8e-08
+ $X=1.08 $Y=0.135 $X2=1.107 $Y2=0.135
r29 26 30 19.3796 $a=3.24e-16 $layer=V0LIG $X=1.08 $Y=0.135 $X2=1.08 $Y2=0.135
r30 1 21 6.54019 $w=2.09524e-08 $layer=Gate_1 $thickness=5.21905e-08 $X=1.053
+ $Y=0.135 $X2=1.053 $Y2=0.135
r31 1 26 12.6539 $w=1.77815e-08 $l=2.7e-08 $layer=LIG $thickness=4.8e-08
+ $X=1.053 $Y=0.135 $X2=1.08 $Y2=0.135
r32 23 22 16.4967 $w=2.1e-08 $l=4.85e-08 $layer=Gate_1 $thickness=5.6e-08
+ $X=1.053 $Y=0.2025 $X2=1.053 $Y2=0.154
r33 21 22 6.6497 $w=2.04211e-08 $l=1.9e-08 $layer=Gate_1 $thickness=5.6e-08
+ $X=1.053 $Y=0.135 $X2=1.053 $Y2=0.154
r34 20 21 6.6497 $w=2.04211e-08 $l=1.9e-08 $layer=Gate_1 $thickness=5.6e-08
+ $X=1.053 $Y=0.116 $X2=1.053 $Y2=0.135
r35 19 20 16.4967 $w=2.1e-08 $l=4.85e-08 $layer=Gate_1 $thickness=5.6e-08
+ $X=1.053 $Y=0.0675 $X2=1.053 $Y2=0.116
r36 19 9 14.6259 $w=2.1e-08 $l=4.3e-08 $layer=Gate_1 $thickness=5.6e-08
+ $X=1.053 $Y=0.0675 $X2=1.053 $Y2=0.0245
.ends

.subckt PM_CKINVDCx11_ASAP7_75t_R%4 vss 19 23 33 36 46 47 50 51 15 3 17 1 10 11
+ 18 9 14
c1 1 vss 0.00631993f $X=1.161 $Y=0.135
c2 3 vss 0.00721221f $X=1.08 $Y=0.0675
c3 4 vss 0.00715931f $X=1.188 $Y=0.0675
c4 9 vss 0.0822549f $X=1.161 $Y=0.0245
c5 10 vss 0.0830363f $X=1.215 $Y=0.135
c6 11 vss 0.00690875f $X=1.0655 $Y=0.0675
c7 12 vss 0.00645615f $X=1.1735 $Y=0.0675
c8 13 vss 0.000348937f $X=1.161 $Y=0.099
c9 14 vss 0.000207659f $X=1.161 $Y=0.135
c10 15 vss 0.00243679f $X=1.134 $Y=0.099
c11 16 vss 0.000149606f $X=1.161 $Y=0.117
c12 17 vss 0.00135687f $X=1.1745 $Y=0.099
c13 18 vss 0.000644177f $X=1.1745 $Y=0.135
r1 51 49 0.0308642 $w=8.1e-08 $l=2.5e-09 $layer=N_src_drn $thickness=1e-09
+ $X=1.2053 $Y=0.0675 $X2=1.2025 $Y2=0.0675
r2 4 49 0.179012 $w=8.1e-08 $l=1.45e-08 $layer=N_src_drn $thickness=1e-09
+ $X=1.188 $Y=0.0675 $X2=1.2025 $Y2=0.0675
r3 12 4 0.179012 $w=8.1e-08 $l=1.45e-08 $layer=N_src_drn $thickness=1e-09
+ $X=1.1735 $Y=0.0675 $X2=1.188 $Y2=0.0675
r4 50 12 0.0308642 $w=8.1e-08 $l=2.5e-09 $layer=N_src_drn $thickness=1e-09
+ $X=1.1706 $Y=0.0675 $X2=1.1735 $Y2=0.0675
r5 47 45 0.0308642 $w=8.1e-08 $l=2.5e-09 $layer=N_src_drn $thickness=1e-09
+ $X=1.0973 $Y=0.0675 $X2=1.0945 $Y2=0.0675
r6 3 45 0.179012 $w=8.1e-08 $l=1.45e-08 $layer=N_src_drn $thickness=1e-09
+ $X=1.08 $Y=0.0675 $X2=1.0945 $Y2=0.0675
r7 11 3 0.179012 $w=8.1e-08 $l=1.45e-08 $layer=N_src_drn $thickness=1e-09
+ $X=1.0655 $Y=0.0675 $X2=1.08 $Y2=0.0675
r8 46 11 0.0308642 $w=8.1e-08 $l=2.5e-09 $layer=N_src_drn $thickness=1e-09
+ $X=1.0626 $Y=0.0675 $X2=1.0655 $Y2=0.0675
r9 4 41 19.3796 $a=3.24e-16 $layer=V0LISD $X=1.188 $Y=0.0675 $X2=1.188 $Y2=0.099
r10 3 39 19.3796 $a=3.24e-16 $layer=V0LISD $X=1.08 $Y=0.0675 $X2=1.08 $Y2=0.099
r11 17 41 3.14806 $w=1.3e-08 $l=1.35e-08 $layer=M1 $thickness=3.6e-08 $X=1.1745
+ $Y=0.099 $X2=1.188 $Y2=0.099
r12 39 40 5.24677 $w=1.3e-08 $l=2.25e-08 $layer=M1 $thickness=3.6e-08 $X=1.08
+ $Y=0.099 $X2=1.1025 $Y2=0.099
r13 15 40 7.34548 $w=1.3e-08 $l=3.15e-08 $layer=M1 $thickness=3.6e-08 $X=1.134
+ $Y=0.099 $X2=1.1025 $Y2=0.099
r14 13 16 3.01711 $w=1.55e-08 $l=1.8e-08 $layer=M1 $thickness=3.6e-08 $X=1.161
+ $Y=0.099 $X2=1.161 $Y2=0.117
r15 13 15 5.11582 $w=1.46667e-08 $l=2.7e-08 $layer=M1 $thickness=3.6e-08
+ $X=1.161 $Y=0.099 $X2=1.134 $Y2=0.099
r16 13 17 1.96775 $w=1.63333e-08 $l=1.35e-08 $layer=M1 $thickness=3.6e-08
+ $X=1.161 $Y=0.099 $X2=1.1745 $Y2=0.099
r17 14 18 1.49895 $w=1.63333e-08 $l=1.35e-08 $layer=M1 $thickness=3.6e-08
+ $X=1.161 $Y=0.135 $X2=1.1745 $Y2=0.135
r18 14 16 2.5483 $w=1.79e-08 $l=1.8e-08 $layer=M1 $thickness=3.6e-08 $X=1.161
+ $Y=0.135 $X2=1.161 $Y2=0.117
r19 36 35 16.4967 $w=2.1e-08 $l=4.85e-08 $layer=Gate_1 $thickness=5.6e-08
+ $X=1.215 $Y=0.2025 $X2=1.215 $Y2=0.154
r20 33 34 16.4967 $w=2.1e-08 $l=4.85e-08 $layer=Gate_1 $thickness=5.6e-08
+ $X=1.215 $Y=0.0675 $X2=1.215 $Y2=0.116
r21 10 27 6.54019 $w=2.09524e-08 $layer=Gate_1 $thickness=5.21905e-08 $X=1.215
+ $Y=0.135 $X2=1.215 $Y2=0.135
r22 10 34 6.6497 $w=2.04211e-08 $l=1.9e-08 $layer=Gate_1 $thickness=5.6e-08
+ $X=1.215 $Y=0.135 $X2=1.215 $Y2=0.116
r23 10 35 6.6497 $w=2.04211e-08 $l=1.9e-08 $layer=Gate_1 $thickness=5.6e-08
+ $X=1.215 $Y=0.135 $X2=1.215 $Y2=0.154
r24 18 29 3.14806 $w=1.3e-08 $l=1.35e-08 $layer=M1 $thickness=3.6e-08 $X=1.1745
+ $Y=0.135 $X2=1.188 $Y2=0.135
r25 26 27 12.6539 $w=1.77815e-08 $l=2.7e-08 $layer=LIG $thickness=4.8e-08
+ $X=1.188 $Y=0.135 $X2=1.215 $Y2=0.135
r26 26 29 19.3796 $a=3.24e-16 $layer=V0LIG $X=1.188 $Y=0.135 $X2=1.188 $Y2=0.135
r27 1 21 6.54019 $w=2.09524e-08 $layer=Gate_1 $thickness=5.21905e-08 $X=1.161
+ $Y=0.135 $X2=1.161 $Y2=0.135
r28 1 26 12.6539 $w=1.77815e-08 $l=2.7e-08 $layer=LIG $thickness=4.8e-08
+ $X=1.161 $Y=0.135 $X2=1.188 $Y2=0.135
r29 23 22 16.4967 $w=2.1e-08 $l=4.85e-08 $layer=Gate_1 $thickness=5.6e-08
+ $X=1.161 $Y=0.2025 $X2=1.161 $Y2=0.154
r30 21 22 6.6497 $w=2.04211e-08 $l=1.9e-08 $layer=Gate_1 $thickness=5.6e-08
+ $X=1.161 $Y=0.135 $X2=1.161 $Y2=0.154
r31 20 21 6.6497 $w=2.04211e-08 $l=1.9e-08 $layer=Gate_1 $thickness=5.6e-08
+ $X=1.161 $Y=0.116 $X2=1.161 $Y2=0.135
r32 19 20 16.4967 $w=2.1e-08 $l=4.85e-08 $layer=Gate_1 $thickness=5.6e-08
+ $X=1.161 $Y=0.0675 $X2=1.161 $Y2=0.116
r33 19 9 14.6259 $w=2.1e-08 $l=4.3e-08 $layer=Gate_1 $thickness=5.6e-08
+ $X=1.161 $Y=0.0675 $X2=1.161 $Y2=0.0245
.ends

.subckt PM_CKINVDCx11_ASAP7_75t_R%A vss 67 42 48 60 63 116 119 122 125 128 131
+ 134 137 163 166 169 172 175 178 181 184 194 197 201 205 1 32 12 34 2 13 35 16
+ 3 17 29 4 20 39 21 27 25 26 11 18 19 22 15 28 23 30 24 14 31 41 38 36 33 40 37
c1 1 vss 0.0106637f $X=0.0765 $Y=0.135
c2 2 vss 0.0152896f $X=0.427 $Y=0.135
c3 3 vss 0.0155173f $X=0.8595 $Y=0.135
c4 4 vss 0.0106637f $X=1.2915 $Y=0.135
c5 11 vss 0.103471f $X=0.081 $Y=0.0245
c6 12 vss 0.0821398f $X=0.135 $Y=0.135
c7 13 vss 0.0853828f $X=0.405 $Y=0.135
c8 14 vss 0.0622305f $X=0.459 $Y=0.135
c9 15 vss 0.0661056f $X=0.513 $Y=0.135
c10 16 vss 0.0836285f $X=0.567 $Y=0.135
c11 17 vss 0.0812243f $X=0.837 $Y=0.135
c12 18 vss 0.0812844f $X=0.891 $Y=0.135
c13 19 vss 0.0812844f $X=0.945 $Y=0.135
c14 20 vss 0.0812243f $X=0.999 $Y=0.135
c15 21 vss 0.0821398f $X=1.269 $Y=0.135
c16 22 vss 0.103471f $X=1.323 $Y=0.135
c17 23 vss 0.00548688f $X=0.059 $Y=0.036
c18 24 vss 0.00980324f $X=0.075 $Y=0.135
c19 25 vss 0.0023441f $X=0.485 $Y=0.036
c20 26 vss 0.000320163f $X=0.485 $Y=0.135
c21 27 vss 0.00234492f $X=0.918 $Y=0.036
c22 28 vss 0.000314855f $X=0.918 $Y=0.135
c23 29 vss 0.00980637f $X=1.345 $Y=0.135
c24 30 vss 0.0054865f $X=1.345 $Y=0.036
c25 31 vss 0.0141959f $X=0.059 $Y=0.1035
c26 32 vss 0.0607459f $X=0.081 $Y=0.036
c27 33 vss 0.00247845f $X=0.4515 $Y=0.135
c28 34 vss 0.00441705f $X=0.485 $Y=0.054
c29 35 vss 0.0609236f $X=0.51 $Y=0.036
c30 36 vss 0.00262712f $X=0.5035 $Y=0.135
c31 37 vss 0.00208206f $X=0.884 $Y=0.135
c32 38 vss 0.00393927f $X=0.918 $Y=0.054
c33 39 vss 0.0611314f $X=0.9425 $Y=0.036
c34 40 vss 0.00253009f $X=0.9365 $Y=0.135
c35 41 vss 0.0141891f $X=1.345 $Y=0.054
r1 205 204 14.6259 $w=2.1e-08 $l=4.3e-08 $layer=Gate_1 $thickness=5.6e-08
+ $X=1.323 $Y=0.2025 $X2=1.323 $Y2=0.1595
r2 203 204 2.89117 $w=2.1e-08 $l=8.5e-09 $layer=Gate_1 $thickness=5.6e-08
+ $X=1.323 $Y=0.151 $X2=1.323 $Y2=0.1595
r3 201 202 14.6259 $w=2.1e-08 $l=4.3e-08 $layer=Gate_1 $thickness=5.6e-08
+ $X=1.323 $Y=0.0675 $X2=1.323 $Y2=0.1105
r4 199 202 2.89117 $w=2.1e-08 $l=8.5e-09 $layer=Gate_1 $thickness=5.6e-08
+ $X=1.323 $Y=0.119 $X2=1.323 $Y2=0.1105
r5 22 191 3.57145 $w=2e-08 $layer=Gate_1 $thickness=5.6e-08 $X=1.323 $Y=0.135
+ $X2=1.323 $Y2=0.135
r6 22 199 5.61228 $w=2.0375e-08 $l=1.6e-08 $layer=Gate_1 $thickness=5.6e-08
+ $X=1.323 $Y=0.135 $X2=1.323 $Y2=0.119
r7 22 203 5.61228 $w=2.0375e-08 $l=1.6e-08 $layer=Gate_1 $thickness=5.6e-08
+ $X=1.323 $Y=0.135 $X2=1.323 $Y2=0.151
r8 197 196 16.6668 $w=2.1e-08 $l=4.9e-08 $layer=Gate_1 $thickness=5.6e-08
+ $X=1.269 $Y=0.2025 $X2=1.269 $Y2=0.1535
r9 194 195 16.6668 $w=2.1e-08 $l=4.9e-08 $layer=Gate_1 $thickness=5.6e-08
+ $X=1.269 $Y=0.0675 $X2=1.269 $Y2=0.1165
r10 21 187 6.74717 $w=2e-08 $layer=Gate_1 $thickness=5.2e-08 $X=1.269 $Y=0.135
+ $X2=1.269 $Y2=0.135
r11 21 195 6.46262 $w=2.04595e-08 $l=1.85e-08 $layer=Gate_1 $thickness=5.6e-08
+ $X=1.269 $Y=0.135 $X2=1.269 $Y2=0.1165
r12 21 196 6.46262 $w=2.04595e-08 $l=1.85e-08 $layer=Gate_1 $thickness=5.6e-08
+ $X=1.269 $Y=0.135 $X2=1.269 $Y2=0.1535
r13 190 191 1.74665 $w=2e-08 $l=4.5e-09 $layer=LIG $thickness=4.8e-08 $X=1.3275
+ $Y=0.135 $X2=1.323 $Y2=0.135
r14 189 190 3.17572 $w=2e-08 $l=1e-08 $layer=LIG $thickness=4.8e-08 $X=1.3175
+ $Y=0.135 $X2=1.3275 $Y2=0.135
r15 186 189 5.91273 $w=1.665e-08 $l=9e-09 $layer=LIG $thickness=4.8e-08
+ $X=1.3085 $Y=0.135 $X2=1.3175 $Y2=0.135
r16 4 186 16.9382 $w=1.33e-08 $l=1.7e-08 $layer=LIG $thickness=4.8e-08
+ $X=1.2915 $Y=0.135 $X2=1.3085 $Y2=0.135
r17 4 187 15.6303 $w=1.62778e-08 $l=2.25e-08 $layer=LIG $thickness=4.8e-08
+ $X=1.2915 $Y=0.135 $X2=1.269 $Y2=0.135
r18 184 183 16.6668 $w=2.1e-08 $l=4.9e-08 $layer=Gate_1 $thickness=5.6e-08
+ $X=0.999 $Y=0.2025 $X2=0.999 $Y2=0.1535
r19 181 182 16.6668 $w=2.1e-08 $l=4.9e-08 $layer=Gate_1 $thickness=5.6e-08
+ $X=0.999 $Y=0.0675 $X2=0.999 $Y2=0.1165
r20 20 157 6.74717 $w=2e-08 $layer=Gate_1 $thickness=5.2e-08 $X=0.999 $Y=0.135
+ $X2=0.999 $Y2=0.135
r21 20 182 6.46262 $w=2.04595e-08 $l=1.85e-08 $layer=Gate_1 $thickness=5.6e-08
+ $X=0.999 $Y=0.135 $X2=0.999 $Y2=0.1165
r22 20 183 6.46262 $w=2.04595e-08 $l=1.85e-08 $layer=Gate_1 $thickness=5.6e-08
+ $X=0.999 $Y=0.135 $X2=0.999 $Y2=0.1535
r23 178 177 16.6668 $w=2.1e-08 $l=4.9e-08 $layer=Gate_1 $thickness=5.6e-08
+ $X=0.945 $Y=0.2025 $X2=0.945 $Y2=0.1535
r24 175 176 16.6668 $w=2.1e-08 $l=4.9e-08 $layer=Gate_1 $thickness=5.6e-08
+ $X=0.945 $Y=0.0675 $X2=0.945 $Y2=0.1165
r25 19 154 3.57145 $w=2e-08 $layer=Gate_1 $thickness=5.6e-08 $X=0.945 $Y=0.135
+ $X2=0.945 $Y2=0.135
r26 19 176 6.46262 $w=2.04595e-08 $l=1.85e-08 $layer=Gate_1 $thickness=5.6e-08
+ $X=0.945 $Y=0.135 $X2=0.945 $Y2=0.1165
r27 19 177 6.46262 $w=2.04595e-08 $l=1.85e-08 $layer=Gate_1 $thickness=5.6e-08
+ $X=0.945 $Y=0.135 $X2=0.945 $Y2=0.1535
r28 172 171 16.6668 $w=2.1e-08 $l=4.9e-08 $layer=Gate_1 $thickness=5.6e-08
+ $X=0.891 $Y=0.2025 $X2=0.891 $Y2=0.1535
r29 169 170 16.6668 $w=2.1e-08 $l=4.9e-08 $layer=Gate_1 $thickness=5.6e-08
+ $X=0.891 $Y=0.0675 $X2=0.891 $Y2=0.1165
r30 18 150 3.57145 $w=2e-08 $layer=Gate_1 $thickness=5.6e-08 $X=0.891 $Y=0.135
+ $X2=0.891 $Y2=0.135
r31 18 170 6.46262 $w=2.04595e-08 $l=1.85e-08 $layer=Gate_1 $thickness=5.6e-08
+ $X=0.891 $Y=0.135 $X2=0.891 $Y2=0.1165
r32 18 171 6.46262 $w=2.04595e-08 $l=1.85e-08 $layer=Gate_1 $thickness=5.6e-08
+ $X=0.891 $Y=0.135 $X2=0.891 $Y2=0.1535
r33 166 165 16.6668 $w=2.1e-08 $l=4.9e-08 $layer=Gate_1 $thickness=5.6e-08
+ $X=0.837 $Y=0.2025 $X2=0.837 $Y2=0.1535
r34 163 164 16.6668 $w=2.1e-08 $l=4.9e-08 $layer=Gate_1 $thickness=5.6e-08
+ $X=0.837 $Y=0.0675 $X2=0.837 $Y2=0.1165
r35 17 146 6.74717 $w=2e-08 $layer=Gate_1 $thickness=5.2e-08 $X=0.837 $Y=0.135
+ $X2=0.837 $Y2=0.135
r36 17 164 6.46262 $w=2.04595e-08 $l=1.85e-08 $layer=Gate_1 $thickness=5.6e-08
+ $X=0.837 $Y=0.135 $X2=0.837 $Y2=0.1165
r37 17 165 6.46262 $w=2.04595e-08 $l=1.85e-08 $layer=Gate_1 $thickness=5.6e-08
+ $X=0.837 $Y=0.135 $X2=0.837 $Y2=0.1535
r38 159 160 3.03147 $w=1.3e-08 $l=1.3e-08 $layer=M1 $thickness=3.6e-08 $X=1.316
+ $Y=0.135 $X2=1.329 $Y2=0.135
r39 159 186 19.3796 $a=3.24e-16 $layer=V0LIG $X=1.316 $Y=0.135 $X2=1.3085
+ $Y2=0.135
r40 29 144 6.16517 $w=1.44286e-08 $l=3.15e-08 $layer=M1 $thickness=3.6e-08
+ $X=1.345 $Y=0.135 $X2=1.345 $Y2=0.1035
r41 29 160 2.55073 $w=1.58125e-08 $l=1.6e-08 $layer=M1 $thickness=3.6e-08
+ $X=1.345 $Y=0.135 $X2=1.329 $Y2=0.135
r42 156 157 15.6303 $w=1.62778e-08 $l=2.25e-08 $layer=LIG $thickness=4.8e-08
+ $X=0.9765 $Y=0.135 $X2=0.999 $Y2=0.135
r43 155 156 16.9382 $w=1.33e-08 $l=1.7e-08 $layer=LIG $thickness=4.8e-08
+ $X=0.9595 $Y=0.135 $X2=0.9765 $Y2=0.135
r44 153 155 5.91273 $w=1.665e-08 $l=9e-09 $layer=LIG $thickness=4.8e-08
+ $X=0.9505 $Y=0.135 $X2=0.9595 $Y2=0.135
r45 152 153 3.17572 $w=2e-08 $l=1e-08 $layer=LIG $thickness=4.8e-08 $X=0.9405
+ $Y=0.135 $X2=0.9505 $Y2=0.135
r46 152 154 1.74665 $w=2e-08 $l=4.5e-09 $layer=LIG $thickness=4.8e-08 $X=0.9405
+ $Y=0.135 $X2=0.945 $Y2=0.135
r47 151 152 18.6849 $w=1.49378e-08 $l=2.25e-08 $layer=LIG $thickness=4.8e-08
+ $X=0.918 $Y=0.135 $X2=0.9405 $Y2=0.135
r48 149 150 1.74665 $w=2e-08 $l=4.5e-09 $layer=LIG $thickness=4.8e-08 $X=0.8955
+ $Y=0.135 $X2=0.891 $Y2=0.135
r49 149 151 18.6849 $w=1.49378e-08 $l=2.25e-08 $layer=LIG $thickness=4.8e-08
+ $X=0.8955 $Y=0.135 $X2=0.918 $Y2=0.135
r50 148 149 3.17572 $w=2e-08 $l=1e-08 $layer=LIG $thickness=4.8e-08 $X=0.8855
+ $Y=0.135 $X2=0.8955 $Y2=0.135
r51 145 148 5.91273 $w=1.665e-08 $l=9e-09 $layer=LIG $thickness=4.8e-08
+ $X=0.8765 $Y=0.135 $X2=0.8855 $Y2=0.135
r52 3 145 16.9382 $w=1.33e-08 $l=1.7e-08 $layer=LIG $thickness=4.8e-08
+ $X=0.8595 $Y=0.135 $X2=0.8765 $Y2=0.135
r53 3 146 15.6303 $w=1.62778e-08 $l=2.25e-08 $layer=LIG $thickness=4.8e-08
+ $X=0.8595 $Y=0.135 $X2=0.837 $Y2=0.135
r54 143 144 7.34548 $w=1.3e-08 $l=3.15e-08 $layer=M1 $thickness=3.6e-08
+ $X=1.345 $Y=0.072 $X2=1.345 $Y2=0.1035
r55 41 143 4.19742 $w=1.3e-08 $l=1.8e-08 $layer=M1 $thickness=3.6e-08 $X=1.345
+ $Y=0.054 $X2=1.345 $Y2=0.072
r56 141 153 19.3796 $a=3.24e-16 $layer=V0LIG $X=0.952 $Y=0.135 $X2=0.9505
+ $Y2=0.135
r57 40 141 3.61444 $w=1.3e-08 $l=1.55e-08 $layer=M1 $thickness=3.6e-08
+ $X=0.9365 $Y=0.135 $X2=0.952 $Y2=0.135
r58 37 139 3.61444 $w=1.3e-08 $l=1.55e-08 $layer=M1 $thickness=3.6e-08 $X=0.884
+ $Y=0.135 $X2=0.8995 $Y2=0.135
r59 37 145 19.3796 $a=3.24e-16 $layer=V0LIG $X=0.884 $Y=0.135 $X2=0.8765
+ $Y2=0.135
r60 137 136 16.6668 $w=2.1e-08 $l=4.9e-08 $layer=Gate_1 $thickness=5.6e-08
+ $X=0.567 $Y=0.2025 $X2=0.567 $Y2=0.1535
r61 134 135 16.6668 $w=2.1e-08 $l=4.9e-08 $layer=Gate_1 $thickness=5.6e-08
+ $X=0.567 $Y=0.0675 $X2=0.567 $Y2=0.1165
r62 16 113 6.74717 $w=2e-08 $layer=Gate_1 $thickness=5.2e-08 $X=0.567 $Y=0.135
+ $X2=0.567 $Y2=0.135
r63 16 135 6.46262 $w=2.04595e-08 $l=1.85e-08 $layer=Gate_1 $thickness=5.6e-08
+ $X=0.567 $Y=0.135 $X2=0.567 $Y2=0.1165
r64 16 136 6.46262 $w=2.04595e-08 $l=1.85e-08 $layer=Gate_1 $thickness=5.6e-08
+ $X=0.567 $Y=0.135 $X2=0.567 $Y2=0.1535
r65 131 130 16.6668 $w=2.1e-08 $l=4.9e-08 $layer=Gate_1 $thickness=5.6e-08
+ $X=0.513 $Y=0.216 $X2=0.513 $Y2=0.167
r66 128 129 16.6668 $w=2.1e-08 $l=4.9e-08 $layer=Gate_1 $thickness=5.6e-08
+ $X=0.513 $Y=0.054 $X2=0.513 $Y2=0.103
r67 15 110 3.57145 $w=2e-08 $layer=Gate_1 $thickness=5.6e-08 $X=0.513 $Y=0.135
+ $X2=0.513 $Y2=0.135
r68 15 129 11.0545 $w=2.06875e-08 $l=3.2e-08 $layer=Gate_1 $thickness=5.6e-08
+ $X=0.513 $Y=0.135 $X2=0.513 $Y2=0.103
r69 15 130 11.0545 $w=2.06875e-08 $l=3.2e-08 $layer=Gate_1 $thickness=5.6e-08
+ $X=0.513 $Y=0.135 $X2=0.513 $Y2=0.167
r70 125 124 16.6668 $w=2.1e-08 $l=4.9e-08 $layer=Gate_1 $thickness=5.6e-08
+ $X=0.459 $Y=0.216 $X2=0.459 $Y2=0.167
r71 122 123 16.6668 $w=2.1e-08 $l=4.9e-08 $layer=Gate_1 $thickness=5.6e-08
+ $X=0.459 $Y=0.054 $X2=0.459 $Y2=0.103
r72 14 106 3.57145 $w=2e-08 $layer=Gate_1 $thickness=5.6e-08 $X=0.459 $Y=0.135
+ $X2=0.459 $Y2=0.135
r73 14 123 11.0545 $w=2.06875e-08 $l=3.2e-08 $layer=Gate_1 $thickness=5.6e-08
+ $X=0.459 $Y=0.135 $X2=0.459 $Y2=0.103
r74 14 124 11.0545 $w=2.06875e-08 $l=3.2e-08 $layer=Gate_1 $thickness=5.6e-08
+ $X=0.459 $Y=0.135 $X2=0.459 $Y2=0.167
r75 119 118 16.6668 $w=2.1e-08 $l=4.9e-08 $layer=Gate_1 $thickness=5.6e-08
+ $X=0.405 $Y=0.216 $X2=0.405 $Y2=0.167
r76 116 117 16.6668 $w=2.1e-08 $l=4.9e-08 $layer=Gate_1 $thickness=5.6e-08
+ $X=0.405 $Y=0.054 $X2=0.405 $Y2=0.103
r77 13 102 6.74717 $w=2e-08 $layer=Gate_1 $thickness=5.2e-08 $X=0.405 $Y=0.135
+ $X2=0.405 $Y2=0.135
r78 13 117 11.0545 $w=2.06875e-08 $l=3.2e-08 $layer=Gate_1 $thickness=5.6e-08
+ $X=0.405 $Y=0.135 $X2=0.405 $Y2=0.103
r79 13 118 11.0545 $w=2.06875e-08 $l=3.2e-08 $layer=Gate_1 $thickness=5.6e-08
+ $X=0.405 $Y=0.135 $X2=0.405 $Y2=0.167
r80 30 100 3.48106 $w=1.50455e-08 $l=2.2e-08 $layer=M1 $thickness=3.6e-08
+ $X=1.345 $Y=0.036 $X2=1.323 $Y2=0.036
r81 30 41 2.5483 $w=1.79e-08 $l=1.8e-08 $layer=M1 $thickness=3.6e-08 $X=1.345
+ $Y=0.036 $X2=1.345 $Y2=0.054
r82 28 92 6.16517 $w=1.44286e-08 $l=3.15e-08 $layer=M1 $thickness=3.6e-08
+ $X=0.918 $Y=0.135 $X2=0.918 $Y2=0.1035
r83 28 139 3.1337 $w=1.54324e-08 $l=1.85e-08 $layer=M1 $thickness=3.6e-08
+ $X=0.918 $Y=0.135 $X2=0.8995 $Y2=0.135
r84 28 40 3.1337 $w=1.54324e-08 $l=1.85e-08 $layer=M1 $thickness=3.6e-08
+ $X=0.918 $Y=0.135 $X2=0.9365 $Y2=0.135
r85 112 113 16.1285 $w=1.6213e-08 $l=2.3e-08 $layer=LIG $thickness=4.8e-08
+ $X=0.544 $Y=0.135 $X2=0.567 $Y2=0.135
r86 111 112 16.9382 $w=1.33e-08 $l=1.7e-08 $layer=LIG $thickness=4.8e-08
+ $X=0.527 $Y=0.135 $X2=0.544 $Y2=0.135
r87 109 110 1.58786 $w=2e-08 $l=5e-09 $layer=LIG $thickness=4.8e-08 $X=0.518
+ $Y=0.135 $X2=0.513 $Y2=0.135
r88 109 111 5.57333 $w=1.70222e-08 $l=9e-09 $layer=LIG $thickness=4.8e-08
+ $X=0.518 $Y=0.135 $X2=0.527 $Y2=0.135
r89 108 109 3.17572 $w=2e-08 $l=1e-08 $layer=LIG $thickness=4.8e-08 $X=0.508
+ $Y=0.135 $X2=0.518 $Y2=0.135
r90 107 108 18.5261 $w=1.48227e-08 $l=2.2e-08 $layer=LIG $thickness=4.8e-08
+ $X=0.486 $Y=0.135 $X2=0.508 $Y2=0.135
r91 105 106 1.90543 $w=2e-08 $l=4e-09 $layer=LIG $thickness=4.8e-08 $X=0.463
+ $Y=0.135 $X2=0.459 $Y2=0.135
r92 105 107 18.8437 $w=1.50478e-08 $l=2.3e-08 $layer=LIG $thickness=4.8e-08
+ $X=0.463 $Y=0.135 $X2=0.486 $Y2=0.135
r93 104 105 3.17572 $w=2e-08 $l=1e-08 $layer=LIG $thickness=4.8e-08 $X=0.453
+ $Y=0.135 $X2=0.463 $Y2=0.135
r94 101 104 6.25213 $w=1.62778e-08 $l=9e-09 $layer=LIG $thickness=4.8e-08
+ $X=0.444 $Y=0.135 $X2=0.453 $Y2=0.135
r95 2 101 16.9382 $w=1.33e-08 $l=1.7e-08 $layer=LIG $thickness=4.8e-08 $X=0.427
+ $Y=0.135 $X2=0.444 $Y2=0.135
r96 2 102 15.1321 $w=1.63455e-08 $l=2.2e-08 $layer=LIG $thickness=4.8e-08
+ $X=0.427 $Y=0.135 $X2=0.405 $Y2=0.135
r97 99 100 8.86121 $w=1.3e-08 $l=3.8e-08 $layer=M1 $thickness=3.6e-08 $X=1.285
+ $Y=0.036 $X2=1.323 $Y2=0.036
r98 98 99 10.7267 $w=1.3e-08 $l=4.6e-08 $layer=M1 $thickness=3.6e-08 $X=1.239
+ $Y=0.036 $X2=1.285 $Y2=0.036
r99 97 98 22.6194 $w=1.3e-08 $l=9.7e-08 $layer=M1 $thickness=3.6e-08 $X=1.142
+ $Y=0.036 $X2=1.239 $Y2=0.036
r100 96 97 18.6552 $w=1.3e-08 $l=8e-08 $layer=M1 $thickness=3.6e-08 $X=1.062
+ $Y=0.036 $X2=1.142 $Y2=0.036
r101 95 96 2.2153 $w=1.3e-08 $l=9.5e-09 $layer=M1 $thickness=3.6e-08 $X=1.0525
+ $Y=0.036 $X2=1.062 $Y2=0.036
r102 94 95 5.82974 $w=1.3e-08 $l=2.5e-08 $layer=M1 $thickness=3.6e-08 $X=1.0275
+ $Y=0.036 $X2=1.0525 $Y2=0.036
r103 93 94 10.3769 $w=1.3e-08 $l=4.45e-08 $layer=M1 $thickness=3.6e-08 $X=0.983
+ $Y=0.036 $X2=1.0275 $Y2=0.036
r104 39 93 9.44419 $w=1.3e-08 $l=4.05e-08 $layer=M1 $thickness=3.6e-08
+ $X=0.9425 $Y=0.036 $X2=0.983 $Y2=0.036
r105 91 92 7.34548 $w=1.3e-08 $l=3.15e-08 $layer=M1 $thickness=3.6e-08 $X=0.918
+ $Y=0.072 $X2=0.918 $Y2=0.1035
r106 38 91 4.19742 $w=1.3e-08 $l=1.8e-08 $layer=M1 $thickness=3.6e-08 $X=0.918
+ $Y=0.054 $X2=0.918 $Y2=0.072
r107 89 109 19.3796 $a=3.24e-16 $layer=V0LIG $X=0.5195 $Y=0.135 $X2=0.518
+ $Y2=0.135
r108 36 89 3.73104 $w=1.3e-08 $l=1.6e-08 $layer=M1 $thickness=3.6e-08 $X=0.5035
+ $Y=0.135 $X2=0.5195 $Y2=0.135
r109 33 87 3.49785 $w=1.3e-08 $l=1.5e-08 $layer=M1 $thickness=3.6e-08 $X=0.4515
+ $Y=0.135 $X2=0.4665 $Y2=0.135
r110 33 101 19.3796 $a=3.24e-16 $layer=V0LIG $X=0.4515 $Y=0.135 $X2=0.444
+ $Y2=0.135
r111 27 86 4.53284 $w=1.48367e-08 $l=2.45e-08 $layer=M1 $thickness=3.6e-08
+ $X=0.918 $Y=0.036 $X2=0.8935 $Y2=0.036
r112 27 38 3.01711 $w=1.55e-08 $l=1.8e-08 $layer=M1 $thickness=3.6e-08 $X=0.918
+ $Y=0.036 $X2=0.918 $Y2=0.054
r113 27 39 4.53284 $w=1.48367e-08 $l=2.45e-08 $layer=M1 $thickness=3.6e-08
+ $X=0.918 $Y=0.036 $X2=0.9425 $Y2=0.036
r114 26 78 6.16517 $w=1.44286e-08 $l=3.15e-08 $layer=M1 $thickness=3.6e-08
+ $X=0.485 $Y=0.135 $X2=0.485 $Y2=0.1035
r115 26 87 3.1337 $w=1.54324e-08 $l=1.85e-08 $layer=M1 $thickness=3.6e-08
+ $X=0.485 $Y=0.135 $X2=0.4665 $Y2=0.135
r116 26 36 3.1337 $w=1.54324e-08 $l=1.85e-08 $layer=M1 $thickness=3.6e-08
+ $X=0.485 $Y=0.135 $X2=0.5035 $Y2=0.135
r117 85 86 9.44419 $w=1.3e-08 $l=4.05e-08 $layer=M1 $thickness=3.6e-08 $X=0.853
+ $Y=0.036 $X2=0.8935 $Y2=0.036
r118 84 85 10.3769 $w=1.3e-08 $l=4.45e-08 $layer=M1 $thickness=3.6e-08
+ $X=0.8085 $Y=0.036 $X2=0.853 $Y2=0.036
r119 83 84 5.82974 $w=1.3e-08 $l=2.5e-08 $layer=M1 $thickness=3.6e-08 $X=0.7835
+ $Y=0.036 $X2=0.8085 $Y2=0.036
r120 82 83 2.2153 $w=1.3e-08 $l=9.5e-09 $layer=M1 $thickness=3.6e-08 $X=0.774
+ $Y=0.036 $X2=0.7835 $Y2=0.036
r121 81 82 18.6552 $w=1.3e-08 $l=8e-08 $layer=M1 $thickness=3.6e-08 $X=0.694
+ $Y=0.036 $X2=0.774 $Y2=0.036
r122 80 81 22.6194 $w=1.3e-08 $l=9.7e-08 $layer=M1 $thickness=3.6e-08 $X=0.597
+ $Y=0.036 $X2=0.694 $Y2=0.036
r123 79 80 10.7267 $w=1.3e-08 $l=4.6e-08 $layer=M1 $thickness=3.6e-08 $X=0.551
+ $Y=0.036 $X2=0.597 $Y2=0.036
r124 35 79 9.56078 $w=1.3e-08 $l=4.1e-08 $layer=M1 $thickness=3.6e-08 $X=0.51
+ $Y=0.036 $X2=0.551 $Y2=0.036
r125 77 78 7.34548 $w=1.3e-08 $l=3.15e-08 $layer=M1 $thickness=3.6e-08 $X=0.485
+ $Y=0.072 $X2=0.485 $Y2=0.1035
r126 34 77 4.19742 $w=1.3e-08 $l=1.8e-08 $layer=M1 $thickness=3.6e-08 $X=0.485
+ $Y=0.054 $X2=0.485 $Y2=0.072
r127 25 76 4.41625 $w=1.4875e-08 $l=2.4e-08 $layer=M1 $thickness=3.6e-08
+ $X=0.485 $Y=0.036 $X2=0.461 $Y2=0.036
r128 25 34 3.01711 $w=1.55e-08 $l=1.8e-08 $layer=M1 $thickness=3.6e-08 $X=0.485
+ $Y=0.036 $X2=0.485 $Y2=0.054
r129 25 35 4.64944 $w=1.48e-08 $l=2.5e-08 $layer=M1 $thickness=3.6e-08 $X=0.485
+ $Y=0.036 $X2=0.51 $Y2=0.036
r130 75 76 9.32759 $w=1.3e-08 $l=4e-08 $layer=M1 $thickness=3.6e-08 $X=0.421
+ $Y=0.036 $X2=0.461 $Y2=0.036
r131 74 75 10.3769 $w=1.3e-08 $l=4.45e-08 $layer=M1 $thickness=3.6e-08
+ $X=0.3765 $Y=0.036 $X2=0.421 $Y2=0.036
r132 73 74 5.82974 $w=1.3e-08 $l=2.5e-08 $layer=M1 $thickness=3.6e-08 $X=0.3515
+ $Y=0.036 $X2=0.3765 $Y2=0.036
r133 72 73 2.2153 $w=1.3e-08 $l=9.5e-09 $layer=M1 $thickness=3.6e-08 $X=0.342
+ $Y=0.036 $X2=0.3515 $Y2=0.036
r134 71 72 18.6552 $w=1.3e-08 $l=8e-08 $layer=M1 $thickness=3.6e-08 $X=0.262
+ $Y=0.036 $X2=0.342 $Y2=0.036
r135 70 71 22.6194 $w=1.3e-08 $l=9.7e-08 $layer=M1 $thickness=3.6e-08 $X=0.165
+ $Y=0.036 $X2=0.262 $Y2=0.036
r136 69 70 10.7267 $w=1.3e-08 $l=4.6e-08 $layer=M1 $thickness=3.6e-08 $X=0.119
+ $Y=0.036 $X2=0.165 $Y2=0.036
r137 32 69 8.86121 $w=1.3e-08 $l=3.8e-08 $layer=M1 $thickness=3.6e-08 $X=0.081
+ $Y=0.036 $X2=0.119 $Y2=0.036
r138 23 66 1.79044 $w=1.89797e-08 $l=1.47e-08 $layer=M1 $thickness=3.6e-08
+ $X=0.059 $Y=0.036 $X2=0.059 $Y2=0.0507
r139 23 32 3.48106 $w=1.50455e-08 $l=2.2e-08 $layer=M1 $thickness=3.6e-08
+ $X=0.059 $Y=0.036 $X2=0.081 $Y2=0.036
r140 67 68 0.757867 $w=1.3e-08 $l=3.2e-09 $layer=M1 $thickness=3.6e-08 $X=0.06
+ $Y=0.057 $X2=0.059 $Y2=0.0602
r141 67 66 1.45744 $w=1.3e-08 $l=6.3e-09 $layer=M1 $thickness=3.6e-08 $X=0.06
+ $Y=0.057 $X2=0.059 $Y2=0.0507
r142 65 68 2.73998 $w=1.3e-08 $l=1.18e-08 $layer=M1 $thickness=3.6e-08 $X=0.059
+ $Y=0.072 $X2=0.059 $Y2=0.0602
r143 31 57 6.16517 $w=1.44286e-08 $l=3.15e-08 $layer=M1 $thickness=3.6e-08
+ $X=0.059 $Y=0.1035 $X2=0.059 $Y2=0.135
r144 31 65 7.34548 $w=1.3e-08 $l=3.15e-08 $layer=M1 $thickness=3.6e-08 $X=0.059
+ $Y=0.1035 $X2=0.059 $Y2=0.072
r145 63 62 16.6668 $w=2.1e-08 $l=4.9e-08 $layer=Gate_1 $thickness=5.6e-08
+ $X=0.135 $Y=0.2025 $X2=0.135 $Y2=0.1535
r146 60 61 16.6668 $w=2.1e-08 $l=4.9e-08 $layer=Gate_1 $thickness=5.6e-08
+ $X=0.135 $Y=0.0675 $X2=0.135 $Y2=0.1165
r147 12 54 6.74717 $w=2e-08 $layer=Gate_1 $thickness=5.2e-08 $X=0.135 $Y=0.135
+ $X2=0.135 $Y2=0.135
r148 12 61 6.46262 $w=2.04595e-08 $l=1.85e-08 $layer=Gate_1 $thickness=5.6e-08
+ $X=0.135 $Y=0.135 $X2=0.135 $Y2=0.1165
r149 12 62 6.46262 $w=2.04595e-08 $l=1.85e-08 $layer=Gate_1 $thickness=5.6e-08
+ $X=0.135 $Y=0.135 $X2=0.135 $Y2=0.1535
r150 24 56 3.03147 $w=1.3e-08 $l=1.3e-08 $layer=M1 $thickness=3.6e-08 $X=0.075
+ $Y=0.135 $X2=0.088 $Y2=0.135
r151 24 57 2.55073 $w=1.58125e-08 $l=1.6e-08 $layer=M1 $thickness=3.6e-08
+ $X=0.075 $Y=0.135 $X2=0.059 $Y2=0.135
r152 53 54 15.6303 $w=1.62778e-08 $l=2.25e-08 $layer=LIG $thickness=4.8e-08
+ $X=0.1125 $Y=0.135 $X2=0.135 $Y2=0.135
r153 52 53 16.9382 $w=1.33e-08 $l=1.7e-08 $layer=LIG $thickness=4.8e-08
+ $X=0.0955 $Y=0.135 $X2=0.1125 $Y2=0.135
r154 50 52 5.91273 $w=1.665e-08 $l=9e-09 $layer=LIG $thickness=4.8e-08
+ $X=0.0865 $Y=0.135 $X2=0.0955 $Y2=0.135
r155 50 56 19.3796 $a=3.24e-16 $layer=V0LIG $X=0.0865 $Y=0.135 $X2=0.088
+ $Y2=0.135
r156 1 50 3.17572 $w=2e-08 $l=1e-08 $layer=LIG $thickness=4.8e-08 $X=0.0765
+ $Y=0.135 $X2=0.0865 $Y2=0.135
r157 1 45 5.3181 $w=2e-08 $l=4.5e-09 $layer=Gate_1 $thickness=5.31613e-08
+ $X=0.0765 $Y=0.135 $X2=0.081 $Y2=0.135
r158 48 47 14.6259 $w=2.1e-08 $l=4.3e-08 $layer=Gate_1 $thickness=5.6e-08
+ $X=0.081 $Y=0.2025 $X2=0.081 $Y2=0.1595
r159 46 47 2.89117 $w=2.1e-08 $l=8.5e-09 $layer=Gate_1 $thickness=5.6e-08
+ $X=0.081 $Y=0.151 $X2=0.081 $Y2=0.1595
r160 45 46 5.61228 $w=2.0375e-08 $l=1.6e-08 $layer=Gate_1 $thickness=5.6e-08
+ $X=0.081 $Y=0.135 $X2=0.081 $Y2=0.151
r161 45 50 5.00052 $w=2e-08 $l=5.5e-09 $layer=Gate_1 $thickness=5.35172e-08
+ $X=0.081 $Y=0.135 $X2=0.0865 $Y2=0.135
r162 44 45 5.61228 $w=2.0375e-08 $l=1.6e-08 $layer=Gate_1 $thickness=5.6e-08
+ $X=0.081 $Y=0.119 $X2=0.081 $Y2=0.135
r163 43 44 2.89117 $w=2.1e-08 $l=8.5e-09 $layer=Gate_1 $thickness=5.6e-08
+ $X=0.081 $Y=0.1105 $X2=0.081 $Y2=0.119
r164 42 43 14.6259 $w=2.1e-08 $l=4.3e-08 $layer=Gate_1 $thickness=5.6e-08
+ $X=0.081 $Y=0.0675 $X2=0.081 $Y2=0.1105
r165 42 11 14.6259 $w=2.1e-08 $l=4.3e-08 $layer=Gate_1 $thickness=5.6e-08
+ $X=0.081 $Y=0.0675 $X2=0.081 $Y2=0.0245
.ends

.subckt PM_CKINVDCx11_ASAP7_75t_R%Y vss 90 78 79 102 103 123 124 136 139 145
+ 146 163 166 176 177 190 191 194 195 212 213 220 221 224 225 49 57 2 8 10 12
+ 45 37 59 53 63 67 4 6 54 64 66 55 40 48 61 41 72 68 47 39 50 51 38 44 46 52
+ 42 43 7 9 5 3 1 11 65 75 69 73 71 70 74
c1 1 vss 0.00687508f $X=0.108 $Y=0.0675
c2 2 vss 0.00824232f $X=0.108 $Y=0.2025
c3 3 vss 0.00707919f $X=0.432 $Y=0.054
c4 4 vss 0.00835038f $X=0.432 $Y=0.1755
c5 5 vss 0.00667459f $X=0.54 $Y=0.0675
c6 6 vss 0.00789238f $X=0.54 $Y=0.2025
c7 7 vss 0.00670229f $X=0.864 $Y=0.0675
c8 8 vss 0.00791527f $X=0.864 $Y=0.2025
c9 9 vss 0.00670229f $X=0.972 $Y=0.0675
c10 10 vss 0.00791527f $X=0.972 $Y=0.2025
c11 11 vss 0.00687508f $X=1.296 $Y=0.0675
c12 12 vss 0.00824232f $X=1.296 $Y=0.2025
c13 37 vss 0.00373324f $X=0.5255 $Y=0.0725
c14 38 vss 0.00432561f $X=0.0935 $Y=0.0675
c15 39 vss 0.0034263f $X=0.4175 $Y=0.054
c16 40 vss 0.000112979f $X=0.5255 $Y=0.0455
c17 41 vss 0.000261421f $X=0.542 $Y=0.0945
c18 42 vss 0.00425378f $X=0.8495 $Y=0.0675
c19 43 vss 0.00425378f $X=0.9575 $Y=0.0675
c20 44 vss 0.00432561f $X=1.2815 $Y=0.0675
c21 45 vss 0.00373658f $X=0.5255 $Y=0.1975
c22 46 vss 0.00434827f $X=0.0935 $Y=0.2025
c23 47 vss 0.00340863f $X=0.4175 $Y=0.216
c24 48 vss 0.000110998f $X=0.5255 $Y=0.2245
c25 49 vss 0.000276588f $X=0.542 $Y=0.1755
c26 50 vss 0.00425859f $X=0.8495 $Y=0.2025
c27 51 vss 0.00425859f $X=0.9575 $Y=0.2025
c28 52 vss 0.00434827f $X=1.2815 $Y=0.2025
c29 53 vss 0.00103613f $X=0.0965 $Y=0.072
c30 54 vss 0.00535333f $X=0.135 $Y=0.234
c31 55 vss 0.00113898f $X=0.405 $Y=0.072
c32 56 vss 0.00199616f $X=0.405 $Y=0.234
c33 57 vss 0.00110793f $X=0.567 $Y=0.072
c34 58 vss 0.00210206f $X=0.567 $Y=0.234
c35 59 vss 0.00112459f $X=0.837 $Y=0.072
c36 60 vss 0.00199616f $X=0.837 $Y=0.234
c37 61 vss 0.00112459f $X=0.999 $Y=0.072
c38 62 vss 0.00199616f $X=0.999 $Y=0.234
c39 63 vss 0.00103613f $X=1.269 $Y=0.072
c40 64 vss 0.00535333f $X=1.269 $Y=0.234
c41 65 vss 0.00334216f $X=0.135 $Y=0.0855
c42 66 vss 0.0222928f $X=0.165 $Y=0.234
c43 67 vss 0.00299267f $X=0.405 $Y=0.2025
c44 68 vss 0.0119634f $X=0.4185 $Y=0.234
c45 69 vss 0.00300897f $X=0.567 $Y=0.2025
c46 70 vss 0.0223957f $X=0.597 $Y=0.234
c47 71 vss 0.00298619f $X=0.837 $Y=0.2025
c48 72 vss 0.0117946f $X=0.8505 $Y=0.234
c49 73 vss 0.00298619f $X=0.999 $Y=0.2025
c50 74 vss 0.0222931f $X=1.0275 $Y=0.234
c51 75 vss 0.00334216f $X=1.269 $Y=0.2025
r1 225 223 0.0308642 $w=8.1e-08 $l=2.5e-09 $layer=N_src_drn $thickness=1e-09
+ $X=1.3133 $Y=0.0675 $X2=1.3105 $Y2=0.0675
r2 11 223 0.179012 $w=8.1e-08 $l=1.45e-08 $layer=N_src_drn $thickness=1e-09
+ $X=1.296 $Y=0.0675 $X2=1.3105 $Y2=0.0675
r3 44 11 0.179012 $w=8.1e-08 $l=1.45e-08 $layer=N_src_drn $thickness=1e-09
+ $X=1.2815 $Y=0.0675 $X2=1.296 $Y2=0.0675
r4 224 44 0.0308642 $w=8.1e-08 $l=2.5e-09 $layer=N_src_drn $thickness=1e-09
+ $X=1.2786 $Y=0.0675 $X2=1.2815 $Y2=0.0675
r5 11 215 19.3796 $a=3.24e-16 $layer=V0LISD $X=1.296 $Y=0.0675 $X2=1.2955
+ $Y2=0.072
r6 221 219 0.0308642 $w=8.1e-08 $l=2.5e-09 $layer=P_src_drn $thickness=1e-09
+ $X=1.3133 $Y=0.2025 $X2=1.3105 $Y2=0.2025
r7 12 219 0.179012 $w=8.1e-08 $l=1.45e-08 $layer=P_src_drn $thickness=1e-09
+ $X=1.296 $Y=0.2025 $X2=1.3105 $Y2=0.2025
r8 52 12 0.179012 $w=8.1e-08 $l=1.45e-08 $layer=P_src_drn $thickness=1e-09
+ $X=1.2815 $Y=0.2025 $X2=1.296 $Y2=0.2025
r9 220 52 0.0308642 $w=8.1e-08 $l=2.5e-09 $layer=P_src_drn $thickness=1e-09
+ $X=1.2786 $Y=0.2025 $X2=1.2815 $Y2=0.2025
r10 214 215 3.03147 $w=1.3e-08 $l=1.3e-08 $layer=M1 $thickness=3.6e-08
+ $X=1.2825 $Y=0.072 $X2=1.2955 $Y2=0.072
r11 63 209 1.96775 $w=1.63333e-08 $l=1.35e-08 $layer=M1 $thickness=3.6e-08
+ $X=1.269 $Y=0.072 $X2=1.269 $Y2=0.0855
r12 63 214 1.96775 $w=1.63333e-08 $l=1.35e-08 $layer=M1 $thickness=3.6e-08
+ $X=1.269 $Y=0.072 $X2=1.2825 $Y2=0.072
r13 213 211 0.0308642 $w=8.1e-08 $l=2.5e-09 $layer=N_src_drn $thickness=1e-09
+ $X=0.9893 $Y=0.0675 $X2=0.9865 $Y2=0.0675
r14 9 211 0.179012 $w=8.1e-08 $l=1.45e-08 $layer=N_src_drn $thickness=1e-09
+ $X=0.972 $Y=0.0675 $X2=0.9865 $Y2=0.0675
r15 43 9 0.179012 $w=8.1e-08 $l=1.45e-08 $layer=N_src_drn $thickness=1e-09
+ $X=0.9575 $Y=0.0675 $X2=0.972 $Y2=0.0675
r16 212 43 0.0308642 $w=8.1e-08 $l=2.5e-09 $layer=N_src_drn $thickness=1e-09
+ $X=0.9546 $Y=0.0675 $X2=0.9575 $Y2=0.0675
r17 12 201 19.3796 $a=3.24e-16 $layer=V0LISD $X=1.296 $Y=0.2025 $X2=1.2955
+ $Y2=0.234
r18 208 209 3.14806 $w=1.3e-08 $l=1.35e-08 $layer=M1 $thickness=3.6e-08
+ $X=1.269 $Y=0.099 $X2=1.269 $Y2=0.0855
r19 207 208 4.19742 $w=1.3e-08 $l=1.8e-08 $layer=M1 $thickness=3.6e-08 $X=1.269
+ $Y=0.117 $X2=1.269 $Y2=0.099
r20 206 207 4.19742 $w=1.3e-08 $l=1.8e-08 $layer=M1 $thickness=3.6e-08 $X=1.269
+ $Y=0.135 $X2=1.269 $Y2=0.117
r21 205 206 4.19742 $w=1.3e-08 $l=1.8e-08 $layer=M1 $thickness=3.6e-08 $X=1.269
+ $Y=0.153 $X2=1.269 $Y2=0.135
r22 204 205 4.19742 $w=1.3e-08 $l=1.8e-08 $layer=M1 $thickness=3.6e-08 $X=1.269
+ $Y=0.171 $X2=1.269 $Y2=0.153
r23 75 204 7.34548 $w=1.3e-08 $l=3.15e-08 $layer=M1 $thickness=3.6e-08 $X=1.269
+ $Y=0.2025 $X2=1.269 $Y2=0.171
r24 9 196 19.3796 $a=3.24e-16 $layer=V0LISD $X=0.972 $Y=0.0675 $X2=0.9725
+ $Y2=0.072
r25 200 201 3.03147 $w=1.3e-08 $l=1.3e-08 $layer=M1 $thickness=3.6e-08
+ $X=1.2825 $Y=0.234 $X2=1.2955 $Y2=0.234
r26 64 187 5.81538 $w=1.45e-08 $l=3e-08 $layer=M1 $thickness=3.6e-08 $X=1.269
+ $Y=0.234 $X2=1.239 $Y2=0.234
r27 64 200 1.96775 $w=1.63333e-08 $l=1.35e-08 $layer=M1 $thickness=3.6e-08
+ $X=1.269 $Y=0.234 $X2=1.2825 $Y2=0.234
r28 64 75 6.16517 $w=1.44286e-08 $l=3.15e-08 $layer=M1 $thickness=3.6e-08
+ $X=1.269 $Y=0.234 $X2=1.269 $Y2=0.2025
r29 196 197 3.03147 $w=1.3e-08 $l=1.3e-08 $layer=M1 $thickness=3.6e-08
+ $X=0.9725 $Y=0.072 $X2=0.9855 $Y2=0.072
r30 61 183 1.96775 $w=1.63333e-08 $l=1.35e-08 $layer=M1 $thickness=3.6e-08
+ $X=0.999 $Y=0.072 $X2=0.999 $Y2=0.0855
r31 61 197 1.96775 $w=1.63333e-08 $l=1.35e-08 $layer=M1 $thickness=3.6e-08
+ $X=0.999 $Y=0.072 $X2=0.9855 $Y2=0.072
r32 195 193 0.0308642 $w=8.1e-08 $l=2.5e-09 $layer=N_src_drn $thickness=1e-09
+ $X=0.8813 $Y=0.0675 $X2=0.8785 $Y2=0.0675
r33 7 193 0.179012 $w=8.1e-08 $l=1.45e-08 $layer=N_src_drn $thickness=1e-09
+ $X=0.864 $Y=0.0675 $X2=0.8785 $Y2=0.0675
r34 42 7 0.179012 $w=8.1e-08 $l=1.45e-08 $layer=N_src_drn $thickness=1e-09
+ $X=0.8495 $Y=0.0675 $X2=0.864 $Y2=0.0675
r35 194 42 0.0308642 $w=8.1e-08 $l=2.5e-09 $layer=N_src_drn $thickness=1e-09
+ $X=0.8466 $Y=0.0675 $X2=0.8495 $Y2=0.0675
r36 191 189 0.0308642 $w=8.1e-08 $l=2.5e-09 $layer=P_src_drn $thickness=1e-09
+ $X=0.9893 $Y=0.2025 $X2=0.9865 $Y2=0.2025
r37 10 189 0.179012 $w=8.1e-08 $l=1.45e-08 $layer=P_src_drn $thickness=1e-09
+ $X=0.972 $Y=0.2025 $X2=0.9865 $Y2=0.2025
r38 51 10 0.179012 $w=8.1e-08 $l=1.45e-08 $layer=P_src_drn $thickness=1e-09
+ $X=0.9575 $Y=0.2025 $X2=0.972 $Y2=0.2025
r39 190 51 0.0308642 $w=8.1e-08 $l=2.5e-09 $layer=P_src_drn $thickness=1e-09
+ $X=0.9546 $Y=0.2025 $X2=0.9575 $Y2=0.2025
r40 186 187 6.06293 $w=1.3e-08 $l=2.6e-08 $layer=M1 $thickness=3.6e-08 $X=1.213
+ $Y=0.234 $X2=1.239 $Y2=0.234
r41 185 186 1.86552 $w=1.3e-08 $l=8e-09 $layer=M1 $thickness=3.6e-08 $X=1.205
+ $Y=0.234 $X2=1.213 $Y2=0.234
r42 184 185 18.7718 $w=1.3e-08 $l=8.05e-08 $layer=M1 $thickness=3.6e-08
+ $X=1.1245 $Y=0.234 $X2=1.205 $Y2=0.234
r43 74 184 22.6194 $w=1.3e-08 $l=9.7e-08 $layer=M1 $thickness=3.6e-08 $X=1.0275
+ $Y=0.234 $X2=1.1245 $Y2=0.234
r44 182 183 3.14806 $w=1.3e-08 $l=1.35e-08 $layer=M1 $thickness=3.6e-08
+ $X=0.999 $Y=0.099 $X2=0.999 $Y2=0.0855
r45 181 182 4.19742 $w=1.3e-08 $l=1.8e-08 $layer=M1 $thickness=3.6e-08 $X=0.999
+ $Y=0.117 $X2=0.999 $Y2=0.099
r46 180 181 4.19742 $w=1.3e-08 $l=1.8e-08 $layer=M1 $thickness=3.6e-08 $X=0.999
+ $Y=0.135 $X2=0.999 $Y2=0.117
r47 179 180 4.19742 $w=1.3e-08 $l=1.8e-08 $layer=M1 $thickness=3.6e-08 $X=0.999
+ $Y=0.153 $X2=0.999 $Y2=0.135
r48 178 179 4.19742 $w=1.3e-08 $l=1.8e-08 $layer=M1 $thickness=3.6e-08 $X=0.999
+ $Y=0.171 $X2=0.999 $Y2=0.153
r49 73 178 7.34548 $w=1.3e-08 $l=3.15e-08 $layer=M1 $thickness=3.6e-08 $X=0.999
+ $Y=0.2025 $X2=0.999 $Y2=0.171
r50 177 175 0.0308642 $w=8.1e-08 $l=2.5e-09 $layer=P_src_drn $thickness=1e-09
+ $X=0.8813 $Y=0.2025 $X2=0.8785 $Y2=0.2025
r51 8 175 0.179012 $w=8.1e-08 $l=1.45e-08 $layer=P_src_drn $thickness=1e-09
+ $X=0.864 $Y=0.2025 $X2=0.8785 $Y2=0.2025
r52 50 8 0.179012 $w=8.1e-08 $l=1.45e-08 $layer=P_src_drn $thickness=1e-09
+ $X=0.8495 $Y=0.2025 $X2=0.864 $Y2=0.2025
r53 176 50 0.0308642 $w=8.1e-08 $l=2.5e-09 $layer=P_src_drn $thickness=1e-09
+ $X=0.8466 $Y=0.2025 $X2=0.8495 $Y2=0.2025
r54 7 171 19.3796 $a=3.24e-16 $layer=V0LISD $X=0.864 $Y=0.0675 $X2=0.8635
+ $Y2=0.072
r55 10 160 19.3796 $a=3.24e-16 $layer=V0LISD $X=0.972 $Y=0.2025 $X2=0.9725
+ $Y2=0.234
r56 62 161 1.96775 $w=1.63333e-08 $l=1.35e-08 $layer=M1 $thickness=3.6e-08
+ $X=0.999 $Y=0.234 $X2=0.9855 $Y2=0.234
r57 62 73 6.16517 $w=1.44286e-08 $l=3.15e-08 $layer=M1 $thickness=3.6e-08
+ $X=0.999 $Y=0.234 $X2=0.999 $Y2=0.2025
r58 62 74 5.4656 $w=1.45789e-08 $l=2.85e-08 $layer=M1 $thickness=3.6e-08
+ $X=0.999 $Y=0.234 $X2=1.0275 $Y2=0.234
r59 8 156 19.3796 $a=3.24e-16 $layer=V0LISD $X=0.864 $Y=0.2025 $X2=0.8635
+ $Y2=0.234
r60 170 171 3.03147 $w=1.3e-08 $l=1.3e-08 $layer=M1 $thickness=3.6e-08
+ $X=0.8505 $Y=0.072 $X2=0.8635 $Y2=0.072
r61 59 155 1.96775 $w=1.63333e-08 $l=1.35e-08 $layer=M1 $thickness=3.6e-08
+ $X=0.837 $Y=0.072 $X2=0.837 $Y2=0.0855
r62 59 170 1.96775 $w=1.63333e-08 $l=1.35e-08 $layer=M1 $thickness=3.6e-08
+ $X=0.837 $Y=0.072 $X2=0.8505 $Y2=0.072
r63 41 5 0.958606 $w=2.2e-08 $l=2.2e-08 $layer=N_src_drn $thickness=1e-09
+ $X=0.542 $Y=0.0945 $X2=0.54 $Y2=0.0675
r64 40 5 0.391892 $w=3.7e-08 $l=1.45e-08 $layer=N_src_drn $thickness=1e-09
+ $X=0.5255 $Y=0.0455 $X2=0.54 $Y2=0.0675
r65 166 165 0.147059 $w=1.7e-08 $l=2.5e-09 $layer=N_src_drn $thickness=1e-09
+ $X=0.5573 $Y=0.0675 $X2=0.5545 $Y2=0.0725
r66 5 165 0.735294 $w=1.7e-08 $l=1.25e-08 $layer=N_src_drn $thickness=1e-09
+ $X=0.54 $Y=0.0675 $X2=0.5545 $Y2=0.0725
r67 162 5 0.705882 $w=1.7e-08 $l=1.2e-08 $layer=N_src_drn $thickness=1e-09
+ $X=0.53 $Y=0.0725 $X2=0.54 $Y2=0.0675
r68 37 162 0.264706 $w=1.7e-08 $l=4.5e-09 $layer=N_src_drn $thickness=1e-09
+ $X=0.5255 $Y=0.0725 $X2=0.53 $Y2=0.0725
r69 163 37 0.147059 $w=1.7e-08 $l=2.5e-09 $layer=N_src_drn $thickness=1e-09
+ $X=0.5226 $Y=0.054 $X2=0.5255 $Y2=0.0725
r70 160 161 3.03147 $w=1.3e-08 $l=1.3e-08 $layer=M1 $thickness=3.6e-08
+ $X=0.9725 $Y=0.234 $X2=0.9855 $Y2=0.234
r71 159 160 2.09871 $w=1.3e-08 $l=9e-09 $layer=M1 $thickness=3.6e-08 $X=0.9635
+ $Y=0.234 $X2=0.9725 $Y2=0.234
r72 158 159 10.6101 $w=1.3e-08 $l=4.55e-08 $layer=M1 $thickness=3.6e-08
+ $X=0.918 $Y=0.234 $X2=0.9635 $Y2=0.234
r73 157 158 10.6101 $w=1.3e-08 $l=4.55e-08 $layer=M1 $thickness=3.6e-08
+ $X=0.8725 $Y=0.234 $X2=0.918 $Y2=0.234
r74 156 157 2.09871 $w=1.3e-08 $l=9e-09 $layer=M1 $thickness=3.6e-08 $X=0.8635
+ $Y=0.234 $X2=0.8725 $Y2=0.234
r75 72 156 3.03147 $w=1.3e-08 $l=1.3e-08 $layer=M1 $thickness=3.6e-08 $X=0.8505
+ $Y=0.234 $X2=0.8635 $Y2=0.234
r76 154 155 3.14806 $w=1.3e-08 $l=1.35e-08 $layer=M1 $thickness=3.6e-08
+ $X=0.837 $Y=0.099 $X2=0.837 $Y2=0.0855
r77 153 154 4.19742 $w=1.3e-08 $l=1.8e-08 $layer=M1 $thickness=3.6e-08 $X=0.837
+ $Y=0.117 $X2=0.837 $Y2=0.099
r78 152 153 4.19742 $w=1.3e-08 $l=1.8e-08 $layer=M1 $thickness=3.6e-08 $X=0.837
+ $Y=0.135 $X2=0.837 $Y2=0.117
r79 151 152 4.19742 $w=1.3e-08 $l=1.8e-08 $layer=M1 $thickness=3.6e-08 $X=0.837
+ $Y=0.153 $X2=0.837 $Y2=0.135
r80 150 151 4.19742 $w=1.3e-08 $l=1.8e-08 $layer=M1 $thickness=3.6e-08 $X=0.837
+ $Y=0.171 $X2=0.837 $Y2=0.153
r81 71 150 7.34548 $w=1.3e-08 $l=3.15e-08 $layer=M1 $thickness=3.6e-08 $X=0.837
+ $Y=0.2025 $X2=0.837 $Y2=0.171
r82 5 147 19.3796 $a=3.24e-16 $layer=V0LISD $X=0.54 $Y=0.0675 $X2=0.54 $Y2=0.072
r83 60 134 5.4656 $w=1.45789e-08 $l=2.85e-08 $layer=M1 $thickness=3.6e-08
+ $X=0.837 $Y=0.234 $X2=0.8085 $Y2=0.234
r84 60 71 6.16517 $w=1.44286e-08 $l=3.15e-08 $layer=M1 $thickness=3.6e-08
+ $X=0.837 $Y=0.234 $X2=0.837 $Y2=0.2025
r85 60 72 1.96775 $w=1.63333e-08 $l=1.35e-08 $layer=M1 $thickness=3.6e-08
+ $X=0.837 $Y=0.234 $X2=0.8505 $Y2=0.234
r86 147 148 3.14806 $w=1.3e-08 $l=1.35e-08 $layer=M1 $thickness=3.6e-08 $X=0.54
+ $Y=0.072 $X2=0.5535 $Y2=0.072
r87 57 130 1.96775 $w=1.63333e-08 $l=1.35e-08 $layer=M1 $thickness=3.6e-08
+ $X=0.567 $Y=0.072 $X2=0.567 $Y2=0.0855
r88 57 148 1.96775 $w=1.63333e-08 $l=1.35e-08 $layer=M1 $thickness=3.6e-08
+ $X=0.567 $Y=0.072 $X2=0.5535 $Y2=0.072
r89 146 144 0.0462963 $w=5.4e-08 $l=2.5e-09 $layer=N_src_drn $thickness=1e-09
+ $X=0.4493 $Y=0.054 $X2=0.4465 $Y2=0.054
r90 3 144 0.268519 $w=5.4e-08 $l=1.45e-08 $layer=N_src_drn $thickness=1e-09
+ $X=0.432 $Y=0.054 $X2=0.4465 $Y2=0.054
r91 39 3 0.268519 $w=5.4e-08 $l=1.45e-08 $layer=N_src_drn $thickness=1e-09
+ $X=0.4175 $Y=0.054 $X2=0.432 $Y2=0.054
r92 145 39 0.0462963 $w=5.4e-08 $l=2.5e-09 $layer=N_src_drn $thickness=1e-09
+ $X=0.4146 $Y=0.054 $X2=0.4175 $Y2=0.054
r93 49 6 0.958606 $w=2.2e-08 $l=2.2e-08 $layer=P_src_drn $thickness=1e-09
+ $X=0.542 $Y=0.1755 $X2=0.54 $Y2=0.2025
r94 48 6 0.391892 $w=3.7e-08 $l=1.45e-08 $layer=P_src_drn $thickness=1e-09
+ $X=0.5255 $Y=0.2245 $X2=0.54 $Y2=0.2025
r95 139 138 0.147059 $w=1.7e-08 $l=2.5e-09 $layer=P_src_drn $thickness=1e-09
+ $X=0.5573 $Y=0.2025 $X2=0.5545 $Y2=0.1975
r96 6 138 0.735294 $w=1.7e-08 $l=1.25e-08 $layer=P_src_drn $thickness=1e-09
+ $X=0.54 $Y=0.2025 $X2=0.5545 $Y2=0.1975
r97 135 6 0.705882 $w=1.7e-08 $l=1.2e-08 $layer=P_src_drn $thickness=1e-09
+ $X=0.53 $Y=0.1975 $X2=0.54 $Y2=0.2025
r98 45 135 0.264706 $w=1.7e-08 $l=4.5e-09 $layer=P_src_drn $thickness=1e-09
+ $X=0.5255 $Y=0.1975 $X2=0.53 $Y2=0.1975
r99 136 45 0.147059 $w=1.7e-08 $l=2.5e-09 $layer=P_src_drn $thickness=1e-09
+ $X=0.5226 $Y=0.216 $X2=0.5255 $Y2=0.1975
r100 133 134 22.6194 $w=1.3e-08 $l=9.7e-08 $layer=M1 $thickness=3.6e-08
+ $X=0.7115 $Y=0.234 $X2=0.8085 $Y2=0.234
r101 132 133 18.7718 $w=1.3e-08 $l=8.05e-08 $layer=M1 $thickness=3.6e-08
+ $X=0.631 $Y=0.234 $X2=0.7115 $Y2=0.234
r102 131 132 1.86552 $w=1.3e-08 $l=8e-09 $layer=M1 $thickness=3.6e-08 $X=0.623
+ $Y=0.234 $X2=0.631 $Y2=0.234
r103 70 131 6.06293 $w=1.3e-08 $l=2.6e-08 $layer=M1 $thickness=3.6e-08 $X=0.597
+ $Y=0.234 $X2=0.623 $Y2=0.234
r104 129 130 3.14806 $w=1.3e-08 $l=1.35e-08 $layer=M1 $thickness=3.6e-08
+ $X=0.567 $Y=0.099 $X2=0.567 $Y2=0.0855
r105 128 129 4.19742 $w=1.3e-08 $l=1.8e-08 $layer=M1 $thickness=3.6e-08
+ $X=0.567 $Y=0.117 $X2=0.567 $Y2=0.099
r106 127 128 4.19742 $w=1.3e-08 $l=1.8e-08 $layer=M1 $thickness=3.6e-08
+ $X=0.567 $Y=0.135 $X2=0.567 $Y2=0.117
r107 126 127 4.19742 $w=1.3e-08 $l=1.8e-08 $layer=M1 $thickness=3.6e-08
+ $X=0.567 $Y=0.153 $X2=0.567 $Y2=0.135
r108 125 126 4.19742 $w=1.3e-08 $l=1.8e-08 $layer=M1 $thickness=3.6e-08
+ $X=0.567 $Y=0.171 $X2=0.567 $Y2=0.153
r109 69 125 7.34548 $w=1.3e-08 $l=3.15e-08 $layer=M1 $thickness=3.6e-08
+ $X=0.567 $Y=0.2025 $X2=0.567 $Y2=0.171
r110 124 122 0.0462963 $w=5.4e-08 $l=2.5e-09 $layer=P_src_drn $thickness=1e-09
+ $X=0.4493 $Y=0.216 $X2=0.4465 $Y2=0.216
r111 119 122 0.268519 $w=5.4e-08 $l=1.45e-08 $layer=P_src_drn $thickness=1e-09
+ $X=0.432 $Y=0.216 $X2=0.4465 $Y2=0.216
r112 47 119 0.268519 $w=5.4e-08 $l=1.45e-08 $layer=P_src_drn $thickness=1e-09
+ $X=0.4175 $Y=0.216 $X2=0.432 $Y2=0.216
r113 123 47 0.0462963 $w=5.4e-08 $l=2.5e-09 $layer=P_src_drn $thickness=1e-09
+ $X=0.4146 $Y=0.216 $X2=0.4175 $Y2=0.216
r114 3 116 19.3796 $a=3.24e-16 $layer=V0LISD $X=0.432 $Y=0.054 $X2=0.431
+ $Y2=0.072
r115 6 113 19.3796 $a=3.24e-16 $layer=V0LISD $X=0.54 $Y=0.2025 $X2=0.54
+ $Y2=0.234
r116 58 114 1.96775 $w=1.63333e-08 $l=1.35e-08 $layer=M1 $thickness=3.6e-08
+ $X=0.567 $Y=0.234 $X2=0.5535 $Y2=0.234
r117 58 69 6.16517 $w=1.44286e-08 $l=3.15e-08 $layer=M1 $thickness=3.6e-08
+ $X=0.567 $Y=0.234 $X2=0.567 $Y2=0.2025
r118 58 70 5.81538 $w=1.45e-08 $l=3e-08 $layer=M1 $thickness=3.6e-08 $X=0.567
+ $Y=0.234 $X2=0.597 $Y2=0.234
r119 4 119 23.8708 $w=2.02e-08 $l=4.05e-08 $layer=LISD $thickness=2.7e-08
+ $X=0.432 $Y=0.1755 $X2=0.432 $Y2=0.216
r120 115 116 2.91487 $w=1.3e-08 $l=1.25e-08 $layer=M1 $thickness=3.6e-08
+ $X=0.4185 $Y=0.072 $X2=0.431 $Y2=0.072
r121 55 109 1.96775 $w=1.63333e-08 $l=1.35e-08 $layer=M1 $thickness=3.6e-08
+ $X=0.405 $Y=0.072 $X2=0.405 $Y2=0.0855
r122 55 115 1.96775 $w=1.63333e-08 $l=1.35e-08 $layer=M1 $thickness=3.6e-08
+ $X=0.405 $Y=0.072 $X2=0.4185 $Y2=0.072
r123 113 114 3.14806 $w=1.3e-08 $l=1.35e-08 $layer=M1 $thickness=3.6e-08
+ $X=0.54 $Y=0.234 $X2=0.5535 $Y2=0.234
r124 112 113 12.5922 $w=1.3e-08 $l=5.4e-08 $layer=M1 $thickness=3.6e-08
+ $X=0.486 $Y=0.234 $X2=0.54 $Y2=0.234
r125 111 112 10.7267 $w=1.3e-08 $l=4.6e-08 $layer=M1 $thickness=3.6e-08 $X=0.44
+ $Y=0.234 $X2=0.486 $Y2=0.234
r126 110 111 2.09871 $w=1.3e-08 $l=9e-09 $layer=M1 $thickness=3.6e-08 $X=0.431
+ $Y=0.234 $X2=0.44 $Y2=0.234
r127 110 119 19.3796 $a=3.24e-16 $layer=V0LISD $X=0.431 $Y=0.234 $X2=0.432
+ $Y2=0.216
r128 68 110 2.91487 $w=1.3e-08 $l=1.25e-08 $layer=M1 $thickness=3.6e-08
+ $X=0.4185 $Y=0.234 $X2=0.431 $Y2=0.234
r129 108 109 3.14806 $w=1.3e-08 $l=1.35e-08 $layer=M1 $thickness=3.6e-08
+ $X=0.405 $Y=0.099 $X2=0.405 $Y2=0.0855
r130 107 108 4.19742 $w=1.3e-08 $l=1.8e-08 $layer=M1 $thickness=3.6e-08
+ $X=0.405 $Y=0.117 $X2=0.405 $Y2=0.099
r131 106 107 4.19742 $w=1.3e-08 $l=1.8e-08 $layer=M1 $thickness=3.6e-08
+ $X=0.405 $Y=0.135 $X2=0.405 $Y2=0.117
r132 105 106 4.19742 $w=1.3e-08 $l=1.8e-08 $layer=M1 $thickness=3.6e-08
+ $X=0.405 $Y=0.153 $X2=0.405 $Y2=0.135
r133 104 105 4.19742 $w=1.3e-08 $l=1.8e-08 $layer=M1 $thickness=3.6e-08
+ $X=0.405 $Y=0.171 $X2=0.405 $Y2=0.153
r134 67 104 7.34548 $w=1.3e-08 $l=3.15e-08 $layer=M1 $thickness=3.6e-08
+ $X=0.405 $Y=0.2025 $X2=0.405 $Y2=0.171
r135 103 101 0.0308642 $w=8.1e-08 $l=2.5e-09 $layer=P_src_drn $thickness=1e-09
+ $X=0.1253 $Y=0.2025 $X2=0.1225 $Y2=0.2025
r136 2 101 0.179012 $w=8.1e-08 $l=1.45e-08 $layer=P_src_drn $thickness=1e-09
+ $X=0.108 $Y=0.2025 $X2=0.1225 $Y2=0.2025
r137 46 2 0.179012 $w=8.1e-08 $l=1.45e-08 $layer=P_src_drn $thickness=1e-09
+ $X=0.0935 $Y=0.2025 $X2=0.108 $Y2=0.2025
r138 102 46 0.0308642 $w=8.1e-08 $l=2.5e-09 $layer=P_src_drn $thickness=1e-09
+ $X=0.0906 $Y=0.2025 $X2=0.0935 $Y2=0.2025
r139 56 99 5.4656 $w=1.45789e-08 $l=2.85e-08 $layer=M1 $thickness=3.6e-08
+ $X=0.405 $Y=0.234 $X2=0.3765 $Y2=0.234
r140 56 67 6.16517 $w=1.44286e-08 $l=3.15e-08 $layer=M1 $thickness=3.6e-08
+ $X=0.405 $Y=0.234 $X2=0.405 $Y2=0.2025
r141 56 68 1.96775 $w=1.63333e-08 $l=1.35e-08 $layer=M1 $thickness=3.6e-08
+ $X=0.405 $Y=0.234 $X2=0.4185 $Y2=0.234
r142 2 92 19.3796 $a=3.24e-16 $layer=V0LISD $X=0.108 $Y=0.2025 $X2=0.1085
+ $Y2=0.234
r143 98 99 22.6194 $w=1.3e-08 $l=9.7e-08 $layer=M1 $thickness=3.6e-08 $X=0.2795
+ $Y=0.234 $X2=0.3765 $Y2=0.234
r144 97 98 18.7718 $w=1.3e-08 $l=8.05e-08 $layer=M1 $thickness=3.6e-08 $X=0.199
+ $Y=0.234 $X2=0.2795 $Y2=0.234
r145 96 97 1.86552 $w=1.3e-08 $l=8e-09 $layer=M1 $thickness=3.6e-08 $X=0.191
+ $Y=0.234 $X2=0.199 $Y2=0.234
r146 66 96 6.06293 $w=1.3e-08 $l=2.6e-08 $layer=M1 $thickness=3.6e-08 $X=0.165
+ $Y=0.234 $X2=0.191 $Y2=0.234
r147 92 93 3.03147 $w=1.3e-08 $l=1.3e-08 $layer=M1 $thickness=3.6e-08 $X=0.1085
+ $Y=0.234 $X2=0.1215 $Y2=0.234
r148 54 91 2.60903 $w=1.57692e-08 $l=1.63e-08 $layer=M1 $thickness=3.6e-08
+ $X=0.135 $Y=0.234 $X2=0.135 $Y2=0.2177
r149 54 93 1.96775 $w=1.63333e-08 $l=1.35e-08 $layer=M1 $thickness=3.6e-08
+ $X=0.135 $Y=0.234 $X2=0.1215 $Y2=0.234
r150 54 66 5.81538 $w=1.45e-08 $l=3e-08 $layer=M1 $thickness=3.6e-08 $X=0.135
+ $Y=0.234 $X2=0.165 $Y2=0.234
r151 90 91 1.80722 $w=1.3e-08 $l=7.7e-09 $layer=M1 $thickness=3.6e-08 $X=0.135
+ $Y=0.21 $X2=0.135 $Y2=0.2177
r152 90 89 3.55614 $w=1.3e-08 $l=1.53e-08 $layer=M1 $thickness=3.6e-08 $X=0.135
+ $Y=0.21 $X2=0.135 $Y2=0.1947
r153 88 89 5.53826 $w=1.3e-08 $l=2.37e-08 $layer=M1 $thickness=3.6e-08 $X=0.135
+ $Y=0.171 $X2=0.135 $Y2=0.1947
r154 87 88 4.19742 $w=1.3e-08 $l=1.8e-08 $layer=M1 $thickness=3.6e-08 $X=0.135
+ $Y=0.153 $X2=0.135 $Y2=0.171
r155 86 87 4.19742 $w=1.3e-08 $l=1.8e-08 $layer=M1 $thickness=3.6e-08 $X=0.135
+ $Y=0.135 $X2=0.135 $Y2=0.153
r156 85 86 4.19742 $w=1.3e-08 $l=1.8e-08 $layer=M1 $thickness=3.6e-08 $X=0.135
+ $Y=0.117 $X2=0.135 $Y2=0.135
r157 84 85 4.19742 $w=1.3e-08 $l=1.8e-08 $layer=M1 $thickness=3.6e-08 $X=0.135
+ $Y=0.099 $X2=0.135 $Y2=0.117
r158 65 83 1.96775 $w=1.63333e-08 $l=1.35e-08 $layer=M1 $thickness=3.6e-08
+ $X=0.135 $Y=0.0855 $X2=0.135 $Y2=0.072
r159 65 84 3.14806 $w=1.3e-08 $l=1.35e-08 $layer=M1 $thickness=3.6e-08 $X=0.135
+ $Y=0.0855 $X2=0.135 $Y2=0.099
r160 82 83 1.96775 $w=1.63333e-08 $l=1.35e-08 $layer=M1 $thickness=3.6e-08
+ $X=0.1215 $Y=0.072 $X2=0.135 $Y2=0.072
r161 81 82 3.03147 $w=1.3e-08 $l=1.3e-08 $layer=M1 $thickness=3.6e-08 $X=0.1085
+ $Y=0.072 $X2=0.1215 $Y2=0.072
r162 80 81 2.09871 $w=1.3e-08 $l=9e-09 $layer=M1 $thickness=3.6e-08 $X=0.0995
+ $Y=0.072 $X2=0.1085 $Y2=0.072
r163 53 80 0.699569 $w=1.3e-08 $l=3e-09 $layer=M1 $thickness=3.6e-08 $X=0.0965
+ $Y=0.072 $X2=0.0995 $Y2=0.072
r164 1 81 19.3796 $a=3.24e-16 $layer=V0LISD $X=0.108 $Y=0.0675 $X2=0.1085
+ $Y2=0.072
r165 79 77 0.0308642 $w=8.1e-08 $l=2.5e-09 $layer=N_src_drn $thickness=1e-09
+ $X=0.1253 $Y=0.0675 $X2=0.1225 $Y2=0.0675
r166 1 77 0.179012 $w=8.1e-08 $l=1.45e-08 $layer=N_src_drn $thickness=1e-09
+ $X=0.108 $Y=0.0675 $X2=0.1225 $Y2=0.0675
r167 38 1 0.179012 $w=8.1e-08 $l=1.45e-08 $layer=N_src_drn $thickness=1e-09
+ $X=0.0935 $Y=0.0675 $X2=0.108 $Y2=0.0675
r168 78 38 0.0308642 $w=8.1e-08 $l=2.5e-09 $layer=N_src_drn $thickness=1e-09
+ $X=0.0906 $Y=0.0675 $X2=0.0935 $Y2=0.0675
r169 5 41 1e-05 $l=2.7074e-08 $X=0.54 $Y=0.0675 $X2=0.542 $Y2=0.0945
r170 6 49 1e-05 $l=2.7074e-08 $X=0.54 $Y=0.2025 $X2=0.542 $Y2=0.1755
.ends

.subckt PM_CKINVDCx11_ASAP7_75t_R%6 vss 19 23 33 36 46 47 50 51 18 3 4 9 15 12
+ 16 10 1 14
c1 1 vss 0.00633479f $X=0.621 $Y=0.135
c2 3 vss 0.00715803f $X=0.648 $Y=0.0675
c3 4 vss 0.00721126f $X=0.756 $Y=0.0675
c4 9 vss 0.082362f $X=0.621 $Y=0.0245
c5 10 vss 0.0822524f $X=0.675 $Y=0.135
c6 11 vss 0.00642841f $X=0.6335 $Y=0.0675
c7 12 vss 0.00687836f $X=0.7415 $Y=0.0675
c8 13 vss 0.000348796f $X=0.675 $Y=0.099
c9 14 vss 0.000207447f $X=0.675 $Y=0.135
c10 15 vss 0.00134321f $X=0.6335 $Y=0.099
c11 16 vss 0.000608307f $X=0.631 $Y=0.135
c12 17 vss 0.000149605f $X=0.675 $Y=0.117
c13 18 vss 0.00245903f $X=0.702 $Y=0.099
r1 51 49 0.0308642 $w=8.1e-08 $l=2.5e-09 $layer=N_src_drn $thickness=1e-09
+ $X=0.7733 $Y=0.0675 $X2=0.7705 $Y2=0.0675
r2 4 49 0.179012 $w=8.1e-08 $l=1.45e-08 $layer=N_src_drn $thickness=1e-09
+ $X=0.756 $Y=0.0675 $X2=0.7705 $Y2=0.0675
r3 12 4 0.179012 $w=8.1e-08 $l=1.45e-08 $layer=N_src_drn $thickness=1e-09
+ $X=0.7415 $Y=0.0675 $X2=0.756 $Y2=0.0675
r4 50 12 0.0308642 $w=8.1e-08 $l=2.5e-09 $layer=N_src_drn $thickness=1e-09
+ $X=0.7386 $Y=0.0675 $X2=0.7415 $Y2=0.0675
r5 47 45 0.0308642 $w=8.1e-08 $l=2.5e-09 $layer=N_src_drn $thickness=1e-09
+ $X=0.6653 $Y=0.0675 $X2=0.6625 $Y2=0.0675
r6 3 45 0.179012 $w=8.1e-08 $l=1.45e-08 $layer=N_src_drn $thickness=1e-09
+ $X=0.648 $Y=0.0675 $X2=0.6625 $Y2=0.0675
r7 11 3 0.179012 $w=8.1e-08 $l=1.45e-08 $layer=N_src_drn $thickness=1e-09
+ $X=0.6335 $Y=0.0675 $X2=0.648 $Y2=0.0675
r8 46 11 0.0308642 $w=8.1e-08 $l=2.5e-09 $layer=N_src_drn $thickness=1e-09
+ $X=0.6306 $Y=0.0675 $X2=0.6335 $Y2=0.0675
r9 4 42 19.3796 $a=3.24e-16 $layer=V0LISD $X=0.756 $Y=0.0675 $X2=0.756 $Y2=0.099
r10 3 38 19.3796 $a=3.24e-16 $layer=V0LISD $X=0.648 $Y=0.0675 $X2=0.648
+ $Y2=0.099
r11 41 42 5.24677 $w=1.3e-08 $l=2.25e-08 $layer=M1 $thickness=3.6e-08 $X=0.7335
+ $Y=0.099 $X2=0.756 $Y2=0.099
r12 18 41 7.34548 $w=1.3e-08 $l=3.15e-08 $layer=M1 $thickness=3.6e-08 $X=0.702
+ $Y=0.099 $X2=0.7335 $Y2=0.099
r13 38 39 3.14806 $w=1.3e-08 $l=1.35e-08 $layer=M1 $thickness=3.6e-08 $X=0.648
+ $Y=0.099 $X2=0.6615 $Y2=0.099
r14 15 38 3.38125 $w=1.3e-08 $l=1.45e-08 $layer=M1 $thickness=3.6e-08 $X=0.6335
+ $Y=0.099 $X2=0.648 $Y2=0.099
r15 13 17 3.01711 $w=1.55e-08 $l=1.8e-08 $layer=M1 $thickness=3.6e-08 $X=0.675
+ $Y=0.099 $X2=0.675 $Y2=0.117
r16 13 39 1.96775 $w=1.63333e-08 $l=1.35e-08 $layer=M1 $thickness=3.6e-08
+ $X=0.675 $Y=0.099 $X2=0.6615 $Y2=0.099
r17 13 18 5.11582 $w=1.46667e-08 $l=2.7e-08 $layer=M1 $thickness=3.6e-08
+ $X=0.675 $Y=0.099 $X2=0.702 $Y2=0.099
r18 14 31 1.49895 $w=1.63333e-08 $l=1.35e-08 $layer=M1 $thickness=3.6e-08
+ $X=0.675 $Y=0.135 $X2=0.6615 $Y2=0.135
r19 14 17 2.5483 $w=1.79e-08 $l=1.8e-08 $layer=M1 $thickness=3.6e-08 $X=0.675
+ $Y=0.135 $X2=0.675 $Y2=0.117
r20 36 35 16.4967 $w=2.1e-08 $l=4.85e-08 $layer=Gate_1 $thickness=5.6e-08
+ $X=0.675 $Y=0.2025 $X2=0.675 $Y2=0.154
r21 33 34 16.4967 $w=2.1e-08 $l=4.85e-08 $layer=Gate_1 $thickness=5.6e-08
+ $X=0.675 $Y=0.0675 $X2=0.675 $Y2=0.116
r22 10 27 6.54019 $w=2.09524e-08 $layer=Gate_1 $thickness=5.21905e-08 $X=0.675
+ $Y=0.135 $X2=0.675 $Y2=0.135
r23 10 34 6.6497 $w=2.04211e-08 $l=1.9e-08 $layer=Gate_1 $thickness=5.6e-08
+ $X=0.675 $Y=0.135 $X2=0.675 $Y2=0.116
r24 10 35 6.6497 $w=2.04211e-08 $l=1.9e-08 $layer=Gate_1 $thickness=5.6e-08
+ $X=0.675 $Y=0.135 $X2=0.675 $Y2=0.154
r25 30 31 3.14806 $w=1.3e-08 $l=1.35e-08 $layer=M1 $thickness=3.6e-08 $X=0.648
+ $Y=0.135 $X2=0.6615 $Y2=0.135
r26 29 30 2.68168 $w=1.3e-08 $l=1.15e-08 $layer=M1 $thickness=3.6e-08 $X=0.6365
+ $Y=0.135 $X2=0.648 $Y2=0.135
r27 16 29 1.28254 $w=1.3e-08 $l=5.5e-09 $layer=M1 $thickness=3.6e-08 $X=0.631
+ $Y=0.135 $X2=0.6365 $Y2=0.135
r28 26 27 12.6539 $w=1.77815e-08 $l=2.7e-08 $layer=LIG $thickness=4.8e-08
+ $X=0.648 $Y=0.135 $X2=0.675 $Y2=0.135
r29 26 30 19.3796 $a=3.24e-16 $layer=V0LIG $X=0.648 $Y=0.135 $X2=0.648 $Y2=0.135
r30 1 21 6.54019 $w=2.09524e-08 $layer=Gate_1 $thickness=5.21905e-08 $X=0.621
+ $Y=0.135 $X2=0.621 $Y2=0.135
r31 1 26 12.6539 $w=1.77815e-08 $l=2.7e-08 $layer=LIG $thickness=4.8e-08
+ $X=0.621 $Y=0.135 $X2=0.648 $Y2=0.135
r32 23 22 16.4967 $w=2.1e-08 $l=4.85e-08 $layer=Gate_1 $thickness=5.6e-08
+ $X=0.621 $Y=0.2025 $X2=0.621 $Y2=0.154
r33 21 22 6.6497 $w=2.04211e-08 $l=1.9e-08 $layer=Gate_1 $thickness=5.6e-08
+ $X=0.621 $Y=0.135 $X2=0.621 $Y2=0.154
r34 20 21 6.6497 $w=2.04211e-08 $l=1.9e-08 $layer=Gate_1 $thickness=5.6e-08
+ $X=0.621 $Y=0.116 $X2=0.621 $Y2=0.135
r35 19 20 16.4967 $w=2.1e-08 $l=4.85e-08 $layer=Gate_1 $thickness=5.6e-08
+ $X=0.621 $Y=0.0675 $X2=0.621 $Y2=0.116
r36 19 9 14.6259 $w=2.1e-08 $l=4.3e-08 $layer=Gate_1 $thickness=5.6e-08
+ $X=0.621 $Y=0.0675 $X2=0.621 $Y2=0.0245
.ends

.subckt PM_CKINVDCx11_ASAP7_75t_R%9 vss 19 23 33 36 46 47 50 51 18 4 15 1 9 10
+ 16 12 14
c1 1 vss 0.00633632f $X=0.189 $Y=0.135
c2 3 vss 0.00725662f $X=0.216 $Y=0.0675
c3 4 vss 0.00728462f $X=0.324 $Y=0.0675
c4 9 vss 0.0833582f $X=0.189 $Y=0.0245
c5 10 vss 0.0824452f $X=0.243 $Y=0.135
c6 11 vss 0.00855374f $X=0.2015 $Y=0.0675
c7 12 vss 0.00925489f $X=0.3095 $Y=0.0675
c8 13 vss 0.000359613f $X=0.243 $Y=0.099
c9 14 vss 0.00022372f $X=0.243 $Y=0.135
c10 15 vss 0.00177201f $X=0.2015 $Y=0.099
c11 16 vss 0.000905187f $X=0.199 $Y=0.135
c12 17 vss 0.000149658f $X=0.243 $Y=0.117
c13 18 vss 0.00277976f $X=0.27 $Y=0.099
r1 51 49 0.0308642 $w=8.1e-08 $l=2.5e-09 $layer=N_src_drn $thickness=1e-09
+ $X=0.3413 $Y=0.0675 $X2=0.3385 $Y2=0.0675
r2 4 49 0.179012 $w=8.1e-08 $l=1.45e-08 $layer=N_src_drn $thickness=1e-09
+ $X=0.324 $Y=0.0675 $X2=0.3385 $Y2=0.0675
r3 12 4 0.179012 $w=8.1e-08 $l=1.45e-08 $layer=N_src_drn $thickness=1e-09
+ $X=0.3095 $Y=0.0675 $X2=0.324 $Y2=0.0675
r4 50 12 0.0308642 $w=8.1e-08 $l=2.5e-09 $layer=N_src_drn $thickness=1e-09
+ $X=0.3066 $Y=0.0675 $X2=0.3095 $Y2=0.0675
r5 47 45 0.0308642 $w=8.1e-08 $l=2.5e-09 $layer=N_src_drn $thickness=1e-09
+ $X=0.2333 $Y=0.0675 $X2=0.2305 $Y2=0.0675
r6 3 45 0.179012 $w=8.1e-08 $l=1.45e-08 $layer=N_src_drn $thickness=1e-09
+ $X=0.216 $Y=0.0675 $X2=0.2305 $Y2=0.0675
r7 11 3 0.179012 $w=8.1e-08 $l=1.45e-08 $layer=N_src_drn $thickness=1e-09
+ $X=0.2015 $Y=0.0675 $X2=0.216 $Y2=0.0675
r8 46 11 0.0308642 $w=8.1e-08 $l=2.5e-09 $layer=N_src_drn $thickness=1e-09
+ $X=0.1986 $Y=0.0675 $X2=0.2015 $Y2=0.0675
r9 4 42 19.3796 $a=3.24e-16 $layer=V0LISD $X=0.324 $Y=0.0675 $X2=0.324 $Y2=0.099
r10 3 38 19.3796 $a=3.24e-16 $layer=V0LISD $X=0.216 $Y=0.0675 $X2=0.216
+ $Y2=0.099
r11 41 42 5.24677 $w=1.3e-08 $l=2.25e-08 $layer=M1 $thickness=3.6e-08 $X=0.3015
+ $Y=0.099 $X2=0.324 $Y2=0.099
r12 18 41 7.34548 $w=1.3e-08 $l=3.15e-08 $layer=M1 $thickness=3.6e-08 $X=0.27
+ $Y=0.099 $X2=0.3015 $Y2=0.099
r13 38 39 3.14806 $w=1.3e-08 $l=1.35e-08 $layer=M1 $thickness=3.6e-08 $X=0.216
+ $Y=0.099 $X2=0.2295 $Y2=0.099
r14 15 38 3.38125 $w=1.3e-08 $l=1.45e-08 $layer=M1 $thickness=3.6e-08 $X=0.2015
+ $Y=0.099 $X2=0.216 $Y2=0.099
r15 13 17 3.01711 $w=1.55e-08 $l=1.8e-08 $layer=M1 $thickness=3.6e-08 $X=0.243
+ $Y=0.099 $X2=0.243 $Y2=0.117
r16 13 39 1.96775 $w=1.63333e-08 $l=1.35e-08 $layer=M1 $thickness=3.6e-08
+ $X=0.243 $Y=0.099 $X2=0.2295 $Y2=0.099
r17 13 18 5.11582 $w=1.46667e-08 $l=2.7e-08 $layer=M1 $thickness=3.6e-08
+ $X=0.243 $Y=0.099 $X2=0.27 $Y2=0.099
r18 14 31 1.49895 $w=1.63333e-08 $l=1.35e-08 $layer=M1 $thickness=3.6e-08
+ $X=0.243 $Y=0.135 $X2=0.2295 $Y2=0.135
r19 14 17 2.5483 $w=1.79e-08 $l=1.8e-08 $layer=M1 $thickness=3.6e-08 $X=0.243
+ $Y=0.135 $X2=0.243 $Y2=0.117
r20 36 35 16.4967 $w=2.1e-08 $l=4.85e-08 $layer=Gate_1 $thickness=5.6e-08
+ $X=0.243 $Y=0.2025 $X2=0.243 $Y2=0.154
r21 33 34 16.4967 $w=2.1e-08 $l=4.85e-08 $layer=Gate_1 $thickness=5.6e-08
+ $X=0.243 $Y=0.0675 $X2=0.243 $Y2=0.116
r22 10 27 6.54019 $w=2.09524e-08 $layer=Gate_1 $thickness=5.21905e-08 $X=0.243
+ $Y=0.135 $X2=0.243 $Y2=0.135
r23 10 34 6.6497 $w=2.04211e-08 $l=1.9e-08 $layer=Gate_1 $thickness=5.6e-08
+ $X=0.243 $Y=0.135 $X2=0.243 $Y2=0.116
r24 10 35 6.6497 $w=2.04211e-08 $l=1.9e-08 $layer=Gate_1 $thickness=5.6e-08
+ $X=0.243 $Y=0.135 $X2=0.243 $Y2=0.154
r25 30 31 3.14806 $w=1.3e-08 $l=1.35e-08 $layer=M1 $thickness=3.6e-08 $X=0.216
+ $Y=0.135 $X2=0.2295 $Y2=0.135
r26 29 30 2.68168 $w=1.3e-08 $l=1.15e-08 $layer=M1 $thickness=3.6e-08 $X=0.2045
+ $Y=0.135 $X2=0.216 $Y2=0.135
r27 16 29 1.28254 $w=1.3e-08 $l=5.5e-09 $layer=M1 $thickness=3.6e-08 $X=0.199
+ $Y=0.135 $X2=0.2045 $Y2=0.135
r28 26 27 12.6539 $w=1.77815e-08 $l=2.7e-08 $layer=LIG $thickness=4.8e-08
+ $X=0.216 $Y=0.135 $X2=0.243 $Y2=0.135
r29 26 30 19.3796 $a=3.24e-16 $layer=V0LIG $X=0.216 $Y=0.135 $X2=0.216 $Y2=0.135
r30 1 21 6.54019 $w=2.09524e-08 $layer=Gate_1 $thickness=5.21905e-08 $X=0.189
+ $Y=0.135 $X2=0.189 $Y2=0.135
r31 1 26 12.6539 $w=1.77815e-08 $l=2.7e-08 $layer=LIG $thickness=4.8e-08
+ $X=0.189 $Y=0.135 $X2=0.216 $Y2=0.135
r32 23 22 16.4967 $w=2.1e-08 $l=4.85e-08 $layer=Gate_1 $thickness=5.6e-08
+ $X=0.189 $Y=0.2025 $X2=0.189 $Y2=0.154
r33 21 22 6.6497 $w=2.04211e-08 $l=1.9e-08 $layer=Gate_1 $thickness=5.6e-08
+ $X=0.189 $Y=0.135 $X2=0.189 $Y2=0.154
r34 20 21 6.6497 $w=2.04211e-08 $l=1.9e-08 $layer=Gate_1 $thickness=5.6e-08
+ $X=0.189 $Y=0.116 $X2=0.189 $Y2=0.135
r35 19 20 16.4967 $w=2.1e-08 $l=4.85e-08 $layer=Gate_1 $thickness=5.6e-08
+ $X=0.189 $Y=0.0675 $X2=0.189 $Y2=0.116
r36 19 9 14.6259 $w=2.1e-08 $l=4.3e-08 $layer=Gate_1 $thickness=5.6e-08
+ $X=0.189 $Y=0.0675 $X2=0.189 $Y2=0.0245
.ends

* End of included file CKINVDCx11_ASAP7_75t_R.pex.sp.pex

*
.subckt CKINVDCx11_ASAP7_75t_CUSTOM_4_25_0_7 VSS VDD A Y
*
* VSS VSS
* VDD VDD
* A A
* Y Y
*
*

M0 N_M0_d N_M0_g VSS VSS nmos_rvt L=2e-08 W=8.1e-08 nfin=3 $X=0.071 $Y=0.027
M1 N_M1_d N_M1_g VSS VSS nmos_rvt L=2e-08 W=8.1e-08 nfin=3 $X=0.125 $Y=0.027
M20 N_M20_d N_M20_g VSS VSS nmos_rvt L=2e-08 W=8.1e-08 nfin=3 $X=0.179 $Y=0.027
M21 N_M21_d N_M21_g VSS VSS nmos_rvt L=2e-08 W=8.1e-08 nfin=3 $X=0.233 $Y=0.027
M18 N_M18_d N_M18_g VSS VSS nmos_rvt L=2e-08 W=8.1e-08 nfin=3 $X=0.287 $Y=0.027
M19 N_M19_d N_M19_g VSS VSS nmos_rvt L=2e-08 W=8.1e-08 nfin=3 $X=0.341 $Y=0.027
M6 N_M6_d N_M6_g VSS VSS nmos_rvt L=2e-08 W=5.4e-08 nfin=2 $X=0.395 $Y=0.027
M7 N_M7_d N_M7_g VSS VSS nmos_rvt L=2e-08 W=5.4e-08 nfin=2 $X=0.449 $Y=0.027
M8 N_M8_d N_M8_g VSS VSS nmos_rvt L=2e-08 W=5.4e-08 nfin=2 $X=0.503 $Y=0.027
M9 N_M9_d N_M9_g VSS VSS nmos_rvt L=2e-08 W=8.1e-08 nfin=3 $X=0.557 $Y=0.027
M10 N_M10_d N_M10_g VSS VSS nmos_rvt L=2e-08 W=8.1e-08 nfin=3 $X=0.611 $Y=0.027
M11 N_M11_d N_M11_g VSS VSS nmos_rvt L=2e-08 W=8.1e-08 nfin=3 $X=0.665 $Y=0.027
M12 N_M12_d N_M12_g VSS VSS nmos_rvt L=2e-08 W=8.1e-08 nfin=3 $X=0.719 $Y=0.027
M13 N_M13_d N_M13_g VSS VSS nmos_rvt L=2e-08 W=8.1e-08 nfin=3 $X=0.773 $Y=0.027
M14 N_M14_d N_M14_g VSS VSS nmos_rvt L=2e-08 W=8.1e-08 nfin=3 $X=0.827 $Y=0.027
M15 N_M15_d N_M15_g VSS VSS nmos_rvt L=2e-08 W=8.1e-08 nfin=3 $X=0.881 $Y=0.027
M16 N_M16_d N_M16_g VSS VSS nmos_rvt L=2e-08 W=8.1e-08 nfin=3 $X=0.935 $Y=0.027
M17 N_M17_d N_M17_g VSS VSS nmos_rvt L=2e-08 W=8.1e-08 nfin=3 $X=0.989 $Y=0.027
M4 N_M4_d N_M4_g VSS VSS nmos_rvt L=2e-08 W=8.1e-08 nfin=3 $X=1.043 $Y=0.027
M5 N_M5_d N_M5_g VSS VSS nmos_rvt L=2e-08 W=8.1e-08 nfin=3 $X=1.097 $Y=0.027
M2 N_M2_d N_M2_g VSS VSS nmos_rvt L=2e-08 W=8.1e-08 nfin=3 $X=1.151 $Y=0.027
M3 N_M3_d N_M3_g VSS VSS nmos_rvt L=2e-08 W=8.1e-08 nfin=3 $X=1.205 $Y=0.027
M22 N_M22_d N_M22_g VSS VSS nmos_rvt L=2e-08 W=8.1e-08 nfin=3 $X=1.259 $Y=0.027
M23 N_M23_d N_M23_g VSS VSS nmos_rvt L=2e-08 W=8.1e-08 nfin=3 $X=1.313 $Y=0.027
M24 N_M24_d N_M24_g VDD VDD pmos_rvt L=2e-08 W=8.1e-08 nfin=3 $X=0.071 $Y=0.162
M25 N_M25_d N_M25_g VDD VDD pmos_rvt L=2e-08 W=8.1e-08 nfin=3 $X=0.125 $Y=0.162
M44 N_M44_d N_M44_g VDD VDD pmos_rvt L=2e-08 W=8.1e-08 nfin=3 $X=0.179 $Y=0.162
M45 N_M45_d N_M45_g VDD VDD pmos_rvt L=2e-08 W=8.1e-08 nfin=3 $X=0.233 $Y=0.162
M42 N_M42_d N_M42_g VDD VDD pmos_rvt L=2e-08 W=8.1e-08 nfin=3 $X=0.287 $Y=0.162
M43 N_M43_d N_M43_g VDD VDD pmos_rvt L=2e-08 W=8.1e-08 nfin=3 $X=0.341 $Y=0.162
M30 N_M30_d N_M30_g VDD VDD pmos_rvt L=2e-08 W=5.4e-08 nfin=2 $X=0.395 $Y=0.189
M31 N_M31_d N_M31_g VDD VDD pmos_rvt L=2e-08 W=5.4e-08 nfin=2 $X=0.449 $Y=0.189
M32 N_M32_d N_M32_g VDD VDD pmos_rvt L=2e-08 W=5.4e-08 nfin=2 $X=0.503 $Y=0.189
M33 N_M33_d N_M33_g VDD VDD pmos_rvt L=2e-08 W=8.1e-08 nfin=3 $X=0.557 $Y=0.162
M34 N_M34_d N_M34_g VDD VDD pmos_rvt L=2e-08 W=8.1e-08 nfin=3 $X=0.611 $Y=0.162
M35 N_M35_d N_M35_g VDD VDD pmos_rvt L=2e-08 W=8.1e-08 nfin=3 $X=0.665 $Y=0.162
M36 N_M36_d N_M36_g VDD VDD pmos_rvt L=2e-08 W=8.1e-08 nfin=3 $X=0.719 $Y=0.162
M37 N_M37_d N_M37_g VDD VDD pmos_rvt L=2e-08 W=8.1e-08 nfin=3 $X=0.773 $Y=0.162
M38 N_M38_d N_M38_g VDD VDD pmos_rvt L=2e-08 W=8.1e-08 nfin=3 $X=0.827 $Y=0.162
M39 N_M39_d N_M39_g VDD VDD pmos_rvt L=2e-08 W=8.1e-08 nfin=3 $X=0.881 $Y=0.162
M40 N_M40_d N_M40_g VDD VDD pmos_rvt L=2e-08 W=8.1e-08 nfin=3 $X=0.935 $Y=0.162
M41 N_M41_d N_M41_g VDD VDD pmos_rvt L=2e-08 W=8.1e-08 nfin=3 $X=0.989 $Y=0.162
M28 N_M28_d N_M28_g VDD VDD pmos_rvt L=2e-08 W=8.1e-08 nfin=3 $X=1.043 $Y=0.162
M29 N_M29_d N_M29_g VDD VDD pmos_rvt L=2e-08 W=8.1e-08 nfin=3 $X=1.097 $Y=0.162
M26 N_M26_d N_M26_g VDD VDD pmos_rvt L=2e-08 W=8.1e-08 nfin=3 $X=1.151 $Y=0.162
M27 N_M27_d N_M27_g VDD VDD pmos_rvt L=2e-08 W=8.1e-08 nfin=3 $X=1.205 $Y=0.162
M46 N_M46_d N_M46_g VDD VDD pmos_rvt L=2e-08 W=8.1e-08 nfin=3 $X=1.259 $Y=0.162
M47 N_M47_d N_M47_g VDD VDD pmos_rvt L=2e-08 W=8.1e-08 nfin=3 $X=1.313 $Y=0.162

* .include "CKINVDCx11_ASAP7_75t_R.pex.sp.pxi"

* Start of included file CKINVDCx11_ASAP7_75t_R.pex.sp.pxi
x_PM_CKINVDCx11_ASAP7_75t_R%8 vss N_M18_g N_M42_g N_M19_g N_M43_g N_M44_d
+ N_M45_d N_M42_d N_M43_d N_8_10 N_8_11 N_8_15 N_8_17 N_8_9 N_8_3 N_8_1 N_8_13
+ N_8_4 N_8_18 PM_CKINVDCx11_ASAP7_75t_R%8
cc_1 N_8_10 N_A_34 4.28969e-20 $X=0.351 $Y=0.135
cc_2 N_8_10 N_A_2 0.00176311f $X=0.351 $Y=0.135
cc_3 N_8_10 N_A_1 0.000114727f $X=0.351 $Y=0.135
cc_4 N_8_10 N_A_13 0.00345102f $X=0.351 $Y=0.135
cc_5 N_8_11 N_9_10 0.0217885f $X=0.2015 $Y=0.2025
cc_6 N_8_15 N_9_16 0.00127705f $X=0.27 $Y=0.171
cc_7 N_8_17 N_9_18 0.00132043f $X=0.3105 $Y=0.135
cc_8 N_8_9 N_9_4 0.00143019f $X=0.297 $Y=0.0245
cc_9 N_8_3 N_9_10 0.00143019f $X=0.216 $Y=0.2025
cc_10 N_8_3 N_9_1 0.00173267f $X=0.216 $Y=0.2025
cc_11 N_8_1 N_9_4 0.00173267f $X=0.297 $Y=0.135
cc_12 N_8_11 N_9_1 0.0029964f $X=0.2015 $Y=0.2025
cc_13 N_8_1 N_9_12 0.0029964f $X=0.297 $Y=0.135
cc_14 N_8_13 N_9_18 0.00381379f $X=0.297 $Y=0.135
cc_15 N_8_15 N_9_14 0.00381581f $X=0.27 $Y=0.171
cc_16 N_8_10 N_9_12 0.0238634f $X=0.351 $Y=0.135
cc_17 N_8_9 N_9_12 0.0398831f $X=0.297 $Y=0.0245
cc_18 N_8_11 N_9_9 0.0506758f $X=0.2015 $Y=0.2025
x_PM_CKINVDCx11_ASAP7_75t_R%7 vss N_M12_g N_M36_g N_M13_g N_M37_g N_M34_d
+ N_M35_d N_M36_d N_M37_d N_7_10 N_7_15 N_7_17 N_7_9 N_7_3 N_7_1 N_7_11 N_7_13
+ N_7_4 N_7_18 PM_CKINVDCx11_ASAP7_75t_R%7
cc_19 N_7_10 N_A_3 0.00151031f $X=0.783 $Y=0.135
cc_20 N_7_10 N_A_2 0.000114798f $X=0.783 $Y=0.135
cc_21 N_7_10 N_A_17 0.00362036f $X=0.783 $Y=0.135
cc_22 N_7_10 N_6_12 0.0305668f $X=0.783 $Y=0.135
cc_23 N_7_15 N_6_16 0.00127848f $X=0.702 $Y=0.171
cc_24 N_7_17 N_6_18 0.00132068f $X=0.7425 $Y=0.135
cc_25 N_7_9 N_6_4 0.00143019f $X=0.729 $Y=0.0245
cc_26 N_7_3 N_6_10 0.00143019f $X=0.648 $Y=0.2025
cc_27 N_7_3 N_6_1 0.00173267f $X=0.648 $Y=0.2025
cc_28 N_7_1 N_6_4 0.00173267f $X=0.729 $Y=0.135
cc_29 N_7_11 N_6_1 0.0029964f $X=0.6335 $Y=0.2025
cc_30 N_7_1 N_6_12 0.0029964f $X=0.729 $Y=0.135
cc_31 N_7_13 N_6_18 0.00381379f $X=0.729 $Y=0.135
cc_32 N_7_15 N_6_14 0.00381598f $X=0.702 $Y=0.171
cc_33 N_7_9 N_6_12 0.0398831f $X=0.729 $Y=0.0245
cc_34 N_7_11 N_6_10 0.0209153f $X=0.6335 $Y=0.2025
cc_35 N_7_11 N_6_9 0.050628f $X=0.6335 $Y=0.2025
x_PM_CKINVDCx11_ASAP7_75t_R%5 vss N_M4_g N_M28_g N_M5_g N_M29_g N_M28_d N_M29_d
+ N_M26_d N_M27_d N_5_9 N_5_18 N_5_16 N_5_4 N_5_10 N_5_1 N_5_12 N_5_13 N_5_3
+ N_5_15 PM_CKINVDCx11_ASAP7_75t_R%5
cc_36 N_5_9 N_A_29 3.94575e-20 $X=1.053 $Y=0.0245
cc_37 N_5_9 N_A_3 0.00137562f $X=1.053 $Y=0.0245
cc_38 N_5_9 N_A_4 0.000114798f $X=1.053 $Y=0.0245
cc_39 N_5_9 N_A_20 0.00363639f $X=1.053 $Y=0.0245
x_PM_CKINVDCx11_ASAP7_75t_R%4 vss N_M2_g N_M26_g N_M3_g N_M27_g N_M4_d N_M5_d
+ N_M2_d N_M3_d N_4_15 N_4_3 N_4_17 N_4_1 N_4_10 N_4_11 N_4_18 N_4_9 N_4_14
+ PM_CKINVDCx11_ASAP7_75t_R%4
cc_40 N_4_15 N_A_29 4.95264e-20 $X=1.134 $Y=0.099
cc_41 N_4_15 N_A_4 0.00013096f $X=1.134 $Y=0.099
cc_42 N_4_3 N_A_39 0.000749204f $X=1.08 $Y=0.0675
cc_43 N_4_17 N_A_39 0.000814573f $X=1.1745 $Y=0.099
cc_44 N_4_1 N_A_4 0.00102927f $X=1.161 $Y=0.135
cc_45 N_4_10 N_A_21 0.00346956f $X=1.215 $Y=0.135
cc_46 N_4_15 N_A_39 0.00728297f $X=1.134 $Y=0.099
cc_47 N_4_11 N_5_9 0.0305668f $X=1.0655 $Y=0.0675
cc_48 N_4_18 N_5_18 0.00127654f $X=1.1745 $Y=0.135
cc_49 N_4_15 N_5_16 0.00132068f $X=1.134 $Y=0.099
cc_50 N_4_9 N_5_4 0.00143019f $X=1.161 $Y=0.0245
cc_51 N_4_3 N_5_10 0.00143019f $X=1.08 $Y=0.0675
cc_52 N_4_3 N_5_1 0.00174171f $X=1.08 $Y=0.0675
cc_53 N_4_1 N_5_4 0.00174171f $X=1.161 $Y=0.135
cc_54 N_4_11 N_5_1 0.0029712f $X=1.0655 $Y=0.0675
cc_55 N_4_1 N_5_12 0.0029712f $X=1.161 $Y=0.135
cc_56 N_4_15 N_5_13 0.00381379f $X=1.134 $Y=0.099
cc_57 N_4_14 N_5_18 0.00381598f $X=1.161 $Y=0.135
cc_58 N_4_11 N_5_10 0.0399111f $X=1.0655 $Y=0.0675
cc_59 N_4_9 N_5_12 0.0209184f $X=1.161 $Y=0.0245
cc_60 N_4_10 N_5_12 0.0506862f $X=1.215 $Y=0.135
x_PM_CKINVDCx11_ASAP7_75t_R%A vss A N_M0_g N_M24_g N_M1_g N_M25_g N_M6_g
+ N_M30_g N_M7_g N_M31_g N_M8_g N_M32_g N_M9_g N_M33_g N_M14_g N_M38_g N_M15_g
+ N_M39_g N_M16_g N_M40_g N_M17_g N_M41_g N_M22_g N_M46_g N_M23_g N_M47_g N_A_1
+ N_A_32 N_A_12 N_A_34 N_A_2 N_A_13 N_A_35 N_A_16 N_A_3 N_A_17 N_A_29 N_A_4
+ N_A_20 N_A_39 N_A_21 N_A_27 N_A_25 N_A_26 N_A_11 N_A_18 N_A_19 N_A_22 N_A_15
+ N_A_28 N_A_23 N_A_30 N_A_24 N_A_14 N_A_31 N_A_41 N_A_38 N_A_36 N_A_33 N_A_40
+ N_A_37 PM_CKINVDCx11_ASAP7_75t_R%A
x_PM_CKINVDCx11_ASAP7_75t_R%Y vss Y N_M0_d N_M1_d N_M24_d N_M25_d N_M30_d
+ N_M31_d N_M32_d N_M33_d N_M6_d N_M7_d N_M8_d N_M9_d N_M38_d N_M39_d N_M40_d
+ N_M41_d N_M14_d N_M15_d N_M16_d N_M17_d N_M46_d N_M47_d N_M22_d N_M23_d
+ N_Y_49 N_Y_57 N_Y_2 N_Y_8 N_Y_10 N_Y_12 N_Y_45 N_Y_37 N_Y_59 N_Y_53 N_Y_63
+ N_Y_67 N_Y_4 N_Y_6 N_Y_54 N_Y_64 N_Y_66 N_Y_55 N_Y_40 N_Y_48 N_Y_61 N_Y_41
+ N_Y_72 N_Y_68 N_Y_47 N_Y_39 N_Y_50 N_Y_51 N_Y_38 N_Y_44 N_Y_46 N_Y_52 N_Y_42
+ N_Y_43 N_Y_7 N_Y_9 N_Y_5 N_Y_3 N_Y_1 N_Y_11 N_Y_65 N_Y_75 N_Y_69 N_Y_73
+ N_Y_71 N_Y_70 N_Y_74 PM_CKINVDCx11_ASAP7_75t_R%Y
cc_61 N_Y_49 N_A_27 0.000111214f $X=0.542 $Y=0.1755
cc_62 N_Y_49 N_A_25 7.89604e-20 $X=0.542 $Y=0.1755
cc_63 N_Y_57 N_A_26 9.78545e-20 $X=0.567 $Y=0.072
cc_64 N_Y_2 N_A_11 0.00163195f $X=0.108 $Y=0.2025
cc_65 N_Y_8 N_A_18 0.00162819f $X=0.864 $Y=0.2025
cc_66 N_Y_10 N_A_19 0.00162819f $X=0.972 $Y=0.2025
cc_67 N_Y_12 N_A_22 0.00163195f $X=1.296 $Y=0.2025
cc_68 N_Y_45 N_A_16 0.0184992f $X=0.5255 $Y=0.1975
cc_69 N_Y_37 N_A_15 0.0551434f $X=0.5255 $Y=0.0725
cc_70 N_Y_59 N_A_28 0.000105859f $X=0.837 $Y=0.072
cc_71 N_Y_53 N_A_23 0.000106903f $X=0.0965 $Y=0.072
cc_72 N_Y_63 N_A_30 0.000106925f $X=1.269 $Y=0.072
cc_73 N_Y_67 N_A_26 0.000112705f $X=0.405 $Y=0.2025
cc_74 N_Y_4 N_A_13 0.000121382f $X=0.432 $Y=0.1755
cc_75 N_Y_6 N_A_16 0.000121382f $X=0.54 $Y=0.2025
cc_76 N_Y_54 N_A_24 0.000159149f $X=0.135 $Y=0.234
cc_77 N_Y_64 N_A_29 0.000159149f $X=1.269 $Y=0.234
cc_78 N_Y_66 N_A_12 0.000159645f $X=0.165 $Y=0.234
cc_79 N_Y_63 N_A_29 0.000207278f $X=1.269 $Y=0.072
cc_80 N_Y_53 N_A_24 0.000242901f $X=0.0965 $Y=0.072
cc_81 N_Y_55 N_A_26 0.000248185f $X=0.405 $Y=0.072
cc_82 N_Y_40 N_A_15 0.000320641f $X=0.5255 $Y=0.0455
cc_83 N_Y_48 N_A_16 0.000329601f $X=0.5255 $Y=0.2245
cc_84 N_Y_61 N_A_28 0.000362222f $X=0.999 $Y=0.072
cc_85 N_Y_41 N_A_16 0.00369221f $X=0.542 $Y=0.0945
cc_86 N_Y_72 N_A_28 0.000512651f $X=0.8505 $Y=0.234
cc_87 N_Y_68 N_A_26 0.000528776f $X=0.4185 $Y=0.234
cc_88 N_Y_47 N_A_13 0.0078032f $X=0.4175 $Y=0.216
cc_89 N_Y_39 N_A_14 0.0345319f $X=0.4175 $Y=0.054
cc_90 N_Y_50 N_A_18 0.0364051f $X=0.8495 $Y=0.2025
cc_91 N_Y_51 N_A_19 0.0364051f $X=0.9575 $Y=0.2025
cc_92 N_Y_38 N_A_12 0.0187017f $X=0.0935 $Y=0.0675
cc_93 N_Y_44 N_A_21 0.0187017f $X=1.2815 $Y=0.0675
cc_94 N_Y_46 N_A_12 0.0539964f $X=0.0935 $Y=0.2025
cc_95 N_Y_52 N_A_21 0.0539964f $X=1.2815 $Y=0.2025
cc_96 N_Y_42 N_A_18 0.000798594f $X=0.8495 $Y=0.0675
cc_97 N_Y_43 N_A_19 0.000798594f $X=0.9575 $Y=0.0675
cc_98 N_Y_7 N_A_35 0.00083716f $X=0.864 $Y=0.0675
cc_99 N_Y_9 N_A_39 0.00083716f $X=0.972 $Y=0.0675
cc_100 N_Y_5 N_A_35 0.000837571f $X=0.54 $Y=0.0675
cc_101 N_Y_3 N_A_32 0.000846515f $X=0.432 $Y=0.054
cc_102 N_Y_1 N_A_32 0.00085069f $X=0.108 $Y=0.0675
cc_103 N_Y_11 N_A_39 0.00085069f $X=1.296 $Y=0.0675
cc_104 N_Y_1 N_A_1 0.00113148f $X=0.108 $Y=0.0675
cc_105 N_Y_11 N_A_4 0.00113148f $X=1.296 $Y=0.0675
cc_106 N_Y_7 N_A_3 0.00115736f $X=0.864 $Y=0.0675
cc_107 N_Y_9 N_A_3 0.00115736f $X=0.972 $Y=0.0675
cc_108 N_Y_6 N_A_2 0.00117058f $X=0.54 $Y=0.2025
cc_109 N_Y_53 N_A_31 0.00119678f $X=0.0965 $Y=0.072
cc_110 N_Y_63 N_A_41 0.00119678f $X=1.269 $Y=0.072
cc_111 N_Y_4 N_A_2 0.00119687f $X=0.432 $Y=0.1755
cc_112 N_Y_6 N_A_15 0.00152694f $X=0.54 $Y=0.2025
cc_113 N_Y_59 N_A_38 0.0016993f $X=0.837 $Y=0.072
cc_114 N_Y_55 N_A_34 0.00185037f $X=0.405 $Y=0.072
cc_115 N_Y_5 N_A_16 0.00203027f $X=0.54 $Y=0.0675
cc_116 N_Y_7 N_A_18 0.00203107f $X=0.864 $Y=0.0675
cc_117 N_Y_9 N_A_19 0.00203107f $X=0.972 $Y=0.0675
cc_118 N_Y_1 N_A_12 0.00204631f $X=0.108 $Y=0.0675
cc_119 N_Y_11 N_A_21 0.00204631f $X=1.296 $Y=0.0675
cc_120 N_Y_4 N_A_14 0.00236054f $X=0.432 $Y=0.1755
cc_121 N_Y_3 N_A_14 0.00284083f $X=0.432 $Y=0.054
cc_122 N_Y_59 N_A_35 0.00297972f $X=0.837 $Y=0.072
cc_123 N_Y_53 N_A_32 0.00300639f $X=0.0965 $Y=0.072
cc_124 N_Y_63 N_A_39 0.00300639f $X=1.269 $Y=0.072
cc_125 N_Y_65 N_A_24 0.00350684f $X=0.135 $Y=0.0855
cc_126 N_Y_75 N_A_29 0.00350684f $X=1.269 $Y=0.2025
cc_127 N_Y_69 N_A_36 0.00360481f $X=0.567 $Y=0.2025
cc_128 N_Y_67 N_A_33 0.00380633f $X=0.405 $Y=0.2025
cc_129 N_Y_73 N_A_40 0.00380861f $X=0.999 $Y=0.2025
cc_130 N_Y_71 N_A_37 0.00383449f $X=0.837 $Y=0.2025
cc_131 N_Y_46 N_A_1 0.00452548f $X=0.0935 $Y=0.2025
cc_132 N_Y_52 N_A_4 0.00452548f $X=1.2815 $Y=0.2025
cc_133 N_Y_41 N_A_15 0.00589905f $X=0.542 $Y=0.0945
cc_134 N_Y_43 N_A_3 0.007566f $X=0.9575 $Y=0.0675
cc_135 N_Y_37 N_A_2 0.00847581f $X=0.5255 $Y=0.0725
cc_136 N_Y_55 N_A_32 0.00906389f $X=0.405 $Y=0.072
cc_137 N_Y_61 N_A_39 0.00909465f $X=0.999 $Y=0.072
cc_138 N_Y_57 N_A_35 0.00918074f $X=0.567 $Y=0.072
cc_139 N_Y_42 N_A_17 0.0275202f $X=0.8495 $Y=0.0675
cc_140 N_Y_43 N_A_20 0.0275202f $X=0.9575 $Y=0.0675
cc_141 N_Y_46 N_A_11 0.00992995f $X=0.0935 $Y=0.2025
cc_142 N_Y_52 N_A_22 0.00992995f $X=1.2815 $Y=0.2025
cc_143 N_Y_47 N_A_14 0.0121269f $X=0.4175 $Y=0.216
cc_144 N_Y_39 N_A_13 0.0392946f $X=0.4175 $Y=0.054
cc_145 N_Y_50 N_A_17 0.0628058f $X=0.8495 $Y=0.2025
cc_146 N_Y_51 N_A_20 0.0628058f $X=0.9575 $Y=0.2025
cc_147 N_Y_38 N_A_11 0.0452143f $X=0.0935 $Y=0.0675
cc_148 N_Y_44 N_A_22 0.0452143f $X=1.2815 $Y=0.0675
cc_149 N_Y_49 N_A_16 0.0601422f $X=0.542 $Y=0.1755
cc_150 N_Y_1 N_9_16 8.57435e-20 $X=0.108 $Y=0.0675
cc_151 N_Y_55 N_9_16 0.000303816f $X=0.405 $Y=0.072
cc_152 N_Y_53 N_9_16 0.000473879f $X=0.0965 $Y=0.072
cc_153 N_Y_67 N_9_16 0.000158296f $X=0.405 $Y=0.2025
cc_154 N_Y_66 N_9_16 0.000429643f $X=0.165 $Y=0.234
cc_155 N_Y_65 N_9_15 0.000650687f $X=0.135 $Y=0.0855
cc_156 N_Y_67 N_9_18 0.000804273f $X=0.405 $Y=0.2025
cc_157 N_Y_65 N_9_16 0.00199712f $X=0.135 $Y=0.0855
cc_158 N_Y_4 N_8_15 9.96333e-20 $X=0.432 $Y=0.1755
cc_159 N_Y_55 N_8_15 0.000101506f $X=0.405 $Y=0.072
cc_160 N_Y_67 N_8_15 0.000191229f $X=0.405 $Y=0.2025
cc_161 N_Y_65 N_8_15 0.000442588f $X=0.135 $Y=0.0855
cc_162 N_Y_67 N_8_17 0.000466036f $X=0.405 $Y=0.2025
cc_163 N_Y_66 N_8_4 0.000847457f $X=0.165 $Y=0.234
cc_164 N_Y_66 N_8_3 0.000879939f $X=0.165 $Y=0.234
cc_165 N_Y_67 N_8_18 0.00119699f $X=0.405 $Y=0.2025
cc_166 N_Y_66 N_8_18 0.00143172f $X=0.165 $Y=0.234
cc_167 N_Y_66 N_8_15 0.00679273f $X=0.165 $Y=0.234
cc_168 N_Y_5 N_6_16 8.99064e-20 $X=0.54 $Y=0.0675
cc_169 N_Y_59 N_6_16 0.000309094f $X=0.837 $Y=0.072
cc_170 N_Y_57 N_6_16 0.000497035f $X=0.567 $Y=0.072
cc_171 N_Y_71 N_6_16 0.000158296f $X=0.837 $Y=0.2025
cc_172 N_Y_70 N_6_16 0.000211347f $X=0.597 $Y=0.234
cc_173 N_Y_69 N_6_15 0.000650687f $X=0.567 $Y=0.2025
cc_174 N_Y_71 N_6_18 0.00080531f $X=0.837 $Y=0.2025
cc_175 N_Y_69 N_6_16 0.00202084f $X=0.567 $Y=0.2025
cc_176 N_Y_8 N_7_15 9.31766e-20 $X=0.864 $Y=0.2025
cc_177 N_Y_59 N_7_15 0.000128188f $X=0.837 $Y=0.072
cc_178 N_Y_71 N_7_15 0.000191229f $X=0.837 $Y=0.2025
cc_179 N_Y_69 N_7_15 0.000446799f $X=0.567 $Y=0.2025
cc_180 N_Y_71 N_7_17 0.000466209f $X=0.837 $Y=0.2025
cc_181 N_Y_70 N_7_4 0.000847457f $X=0.597 $Y=0.234
cc_182 N_Y_70 N_7_3 0.000879939f $X=0.597 $Y=0.234
cc_183 N_Y_71 N_7_18 0.00123004f $X=0.837 $Y=0.2025
cc_184 N_Y_70 N_7_18 0.00143172f $X=0.597 $Y=0.234
cc_185 N_Y_70 N_7_15 0.00693294f $X=0.597 $Y=0.234
cc_186 N_Y_73 N_5_18 0.000347538f $X=0.999 $Y=0.2025
cc_187 N_Y_61 N_5_18 0.000129262f $X=0.999 $Y=0.072
cc_188 N_Y_75 N_5_18 0.00044263f $X=1.269 $Y=0.2025
cc_189 N_Y_73 N_5_16 0.000466209f $X=0.999 $Y=0.2025
cc_190 N_Y_74 N_5_3 0.000847457f $X=1.0275 $Y=0.234
cc_191 N_Y_74 N_5_4 0.000879939f $X=1.0275 $Y=0.234
cc_192 N_Y_73 N_5_15 0.00123004f $X=0.999 $Y=0.2025
cc_193 N_Y_74 N_5_15 0.00143172f $X=1.0275 $Y=0.234
cc_194 N_Y_74 N_5_18 0.00685205f $X=1.0275 $Y=0.234
cc_195 N_Y_11 N_4_18 8.57435e-20 $X=1.296 $Y=0.0675
cc_196 N_Y_61 N_4_18 0.000309835f $X=0.999 $Y=0.072
cc_197 N_Y_63 N_4_18 0.000473376f $X=1.269 $Y=0.072
cc_198 N_Y_73 N_4_18 0.000158296f $X=0.999 $Y=0.2025
cc_199 N_Y_74 N_4_18 0.000429922f $X=1.0275 $Y=0.234
cc_200 N_Y_75 N_4_17 0.000650687f $X=1.269 $Y=0.2025
cc_201 N_Y_73 N_4_15 0.000807092f $X=0.999 $Y=0.2025
cc_202 N_Y_75 N_4_18 0.00210614f $X=1.269 $Y=0.2025
x_PM_CKINVDCx11_ASAP7_75t_R%6 vss N_M10_g N_M34_g N_M11_g N_M35_g N_M10_d
+ N_M11_d N_M12_d N_M13_d N_6_18 N_6_3 N_6_4 N_6_9 N_6_15 N_6_12 N_6_16 N_6_10
+ N_6_1 N_6_14 PM_CKINVDCx11_ASAP7_75t_R%6
cc_203 N_6_18 N_A_34 5.26091e-20 $X=0.702 $Y=0.099
cc_204 N_6_18 N_A_2 0.000848041f $X=0.702 $Y=0.099
cc_205 N_6_3 N_A_35 0.00073852f $X=0.648 $Y=0.0675
cc_206 N_6_4 N_A_35 0.000749204f $X=0.756 $Y=0.0675
cc_207 N_6_9 N_A_2 0.000753058f $X=0.621 $Y=0.0245
cc_208 N_6_15 N_A_35 0.000814573f $X=0.6335 $Y=0.099
cc_209 N_6_9 N_A_16 0.00341513f $X=0.621 $Y=0.0245
cc_210 N_6_18 N_A_35 0.00649782f $X=0.702 $Y=0.099
x_PM_CKINVDCx11_ASAP7_75t_R%9 vss N_M20_g N_M44_g N_M21_g N_M45_g N_M20_d
+ N_M21_d N_M18_d N_M19_d N_9_18 N_9_4 N_9_15 N_9_1 N_9_9 N_9_10 N_9_16 N_9_12
+ N_9_14 PM_CKINVDCx11_ASAP7_75t_R%9
cc_211 N_9_18 N_A_1 0.00021178f $X=0.27 $Y=0.099
cc_212 N_9_4 N_A_32 0.000749204f $X=0.324 $Y=0.0675
cc_213 N_9_15 N_A_32 0.000814573f $X=0.2015 $Y=0.099
cc_214 N_9_1 N_A_1 0.00107621f $X=0.189 $Y=0.135
cc_215 N_9_9 N_A_12 0.00346785f $X=0.189 $Y=0.0245
cc_216 N_9_18 N_A_32 0.00728972f $X=0.27 $Y=0.099

* End of included file CKINVDCx11_ASAP7_75t_R.pex.sp.pxi
.ends

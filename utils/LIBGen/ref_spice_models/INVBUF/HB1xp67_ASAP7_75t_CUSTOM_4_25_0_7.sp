.subckt PM_HB1xp67_ASAP7_75t_R%A vss 26 10 16 3 9 1 4 6
c1 1 vss 0.00371923f $X=0.072 $Y=0.135
c2 3 vss 0.0731243f $X=0.081 $Y=0.0245
c3 4 vss 0.00272245f $X=0.027 $Y=0.072
c4 5 vss 0.000846061f $X=0.027 $Y=0.135
c5 6 vss 0.00267832f $X=0.027 $Y=0.198
c6 7 vss 0.00246907f $X=0.027 $Y=0.1215
c7 8 vss 0.00246907f $X=0.027 $Y=0.1465
c8 9 vss 0.00123166f $X=0.0455 $Y=0.135
r1 6 29 3.01711 $w=1.55e-08 $l=1.8e-08 $layer=M1 $thickness=3.6e-08 $X=0.027
+ $Y=0.198 $X2=0.027 $Y2=0.18
r2 4 25 3.01711 $w=1.55e-08 $l=1.8e-08 $layer=M1 $thickness=3.6e-08 $X=0.027
+ $Y=0.072 $X2=0.027 $Y2=0.09
r3 28 29 4.19742 $w=1.3e-08 $l=1.8e-08 $layer=M1 $thickness=3.6e-08 $X=0.027
+ $Y=0.162 $X2=0.027 $Y2=0.18
r4 27 28 2.44849 $w=1.3e-08 $l=1.05e-08 $layer=M1 $thickness=3.6e-08 $X=0.027
+ $Y=0.1515 $X2=0.027 $Y2=0.162
r5 26 27 0.46638 $w=1.3e-08 $l=2e-09 $layer=M1 $thickness=3.6e-08 $X=0.019
+ $Y=0.1495 $X2=0.027 $Y2=0.1515
r6 26 8 0.699569 $w=1.3e-08 $l=3e-09 $layer=M1 $thickness=3.6e-08 $X=0.019
+ $Y=0.1495 $X2=0.027 $Y2=0.1465
r7 24 25 4.19742 $w=1.3e-08 $l=1.8e-08 $layer=M1 $thickness=3.6e-08 $X=0.027
+ $Y=0.108 $X2=0.027 $Y2=0.09
r8 7 24 3.14806 $w=1.3e-08 $l=1.35e-08 $layer=M1 $thickness=3.6e-08 $X=0.027
+ $Y=0.1215 $X2=0.027 $Y2=0.108
r9 5 9 3.1337 $w=1.54324e-08 $l=1.85e-08 $layer=M1 $thickness=3.6e-08 $X=0.027
+ $Y=0.135 $X2=0.0455 $Y2=0.135
r10 5 7 1.96775 $w=1.63333e-08 $l=1.35e-08 $layer=M1 $thickness=3.6e-08
+ $X=0.027 $Y=0.135 $X2=0.027 $Y2=0.1215
r11 5 8 1.50137 $w=1.6913e-08 $l=1.15e-08 $layer=M1 $thickness=3.6e-08 $X=0.027
+ $Y=0.135 $X2=0.027 $Y2=0.1465
r12 9 22 4.31401 $w=1.3e-08 $l=1.85e-08 $layer=M1 $thickness=3.6e-08 $X=0.0455
+ $Y=0.135 $X2=0.064 $Y2=0.135
r13 20 22 19.3796 $a=3.24e-16 $layer=V0LIG $X=0.063 $Y=0.135 $X2=0.064 $Y2=0.135
r14 1 18 2.6116 $w=2.2e-08 $l=1e-08 $layer=LIG $thickness=4.8e-08 $X=0.072
+ $Y=0.135 $X2=0.082 $Y2=0.135
r15 1 20 4.98695 $w=1.60444e-08 $l=9e-09 $layer=LIG $thickness=4.8e-08 $X=0.072
+ $Y=0.135 $X2=0.063 $Y2=0.135
r16 16 15 14.6259 $w=2.1e-08 $l=4.3e-08 $layer=Gate_1 $thickness=5.6e-08
+ $X=0.081 $Y=0.2295 $X2=0.081 $Y2=0.1865
r17 14 15 11.9048 $w=2.1e-08 $l=3.5e-08 $layer=Gate_1 $thickness=5.6e-08
+ $X=0.081 $Y=0.1515 $X2=0.081 $Y2=0.1865
r18 13 14 5.79936 $w=2.03333e-08 $l=1.65e-08 $layer=Gate_1 $thickness=5.6e-08
+ $X=0.081 $Y=0.135 $X2=0.081 $Y2=0.1515
r19 13 18 6.27904 $w=2.09e-08 $l=1e-09 $layer=Gate_1 $thickness=5.24e-08
+ $X=0.081 $Y=0.135 $X2=0.082 $Y2=0.135
r20 12 13 5.79936 $w=2.03333e-08 $l=1.65e-08 $layer=Gate_1 $thickness=5.6e-08
+ $X=0.081 $Y=0.1185 $X2=0.081 $Y2=0.135
r21 11 12 11.9048 $w=2.1e-08 $l=3.5e-08 $layer=Gate_1 $thickness=5.6e-08
+ $X=0.081 $Y=0.0835 $X2=0.081 $Y2=0.1185
r22 10 11 14.6259 $w=2.1e-08 $l=4.3e-08 $layer=Gate_1 $thickness=5.6e-08
+ $X=0.081 $Y=0.0405 $X2=0.081 $Y2=0.0835
r23 10 3 5.44221 $w=2.1e-08 $l=1.6e-08 $layer=Gate_1 $thickness=5.6e-08
+ $X=0.081 $Y=0.0405 $X2=0.081 $Y2=0.0245
.ends

.subckt PM_HB1xp67_ASAP7_75t_R%Y vss 19 13 27 8 11 9 10 7
c1 1 vss 0.00751092f $X=0.162 $Y=0.054
c2 2 vss 0.00760447f $X=0.162 $Y=0.216
c3 7 vss 0.0286576f $X=0.1475 $Y=0.054
c4 8 vss 0.0286029f $X=0.1475 $Y=0.216
c5 9 vss 0.00597594f $X=0.1505 $Y=0.036
c6 10 vss 0.00593038f $X=0.189 $Y=0.234
c7 11 vss 0.00618128f $X=0.189 $Y=0.072
r1 8 2 0.231482 $w=5.4e-08 $l=1.25e-08 $layer=P_src_drn $thickness=1e-09
+ $X=0.1475 $Y=0.216 $X2=0.162 $Y2=0.216
r2 27 8 0.0462963 $w=5.4e-08 $l=2.5e-09 $layer=P_src_drn $thickness=1e-09
+ $X=0.1446 $Y=0.216 $X2=0.1475 $Y2=0.216
r3 2 24 19.3796 $a=3.24e-16 $layer=V0LISD $X=0.162 $Y=0.216 $X2=0.162 $Y2=0.234
r4 24 25 3.14806 $w=1.3e-08 $l=1.35e-08 $layer=M1 $thickness=3.6e-08 $X=0.162
+ $Y=0.234 $X2=0.1755 $Y2=0.234
r5 10 22 7.21452 $w=1.425e-08 $l=3.6e-08 $layer=M1 $thickness=3.6e-08 $X=0.189
+ $Y=0.234 $X2=0.189 $Y2=0.198
r6 10 25 1.96775 $w=1.63333e-08 $l=1.35e-08 $layer=M1 $thickness=3.6e-08
+ $X=0.189 $Y=0.234 $X2=0.1755 $Y2=0.234
r7 21 22 8.39483 $w=1.3e-08 $l=3.6e-08 $layer=M1 $thickness=3.6e-08 $X=0.189
+ $Y=0.162 $X2=0.189 $Y2=0.198
r8 20 21 2.44849 $w=1.3e-08 $l=1.05e-08 $layer=M1 $thickness=3.6e-08 $X=0.189
+ $Y=0.1515 $X2=0.189 $Y2=0.162
r9 19 20 0.46638 $w=1.3e-08 $l=2e-09 $layer=M1 $thickness=3.6e-08 $X=0.19
+ $Y=0.1495 $X2=0.189 $Y2=0.1515
r10 19 18 3.84763 $w=1.3e-08 $l=1.65e-08 $layer=M1 $thickness=3.6e-08 $X=0.19
+ $Y=0.1495 $X2=0.189 $Y2=0.133
r11 17 18 5.82974 $w=1.3e-08 $l=2.5e-08 $layer=M1 $thickness=3.6e-08 $X=0.189
+ $Y=0.108 $X2=0.189 $Y2=0.133
r12 11 16 7.21452 $w=1.425e-08 $l=3.6e-08 $layer=M1 $thickness=3.6e-08 $X=0.189
+ $Y=0.072 $X2=0.189 $Y2=0.036
r13 11 17 8.39483 $w=1.3e-08 $l=3.6e-08 $layer=M1 $thickness=3.6e-08 $X=0.189
+ $Y=0.072 $X2=0.189 $Y2=0.108
r14 15 16 1.96775 $w=1.63333e-08 $l=1.35e-08 $layer=M1 $thickness=3.6e-08
+ $X=0.1755 $Y=0.036 $X2=0.189 $Y2=0.036
r15 14 15 3.14806 $w=1.3e-08 $l=1.35e-08 $layer=M1 $thickness=3.6e-08 $X=0.162
+ $Y=0.036 $X2=0.1755 $Y2=0.036
r16 9 14 2.68168 $w=1.3e-08 $l=1.15e-08 $layer=M1 $thickness=3.6e-08 $X=0.1505
+ $Y=0.036 $X2=0.162 $Y2=0.036
r17 1 14 19.3796 $a=3.24e-16 $layer=V0LISD $X=0.162 $Y=0.054 $X2=0.162 $Y2=0.036
r18 7 1 0.231482 $w=5.4e-08 $l=1.25e-08 $layer=N_src_drn $thickness=1e-09
+ $X=0.1475 $Y=0.054 $X2=0.162 $Y2=0.054
r19 13 7 0.0462963 $w=5.4e-08 $l=2.5e-09 $layer=N_src_drn $thickness=1e-09
+ $X=0.1446 $Y=0.054 $X2=0.1475 $Y2=0.054
.ends

.subckt PM_HB1xp67_ASAP7_75t_R%4 vss 21 27 48 50 18 19 13 14 11 10 1 16 17 9 12
+ 15 20
c1 1 vss 0.00207935f $X=0.135 $Y=0.135
c2 9 vss 0.0615524f $X=0.135 $Y=0.0245
c3 10 vss 0.026706f $X=0.056 $Y=0.0405
c4 11 vss 0.0266978f $X=0.056 $Y=0.2295
c5 12 vss 0.00287571f $X=0.108 $Y=0.036
c6 13 vss 0.000914324f $X=0.135 $Y=0.108
c7 14 vss 0.000914324f $X=0.135 $Y=0.162
c8 15 vss 0.00287571f $X=0.108 $Y=0.234
c9 16 vss 0.00697914f $X=0.0885 $Y=0.036
c10 17 vss 0.00697914f $X=0.0885 $Y=0.234
c11 18 vss 0.00254039f $X=0.108 $Y=0.09
c12 19 vss 0.00254039f $X=0.108 $Y=0.18
c13 20 vss 0.00081572f $X=0.135 $Y=0.135
r1 50 49 0.0925926 $w=2.7e-08 $l=2.5e-09 $layer=P_src_drn $thickness=1e-09
+ $X=0.0713 $Y=0.2295 $X2=0.0685 $Y2=0.2295
r2 11 49 0.462963 $w=2.7e-08 $l=1.25e-08 $layer=P_src_drn $thickness=1e-09
+ $X=0.056 $Y=0.2295 $X2=0.0685 $Y2=0.2295
r3 48 47 0.0925926 $w=2.7e-08 $l=2.5e-09 $layer=N_src_drn $thickness=1e-09
+ $X=0.0713 $Y=0.0405 $X2=0.0685 $Y2=0.0405
r4 10 47 0.462963 $w=2.7e-08 $l=1.25e-08 $layer=N_src_drn $thickness=1e-09
+ $X=0.056 $Y=0.0405 $X2=0.0685 $Y2=0.0405
r5 11 46 19.3796 $a=3.24e-16 $layer=V0LISD $X=0.056 $Y=0.2295 $X2=0.05 $Y2=0.234
r6 10 42 19.3796 $a=3.24e-16 $layer=V0LISD $X=0.056 $Y=0.0405 $X2=0.05 $Y2=0.036
r7 43 44 2.68168 $w=1.3e-08 $l=1.15e-08 $layer=M1 $thickness=3.6e-08 $X=0.059
+ $Y=0.234 $X2=0.0705 $Y2=0.234
r8 43 46 2.09871 $w=1.3e-08 $l=9e-09 $layer=M1 $thickness=3.6e-08 $X=0.059
+ $Y=0.234 $X2=0.05 $Y2=0.234
r9 17 44 4.19742 $w=1.3e-08 $l=1.8e-08 $layer=M1 $thickness=3.6e-08 $X=0.0885
+ $Y=0.234 $X2=0.0705 $Y2=0.234
r10 39 40 2.68168 $w=1.3e-08 $l=1.15e-08 $layer=M1 $thickness=3.6e-08 $X=0.059
+ $Y=0.036 $X2=0.0705 $Y2=0.036
r11 39 42 2.09871 $w=1.3e-08 $l=9e-09 $layer=M1 $thickness=3.6e-08 $X=0.059
+ $Y=0.036 $X2=0.05 $Y2=0.036
r12 16 40 4.19742 $w=1.3e-08 $l=1.8e-08 $layer=M1 $thickness=3.6e-08 $X=0.0885
+ $Y=0.036 $X2=0.0705 $Y2=0.036
r13 15 38 2.5483 $w=1.79e-08 $l=1.8e-08 $layer=M1 $thickness=3.6e-08 $X=0.108
+ $Y=0.234 $X2=0.108 $Y2=0.216
r14 15 17 2.89809 $w=1.53077e-08 $l=1.95e-08 $layer=M1 $thickness=3.6e-08
+ $X=0.108 $Y=0.234 $X2=0.0885 $Y2=0.234
r15 12 36 2.5483 $w=1.79e-08 $l=1.8e-08 $layer=M1 $thickness=3.6e-08 $X=0.108
+ $Y=0.036 $X2=0.108 $Y2=0.054
r16 12 16 2.89809 $w=1.53077e-08 $l=1.95e-08 $layer=M1 $thickness=3.6e-08
+ $X=0.108 $Y=0.036 $X2=0.0885 $Y2=0.036
r17 37 38 4.19742 $w=1.3e-08 $l=1.8e-08 $layer=M1 $thickness=3.6e-08 $X=0.108
+ $Y=0.198 $X2=0.108 $Y2=0.216
r18 19 34 3.01711 $w=1.55e-08 $l=1.8e-08 $layer=M1 $thickness=3.6e-08 $X=0.108
+ $Y=0.18 $X2=0.108 $Y2=0.162
r19 19 37 4.19742 $w=1.3e-08 $l=1.8e-08 $layer=M1 $thickness=3.6e-08 $X=0.108
+ $Y=0.18 $X2=0.108 $Y2=0.198
r20 35 36 4.19742 $w=1.3e-08 $l=1.8e-08 $layer=M1 $thickness=3.6e-08 $X=0.108
+ $Y=0.072 $X2=0.108 $Y2=0.054
r21 18 32 3.01711 $w=1.55e-08 $l=1.8e-08 $layer=M1 $thickness=3.6e-08 $X=0.108
+ $Y=0.09 $X2=0.108 $Y2=0.108
r22 18 35 4.19742 $w=1.3e-08 $l=1.8e-08 $layer=M1 $thickness=3.6e-08 $X=0.108
+ $Y=0.09 $X2=0.108 $Y2=0.072
r23 33 34 1.96775 $w=1.63333e-08 $l=1.35e-08 $layer=M1 $thickness=3.6e-08
+ $X=0.1215 $Y=0.162 $X2=0.108 $Y2=0.162
r24 14 30 1.96775 $w=1.63333e-08 $l=1.35e-08 $layer=M1 $thickness=3.6e-08
+ $X=0.135 $Y=0.162 $X2=0.135 $Y2=0.1485
r25 14 33 1.96775 $w=1.63333e-08 $l=1.35e-08 $layer=M1 $thickness=3.6e-08
+ $X=0.135 $Y=0.162 $X2=0.1215 $Y2=0.162
r26 31 32 1.96775 $w=1.63333e-08 $l=1.35e-08 $layer=M1 $thickness=3.6e-08
+ $X=0.1215 $Y=0.108 $X2=0.108 $Y2=0.108
r27 13 29 1.96775 $w=1.63333e-08 $l=1.35e-08 $layer=M1 $thickness=3.6e-08
+ $X=0.135 $Y=0.108 $X2=0.135 $Y2=0.1215
r28 13 31 1.96775 $w=1.63333e-08 $l=1.35e-08 $layer=M1 $thickness=3.6e-08
+ $X=0.135 $Y=0.108 $X2=0.1215 $Y2=0.108
r29 20 29 3.14806 $w=1.3e-08 $l=1.35e-08 $layer=M1 $thickness=3.6e-08 $X=0.135
+ $Y=0.135 $X2=0.135 $Y2=0.1215
r30 20 30 3.14806 $w=1.3e-08 $l=1.35e-08 $layer=M1 $thickness=3.6e-08 $X=0.135
+ $Y=0.135 $X2=0.135 $Y2=0.1485
r31 1 24 10.4265 $w=1.765e-08 $layer=LIG $thickness=5.2e-08 $X=0.135 $Y=0.135
+ $X2=0.135 $Y2=0.135
r32 1 20 19.3796 $a=3.24e-16 $layer=V0LIG $X=0.135 $Y=0.135 $X2=0.135 $Y2=0.135
r33 27 26 14.6259 $w=2.1e-08 $l=4.3e-08 $layer=Gate_1 $thickness=5.6e-08
+ $X=0.135 $Y=0.216 $X2=0.135 $Y2=0.173
r34 25 26 7.31297 $w=2.1e-08 $l=2.15e-08 $layer=Gate_1 $thickness=5.6e-08
+ $X=0.135 $Y=0.1515 $X2=0.135 $Y2=0.173
r35 24 25 5.79936 $w=2.03333e-08 $l=1.65e-08 $layer=Gate_1 $thickness=5.6e-08
+ $X=0.135 $Y=0.135 $X2=0.135 $Y2=0.1515
r36 23 24 5.79936 $w=2.03333e-08 $l=1.65e-08 $layer=Gate_1 $thickness=5.6e-08
+ $X=0.135 $Y=0.1185 $X2=0.135 $Y2=0.135
r37 22 23 7.31297 $w=2.1e-08 $l=2.15e-08 $layer=Gate_1 $thickness=5.6e-08
+ $X=0.135 $Y=0.097 $X2=0.135 $Y2=0.1185
r38 21 22 14.6259 $w=2.1e-08 $l=4.3e-08 $layer=Gate_1 $thickness=5.6e-08
+ $X=0.135 $Y=0.054 $X2=0.135 $Y2=0.097
r39 21 9 10.0341 $w=2.1e-08 $l=2.95e-08 $layer=Gate_1 $thickness=5.6e-08
+ $X=0.135 $Y=0.054 $X2=0.135 $Y2=0.0245
.ends

* End of included file HB1xp67_ASAP7_75t_R.pex.sp.pex

*
.subckt HB1xp67_ASAP7_75t_CUSTOM_4_25_0_7 VSS VDD A Y
*
* VSS VSS
* VDD VDD
* A A
* Y Y
*
*

M0 VSS N_M0_g N_M0_s VSS nmos_rvt L=2e-08 W=2.7e-08 nfin=1 $X=0.071 $Y=0.027
M1 N_M1_d N_M1_g VSS VSS nmos_rvt L=2e-08 W=5.4e-08 nfin=2 $X=0.125 $Y=0.027
M2 VDD N_M2_g N_M2_s VDD pmos_rvt L=2e-08 W=2.7e-08 nfin=1 $X=0.071 $Y=0.216
M3 N_M3_d N_M3_g VDD VDD pmos_rvt L=2e-08 W=5.4e-08 nfin=2 $X=0.125 $Y=0.189

* .include "HB1xp67_ASAP7_75t_R.pex.sp.pxi"

* Start of included file HB1xp67_ASAP7_75t_R.pex.sp.pxi
x_PM_HB1xp67_ASAP7_75t_R%A vss A N_M0_g N_M2_g N_A_3 N_A_9 N_A_1 N_A_4 N_A_6
+ PM_HB1xp67_ASAP7_75t_R%A
x_PM_HB1xp67_ASAP7_75t_R%Y vss Y N_M1_d N_M3_d N_Y_8 N_Y_11 N_Y_9 N_Y_10 N_Y_7
+ PM_HB1xp67_ASAP7_75t_R%Y
cc_1 N_Y_8 N_4_1 0.000864372f $X=0.1475 $Y=0.216
cc_2 N_Y_8 N_4_13 0.000992057f $X=0.1475 $Y=0.216
cc_3 N_Y_11 N_4_14 0.000992057f $X=0.189 $Y=0.072
cc_4 N_Y_9 N_4_12 0.00114177f $X=0.1505 $Y=0.036
cc_5 N_Y_10 N_4_15 0.00116026f $X=0.189 $Y=0.234
cc_6 N_Y_11 N_4_20 0.00353867f $X=0.189 $Y=0.072
cc_7 N_Y_7 N_4_9 0.0107715f $X=0.1475 $Y=0.054
cc_8 N_Y_8 N_4_9 0.0439764f $X=0.1475 $Y=0.216
x_PM_HB1xp67_ASAP7_75t_R%4 vss N_M1_g N_M3_g N_M0_s N_M2_s N_4_18 N_4_19 N_4_13
+ N_4_14 N_4_11 N_4_10 N_4_1 N_4_16 N_4_17 N_4_9 N_4_12 N_4_15 N_4_20
+ PM_HB1xp67_ASAP7_75t_R%4
cc_9 N_4_18 N_A_3 0.000647f $X=0.108 $Y=0.09
cc_10 N_4_19 N_A_3 0.000647f $X=0.108 $Y=0.18
cc_11 N_4_13 N_A_3 0.00167214f $X=0.135 $Y=0.108
cc_12 N_4_14 N_A_9 0.00228993f $X=0.135 $Y=0.162
cc_13 N_4_11 N_A_3 0.0065425f $X=0.056 $Y=0.2295
cc_14 N_4_10 N_A_3 0.00654172f $X=0.056 $Y=0.0405
cc_15 N_4_1 N_A_1 0.0028904f $X=0.135 $Y=0.135
cc_16 N_4_16 N_A_4 0.00325699f $X=0.0885 $Y=0.036
cc_17 N_4_17 N_A_6 0.00326735f $X=0.0885 $Y=0.234
cc_18 N_4_9 N_A_3 0.0302377f $X=0.135 $Y=0.0245

* End of included file HB1xp67_ASAP7_75t_R.pex.sp.pxi
.ends

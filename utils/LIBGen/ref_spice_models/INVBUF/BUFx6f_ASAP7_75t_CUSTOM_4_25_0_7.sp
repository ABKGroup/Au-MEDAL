.subckt PM_BUFx6f_ASAP7_75t_R%A vss 23 9 15 28 31 4 7 8 3 1
c1 1 vss 0.00968027f $X=0.075 $Y=0.1345
c2 3 vss 0.0882634f $X=0.081 $Y=0.0245
c3 4 vss 0.0810694f $X=0.135 $Y=0.1345
c4 5 vss 0.00167674f $X=0.027 $Y=0.135
c5 6 vss 0.0135421f $X=0.027 $Y=0.0855
c6 7 vss 0.0135493f $X=0.027 $Y=0.1845
c7 8 vss 0.00312308f $X=0.0442 $Y=0.135
r1 5 8 2.84222 $w=1.56087e-08 $l=1.72e-08 $layer=M1 $thickness=3.6e-08 $X=0.027
+ $Y=0.135 $X2=0.0442 $Y2=0.135
r2 5 6 10.3626 $w=1.39091e-08 $l=4.95e-08 $layer=M1 $thickness=3.6e-08 $X=0.027
+ $Y=0.135 $X2=0.027 $Y2=0.0855
r3 5 7 10.3626 $w=1.39091e-08 $l=4.95e-08 $layer=M1 $thickness=3.6e-08 $X=0.027
+ $Y=0.135 $X2=0.027 $Y2=0.1845
r4 31 30 16.4967 $w=2.1e-08 $l=4.85e-08 $layer=Gate_1 $thickness=5.6e-08
+ $X=0.135 $Y=0.2025 $X2=0.135 $Y2=0.154
r5 28 29 16.3266 $w=2.1e-08 $l=4.8e-08 $layer=Gate_1 $thickness=5.6e-08
+ $X=0.135 $Y=0.0675 $X2=0.135 $Y2=0.1155
r6 4 21 6.4735 $w=2.13953e-08 $layer=Gate_1 $thickness=5.22791e-08 $X=0.135
+ $Y=0.1345 $X2=0.135 $Y2=0.1345
r7 4 29 6.6582 $w=2.03947e-08 $l=1.9e-08 $layer=Gate_1 $thickness=5.6e-08
+ $X=0.135 $Y=0.1345 $X2=0.135 $Y2=0.1155
r8 4 30 6.82827 $w=2.04103e-08 $l=1.95e-08 $layer=Gate_1 $thickness=5.6e-08
+ $X=0.135 $Y=0.1345 $X2=0.135 $Y2=0.154
r9 24 25 2.97317 $w=1.3e-08 $l=1.28e-08 $layer=M1 $thickness=3.6e-08 $X=0.0572
+ $Y=0.135 $X2=0.07 $Y2=0.135
r10 23 24 0.991056 $w=1.3e-08 $l=4.2e-09 $layer=M1 $thickness=3.6e-08 $X=0.053
+ $Y=0.136 $X2=0.0572 $Y2=0.135
r11 23 8 2.04041 $w=1.3e-08 $l=8.8e-09 $layer=M1 $thickness=3.6e-08 $X=0.053
+ $Y=0.136 $X2=0.0442 $Y2=0.135
r12 20 21 10.1596 $w=1.87815e-08 $l=2.7e-08 $layer=LIG $thickness=4.8e-08
+ $X=0.108 $Y=0.1345 $X2=0.135 $Y2=0.1345
r13 19 25 19.3796 $a=3.24e-16 $layer=V0LIG $X=0.066 $Y=0.1345 $X2=0.07 $Y2=0.135
r14 17 20 9.21311 $w=1.80478e-08 $l=2.3e-08 $layer=LIG $thickness=4.8e-08
+ $X=0.085 $Y=0.1345 $X2=0.108 $Y2=0.1345
r15 1 17 2.36633 $w=2.3e-08 $l=1e-08 $layer=LIG $thickness=4.8e-08 $X=0.075
+ $Y=0.1345 $X2=0.085 $Y2=0.1345
r16 1 19 3.23868 $w=1.92778e-08 $l=9e-09 $layer=LIG $thickness=4.8e-08 $X=0.075
+ $Y=0.1345 $X2=0.066 $Y2=0.1345
r17 15 14 14.6259 $w=2.1e-08 $l=4.3e-08 $layer=Gate_1 $thickness=5.6e-08
+ $X=0.081 $Y=0.2025 $X2=0.081 $Y2=0.1595
r18 13 14 2.7211 $w=2.1e-08 $l=8e-09 $layer=Gate_1 $thickness=5.6e-08 $X=0.081
+ $Y=0.1515 $X2=0.081 $Y2=0.1595
r19 12 13 5.97793 $w=2.03235e-08 $l=1.7e-08 $layer=Gate_1 $thickness=5.6e-08
+ $X=0.081 $Y=0.1345 $X2=0.081 $Y2=0.1515
r20 12 17 5.52696 $w=2.10286e-08 $l=4e-09 $layer=Gate_1 $thickness=5.32571e-08
+ $X=0.081 $Y=0.1345 $X2=0.085 $Y2=0.1345
r21 11 12 5.80786 $w=2.0303e-08 $l=1.65e-08 $layer=Gate_1 $thickness=5.6e-08
+ $X=0.081 $Y=0.118 $X2=0.081 $Y2=0.1345
r22 10 11 2.55104 $w=2.1e-08 $l=7.5e-09 $layer=Gate_1 $thickness=5.6e-08
+ $X=0.081 $Y=0.1105 $X2=0.081 $Y2=0.118
r23 9 10 14.6259 $w=2.1e-08 $l=4.3e-08 $layer=Gate_1 $thickness=5.6e-08
+ $X=0.081 $Y=0.0675 $X2=0.081 $Y2=0.1105
r24 9 3 14.6259 $w=2.1e-08 $l=4.3e-08 $layer=Gate_1 $thickness=5.6e-08 $X=0.081
+ $Y=0.0675 $X2=0.081 $Y2=0.0245
.ends

.subckt PM_BUFx6f_ASAP7_75t_R%Y vss 51 32 33 43 44 47 48 62 63 66 67 70 71 24
+ 22 20 23 21 29 5 6 3 4 1 2 27 28 19
c1 1 vss 0.00831381f $X=0.216 $Y=0.0675
c2 2 vss 0.00828242f $X=0.216 $Y=0.2025
c3 3 vss 0.00825198f $X=0.324 $Y=0.0675
c4 4 vss 0.00825198f $X=0.324 $Y=0.2025
c5 5 vss 0.00830859f $X=0.432 $Y=0.0675
c6 6 vss 0.00830859f $X=0.432 $Y=0.2025
c7 19 vss 0.00434787f $X=0.2015 $Y=0.0675
c8 20 vss 0.00431951f $X=0.3095 $Y=0.0675
c9 21 vss 0.00424879f $X=0.4175 $Y=0.0675
c10 22 vss 0.00434343f $X=0.2015 $Y=0.2025
c11 23 vss 0.00431462f $X=0.3095 $Y=0.2025
c12 24 vss 0.00424557f $X=0.4175 $Y=0.2025
c13 25 vss 0.00283503f $X=0.513 $Y=0.036
c14 26 vss 0.00283503f $X=0.513 $Y=0.234
c15 27 vss 0.0266399f $X=0.2045 $Y=0.036
c16 28 vss 0.0266405f $X=0.4885 $Y=0.234
c17 29 vss 0.00782542f $X=0.513 $Y=0.0855
r1 71 69 0.0308642 $w=8.1e-08 $l=2.5e-09 $layer=P_src_drn $thickness=1e-09
+ $X=0.4493 $Y=0.2025 $X2=0.4465 $Y2=0.2025
r2 6 69 0.179012 $w=8.1e-08 $l=1.45e-08 $layer=P_src_drn $thickness=1e-09
+ $X=0.432 $Y=0.2025 $X2=0.4465 $Y2=0.2025
r3 24 6 0.179012 $w=8.1e-08 $l=1.45e-08 $layer=P_src_drn $thickness=1e-09
+ $X=0.4175 $Y=0.2025 $X2=0.432 $Y2=0.2025
r4 70 24 0.0308642 $w=8.1e-08 $l=2.5e-09 $layer=P_src_drn $thickness=1e-09
+ $X=0.4146 $Y=0.2025 $X2=0.4175 $Y2=0.2025
r5 67 65 0.0308642 $w=8.1e-08 $l=2.5e-09 $layer=P_src_drn $thickness=1e-09
+ $X=0.3413 $Y=0.2025 $X2=0.3385 $Y2=0.2025
r6 4 65 0.179012 $w=8.1e-08 $l=1.45e-08 $layer=P_src_drn $thickness=1e-09
+ $X=0.324 $Y=0.2025 $X2=0.3385 $Y2=0.2025
r7 23 4 0.179012 $w=8.1e-08 $l=1.45e-08 $layer=P_src_drn $thickness=1e-09
+ $X=0.3095 $Y=0.2025 $X2=0.324 $Y2=0.2025
r8 66 23 0.0308642 $w=8.1e-08 $l=2.5e-09 $layer=P_src_drn $thickness=1e-09
+ $X=0.3066 $Y=0.2025 $X2=0.3095 $Y2=0.2025
r9 63 61 0.0308642 $w=8.1e-08 $l=2.5e-09 $layer=P_src_drn $thickness=1e-09
+ $X=0.2333 $Y=0.2025 $X2=0.2305 $Y2=0.2025
r10 2 61 0.179012 $w=8.1e-08 $l=1.45e-08 $layer=P_src_drn $thickness=1e-09
+ $X=0.216 $Y=0.2025 $X2=0.2305 $Y2=0.2025
r11 22 2 0.179012 $w=8.1e-08 $l=1.45e-08 $layer=P_src_drn $thickness=1e-09
+ $X=0.2015 $Y=0.2025 $X2=0.216 $Y2=0.2025
r12 62 22 0.0308642 $w=8.1e-08 $l=2.5e-09 $layer=P_src_drn $thickness=1e-09
+ $X=0.1986 $Y=0.2025 $X2=0.2015 $Y2=0.2025
r13 6 58 19.3796 $a=3.24e-16 $layer=V0LISD $X=0.432 $Y=0.2025 $X2=0.432
+ $Y2=0.234
r14 4 56 19.3796 $a=3.24e-16 $layer=V0LISD $X=0.324 $Y=0.2025 $X2=0.324
+ $Y2=0.234
r15 2 54 19.3796 $a=3.24e-16 $layer=V0LISD $X=0.216 $Y=0.2025 $X2=0.216
+ $Y2=0.234
r16 58 59 5.82974 $w=1.3e-08 $l=2.5e-08 $layer=M1 $thickness=3.6e-08 $X=0.432
+ $Y=0.234 $X2=0.457 $Y2=0.234
r17 57 58 12.5922 $w=1.3e-08 $l=5.4e-08 $layer=M1 $thickness=3.6e-08 $X=0.378
+ $Y=0.234 $X2=0.432 $Y2=0.234
r18 56 57 12.5922 $w=1.3e-08 $l=5.4e-08 $layer=M1 $thickness=3.6e-08 $X=0.324
+ $Y=0.234 $X2=0.378 $Y2=0.234
r19 55 56 12.5922 $w=1.3e-08 $l=5.4e-08 $layer=M1 $thickness=3.6e-08 $X=0.27
+ $Y=0.234 $X2=0.324 $Y2=0.234
r20 54 55 12.5922 $w=1.3e-08 $l=5.4e-08 $layer=M1 $thickness=3.6e-08 $X=0.216
+ $Y=0.234 $X2=0.27 $Y2=0.234
r21 28 59 7.34548 $w=1.3e-08 $l=3.15e-08 $layer=M1 $thickness=3.6e-08 $X=0.4885
+ $Y=0.234 $X2=0.457 $Y2=0.234
r22 26 52 8.78613 $w=1.49709e-08 $l=4.48e-08 $layer=M1 $thickness=3.6e-08
+ $X=0.513 $Y=0.234 $X2=0.513 $Y2=0.1892
r23 26 28 4.06404 $w=1.48367e-08 $l=2.45e-08 $layer=M1 $thickness=3.6e-08
+ $X=0.513 $Y=0.234 $X2=0.4885 $Y2=0.234
r24 51 52 8.45313 $w=1.3e-08 $l=3.62e-08 $layer=M1 $thickness=3.6e-08 $X=0.514
+ $Y=0.153 $X2=0.513 $Y2=0.1892
r25 51 50 1.10765 $w=1.3e-08 $l=4.8e-09 $layer=M1 $thickness=3.6e-08 $X=0.514
+ $Y=0.153 $X2=0.513 $Y2=0.1482
r26 49 50 3.08976 $w=1.3e-08 $l=1.32e-08 $layer=M1 $thickness=3.6e-08 $X=0.513
+ $Y=0.135 $X2=0.513 $Y2=0.1482
r27 29 49 11.5429 $w=1.3e-08 $l=4.95e-08 $layer=M1 $thickness=3.6e-08 $X=0.513
+ $Y=0.0855 $X2=0.513 $Y2=0.135
r28 48 46 0.0308642 $w=8.1e-08 $l=2.5e-09 $layer=N_src_drn $thickness=1e-09
+ $X=0.4493 $Y=0.0675 $X2=0.4465 $Y2=0.0675
r29 5 46 0.179012 $w=8.1e-08 $l=1.45e-08 $layer=N_src_drn $thickness=1e-09
+ $X=0.432 $Y=0.0675 $X2=0.4465 $Y2=0.0675
r30 21 5 0.179012 $w=8.1e-08 $l=1.45e-08 $layer=N_src_drn $thickness=1e-09
+ $X=0.4175 $Y=0.0675 $X2=0.432 $Y2=0.0675
r31 47 21 0.0308642 $w=8.1e-08 $l=2.5e-09 $layer=N_src_drn $thickness=1e-09
+ $X=0.4146 $Y=0.0675 $X2=0.4175 $Y2=0.0675
r32 44 42 0.0308642 $w=8.1e-08 $l=2.5e-09 $layer=N_src_drn $thickness=1e-09
+ $X=0.3413 $Y=0.0675 $X2=0.3385 $Y2=0.0675
r33 3 42 0.179012 $w=8.1e-08 $l=1.45e-08 $layer=N_src_drn $thickness=1e-09
+ $X=0.324 $Y=0.0675 $X2=0.3385 $Y2=0.0675
r34 20 3 0.179012 $w=8.1e-08 $l=1.45e-08 $layer=N_src_drn $thickness=1e-09
+ $X=0.3095 $Y=0.0675 $X2=0.324 $Y2=0.0675
r35 43 20 0.0308642 $w=8.1e-08 $l=2.5e-09 $layer=N_src_drn $thickness=1e-09
+ $X=0.3066 $Y=0.0675 $X2=0.3095 $Y2=0.0675
r36 25 40 4.06404 $w=1.48367e-08 $l=2.45e-08 $layer=M1 $thickness=3.6e-08
+ $X=0.513 $Y=0.036 $X2=0.4885 $Y2=0.036
r37 25 29 9.89378 $w=1.47818e-08 $l=4.95e-08 $layer=M1 $thickness=3.6e-08
+ $X=0.513 $Y=0.036 $X2=0.513 $Y2=0.0855
r38 5 38 19.3796 $a=3.24e-16 $layer=V0LISD $X=0.432 $Y=0.0675 $X2=0.432
+ $Y2=0.036
r39 3 36 19.3796 $a=3.24e-16 $layer=V0LISD $X=0.324 $Y=0.0675 $X2=0.324
+ $Y2=0.036
r40 39 40 7.34548 $w=1.3e-08 $l=3.15e-08 $layer=M1 $thickness=3.6e-08 $X=0.457
+ $Y=0.036 $X2=0.4885 $Y2=0.036
r41 38 39 5.82974 $w=1.3e-08 $l=2.5e-08 $layer=M1 $thickness=3.6e-08 $X=0.432
+ $Y=0.036 $X2=0.457 $Y2=0.036
r42 37 38 12.5922 $w=1.3e-08 $l=5.4e-08 $layer=M1 $thickness=3.6e-08 $X=0.378
+ $Y=0.036 $X2=0.432 $Y2=0.036
r43 36 37 12.5922 $w=1.3e-08 $l=5.4e-08 $layer=M1 $thickness=3.6e-08 $X=0.324
+ $Y=0.036 $X2=0.378 $Y2=0.036
r44 35 36 12.5922 $w=1.3e-08 $l=5.4e-08 $layer=M1 $thickness=3.6e-08 $X=0.27
+ $Y=0.036 $X2=0.324 $Y2=0.036
r45 34 35 12.5922 $w=1.3e-08 $l=5.4e-08 $layer=M1 $thickness=3.6e-08 $X=0.216
+ $Y=0.036 $X2=0.27 $Y2=0.036
r46 27 34 2.68168 $w=1.3e-08 $l=1.15e-08 $layer=M1 $thickness=3.6e-08 $X=0.2045
+ $Y=0.036 $X2=0.216 $Y2=0.036
r47 1 34 19.3796 $a=3.24e-16 $layer=V0LISD $X=0.216 $Y=0.0675 $X2=0.216
+ $Y2=0.036
r48 33 31 0.0308642 $w=8.1e-08 $l=2.5e-09 $layer=N_src_drn $thickness=1e-09
+ $X=0.2333 $Y=0.0675 $X2=0.2305 $Y2=0.0675
r49 1 31 0.179012 $w=8.1e-08 $l=1.45e-08 $layer=N_src_drn $thickness=1e-09
+ $X=0.216 $Y=0.0675 $X2=0.2305 $Y2=0.0675
r50 19 1 0.179012 $w=8.1e-08 $l=1.45e-08 $layer=N_src_drn $thickness=1e-09
+ $X=0.2015 $Y=0.0675 $X2=0.216 $Y2=0.0675
r51 32 19 0.0308642 $w=8.1e-08 $l=2.5e-09 $layer=N_src_drn $thickness=1e-09
+ $X=0.1986 $Y=0.0675 $X2=0.2015 $Y2=0.0675
.ends

.subckt PM_BUFx6f_ASAP7_75t_R%4 vss 28 32 72 75 78 81 84 87 90 93 97 101 111
+ 112 115 116 1 9 20 26 25 22 23 24 14 8 21 15 16 18 19 27 17
c1 1 vss 0.0437097f $X=0.1795 $Y=0.135
c2 8 vss 0.0134144f $X=0.108 $Y=0.0675
c3 9 vss 0.0134364f $X=0.108 $Y=0.2025
c4 14 vss 0.0824772f $X=0.189 $Y=0.0245
c5 15 vss 0.0828153f $X=0.243 $Y=0.135
c6 16 vss 0.0828095f $X=0.297 $Y=0.135
c7 17 vss 0.0826694f $X=0.351 $Y=0.135
c8 18 vss 0.0831204f $X=0.405 $Y=0.135
c9 19 vss 0.0831105f $X=0.459 $Y=0.135
c10 20 vss 0.0114795f $X=0.0935 $Y=0.0675
c11 21 vss 0.0112793f $X=0.0935 $Y=0.2025
c12 22 vss 0.00860094f $X=0.135 $Y=0.036
c13 23 vss 0.00860094f $X=0.135 $Y=0.234
c14 24 vss 0.00243961f $X=0.135 $Y=0.135
c15 25 vss 0.00513294f $X=0.135 $Y=0.0855
c16 26 vss 0.00533316f $X=0.135 $Y=0.1845
c17 27 vss 0.00910999f $X=0.162 $Y=0.135
r1 116 114 0.0308642 $w=8.1e-08 $l=2.5e-09 $layer=P_src_drn $thickness=1e-09
+ $X=0.1253 $Y=0.2025 $X2=0.1225 $Y2=0.2025
r2 9 114 0.179012 $w=8.1e-08 $l=1.45e-08 $layer=P_src_drn $thickness=1e-09
+ $X=0.108 $Y=0.2025 $X2=0.1225 $Y2=0.2025
r3 21 9 0.179012 $w=8.1e-08 $l=1.45e-08 $layer=P_src_drn $thickness=1e-09
+ $X=0.0935 $Y=0.2025 $X2=0.108 $Y2=0.2025
r4 115 21 0.0308642 $w=8.1e-08 $l=2.5e-09 $layer=P_src_drn $thickness=1e-09
+ $X=0.0906 $Y=0.2025 $X2=0.0935 $Y2=0.2025
r5 112 110 0.0308642 $w=8.1e-08 $l=2.5e-09 $layer=N_src_drn $thickness=1e-09
+ $X=0.1253 $Y=0.0675 $X2=0.1225 $Y2=0.0675
r6 8 110 0.179012 $w=8.1e-08 $l=1.45e-08 $layer=N_src_drn $thickness=1e-09
+ $X=0.108 $Y=0.0675 $X2=0.1225 $Y2=0.0675
r7 20 8 0.179012 $w=8.1e-08 $l=1.45e-08 $layer=N_src_drn $thickness=1e-09
+ $X=0.0935 $Y=0.0675 $X2=0.108 $Y2=0.0675
r8 111 20 0.0308642 $w=8.1e-08 $l=2.5e-09 $layer=N_src_drn $thickness=1e-09
+ $X=0.0906 $Y=0.0675 $X2=0.0935 $Y2=0.0675
r9 9 107 19.3796 $a=3.24e-16 $layer=V0LISD $X=0.108 $Y=0.2025 $X2=0.108
+ $Y2=0.234
r10 8 104 19.3796 $a=3.24e-16 $layer=V0LISD $X=0.108 $Y=0.0675 $X2=0.108
+ $Y2=0.036
r11 107 108 3.14806 $w=1.3e-08 $l=1.35e-08 $layer=M1 $thickness=3.6e-08
+ $X=0.108 $Y=0.234 $X2=0.1215 $Y2=0.234
r12 23 26 10.3626 $w=1.39091e-08 $l=4.95e-08 $layer=M1 $thickness=3.6e-08
+ $X=0.135 $Y=0.234 $X2=0.135 $Y2=0.1845
r13 23 108 1.96775 $w=1.63333e-08 $l=1.35e-08 $layer=M1 $thickness=3.6e-08
+ $X=0.135 $Y=0.234 $X2=0.1215 $Y2=0.234
r14 104 105 3.14806 $w=1.3e-08 $l=1.35e-08 $layer=M1 $thickness=3.6e-08
+ $X=0.108 $Y=0.036 $X2=0.1215 $Y2=0.036
r15 22 25 10.3626 $w=1.39091e-08 $l=4.95e-08 $layer=M1 $thickness=3.6e-08
+ $X=0.135 $Y=0.036 $X2=0.135 $Y2=0.0855
r16 22 105 1.96775 $w=1.63333e-08 $l=1.35e-08 $layer=M1 $thickness=3.6e-08
+ $X=0.135 $Y=0.036 $X2=0.1215 $Y2=0.036
r17 24 27 5.11582 $w=1.46667e-08 $l=2.7e-08 $layer=M1 $thickness=3.6e-08
+ $X=0.135 $Y=0.135 $X2=0.162 $Y2=0.135
r18 24 25 10.3626 $w=1.39091e-08 $l=4.95e-08 $layer=M1 $thickness=3.6e-08
+ $X=0.135 $Y=0.135 $X2=0.135 $Y2=0.0855
r19 24 26 10.3626 $w=1.39091e-08 $l=4.95e-08 $layer=M1 $thickness=3.6e-08
+ $X=0.135 $Y=0.135 $X2=0.135 $Y2=0.1845
r20 101 100 14.6259 $w=2.1e-08 $l=4.3e-08 $layer=Gate_1 $thickness=5.6e-08
+ $X=0.459 $Y=0.2025 $X2=0.459 $Y2=0.1595
r21 99 100 2.7211 $w=2.1e-08 $l=8e-09 $layer=Gate_1 $thickness=5.6e-08 $X=0.459
+ $Y=0.1515 $X2=0.459 $Y2=0.1595
r22 97 98 14.6259 $w=2.1e-08 $l=4.3e-08 $layer=Gate_1 $thickness=5.6e-08
+ $X=0.459 $Y=0.0675 $X2=0.459 $Y2=0.1105
r23 95 98 2.7211 $w=2.1e-08 $l=8e-09 $layer=Gate_1 $thickness=5.6e-08 $X=0.459
+ $Y=0.1185 $X2=0.459 $Y2=0.1105
r24 19 55 6.27904 $w=2.09e-08 $layer=Gate_1 $thickness=5.24e-08 $X=0.459
+ $Y=0.135 $X2=0.459 $Y2=0.135
r25 19 95 5.79936 $w=2.03333e-08 $l=1.65e-08 $layer=Gate_1 $thickness=5.6e-08
+ $X=0.459 $Y=0.135 $X2=0.459 $Y2=0.1185
r26 19 99 5.79936 $w=2.03333e-08 $l=1.65e-08 $layer=Gate_1 $thickness=5.6e-08
+ $X=0.459 $Y=0.135 $X2=0.459 $Y2=0.1515
r27 93 92 16.4967 $w=2.1e-08 $l=4.85e-08 $layer=Gate_1 $thickness=5.6e-08
+ $X=0.405 $Y=0.2025 $X2=0.405 $Y2=0.154
r28 90 91 16.4967 $w=2.1e-08 $l=4.85e-08 $layer=Gate_1 $thickness=5.6e-08
+ $X=0.405 $Y=0.0675 $X2=0.405 $Y2=0.116
r29 18 51 6.27904 $w=2.09e-08 $layer=Gate_1 $thickness=5.24e-08 $X=0.405
+ $Y=0.135 $X2=0.405 $Y2=0.135
r30 18 91 6.6497 $w=2.04211e-08 $l=1.9e-08 $layer=Gate_1 $thickness=5.6e-08
+ $X=0.405 $Y=0.135 $X2=0.405 $Y2=0.116
r31 18 92 6.6497 $w=2.04211e-08 $l=1.9e-08 $layer=Gate_1 $thickness=5.6e-08
+ $X=0.405 $Y=0.135 $X2=0.405 $Y2=0.154
r32 87 86 16.4967 $w=2.1e-08 $l=4.85e-08 $layer=Gate_1 $thickness=5.6e-08
+ $X=0.351 $Y=0.2025 $X2=0.351 $Y2=0.154
r33 84 85 16.4967 $w=2.1e-08 $l=4.85e-08 $layer=Gate_1 $thickness=5.6e-08
+ $X=0.351 $Y=0.0675 $X2=0.351 $Y2=0.116
r34 17 47 6.27904 $w=2.09e-08 $layer=Gate_1 $thickness=5.24e-08 $X=0.351
+ $Y=0.135 $X2=0.351 $Y2=0.135
r35 17 85 6.6497 $w=2.04211e-08 $l=1.9e-08 $layer=Gate_1 $thickness=5.6e-08
+ $X=0.351 $Y=0.135 $X2=0.351 $Y2=0.116
r36 17 86 6.6497 $w=2.04211e-08 $l=1.9e-08 $layer=Gate_1 $thickness=5.6e-08
+ $X=0.351 $Y=0.135 $X2=0.351 $Y2=0.154
r37 81 80 16.4967 $w=2.1e-08 $l=4.85e-08 $layer=Gate_1 $thickness=5.6e-08
+ $X=0.297 $Y=0.2025 $X2=0.297 $Y2=0.154
r38 78 79 16.4967 $w=2.1e-08 $l=4.85e-08 $layer=Gate_1 $thickness=5.6e-08
+ $X=0.297 $Y=0.0675 $X2=0.297 $Y2=0.116
r39 16 43 6.27904 $w=2.09e-08 $layer=Gate_1 $thickness=5.24e-08 $X=0.297
+ $Y=0.135 $X2=0.297 $Y2=0.135
r40 16 79 6.6497 $w=2.04211e-08 $l=1.9e-08 $layer=Gate_1 $thickness=5.6e-08
+ $X=0.297 $Y=0.135 $X2=0.297 $Y2=0.116
r41 16 80 6.6497 $w=2.04211e-08 $l=1.9e-08 $layer=Gate_1 $thickness=5.6e-08
+ $X=0.297 $Y=0.135 $X2=0.297 $Y2=0.154
r42 75 74 16.4967 $w=2.1e-08 $l=4.85e-08 $layer=Gate_1 $thickness=5.6e-08
+ $X=0.243 $Y=0.2025 $X2=0.243 $Y2=0.154
r43 72 73 16.4967 $w=2.1e-08 $l=4.85e-08 $layer=Gate_1 $thickness=5.6e-08
+ $X=0.243 $Y=0.0675 $X2=0.243 $Y2=0.116
r44 15 39 6.27904 $w=2.09e-08 $layer=Gate_1 $thickness=5.24e-08 $X=0.243
+ $Y=0.135 $X2=0.243 $Y2=0.135
r45 15 73 6.6497 $w=2.04211e-08 $l=1.9e-08 $layer=Gate_1 $thickness=5.6e-08
+ $X=0.243 $Y=0.135 $X2=0.243 $Y2=0.116
r46 15 74 6.6497 $w=2.04211e-08 $l=1.9e-08 $layer=Gate_1 $thickness=5.6e-08
+ $X=0.243 $Y=0.135 $X2=0.243 $Y2=0.154
r47 68 69 6.29612 $w=1.3e-08 $l=2.7e-08 $layer=M1 $thickness=3.6e-08 $X=0.432
+ $Y=0.135 $X2=0.459 $Y2=0.135
r48 67 68 6.29612 $w=1.3e-08 $l=2.7e-08 $layer=M1 $thickness=3.6e-08 $X=0.405
+ $Y=0.135 $X2=0.432 $Y2=0.135
r49 66 67 6.29612 $w=1.3e-08 $l=2.7e-08 $layer=M1 $thickness=3.6e-08 $X=0.378
+ $Y=0.135 $X2=0.405 $Y2=0.135
r50 65 66 6.29612 $w=1.3e-08 $l=2.7e-08 $layer=M1 $thickness=3.6e-08 $X=0.351
+ $Y=0.135 $X2=0.378 $Y2=0.135
r51 64 65 6.29612 $w=1.3e-08 $l=2.7e-08 $layer=M1 $thickness=3.6e-08 $X=0.324
+ $Y=0.135 $X2=0.351 $Y2=0.135
r52 63 64 6.29612 $w=1.3e-08 $l=2.7e-08 $layer=M1 $thickness=3.6e-08 $X=0.297
+ $Y=0.135 $X2=0.324 $Y2=0.135
r53 62 63 6.29612 $w=1.3e-08 $l=2.7e-08 $layer=M1 $thickness=3.6e-08 $X=0.27
+ $Y=0.135 $X2=0.297 $Y2=0.135
r54 61 62 6.29612 $w=1.3e-08 $l=2.7e-08 $layer=M1 $thickness=3.6e-08 $X=0.243
+ $Y=0.135 $X2=0.27 $Y2=0.135
r55 60 61 5.82974 $w=1.3e-08 $l=2.5e-08 $layer=M1 $thickness=3.6e-08 $X=0.218
+ $Y=0.135 $X2=0.243 $Y2=0.135
r56 59 60 4.19742 $w=1.3e-08 $l=1.8e-08 $layer=M1 $thickness=3.6e-08 $X=0.2
+ $Y=0.135 $X2=0.218 $Y2=0.135
r57 58 59 2.56509 $w=1.3e-08 $l=1.1e-08 $layer=M1 $thickness=3.6e-08 $X=0.189
+ $Y=0.135 $X2=0.2 $Y2=0.135
r58 27 58 6.29612 $w=1.3e-08 $l=2.7e-08 $layer=M1 $thickness=3.6e-08 $X=0.162
+ $Y=0.135 $X2=0.189 $Y2=0.135
r59 55 69 19.3796 $a=3.24e-16 $layer=V0LIG $X=0.459 $Y=0.135 $X2=0.459 $Y2=0.135
r60 54 55 2.48102 $w=2.2e-08 $l=9.5e-09 $layer=LIG $thickness=4.8e-08 $X=0.4495
+ $Y=0.135 $X2=0.459 $Y2=0.135
r61 53 54 10.1729 $w=1.54914e-08 $l=1.75e-08 $layer=LIG $thickness=4.8e-08
+ $X=0.432 $Y=0.135 $X2=0.4495 $Y2=0.135
r62 52 53 10.1729 $w=1.54914e-08 $l=1.75e-08 $layer=LIG $thickness=4.8e-08
+ $X=0.4145 $Y=0.135 $X2=0.432 $Y2=0.135
r63 51 52 2.48102 $w=2.2e-08 $l=9.5e-09 $layer=LIG $thickness=4.8e-08 $X=0.405
+ $Y=0.135 $X2=0.4145 $Y2=0.135
r64 51 67 19.3796 $a=3.24e-16 $layer=V0LIG $X=0.405 $Y=0.135 $X2=0.405 $Y2=0.135
r65 50 51 2.48102 $w=2.2e-08 $l=9.5e-09 $layer=LIG $thickness=4.8e-08 $X=0.3955
+ $Y=0.135 $X2=0.405 $Y2=0.135
r66 49 50 10.1729 $w=1.54914e-08 $l=1.75e-08 $layer=LIG $thickness=4.8e-08
+ $X=0.378 $Y=0.135 $X2=0.3955 $Y2=0.135
r67 48 49 10.1729 $w=1.54914e-08 $l=1.75e-08 $layer=LIG $thickness=4.8e-08
+ $X=0.3605 $Y=0.135 $X2=0.378 $Y2=0.135
r68 47 48 2.48102 $w=2.2e-08 $l=9.5e-09 $layer=LIG $thickness=4.8e-08 $X=0.351
+ $Y=0.135 $X2=0.3605 $Y2=0.135
r69 47 65 19.3796 $a=3.24e-16 $layer=V0LIG $X=0.351 $Y=0.135 $X2=0.351 $Y2=0.135
r70 46 47 2.48102 $w=2.2e-08 $l=9.5e-09 $layer=LIG $thickness=4.8e-08 $X=0.3415
+ $Y=0.135 $X2=0.351 $Y2=0.135
r71 45 46 10.1729 $w=1.54914e-08 $l=1.75e-08 $layer=LIG $thickness=4.8e-08
+ $X=0.324 $Y=0.135 $X2=0.3415 $Y2=0.135
r72 44 45 10.1729 $w=1.54914e-08 $l=1.75e-08 $layer=LIG $thickness=4.8e-08
+ $X=0.3065 $Y=0.135 $X2=0.324 $Y2=0.135
r73 43 44 2.48102 $w=2.2e-08 $l=9.5e-09 $layer=LIG $thickness=4.8e-08 $X=0.297
+ $Y=0.135 $X2=0.3065 $Y2=0.135
r74 43 63 19.3796 $a=3.24e-16 $layer=V0LIG $X=0.297 $Y=0.135 $X2=0.297 $Y2=0.135
r75 42 43 2.48102 $w=2.2e-08 $l=9.5e-09 $layer=LIG $thickness=4.8e-08 $X=0.2875
+ $Y=0.135 $X2=0.297 $Y2=0.135
r76 41 42 10.1729 $w=1.54914e-08 $l=1.75e-08 $layer=LIG $thickness=4.8e-08
+ $X=0.27 $Y=0.135 $X2=0.2875 $Y2=0.135
r77 40 41 10.1729 $w=1.54914e-08 $l=1.75e-08 $layer=LIG $thickness=4.8e-08
+ $X=0.2525 $Y=0.135 $X2=0.27 $Y2=0.135
r78 39 40 2.48102 $w=2.2e-08 $l=9.5e-09 $layer=LIG $thickness=4.8e-08 $X=0.243
+ $Y=0.135 $X2=0.2525 $Y2=0.135
r79 39 61 19.3796 $a=3.24e-16 $layer=V0LIG $X=0.243 $Y=0.135 $X2=0.243 $Y2=0.135
r80 38 39 2.48102 $w=2.2e-08 $l=9.5e-09 $layer=LIG $thickness=4.8e-08 $X=0.2335
+ $Y=0.135 $X2=0.243 $Y2=0.135
r81 37 38 10.1729 $w=1.54914e-08 $l=1.75e-08 $layer=LIG $thickness=4.8e-08
+ $X=0.216 $Y=0.135 $X2=0.2335 $Y2=0.135
r82 35 37 10.1729 $w=1.54914e-08 $l=1.75e-08 $layer=LIG $thickness=4.8e-08
+ $X=0.1985 $Y=0.135 $X2=0.216 $Y2=0.135
r83 34 35 2.48102 $w=2.2e-08 $l=9.5e-09 $layer=LIG $thickness=4.8e-08 $X=0.189
+ $Y=0.135 $X2=0.1985 $Y2=0.135
r84 34 58 19.3796 $a=3.24e-16 $layer=V0LIG $X=0.189 $Y=0.135 $X2=0.189 $Y2=0.135
r85 1 34 2.48102 $w=2.2e-08 $l=9.5e-09 $layer=LIG $thickness=4.8e-08 $X=0.1795
+ $Y=0.135 $X2=0.189 $Y2=0.135
r86 32 31 16.4967 $w=2.1e-08 $l=4.85e-08 $layer=Gate_1 $thickness=5.6e-08
+ $X=0.189 $Y=0.2025 $X2=0.189 $Y2=0.154
r87 30 31 6.6497 $w=2.04211e-08 $l=1.9e-08 $layer=Gate_1 $thickness=5.6e-08
+ $X=0.189 $Y=0.135 $X2=0.189 $Y2=0.154
r88 30 35 4.05918 $w=2.0087e-08 $l=9.5e-09 $layer=Gate_1 $thickness=5.56522e-08
+ $X=0.189 $Y=0.135 $X2=0.1985 $Y2=0.135
r89 30 34 6.27904 $w=2.09e-08 $layer=Gate_1 $thickness=5.24e-08 $X=0.189
+ $Y=0.135 $X2=0.189 $Y2=0.135
r90 29 30 6.6497 $w=2.04211e-08 $l=1.9e-08 $layer=Gate_1 $thickness=5.6e-08
+ $X=0.189 $Y=0.116 $X2=0.189 $Y2=0.135
r91 28 29 16.4967 $w=2.1e-08 $l=4.85e-08 $layer=Gate_1 $thickness=5.6e-08
+ $X=0.189 $Y=0.0675 $X2=0.189 $Y2=0.116
r92 28 14 14.6259 $w=2.1e-08 $l=4.3e-08 $layer=Gate_1 $thickness=5.6e-08
+ $X=0.189 $Y=0.0675 $X2=0.189 $Y2=0.0245
.ends

* End of included file BUFx6f_ASAP7_75t_R.pex.sp.pex

*
.subckt BUFx6f_ASAP7_75t_CUSTOM_4_25_0_7 VSS VDD A Y
*
* VSS VSS
* VDD VDD
* A A
* Y Y
*
*

M0 N_M0_d N_M0_g VSS VSS nmos_rvt L=2e-08 W=8.1e-08 nfin=3 $X=0.071 $Y=0.027
M1 N_M1_d N_M1_g VSS VSS nmos_rvt L=2e-08 W=8.1e-08 nfin=3 $X=0.125 $Y=0.027
M2 N_M2_d N_M2_g VSS VSS nmos_rvt L=2e-08 W=8.1e-08 nfin=3 $X=0.179 $Y=0.027
M3 N_M3_d N_M3_g VSS VSS nmos_rvt L=2e-08 W=8.1e-08 nfin=3 $X=0.233 $Y=0.027
M4 N_M4_d N_M4_g VSS VSS nmos_rvt L=2e-08 W=8.1e-08 nfin=3 $X=0.287 $Y=0.027
M5 N_M5_d N_M5_g VSS VSS nmos_rvt L=2e-08 W=8.1e-08 nfin=3 $X=0.341 $Y=0.027
M6 N_M6_d N_M6_g VSS VSS nmos_rvt L=2e-08 W=8.1e-08 nfin=3 $X=0.395 $Y=0.027
M7 N_M7_d N_M7_g VSS VSS nmos_rvt L=2e-08 W=8.1e-08 nfin=3 $X=0.449 $Y=0.027
M8 N_M8_d N_M8_g VDD VDD pmos_rvt L=2e-08 W=8.1e-08 nfin=3 $X=0.071 $Y=0.162
M9 N_M9_d N_M9_g VDD VDD pmos_rvt L=2e-08 W=8.1e-08 nfin=3 $X=0.125 $Y=0.162
M10 N_M10_d N_M10_g VDD VDD pmos_rvt L=2e-08 W=8.1e-08 nfin=3 $X=0.179 $Y=0.162
M11 N_M11_d N_M11_g VDD VDD pmos_rvt L=2e-08 W=8.1e-08 nfin=3 $X=0.233 $Y=0.162
M12 N_M12_d N_M12_g VDD VDD pmos_rvt L=2e-08 W=8.1e-08 nfin=3 $X=0.287 $Y=0.162
M13 N_M13_d N_M13_g VDD VDD pmos_rvt L=2e-08 W=8.1e-08 nfin=3 $X=0.341 $Y=0.162
M14 N_M14_d N_M14_g VDD VDD pmos_rvt L=2e-08 W=8.1e-08 nfin=3 $X=0.395 $Y=0.162
M15 N_M15_d N_M15_g VDD VDD pmos_rvt L=2e-08 W=8.1e-08 nfin=3 $X=0.449 $Y=0.162

* .include "BUFx6f_ASAP7_75t_R.pex.sp.pxi"

* Start of included file BUFx6f_ASAP7_75t_R.pex.sp.pxi
x_PM_BUFx6f_ASAP7_75t_R%A vss A N_M0_g N_M8_g N_M1_g N_M9_g N_A_4 N_A_7 N_A_8
+ N_A_3 N_A_1 PM_BUFx6f_ASAP7_75t_R%A
x_PM_BUFx6f_ASAP7_75t_R%Y vss Y N_M2_d N_M3_d N_M4_d N_M5_d N_M6_d N_M7_d
+ N_M10_d N_M11_d N_M12_d N_M13_d N_M14_d N_M15_d N_Y_24 N_Y_22 N_Y_20 N_Y_23
+ N_Y_21 N_Y_29 N_Y_5 N_Y_6 N_Y_3 N_Y_4 N_Y_1 N_Y_2 N_Y_27 N_Y_28 N_Y_19
+ PM_BUFx6f_ASAP7_75t_R%Y
cc_1 N_Y_24 N_4_22 0.000196133f $X=0.4175 $Y=0.2025
cc_2 N_Y_24 N_4_23 0.000196133f $X=0.4175 $Y=0.2025
cc_3 N_Y_24 N_4_26 0.000342379f $X=0.4175 $Y=0.2025
cc_4 N_Y_24 N_4_25 0.000351794f $X=0.4175 $Y=0.2025
cc_5 N_Y_24 N_4_1 0.0034276f $X=0.4175 $Y=0.2025
cc_6 N_Y_24 N_4_14 0.000807562f $X=0.4175 $Y=0.2025
cc_7 N_Y_22 N_4_15 0.000813074f $X=0.2015 $Y=0.2025
cc_8 N_Y_20 N_4_16 0.0108079f $X=0.3095 $Y=0.0675
cc_9 N_Y_24 N_4_18 0.0550742f $X=0.4175 $Y=0.2025
cc_10 N_Y_23 N_4_16 0.0468987f $X=0.3095 $Y=0.2025
cc_11 N_Y_21 N_4_19 0.0109334f $X=0.4175 $Y=0.0675
cc_12 N_Y_29 N_4_27 0.0016486f $X=0.513 $Y=0.0855
cc_13 N_Y_5 N_4_19 0.00184387f $X=0.432 $Y=0.0675
cc_14 N_Y_6 N_4_19 0.00184387f $X=0.432 $Y=0.2025
cc_15 N_Y_3 N_4_17 0.00192376f $X=0.324 $Y=0.0675
cc_16 N_Y_4 N_4_16 0.00192382f $X=0.324 $Y=0.2025
cc_17 N_Y_1 N_4_15 0.00207557f $X=0.216 $Y=0.0675
cc_18 N_Y_2 N_4_14 0.00207578f $X=0.216 $Y=0.2025
cc_19 N_Y_27 N_4_27 0.0022945f $X=0.2045 $Y=0.036
cc_20 N_Y_28 N_4_27 0.00229468f $X=0.4885 $Y=0.234
cc_21 N_Y_4 N_4_27 0.0062467f $X=0.324 $Y=0.2025
cc_22 N_Y_19 N_4_14 0.0100989f $X=0.2015 $Y=0.0675
cc_23 N_Y_20 N_4_1 0.0125882f $X=0.3095 $Y=0.0675
cc_24 N_Y_22 N_4_14 0.0637912f $X=0.2015 $Y=0.2025
cc_25 N_Y_19 N_4_15 0.054059f $X=0.2015 $Y=0.0675
cc_26 N_Y_23 N_4_17 0.0539911f $X=0.3095 $Y=0.2025
cc_27 N_Y_20 N_4_17 0.0179843f $X=0.3095 $Y=0.0675
cc_28 N_Y_21 N_4_18 0.0180431f $X=0.4175 $Y=0.0675
cc_29 N_Y_24 N_4_19 0.0470217f $X=0.4175 $Y=0.2025
x_PM_BUFx6f_ASAP7_75t_R%4 vss N_M2_g N_M10_g N_M3_g N_M11_g N_M4_g N_M12_g
+ N_M5_g N_M13_g N_M6_g N_M14_g N_M7_g N_M15_g N_M0_d N_M1_d N_M8_d N_M9_d
+ N_4_1 N_4_9 N_4_20 N_4_26 N_4_25 N_4_22 N_4_23 N_4_24 N_4_14 N_4_8 N_4_21
+ N_4_15 N_4_16 N_4_18 N_4_19 N_4_27 N_4_17 PM_BUFx6f_ASAP7_75t_R%4
cc_30 N_4_1 N_A_4 0.000317469f $X=0.1795 $Y=0.135
cc_31 N_4_9 N_A_4 0.000652806f $X=0.108 $Y=0.2025
cc_32 N_4_20 N_A_4 0.01992f $X=0.0935 $Y=0.0675
cc_33 N_4_26 N_A_4 0.000876467f $X=0.135 $Y=0.1845
cc_34 N_4_25 N_A_4 0.000902131f $X=0.135 $Y=0.0855
cc_35 N_4_22 N_A_4 0.00107905f $X=0.135 $Y=0.036
cc_36 N_4_23 N_A_7 0.00108f $X=0.135 $Y=0.234
cc_37 N_4_24 N_A_8 0.00127539f $X=0.135 $Y=0.135
cc_38 N_4_14 N_A_4 0.00174596f $X=0.189 $Y=0.0245
cc_39 N_4_9 N_A_3 0.00182152f $X=0.108 $Y=0.2025
cc_40 N_4_8 N_A_3 0.00187492f $X=0.108 $Y=0.0675
cc_41 N_4_20 N_A_1 0.00639945f $X=0.0935 $Y=0.0675
cc_42 N_4_20 N_A_3 0.0106084f $X=0.0935 $Y=0.0675
cc_43 N_4_21 N_A_3 0.0569729f $X=0.0935 $Y=0.2025
cc_44 N_4_21 N_A_4 0.0517677f $X=0.0935 $Y=0.2025

* End of included file BUFx6f_ASAP7_75t_R.pex.sp.pxi
.ends

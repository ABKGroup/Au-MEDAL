.subckt PM_INVx2_ASAP7_75t_R%A vss 25 11 17 31 35 4 1 3
c1 1 vss 0.014046f $X=0.072 $Y=0.135
c2 3 vss 0.0878042f $X=0.081 $Y=0.0245
c3 4 vss 0.0886921f $X=0.135 $Y=0.135
c4 5 vss 0.00807098f $X=0.027 $Y=0.036
c5 6 vss 0.00165752f $X=0.027 $Y=0.135
c6 7 vss 0.00807341f $X=0.027 $Y=0.234
c7 8 vss 0.00947849f $X=0.027 $Y=0.0855
c8 9 vss 0.00949267f $X=0.027 $Y=0.1845
c9 10 vss 0.00247886f $X=0.0387 $Y=0.135
r1 7 9 10.3626 $w=1.39091e-08 $l=4.95e-08 $layer=M1 $thickness=3.6e-08 $X=0.027
+ $Y=0.234 $X2=0.027 $Y2=0.1845
r2 5 8 10.3626 $w=1.39091e-08 $l=4.95e-08 $layer=M1 $thickness=3.6e-08 $X=0.027
+ $Y=0.036 $X2=0.027 $Y2=0.0855
r3 6 10 1.55967 $w=1.68298e-08 $l=1.17e-08 $layer=M1 $thickness=3.6e-08
+ $X=0.027 $Y=0.135 $X2=0.0387 $Y2=0.135
r4 6 8 10.3626 $w=1.39091e-08 $l=4.95e-08 $layer=M1 $thickness=3.6e-08 $X=0.027
+ $Y=0.135 $X2=0.027 $Y2=0.0855
r5 6 9 10.3626 $w=1.39091e-08 $l=4.95e-08 $layer=M1 $thickness=3.6e-08 $X=0.027
+ $Y=0.135 $X2=0.027 $Y2=0.1845
r6 35 34 14.6259 $w=2.1e-08 $l=4.3e-08 $layer=Gate_1 $thickness=5.6e-08
+ $X=0.135 $Y=0.2025 $X2=0.135 $Y2=0.1595
r7 33 34 2.7211 $w=2.1e-08 $l=8e-09 $layer=Gate_1 $thickness=5.6e-08 $X=0.135
+ $Y=0.1515 $X2=0.135 $Y2=0.1595
r8 31 32 14.6259 $w=2.1e-08 $l=4.3e-08 $layer=Gate_1 $thickness=5.6e-08
+ $X=0.135 $Y=0.0675 $X2=0.135 $Y2=0.1105
r9 29 32 2.7211 $w=2.1e-08 $l=8e-09 $layer=Gate_1 $thickness=5.6e-08 $X=0.135
+ $Y=0.1185 $X2=0.135 $Y2=0.1105
r10 4 23 6.54019 $w=2.09524e-08 $layer=Gate_1 $thickness=5.21905e-08 $X=0.135
+ $Y=0.135 $X2=0.135 $Y2=0.135
r11 4 29 5.79936 $w=2.03333e-08 $l=1.65e-08 $layer=Gate_1 $thickness=5.6e-08
+ $X=0.135 $Y=0.135 $X2=0.135 $Y2=0.1185
r12 4 33 5.79936 $w=2.03333e-08 $l=1.65e-08 $layer=Gate_1 $thickness=5.6e-08
+ $X=0.135 $Y=0.135 $X2=0.135 $Y2=0.1515
r13 26 27 3.55614 $w=1.3e-08 $l=1.53e-08 $layer=M1 $thickness=3.6e-08 $X=0.0487
+ $Y=0.135 $X2=0.064 $Y2=0.135
r14 25 26 1.57403 $w=1.3e-08 $l=6.7e-09 $layer=M1 $thickness=3.6e-08 $X=0.042
+ $Y=0.1345 $X2=0.0487 $Y2=0.135
r15 25 10 0.757867 $w=1.3e-08 $l=3.3e-09 $layer=M1 $thickness=3.6e-08 $X=0.042
+ $Y=0.1345 $X2=0.0387 $Y2=0.135
r16 22 23 12.6539 $w=1.77815e-08 $l=2.7e-08 $layer=LIG $thickness=4.8e-08
+ $X=0.108 $Y=0.135 $X2=0.135 $Y2=0.135
r17 21 27 19.3796 $a=3.24e-16 $layer=V0LIG $X=0.063 $Y=0.135 $X2=0.064 $Y2=0.135
r18 19 22 12.3927 $w=1.76192e-08 $l=2.6e-08 $layer=LIG $thickness=4.8e-08
+ $X=0.082 $Y=0.135 $X2=0.108 $Y2=0.135
r19 1 19 2.6116 $w=2.2e-08 $l=1e-08 $layer=LIG $thickness=4.8e-08 $X=0.072
+ $Y=0.135 $X2=0.082 $Y2=0.135
r20 1 21 4.98695 $w=1.60444e-08 $l=9e-09 $layer=LIG $thickness=4.8e-08 $X=0.072
+ $Y=0.135 $X2=0.063 $Y2=0.135
r21 17 16 14.6259 $w=2.1e-08 $l=4.3e-08 $layer=Gate_1 $thickness=5.6e-08
+ $X=0.081 $Y=0.2025 $X2=0.081 $Y2=0.1595
r22 15 16 2.7211 $w=2.1e-08 $l=8e-09 $layer=Gate_1 $thickness=5.6e-08 $X=0.081
+ $Y=0.1515 $X2=0.081 $Y2=0.1595
r23 14 15 5.79936 $w=2.03333e-08 $l=1.65e-08 $layer=Gate_1 $thickness=5.6e-08
+ $X=0.081 $Y=0.135 $X2=0.081 $Y2=0.1515
r24 14 19 6.27904 $w=2.09e-08 $l=1e-09 $layer=Gate_1 $thickness=5.24e-08
+ $X=0.081 $Y=0.135 $X2=0.082 $Y2=0.135
r25 13 14 5.79936 $w=2.03333e-08 $l=1.65e-08 $layer=Gate_1 $thickness=5.6e-08
+ $X=0.081 $Y=0.1185 $X2=0.081 $Y2=0.135
r26 12 13 2.7211 $w=2.1e-08 $l=8e-09 $layer=Gate_1 $thickness=5.6e-08 $X=0.081
+ $Y=0.1105 $X2=0.081 $Y2=0.1185
r27 11 12 14.6259 $w=2.1e-08 $l=4.3e-08 $layer=Gate_1 $thickness=5.6e-08
+ $X=0.081 $Y=0.0675 $X2=0.081 $Y2=0.1105
r28 11 3 14.6259 $w=2.1e-08 $l=4.3e-08 $layer=Gate_1 $thickness=5.6e-08
+ $X=0.081 $Y=0.0675 $X2=0.081 $Y2=0.0245
.ends

.subckt PM_INVx2_ASAP7_75t_R%Y vss 21 14 15 28 29 2 11 7 8
c1 1 vss 0.00876719f $X=0.108 $Y=0.0675
c2 2 vss 0.00876719f $X=0.108 $Y=0.2025
c3 7 vss 0.00442738f $X=0.0935 $Y=0.0675
c4 8 vss 0.00443274f $X=0.0935 $Y=0.2025
c5 9 vss 0.00593307f $X=0.0965 $Y=0.036
c6 10 vss 0.00593307f $X=0.135 $Y=0.234
c7 11 vss 0.00764557f $X=0.135 $Y=0.0855
r1 29 27 0.0308642 $w=8.1e-08 $l=2.5e-09 $layer=P_src_drn $thickness=1e-09
+ $X=0.1253 $Y=0.2025 $X2=0.1225 $Y2=0.2025
r2 2 27 0.179012 $w=8.1e-08 $l=1.45e-08 $layer=P_src_drn $thickness=1e-09
+ $X=0.108 $Y=0.2025 $X2=0.1225 $Y2=0.2025
r3 8 2 0.179012 $w=8.1e-08 $l=1.45e-08 $layer=P_src_drn $thickness=1e-09
+ $X=0.0935 $Y=0.2025 $X2=0.108 $Y2=0.2025
r4 28 8 0.0308642 $w=8.1e-08 $l=2.5e-09 $layer=P_src_drn $thickness=1e-09
+ $X=0.0906 $Y=0.2025 $X2=0.0935 $Y2=0.2025
r5 2 24 19.3796 $a=3.24e-16 $layer=V0LISD $X=0.108 $Y=0.2025 $X2=0.108 $Y2=0.234
r6 24 25 3.14806 $w=1.3e-08 $l=1.35e-08 $layer=M1 $thickness=3.6e-08 $X=0.108
+ $Y=0.234 $X2=0.1215 $Y2=0.234
r7 10 22 9.89621 $w=1.39474e-08 $l=4.75e-08 $layer=M1 $thickness=3.6e-08
+ $X=0.135 $Y=0.234 $X2=0.135 $Y2=0.1865
r8 10 25 1.96775 $w=1.63333e-08 $l=1.35e-08 $layer=M1 $thickness=3.6e-08
+ $X=0.135 $Y=0.234 $X2=0.1215 $Y2=0.234
r9 21 22 9.0944 $w=1.3e-08 $l=3.9e-08 $layer=M1 $thickness=3.6e-08 $X=0.134
+ $Y=0.1475 $X2=0.135 $Y2=0.1865
r10 21 20 0.46638 $w=1.3e-08 $l=2e-09 $layer=M1 $thickness=3.6e-08 $X=0.134
+ $Y=0.1475 $X2=0.135 $Y2=0.1455
r11 19 20 2.44849 $w=1.3e-08 $l=1.05e-08 $layer=M1 $thickness=3.6e-08 $X=0.135
+ $Y=0.135 $X2=0.135 $Y2=0.1455
r12 11 18 10.3626 $w=1.39091e-08 $l=4.95e-08 $layer=M1 $thickness=3.6e-08
+ $X=0.135 $Y=0.0855 $X2=0.135 $Y2=0.036
r13 11 19 11.5429 $w=1.3e-08 $l=4.95e-08 $layer=M1 $thickness=3.6e-08 $X=0.135
+ $Y=0.0855 $X2=0.135 $Y2=0.135
r14 17 18 1.96775 $w=1.63333e-08 $l=1.35e-08 $layer=M1 $thickness=3.6e-08
+ $X=0.1215 $Y=0.036 $X2=0.135 $Y2=0.036
r15 16 17 3.14806 $w=1.3e-08 $l=1.35e-08 $layer=M1 $thickness=3.6e-08 $X=0.108
+ $Y=0.036 $X2=0.1215 $Y2=0.036
r16 9 16 2.68168 $w=1.3e-08 $l=1.15e-08 $layer=M1 $thickness=3.6e-08 $X=0.0965
+ $Y=0.036 $X2=0.108 $Y2=0.036
r17 1 16 19.3796 $a=3.24e-16 $layer=V0LISD $X=0.108 $Y=0.0675 $X2=0.108
+ $Y2=0.036
r18 15 13 0.0308642 $w=8.1e-08 $l=2.5e-09 $layer=N_src_drn $thickness=1e-09
+ $X=0.1253 $Y=0.0675 $X2=0.1225 $Y2=0.0675
r19 1 13 0.179012 $w=8.1e-08 $l=1.45e-08 $layer=N_src_drn $thickness=1e-09
+ $X=0.108 $Y=0.0675 $X2=0.1225 $Y2=0.0675
r20 7 1 0.179012 $w=8.1e-08 $l=1.45e-08 $layer=N_src_drn $thickness=1e-09
+ $X=0.0935 $Y=0.0675 $X2=0.108 $Y2=0.0675
r21 14 7 0.0308642 $w=8.1e-08 $l=2.5e-09 $layer=N_src_drn $thickness=1e-09
+ $X=0.0906 $Y=0.0675 $X2=0.0935 $Y2=0.0675
.ends

* End of included file INVx2_ASAP7_75t_R.pex.sp.pex

*
.subckt INVx2_ASAP7_75t_CUSTOM_4_25_0_7 VSS VDD A Y
*
* VSS VSS
* VDD VDD
* A A
* Y Y
*
*

M0 N_M0_d N_M0_g VSS VSS nmos_rvt L=2e-08 W=8.1e-08 nfin=3 $X=0.071 $Y=0.027
M1 N_M1_d N_M1_g VSS VSS nmos_rvt L=2e-08 W=8.1e-08 nfin=3 $X=0.125 $Y=0.027
M2 N_M2_d N_M2_g VDD VDD pmos_rvt L=2e-08 W=8.1e-08 nfin=3 $X=0.071 $Y=0.162
M3 N_M3_d N_M3_g VDD VDD pmos_rvt L=2e-08 W=8.1e-08 nfin=3 $X=0.125 $Y=0.162

* .include "INVx2_ASAP7_75t_R.pex.sp.pxi"

* Start of included file INVx2_ASAP7_75t_R.pex.sp.pxi
x_PM_INVx2_ASAP7_75t_R%A vss A N_M0_g N_M2_g N_M1_g N_M3_g N_A_4 N_A_1 N_A_3
+ PM_INVx2_ASAP7_75t_R%A
x_PM_INVx2_ASAP7_75t_R%Y vss Y N_M0_d N_M1_d N_M2_d N_M3_d N_Y_2 N_Y_11 N_Y_7
+ N_Y_8 PM_INVx2_ASAP7_75t_R%Y
cc_1 N_Y_2 N_A_4 0.00174596f $X=0.108 $Y=0.2025
cc_2 N_Y_11 N_A_1 0.00206596f $X=0.135 $Y=0.0855
cc_3 N_Y_7 N_A_1 0.00539177f $X=0.0935 $Y=0.0675
cc_4 N_Y_8 N_A_3 0.0101485f $X=0.0935 $Y=0.2025
cc_5 N_Y_8 N_A_4 0.018075f $X=0.0935 $Y=0.2025
cc_6 N_Y_7 N_A_3 0.0546317f $X=0.0935 $Y=0.0675
cc_7 N_Y_7 N_A_4 0.0542572f $X=0.0935 $Y=0.0675

* End of included file INVx2_ASAP7_75t_R.pex.sp.pxi
.ends

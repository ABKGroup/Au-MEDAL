.subckt PM_INVx11_ASAP7_75t_R%Y vss 70 56 57 74 75 78 79 82 83 86 87 89 104 105
+ 108 109 112 113 116 117 120 121 123 37 52 51 1 11 12 43 44 45 46 47 38 39 40
+ 41 3 4 5 6 7 8 9 10 2 42 48
c1 1 vss 0.00875912f $X=0.108 $Y=0.0675
c2 2 vss 0.00875912f $X=0.108 $Y=0.2025
c3 3 vss 0.00851358f $X=0.216 $Y=0.0675
c4 4 vss 0.00851358f $X=0.216 $Y=0.2025
c5 5 vss 0.00851358f $X=0.324 $Y=0.0675
c6 6 vss 0.00851358f $X=0.324 $Y=0.2025
c7 7 vss 0.00851358f $X=0.432 $Y=0.0675
c8 8 vss 0.00851358f $X=0.432 $Y=0.2025
c9 9 vss 0.00851358f $X=0.54 $Y=0.0675
c10 10 vss 0.00851358f $X=0.54 $Y=0.2025
c11 11 vss 0.00793866f $X=0.648 $Y=0.0675
c12 12 vss 0.00793866f $X=0.648 $Y=0.2025
c13 37 vss 0.00424775f $X=0.0935 $Y=0.0675
c14 38 vss 0.00424143f $X=0.2015 $Y=0.0675
c15 39 vss 0.00424143f $X=0.3095 $Y=0.0675
c16 40 vss 0.00424143f $X=0.4175 $Y=0.0675
c17 41 vss 0.00423651f $X=0.5255 $Y=0.0675
c18 42 vss 0.0361774f $X=0.6335 $Y=0.0675
c19 43 vss 0.00424686f $X=0.0935 $Y=0.2025
c20 44 vss 0.00424063f $X=0.2015 $Y=0.2025
c21 45 vss 0.00424063f $X=0.3095 $Y=0.2025
c22 46 vss 0.00424063f $X=0.4175 $Y=0.2025
c23 47 vss 0.00423573f $X=0.5255 $Y=0.2025
c24 48 vss 0.0361735f $X=0.6335 $Y=0.2025
c25 49 vss 0.00259507f $X=0.675 $Y=0.036
c26 50 vss 0.00259507f $X=0.675 $Y=0.234
c27 51 vss 0.0505098f $X=0.0965 $Y=0.036
c28 52 vss 0.0505098f $X=0.0965 $Y=0.234
c29 53 vss 0.00480581f $X=0.675 $Y=0.096
r1 48 12 0.154321 $w=8.1e-08 $l=1.25e-08 $layer=P_src_drn $thickness=1e-09
+ $X=0.6335 $Y=0.2025 $X2=0.648 $Y2=0.2025
r2 123 48 0.0308642 $w=8.1e-08 $l=2.5e-09 $layer=P_src_drn $thickness=1e-09
+ $X=0.6306 $Y=0.2025 $X2=0.6335 $Y2=0.2025
r3 121 119 0.0308642 $w=8.1e-08 $l=2.5e-09 $layer=P_src_drn $thickness=1e-09
+ $X=0.5573 $Y=0.2025 $X2=0.5545 $Y2=0.2025
r4 10 119 0.179012 $w=8.1e-08 $l=1.45e-08 $layer=P_src_drn $thickness=1e-09
+ $X=0.54 $Y=0.2025 $X2=0.5545 $Y2=0.2025
r5 47 10 0.179012 $w=8.1e-08 $l=1.45e-08 $layer=P_src_drn $thickness=1e-09
+ $X=0.5255 $Y=0.2025 $X2=0.54 $Y2=0.2025
r6 120 47 0.0308642 $w=8.1e-08 $l=2.5e-09 $layer=P_src_drn $thickness=1e-09
+ $X=0.5226 $Y=0.2025 $X2=0.5255 $Y2=0.2025
r7 117 115 0.0308642 $w=8.1e-08 $l=2.5e-09 $layer=P_src_drn $thickness=1e-09
+ $X=0.4493 $Y=0.2025 $X2=0.4465 $Y2=0.2025
r8 8 115 0.179012 $w=8.1e-08 $l=1.45e-08 $layer=P_src_drn $thickness=1e-09
+ $X=0.432 $Y=0.2025 $X2=0.4465 $Y2=0.2025
r9 46 8 0.179012 $w=8.1e-08 $l=1.45e-08 $layer=P_src_drn $thickness=1e-09
+ $X=0.4175 $Y=0.2025 $X2=0.432 $Y2=0.2025
r10 116 46 0.0308642 $w=8.1e-08 $l=2.5e-09 $layer=P_src_drn $thickness=1e-09
+ $X=0.4146 $Y=0.2025 $X2=0.4175 $Y2=0.2025
r11 113 111 0.0308642 $w=8.1e-08 $l=2.5e-09 $layer=P_src_drn $thickness=1e-09
+ $X=0.3413 $Y=0.2025 $X2=0.3385 $Y2=0.2025
r12 6 111 0.179012 $w=8.1e-08 $l=1.45e-08 $layer=P_src_drn $thickness=1e-09
+ $X=0.324 $Y=0.2025 $X2=0.3385 $Y2=0.2025
r13 45 6 0.179012 $w=8.1e-08 $l=1.45e-08 $layer=P_src_drn $thickness=1e-09
+ $X=0.3095 $Y=0.2025 $X2=0.324 $Y2=0.2025
r14 112 45 0.0308642 $w=8.1e-08 $l=2.5e-09 $layer=P_src_drn $thickness=1e-09
+ $X=0.3066 $Y=0.2025 $X2=0.3095 $Y2=0.2025
r15 109 107 0.0308642 $w=8.1e-08 $l=2.5e-09 $layer=P_src_drn $thickness=1e-09
+ $X=0.2333 $Y=0.2025 $X2=0.2305 $Y2=0.2025
r16 4 107 0.179012 $w=8.1e-08 $l=1.45e-08 $layer=P_src_drn $thickness=1e-09
+ $X=0.216 $Y=0.2025 $X2=0.2305 $Y2=0.2025
r17 44 4 0.179012 $w=8.1e-08 $l=1.45e-08 $layer=P_src_drn $thickness=1e-09
+ $X=0.2015 $Y=0.2025 $X2=0.216 $Y2=0.2025
r18 108 44 0.0308642 $w=8.1e-08 $l=2.5e-09 $layer=P_src_drn $thickness=1e-09
+ $X=0.1986 $Y=0.2025 $X2=0.2015 $Y2=0.2025
r19 105 103 0.0308642 $w=8.1e-08 $l=2.5e-09 $layer=P_src_drn $thickness=1e-09
+ $X=0.1253 $Y=0.2025 $X2=0.1225 $Y2=0.2025
r20 2 103 0.179012 $w=8.1e-08 $l=1.45e-08 $layer=P_src_drn $thickness=1e-09
+ $X=0.108 $Y=0.2025 $X2=0.1225 $Y2=0.2025
r21 43 2 0.179012 $w=8.1e-08 $l=1.45e-08 $layer=P_src_drn $thickness=1e-09
+ $X=0.0935 $Y=0.2025 $X2=0.108 $Y2=0.2025
r22 104 43 0.0308642 $w=8.1e-08 $l=2.5e-09 $layer=P_src_drn $thickness=1e-09
+ $X=0.0906 $Y=0.2025 $X2=0.0935 $Y2=0.2025
r23 12 100 19.3796 $a=3.24e-16 $layer=V0LISD $X=0.648 $Y=0.2025 $X2=0.648
+ $Y2=0.234
r24 10 98 19.3796 $a=3.24e-16 $layer=V0LISD $X=0.54 $Y=0.2025 $X2=0.54 $Y2=0.234
r25 8 96 19.3796 $a=3.24e-16 $layer=V0LISD $X=0.432 $Y=0.2025 $X2=0.432
+ $Y2=0.234
r26 6 94 19.3796 $a=3.24e-16 $layer=V0LISD $X=0.324 $Y=0.2025 $X2=0.324
+ $Y2=0.234
r27 4 92 19.3796 $a=3.24e-16 $layer=V0LISD $X=0.216 $Y=0.2025 $X2=0.216
+ $Y2=0.234
r28 2 90 19.3796 $a=3.24e-16 $layer=V0LISD $X=0.108 $Y=0.2025 $X2=0.108
+ $Y2=0.234
r29 100 101 3.14806 $w=1.3e-08 $l=1.35e-08 $layer=M1 $thickness=3.6e-08
+ $X=0.648 $Y=0.234 $X2=0.6615 $Y2=0.234
r30 99 100 12.5922 $w=1.3e-08 $l=5.4e-08 $layer=M1 $thickness=3.6e-08 $X=0.594
+ $Y=0.234 $X2=0.648 $Y2=0.234
r31 98 99 12.5922 $w=1.3e-08 $l=5.4e-08 $layer=M1 $thickness=3.6e-08 $X=0.54
+ $Y=0.234 $X2=0.594 $Y2=0.234
r32 97 98 12.5922 $w=1.3e-08 $l=5.4e-08 $layer=M1 $thickness=3.6e-08 $X=0.486
+ $Y=0.234 $X2=0.54 $Y2=0.234
r33 96 97 12.5922 $w=1.3e-08 $l=5.4e-08 $layer=M1 $thickness=3.6e-08 $X=0.432
+ $Y=0.234 $X2=0.486 $Y2=0.234
r34 95 96 12.5922 $w=1.3e-08 $l=5.4e-08 $layer=M1 $thickness=3.6e-08 $X=0.378
+ $Y=0.234 $X2=0.432 $Y2=0.234
r35 94 95 12.5922 $w=1.3e-08 $l=5.4e-08 $layer=M1 $thickness=3.6e-08 $X=0.324
+ $Y=0.234 $X2=0.378 $Y2=0.234
r36 93 94 12.5922 $w=1.3e-08 $l=5.4e-08 $layer=M1 $thickness=3.6e-08 $X=0.27
+ $Y=0.234 $X2=0.324 $Y2=0.234
r37 92 93 12.5922 $w=1.3e-08 $l=5.4e-08 $layer=M1 $thickness=3.6e-08 $X=0.216
+ $Y=0.234 $X2=0.27 $Y2=0.234
r38 91 92 12.5922 $w=1.3e-08 $l=5.4e-08 $layer=M1 $thickness=3.6e-08 $X=0.162
+ $Y=0.234 $X2=0.216 $Y2=0.234
r39 90 91 12.5922 $w=1.3e-08 $l=5.4e-08 $layer=M1 $thickness=3.6e-08 $X=0.108
+ $Y=0.234 $X2=0.162 $Y2=0.234
r40 52 90 2.68168 $w=1.3e-08 $l=1.15e-08 $layer=M1 $thickness=3.6e-08 $X=0.0965
+ $Y=0.234 $X2=0.108 $Y2=0.234
r41 50 71 9.4274 $w=1.48568e-08 $l=4.75e-08 $layer=M1 $thickness=3.6e-08
+ $X=0.675 $Y=0.234 $X2=0.675 $Y2=0.1865
r42 50 101 1.49895 $w=1.63333e-08 $l=1.35e-08 $layer=M1 $thickness=3.6e-08
+ $X=0.675 $Y=0.234 $X2=0.6615 $Y2=0.234
r43 42 11 0.154321 $w=8.1e-08 $l=1.25e-08 $layer=N_src_drn $thickness=1e-09
+ $X=0.6335 $Y=0.0675 $X2=0.648 $Y2=0.0675
r44 89 42 0.0308642 $w=8.1e-08 $l=2.5e-09 $layer=N_src_drn $thickness=1e-09
+ $X=0.6306 $Y=0.0675 $X2=0.6335 $Y2=0.0675
r45 87 85 0.0308642 $w=8.1e-08 $l=2.5e-09 $layer=N_src_drn $thickness=1e-09
+ $X=0.5573 $Y=0.0675 $X2=0.5545 $Y2=0.0675
r46 9 85 0.179012 $w=8.1e-08 $l=1.45e-08 $layer=N_src_drn $thickness=1e-09
+ $X=0.54 $Y=0.0675 $X2=0.5545 $Y2=0.0675
r47 41 9 0.179012 $w=8.1e-08 $l=1.45e-08 $layer=N_src_drn $thickness=1e-09
+ $X=0.5255 $Y=0.0675 $X2=0.54 $Y2=0.0675
r48 86 41 0.0308642 $w=8.1e-08 $l=2.5e-09 $layer=N_src_drn $thickness=1e-09
+ $X=0.5226 $Y=0.0675 $X2=0.5255 $Y2=0.0675
r49 83 81 0.0308642 $w=8.1e-08 $l=2.5e-09 $layer=N_src_drn $thickness=1e-09
+ $X=0.4493 $Y=0.0675 $X2=0.4465 $Y2=0.0675
r50 7 81 0.179012 $w=8.1e-08 $l=1.45e-08 $layer=N_src_drn $thickness=1e-09
+ $X=0.432 $Y=0.0675 $X2=0.4465 $Y2=0.0675
r51 40 7 0.179012 $w=8.1e-08 $l=1.45e-08 $layer=N_src_drn $thickness=1e-09
+ $X=0.4175 $Y=0.0675 $X2=0.432 $Y2=0.0675
r52 82 40 0.0308642 $w=8.1e-08 $l=2.5e-09 $layer=N_src_drn $thickness=1e-09
+ $X=0.4146 $Y=0.0675 $X2=0.4175 $Y2=0.0675
r53 79 77 0.0308642 $w=8.1e-08 $l=2.5e-09 $layer=N_src_drn $thickness=1e-09
+ $X=0.3413 $Y=0.0675 $X2=0.3385 $Y2=0.0675
r54 5 77 0.179012 $w=8.1e-08 $l=1.45e-08 $layer=N_src_drn $thickness=1e-09
+ $X=0.324 $Y=0.0675 $X2=0.3385 $Y2=0.0675
r55 39 5 0.179012 $w=8.1e-08 $l=1.45e-08 $layer=N_src_drn $thickness=1e-09
+ $X=0.3095 $Y=0.0675 $X2=0.324 $Y2=0.0675
r56 78 39 0.0308642 $w=8.1e-08 $l=2.5e-09 $layer=N_src_drn $thickness=1e-09
+ $X=0.3066 $Y=0.0675 $X2=0.3095 $Y2=0.0675
r57 75 73 0.0308642 $w=8.1e-08 $l=2.5e-09 $layer=N_src_drn $thickness=1e-09
+ $X=0.2333 $Y=0.0675 $X2=0.2305 $Y2=0.0675
r58 3 73 0.179012 $w=8.1e-08 $l=1.45e-08 $layer=N_src_drn $thickness=1e-09
+ $X=0.216 $Y=0.0675 $X2=0.2305 $Y2=0.0675
r59 38 3 0.179012 $w=8.1e-08 $l=1.45e-08 $layer=N_src_drn $thickness=1e-09
+ $X=0.2015 $Y=0.0675 $X2=0.216 $Y2=0.0675
r60 74 38 0.0308642 $w=8.1e-08 $l=2.5e-09 $layer=N_src_drn $thickness=1e-09
+ $X=0.1986 $Y=0.0675 $X2=0.2015 $Y2=0.0675
r61 70 71 9.0944 $w=1.3e-08 $l=3.9e-08 $layer=M1 $thickness=3.6e-08 $X=0.6775
+ $Y=0.1475 $X2=0.675 $Y2=0.1865
r62 70 53 12.0093 $w=1.3e-08 $l=5.15e-08 $layer=M1 $thickness=3.6e-08 $X=0.6775
+ $Y=0.1475 $X2=0.675 $Y2=0.096
r63 11 68 19.3796 $a=3.24e-16 $layer=V0LISD $X=0.648 $Y=0.0675 $X2=0.648
+ $Y2=0.036
r64 9 66 19.3796 $a=3.24e-16 $layer=V0LISD $X=0.54 $Y=0.0675 $X2=0.54 $Y2=0.036
r65 7 64 19.3796 $a=3.24e-16 $layer=V0LISD $X=0.432 $Y=0.0675 $X2=0.432
+ $Y2=0.036
r66 5 62 19.3796 $a=3.24e-16 $layer=V0LISD $X=0.324 $Y=0.0675 $X2=0.324
+ $Y2=0.036
r67 3 60 19.3796 $a=3.24e-16 $layer=V0LISD $X=0.216 $Y=0.0675 $X2=0.216
+ $Y2=0.036
r68 49 69 1.49895 $w=1.63333e-08 $l=1.35e-08 $layer=M1 $thickness=3.6e-08
+ $X=0.675 $Y=0.036 $X2=0.6615 $Y2=0.036
r69 49 53 12.3423 $w=1.447e-08 $l=6e-08 $layer=M1 $thickness=3.6e-08 $X=0.675
+ $Y=0.036 $X2=0.675 $Y2=0.096
r70 68 69 3.14806 $w=1.3e-08 $l=1.35e-08 $layer=M1 $thickness=3.6e-08 $X=0.648
+ $Y=0.036 $X2=0.6615 $Y2=0.036
r71 67 68 12.5922 $w=1.3e-08 $l=5.4e-08 $layer=M1 $thickness=3.6e-08 $X=0.594
+ $Y=0.036 $X2=0.648 $Y2=0.036
r72 66 67 12.5922 $w=1.3e-08 $l=5.4e-08 $layer=M1 $thickness=3.6e-08 $X=0.54
+ $Y=0.036 $X2=0.594 $Y2=0.036
r73 65 66 12.5922 $w=1.3e-08 $l=5.4e-08 $layer=M1 $thickness=3.6e-08 $X=0.486
+ $Y=0.036 $X2=0.54 $Y2=0.036
r74 64 65 12.5922 $w=1.3e-08 $l=5.4e-08 $layer=M1 $thickness=3.6e-08 $X=0.432
+ $Y=0.036 $X2=0.486 $Y2=0.036
r75 63 64 12.5922 $w=1.3e-08 $l=5.4e-08 $layer=M1 $thickness=3.6e-08 $X=0.378
+ $Y=0.036 $X2=0.432 $Y2=0.036
r76 62 63 12.5922 $w=1.3e-08 $l=5.4e-08 $layer=M1 $thickness=3.6e-08 $X=0.324
+ $Y=0.036 $X2=0.378 $Y2=0.036
r77 61 62 12.5922 $w=1.3e-08 $l=5.4e-08 $layer=M1 $thickness=3.6e-08 $X=0.27
+ $Y=0.036 $X2=0.324 $Y2=0.036
r78 60 61 12.5922 $w=1.3e-08 $l=5.4e-08 $layer=M1 $thickness=3.6e-08 $X=0.216
+ $Y=0.036 $X2=0.27 $Y2=0.036
r79 59 60 12.5922 $w=1.3e-08 $l=5.4e-08 $layer=M1 $thickness=3.6e-08 $X=0.162
+ $Y=0.036 $X2=0.216 $Y2=0.036
r80 58 59 12.5922 $w=1.3e-08 $l=5.4e-08 $layer=M1 $thickness=3.6e-08 $X=0.108
+ $Y=0.036 $X2=0.162 $Y2=0.036
r81 51 58 2.68168 $w=1.3e-08 $l=1.15e-08 $layer=M1 $thickness=3.6e-08 $X=0.0965
+ $Y=0.036 $X2=0.108 $Y2=0.036
r82 1 58 19.3796 $a=3.24e-16 $layer=V0LISD $X=0.108 $Y=0.0675 $X2=0.108
+ $Y2=0.036
r83 57 55 0.0308642 $w=8.1e-08 $l=2.5e-09 $layer=N_src_drn $thickness=1e-09
+ $X=0.1253 $Y=0.0675 $X2=0.1225 $Y2=0.0675
r84 1 55 0.179012 $w=8.1e-08 $l=1.45e-08 $layer=N_src_drn $thickness=1e-09
+ $X=0.108 $Y=0.0675 $X2=0.1225 $Y2=0.0675
r85 37 1 0.179012 $w=8.1e-08 $l=1.45e-08 $layer=N_src_drn $thickness=1e-09
+ $X=0.0935 $Y=0.0675 $X2=0.108 $Y2=0.0675
r86 56 37 0.0308642 $w=8.1e-08 $l=2.5e-09 $layer=N_src_drn $thickness=1e-09
+ $X=0.0906 $Y=0.0675 $X2=0.0935 $Y2=0.0675
.ends

.subckt PM_INVx11_ASAP7_75t_R%A vss 52 20 26 55 58 61 64 67 70 73 76 79 82 85
+ 88 91 94 97 100 103 106 110 114 1 13 17 18 14 16 11 19 3 4 6 8 10 12 5 7 9
c1 1 vss 0.0689918f $X=0.072 $Y=0.135
c2 3 vss 0.0874407f $X=0.081 $Y=0.0245
c3 4 vss 0.0882237f $X=0.135 $Y=0.135
c4 5 vss 0.0877515f $X=0.189 $Y=0.135
c5 6 vss 0.0879191f $X=0.243 $Y=0.135
c6 7 vss 0.0879191f $X=0.297 $Y=0.135
c7 8 vss 0.0879191f $X=0.351 $Y=0.135
c8 9 vss 0.0879191f $X=0.405 $Y=0.135
c9 10 vss 0.0879191f $X=0.459 $Y=0.135
c10 11 vss 0.0877569f $X=0.513 $Y=0.135
c11 12 vss 0.0881771f $X=0.567 $Y=0.135
c12 13 vss 0.0871469f $X=0.621 $Y=0.135
c13 14 vss 0.0133996f $X=0.027 $Y=0.036
c14 15 vss 0.00805754f $X=0.027 $Y=0.135
c15 16 vss 0.0133996f $X=0.027 $Y=0.234
c16 17 vss 0.0112629f $X=0.027 $Y=0.0855
c17 18 vss 0.0112629f $X=0.027 $Y=0.1845
c18 19 vss 0.00864604f $X=0.0455 $Y=0.135
r1 16 18 10.3626 $w=1.39091e-08 $l=4.95e-08 $layer=M1 $thickness=3.6e-08
+ $X=0.027 $Y=0.234 $X2=0.027 $Y2=0.1845
r2 14 17 10.3626 $w=1.39091e-08 $l=4.95e-08 $layer=M1 $thickness=3.6e-08
+ $X=0.027 $Y=0.036 $X2=0.027 $Y2=0.0855
r3 15 19 3.1337 $w=1.54324e-08 $l=1.85e-08 $layer=M1 $thickness=3.6e-08
+ $X=0.027 $Y=0.135 $X2=0.0455 $Y2=0.135
r4 15 17 10.3626 $w=1.39091e-08 $l=4.95e-08 $layer=M1 $thickness=3.6e-08
+ $X=0.027 $Y=0.135 $X2=0.027 $Y2=0.0855
r5 15 18 10.3626 $w=1.39091e-08 $l=4.95e-08 $layer=M1 $thickness=3.6e-08
+ $X=0.027 $Y=0.135 $X2=0.027 $Y2=0.1845
r6 114 113 14.6259 $w=2.1e-08 $l=4.3e-08 $layer=Gate_1 $thickness=5.6e-08
+ $X=0.621 $Y=0.2025 $X2=0.621 $Y2=0.1595
r7 112 113 2.7211 $w=2.1e-08 $l=8e-09 $layer=Gate_1 $thickness=5.6e-08 $X=0.621
+ $Y=0.1515 $X2=0.621 $Y2=0.1595
r8 110 111 14.6259 $w=2.1e-08 $l=4.3e-08 $layer=Gate_1 $thickness=5.6e-08
+ $X=0.621 $Y=0.0675 $X2=0.621 $Y2=0.1105
r9 108 111 2.7211 $w=2.1e-08 $l=8e-09 $layer=Gate_1 $thickness=5.6e-08 $X=0.621
+ $Y=0.1185 $X2=0.621 $Y2=0.1105
r10 13 50 6.54019 $w=2.09524e-08 $layer=Gate_1 $thickness=5.21905e-08 $X=0.621
+ $Y=0.135 $X2=0.621 $Y2=0.135
r11 13 108 5.79936 $w=2.03333e-08 $l=1.65e-08 $layer=Gate_1 $thickness=5.6e-08
+ $X=0.621 $Y=0.135 $X2=0.621 $Y2=0.1185
r12 13 112 5.79936 $w=2.03333e-08 $l=1.65e-08 $layer=Gate_1 $thickness=5.6e-08
+ $X=0.621 $Y=0.135 $X2=0.621 $Y2=0.1515
r13 106 105 16.4967 $w=2.1e-08 $l=4.85e-08 $layer=Gate_1 $thickness=5.6e-08
+ $X=0.567 $Y=0.2025 $X2=0.567 $Y2=0.154
r14 103 104 16.4967 $w=2.1e-08 $l=4.85e-08 $layer=Gate_1 $thickness=5.6e-08
+ $X=0.567 $Y=0.0675 $X2=0.567 $Y2=0.116
r15 12 48 6.54019 $w=2.09524e-08 $layer=Gate_1 $thickness=5.21905e-08 $X=0.567
+ $Y=0.135 $X2=0.567 $Y2=0.135
r16 12 104 6.6497 $w=2.04211e-08 $l=1.9e-08 $layer=Gate_1 $thickness=5.6e-08
+ $X=0.567 $Y=0.135 $X2=0.567 $Y2=0.116
r17 12 105 6.6497 $w=2.04211e-08 $l=1.9e-08 $layer=Gate_1 $thickness=5.6e-08
+ $X=0.567 $Y=0.135 $X2=0.567 $Y2=0.154
r18 100 99 16.4967 $w=2.1e-08 $l=4.85e-08 $layer=Gate_1 $thickness=5.6e-08
+ $X=0.513 $Y=0.2025 $X2=0.513 $Y2=0.154
r19 97 98 16.4967 $w=2.1e-08 $l=4.85e-08 $layer=Gate_1 $thickness=5.6e-08
+ $X=0.513 $Y=0.0675 $X2=0.513 $Y2=0.116
r20 11 46 6.54019 $w=2.09524e-08 $layer=Gate_1 $thickness=5.21905e-08 $X=0.513
+ $Y=0.135 $X2=0.513 $Y2=0.135
r21 11 98 6.6497 $w=2.04211e-08 $l=1.9e-08 $layer=Gate_1 $thickness=5.6e-08
+ $X=0.513 $Y=0.135 $X2=0.513 $Y2=0.116
r22 11 99 6.6497 $w=2.04211e-08 $l=1.9e-08 $layer=Gate_1 $thickness=5.6e-08
+ $X=0.513 $Y=0.135 $X2=0.513 $Y2=0.154
r23 94 93 16.4967 $w=2.1e-08 $l=4.85e-08 $layer=Gate_1 $thickness=5.6e-08
+ $X=0.459 $Y=0.2025 $X2=0.459 $Y2=0.154
r24 91 92 16.4967 $w=2.1e-08 $l=4.85e-08 $layer=Gate_1 $thickness=5.6e-08
+ $X=0.459 $Y=0.0675 $X2=0.459 $Y2=0.116
r25 10 44 6.54019 $w=2.09524e-08 $layer=Gate_1 $thickness=5.21905e-08 $X=0.459
+ $Y=0.135 $X2=0.459 $Y2=0.135
r26 10 92 6.6497 $w=2.04211e-08 $l=1.9e-08 $layer=Gate_1 $thickness=5.6e-08
+ $X=0.459 $Y=0.135 $X2=0.459 $Y2=0.116
r27 10 93 6.6497 $w=2.04211e-08 $l=1.9e-08 $layer=Gate_1 $thickness=5.6e-08
+ $X=0.459 $Y=0.135 $X2=0.459 $Y2=0.154
r28 88 87 16.4967 $w=2.1e-08 $l=4.85e-08 $layer=Gate_1 $thickness=5.6e-08
+ $X=0.405 $Y=0.2025 $X2=0.405 $Y2=0.154
r29 85 86 16.4967 $w=2.1e-08 $l=4.85e-08 $layer=Gate_1 $thickness=5.6e-08
+ $X=0.405 $Y=0.0675 $X2=0.405 $Y2=0.116
r30 9 42 6.54019 $w=2.09524e-08 $layer=Gate_1 $thickness=5.21905e-08 $X=0.405
+ $Y=0.135 $X2=0.405 $Y2=0.135
r31 9 86 6.6497 $w=2.04211e-08 $l=1.9e-08 $layer=Gate_1 $thickness=5.6e-08
+ $X=0.405 $Y=0.135 $X2=0.405 $Y2=0.116
r32 9 87 6.6497 $w=2.04211e-08 $l=1.9e-08 $layer=Gate_1 $thickness=5.6e-08
+ $X=0.405 $Y=0.135 $X2=0.405 $Y2=0.154
r33 82 81 16.4967 $w=2.1e-08 $l=4.85e-08 $layer=Gate_1 $thickness=5.6e-08
+ $X=0.351 $Y=0.2025 $X2=0.351 $Y2=0.154
r34 79 80 16.4967 $w=2.1e-08 $l=4.85e-08 $layer=Gate_1 $thickness=5.6e-08
+ $X=0.351 $Y=0.0675 $X2=0.351 $Y2=0.116
r35 8 40 6.54019 $w=2.09524e-08 $layer=Gate_1 $thickness=5.21905e-08 $X=0.351
+ $Y=0.135 $X2=0.351 $Y2=0.135
r36 8 80 6.6497 $w=2.04211e-08 $l=1.9e-08 $layer=Gate_1 $thickness=5.6e-08
+ $X=0.351 $Y=0.135 $X2=0.351 $Y2=0.116
r37 8 81 6.6497 $w=2.04211e-08 $l=1.9e-08 $layer=Gate_1 $thickness=5.6e-08
+ $X=0.351 $Y=0.135 $X2=0.351 $Y2=0.154
r38 76 75 16.4967 $w=2.1e-08 $l=4.85e-08 $layer=Gate_1 $thickness=5.6e-08
+ $X=0.297 $Y=0.2025 $X2=0.297 $Y2=0.154
r39 73 74 16.4967 $w=2.1e-08 $l=4.85e-08 $layer=Gate_1 $thickness=5.6e-08
+ $X=0.297 $Y=0.0675 $X2=0.297 $Y2=0.116
r40 7 38 6.54019 $w=2.09524e-08 $layer=Gate_1 $thickness=5.21905e-08 $X=0.297
+ $Y=0.135 $X2=0.297 $Y2=0.135
r41 7 74 6.6497 $w=2.04211e-08 $l=1.9e-08 $layer=Gate_1 $thickness=5.6e-08
+ $X=0.297 $Y=0.135 $X2=0.297 $Y2=0.116
r42 7 75 6.6497 $w=2.04211e-08 $l=1.9e-08 $layer=Gate_1 $thickness=5.6e-08
+ $X=0.297 $Y=0.135 $X2=0.297 $Y2=0.154
r43 70 69 16.4967 $w=2.1e-08 $l=4.85e-08 $layer=Gate_1 $thickness=5.6e-08
+ $X=0.243 $Y=0.2025 $X2=0.243 $Y2=0.154
r44 67 68 16.4967 $w=2.1e-08 $l=4.85e-08 $layer=Gate_1 $thickness=5.6e-08
+ $X=0.243 $Y=0.0675 $X2=0.243 $Y2=0.116
r45 6 36 6.54019 $w=2.09524e-08 $layer=Gate_1 $thickness=5.21905e-08 $X=0.243
+ $Y=0.135 $X2=0.243 $Y2=0.135
r46 6 68 6.6497 $w=2.04211e-08 $l=1.9e-08 $layer=Gate_1 $thickness=5.6e-08
+ $X=0.243 $Y=0.135 $X2=0.243 $Y2=0.116
r47 6 69 6.6497 $w=2.04211e-08 $l=1.9e-08 $layer=Gate_1 $thickness=5.6e-08
+ $X=0.243 $Y=0.135 $X2=0.243 $Y2=0.154
r48 64 63 16.4967 $w=2.1e-08 $l=4.85e-08 $layer=Gate_1 $thickness=5.6e-08
+ $X=0.189 $Y=0.2025 $X2=0.189 $Y2=0.154
r49 61 62 16.4967 $w=2.1e-08 $l=4.85e-08 $layer=Gate_1 $thickness=5.6e-08
+ $X=0.189 $Y=0.0675 $X2=0.189 $Y2=0.116
r50 5 34 6.54019 $w=2.09524e-08 $layer=Gate_1 $thickness=5.21905e-08 $X=0.189
+ $Y=0.135 $X2=0.189 $Y2=0.135
r51 5 62 6.6497 $w=2.04211e-08 $l=1.9e-08 $layer=Gate_1 $thickness=5.6e-08
+ $X=0.189 $Y=0.135 $X2=0.189 $Y2=0.116
r52 5 63 6.6497 $w=2.04211e-08 $l=1.9e-08 $layer=Gate_1 $thickness=5.6e-08
+ $X=0.189 $Y=0.135 $X2=0.189 $Y2=0.154
r53 58 57 16.4967 $w=2.1e-08 $l=4.85e-08 $layer=Gate_1 $thickness=5.6e-08
+ $X=0.135 $Y=0.2025 $X2=0.135 $Y2=0.154
r54 55 56 16.4967 $w=2.1e-08 $l=4.85e-08 $layer=Gate_1 $thickness=5.6e-08
+ $X=0.135 $Y=0.0675 $X2=0.135 $Y2=0.116
r55 4 32 6.54019 $w=2.09524e-08 $layer=Gate_1 $thickness=5.21905e-08 $X=0.135
+ $Y=0.135 $X2=0.135 $Y2=0.135
r56 4 56 6.6497 $w=2.04211e-08 $l=1.9e-08 $layer=Gate_1 $thickness=5.6e-08
+ $X=0.135 $Y=0.135 $X2=0.135 $Y2=0.116
r57 4 57 6.6497 $w=2.04211e-08 $l=1.9e-08 $layer=Gate_1 $thickness=5.6e-08
+ $X=0.135 $Y=0.135 $X2=0.135 $Y2=0.154
r58 52 19 4.31401 $w=1.3e-08 $l=1.85e-08 $layer=M1 $thickness=3.6e-08 $X=0.063
+ $Y=0.1355 $X2=0.0455 $Y2=0.135
r59 49 50 12.6539 $w=1.77815e-08 $l=2.7e-08 $layer=LIG $thickness=4.8e-08
+ $X=0.594 $Y=0.135 $X2=0.621 $Y2=0.135
r60 48 49 12.6539 $w=1.77815e-08 $l=2.7e-08 $layer=LIG $thickness=4.8e-08
+ $X=0.567 $Y=0.135 $X2=0.594 $Y2=0.135
r61 47 48 12.6539 $w=1.77815e-08 $l=2.7e-08 $layer=LIG $thickness=4.8e-08
+ $X=0.54 $Y=0.135 $X2=0.567 $Y2=0.135
r62 46 47 12.6539 $w=1.77815e-08 $l=2.7e-08 $layer=LIG $thickness=4.8e-08
+ $X=0.513 $Y=0.135 $X2=0.54 $Y2=0.135
r63 45 46 12.6539 $w=1.77815e-08 $l=2.7e-08 $layer=LIG $thickness=4.8e-08
+ $X=0.486 $Y=0.135 $X2=0.513 $Y2=0.135
r64 44 45 12.6539 $w=1.77815e-08 $l=2.7e-08 $layer=LIG $thickness=4.8e-08
+ $X=0.459 $Y=0.135 $X2=0.486 $Y2=0.135
r65 43 44 12.6539 $w=1.77815e-08 $l=2.7e-08 $layer=LIG $thickness=4.8e-08
+ $X=0.432 $Y=0.135 $X2=0.459 $Y2=0.135
r66 42 43 12.6539 $w=1.77815e-08 $l=2.7e-08 $layer=LIG $thickness=4.8e-08
+ $X=0.405 $Y=0.135 $X2=0.432 $Y2=0.135
r67 41 42 12.6539 $w=1.77815e-08 $l=2.7e-08 $layer=LIG $thickness=4.8e-08
+ $X=0.378 $Y=0.135 $X2=0.405 $Y2=0.135
r68 40 41 12.6539 $w=1.77815e-08 $l=2.7e-08 $layer=LIG $thickness=4.8e-08
+ $X=0.351 $Y=0.135 $X2=0.378 $Y2=0.135
r69 39 40 12.6539 $w=1.77815e-08 $l=2.7e-08 $layer=LIG $thickness=4.8e-08
+ $X=0.324 $Y=0.135 $X2=0.351 $Y2=0.135
r70 38 39 12.6539 $w=1.77815e-08 $l=2.7e-08 $layer=LIG $thickness=4.8e-08
+ $X=0.297 $Y=0.135 $X2=0.324 $Y2=0.135
r71 37 38 12.6539 $w=1.77815e-08 $l=2.7e-08 $layer=LIG $thickness=4.8e-08
+ $X=0.27 $Y=0.135 $X2=0.297 $Y2=0.135
r72 36 37 12.6539 $w=1.77815e-08 $l=2.7e-08 $layer=LIG $thickness=4.8e-08
+ $X=0.243 $Y=0.135 $X2=0.27 $Y2=0.135
r73 35 36 12.6539 $w=1.77815e-08 $l=2.7e-08 $layer=LIG $thickness=4.8e-08
+ $X=0.216 $Y=0.135 $X2=0.243 $Y2=0.135
r74 34 35 12.6539 $w=1.77815e-08 $l=2.7e-08 $layer=LIG $thickness=4.8e-08
+ $X=0.189 $Y=0.135 $X2=0.216 $Y2=0.135
r75 33 34 12.6539 $w=1.77815e-08 $l=2.7e-08 $layer=LIG $thickness=4.8e-08
+ $X=0.162 $Y=0.135 $X2=0.189 $Y2=0.135
r76 32 33 12.6539 $w=1.77815e-08 $l=2.7e-08 $layer=LIG $thickness=4.8e-08
+ $X=0.135 $Y=0.135 $X2=0.162 $Y2=0.135
r77 31 32 12.6539 $w=1.77815e-08 $l=2.7e-08 $layer=LIG $thickness=4.8e-08
+ $X=0.108 $Y=0.135 $X2=0.135 $Y2=0.135
r78 52 30 19.3796 $a=3.24e-16 $layer=V0LIG $X=0.063 $Y=0.1355 $X2=0.063
+ $Y2=0.135
r79 28 31 12.3927 $w=1.76192e-08 $l=2.6e-08 $layer=LIG $thickness=4.8e-08
+ $X=0.082 $Y=0.135 $X2=0.108 $Y2=0.135
r80 1 28 2.6116 $w=2.2e-08 $l=1e-08 $layer=LIG $thickness=4.8e-08 $X=0.072
+ $Y=0.135 $X2=0.082 $Y2=0.135
r81 1 30 4.98695 $w=1.60444e-08 $l=9e-09 $layer=LIG $thickness=4.8e-08 $X=0.072
+ $Y=0.135 $X2=0.063 $Y2=0.135
r82 26 25 14.6259 $w=2.1e-08 $l=4.3e-08 $layer=Gate_1 $thickness=5.6e-08
+ $X=0.081 $Y=0.2025 $X2=0.081 $Y2=0.1595
r83 24 25 2.7211 $w=2.1e-08 $l=8e-09 $layer=Gate_1 $thickness=5.6e-08 $X=0.081
+ $Y=0.1515 $X2=0.081 $Y2=0.1595
r84 23 24 5.79936 $w=2.03333e-08 $l=1.65e-08 $layer=Gate_1 $thickness=5.6e-08
+ $X=0.081 $Y=0.135 $X2=0.081 $Y2=0.1515
r85 23 28 6.27904 $w=2.09e-08 $l=1e-09 $layer=Gate_1 $thickness=5.24e-08
+ $X=0.081 $Y=0.135 $X2=0.082 $Y2=0.135
r86 22 23 5.79936 $w=2.03333e-08 $l=1.65e-08 $layer=Gate_1 $thickness=5.6e-08
+ $X=0.081 $Y=0.1185 $X2=0.081 $Y2=0.135
r87 21 22 2.7211 $w=2.1e-08 $l=8e-09 $layer=Gate_1 $thickness=5.6e-08 $X=0.081
+ $Y=0.1105 $X2=0.081 $Y2=0.1185
r88 20 21 14.6259 $w=2.1e-08 $l=4.3e-08 $layer=Gate_1 $thickness=5.6e-08
+ $X=0.081 $Y=0.0675 $X2=0.081 $Y2=0.1105
r89 20 3 14.6259 $w=2.1e-08 $l=4.3e-08 $layer=Gate_1 $thickness=5.6e-08
+ $X=0.081 $Y=0.0675 $X2=0.081 $Y2=0.0245
.ends

* End of included file INVx11_ASAP7_75t_R.pex.sp.pex

*
.subckt INVx11_ASAP7_75t_CUSTOM_4_25_0_7 VSS VDD A Y
*
* VSS VSS
* VDD VDD
* A A
* Y Y
*
*

M0 N_M0_d N_M0_g VSS VSS nmos_rvt L=2e-08 W=8.1e-08 nfin=3 $X=0.071 $Y=0.027
M1 N_M1_d N_M1_g VSS VSS nmos_rvt L=2e-08 W=8.1e-08 nfin=3 $X=0.125 $Y=0.027
M2 N_M2_d N_M2_g VSS VSS nmos_rvt L=2e-08 W=8.1e-08 nfin=3 $X=0.179 $Y=0.027
M3 N_M3_d N_M3_g VSS VSS nmos_rvt L=2e-08 W=8.1e-08 nfin=3 $X=0.233 $Y=0.027
M4 N_M4_d N_M4_g VSS VSS nmos_rvt L=2e-08 W=8.1e-08 nfin=3 $X=0.287 $Y=0.027
M5 N_M5_d N_M5_g VSS VSS nmos_rvt L=2e-08 W=8.1e-08 nfin=3 $X=0.341 $Y=0.027
M6 N_M6_d N_M6_g VSS VSS nmos_rvt L=2e-08 W=8.1e-08 nfin=3 $X=0.395 $Y=0.027
M7 N_M7_d N_M7_g VSS VSS nmos_rvt L=2e-08 W=8.1e-08 nfin=3 $X=0.449 $Y=0.027
M8 N_M8_d N_M8_g VSS VSS nmos_rvt L=2e-08 W=8.1e-08 nfin=3 $X=0.503 $Y=0.027
M9 N_M9_d N_M9_g VSS VSS nmos_rvt L=2e-08 W=8.1e-08 nfin=3 $X=0.557 $Y=0.027
M10 N_M10_d N_M10_g VSS VSS nmos_rvt L=2e-08 W=8.1e-08 nfin=3 $X=0.611 $Y=0.027
M11 N_M11_d N_M11_g VDD VDD pmos_rvt L=2e-08 W=8.1e-08 nfin=3 $X=0.071 $Y=0.162
M12 N_M12_d N_M12_g VDD VDD pmos_rvt L=2e-08 W=8.1e-08 nfin=3 $X=0.125 $Y=0.162
M13 N_M13_d N_M13_g VDD VDD pmos_rvt L=2e-08 W=8.1e-08 nfin=3 $X=0.179 $Y=0.162
M14 N_M14_d N_M14_g VDD VDD pmos_rvt L=2e-08 W=8.1e-08 nfin=3 $X=0.233 $Y=0.162
M15 N_M15_d N_M15_g VDD VDD pmos_rvt L=2e-08 W=8.1e-08 nfin=3 $X=0.287 $Y=0.162
M16 N_M16_d N_M16_g VDD VDD pmos_rvt L=2e-08 W=8.1e-08 nfin=3 $X=0.341 $Y=0.162
M17 N_M17_d N_M17_g VDD VDD pmos_rvt L=2e-08 W=8.1e-08 nfin=3 $X=0.395 $Y=0.162
M18 N_M18_d N_M18_g VDD VDD pmos_rvt L=2e-08 W=8.1e-08 nfin=3 $X=0.449 $Y=0.162
M19 N_M19_d N_M19_g VDD VDD pmos_rvt L=2e-08 W=8.1e-08 nfin=3 $X=0.503 $Y=0.162
M20 N_M20_d N_M20_g VDD VDD pmos_rvt L=2e-08 W=8.1e-08 nfin=3 $X=0.557 $Y=0.162
M21 N_M21_d N_M21_g VDD VDD pmos_rvt L=2e-08 W=8.1e-08 nfin=3 $X=0.611 $Y=0.162

* .include "INVx11_ASAP7_75t_R.pex.sp.pxi"

* Start of included file INVx11_ASAP7_75t_R.pex.sp.pxi
x_PM_INVx11_ASAP7_75t_R%Y vss Y N_M0_d N_M1_d N_M2_d N_M3_d N_M4_d N_M5_d
+ N_M6_d N_M7_d N_M8_d N_M9_d N_M10_d N_M11_d N_M12_d N_M13_d N_M14_d N_M15_d
+ N_M16_d N_M17_d N_M18_d N_M19_d N_M20_d N_M21_d N_Y_37 N_Y_52 N_Y_51 N_Y_1
+ N_Y_11 N_Y_12 N_Y_43 N_Y_44 N_Y_45 N_Y_46 N_Y_47 N_Y_38 N_Y_39 N_Y_40 N_Y_41
+ N_Y_3 N_Y_4 N_Y_5 N_Y_6 N_Y_7 N_Y_8 N_Y_9 N_Y_10 N_Y_2 N_Y_42 N_Y_48
+ PM_INVx11_ASAP7_75t_R%Y
cc_1 N_Y_37 N_A_1 0.000756246f $X=0.0935 $Y=0.0675
cc_2 N_Y_37 N_A_13 0.00081809f $X=0.0935 $Y=0.0675
cc_3 N_Y_37 N_A_17 0.000427143f $X=0.0935 $Y=0.0675
cc_4 N_Y_52 N_A_18 0.000427143f $X=0.0965 $Y=0.234
cc_5 N_Y_51 N_A_14 0.00042991f $X=0.0965 $Y=0.036
cc_6 N_Y_52 N_A_16 0.00042991f $X=0.0965 $Y=0.234
cc_7 N_Y_51 N_A_11 0.00052673f $X=0.0965 $Y=0.036
cc_8 N_Y_52 N_A_11 0.00052673f $X=0.0965 $Y=0.234
cc_9 N_Y_1 N_A_19 0.000633291f $X=0.108 $Y=0.0675
cc_10 N_Y_11 N_A_13 0.000730173f $X=0.648 $Y=0.0675
cc_11 N_Y_12 N_A_13 0.000730173f $X=0.648 $Y=0.2025
cc_12 N_Y_37 N_A_3 0.0189249f $X=0.0935 $Y=0.0675
cc_13 N_Y_43 N_A_4 0.0291622f $X=0.0935 $Y=0.2025
cc_14 N_Y_44 N_A_6 0.0471659f $X=0.2015 $Y=0.2025
cc_15 N_Y_45 N_A_8 0.0471659f $X=0.3095 $Y=0.2025
cc_16 N_Y_46 N_A_10 0.0471659f $X=0.4175 $Y=0.2025
cc_17 N_Y_47 N_A_12 0.0654107f $X=0.5255 $Y=0.2025
cc_18 N_Y_38 N_A_5 0.018914f $X=0.2015 $Y=0.0675
cc_19 N_Y_39 N_A_7 0.00082302f $X=0.3095 $Y=0.0675
cc_20 N_Y_40 N_A_9 0.00082302f $X=0.4175 $Y=0.0675
cc_21 N_Y_41 N_A_11 0.018914f $X=0.5255 $Y=0.0675
cc_22 N_Y_51 N_A_6 0.00141398f $X=0.0965 $Y=0.036
cc_23 N_Y_52 N_A_6 0.00141398f $X=0.0965 $Y=0.234
cc_24 N_Y_3 N_A_5 0.00156874f $X=0.216 $Y=0.0675
cc_25 N_Y_4 N_A_6 0.00156874f $X=0.216 $Y=0.2025
cc_26 N_Y_5 N_A_7 0.00156874f $X=0.324 $Y=0.0675
cc_27 N_Y_6 N_A_8 0.00156874f $X=0.324 $Y=0.2025
cc_28 N_Y_7 N_A_9 0.00156874f $X=0.432 $Y=0.0675
cc_29 N_Y_8 N_A_10 0.00156874f $X=0.432 $Y=0.2025
cc_30 N_Y_9 N_A_11 0.00156874f $X=0.54 $Y=0.0675
cc_31 N_Y_10 N_A_12 0.00156874f $X=0.54 $Y=0.2025
cc_32 N_Y_1 N_A_4 0.00191532f $X=0.108 $Y=0.0675
cc_33 N_Y_2 N_A_4 0.00191532f $X=0.108 $Y=0.2025
cc_34 N_Y_42 N_A_13 0.0141799f $X=0.6335 $Y=0.0675
cc_35 N_Y_48 N_A_13 0.0508283f $X=0.6335 $Y=0.2025
cc_36 N_Y_38 N_A_6 0.0101428f $X=0.2015 $Y=0.0675
cc_37 N_Y_39 N_A_8 0.0282338f $X=0.3095 $Y=0.0675
cc_38 N_Y_40 N_A_10 0.0282338f $X=0.4175 $Y=0.0675
cc_39 N_Y_41 N_A_12 0.0101428f $X=0.5255 $Y=0.0675
cc_40 N_Y_44 N_A_5 0.0542077f $X=0.2015 $Y=0.2025
cc_41 N_Y_45 N_A_7 0.0542832f $X=0.3095 $Y=0.2025
cc_42 N_Y_46 N_A_9 0.0542832f $X=0.4175 $Y=0.2025
cc_43 N_Y_45 N_A_1 0.0276483f $X=0.3095 $Y=0.2025
cc_44 N_Y_43 N_A_3 0.0359839f $X=0.0935 $Y=0.2025
cc_45 N_Y_47 N_A_11 0.036125f $X=0.5255 $Y=0.2025
cc_46 N_Y_37 N_A_4 0.0480147f $X=0.0935 $Y=0.0675
x_PM_INVx11_ASAP7_75t_R%A vss A N_M0_g N_M11_g N_M1_g N_M12_g N_M2_g N_M13_g
+ N_M3_g N_M14_g N_M4_g N_M15_g N_M5_g N_M16_g N_M6_g N_M17_g N_M7_g N_M18_g
+ N_M8_g N_M19_g N_M9_g N_M20_g N_M10_g N_M21_g N_A_1 N_A_13 N_A_17 N_A_18
+ N_A_14 N_A_16 N_A_11 N_A_19 N_A_3 N_A_4 N_A_6 N_A_8 N_A_10 N_A_12 N_A_5 N_A_7
+ N_A_9 PM_INVx11_ASAP7_75t_R%A

* End of included file INVx11_ASAP7_75t_R.pex.sp.pxi
.ends

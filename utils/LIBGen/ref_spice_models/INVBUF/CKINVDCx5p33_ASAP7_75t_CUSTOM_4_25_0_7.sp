.subckt PM_CKINVDCx5p33_ASAP7_75t_R%9 vss 19 23 33 36 46 47 50 51 3 18 15 4 1 9
+ 10 16 12 14
c1 1 vss 0.00632093f $X=0.189 $Y=0.135
c2 3 vss 0.00716133f $X=0.216 $Y=0.0675
c3 4 vss 0.00712993f $X=0.324 $Y=0.0675
c4 9 vss 0.103889f $X=0.189 $Y=0.0245
c5 10 vss 0.0822531f $X=0.243 $Y=0.135
c6 11 vss 0.00647727f $X=0.2015 $Y=0.0675
c7 12 vss 0.00686289f $X=0.3095 $Y=0.0675
c8 13 vss 0.000306633f $X=0.243 $Y=0.099
c9 14 vss 0.000204227f $X=0.243 $Y=0.135
c10 15 vss 0.00131556f $X=0.2015 $Y=0.099
c11 16 vss 0.000639431f $X=0.199 $Y=0.135
c12 17 vss 0.000149606f $X=0.243 $Y=0.117
c13 18 vss 0.00239429f $X=0.27 $Y=0.099
r1 51 49 0.0308642 $w=8.1e-08 $l=2.5e-09 $layer=N_src_drn $thickness=1e-09
+ $X=0.3413 $Y=0.0675 $X2=0.3385 $Y2=0.0675
r2 4 49 0.179012 $w=8.1e-08 $l=1.45e-08 $layer=N_src_drn $thickness=1e-09
+ $X=0.324 $Y=0.0675 $X2=0.3385 $Y2=0.0675
r3 12 4 0.179012 $w=8.1e-08 $l=1.45e-08 $layer=N_src_drn $thickness=1e-09
+ $X=0.3095 $Y=0.0675 $X2=0.324 $Y2=0.0675
r4 50 12 0.0308642 $w=8.1e-08 $l=2.5e-09 $layer=N_src_drn $thickness=1e-09
+ $X=0.3066 $Y=0.0675 $X2=0.3095 $Y2=0.0675
r5 47 45 0.0308642 $w=8.1e-08 $l=2.5e-09 $layer=N_src_drn $thickness=1e-09
+ $X=0.2333 $Y=0.0675 $X2=0.2305 $Y2=0.0675
r6 3 45 0.179012 $w=8.1e-08 $l=1.45e-08 $layer=N_src_drn $thickness=1e-09
+ $X=0.216 $Y=0.0675 $X2=0.2305 $Y2=0.0675
r7 11 3 0.179012 $w=8.1e-08 $l=1.45e-08 $layer=N_src_drn $thickness=1e-09
+ $X=0.2015 $Y=0.0675 $X2=0.216 $Y2=0.0675
r8 46 11 0.0308642 $w=8.1e-08 $l=2.5e-09 $layer=N_src_drn $thickness=1e-09
+ $X=0.1986 $Y=0.0675 $X2=0.2015 $Y2=0.0675
r9 4 42 19.3796 $a=3.24e-16 $layer=V0LISD $X=0.324 $Y=0.0675 $X2=0.324 $Y2=0.099
r10 3 38 19.3796 $a=3.24e-16 $layer=V0LISD $X=0.216 $Y=0.0675 $X2=0.216
+ $Y2=0.099
r11 41 42 5.24677 $w=1.3e-08 $l=2.25e-08 $layer=M1 $thickness=3.6e-08 $X=0.3015
+ $Y=0.099 $X2=0.324 $Y2=0.099
r12 18 41 7.34548 $w=1.3e-08 $l=3.15e-08 $layer=M1 $thickness=3.6e-08 $X=0.27
+ $Y=0.099 $X2=0.3015 $Y2=0.099
r13 38 39 3.14806 $w=1.3e-08 $l=1.35e-08 $layer=M1 $thickness=3.6e-08 $X=0.216
+ $Y=0.099 $X2=0.2295 $Y2=0.099
r14 15 38 3.38125 $w=1.3e-08 $l=1.45e-08 $layer=M1 $thickness=3.6e-08 $X=0.2015
+ $Y=0.099 $X2=0.216 $Y2=0.099
r15 13 17 3.01711 $w=1.55e-08 $l=1.8e-08 $layer=M1 $thickness=3.6e-08 $X=0.243
+ $Y=0.099 $X2=0.243 $Y2=0.117
r16 13 39 1.96775 $w=1.63333e-08 $l=1.35e-08 $layer=M1 $thickness=3.6e-08
+ $X=0.243 $Y=0.099 $X2=0.2295 $Y2=0.099
r17 13 18 5.11582 $w=1.46667e-08 $l=2.7e-08 $layer=M1 $thickness=3.6e-08
+ $X=0.243 $Y=0.099 $X2=0.27 $Y2=0.099
r18 14 31 1.49895 $w=1.63333e-08 $l=1.35e-08 $layer=M1 $thickness=3.6e-08
+ $X=0.243 $Y=0.135 $X2=0.2295 $Y2=0.135
r19 14 17 2.5483 $w=1.79e-08 $l=1.8e-08 $layer=M1 $thickness=3.6e-08 $X=0.243
+ $Y=0.135 $X2=0.243 $Y2=0.117
r20 36 35 16.4967 $w=2.1e-08 $l=4.85e-08 $layer=Gate_1 $thickness=5.6e-08
+ $X=0.243 $Y=0.2025 $X2=0.243 $Y2=0.154
r21 33 34 16.4967 $w=2.1e-08 $l=4.85e-08 $layer=Gate_1 $thickness=5.6e-08
+ $X=0.243 $Y=0.0675 $X2=0.243 $Y2=0.116
r22 10 27 6.54019 $w=2.09524e-08 $layer=Gate_1 $thickness=5.21905e-08 $X=0.243
+ $Y=0.135 $X2=0.243 $Y2=0.135
r23 10 34 6.6497 $w=2.04211e-08 $l=1.9e-08 $layer=Gate_1 $thickness=5.6e-08
+ $X=0.243 $Y=0.135 $X2=0.243 $Y2=0.116
r24 10 35 6.6497 $w=2.04211e-08 $l=1.9e-08 $layer=Gate_1 $thickness=5.6e-08
+ $X=0.243 $Y=0.135 $X2=0.243 $Y2=0.154
r25 30 31 3.14806 $w=1.3e-08 $l=1.35e-08 $layer=M1 $thickness=3.6e-08 $X=0.216
+ $Y=0.135 $X2=0.2295 $Y2=0.135
r26 29 30 2.68168 $w=1.3e-08 $l=1.15e-08 $layer=M1 $thickness=3.6e-08 $X=0.2045
+ $Y=0.135 $X2=0.216 $Y2=0.135
r27 16 29 1.28254 $w=1.3e-08 $l=5.5e-09 $layer=M1 $thickness=3.6e-08 $X=0.199
+ $Y=0.135 $X2=0.2045 $Y2=0.135
r28 26 27 12.6539 $w=1.77815e-08 $l=2.7e-08 $layer=LIG $thickness=4.8e-08
+ $X=0.216 $Y=0.135 $X2=0.243 $Y2=0.135
r29 26 30 19.3796 $a=3.24e-16 $layer=V0LIG $X=0.216 $Y=0.135 $X2=0.216 $Y2=0.135
r30 1 21 6.54019 $w=2.09524e-08 $layer=Gate_1 $thickness=5.21905e-08 $X=0.189
+ $Y=0.135 $X2=0.189 $Y2=0.135
r31 1 26 12.6539 $w=1.77815e-08 $l=2.7e-08 $layer=LIG $thickness=4.8e-08
+ $X=0.189 $Y=0.135 $X2=0.216 $Y2=0.135
r32 23 22 16.4967 $w=2.1e-08 $l=4.85e-08 $layer=Gate_1 $thickness=5.6e-08
+ $X=0.189 $Y=0.2025 $X2=0.189 $Y2=0.154
r33 21 22 6.6497 $w=2.04211e-08 $l=1.9e-08 $layer=Gate_1 $thickness=5.6e-08
+ $X=0.189 $Y=0.135 $X2=0.189 $Y2=0.154
r34 20 21 6.6497 $w=2.04211e-08 $l=1.9e-08 $layer=Gate_1 $thickness=5.6e-08
+ $X=0.189 $Y=0.116 $X2=0.189 $Y2=0.135
r35 19 20 16.4967 $w=2.1e-08 $l=4.85e-08 $layer=Gate_1 $thickness=5.6e-08
+ $X=0.189 $Y=0.0675 $X2=0.189 $Y2=0.116
r36 19 9 14.6259 $w=2.1e-08 $l=4.3e-08 $layer=Gate_1 $thickness=5.6e-08
+ $X=0.189 $Y=0.0675 $X2=0.189 $Y2=0.0245
.ends

.subckt PM_CKINVDCx5p33_ASAP7_75t_R%7 vss 19 23 33 36 46 47 50 51 10 11 15 17 9
+ 3 1 13 4 18
c1 1 vss 0.00632112f $X=0.621 $Y=0.135
c2 3 vss 0.00729666f $X=0.54 $Y=0.2025
c3 4 vss 0.00717311f $X=0.648 $Y=0.2025
c4 9 vss 0.0822746f $X=0.621 $Y=0.0245
c5 10 vss 0.117899f $X=0.675 $Y=0.135
c6 11 vss 0.00721159f $X=0.5255 $Y=0.2025
c7 12 vss 0.00671984f $X=0.6335 $Y=0.2025
c8 13 vss 0.000205788f $X=0.621 $Y=0.135
c9 14 vss 0.000306971f $X=0.621 $Y=0.171
c10 15 vss 0.00269345f $X=0.594 $Y=0.171
c11 16 vss 0.000149612f $X=0.621 $Y=0.153
c12 17 vss 0.00072798f $X=0.6345 $Y=0.135
c13 18 vss 0.00138525f $X=0.6345 $Y=0.171
r1 51 49 0.0308642 $w=8.1e-08 $l=2.5e-09 $layer=P_src_drn $thickness=1e-09
+ $X=0.6653 $Y=0.2025 $X2=0.6625 $Y2=0.2025
r2 4 49 0.179012 $w=8.1e-08 $l=1.45e-08 $layer=P_src_drn $thickness=1e-09
+ $X=0.648 $Y=0.2025 $X2=0.6625 $Y2=0.2025
r3 12 4 0.179012 $w=8.1e-08 $l=1.45e-08 $layer=P_src_drn $thickness=1e-09
+ $X=0.6335 $Y=0.2025 $X2=0.648 $Y2=0.2025
r4 50 12 0.0308642 $w=8.1e-08 $l=2.5e-09 $layer=P_src_drn $thickness=1e-09
+ $X=0.6306 $Y=0.2025 $X2=0.6335 $Y2=0.2025
r5 47 45 0.0308642 $w=8.1e-08 $l=2.5e-09 $layer=P_src_drn $thickness=1e-09
+ $X=0.5573 $Y=0.2025 $X2=0.5545 $Y2=0.2025
r6 3 45 0.179012 $w=8.1e-08 $l=1.45e-08 $layer=P_src_drn $thickness=1e-09
+ $X=0.54 $Y=0.2025 $X2=0.5545 $Y2=0.2025
r7 11 3 0.179012 $w=8.1e-08 $l=1.45e-08 $layer=P_src_drn $thickness=1e-09
+ $X=0.5255 $Y=0.2025 $X2=0.54 $Y2=0.2025
r8 46 11 0.0308642 $w=8.1e-08 $l=2.5e-09 $layer=P_src_drn $thickness=1e-09
+ $X=0.5226 $Y=0.2025 $X2=0.5255 $Y2=0.2025
r9 4 41 19.3796 $a=3.24e-16 $layer=V0LISD $X=0.648 $Y=0.2025 $X2=0.648 $Y2=0.171
r10 3 39 19.3796 $a=3.24e-16 $layer=V0LISD $X=0.54 $Y=0.2025 $X2=0.54 $Y2=0.171
r11 18 41 3.14806 $w=1.3e-08 $l=1.35e-08 $layer=M1 $thickness=3.6e-08 $X=0.6345
+ $Y=0.171 $X2=0.648 $Y2=0.171
r12 39 40 5.24677 $w=1.3e-08 $l=2.25e-08 $layer=M1 $thickness=3.6e-08 $X=0.54
+ $Y=0.171 $X2=0.5625 $Y2=0.171
r13 15 40 7.34548 $w=1.3e-08 $l=3.15e-08 $layer=M1 $thickness=3.6e-08 $X=0.594
+ $Y=0.171 $X2=0.5625 $Y2=0.171
r14 14 16 3.01711 $w=1.55e-08 $l=1.8e-08 $layer=M1 $thickness=3.6e-08 $X=0.621
+ $Y=0.171 $X2=0.621 $Y2=0.153
r15 14 15 5.11582 $w=1.46667e-08 $l=2.7e-08 $layer=M1 $thickness=3.6e-08
+ $X=0.621 $Y=0.171 $X2=0.594 $Y2=0.171
r16 14 18 1.96775 $w=1.63333e-08 $l=1.35e-08 $layer=M1 $thickness=3.6e-08
+ $X=0.621 $Y=0.171 $X2=0.6345 $Y2=0.171
r17 13 17 1.49895 $w=1.63333e-08 $l=1.35e-08 $layer=M1 $thickness=3.6e-08
+ $X=0.621 $Y=0.135 $X2=0.6345 $Y2=0.135
r18 13 16 2.5483 $w=1.79e-08 $l=1.8e-08 $layer=M1 $thickness=3.6e-08 $X=0.621
+ $Y=0.135 $X2=0.621 $Y2=0.153
r19 36 35 16.4967 $w=2.1e-08 $l=4.85e-08 $layer=Gate_1 $thickness=5.6e-08
+ $X=0.675 $Y=0.2025 $X2=0.675 $Y2=0.154
r20 33 34 16.4967 $w=2.1e-08 $l=4.85e-08 $layer=Gate_1 $thickness=5.6e-08
+ $X=0.675 $Y=0.0675 $X2=0.675 $Y2=0.116
r21 10 27 6.54019 $w=2.09524e-08 $layer=Gate_1 $thickness=5.21905e-08 $X=0.675
+ $Y=0.135 $X2=0.675 $Y2=0.135
r22 10 34 6.6497 $w=2.04211e-08 $l=1.9e-08 $layer=Gate_1 $thickness=5.6e-08
+ $X=0.675 $Y=0.135 $X2=0.675 $Y2=0.116
r23 10 35 6.6497 $w=2.04211e-08 $l=1.9e-08 $layer=Gate_1 $thickness=5.6e-08
+ $X=0.675 $Y=0.135 $X2=0.675 $Y2=0.154
r24 17 29 3.14806 $w=1.3e-08 $l=1.35e-08 $layer=M1 $thickness=3.6e-08 $X=0.6345
+ $Y=0.135 $X2=0.648 $Y2=0.135
r25 26 27 12.6539 $w=1.77815e-08 $l=2.7e-08 $layer=LIG $thickness=4.8e-08
+ $X=0.648 $Y=0.135 $X2=0.675 $Y2=0.135
r26 26 29 19.3796 $a=3.24e-16 $layer=V0LIG $X=0.648 $Y=0.135 $X2=0.648 $Y2=0.135
r27 1 21 6.54019 $w=2.09524e-08 $layer=Gate_1 $thickness=5.21905e-08 $X=0.621
+ $Y=0.135 $X2=0.621 $Y2=0.135
r28 1 26 12.6539 $w=1.77815e-08 $l=2.7e-08 $layer=LIG $thickness=4.8e-08
+ $X=0.621 $Y=0.135 $X2=0.648 $Y2=0.135
r29 23 22 16.4967 $w=2.1e-08 $l=4.85e-08 $layer=Gate_1 $thickness=5.6e-08
+ $X=0.621 $Y=0.2025 $X2=0.621 $Y2=0.154
r30 21 22 6.6497 $w=2.04211e-08 $l=1.9e-08 $layer=Gate_1 $thickness=5.6e-08
+ $X=0.621 $Y=0.135 $X2=0.621 $Y2=0.154
r31 20 21 6.6497 $w=2.04211e-08 $l=1.9e-08 $layer=Gate_1 $thickness=5.6e-08
+ $X=0.621 $Y=0.116 $X2=0.621 $Y2=0.135
r32 19 20 16.4967 $w=2.1e-08 $l=4.85e-08 $layer=Gate_1 $thickness=5.6e-08
+ $X=0.621 $Y=0.0675 $X2=0.621 $Y2=0.116
r33 19 9 14.6259 $w=2.1e-08 $l=4.3e-08 $layer=Gate_1 $thickness=5.6e-08
+ $X=0.621 $Y=0.0675 $X2=0.621 $Y2=0.0245
.ends

.subckt PM_CKINVDCx5p33_ASAP7_75t_R%4 vss 19 23 33 36 46 47 50 51 4 15 17 3 1
+ 10 9 18 11 14
c1 1 vss 0.00631968f $X=0.945 $Y=0.135
c2 3 vss 0.00712882f $X=0.864 $Y=0.0675
c3 4 vss 0.00715978f $X=0.972 $Y=0.0675
c4 9 vss 0.0822503f $X=0.945 $Y=0.0245
c5 10 vss 0.103888f $X=0.999 $Y=0.135
c6 11 vss 0.00682696f $X=0.8495 $Y=0.0675
c7 12 vss 0.00644385f $X=0.9575 $Y=0.0675
c8 13 vss 0.000306588f $X=0.945 $Y=0.099
c9 14 vss 0.000204021f $X=0.945 $Y=0.135
c10 15 vss 0.00238912f $X=0.918 $Y=0.099
c11 16 vss 0.000149605f $X=0.945 $Y=0.117
c12 17 vss 0.00130879f $X=0.9585 $Y=0.099
c13 18 vss 0.000635123f $X=0.9585 $Y=0.135
r1 51 49 0.0308642 $w=8.1e-08 $l=2.5e-09 $layer=N_src_drn $thickness=1e-09
+ $X=0.9893 $Y=0.0675 $X2=0.9865 $Y2=0.0675
r2 4 49 0.179012 $w=8.1e-08 $l=1.45e-08 $layer=N_src_drn $thickness=1e-09
+ $X=0.972 $Y=0.0675 $X2=0.9865 $Y2=0.0675
r3 12 4 0.179012 $w=8.1e-08 $l=1.45e-08 $layer=N_src_drn $thickness=1e-09
+ $X=0.9575 $Y=0.0675 $X2=0.972 $Y2=0.0675
r4 50 12 0.0308642 $w=8.1e-08 $l=2.5e-09 $layer=N_src_drn $thickness=1e-09
+ $X=0.9546 $Y=0.0675 $X2=0.9575 $Y2=0.0675
r5 47 45 0.0308642 $w=8.1e-08 $l=2.5e-09 $layer=N_src_drn $thickness=1e-09
+ $X=0.8813 $Y=0.0675 $X2=0.8785 $Y2=0.0675
r6 3 45 0.179012 $w=8.1e-08 $l=1.45e-08 $layer=N_src_drn $thickness=1e-09
+ $X=0.864 $Y=0.0675 $X2=0.8785 $Y2=0.0675
r7 11 3 0.179012 $w=8.1e-08 $l=1.45e-08 $layer=N_src_drn $thickness=1e-09
+ $X=0.8495 $Y=0.0675 $X2=0.864 $Y2=0.0675
r8 46 11 0.0308642 $w=8.1e-08 $l=2.5e-09 $layer=N_src_drn $thickness=1e-09
+ $X=0.8466 $Y=0.0675 $X2=0.8495 $Y2=0.0675
r9 4 41 19.3796 $a=3.24e-16 $layer=V0LISD $X=0.972 $Y=0.0675 $X2=0.972 $Y2=0.099
r10 3 39 19.3796 $a=3.24e-16 $layer=V0LISD $X=0.864 $Y=0.0675 $X2=0.864
+ $Y2=0.099
r11 17 41 3.14806 $w=1.3e-08 $l=1.35e-08 $layer=M1 $thickness=3.6e-08 $X=0.9585
+ $Y=0.099 $X2=0.972 $Y2=0.099
r12 39 40 5.24677 $w=1.3e-08 $l=2.25e-08 $layer=M1 $thickness=3.6e-08 $X=0.864
+ $Y=0.099 $X2=0.8865 $Y2=0.099
r13 15 40 7.34548 $w=1.3e-08 $l=3.15e-08 $layer=M1 $thickness=3.6e-08 $X=0.918
+ $Y=0.099 $X2=0.8865 $Y2=0.099
r14 13 16 3.01711 $w=1.55e-08 $l=1.8e-08 $layer=M1 $thickness=3.6e-08 $X=0.945
+ $Y=0.099 $X2=0.945 $Y2=0.117
r15 13 15 5.11582 $w=1.46667e-08 $l=2.7e-08 $layer=M1 $thickness=3.6e-08
+ $X=0.945 $Y=0.099 $X2=0.918 $Y2=0.099
r16 13 17 1.96775 $w=1.63333e-08 $l=1.35e-08 $layer=M1 $thickness=3.6e-08
+ $X=0.945 $Y=0.099 $X2=0.9585 $Y2=0.099
r17 14 18 1.49895 $w=1.63333e-08 $l=1.35e-08 $layer=M1 $thickness=3.6e-08
+ $X=0.945 $Y=0.135 $X2=0.9585 $Y2=0.135
r18 14 16 2.5483 $w=1.79e-08 $l=1.8e-08 $layer=M1 $thickness=3.6e-08 $X=0.945
+ $Y=0.135 $X2=0.945 $Y2=0.117
r19 36 35 16.4967 $w=2.1e-08 $l=4.85e-08 $layer=Gate_1 $thickness=5.6e-08
+ $X=0.999 $Y=0.2025 $X2=0.999 $Y2=0.154
r20 33 34 16.4967 $w=2.1e-08 $l=4.85e-08 $layer=Gate_1 $thickness=5.6e-08
+ $X=0.999 $Y=0.0675 $X2=0.999 $Y2=0.116
r21 10 27 6.54019 $w=2.09524e-08 $layer=Gate_1 $thickness=5.21905e-08 $X=0.999
+ $Y=0.135 $X2=0.999 $Y2=0.135
r22 10 34 6.6497 $w=2.04211e-08 $l=1.9e-08 $layer=Gate_1 $thickness=5.6e-08
+ $X=0.999 $Y=0.135 $X2=0.999 $Y2=0.116
r23 10 35 6.6497 $w=2.04211e-08 $l=1.9e-08 $layer=Gate_1 $thickness=5.6e-08
+ $X=0.999 $Y=0.135 $X2=0.999 $Y2=0.154
r24 18 29 3.14806 $w=1.3e-08 $l=1.35e-08 $layer=M1 $thickness=3.6e-08 $X=0.9585
+ $Y=0.135 $X2=0.972 $Y2=0.135
r25 26 27 12.6539 $w=1.77815e-08 $l=2.7e-08 $layer=LIG $thickness=4.8e-08
+ $X=0.972 $Y=0.135 $X2=0.999 $Y2=0.135
r26 26 29 19.3796 $a=3.24e-16 $layer=V0LIG $X=0.972 $Y=0.135 $X2=0.972 $Y2=0.135
r27 1 21 6.54019 $w=2.09524e-08 $layer=Gate_1 $thickness=5.21905e-08 $X=0.945
+ $Y=0.135 $X2=0.945 $Y2=0.135
r28 1 26 12.6539 $w=1.77815e-08 $l=2.7e-08 $layer=LIG $thickness=4.8e-08
+ $X=0.945 $Y=0.135 $X2=0.972 $Y2=0.135
r29 23 22 16.4967 $w=2.1e-08 $l=4.85e-08 $layer=Gate_1 $thickness=5.6e-08
+ $X=0.945 $Y=0.2025 $X2=0.945 $Y2=0.154
r30 21 22 6.6497 $w=2.04211e-08 $l=1.9e-08 $layer=Gate_1 $thickness=5.6e-08
+ $X=0.945 $Y=0.135 $X2=0.945 $Y2=0.154
r31 20 21 6.6497 $w=2.04211e-08 $l=1.9e-08 $layer=Gate_1 $thickness=5.6e-08
+ $X=0.945 $Y=0.116 $X2=0.945 $Y2=0.135
r32 19 20 16.4967 $w=2.1e-08 $l=4.85e-08 $layer=Gate_1 $thickness=5.6e-08
+ $X=0.945 $Y=0.0675 $X2=0.945 $Y2=0.116
r33 19 9 14.6259 $w=2.1e-08 $l=4.3e-08 $layer=Gate_1 $thickness=5.6e-08
+ $X=0.945 $Y=0.0675 $X2=0.945 $Y2=0.0245
.ends

.subckt PM_CKINVDCx5p33_ASAP7_75t_R%A vss 57 32 38 50 53 98 101 104 107 122 125
+ 128 131 144 147 151 155 18 1 20 27 26 10 2 11 29 28 12 3 13 21 4 30 14 15 24
+ 17 23 9 25 31 16
c1 1 vss 0.00857541f $X=0.0765 $Y=0.135
c2 2 vss 0.00786527f $X=0.4005 $Y=0.135
c3 3 vss 0.00723964f $X=0.7515 $Y=0.135
c4 4 vss 0.00857541f $X=1.0755 $Y=0.135
c5 9 vss 0.0672802f $X=0.081 $Y=0.0245
c6 10 vss 0.0860822f $X=0.135 $Y=0.135
c7 11 vss 0.0865413f $X=0.405 $Y=0.135
c8 12 vss 0.0847896f $X=0.459 $Y=0.135
c9 13 vss 0.0850694f $X=0.729 $Y=0.135
c10 14 vss 0.0865413f $X=0.783 $Y=0.135
c11 15 vss 0.0860822f $X=1.053 $Y=0.135
c12 16 vss 0.0672802f $X=1.107 $Y=0.135
c13 17 vss 0.00483624f $X=0.059 $Y=0.036
c14 18 vss 0.00757307f $X=0.075 $Y=0.135
c15 19 vss 0.00238337f $X=0.383 $Y=0.036
c16 20 vss 0.00186624f $X=0.383 $Y=0.135
c17 21 vss 0.001901f $X=0.805 $Y=0.135
c18 22 vss 0.00238337f $X=0.805 $Y=0.036
c19 23 vss 0.00759853f $X=1.129 $Y=0.135
c20 24 vss 0.00483653f $X=1.129 $Y=0.036
c21 25 vss 0.0111015f $X=0.059 $Y=0.1035
c22 26 vss 0.0378904f $X=0.081 $Y=0.036
c23 27 vss 0.00353387f $X=0.383 $Y=0.054
c24 28 vss 0.0536317f $X=0.405 $Y=0.036
c25 29 vss 0.00353355f $X=0.805 $Y=0.054
c26 30 vss 0.0374573f $X=0.8225 $Y=0.036
c27 31 vss 0.0111018f $X=1.129 $Y=0.054
r1 155 154 14.6259 $w=2.1e-08 $l=4.3e-08 $layer=Gate_1 $thickness=5.6e-08
+ $X=1.107 $Y=0.216 $X2=1.107 $Y2=0.173
r2 153 154 7.48304 $w=2.1e-08 $l=2.2e-08 $layer=Gate_1 $thickness=5.6e-08
+ $X=1.107 $Y=0.151 $X2=1.107 $Y2=0.173
r3 151 152 14.6259 $w=2.1e-08 $l=4.3e-08 $layer=Gate_1 $thickness=5.6e-08
+ $X=1.107 $Y=0.054 $X2=1.107 $Y2=0.097
r4 149 152 7.48304 $w=2.1e-08 $l=2.2e-08 $layer=Gate_1 $thickness=5.6e-08
+ $X=1.107 $Y=0.119 $X2=1.107 $Y2=0.097
r5 16 141 3.57145 $w=2e-08 $layer=Gate_1 $thickness=5.6e-08 $X=1.107 $Y=0.135
+ $X2=1.107 $Y2=0.135
r6 16 149 5.61228 $w=2.0375e-08 $l=1.6e-08 $layer=Gate_1 $thickness=5.6e-08
+ $X=1.107 $Y=0.135 $X2=1.107 $Y2=0.119
r7 16 153 5.61228 $w=2.0375e-08 $l=1.6e-08 $layer=Gate_1 $thickness=5.6e-08
+ $X=1.107 $Y=0.135 $X2=1.107 $Y2=0.151
r8 147 146 16.6668 $w=2.1e-08 $l=4.9e-08 $layer=Gate_1 $thickness=5.6e-08
+ $X=1.053 $Y=0.216 $X2=1.053 $Y2=0.167
r9 144 145 16.6668 $w=2.1e-08 $l=4.9e-08 $layer=Gate_1 $thickness=5.6e-08
+ $X=1.053 $Y=0.054 $X2=1.053 $Y2=0.103
r10 15 137 6.74717 $w=2e-08 $layer=Gate_1 $thickness=5.2e-08 $X=1.053 $Y=0.135
+ $X2=1.053 $Y2=0.135
r11 15 145 11.0545 $w=2.06875e-08 $l=3.2e-08 $layer=Gate_1 $thickness=5.6e-08
+ $X=1.053 $Y=0.135 $X2=1.053 $Y2=0.103
r12 15 146 11.0545 $w=2.06875e-08 $l=3.2e-08 $layer=Gate_1 $thickness=5.6e-08
+ $X=1.053 $Y=0.135 $X2=1.053 $Y2=0.167
r13 140 141 1.74665 $w=2e-08 $l=4.5e-09 $layer=LIG $thickness=4.8e-08 $X=1.1115
+ $Y=0.135 $X2=1.107 $Y2=0.135
r14 139 140 3.17572 $w=2e-08 $l=1e-08 $layer=LIG $thickness=4.8e-08 $X=1.1015
+ $Y=0.135 $X2=1.1115 $Y2=0.135
r15 136 139 5.91273 $w=1.665e-08 $l=9e-09 $layer=LIG $thickness=4.8e-08
+ $X=1.0925 $Y=0.135 $X2=1.1015 $Y2=0.135
r16 4 136 16.9382 $w=1.33e-08 $l=1.7e-08 $layer=LIG $thickness=4.8e-08
+ $X=1.0755 $Y=0.135 $X2=1.0925 $Y2=0.135
r17 4 137 15.6303 $w=1.62778e-08 $l=2.25e-08 $layer=LIG $thickness=4.8e-08
+ $X=1.0755 $Y=0.135 $X2=1.053 $Y2=0.135
r18 133 134 3.03147 $w=1.3e-08 $l=1.3e-08 $layer=M1 $thickness=3.6e-08 $X=1.1
+ $Y=0.135 $X2=1.113 $Y2=0.135
r19 133 136 19.3796 $a=3.24e-16 $layer=V0LIG $X=1.1 $Y=0.135 $X2=1.0925
+ $Y2=0.135
r20 23 120 6.16517 $w=1.44286e-08 $l=3.15e-08 $layer=M1 $thickness=3.6e-08
+ $X=1.129 $Y=0.135 $X2=1.129 $Y2=0.1035
r21 23 134 2.55073 $w=1.58125e-08 $l=1.6e-08 $layer=M1 $thickness=3.6e-08
+ $X=1.129 $Y=0.135 $X2=1.113 $Y2=0.135
r22 131 130 16.6668 $w=2.1e-08 $l=4.9e-08 $layer=Gate_1 $thickness=5.6e-08
+ $X=0.783 $Y=0.216 $X2=0.783 $Y2=0.167
r23 128 129 16.6668 $w=2.1e-08 $l=4.9e-08 $layer=Gate_1 $thickness=5.6e-08
+ $X=0.783 $Y=0.054 $X2=0.783 $Y2=0.103
r24 14 117 3.57145 $w=2e-08 $layer=Gate_1 $thickness=5.6e-08 $X=0.783 $Y=0.135
+ $X2=0.783 $Y2=0.135
r25 14 129 11.0545 $w=2.06875e-08 $l=3.2e-08 $layer=Gate_1 $thickness=5.6e-08
+ $X=0.783 $Y=0.135 $X2=0.783 $Y2=0.103
r26 14 130 11.0545 $w=2.06875e-08 $l=3.2e-08 $layer=Gate_1 $thickness=5.6e-08
+ $X=0.783 $Y=0.135 $X2=0.783 $Y2=0.167
r27 125 124 16.6668 $w=2.1e-08 $l=4.9e-08 $layer=Gate_1 $thickness=5.6e-08
+ $X=0.729 $Y=0.216 $X2=0.729 $Y2=0.167
r28 122 123 16.6668 $w=2.1e-08 $l=4.9e-08 $layer=Gate_1 $thickness=5.6e-08
+ $X=0.729 $Y=0.054 $X2=0.729 $Y2=0.103
r29 13 113 6.74717 $w=2e-08 $layer=Gate_1 $thickness=5.2e-08 $X=0.729 $Y=0.135
+ $X2=0.729 $Y2=0.135
r30 13 123 11.0545 $w=2.06875e-08 $l=3.2e-08 $layer=Gate_1 $thickness=5.6e-08
+ $X=0.729 $Y=0.135 $X2=0.729 $Y2=0.103
r31 13 124 11.0545 $w=2.06875e-08 $l=3.2e-08 $layer=Gate_1 $thickness=5.6e-08
+ $X=0.729 $Y=0.135 $X2=0.729 $Y2=0.167
r32 119 120 7.34548 $w=1.3e-08 $l=3.15e-08 $layer=M1 $thickness=3.6e-08
+ $X=1.129 $Y=0.072 $X2=1.129 $Y2=0.1035
r33 31 119 4.19742 $w=1.3e-08 $l=1.8e-08 $layer=M1 $thickness=3.6e-08 $X=1.129
+ $Y=0.054 $X2=1.129 $Y2=0.072
r34 116 117 1.74665 $w=2e-08 $l=4.5e-09 $layer=LIG $thickness=4.8e-08 $X=0.7875
+ $Y=0.135 $X2=0.783 $Y2=0.135
r35 115 116 3.17572 $w=2e-08 $l=1e-08 $layer=LIG $thickness=4.8e-08 $X=0.7775
+ $Y=0.135 $X2=0.7875 $Y2=0.135
r36 112 115 5.91273 $w=1.665e-08 $l=9e-09 $layer=LIG $thickness=4.8e-08
+ $X=0.7685 $Y=0.135 $X2=0.7775 $Y2=0.135
r37 3 112 16.9382 $w=1.33e-08 $l=1.7e-08 $layer=LIG $thickness=4.8e-08
+ $X=0.7515 $Y=0.135 $X2=0.7685 $Y2=0.135
r38 3 113 15.6303 $w=1.62778e-08 $l=2.25e-08 $layer=LIG $thickness=4.8e-08
+ $X=0.7515 $Y=0.135 $X2=0.729 $Y2=0.135
r39 24 96 3.48106 $w=1.50455e-08 $l=2.2e-08 $layer=M1 $thickness=3.6e-08
+ $X=1.129 $Y=0.036 $X2=1.107 $Y2=0.036
r40 24 31 2.5483 $w=1.79e-08 $l=1.8e-08 $layer=M1 $thickness=3.6e-08 $X=1.129
+ $Y=0.036 $X2=1.129 $Y2=0.054
r41 109 110 3.03147 $w=1.3e-08 $l=1.3e-08 $layer=M1 $thickness=3.6e-08 $X=0.776
+ $Y=0.135 $X2=0.789 $Y2=0.135
r42 109 112 19.3796 $a=3.24e-16 $layer=V0LIG $X=0.776 $Y=0.135 $X2=0.7685
+ $Y2=0.135
r43 21 90 3.01711 $w=1.55e-08 $l=1.8e-08 $layer=M1 $thickness=3.6e-08 $X=0.805
+ $Y=0.135 $X2=0.805 $Y2=0.117
r44 21 110 2.55073 $w=1.58125e-08 $l=1.6e-08 $layer=M1 $thickness=3.6e-08
+ $X=0.805 $Y=0.135 $X2=0.789 $Y2=0.135
r45 107 106 16.6668 $w=2.1e-08 $l=4.9e-08 $layer=Gate_1 $thickness=5.6e-08
+ $X=0.459 $Y=0.216 $X2=0.459 $Y2=0.167
r46 104 105 16.6668 $w=2.1e-08 $l=4.9e-08 $layer=Gate_1 $thickness=5.6e-08
+ $X=0.459 $Y=0.054 $X2=0.459 $Y2=0.103
r47 12 85 6.74717 $w=2e-08 $layer=Gate_1 $thickness=5.2e-08 $X=0.459 $Y=0.135
+ $X2=0.459 $Y2=0.135
r48 12 105 11.0545 $w=2.06875e-08 $l=3.2e-08 $layer=Gate_1 $thickness=5.6e-08
+ $X=0.459 $Y=0.135 $X2=0.459 $Y2=0.103
r49 12 106 11.0545 $w=2.06875e-08 $l=3.2e-08 $layer=Gate_1 $thickness=5.6e-08
+ $X=0.459 $Y=0.135 $X2=0.459 $Y2=0.167
r50 101 100 16.6668 $w=2.1e-08 $l=4.9e-08 $layer=Gate_1 $thickness=5.6e-08
+ $X=0.405 $Y=0.216 $X2=0.405 $Y2=0.167
r51 98 99 16.6668 $w=2.1e-08 $l=4.9e-08 $layer=Gate_1 $thickness=5.6e-08
+ $X=0.405 $Y=0.054 $X2=0.405 $Y2=0.103
r52 11 81 3.57145 $w=2e-08 $layer=Gate_1 $thickness=5.6e-08 $X=0.405 $Y=0.135
+ $X2=0.405 $Y2=0.135
r53 11 99 11.0545 $w=2.06875e-08 $l=3.2e-08 $layer=Gate_1 $thickness=5.6e-08
+ $X=0.405 $Y=0.135 $X2=0.405 $Y2=0.103
r54 11 100 11.0545 $w=2.06875e-08 $l=3.2e-08 $layer=Gate_1 $thickness=5.6e-08
+ $X=0.405 $Y=0.135 $X2=0.405 $Y2=0.167
r55 95 96 8.86121 $w=1.3e-08 $l=3.8e-08 $layer=M1 $thickness=3.6e-08 $X=1.069
+ $Y=0.036 $X2=1.107 $Y2=0.036
r56 94 95 10.7267 $w=1.3e-08 $l=4.6e-08 $layer=M1 $thickness=3.6e-08 $X=1.023
+ $Y=0.036 $X2=1.069 $Y2=0.036
r57 93 94 22.6194 $w=1.3e-08 $l=9.7e-08 $layer=M1 $thickness=3.6e-08 $X=0.926
+ $Y=0.036 $X2=1.023 $Y2=0.036
r58 92 93 18.6552 $w=1.3e-08 $l=8e-08 $layer=M1 $thickness=3.6e-08 $X=0.846
+ $Y=0.036 $X2=0.926 $Y2=0.036
r59 91 92 2.2153 $w=1.3e-08 $l=9.5e-09 $layer=M1 $thickness=3.6e-08 $X=0.8365
+ $Y=0.036 $X2=0.846 $Y2=0.036
r60 30 91 3.26466 $w=1.3e-08 $l=1.4e-08 $layer=M1 $thickness=3.6e-08 $X=0.8225
+ $Y=0.036 $X2=0.8365 $Y2=0.036
r61 89 90 4.19742 $w=1.3e-08 $l=1.8e-08 $layer=M1 $thickness=3.6e-08 $X=0.805
+ $Y=0.099 $X2=0.805 $Y2=0.117
r62 88 89 3.14806 $w=1.3e-08 $l=1.35e-08 $layer=M1 $thickness=3.6e-08 $X=0.805
+ $Y=0.0855 $X2=0.805 $Y2=0.099
r63 87 88 3.14806 $w=1.3e-08 $l=1.35e-08 $layer=M1 $thickness=3.6e-08 $X=0.805
+ $Y=0.072 $X2=0.805 $Y2=0.0855
r64 29 87 4.19742 $w=1.3e-08 $l=1.8e-08 $layer=M1 $thickness=3.6e-08 $X=0.805
+ $Y=0.054 $X2=0.805 $Y2=0.072
r65 84 85 15.6303 $w=1.62778e-08 $l=2.25e-08 $layer=LIG $thickness=4.8e-08
+ $X=0.4365 $Y=0.135 $X2=0.459 $Y2=0.135
r66 83 84 16.9382 $w=1.33e-08 $l=1.7e-08 $layer=LIG $thickness=4.8e-08
+ $X=0.4195 $Y=0.135 $X2=0.4365 $Y2=0.135
r67 80 83 5.91273 $w=1.665e-08 $l=9e-09 $layer=LIG $thickness=4.8e-08 $X=0.4105
+ $Y=0.135 $X2=0.4195 $Y2=0.135
r68 2 80 3.17572 $w=2e-08 $l=1e-08 $layer=LIG $thickness=4.8e-08 $X=0.4005
+ $Y=0.135 $X2=0.4105 $Y2=0.135
r69 2 81 1.74665 $w=2e-08 $l=4.5e-09 $layer=LIG $thickness=4.8e-08 $X=0.4005
+ $Y=0.135 $X2=0.405 $Y2=0.135
r70 22 76 3.94987 $w=1.50455e-08 $l=2.2e-08 $layer=M1 $thickness=3.6e-08
+ $X=0.805 $Y=0.036 $X2=0.783 $Y2=0.036
r71 22 29 3.01711 $w=1.55e-08 $l=1.8e-08 $layer=M1 $thickness=3.6e-08 $X=0.805
+ $Y=0.036 $X2=0.805 $Y2=0.054
r72 22 30 2.90051 $w=1.55714e-08 $l=1.75e-08 $layer=M1 $thickness=3.6e-08
+ $X=0.805 $Y=0.036 $X2=0.8225 $Y2=0.036
r73 78 80 19.3796 $a=3.24e-16 $layer=V0LIG $X=0.412 $Y=0.135 $X2=0.4105
+ $Y2=0.135
r74 77 78 3.03147 $w=1.3e-08 $l=1.3e-08 $layer=M1 $thickness=3.6e-08 $X=0.399
+ $Y=0.135 $X2=0.412 $Y2=0.135
r75 20 68 3.01711 $w=1.55e-08 $l=1.8e-08 $layer=M1 $thickness=3.6e-08 $X=0.383
+ $Y=0.135 $X2=0.383 $Y2=0.117
r76 20 77 2.55073 $w=1.58125e-08 $l=1.6e-08 $layer=M1 $thickness=3.6e-08
+ $X=0.383 $Y=0.135 $X2=0.399 $Y2=0.135
r77 75 76 8.86121 $w=1.3e-08 $l=3.8e-08 $layer=M1 $thickness=3.6e-08 $X=0.745
+ $Y=0.036 $X2=0.783 $Y2=0.036
r78 74 75 10.3769 $w=1.3e-08 $l=4.45e-08 $layer=M1 $thickness=3.6e-08 $X=0.7005
+ $Y=0.036 $X2=0.745 $Y2=0.036
r79 73 74 5.82974 $w=1.3e-08 $l=2.5e-08 $layer=M1 $thickness=3.6e-08 $X=0.6755
+ $Y=0.036 $X2=0.7005 $Y2=0.036
r80 72 73 2.2153 $w=1.3e-08 $l=9.5e-09 $layer=M1 $thickness=3.6e-08 $X=0.666
+ $Y=0.036 $X2=0.6755 $Y2=0.036
r81 71 72 18.6552 $w=1.3e-08 $l=8e-08 $layer=M1 $thickness=3.6e-08 $X=0.586
+ $Y=0.036 $X2=0.666 $Y2=0.036
r82 70 71 22.6194 $w=1.3e-08 $l=9.7e-08 $layer=M1 $thickness=3.6e-08 $X=0.489
+ $Y=0.036 $X2=0.586 $Y2=0.036
r83 69 70 10.7267 $w=1.3e-08 $l=4.6e-08 $layer=M1 $thickness=3.6e-08 $X=0.443
+ $Y=0.036 $X2=0.489 $Y2=0.036
r84 28 69 8.86121 $w=1.3e-08 $l=3.8e-08 $layer=M1 $thickness=3.6e-08 $X=0.405
+ $Y=0.036 $X2=0.443 $Y2=0.036
r85 67 68 4.19742 $w=1.3e-08 $l=1.8e-08 $layer=M1 $thickness=3.6e-08 $X=0.383
+ $Y=0.099 $X2=0.383 $Y2=0.117
r86 66 67 3.14806 $w=1.3e-08 $l=1.35e-08 $layer=M1 $thickness=3.6e-08 $X=0.383
+ $Y=0.0855 $X2=0.383 $Y2=0.099
r87 65 66 3.14806 $w=1.3e-08 $l=1.35e-08 $layer=M1 $thickness=3.6e-08 $X=0.383
+ $Y=0.072 $X2=0.383 $Y2=0.0855
r88 27 65 4.19742 $w=1.3e-08 $l=1.8e-08 $layer=M1 $thickness=3.6e-08 $X=0.383
+ $Y=0.054 $X2=0.383 $Y2=0.072
r89 19 64 2.90051 $w=1.55714e-08 $l=1.75e-08 $layer=M1 $thickness=3.6e-08
+ $X=0.383 $Y=0.036 $X2=0.3655 $Y2=0.036
r90 19 27 3.01711 $w=1.55e-08 $l=1.8e-08 $layer=M1 $thickness=3.6e-08 $X=0.383
+ $Y=0.036 $X2=0.383 $Y2=0.054
r91 19 28 3.94987 $w=1.50455e-08 $l=2.2e-08 $layer=M1 $thickness=3.6e-08
+ $X=0.383 $Y=0.036 $X2=0.405 $Y2=0.036
r92 63 64 3.26466 $w=1.3e-08 $l=1.4e-08 $layer=M1 $thickness=3.6e-08 $X=0.3515
+ $Y=0.036 $X2=0.3655 $Y2=0.036
r93 62 63 2.2153 $w=1.3e-08 $l=9.5e-09 $layer=M1 $thickness=3.6e-08 $X=0.342
+ $Y=0.036 $X2=0.3515 $Y2=0.036
r94 61 62 18.6552 $w=1.3e-08 $l=8e-08 $layer=M1 $thickness=3.6e-08 $X=0.262
+ $Y=0.036 $X2=0.342 $Y2=0.036
r95 60 61 22.6194 $w=1.3e-08 $l=9.7e-08 $layer=M1 $thickness=3.6e-08 $X=0.165
+ $Y=0.036 $X2=0.262 $Y2=0.036
r96 59 60 10.7267 $w=1.3e-08 $l=4.6e-08 $layer=M1 $thickness=3.6e-08 $X=0.119
+ $Y=0.036 $X2=0.165 $Y2=0.036
r97 26 59 8.86121 $w=1.3e-08 $l=3.8e-08 $layer=M1 $thickness=3.6e-08 $X=0.081
+ $Y=0.036 $X2=0.119 $Y2=0.036
r98 17 56 1.79044 $w=1.89797e-08 $l=1.47e-08 $layer=M1 $thickness=3.6e-08
+ $X=0.059 $Y=0.036 $X2=0.059 $Y2=0.0507
r99 17 26 3.48106 $w=1.50455e-08 $l=2.2e-08 $layer=M1 $thickness=3.6e-08
+ $X=0.059 $Y=0.036 $X2=0.081 $Y2=0.036
r100 57 58 0.757867 $w=1.3e-08 $l=3.2e-09 $layer=M1 $thickness=3.6e-08 $X=0.06
+ $Y=0.057 $X2=0.059 $Y2=0.0602
r101 57 56 1.45744 $w=1.3e-08 $l=6.3e-09 $layer=M1 $thickness=3.6e-08 $X=0.06
+ $Y=0.057 $X2=0.059 $Y2=0.0507
r102 55 58 2.73998 $w=1.3e-08 $l=1.18e-08 $layer=M1 $thickness=3.6e-08 $X=0.059
+ $Y=0.072 $X2=0.059 $Y2=0.0602
r103 25 47 6.16517 $w=1.44286e-08 $l=3.15e-08 $layer=M1 $thickness=3.6e-08
+ $X=0.059 $Y=0.1035 $X2=0.059 $Y2=0.135
r104 25 55 7.34548 $w=1.3e-08 $l=3.15e-08 $layer=M1 $thickness=3.6e-08 $X=0.059
+ $Y=0.1035 $X2=0.059 $Y2=0.072
r105 53 52 16.6668 $w=2.1e-08 $l=4.9e-08 $layer=Gate_1 $thickness=5.6e-08
+ $X=0.135 $Y=0.216 $X2=0.135 $Y2=0.167
r106 50 51 16.6668 $w=2.1e-08 $l=4.9e-08 $layer=Gate_1 $thickness=5.6e-08
+ $X=0.135 $Y=0.054 $X2=0.135 $Y2=0.103
r107 10 44 6.74717 $w=2e-08 $layer=Gate_1 $thickness=5.2e-08 $X=0.135 $Y=0.135
+ $X2=0.135 $Y2=0.135
r108 10 51 11.0545 $w=2.06875e-08 $l=3.2e-08 $layer=Gate_1 $thickness=5.6e-08
+ $X=0.135 $Y=0.135 $X2=0.135 $Y2=0.103
r109 10 52 11.0545 $w=2.06875e-08 $l=3.2e-08 $layer=Gate_1 $thickness=5.6e-08
+ $X=0.135 $Y=0.135 $X2=0.135 $Y2=0.167
r110 18 46 3.03147 $w=1.3e-08 $l=1.3e-08 $layer=M1 $thickness=3.6e-08 $X=0.075
+ $Y=0.135 $X2=0.088 $Y2=0.135
r111 18 47 2.55073 $w=1.58125e-08 $l=1.6e-08 $layer=M1 $thickness=3.6e-08
+ $X=0.075 $Y=0.135 $X2=0.059 $Y2=0.135
r112 43 44 15.6303 $w=1.62778e-08 $l=2.25e-08 $layer=LIG $thickness=4.8e-08
+ $X=0.1125 $Y=0.135 $X2=0.135 $Y2=0.135
r113 42 43 16.9382 $w=1.33e-08 $l=1.7e-08 $layer=LIG $thickness=4.8e-08
+ $X=0.0955 $Y=0.135 $X2=0.1125 $Y2=0.135
r114 40 42 5.91273 $w=1.665e-08 $l=9e-09 $layer=LIG $thickness=4.8e-08
+ $X=0.0865 $Y=0.135 $X2=0.0955 $Y2=0.135
r115 40 46 19.3796 $a=3.24e-16 $layer=V0LIG $X=0.0865 $Y=0.135 $X2=0.088
+ $Y2=0.135
r116 1 40 3.17572 $w=2e-08 $l=1e-08 $layer=LIG $thickness=4.8e-08 $X=0.0765
+ $Y=0.135 $X2=0.0865 $Y2=0.135
r117 1 35 5.3181 $w=2e-08 $l=4.5e-09 $layer=Gate_1 $thickness=5.31613e-08
+ $X=0.0765 $Y=0.135 $X2=0.081 $Y2=0.135
r118 38 37 14.6259 $w=2.1e-08 $l=4.3e-08 $layer=Gate_1 $thickness=5.6e-08
+ $X=0.081 $Y=0.216 $X2=0.081 $Y2=0.173
r119 36 37 7.48304 $w=2.1e-08 $l=2.2e-08 $layer=Gate_1 $thickness=5.6e-08
+ $X=0.081 $Y=0.151 $X2=0.081 $Y2=0.173
r120 35 36 5.61228 $w=2.0375e-08 $l=1.6e-08 $layer=Gate_1 $thickness=5.6e-08
+ $X=0.081 $Y=0.135 $X2=0.081 $Y2=0.151
r121 35 40 5.00052 $w=2e-08 $l=5.5e-09 $layer=Gate_1 $thickness=5.35172e-08
+ $X=0.081 $Y=0.135 $X2=0.0865 $Y2=0.135
r122 34 35 5.61228 $w=2.0375e-08 $l=1.6e-08 $layer=Gate_1 $thickness=5.6e-08
+ $X=0.081 $Y=0.119 $X2=0.081 $Y2=0.135
r123 33 34 7.48304 $w=2.1e-08 $l=2.2e-08 $layer=Gate_1 $thickness=5.6e-08
+ $X=0.081 $Y=0.097 $X2=0.081 $Y2=0.119
r124 32 33 14.6259 $w=2.1e-08 $l=4.3e-08 $layer=Gate_1 $thickness=5.6e-08
+ $X=0.081 $Y=0.054 $X2=0.081 $Y2=0.097
r125 32 9 10.0341 $w=2.1e-08 $l=2.95e-08 $layer=Gate_1 $thickness=5.6e-08
+ $X=0.081 $Y=0.054 $X2=0.081 $Y2=0.0245
.ends

.subckt PM_CKINVDCx5p33_ASAP7_75t_R%5 vss 19 23 33 36 46 47 50 51 9 15 1 16 12
+ 18 4 10 13 14 3
c1 1 vss 0.00632745f $X=0.837 $Y=0.135
c2 3 vss 0.0073317f $X=0.864 $Y=0.2025
c3 4 vss 0.00728482f $X=0.972 $Y=0.2025
c4 9 vss 0.104124f $X=0.837 $Y=0.0245
c5 10 vss 0.082261f $X=0.891 $Y=0.135
c6 11 vss 0.00655922f $X=0.8495 $Y=0.2025
c7 12 vss 0.00703604f $X=0.9575 $Y=0.2025
c8 13 vss 0.00022099f $X=0.891 $Y=0.135
c9 14 vss 0.000378959f $X=0.891 $Y=0.171
c10 15 vss 0.00133595f $X=0.8485 $Y=0.171
c11 16 vss 0.00041728f $X=0.846 $Y=0.135
c12 17 vss 0.000156069f $X=0.891 $Y=0.153
c13 18 vss 0.00260456f $X=0.918 $Y=0.171
r1 51 49 0.0308642 $w=8.1e-08 $l=2.5e-09 $layer=P_src_drn $thickness=1e-09
+ $X=0.9893 $Y=0.2025 $X2=0.9865 $Y2=0.2025
r2 4 49 0.179012 $w=8.1e-08 $l=1.45e-08 $layer=P_src_drn $thickness=1e-09
+ $X=0.972 $Y=0.2025 $X2=0.9865 $Y2=0.2025
r3 12 4 0.179012 $w=8.1e-08 $l=1.45e-08 $layer=P_src_drn $thickness=1e-09
+ $X=0.9575 $Y=0.2025 $X2=0.972 $Y2=0.2025
r4 50 12 0.0308642 $w=8.1e-08 $l=2.5e-09 $layer=P_src_drn $thickness=1e-09
+ $X=0.9546 $Y=0.2025 $X2=0.9575 $Y2=0.2025
r5 47 45 0.0308642 $w=8.1e-08 $l=2.5e-09 $layer=P_src_drn $thickness=1e-09
+ $X=0.8813 $Y=0.2025 $X2=0.8785 $Y2=0.2025
r6 3 45 0.179012 $w=8.1e-08 $l=1.45e-08 $layer=P_src_drn $thickness=1e-09
+ $X=0.864 $Y=0.2025 $X2=0.8785 $Y2=0.2025
r7 11 3 0.179012 $w=8.1e-08 $l=1.45e-08 $layer=P_src_drn $thickness=1e-09
+ $X=0.8495 $Y=0.2025 $X2=0.864 $Y2=0.2025
r8 46 11 0.0308642 $w=8.1e-08 $l=2.5e-09 $layer=P_src_drn $thickness=1e-09
+ $X=0.8466 $Y=0.2025 $X2=0.8495 $Y2=0.2025
r9 4 42 19.3796 $a=3.24e-16 $layer=V0LISD $X=0.972 $Y=0.2025 $X2=0.972 $Y2=0.171
r10 3 38 19.3796 $a=3.24e-16 $layer=V0LISD $X=0.864 $Y=0.2025 $X2=0.864
+ $Y2=0.171
r11 41 42 5.24677 $w=1.3e-08 $l=2.25e-08 $layer=M1 $thickness=3.6e-08 $X=0.9495
+ $Y=0.171 $X2=0.972 $Y2=0.171
r12 18 41 7.34548 $w=1.3e-08 $l=3.15e-08 $layer=M1 $thickness=3.6e-08 $X=0.918
+ $Y=0.171 $X2=0.9495 $Y2=0.171
r13 38 39 3.14806 $w=1.3e-08 $l=1.35e-08 $layer=M1 $thickness=3.6e-08 $X=0.864
+ $Y=0.171 $X2=0.8775 $Y2=0.171
r14 15 38 3.61444 $w=1.3e-08 $l=1.55e-08 $layer=M1 $thickness=3.6e-08 $X=0.8485
+ $Y=0.171 $X2=0.864 $Y2=0.171
r15 14 17 3.01711 $w=1.55e-08 $l=1.8e-08 $layer=M1 $thickness=3.6e-08 $X=0.891
+ $Y=0.171 $X2=0.891 $Y2=0.153
r16 14 39 1.96775 $w=1.63333e-08 $l=1.35e-08 $layer=M1 $thickness=3.6e-08
+ $X=0.891 $Y=0.171 $X2=0.8775 $Y2=0.171
r17 14 18 5.11582 $w=1.46667e-08 $l=2.7e-08 $layer=M1 $thickness=3.6e-08
+ $X=0.891 $Y=0.171 $X2=0.918 $Y2=0.171
r18 13 31 1.49895 $w=1.63333e-08 $l=1.35e-08 $layer=M1 $thickness=3.6e-08
+ $X=0.891 $Y=0.135 $X2=0.8775 $Y2=0.135
r19 13 17 2.5483 $w=1.79e-08 $l=1.8e-08 $layer=M1 $thickness=3.6e-08 $X=0.891
+ $Y=0.135 $X2=0.891 $Y2=0.153
r20 36 35 16.4967 $w=2.1e-08 $l=4.85e-08 $layer=Gate_1 $thickness=5.6e-08
+ $X=0.891 $Y=0.2025 $X2=0.891 $Y2=0.154
r21 33 34 16.4967 $w=2.1e-08 $l=4.85e-08 $layer=Gate_1 $thickness=5.6e-08
+ $X=0.891 $Y=0.0675 $X2=0.891 $Y2=0.116
r22 10 27 6.54019 $w=2.09524e-08 $layer=Gate_1 $thickness=5.21905e-08 $X=0.891
+ $Y=0.135 $X2=0.891 $Y2=0.135
r23 10 34 6.6497 $w=2.04211e-08 $l=1.9e-08 $layer=Gate_1 $thickness=5.6e-08
+ $X=0.891 $Y=0.135 $X2=0.891 $Y2=0.116
r24 10 35 6.6497 $w=2.04211e-08 $l=1.9e-08 $layer=Gate_1 $thickness=5.6e-08
+ $X=0.891 $Y=0.135 $X2=0.891 $Y2=0.154
r25 30 31 3.14806 $w=1.3e-08 $l=1.35e-08 $layer=M1 $thickness=3.6e-08 $X=0.864
+ $Y=0.135 $X2=0.8775 $Y2=0.135
r26 29 30 2.68168 $w=1.3e-08 $l=1.15e-08 $layer=M1 $thickness=3.6e-08 $X=0.8525
+ $Y=0.135 $X2=0.864 $Y2=0.135
r27 16 29 1.51573 $w=1.3e-08 $l=6.5e-09 $layer=M1 $thickness=3.6e-08 $X=0.846
+ $Y=0.135 $X2=0.8525 $Y2=0.135
r28 26 27 12.6539 $w=1.77815e-08 $l=2.7e-08 $layer=LIG $thickness=4.8e-08
+ $X=0.864 $Y=0.135 $X2=0.891 $Y2=0.135
r29 26 30 19.3796 $a=3.24e-16 $layer=V0LIG $X=0.864 $Y=0.135 $X2=0.864 $Y2=0.135
r30 1 21 6.54019 $w=2.09524e-08 $layer=Gate_1 $thickness=5.21905e-08 $X=0.837
+ $Y=0.135 $X2=0.837 $Y2=0.135
r31 1 26 12.6539 $w=1.77815e-08 $l=2.7e-08 $layer=LIG $thickness=4.8e-08
+ $X=0.837 $Y=0.135 $X2=0.864 $Y2=0.135
r32 23 22 16.4967 $w=2.1e-08 $l=4.85e-08 $layer=Gate_1 $thickness=5.6e-08
+ $X=0.837 $Y=0.2025 $X2=0.837 $Y2=0.154
r33 21 22 6.6497 $w=2.04211e-08 $l=1.9e-08 $layer=Gate_1 $thickness=5.6e-08
+ $X=0.837 $Y=0.135 $X2=0.837 $Y2=0.154
r34 20 21 6.6497 $w=2.04211e-08 $l=1.9e-08 $layer=Gate_1 $thickness=5.6e-08
+ $X=0.837 $Y=0.116 $X2=0.837 $Y2=0.135
r35 19 20 16.4967 $w=2.1e-08 $l=4.85e-08 $layer=Gate_1 $thickness=5.6e-08
+ $X=0.837 $Y=0.0675 $X2=0.837 $Y2=0.116
r36 19 9 14.6259 $w=2.1e-08 $l=4.3e-08 $layer=Gate_1 $thickness=5.6e-08
+ $X=0.837 $Y=0.0675 $X2=0.837 $Y2=0.0245
.ends

.subckt PM_CKINVDCx5p33_ASAP7_75t_R%Y vss 63 50 51 81 82 95 96 118 119 132 133
+ 143 144 151 152 156 157 27 33 2 4 6 8 34 40 39 37 35 29 32 25 28 30 31 26 46
+ 42 1 3 7 5 43 41 47 45 44
c1 1 vss 0.00739265f $X=0.108 $Y=0.054
c2 2 vss 0.00921458f $X=0.108 $Y=0.1755
c3 3 vss 0.00734132f $X=0.432 $Y=0.054
c4 4 vss 0.00898665f $X=0.432 $Y=0.1755
c5 5 vss 0.00730072f $X=0.756 $Y=0.054
c6 6 vss 0.00898665f $X=0.756 $Y=0.1755
c7 7 vss 0.00739265f $X=1.08 $Y=0.054
c8 8 vss 0.00921458f $X=1.08 $Y=0.1755
c9 25 vss 0.00353384f $X=0.0935 $Y=0.054
c10 26 vss 0.00356033f $X=0.4175 $Y=0.054
c11 27 vss 0.00356033f $X=0.7415 $Y=0.054
c12 28 vss 0.00353022f $X=1.0655 $Y=0.054
c13 29 vss 0.00355252f $X=0.0935 $Y=0.216
c14 30 vss 0.00352057f $X=0.4175 $Y=0.216
c15 31 vss 0.00352057f $X=0.7415 $Y=0.216
c16 32 vss 0.00355252f $X=1.0655 $Y=0.216
c17 33 vss 0.00106281f $X=0.0965 $Y=0.072
c18 34 vss 0.00547131f $X=0.135 $Y=0.234
c19 35 vss 0.00106281f $X=0.459 $Y=0.072
c20 36 vss 0.00214929f $X=0.459 $Y=0.234
c21 37 vss 0.00102798f $X=0.729 $Y=0.072
c22 38 vss 0.00203895f $X=0.729 $Y=0.234
c23 39 vss 0.00106281f $X=1.053 $Y=0.072
c24 40 vss 0.00547131f $X=1.053 $Y=0.234
c25 41 vss 0.00341437f $X=0.135 $Y=0.0855
c26 42 vss 0.026928f $X=0.165 $Y=0.234
c27 43 vss 0.00307011f $X=0.459 $Y=0.2025
c28 44 vss 0.022801f $X=0.489 $Y=0.234
c29 45 vss 0.00309042f $X=0.729 $Y=0.2025
c30 46 vss 0.0269218f $X=0.7425 $Y=0.234
c31 47 vss 0.00341437f $X=1.053 $Y=0.2025
r1 157 155 0.0462963 $w=5.4e-08 $l=2.5e-09 $layer=N_src_drn $thickness=1e-09
+ $X=1.0973 $Y=0.054 $X2=1.0945 $Y2=0.054
r2 7 155 0.268519 $w=5.4e-08 $l=1.45e-08 $layer=N_src_drn $thickness=1e-09
+ $X=1.08 $Y=0.054 $X2=1.0945 $Y2=0.054
r3 28 7 0.268519 $w=5.4e-08 $l=1.45e-08 $layer=N_src_drn $thickness=1e-09
+ $X=1.0655 $Y=0.054 $X2=1.08 $Y2=0.054
r4 156 28 0.0462963 $w=5.4e-08 $l=2.5e-09 $layer=N_src_drn $thickness=1e-09
+ $X=1.0626 $Y=0.054 $X2=1.0655 $Y2=0.054
r5 7 146 19.3796 $a=3.24e-16 $layer=V0LISD $X=1.08 $Y=0.054 $X2=1.0795 $Y2=0.072
r6 152 150 0.0462963 $w=5.4e-08 $l=2.5e-09 $layer=P_src_drn $thickness=1e-09
+ $X=1.0973 $Y=0.216 $X2=1.0945 $Y2=0.216
r7 140 150 0.268519 $w=5.4e-08 $l=1.45e-08 $layer=P_src_drn $thickness=1e-09
+ $X=1.08 $Y=0.216 $X2=1.0945 $Y2=0.216
r8 32 140 0.268519 $w=5.4e-08 $l=1.45e-08 $layer=P_src_drn $thickness=1e-09
+ $X=1.0655 $Y=0.216 $X2=1.08 $Y2=0.216
r9 151 32 0.0462963 $w=5.4e-08 $l=2.5e-09 $layer=P_src_drn $thickness=1e-09
+ $X=1.0626 $Y=0.216 $X2=1.0655 $Y2=0.216
r10 145 146 3.03147 $w=1.3e-08 $l=1.3e-08 $layer=M1 $thickness=3.6e-08
+ $X=1.0665 $Y=0.072 $X2=1.0795 $Y2=0.072
r11 39 139 1.96775 $w=1.63333e-08 $l=1.35e-08 $layer=M1 $thickness=3.6e-08
+ $X=1.053 $Y=0.072 $X2=1.053 $Y2=0.0855
r12 39 145 1.96775 $w=1.63333e-08 $l=1.35e-08 $layer=M1 $thickness=3.6e-08
+ $X=1.053 $Y=0.072 $X2=1.0665 $Y2=0.072
r13 144 142 0.0462963 $w=5.4e-08 $l=2.5e-09 $layer=N_src_drn $thickness=1e-09
+ $X=0.7733 $Y=0.054 $X2=0.7705 $Y2=0.054
r14 5 142 0.268519 $w=5.4e-08 $l=1.45e-08 $layer=N_src_drn $thickness=1e-09
+ $X=0.756 $Y=0.054 $X2=0.7705 $Y2=0.054
r15 27 5 0.268519 $w=5.4e-08 $l=1.45e-08 $layer=N_src_drn $thickness=1e-09
+ $X=0.7415 $Y=0.054 $X2=0.756 $Y2=0.054
r16 143 27 0.0462963 $w=5.4e-08 $l=2.5e-09 $layer=N_src_drn $thickness=1e-09
+ $X=0.7386 $Y=0.054 $X2=0.7415 $Y2=0.054
r17 8 140 23.8708 $w=2.02e-08 $l=4.05e-08 $layer=LISD $thickness=2.7e-08
+ $X=1.08 $Y=0.1755 $X2=1.08 $Y2=0.216
r18 138 139 3.14806 $w=1.3e-08 $l=1.35e-08 $layer=M1 $thickness=3.6e-08
+ $X=1.053 $Y=0.099 $X2=1.053 $Y2=0.0855
r19 137 138 4.19742 $w=1.3e-08 $l=1.8e-08 $layer=M1 $thickness=3.6e-08 $X=1.053
+ $Y=0.117 $X2=1.053 $Y2=0.099
r20 136 137 4.19742 $w=1.3e-08 $l=1.8e-08 $layer=M1 $thickness=3.6e-08 $X=1.053
+ $Y=0.135 $X2=1.053 $Y2=0.117
r21 135 136 4.19742 $w=1.3e-08 $l=1.8e-08 $layer=M1 $thickness=3.6e-08 $X=1.053
+ $Y=0.153 $X2=1.053 $Y2=0.135
r22 134 135 4.19742 $w=1.3e-08 $l=1.8e-08 $layer=M1 $thickness=3.6e-08 $X=1.053
+ $Y=0.171 $X2=1.053 $Y2=0.153
r23 47 134 7.34548 $w=1.3e-08 $l=3.15e-08 $layer=M1 $thickness=3.6e-08 $X=1.053
+ $Y=0.2025 $X2=1.053 $Y2=0.171
r24 133 131 0.0462963 $w=5.4e-08 $l=2.5e-09 $layer=P_src_drn $thickness=1e-09
+ $X=0.7733 $Y=0.216 $X2=0.7705 $Y2=0.216
r25 124 131 0.268519 $w=5.4e-08 $l=1.45e-08 $layer=P_src_drn $thickness=1e-09
+ $X=0.756 $Y=0.216 $X2=0.7705 $Y2=0.216
r26 31 124 0.268519 $w=5.4e-08 $l=1.45e-08 $layer=P_src_drn $thickness=1e-09
+ $X=0.7415 $Y=0.216 $X2=0.756 $Y2=0.216
r27 132 31 0.0462963 $w=5.4e-08 $l=2.5e-09 $layer=P_src_drn $thickness=1e-09
+ $X=0.7386 $Y=0.216 $X2=0.7415 $Y2=0.216
r28 5 121 19.3796 $a=3.24e-16 $layer=V0LISD $X=0.756 $Y=0.054 $X2=0.7555
+ $Y2=0.072
r29 126 140 19.3796 $a=3.24e-16 $layer=V0LISD $X=1.0795 $Y=0.234 $X2=1.08
+ $Y2=0.216
r30 125 126 3.03147 $w=1.3e-08 $l=1.3e-08 $layer=M1 $thickness=3.6e-08
+ $X=1.0665 $Y=0.234 $X2=1.0795 $Y2=0.234
r31 40 115 5.81538 $w=1.45e-08 $l=3e-08 $layer=M1 $thickness=3.6e-08 $X=1.053
+ $Y=0.234 $X2=1.023 $Y2=0.234
r32 40 125 1.96775 $w=1.63333e-08 $l=1.35e-08 $layer=M1 $thickness=3.6e-08
+ $X=1.053 $Y=0.234 $X2=1.0665 $Y2=0.234
r33 40 47 6.16517 $w=1.44286e-08 $l=3.15e-08 $layer=M1 $thickness=3.6e-08
+ $X=1.053 $Y=0.234 $X2=1.053 $Y2=0.2025
r34 6 124 23.8708 $w=2.02e-08 $l=4.05e-08 $layer=LISD $thickness=2.7e-08
+ $X=0.756 $Y=0.1755 $X2=0.756 $Y2=0.216
r35 120 121 3.03147 $w=1.3e-08 $l=1.3e-08 $layer=M1 $thickness=3.6e-08
+ $X=0.7425 $Y=0.072 $X2=0.7555 $Y2=0.072
r36 37 107 1.96775 $w=1.63333e-08 $l=1.35e-08 $layer=M1 $thickness=3.6e-08
+ $X=0.729 $Y=0.072 $X2=0.729 $Y2=0.0855
r37 37 120 1.96775 $w=1.63333e-08 $l=1.35e-08 $layer=M1 $thickness=3.6e-08
+ $X=0.729 $Y=0.072 $X2=0.7425 $Y2=0.072
r38 119 117 0.0462963 $w=5.4e-08 $l=2.5e-09 $layer=N_src_drn $thickness=1e-09
+ $X=0.4493 $Y=0.054 $X2=0.4465 $Y2=0.054
r39 3 117 0.268519 $w=5.4e-08 $l=1.45e-08 $layer=N_src_drn $thickness=1e-09
+ $X=0.432 $Y=0.054 $X2=0.4465 $Y2=0.054
r40 26 3 0.268519 $w=5.4e-08 $l=1.45e-08 $layer=N_src_drn $thickness=1e-09
+ $X=0.4175 $Y=0.054 $X2=0.432 $Y2=0.054
r41 118 26 0.0462963 $w=5.4e-08 $l=2.5e-09 $layer=N_src_drn $thickness=1e-09
+ $X=0.4146 $Y=0.054 $X2=0.4175 $Y2=0.054
r42 114 115 6.06293 $w=1.3e-08 $l=2.6e-08 $layer=M1 $thickness=3.6e-08 $X=0.997
+ $Y=0.234 $X2=1.023 $Y2=0.234
r43 113 114 1.86552 $w=1.3e-08 $l=8e-09 $layer=M1 $thickness=3.6e-08 $X=0.989
+ $Y=0.234 $X2=0.997 $Y2=0.234
r44 112 113 18.7718 $w=1.3e-08 $l=8.05e-08 $layer=M1 $thickness=3.6e-08
+ $X=0.9085 $Y=0.234 $X2=0.989 $Y2=0.234
r45 111 112 20.0543 $w=1.3e-08 $l=8.6e-08 $layer=M1 $thickness=3.6e-08
+ $X=0.8225 $Y=0.234 $X2=0.9085 $Y2=0.234
r46 110 111 7.69526 $w=1.3e-08 $l=3.3e-08 $layer=M1 $thickness=3.6e-08
+ $X=0.7895 $Y=0.234 $X2=0.8225 $Y2=0.234
r47 109 110 5.82974 $w=1.3e-08 $l=2.5e-08 $layer=M1 $thickness=3.6e-08
+ $X=0.7645 $Y=0.234 $X2=0.7895 $Y2=0.234
r48 108 109 2.09871 $w=1.3e-08 $l=9e-09 $layer=M1 $thickness=3.6e-08 $X=0.7555
+ $Y=0.234 $X2=0.7645 $Y2=0.234
r49 108 124 19.3796 $a=3.24e-16 $layer=V0LISD $X=0.7555 $Y=0.234 $X2=0.756
+ $Y2=0.216
r50 46 108 3.03147 $w=1.3e-08 $l=1.3e-08 $layer=M1 $thickness=3.6e-08 $X=0.7425
+ $Y=0.234 $X2=0.7555 $Y2=0.234
r51 106 107 3.14806 $w=1.3e-08 $l=1.35e-08 $layer=M1 $thickness=3.6e-08
+ $X=0.729 $Y=0.099 $X2=0.729 $Y2=0.0855
r52 105 106 4.19742 $w=1.3e-08 $l=1.8e-08 $layer=M1 $thickness=3.6e-08 $X=0.729
+ $Y=0.117 $X2=0.729 $Y2=0.099
r53 104 105 4.19742 $w=1.3e-08 $l=1.8e-08 $layer=M1 $thickness=3.6e-08 $X=0.729
+ $Y=0.135 $X2=0.729 $Y2=0.117
r54 103 104 4.19742 $w=1.3e-08 $l=1.8e-08 $layer=M1 $thickness=3.6e-08 $X=0.729
+ $Y=0.153 $X2=0.729 $Y2=0.135
r55 102 103 4.19742 $w=1.3e-08 $l=1.8e-08 $layer=M1 $thickness=3.6e-08 $X=0.729
+ $Y=0.171 $X2=0.729 $Y2=0.153
r56 45 102 7.34548 $w=1.3e-08 $l=3.15e-08 $layer=M1 $thickness=3.6e-08 $X=0.729
+ $Y=0.2025 $X2=0.729 $Y2=0.171
r57 3 97 19.3796 $a=3.24e-16 $layer=V0LISD $X=0.432 $Y=0.054 $X2=0.4325
+ $Y2=0.072
r58 38 92 5.4656 $w=1.45789e-08 $l=2.85e-08 $layer=M1 $thickness=3.6e-08
+ $X=0.729 $Y=0.234 $X2=0.7005 $Y2=0.234
r59 38 45 6.16517 $w=1.44286e-08 $l=3.15e-08 $layer=M1 $thickness=3.6e-08
+ $X=0.729 $Y=0.234 $X2=0.729 $Y2=0.2025
r60 38 46 1.96775 $w=1.63333e-08 $l=1.35e-08 $layer=M1 $thickness=3.6e-08
+ $X=0.729 $Y=0.234 $X2=0.7425 $Y2=0.234
r61 97 98 3.03147 $w=1.3e-08 $l=1.3e-08 $layer=M1 $thickness=3.6e-08 $X=0.4325
+ $Y=0.072 $X2=0.4455 $Y2=0.072
r62 35 88 1.96775 $w=1.63333e-08 $l=1.35e-08 $layer=M1 $thickness=3.6e-08
+ $X=0.459 $Y=0.072 $X2=0.459 $Y2=0.0855
r63 35 98 1.96775 $w=1.63333e-08 $l=1.35e-08 $layer=M1 $thickness=3.6e-08
+ $X=0.459 $Y=0.072 $X2=0.4455 $Y2=0.072
r64 96 94 0.0462963 $w=5.4e-08 $l=2.5e-09 $layer=P_src_drn $thickness=1e-09
+ $X=0.4493 $Y=0.216 $X2=0.4465 $Y2=0.216
r65 78 94 0.268519 $w=5.4e-08 $l=1.45e-08 $layer=P_src_drn $thickness=1e-09
+ $X=0.432 $Y=0.216 $X2=0.4465 $Y2=0.216
r66 30 78 0.268519 $w=5.4e-08 $l=1.45e-08 $layer=P_src_drn $thickness=1e-09
+ $X=0.4175 $Y=0.216 $X2=0.432 $Y2=0.216
r67 95 30 0.0462963 $w=5.4e-08 $l=2.5e-09 $layer=P_src_drn $thickness=1e-09
+ $X=0.4146 $Y=0.216 $X2=0.4175 $Y2=0.216
r68 91 92 22.6194 $w=1.3e-08 $l=9.7e-08 $layer=M1 $thickness=3.6e-08 $X=0.6035
+ $Y=0.234 $X2=0.7005 $Y2=0.234
r69 90 91 18.7718 $w=1.3e-08 $l=8.05e-08 $layer=M1 $thickness=3.6e-08 $X=0.523
+ $Y=0.234 $X2=0.6035 $Y2=0.234
r70 89 90 1.86552 $w=1.3e-08 $l=8e-09 $layer=M1 $thickness=3.6e-08 $X=0.515
+ $Y=0.234 $X2=0.523 $Y2=0.234
r71 44 89 6.06293 $w=1.3e-08 $l=2.6e-08 $layer=M1 $thickness=3.6e-08 $X=0.489
+ $Y=0.234 $X2=0.515 $Y2=0.234
r72 87 88 3.14806 $w=1.3e-08 $l=1.35e-08 $layer=M1 $thickness=3.6e-08 $X=0.459
+ $Y=0.099 $X2=0.459 $Y2=0.0855
r73 86 87 4.19742 $w=1.3e-08 $l=1.8e-08 $layer=M1 $thickness=3.6e-08 $X=0.459
+ $Y=0.117 $X2=0.459 $Y2=0.099
r74 85 86 4.19742 $w=1.3e-08 $l=1.8e-08 $layer=M1 $thickness=3.6e-08 $X=0.459
+ $Y=0.135 $X2=0.459 $Y2=0.117
r75 84 85 4.19742 $w=1.3e-08 $l=1.8e-08 $layer=M1 $thickness=3.6e-08 $X=0.459
+ $Y=0.153 $X2=0.459 $Y2=0.135
r76 83 84 4.19742 $w=1.3e-08 $l=1.8e-08 $layer=M1 $thickness=3.6e-08 $X=0.459
+ $Y=0.171 $X2=0.459 $Y2=0.153
r77 43 83 7.34548 $w=1.3e-08 $l=3.15e-08 $layer=M1 $thickness=3.6e-08 $X=0.459
+ $Y=0.2025 $X2=0.459 $Y2=0.171
r78 82 80 0.0462963 $w=5.4e-08 $l=2.5e-09 $layer=P_src_drn $thickness=1e-09
+ $X=0.1253 $Y=0.216 $X2=0.1225 $Y2=0.216
r79 77 80 0.268519 $w=5.4e-08 $l=1.45e-08 $layer=P_src_drn $thickness=1e-09
+ $X=0.108 $Y=0.216 $X2=0.1225 $Y2=0.216
r80 29 77 0.268519 $w=5.4e-08 $l=1.45e-08 $layer=P_src_drn $thickness=1e-09
+ $X=0.0935 $Y=0.216 $X2=0.108 $Y2=0.216
r81 81 29 0.0462963 $w=5.4e-08 $l=2.5e-09 $layer=P_src_drn $thickness=1e-09
+ $X=0.0906 $Y=0.216 $X2=0.0935 $Y2=0.216
r82 4 78 23.8708 $w=2.02e-08 $l=4.05e-08 $layer=LISD $thickness=2.7e-08
+ $X=0.432 $Y=0.1755 $X2=0.432 $Y2=0.216
r83 36 76 1.96775 $w=1.63333e-08 $l=1.35e-08 $layer=M1 $thickness=3.6e-08
+ $X=0.459 $Y=0.234 $X2=0.4455 $Y2=0.234
r84 36 43 6.16517 $w=1.44286e-08 $l=3.15e-08 $layer=M1 $thickness=3.6e-08
+ $X=0.459 $Y=0.234 $X2=0.459 $Y2=0.2025
r85 36 44 5.81538 $w=1.45e-08 $l=3e-08 $layer=M1 $thickness=3.6e-08 $X=0.459
+ $Y=0.234 $X2=0.489 $Y2=0.234
r86 2 77 23.8708 $w=2.02e-08 $l=4.05e-08 $layer=LISD $thickness=2.7e-08
+ $X=0.108 $Y=0.1755 $X2=0.108 $Y2=0.216
r87 75 76 3.03147 $w=1.3e-08 $l=1.3e-08 $layer=M1 $thickness=3.6e-08 $X=0.4325
+ $Y=0.234 $X2=0.4455 $Y2=0.234
r88 75 78 19.3796 $a=3.24e-16 $layer=V0LISD $X=0.4325 $Y=0.234 $X2=0.432
+ $Y2=0.216
r89 74 75 2.09871 $w=1.3e-08 $l=9e-09 $layer=M1 $thickness=3.6e-08 $X=0.4235
+ $Y=0.234 $X2=0.4325 $Y2=0.234
r90 73 74 5.82974 $w=1.3e-08 $l=2.5e-08 $layer=M1 $thickness=3.6e-08 $X=0.3985
+ $Y=0.234 $X2=0.4235 $Y2=0.234
r91 72 73 7.69526 $w=1.3e-08 $l=3.3e-08 $layer=M1 $thickness=3.6e-08 $X=0.3655
+ $Y=0.234 $X2=0.3985 $Y2=0.234
r92 71 72 20.0543 $w=1.3e-08 $l=8.6e-08 $layer=M1 $thickness=3.6e-08 $X=0.2795
+ $Y=0.234 $X2=0.3655 $Y2=0.234
r93 70 71 18.7718 $w=1.3e-08 $l=8.05e-08 $layer=M1 $thickness=3.6e-08 $X=0.199
+ $Y=0.234 $X2=0.2795 $Y2=0.234
r94 69 70 1.86552 $w=1.3e-08 $l=8e-09 $layer=M1 $thickness=3.6e-08 $X=0.191
+ $Y=0.234 $X2=0.199 $Y2=0.234
r95 42 69 6.06293 $w=1.3e-08 $l=2.6e-08 $layer=M1 $thickness=3.6e-08 $X=0.165
+ $Y=0.234 $X2=0.191 $Y2=0.234
r96 65 66 3.03147 $w=1.3e-08 $l=1.3e-08 $layer=M1 $thickness=3.6e-08 $X=0.1085
+ $Y=0.234 $X2=0.1215 $Y2=0.234
r97 65 77 19.3796 $a=3.24e-16 $layer=V0LISD $X=0.1085 $Y=0.234 $X2=0.108
+ $Y2=0.216
r98 34 64 2.60903 $w=1.57692e-08 $l=1.63e-08 $layer=M1 $thickness=3.6e-08
+ $X=0.135 $Y=0.234 $X2=0.135 $Y2=0.2177
r99 34 66 1.96775 $w=1.63333e-08 $l=1.35e-08 $layer=M1 $thickness=3.6e-08
+ $X=0.135 $Y=0.234 $X2=0.1215 $Y2=0.234
r100 34 42 5.81538 $w=1.45e-08 $l=3e-08 $layer=M1 $thickness=3.6e-08 $X=0.135
+ $Y=0.234 $X2=0.165 $Y2=0.234
r101 63 64 1.80722 $w=1.3e-08 $l=7.7e-09 $layer=M1 $thickness=3.6e-08 $X=0.135
+ $Y=0.21 $X2=0.135 $Y2=0.2177
r102 63 62 3.55614 $w=1.3e-08 $l=1.53e-08 $layer=M1 $thickness=3.6e-08 $X=0.135
+ $Y=0.21 $X2=0.135 $Y2=0.1947
r103 61 62 5.53826 $w=1.3e-08 $l=2.37e-08 $layer=M1 $thickness=3.6e-08 $X=0.135
+ $Y=0.171 $X2=0.135 $Y2=0.1947
r104 60 61 4.19742 $w=1.3e-08 $l=1.8e-08 $layer=M1 $thickness=3.6e-08 $X=0.135
+ $Y=0.153 $X2=0.135 $Y2=0.171
r105 59 60 4.19742 $w=1.3e-08 $l=1.8e-08 $layer=M1 $thickness=3.6e-08 $X=0.135
+ $Y=0.135 $X2=0.135 $Y2=0.153
r106 58 59 4.19742 $w=1.3e-08 $l=1.8e-08 $layer=M1 $thickness=3.6e-08 $X=0.135
+ $Y=0.117 $X2=0.135 $Y2=0.135
r107 57 58 4.19742 $w=1.3e-08 $l=1.8e-08 $layer=M1 $thickness=3.6e-08 $X=0.135
+ $Y=0.099 $X2=0.135 $Y2=0.117
r108 41 56 1.96775 $w=1.63333e-08 $l=1.35e-08 $layer=M1 $thickness=3.6e-08
+ $X=0.135 $Y=0.0855 $X2=0.135 $Y2=0.072
r109 41 57 3.14806 $w=1.3e-08 $l=1.35e-08 $layer=M1 $thickness=3.6e-08 $X=0.135
+ $Y=0.0855 $X2=0.135 $Y2=0.099
r110 55 56 1.96775 $w=1.63333e-08 $l=1.35e-08 $layer=M1 $thickness=3.6e-08
+ $X=0.1215 $Y=0.072 $X2=0.135 $Y2=0.072
r111 54 55 3.03147 $w=1.3e-08 $l=1.3e-08 $layer=M1 $thickness=3.6e-08 $X=0.1085
+ $Y=0.072 $X2=0.1215 $Y2=0.072
r112 53 54 2.09871 $w=1.3e-08 $l=9e-09 $layer=M1 $thickness=3.6e-08 $X=0.0995
+ $Y=0.072 $X2=0.1085 $Y2=0.072
r113 33 53 0.699569 $w=1.3e-08 $l=3e-09 $layer=M1 $thickness=3.6e-08 $X=0.0965
+ $Y=0.072 $X2=0.0995 $Y2=0.072
r114 1 54 19.3796 $a=3.24e-16 $layer=V0LISD $X=0.108 $Y=0.054 $X2=0.1085
+ $Y2=0.072
r115 51 49 0.0462963 $w=5.4e-08 $l=2.5e-09 $layer=N_src_drn $thickness=1e-09
+ $X=0.1253 $Y=0.054 $X2=0.1225 $Y2=0.054
r116 1 49 0.268519 $w=5.4e-08 $l=1.45e-08 $layer=N_src_drn $thickness=1e-09
+ $X=0.108 $Y=0.054 $X2=0.1225 $Y2=0.054
r117 25 1 0.268519 $w=5.4e-08 $l=1.45e-08 $layer=N_src_drn $thickness=1e-09
+ $X=0.0935 $Y=0.054 $X2=0.108 $Y2=0.054
r118 50 25 0.0462963 $w=5.4e-08 $l=2.5e-09 $layer=N_src_drn $thickness=1e-09
+ $X=0.0906 $Y=0.054 $X2=0.0935 $Y2=0.054
.ends

.subckt PM_CKINVDCx5p33_ASAP7_75t_R%6 vss 19 23 33 36 46 47 50 51 18 15 4 1 9
+ 10 16 12 14
c1 1 vss 0.00632088f $X=0.513 $Y=0.135
c2 3 vss 0.00715797f $X=0.54 $Y=0.0675
c3 4 vss 0.00719036f $X=0.648 $Y=0.0675
c4 9 vss 0.11789f $X=0.513 $Y=0.0245
c5 10 vss 0.082247f $X=0.567 $Y=0.135
c6 11 vss 0.00640517f $X=0.5255 $Y=0.0675
c7 12 vss 0.00678536f $X=0.6335 $Y=0.0675
c8 13 vss 0.000306537f $X=0.567 $Y=0.099
c9 14 vss 0.000203783f $X=0.567 $Y=0.135
c10 15 vss 0.00130111f $X=0.5255 $Y=0.099
c11 16 vss 0.00063024f $X=0.523 $Y=0.135
c12 17 vss 0.000149604f $X=0.567 $Y=0.117
c13 18 vss 0.00253925f $X=0.594 $Y=0.099
r1 51 49 0.0308642 $w=8.1e-08 $l=2.5e-09 $layer=N_src_drn $thickness=1e-09
+ $X=0.6653 $Y=0.0675 $X2=0.6625 $Y2=0.0675
r2 4 49 0.179012 $w=8.1e-08 $l=1.45e-08 $layer=N_src_drn $thickness=1e-09
+ $X=0.648 $Y=0.0675 $X2=0.6625 $Y2=0.0675
r3 12 4 0.179012 $w=8.1e-08 $l=1.45e-08 $layer=N_src_drn $thickness=1e-09
+ $X=0.6335 $Y=0.0675 $X2=0.648 $Y2=0.0675
r4 50 12 0.0308642 $w=8.1e-08 $l=2.5e-09 $layer=N_src_drn $thickness=1e-09
+ $X=0.6306 $Y=0.0675 $X2=0.6335 $Y2=0.0675
r5 47 45 0.0308642 $w=8.1e-08 $l=2.5e-09 $layer=N_src_drn $thickness=1e-09
+ $X=0.5573 $Y=0.0675 $X2=0.5545 $Y2=0.0675
r6 3 45 0.179012 $w=8.1e-08 $l=1.45e-08 $layer=N_src_drn $thickness=1e-09
+ $X=0.54 $Y=0.0675 $X2=0.5545 $Y2=0.0675
r7 11 3 0.179012 $w=8.1e-08 $l=1.45e-08 $layer=N_src_drn $thickness=1e-09
+ $X=0.5255 $Y=0.0675 $X2=0.54 $Y2=0.0675
r8 46 11 0.0308642 $w=8.1e-08 $l=2.5e-09 $layer=N_src_drn $thickness=1e-09
+ $X=0.5226 $Y=0.0675 $X2=0.5255 $Y2=0.0675
r9 4 42 19.3796 $a=3.24e-16 $layer=V0LISD $X=0.648 $Y=0.0675 $X2=0.648 $Y2=0.099
r10 3 38 19.3796 $a=3.24e-16 $layer=V0LISD $X=0.54 $Y=0.0675 $X2=0.54 $Y2=0.099
r11 41 42 5.24677 $w=1.3e-08 $l=2.25e-08 $layer=M1 $thickness=3.6e-08 $X=0.6255
+ $Y=0.099 $X2=0.648 $Y2=0.099
r12 18 41 7.34548 $w=1.3e-08 $l=3.15e-08 $layer=M1 $thickness=3.6e-08 $X=0.594
+ $Y=0.099 $X2=0.6255 $Y2=0.099
r13 38 39 3.14806 $w=1.3e-08 $l=1.35e-08 $layer=M1 $thickness=3.6e-08 $X=0.54
+ $Y=0.099 $X2=0.5535 $Y2=0.099
r14 15 38 3.38125 $w=1.3e-08 $l=1.45e-08 $layer=M1 $thickness=3.6e-08 $X=0.5255
+ $Y=0.099 $X2=0.54 $Y2=0.099
r15 13 17 3.01711 $w=1.55e-08 $l=1.8e-08 $layer=M1 $thickness=3.6e-08 $X=0.567
+ $Y=0.099 $X2=0.567 $Y2=0.117
r16 13 39 1.96775 $w=1.63333e-08 $l=1.35e-08 $layer=M1 $thickness=3.6e-08
+ $X=0.567 $Y=0.099 $X2=0.5535 $Y2=0.099
r17 13 18 5.11582 $w=1.46667e-08 $l=2.7e-08 $layer=M1 $thickness=3.6e-08
+ $X=0.567 $Y=0.099 $X2=0.594 $Y2=0.099
r18 14 31 1.49895 $w=1.63333e-08 $l=1.35e-08 $layer=M1 $thickness=3.6e-08
+ $X=0.567 $Y=0.135 $X2=0.5535 $Y2=0.135
r19 14 17 2.5483 $w=1.79e-08 $l=1.8e-08 $layer=M1 $thickness=3.6e-08 $X=0.567
+ $Y=0.135 $X2=0.567 $Y2=0.117
r20 36 35 16.4967 $w=2.1e-08 $l=4.85e-08 $layer=Gate_1 $thickness=5.6e-08
+ $X=0.567 $Y=0.2025 $X2=0.567 $Y2=0.154
r21 33 34 16.4967 $w=2.1e-08 $l=4.85e-08 $layer=Gate_1 $thickness=5.6e-08
+ $X=0.567 $Y=0.0675 $X2=0.567 $Y2=0.116
r22 10 27 6.54019 $w=2.09524e-08 $layer=Gate_1 $thickness=5.21905e-08 $X=0.567
+ $Y=0.135 $X2=0.567 $Y2=0.135
r23 10 34 6.6497 $w=2.04211e-08 $l=1.9e-08 $layer=Gate_1 $thickness=5.6e-08
+ $X=0.567 $Y=0.135 $X2=0.567 $Y2=0.116
r24 10 35 6.6497 $w=2.04211e-08 $l=1.9e-08 $layer=Gate_1 $thickness=5.6e-08
+ $X=0.567 $Y=0.135 $X2=0.567 $Y2=0.154
r25 30 31 3.14806 $w=1.3e-08 $l=1.35e-08 $layer=M1 $thickness=3.6e-08 $X=0.54
+ $Y=0.135 $X2=0.5535 $Y2=0.135
r26 29 30 2.68168 $w=1.3e-08 $l=1.15e-08 $layer=M1 $thickness=3.6e-08 $X=0.5285
+ $Y=0.135 $X2=0.54 $Y2=0.135
r27 16 29 1.28254 $w=1.3e-08 $l=5.5e-09 $layer=M1 $thickness=3.6e-08 $X=0.523
+ $Y=0.135 $X2=0.5285 $Y2=0.135
r28 26 27 12.6539 $w=1.77815e-08 $l=2.7e-08 $layer=LIG $thickness=4.8e-08
+ $X=0.54 $Y=0.135 $X2=0.567 $Y2=0.135
r29 26 30 19.3796 $a=3.24e-16 $layer=V0LIG $X=0.54 $Y=0.135 $X2=0.54 $Y2=0.135
r30 1 21 6.54019 $w=2.09524e-08 $layer=Gate_1 $thickness=5.21905e-08 $X=0.513
+ $Y=0.135 $X2=0.513 $Y2=0.135
r31 1 26 12.6539 $w=1.77815e-08 $l=2.7e-08 $layer=LIG $thickness=4.8e-08
+ $X=0.513 $Y=0.135 $X2=0.54 $Y2=0.135
r32 23 22 16.4967 $w=2.1e-08 $l=4.85e-08 $layer=Gate_1 $thickness=5.6e-08
+ $X=0.513 $Y=0.2025 $X2=0.513 $Y2=0.154
r33 21 22 6.6497 $w=2.04211e-08 $l=1.9e-08 $layer=Gate_1 $thickness=5.6e-08
+ $X=0.513 $Y=0.135 $X2=0.513 $Y2=0.154
r34 20 21 6.6497 $w=2.04211e-08 $l=1.9e-08 $layer=Gate_1 $thickness=5.6e-08
+ $X=0.513 $Y=0.116 $X2=0.513 $Y2=0.135
r35 19 20 16.4967 $w=2.1e-08 $l=4.85e-08 $layer=Gate_1 $thickness=5.6e-08
+ $X=0.513 $Y=0.0675 $X2=0.513 $Y2=0.116
r36 19 9 14.6259 $w=2.1e-08 $l=4.3e-08 $layer=Gate_1 $thickness=5.6e-08
+ $X=0.513 $Y=0.0675 $X2=0.513 $Y2=0.0245
.ends

.subckt PM_CKINVDCx5p33_ASAP7_75t_R%8 vss 19 23 33 36 46 47 50 51 10 18 1 17 11
+ 15 9 3 13 14 4
c1 1 vss 0.00632627f $X=0.297 $Y=0.135
c2 3 vss 0.00727965f $X=0.216 $Y=0.2025
c3 4 vss 0.00732235f $X=0.324 $Y=0.2025
c4 9 vss 0.0822551f $X=0.297 $Y=0.0245
c5 10 vss 0.104122f $X=0.351 $Y=0.135
c6 11 vss 0.00695931f $X=0.2015 $Y=0.2025
c7 12 vss 0.00648902f $X=0.3095 $Y=0.2025
c8 13 vss 0.000220405f $X=0.297 $Y=0.135
c9 14 vss 0.000378236f $X=0.297 $Y=0.171
c10 15 vss 0.00261954f $X=0.27 $Y=0.171
c11 16 vss 0.000156067f $X=0.297 $Y=0.153
c12 17 vss 0.000416962f $X=0.3105 $Y=0.135
c13 18 vss 0.00137684f $X=0.3105 $Y=0.171
r1 51 49 0.0308642 $w=8.1e-08 $l=2.5e-09 $layer=P_src_drn $thickness=1e-09
+ $X=0.3413 $Y=0.2025 $X2=0.3385 $Y2=0.2025
r2 4 49 0.179012 $w=8.1e-08 $l=1.45e-08 $layer=P_src_drn $thickness=1e-09
+ $X=0.324 $Y=0.2025 $X2=0.3385 $Y2=0.2025
r3 12 4 0.179012 $w=8.1e-08 $l=1.45e-08 $layer=P_src_drn $thickness=1e-09
+ $X=0.3095 $Y=0.2025 $X2=0.324 $Y2=0.2025
r4 50 12 0.0308642 $w=8.1e-08 $l=2.5e-09 $layer=P_src_drn $thickness=1e-09
+ $X=0.3066 $Y=0.2025 $X2=0.3095 $Y2=0.2025
r5 47 45 0.0308642 $w=8.1e-08 $l=2.5e-09 $layer=P_src_drn $thickness=1e-09
+ $X=0.2333 $Y=0.2025 $X2=0.2305 $Y2=0.2025
r6 3 45 0.179012 $w=8.1e-08 $l=1.45e-08 $layer=P_src_drn $thickness=1e-09
+ $X=0.216 $Y=0.2025 $X2=0.2305 $Y2=0.2025
r7 11 3 0.179012 $w=8.1e-08 $l=1.45e-08 $layer=P_src_drn $thickness=1e-09
+ $X=0.2015 $Y=0.2025 $X2=0.216 $Y2=0.2025
r8 46 11 0.0308642 $w=8.1e-08 $l=2.5e-09 $layer=P_src_drn $thickness=1e-09
+ $X=0.1986 $Y=0.2025 $X2=0.2015 $Y2=0.2025
r9 4 41 19.3796 $a=3.24e-16 $layer=V0LISD $X=0.324 $Y=0.2025 $X2=0.324 $Y2=0.171
r10 3 39 19.3796 $a=3.24e-16 $layer=V0LISD $X=0.216 $Y=0.2025 $X2=0.216
+ $Y2=0.171
r11 18 41 3.14806 $w=1.3e-08 $l=1.35e-08 $layer=M1 $thickness=3.6e-08 $X=0.3105
+ $Y=0.171 $X2=0.324 $Y2=0.171
r12 39 40 5.24677 $w=1.3e-08 $l=2.25e-08 $layer=M1 $thickness=3.6e-08 $X=0.216
+ $Y=0.171 $X2=0.2385 $Y2=0.171
r13 15 40 7.34548 $w=1.3e-08 $l=3.15e-08 $layer=M1 $thickness=3.6e-08 $X=0.27
+ $Y=0.171 $X2=0.2385 $Y2=0.171
r14 14 16 3.01711 $w=1.55e-08 $l=1.8e-08 $layer=M1 $thickness=3.6e-08 $X=0.297
+ $Y=0.171 $X2=0.297 $Y2=0.153
r15 14 15 5.11582 $w=1.46667e-08 $l=2.7e-08 $layer=M1 $thickness=3.6e-08
+ $X=0.297 $Y=0.171 $X2=0.27 $Y2=0.171
r16 14 18 1.96775 $w=1.63333e-08 $l=1.35e-08 $layer=M1 $thickness=3.6e-08
+ $X=0.297 $Y=0.171 $X2=0.3105 $Y2=0.171
r17 13 17 1.49895 $w=1.63333e-08 $l=1.35e-08 $layer=M1 $thickness=3.6e-08
+ $X=0.297 $Y=0.135 $X2=0.3105 $Y2=0.135
r18 13 16 2.5483 $w=1.79e-08 $l=1.8e-08 $layer=M1 $thickness=3.6e-08 $X=0.297
+ $Y=0.135 $X2=0.297 $Y2=0.153
r19 36 35 16.4967 $w=2.1e-08 $l=4.85e-08 $layer=Gate_1 $thickness=5.6e-08
+ $X=0.351 $Y=0.2025 $X2=0.351 $Y2=0.154
r20 33 34 16.4967 $w=2.1e-08 $l=4.85e-08 $layer=Gate_1 $thickness=5.6e-08
+ $X=0.351 $Y=0.0675 $X2=0.351 $Y2=0.116
r21 10 27 6.54019 $w=2.09524e-08 $layer=Gate_1 $thickness=5.21905e-08 $X=0.351
+ $Y=0.135 $X2=0.351 $Y2=0.135
r22 10 34 6.6497 $w=2.04211e-08 $l=1.9e-08 $layer=Gate_1 $thickness=5.6e-08
+ $X=0.351 $Y=0.135 $X2=0.351 $Y2=0.116
r23 10 35 6.6497 $w=2.04211e-08 $l=1.9e-08 $layer=Gate_1 $thickness=5.6e-08
+ $X=0.351 $Y=0.135 $X2=0.351 $Y2=0.154
r24 17 29 3.14806 $w=1.3e-08 $l=1.35e-08 $layer=M1 $thickness=3.6e-08 $X=0.3105
+ $Y=0.135 $X2=0.324 $Y2=0.135
r25 26 27 12.6539 $w=1.77815e-08 $l=2.7e-08 $layer=LIG $thickness=4.8e-08
+ $X=0.324 $Y=0.135 $X2=0.351 $Y2=0.135
r26 26 29 19.3796 $a=3.24e-16 $layer=V0LIG $X=0.324 $Y=0.135 $X2=0.324 $Y2=0.135
r27 1 21 6.54019 $w=2.09524e-08 $layer=Gate_1 $thickness=5.21905e-08 $X=0.297
+ $Y=0.135 $X2=0.297 $Y2=0.135
r28 1 26 12.6539 $w=1.77815e-08 $l=2.7e-08 $layer=LIG $thickness=4.8e-08
+ $X=0.297 $Y=0.135 $X2=0.324 $Y2=0.135
r29 23 22 16.4967 $w=2.1e-08 $l=4.85e-08 $layer=Gate_1 $thickness=5.6e-08
+ $X=0.297 $Y=0.2025 $X2=0.297 $Y2=0.154
r30 21 22 6.6497 $w=2.04211e-08 $l=1.9e-08 $layer=Gate_1 $thickness=5.6e-08
+ $X=0.297 $Y=0.135 $X2=0.297 $Y2=0.154
r31 20 21 6.6497 $w=2.04211e-08 $l=1.9e-08 $layer=Gate_1 $thickness=5.6e-08
+ $X=0.297 $Y=0.116 $X2=0.297 $Y2=0.135
r32 19 20 16.4967 $w=2.1e-08 $l=4.85e-08 $layer=Gate_1 $thickness=5.6e-08
+ $X=0.297 $Y=0.0675 $X2=0.297 $Y2=0.116
r33 19 9 14.6259 $w=2.1e-08 $l=4.3e-08 $layer=Gate_1 $thickness=5.6e-08
+ $X=0.297 $Y=0.0675 $X2=0.297 $Y2=0.0245
.ends

* End of included file CKINVDCx5p33_ASAP7_75t_R.pex.sp.pex

*
.subckt CKINVDCx5p33_ASAP7_75t_CUSTOM_4_25_0_7 VSS VDD A Y
*
* VSS VSS
* VDD VDD
* A A
* Y Y
*
*

M0 N_M0_d N_M0_g VSS VSS nmos_rvt L=2e-08 W=5.4e-08 nfin=2 $X=0.071 $Y=0.027
M1 N_M1_d N_M1_g VSS VSS nmos_rvt L=2e-08 W=5.4e-08 nfin=2 $X=0.125 $Y=0.027
M16 N_M16_d N_M16_g VSS VSS nmos_rvt L=2e-08 W=8.1e-08 nfin=3 $X=0.179 $Y=0.027
M17 N_M17_d N_M17_g VSS VSS nmos_rvt L=2e-08 W=8.1e-08 nfin=3 $X=0.233 $Y=0.027
M14 N_M14_d N_M14_g VSS VSS nmos_rvt L=2e-08 W=8.1e-08 nfin=3 $X=0.287 $Y=0.027
M15 N_M15_d N_M15_g VSS VSS nmos_rvt L=2e-08 W=8.1e-08 nfin=3 $X=0.341 $Y=0.027
M6 N_M6_d N_M6_g VSS VSS nmos_rvt L=2e-08 W=5.4e-08 nfin=2 $X=0.395 $Y=0.027
M7 N_M7_d N_M7_g VSS VSS nmos_rvt L=2e-08 W=5.4e-08 nfin=2 $X=0.449 $Y=0.027
M8 N_M8_d N_M8_g VSS VSS nmos_rvt L=2e-08 W=8.1e-08 nfin=3 $X=0.503 $Y=0.027
M9 N_M9_d N_M9_g VSS VSS nmos_rvt L=2e-08 W=8.1e-08 nfin=3 $X=0.557 $Y=0.027
M10 N_M10_d N_M10_g VSS VSS nmos_rvt L=2e-08 W=8.1e-08 nfin=3 $X=0.611 $Y=0.027
M11 N_M11_d N_M11_g VSS VSS nmos_rvt L=2e-08 W=8.1e-08 nfin=3 $X=0.665 $Y=0.027
M12 N_M12_d N_M12_g VSS VSS nmos_rvt L=2e-08 W=5.4e-08 nfin=2 $X=0.719 $Y=0.027
M13 N_M13_d N_M13_g VSS VSS nmos_rvt L=2e-08 W=5.4e-08 nfin=2 $X=0.773 $Y=0.027
M4 N_M4_d N_M4_g VSS VSS nmos_rvt L=2e-08 W=8.1e-08 nfin=3 $X=0.827 $Y=0.027
M5 N_M5_d N_M5_g VSS VSS nmos_rvt L=2e-08 W=8.1e-08 nfin=3 $X=0.881 $Y=0.027
M2 N_M2_d N_M2_g VSS VSS nmos_rvt L=2e-08 W=8.1e-08 nfin=3 $X=0.935 $Y=0.027
M3 N_M3_d N_M3_g VSS VSS nmos_rvt L=2e-08 W=8.1e-08 nfin=3 $X=0.989 $Y=0.027
M18 N_M18_d N_M18_g VSS VSS nmos_rvt L=2e-08 W=5.4e-08 nfin=2 $X=1.043 $Y=0.027
M19 N_M19_d N_M19_g VSS VSS nmos_rvt L=2e-08 W=5.4e-08 nfin=2 $X=1.097 $Y=0.027
M20 N_M20_d N_M20_g VDD VDD pmos_rvt L=2e-08 W=5.4e-08 nfin=2 $X=0.071 $Y=0.189
M21 N_M21_d N_M21_g VDD VDD pmos_rvt L=2e-08 W=5.4e-08 nfin=2 $X=0.125 $Y=0.189
M36 N_M36_d N_M36_g VDD VDD pmos_rvt L=2e-08 W=8.1e-08 nfin=3 $X=0.179 $Y=0.162
M37 N_M37_d N_M37_g VDD VDD pmos_rvt L=2e-08 W=8.1e-08 nfin=3 $X=0.233 $Y=0.162
M34 N_M34_d N_M34_g VDD VDD pmos_rvt L=2e-08 W=8.1e-08 nfin=3 $X=0.287 $Y=0.162
M35 N_M35_d N_M35_g VDD VDD pmos_rvt L=2e-08 W=8.1e-08 nfin=3 $X=0.341 $Y=0.162
M26 N_M26_d N_M26_g VDD VDD pmos_rvt L=2e-08 W=5.4e-08 nfin=2 $X=0.395 $Y=0.189
M27 N_M27_d N_M27_g VDD VDD pmos_rvt L=2e-08 W=5.4e-08 nfin=2 $X=0.449 $Y=0.189
M28 N_M28_d N_M28_g VDD VDD pmos_rvt L=2e-08 W=8.1e-08 nfin=3 $X=0.503 $Y=0.162
M29 N_M29_d N_M29_g VDD VDD pmos_rvt L=2e-08 W=8.1e-08 nfin=3 $X=0.557 $Y=0.162
M30 N_M30_d N_M30_g VDD VDD pmos_rvt L=2e-08 W=8.1e-08 nfin=3 $X=0.611 $Y=0.162
M31 N_M31_d N_M31_g VDD VDD pmos_rvt L=2e-08 W=8.1e-08 nfin=3 $X=0.665 $Y=0.162
M32 N_M32_d N_M32_g VDD VDD pmos_rvt L=2e-08 W=5.4e-08 nfin=2 $X=0.719 $Y=0.189
M33 N_M33_d N_M33_g VDD VDD pmos_rvt L=2e-08 W=5.4e-08 nfin=2 $X=0.773 $Y=0.189
M24 N_M24_d N_M24_g VDD VDD pmos_rvt L=2e-08 W=8.1e-08 nfin=3 $X=0.827 $Y=0.162
M25 N_M25_d N_M25_g VDD VDD pmos_rvt L=2e-08 W=8.1e-08 nfin=3 $X=0.881 $Y=0.162
M22 N_M22_d N_M22_g VDD VDD pmos_rvt L=2e-08 W=8.1e-08 nfin=3 $X=0.935 $Y=0.162
M23 N_M23_d N_M23_g VDD VDD pmos_rvt L=2e-08 W=8.1e-08 nfin=3 $X=0.989 $Y=0.162
M38 N_M38_d N_M38_g VDD VDD pmos_rvt L=2e-08 W=5.4e-08 nfin=2 $X=1.043 $Y=0.189
M39 N_M39_d N_M39_g VDD VDD pmos_rvt L=2e-08 W=5.4e-08 nfin=2 $X=1.097 $Y=0.189

* .include "CKINVDCx5p33_ASAP7_75t_R.pex.sp.pxi"

* Start of included file CKINVDCx5p33_ASAP7_75t_R.pex.sp.pxi
x_PM_CKINVDCx5p33_ASAP7_75t_R%9 vss N_M16_g N_M36_g N_M17_g N_M37_g N_M16_d
+ N_M17_d N_M14_d N_M15_d N_9_3 N_9_18 N_9_15 N_9_4 N_9_1 N_9_9 N_9_10 N_9_16
+ N_9_12 N_9_14 PM_CKINVDCx5p33_ASAP7_75t_R%9
cc_1 N_9_3 N_A_18 4.86885e-20 $X=0.216 $Y=0.0675
cc_2 N_9_3 N_A_1 0.000128528f $X=0.216 $Y=0.0675
cc_3 N_9_3 N_A_20 0.000167975f $X=0.216 $Y=0.0675
cc_4 N_9_3 N_A_27 0.000442219f $X=0.216 $Y=0.0675
cc_5 N_9_18 N_A_27 0.000741448f $X=0.27 $Y=0.099
cc_6 N_9_15 N_A_26 0.00080279f $X=0.2015 $Y=0.099
cc_7 N_9_4 N_A_26 0.000922237f $X=0.324 $Y=0.0675
cc_8 N_9_1 N_A_1 0.00104399f $X=0.189 $Y=0.135
cc_9 N_9_18 N_A_26 0.00183886f $X=0.27 $Y=0.099
cc_10 N_9_9 N_A_10 0.0032872f $X=0.189 $Y=0.0245
cc_11 N_9_3 N_A_26 0.00547571f $X=0.216 $Y=0.0675
x_PM_CKINVDCx5p33_ASAP7_75t_R%7 vss N_M10_g N_M30_g N_M11_g N_M31_g N_M28_d
+ N_M29_d N_M30_d N_M31_d N_7_10 N_7_11 N_7_15 N_7_17 N_7_9 N_7_3 N_7_1 N_7_13
+ N_7_4 N_7_18 PM_CKINVDCx5p33_ASAP7_75t_R%7
cc_12 N_7_10 N_A_28 0.000124861f $X=0.675 $Y=0.135
cc_13 N_7_10 N_A_3 0.00120341f $X=0.675 $Y=0.135
cc_14 N_7_10 N_A_13 0.0034061f $X=0.675 $Y=0.135
cc_15 N_7_11 N_6_10 0.0512011f $X=0.5255 $Y=0.2025
cc_16 N_7_15 N_6_16 0.00130326f $X=0.594 $Y=0.171
cc_17 N_7_17 N_6_18 0.00131998f $X=0.6345 $Y=0.135
cc_18 N_7_9 N_6_4 0.00142782f $X=0.621 $Y=0.0245
cc_19 N_7_3 N_6_10 0.00142782f $X=0.54 $Y=0.2025
cc_20 N_7_3 N_6_1 0.00174171f $X=0.54 $Y=0.2025
cc_21 N_7_1 N_6_4 0.00174171f $X=0.621 $Y=0.135
cc_22 N_7_11 N_6_1 0.00299575f $X=0.5255 $Y=0.2025
cc_23 N_7_1 N_6_12 0.00299575f $X=0.621 $Y=0.135
cc_24 N_7_15 N_6_14 0.00378857f $X=0.594 $Y=0.171
cc_25 N_7_13 N_6_18 0.00381332f $X=0.621 $Y=0.135
cc_26 N_7_11 N_6_9 0.0132271f $X=0.5255 $Y=0.2025
cc_27 N_7_10 N_6_12 0.0132271f $X=0.675 $Y=0.135
cc_28 N_7_9 N_6_12 0.0523744f $X=0.621 $Y=0.0245
x_PM_CKINVDCx5p33_ASAP7_75t_R%4 vss N_M2_g N_M22_g N_M3_g N_M23_g N_M4_d N_M5_d
+ N_M2_d N_M3_d N_4_4 N_4_15 N_4_17 N_4_3 N_4_1 N_4_10 N_4_9 N_4_18 N_4_11
+ N_4_14 PM_CKINVDCx5p33_ASAP7_75t_R%4
cc_29 N_4_4 N_A_4 0.000128528f $X=0.972 $Y=0.0675
cc_30 N_4_4 N_A_21 0.000167975f $X=0.972 $Y=0.0675
cc_31 N_4_4 N_A_29 0.000442219f $X=0.972 $Y=0.0675
cc_32 N_4_15 N_A_29 0.000741448f $X=0.918 $Y=0.099
cc_33 N_4_17 N_A_30 0.00080279f $X=0.9585 $Y=0.099
cc_34 N_4_3 N_A_30 0.000922237f $X=0.864 $Y=0.0675
cc_35 N_4_1 N_A_4 0.00104707f $X=0.945 $Y=0.135
cc_36 N_4_15 N_A_30 0.00183886f $X=0.918 $Y=0.099
cc_37 N_4_10 N_A_15 0.0032872f $X=0.999 $Y=0.135
cc_38 N_4_4 N_A_30 0.00550401f $X=0.972 $Y=0.0675
cc_39 N_4_9 N_5_12 0.0512011f $X=0.945 $Y=0.0245
cc_40 N_4_15 N_5_16 0.00114063f $X=0.918 $Y=0.099
cc_41 N_4_18 N_5_18 0.00130326f $X=0.9585 $Y=0.135
cc_42 N_4_9 N_5_4 0.00142782f $X=0.945 $Y=0.0245
cc_43 N_4_3 N_5_10 0.00142782f $X=0.864 $Y=0.0675
cc_44 N_4_3 N_5_1 0.00170826f $X=0.864 $Y=0.0675
cc_45 N_4_1 N_5_4 0.00174163f $X=0.945 $Y=0.135
cc_46 N_4_11 N_5_1 0.00296468f $X=0.8495 $Y=0.0675
cc_47 N_4_1 N_5_12 0.00297177f $X=0.945 $Y=0.135
cc_48 N_4_15 N_5_13 0.00373515f $X=0.918 $Y=0.099
cc_49 N_4_14 N_5_18 0.00380434f $X=0.945 $Y=0.135
cc_50 N_4_10 N_5_12 0.0131585f $X=0.999 $Y=0.135
cc_51 N_4_11 N_5_9 0.013228f $X=0.8495 $Y=0.0675
cc_52 N_4_11 N_5_10 0.0523556f $X=0.8495 $Y=0.0675
x_PM_CKINVDCx5p33_ASAP7_75t_R%A vss A N_M0_g N_M20_g N_M1_g N_M21_g N_M6_g
+ N_M26_g N_M7_g N_M27_g N_M12_g N_M32_g N_M13_g N_M33_g N_M18_g N_M38_g
+ N_M19_g N_M39_g N_A_18 N_A_1 N_A_20 N_A_27 N_A_26 N_A_10 N_A_2 N_A_11 N_A_29
+ N_A_28 N_A_12 N_A_3 N_A_13 N_A_21 N_A_4 N_A_30 N_A_14 N_A_15 N_A_24 N_A_17
+ N_A_23 N_A_9 N_A_25 N_A_31 N_A_16 PM_CKINVDCx5p33_ASAP7_75t_R%A
x_PM_CKINVDCx5p33_ASAP7_75t_R%5 vss N_M4_g N_M24_g N_M5_g N_M25_g N_M24_d
+ N_M25_d N_M22_d N_M23_d N_5_9 N_5_15 N_5_1 N_5_16 N_5_12 N_5_18 N_5_4 N_5_10
+ N_5_13 N_5_14 N_5_3 PM_CKINVDCx5p33_ASAP7_75t_R%5
cc_53 N_5_9 N_A_21 0.000431645f $X=0.837 $Y=0.0245
cc_54 N_5_9 N_A_4 0.000148996f $X=0.837 $Y=0.0245
cc_55 N_5_9 N_A_3 0.000232856f $X=0.837 $Y=0.0245
cc_56 N_5_9 N_A_30 0.000304891f $X=0.837 $Y=0.0245
cc_57 N_5_9 N_A_29 0.000537689f $X=0.837 $Y=0.0245
cc_58 N_5_15 N_A_21 0.00084468f $X=0.8485 $Y=0.171
cc_59 N_5_1 N_A_3 0.00118139f $X=0.837 $Y=0.135
cc_60 N_5_16 N_A_21 0.00175607f $X=0.846 $Y=0.135
cc_61 N_5_9 N_A_14 0.00343109f $X=0.837 $Y=0.0245
x_PM_CKINVDCx5p33_ASAP7_75t_R%Y vss Y N_M0_d N_M1_d N_M20_d N_M21_d N_M26_d
+ N_M27_d N_M6_d N_M7_d N_M32_d N_M33_d N_M12_d N_M13_d N_M38_d N_M39_d N_M18_d
+ N_M19_d N_Y_27 N_Y_33 N_Y_2 N_Y_4 N_Y_6 N_Y_8 N_Y_34 N_Y_40 N_Y_39 N_Y_37
+ N_Y_35 N_Y_29 N_Y_32 N_Y_25 N_Y_28 N_Y_30 N_Y_31 N_Y_26 N_Y_46 N_Y_42 N_Y_1
+ N_Y_3 N_Y_7 N_Y_5 N_Y_43 N_Y_41 N_Y_47 N_Y_45 N_Y_44
+ PM_CKINVDCx5p33_ASAP7_75t_R%Y
cc_62 N_Y_27 N_A_24 0.000107832f $X=0.7415 $Y=0.054
cc_63 N_Y_33 N_A_17 0.000107856f $X=0.0965 $Y=0.072
cc_64 N_Y_2 N_A_10 0.00249109f $X=0.108 $Y=0.1755
cc_65 N_Y_4 N_A_12 0.00247936f $X=0.432 $Y=0.1755
cc_66 N_Y_6 N_A_14 0.000123404f $X=0.756 $Y=0.1755
cc_67 N_Y_8 N_A_15 0.00249109f $X=1.08 $Y=0.1755
cc_68 N_Y_34 N_A_18 0.000154931f $X=0.135 $Y=0.234
cc_69 N_Y_40 N_A_23 0.000154931f $X=1.053 $Y=0.234
cc_70 N_Y_33 N_A_18 0.000204997f $X=0.0965 $Y=0.072
cc_71 N_Y_39 N_A_23 0.000241107f $X=1.053 $Y=0.072
cc_72 N_Y_37 N_A_21 0.000337324f $X=0.729 $Y=0.072
cc_73 N_Y_35 N_A_20 0.000340235f $X=0.459 $Y=0.072
cc_74 N_Y_29 N_A_10 0.000606204f $X=0.0935 $Y=0.216
cc_75 N_Y_32 N_A_15 0.000606204f $X=1.0655 $Y=0.216
cc_76 N_Y_25 N_A_9 0.0208372f $X=0.0935 $Y=0.054
cc_77 N_Y_28 N_A_15 0.0282929f $X=1.0655 $Y=0.054
cc_78 N_Y_30 N_A_12 0.00062793f $X=0.4175 $Y=0.216
cc_79 N_Y_31 N_A_13 0.0130094f $X=0.7415 $Y=0.216
cc_80 N_Y_26 N_A_12 0.0351775f $X=0.4175 $Y=0.054
cc_81 N_Y_27 N_A_14 0.0407158f $X=0.7415 $Y=0.054
cc_82 N_Y_46 N_A_21 0.000717154f $X=0.7425 $Y=0.234
cc_83 N_Y_42 N_A_20 0.000717881f $X=0.165 $Y=0.234
cc_84 N_Y_1 N_A_26 0.000869449f $X=0.108 $Y=0.054
cc_85 N_Y_3 N_A_28 0.000869449f $X=0.432 $Y=0.054
cc_86 N_Y_7 N_A_30 0.000869449f $X=1.08 $Y=0.054
cc_87 N_Y_5 N_A_28 0.00087426f $X=0.756 $Y=0.054
cc_88 N_Y_35 N_A_27 0.00113704f $X=0.459 $Y=0.072
cc_89 N_Y_37 N_A_29 0.00113704f $X=0.729 $Y=0.072
cc_90 N_Y_4 N_A_2 0.00506614f $X=0.432 $Y=0.1755
cc_91 N_Y_6 N_A_3 0.00506614f $X=0.756 $Y=0.1755
cc_92 N_Y_1 N_A_1 0.00115513f $X=0.108 $Y=0.054
cc_93 N_Y_7 N_A_4 0.00115513f $X=1.08 $Y=0.054
cc_94 N_Y_33 N_A_25 0.00122707f $X=0.0965 $Y=0.072
cc_95 N_Y_39 N_A_31 0.00122707f $X=1.053 $Y=0.072
cc_96 N_Y_6 N_A_13 0.00235595f $X=0.756 $Y=0.1755
cc_97 N_Y_3 N_A_12 0.0029276f $X=0.432 $Y=0.054
cc_98 N_Y_5 N_A_13 0.0029276f $X=0.756 $Y=0.054
cc_99 N_Y_1 N_A_9 0.00295842f $X=0.108 $Y=0.054
cc_100 N_Y_7 N_A_16 0.00295842f $X=1.08 $Y=0.054
cc_101 N_Y_35 N_A_28 0.00311969f $X=0.459 $Y=0.072
cc_102 N_Y_43 N_A_20 0.00360338f $X=0.459 $Y=0.2025
cc_103 N_Y_41 N_A_18 0.0036235f $X=0.135 $Y=0.0855
cc_104 N_Y_47 N_A_23 0.0036235f $X=1.053 $Y=0.2025
cc_105 N_Y_45 N_A_21 0.00366377f $X=0.729 $Y=0.2025
cc_106 N_Y_2 N_A_1 0.0038865f $X=0.108 $Y=0.1755
cc_107 N_Y_8 N_A_4 0.0038865f $X=1.08 $Y=0.1755
cc_108 N_Y_33 N_A_26 0.00625334f $X=0.0965 $Y=0.072
cc_109 N_Y_39 N_A_30 0.00628962f $X=1.053 $Y=0.072
cc_110 N_Y_30 N_A_11 0.0199178f $X=0.4175 $Y=0.216
cc_111 N_Y_31 N_A_14 0.00753634f $X=0.7415 $Y=0.216
cc_112 N_Y_28 N_A_16 0.0202309f $X=1.0655 $Y=0.054
cc_113 N_Y_37 N_A_28 0.00926964f $X=0.729 $Y=0.072
cc_114 N_Y_26 N_A_11 0.0400876f $X=0.4175 $Y=0.054
cc_115 N_Y_29 N_A_9 0.0466176f $X=0.0935 $Y=0.216
cc_116 N_Y_32 N_A_16 0.0466176f $X=1.0655 $Y=0.216
cc_117 N_Y_25 N_A_10 0.0276811f $X=0.0935 $Y=0.054
cc_118 N_Y_27 N_A_13 0.0347411f $X=0.7415 $Y=0.054
cc_119 N_Y_1 N_9_16 9.40082e-20 $X=0.108 $Y=0.054
cc_120 N_Y_33 N_9_16 0.000464508f $X=0.0965 $Y=0.072
cc_121 N_Y_35 N_9_16 0.000208718f $X=0.459 $Y=0.072
cc_122 N_Y_42 N_9_16 0.000532214f $X=0.165 $Y=0.234
cc_123 N_Y_41 N_9_15 0.000656104f $X=0.135 $Y=0.0855
cc_124 N_Y_41 N_9_16 0.00217454f $X=0.135 $Y=0.0855
cc_125 N_Y_4 N_8_14 0.000171205f $X=0.432 $Y=0.1755
cc_126 N_Y_43 N_8_14 0.000269739f $X=0.459 $Y=0.2025
cc_127 N_Y_41 N_8_14 0.000456592f $X=0.135 $Y=0.0855
cc_128 N_Y_42 N_8_4 0.000822661f $X=0.165 $Y=0.234
cc_129 N_Y_42 N_8_3 0.000851754f $X=0.165 $Y=0.234
cc_130 N_Y_42 N_8_18 0.000979764f $X=0.165 $Y=0.234
cc_131 N_Y_42 N_8_15 0.00161072f $X=0.165 $Y=0.234
cc_132 N_Y_42 N_8_14 0.00519668f $X=0.165 $Y=0.234
cc_133 N_Y_3 N_6_16 9.68606e-20 $X=0.432 $Y=0.054
cc_134 N_Y_37 N_6_16 0.000130391f $X=0.729 $Y=0.072
cc_135 N_Y_35 N_6_16 0.000464517f $X=0.459 $Y=0.072
cc_136 N_Y_45 N_6_16 0.000161519f $X=0.729 $Y=0.2025
cc_137 N_Y_44 N_6_16 0.000525524f $X=0.489 $Y=0.234
cc_138 N_Y_43 N_6_15 0.000656104f $X=0.459 $Y=0.2025
cc_139 N_Y_45 N_6_18 0.000808001f $X=0.729 $Y=0.2025
cc_140 N_Y_43 N_6_16 0.00221418f $X=0.459 $Y=0.2025
cc_141 N_Y_6 N_7_15 0.000104875f $X=0.756 $Y=0.1755
cc_142 N_Y_45 N_7_15 0.000347519f $X=0.729 $Y=0.2025
cc_143 N_Y_45 N_7_17 0.000483247f $X=0.729 $Y=0.2025
cc_144 N_Y_43 N_7_15 0.000486021f $X=0.459 $Y=0.2025
cc_145 N_Y_44 N_7_3 0.000851754f $X=0.489 $Y=0.234
cc_146 N_Y_44 N_7_4 0.000865887f $X=0.489 $Y=0.234
cc_147 N_Y_45 N_7_18 0.00128667f $X=0.729 $Y=0.2025
cc_148 N_Y_44 N_7_18 0.00145057f $X=0.489 $Y=0.234
cc_149 N_Y_44 N_7_15 0.00687068f $X=0.489 $Y=0.234
cc_150 N_Y_45 N_5_14 0.000151878f $X=0.729 $Y=0.2025
cc_151 N_Y_6 N_5_14 0.000171205f $X=0.756 $Y=0.1755
cc_152 N_Y_47 N_5_14 0.000452248f $X=1.053 $Y=0.2025
cc_153 N_Y_46 N_5_3 0.000822661f $X=0.7425 $Y=0.234
cc_154 N_Y_46 N_5_4 0.000851754f $X=0.7425 $Y=0.234
cc_155 N_Y_46 N_5_15 0.000988829f $X=0.7425 $Y=0.234
cc_156 N_Y_46 N_5_18 0.00161072f $X=0.7425 $Y=0.234
cc_157 N_Y_46 N_5_14 0.00521498f $X=0.7425 $Y=0.234
cc_158 N_Y_7 N_4_18 9.40082e-20 $X=1.08 $Y=0.054
cc_159 N_Y_39 N_4_18 0.000464517f $X=1.053 $Y=0.072
cc_160 N_Y_37 N_4_18 0.000257823f $X=0.729 $Y=0.072
cc_161 N_Y_46 N_4_18 0.000532102f $X=0.7425 $Y=0.234
cc_162 N_Y_47 N_4_17 0.000656104f $X=1.053 $Y=0.2025
cc_163 N_Y_47 N_4_18 0.00222731f $X=1.053 $Y=0.2025
x_PM_CKINVDCx5p33_ASAP7_75t_R%6 vss N_M8_g N_M28_g N_M9_g N_M29_g N_M8_d N_M9_d
+ N_M10_d N_M11_d N_6_18 N_6_15 N_6_4 N_6_1 N_6_9 N_6_10 N_6_16 N_6_12 N_6_14
+ PM_CKINVDCx5p33_ASAP7_75t_R%6
cc_164 N_6_18 N_A_29 3.99153e-20 $X=0.594 $Y=0.099
cc_165 N_6_18 N_A_2 0.000128528f $X=0.594 $Y=0.099
cc_166 N_6_15 N_A_28 0.00080279f $X=0.5255 $Y=0.099
cc_167 N_6_4 N_A_28 0.000922237f $X=0.648 $Y=0.0675
cc_168 N_6_1 N_A_2 0.000984776f $X=0.513 $Y=0.135
cc_169 N_6_9 N_A_12 0.00320955f $X=0.513 $Y=0.0245
cc_170 N_6_18 N_A_28 0.00723191f $X=0.594 $Y=0.099
x_PM_CKINVDCx5p33_ASAP7_75t_R%8 vss N_M14_g N_M34_g N_M15_g N_M35_g N_M36_d
+ N_M37_d N_M34_d N_M35_d N_8_10 N_8_18 N_8_1 N_8_17 N_8_11 N_8_15 N_8_9 N_8_3
+ N_8_13 N_8_14 N_8_4 PM_CKINVDCx5p33_ASAP7_75t_R%8
cc_171 N_8_10 N_A_20 0.000431711f $X=0.351 $Y=0.135
cc_172 N_8_10 N_A_1 0.000135817f $X=0.351 $Y=0.135
cc_173 N_8_10 N_A_2 0.000232856f $X=0.351 $Y=0.135
cc_174 N_8_10 N_A_26 0.000304891f $X=0.351 $Y=0.135
cc_175 N_8_10 N_A_27 0.000537689f $X=0.351 $Y=0.135
cc_176 N_8_18 N_A_20 0.00083531f $X=0.3105 $Y=0.171
cc_177 N_8_1 N_A_2 0.00118144f $X=0.297 $Y=0.135
cc_178 N_8_17 N_A_20 0.00175607f $X=0.3105 $Y=0.135
cc_179 N_8_10 N_A_11 0.00345072f $X=0.351 $Y=0.135
cc_180 N_8_11 N_9_10 0.0512011f $X=0.2015 $Y=0.2025
cc_181 N_8_17 N_9_18 0.00114063f $X=0.3105 $Y=0.135
cc_182 N_8_15 N_9_16 0.00130322f $X=0.27 $Y=0.171
cc_183 N_8_9 N_9_4 0.00142782f $X=0.297 $Y=0.0245
cc_184 N_8_3 N_9_10 0.00142782f $X=0.216 $Y=0.2025
cc_185 N_8_1 N_9_4 0.00170816f $X=0.297 $Y=0.135
cc_186 N_8_3 N_9_1 0.00174171f $X=0.216 $Y=0.2025
cc_187 N_8_1 N_9_12 0.00296467f $X=0.297 $Y=0.135
cc_188 N_8_11 N_9_1 0.00299575f $X=0.2015 $Y=0.2025
cc_189 N_8_13 N_9_18 0.00373515f $X=0.297 $Y=0.135
cc_190 N_8_15 N_9_14 0.00380434f $X=0.27 $Y=0.171
cc_191 N_8_11 N_9_9 0.0131585f $X=0.2015 $Y=0.2025
cc_192 N_8_10 N_9_12 0.013228f $X=0.351 $Y=0.135
cc_193 N_8_9 N_9_12 0.0523556f $X=0.297 $Y=0.0245

* End of included file CKINVDCx5p33_ASAP7_75t_R.pex.sp.pxi
.ends

.subckt PM_CKINVDCx20_ASAP7_75t_R%4 vss 19 23 33 36 46 47 50 51 18 1 3 4 15 9
+ 12 16 14 10
c1 1 vss 0.00633075f $X=0.297 $Y=0.135
c2 3 vss 0.00715325f $X=0.324 $Y=0.0675
c3 4 vss 0.00721196f $X=0.432 $Y=0.0675
c4 9 vss 0.0823602f $X=0.297 $Y=0.0245
c5 10 vss 0.0821629f $X=0.351 $Y=0.135
c6 11 vss 0.00642311f $X=0.3095 $Y=0.0675
c7 12 vss 0.00690067f $X=0.4175 $Y=0.0675
c8 13 vss 0.000348899f $X=0.351 $Y=0.099
c9 14 vss 0.000207603f $X=0.351 $Y=0.135
c10 15 vss 0.00126508f $X=0.3095 $Y=0.099
c11 16 vss 0.000613297f $X=0.307 $Y=0.135
c12 17 vss 0.000149606f $X=0.351 $Y=0.117
c13 18 vss 0.00243225f $X=0.378 $Y=0.099
r1 51 49 0.0308642 $w=8.1e-08 $l=2.5e-09 $layer=N_src_drn $thickness=1e-09
+ $X=0.4493 $Y=0.0675 $X2=0.4465 $Y2=0.0675
r2 4 49 0.179012 $w=8.1e-08 $l=1.45e-08 $layer=N_src_drn $thickness=1e-09
+ $X=0.432 $Y=0.0675 $X2=0.4465 $Y2=0.0675
r3 12 4 0.179012 $w=8.1e-08 $l=1.45e-08 $layer=N_src_drn $thickness=1e-09
+ $X=0.4175 $Y=0.0675 $X2=0.432 $Y2=0.0675
r4 50 12 0.0308642 $w=8.1e-08 $l=2.5e-09 $layer=N_src_drn $thickness=1e-09
+ $X=0.4146 $Y=0.0675 $X2=0.4175 $Y2=0.0675
r5 47 45 0.0308642 $w=8.1e-08 $l=2.5e-09 $layer=N_src_drn $thickness=1e-09
+ $X=0.3413 $Y=0.0675 $X2=0.3385 $Y2=0.0675
r6 3 45 0.179012 $w=8.1e-08 $l=1.45e-08 $layer=N_src_drn $thickness=1e-09
+ $X=0.324 $Y=0.0675 $X2=0.3385 $Y2=0.0675
r7 11 3 0.179012 $w=8.1e-08 $l=1.45e-08 $layer=N_src_drn $thickness=1e-09
+ $X=0.3095 $Y=0.0675 $X2=0.324 $Y2=0.0675
r8 46 11 0.0308642 $w=8.1e-08 $l=2.5e-09 $layer=N_src_drn $thickness=1e-09
+ $X=0.3066 $Y=0.0675 $X2=0.3095 $Y2=0.0675
r9 4 42 19.3796 $a=3.24e-16 $layer=V0LISD $X=0.432 $Y=0.0675 $X2=0.432 $Y2=0.099
r10 3 38 19.3796 $a=3.24e-16 $layer=V0LISD $X=0.324 $Y=0.0675 $X2=0.324
+ $Y2=0.099
r11 41 42 5.24677 $w=1.3e-08 $l=2.25e-08 $layer=M1 $thickness=3.6e-08 $X=0.4095
+ $Y=0.099 $X2=0.432 $Y2=0.099
r12 18 41 7.34548 $w=1.3e-08 $l=3.15e-08 $layer=M1 $thickness=3.6e-08 $X=0.378
+ $Y=0.099 $X2=0.4095 $Y2=0.099
r13 38 39 3.14806 $w=1.3e-08 $l=1.35e-08 $layer=M1 $thickness=3.6e-08 $X=0.324
+ $Y=0.099 $X2=0.3375 $Y2=0.099
r14 15 38 3.38125 $w=1.3e-08 $l=1.45e-08 $layer=M1 $thickness=3.6e-08 $X=0.3095
+ $Y=0.099 $X2=0.324 $Y2=0.099
r15 13 17 3.01711 $w=1.55e-08 $l=1.8e-08 $layer=M1 $thickness=3.6e-08 $X=0.351
+ $Y=0.099 $X2=0.351 $Y2=0.117
r16 13 39 1.96775 $w=1.63333e-08 $l=1.35e-08 $layer=M1 $thickness=3.6e-08
+ $X=0.351 $Y=0.099 $X2=0.3375 $Y2=0.099
r17 13 18 5.11582 $w=1.46667e-08 $l=2.7e-08 $layer=M1 $thickness=3.6e-08
+ $X=0.351 $Y=0.099 $X2=0.378 $Y2=0.099
r18 14 31 1.49895 $w=1.63333e-08 $l=1.35e-08 $layer=M1 $thickness=3.6e-08
+ $X=0.351 $Y=0.135 $X2=0.3375 $Y2=0.135
r19 14 17 2.5483 $w=1.79e-08 $l=1.8e-08 $layer=M1 $thickness=3.6e-08 $X=0.351
+ $Y=0.135 $X2=0.351 $Y2=0.117
r20 36 35 16.4967 $w=2.1e-08 $l=4.85e-08 $layer=Gate_1 $thickness=5.6e-08
+ $X=0.351 $Y=0.2025 $X2=0.351 $Y2=0.154
r21 33 34 16.4967 $w=2.1e-08 $l=4.85e-08 $layer=Gate_1 $thickness=5.6e-08
+ $X=0.351 $Y=0.0675 $X2=0.351 $Y2=0.116
r22 10 27 6.54019 $w=2.09524e-08 $layer=Gate_1 $thickness=5.21905e-08 $X=0.351
+ $Y=0.135 $X2=0.351 $Y2=0.135
r23 10 34 6.6497 $w=2.04211e-08 $l=1.9e-08 $layer=Gate_1 $thickness=5.6e-08
+ $X=0.351 $Y=0.135 $X2=0.351 $Y2=0.116
r24 10 35 6.6497 $w=2.04211e-08 $l=1.9e-08 $layer=Gate_1 $thickness=5.6e-08
+ $X=0.351 $Y=0.135 $X2=0.351 $Y2=0.154
r25 30 31 3.14806 $w=1.3e-08 $l=1.35e-08 $layer=M1 $thickness=3.6e-08 $X=0.324
+ $Y=0.135 $X2=0.3375 $Y2=0.135
r26 29 30 2.68168 $w=1.3e-08 $l=1.15e-08 $layer=M1 $thickness=3.6e-08 $X=0.3125
+ $Y=0.135 $X2=0.324 $Y2=0.135
r27 16 29 1.28254 $w=1.3e-08 $l=5.5e-09 $layer=M1 $thickness=3.6e-08 $X=0.307
+ $Y=0.135 $X2=0.3125 $Y2=0.135
r28 26 27 12.6539 $w=1.77815e-08 $l=2.7e-08 $layer=LIG $thickness=4.8e-08
+ $X=0.324 $Y=0.135 $X2=0.351 $Y2=0.135
r29 26 30 19.3796 $a=3.24e-16 $layer=V0LIG $X=0.324 $Y=0.135 $X2=0.324 $Y2=0.135
r30 1 21 6.54019 $w=2.09524e-08 $layer=Gate_1 $thickness=5.21905e-08 $X=0.297
+ $Y=0.135 $X2=0.297 $Y2=0.135
r31 1 26 12.6539 $w=1.77815e-08 $l=2.7e-08 $layer=LIG $thickness=4.8e-08
+ $X=0.297 $Y=0.135 $X2=0.324 $Y2=0.135
r32 23 22 16.4967 $w=2.1e-08 $l=4.85e-08 $layer=Gate_1 $thickness=5.6e-08
+ $X=0.297 $Y=0.2025 $X2=0.297 $Y2=0.154
r33 21 22 6.6497 $w=2.04211e-08 $l=1.9e-08 $layer=Gate_1 $thickness=5.6e-08
+ $X=0.297 $Y=0.135 $X2=0.297 $Y2=0.154
r34 20 21 6.6497 $w=2.04211e-08 $l=1.9e-08 $layer=Gate_1 $thickness=5.6e-08
+ $X=0.297 $Y=0.116 $X2=0.297 $Y2=0.135
r35 19 20 16.4967 $w=2.1e-08 $l=4.85e-08 $layer=Gate_1 $thickness=5.6e-08
+ $X=0.297 $Y=0.0675 $X2=0.297 $Y2=0.116
r36 19 9 14.6259 $w=2.1e-08 $l=4.3e-08 $layer=Gate_1 $thickness=5.6e-08
+ $X=0.297 $Y=0.0675 $X2=0.297 $Y2=0.0245
.ends

.subckt PM_CKINVDCx20_ASAP7_75t_R%7 vss 19 23 33 36 46 47 50 51 10 15 17 3 1 11
+ 13 9 4 18
c1 1 vss 0.00633091f $X=0.837 $Y=0.135
c2 3 vss 0.00722018f $X=0.756 $Y=0.2025
c3 4 vss 0.00716416f $X=0.864 $Y=0.2025
c4 9 vss 0.0821856f $X=0.837 $Y=0.0245
c5 10 vss 0.0823942f $X=0.891 $Y=0.135
c6 11 vss 0.00718726f $X=0.7415 $Y=0.2025
c7 12 vss 0.00667315f $X=0.8495 $Y=0.2025
c8 13 vss 0.000209427f $X=0.837 $Y=0.135
c9 14 vss 0.000356275f $X=0.837 $Y=0.171
c10 15 vss 0.00257905f $X=0.81 $Y=0.171
c11 16 vss 0.000149612f $X=0.837 $Y=0.153
c12 17 vss 0.00068299f $X=0.8505 $Y=0.135
c13 18 vss 0.00130566f $X=0.8505 $Y=0.171
r1 51 49 0.0308642 $w=8.1e-08 $l=2.5e-09 $layer=P_src_drn $thickness=1e-09
+ $X=0.8813 $Y=0.2025 $X2=0.8785 $Y2=0.2025
r2 4 49 0.179012 $w=8.1e-08 $l=1.45e-08 $layer=P_src_drn $thickness=1e-09
+ $X=0.864 $Y=0.2025 $X2=0.8785 $Y2=0.2025
r3 12 4 0.179012 $w=8.1e-08 $l=1.45e-08 $layer=P_src_drn $thickness=1e-09
+ $X=0.8495 $Y=0.2025 $X2=0.864 $Y2=0.2025
r4 50 12 0.0308642 $w=8.1e-08 $l=2.5e-09 $layer=P_src_drn $thickness=1e-09
+ $X=0.8466 $Y=0.2025 $X2=0.8495 $Y2=0.2025
r5 47 45 0.0308642 $w=8.1e-08 $l=2.5e-09 $layer=P_src_drn $thickness=1e-09
+ $X=0.7733 $Y=0.2025 $X2=0.7705 $Y2=0.2025
r6 3 45 0.179012 $w=8.1e-08 $l=1.45e-08 $layer=P_src_drn $thickness=1e-09
+ $X=0.756 $Y=0.2025 $X2=0.7705 $Y2=0.2025
r7 11 3 0.179012 $w=8.1e-08 $l=1.45e-08 $layer=P_src_drn $thickness=1e-09
+ $X=0.7415 $Y=0.2025 $X2=0.756 $Y2=0.2025
r8 46 11 0.0308642 $w=8.1e-08 $l=2.5e-09 $layer=P_src_drn $thickness=1e-09
+ $X=0.7386 $Y=0.2025 $X2=0.7415 $Y2=0.2025
r9 4 41 19.3796 $a=3.24e-16 $layer=V0LISD $X=0.864 $Y=0.2025 $X2=0.864 $Y2=0.171
r10 3 39 19.3796 $a=3.24e-16 $layer=V0LISD $X=0.756 $Y=0.2025 $X2=0.756
+ $Y2=0.171
r11 18 41 3.14806 $w=1.3e-08 $l=1.35e-08 $layer=M1 $thickness=3.6e-08 $X=0.8505
+ $Y=0.171 $X2=0.864 $Y2=0.171
r12 39 40 5.24677 $w=1.3e-08 $l=2.25e-08 $layer=M1 $thickness=3.6e-08 $X=0.756
+ $Y=0.171 $X2=0.7785 $Y2=0.171
r13 15 40 7.34548 $w=1.3e-08 $l=3.15e-08 $layer=M1 $thickness=3.6e-08 $X=0.81
+ $Y=0.171 $X2=0.7785 $Y2=0.171
r14 14 16 3.01711 $w=1.55e-08 $l=1.8e-08 $layer=M1 $thickness=3.6e-08 $X=0.837
+ $Y=0.171 $X2=0.837 $Y2=0.153
r15 14 15 5.11582 $w=1.46667e-08 $l=2.7e-08 $layer=M1 $thickness=3.6e-08
+ $X=0.837 $Y=0.171 $X2=0.81 $Y2=0.171
r16 14 18 1.96775 $w=1.63333e-08 $l=1.35e-08 $layer=M1 $thickness=3.6e-08
+ $X=0.837 $Y=0.171 $X2=0.8505 $Y2=0.171
r17 13 17 1.49895 $w=1.63333e-08 $l=1.35e-08 $layer=M1 $thickness=3.6e-08
+ $X=0.837 $Y=0.135 $X2=0.8505 $Y2=0.135
r18 13 16 2.5483 $w=1.79e-08 $l=1.8e-08 $layer=M1 $thickness=3.6e-08 $X=0.837
+ $Y=0.135 $X2=0.837 $Y2=0.153
r19 36 35 16.4967 $w=2.1e-08 $l=4.85e-08 $layer=Gate_1 $thickness=5.6e-08
+ $X=0.891 $Y=0.2025 $X2=0.891 $Y2=0.154
r20 33 34 16.4967 $w=2.1e-08 $l=4.85e-08 $layer=Gate_1 $thickness=5.6e-08
+ $X=0.891 $Y=0.0675 $X2=0.891 $Y2=0.116
r21 10 27 6.54019 $w=2.09524e-08 $layer=Gate_1 $thickness=5.21905e-08 $X=0.891
+ $Y=0.135 $X2=0.891 $Y2=0.135
r22 10 34 6.6497 $w=2.04211e-08 $l=1.9e-08 $layer=Gate_1 $thickness=5.6e-08
+ $X=0.891 $Y=0.135 $X2=0.891 $Y2=0.116
r23 10 35 6.6497 $w=2.04211e-08 $l=1.9e-08 $layer=Gate_1 $thickness=5.6e-08
+ $X=0.891 $Y=0.135 $X2=0.891 $Y2=0.154
r24 17 29 3.14806 $w=1.3e-08 $l=1.35e-08 $layer=M1 $thickness=3.6e-08 $X=0.8505
+ $Y=0.135 $X2=0.864 $Y2=0.135
r25 26 27 12.6539 $w=1.77815e-08 $l=2.7e-08 $layer=LIG $thickness=4.8e-08
+ $X=0.864 $Y=0.135 $X2=0.891 $Y2=0.135
r26 26 29 19.3796 $a=3.24e-16 $layer=V0LIG $X=0.864 $Y=0.135 $X2=0.864 $Y2=0.135
r27 1 21 6.54019 $w=2.09524e-08 $layer=Gate_1 $thickness=5.21905e-08 $X=0.837
+ $Y=0.135 $X2=0.837 $Y2=0.135
r28 1 26 12.6539 $w=1.77815e-08 $l=2.7e-08 $layer=LIG $thickness=4.8e-08
+ $X=0.837 $Y=0.135 $X2=0.864 $Y2=0.135
r29 23 22 16.4967 $w=2.1e-08 $l=4.85e-08 $layer=Gate_1 $thickness=5.6e-08
+ $X=0.837 $Y=0.2025 $X2=0.837 $Y2=0.154
r30 21 22 6.6497 $w=2.04211e-08 $l=1.9e-08 $layer=Gate_1 $thickness=5.6e-08
+ $X=0.837 $Y=0.135 $X2=0.837 $Y2=0.154
r31 20 21 6.6497 $w=2.04211e-08 $l=1.9e-08 $layer=Gate_1 $thickness=5.6e-08
+ $X=0.837 $Y=0.116 $X2=0.837 $Y2=0.135
r32 19 20 16.4967 $w=2.1e-08 $l=4.85e-08 $layer=Gate_1 $thickness=5.6e-08
+ $X=0.837 $Y=0.0675 $X2=0.837 $Y2=0.116
r33 19 9 14.6259 $w=2.1e-08 $l=4.3e-08 $layer=Gate_1 $thickness=5.6e-08
+ $X=0.837 $Y=0.0675 $X2=0.837 $Y2=0.0245
.ends

.subckt PM_CKINVDCx20_ASAP7_75t_R%10 vss 19 23 33 36 46 47 50 51 9 18 16 4 1 12
+ 13 10 3 15
c1 1 vss 0.00633394f $X=1.161 $Y=0.135
c2 3 vss 0.00716524f $X=1.188 $Y=0.2025
c3 4 vss 0.007221f $X=1.296 $Y=0.2025
c4 9 vss 0.0823976f $X=1.161 $Y=0.0245
c5 10 vss 0.0821878f $X=1.215 $Y=0.135
c6 11 vss 0.00669691f $X=1.1735 $Y=0.2025
c7 12 vss 0.00721327f $X=1.2815 $Y=0.2025
c8 13 vss 0.000209608f $X=1.215 $Y=0.135
c9 14 vss 0.000356456f $X=1.215 $Y=0.171
c10 15 vss 0.00130902f $X=1.1725 $Y=0.171
c11 16 vss 0.000664937f $X=1.17 $Y=0.135
c12 17 vss 0.000149612f $X=1.215 $Y=0.153
c13 18 vss 0.00258344f $X=1.242 $Y=0.171
r1 51 49 0.0308642 $w=8.1e-08 $l=2.5e-09 $layer=P_src_drn $thickness=1e-09
+ $X=1.3133 $Y=0.2025 $X2=1.3105 $Y2=0.2025
r2 4 49 0.179012 $w=8.1e-08 $l=1.45e-08 $layer=P_src_drn $thickness=1e-09
+ $X=1.296 $Y=0.2025 $X2=1.3105 $Y2=0.2025
r3 12 4 0.179012 $w=8.1e-08 $l=1.45e-08 $layer=P_src_drn $thickness=1e-09
+ $X=1.2815 $Y=0.2025 $X2=1.296 $Y2=0.2025
r4 50 12 0.0308642 $w=8.1e-08 $l=2.5e-09 $layer=P_src_drn $thickness=1e-09
+ $X=1.2786 $Y=0.2025 $X2=1.2815 $Y2=0.2025
r5 47 45 0.0308642 $w=8.1e-08 $l=2.5e-09 $layer=P_src_drn $thickness=1e-09
+ $X=1.2053 $Y=0.2025 $X2=1.2025 $Y2=0.2025
r6 3 45 0.179012 $w=8.1e-08 $l=1.45e-08 $layer=P_src_drn $thickness=1e-09
+ $X=1.188 $Y=0.2025 $X2=1.2025 $Y2=0.2025
r7 11 3 0.179012 $w=8.1e-08 $l=1.45e-08 $layer=P_src_drn $thickness=1e-09
+ $X=1.1735 $Y=0.2025 $X2=1.188 $Y2=0.2025
r8 46 11 0.0308642 $w=8.1e-08 $l=2.5e-09 $layer=P_src_drn $thickness=1e-09
+ $X=1.1706 $Y=0.2025 $X2=1.1735 $Y2=0.2025
r9 4 42 19.3796 $a=3.24e-16 $layer=V0LISD $X=1.296 $Y=0.2025 $X2=1.296 $Y2=0.171
r10 3 38 19.3796 $a=3.24e-16 $layer=V0LISD $X=1.188 $Y=0.2025 $X2=1.188
+ $Y2=0.171
r11 41 42 5.24677 $w=1.3e-08 $l=2.25e-08 $layer=M1 $thickness=3.6e-08 $X=1.2735
+ $Y=0.171 $X2=1.296 $Y2=0.171
r12 18 41 7.34548 $w=1.3e-08 $l=3.15e-08 $layer=M1 $thickness=3.6e-08 $X=1.242
+ $Y=0.171 $X2=1.2735 $Y2=0.171
r13 38 39 3.14806 $w=1.3e-08 $l=1.35e-08 $layer=M1 $thickness=3.6e-08 $X=1.188
+ $Y=0.171 $X2=1.2015 $Y2=0.171
r14 15 38 3.61444 $w=1.3e-08 $l=1.55e-08 $layer=M1 $thickness=3.6e-08 $X=1.1725
+ $Y=0.171 $X2=1.188 $Y2=0.171
r15 14 17 3.01711 $w=1.55e-08 $l=1.8e-08 $layer=M1 $thickness=3.6e-08 $X=1.215
+ $Y=0.171 $X2=1.215 $Y2=0.153
r16 14 39 1.96775 $w=1.63333e-08 $l=1.35e-08 $layer=M1 $thickness=3.6e-08
+ $X=1.215 $Y=0.171 $X2=1.2015 $Y2=0.171
r17 14 18 5.11582 $w=1.46667e-08 $l=2.7e-08 $layer=M1 $thickness=3.6e-08
+ $X=1.215 $Y=0.171 $X2=1.242 $Y2=0.171
r18 13 31 1.49895 $w=1.63333e-08 $l=1.35e-08 $layer=M1 $thickness=3.6e-08
+ $X=1.215 $Y=0.135 $X2=1.2015 $Y2=0.135
r19 13 17 2.5483 $w=1.79e-08 $l=1.8e-08 $layer=M1 $thickness=3.6e-08 $X=1.215
+ $Y=0.135 $X2=1.215 $Y2=0.153
r20 36 35 16.4967 $w=2.1e-08 $l=4.85e-08 $layer=Gate_1 $thickness=5.6e-08
+ $X=1.215 $Y=0.2025 $X2=1.215 $Y2=0.154
r21 33 34 16.4967 $w=2.1e-08 $l=4.85e-08 $layer=Gate_1 $thickness=5.6e-08
+ $X=1.215 $Y=0.0675 $X2=1.215 $Y2=0.116
r22 10 27 6.54019 $w=2.09524e-08 $layer=Gate_1 $thickness=5.21905e-08 $X=1.215
+ $Y=0.135 $X2=1.215 $Y2=0.135
r23 10 34 6.6497 $w=2.04211e-08 $l=1.9e-08 $layer=Gate_1 $thickness=5.6e-08
+ $X=1.215 $Y=0.135 $X2=1.215 $Y2=0.116
r24 10 35 6.6497 $w=2.04211e-08 $l=1.9e-08 $layer=Gate_1 $thickness=5.6e-08
+ $X=1.215 $Y=0.135 $X2=1.215 $Y2=0.154
r25 30 31 3.14806 $w=1.3e-08 $l=1.35e-08 $layer=M1 $thickness=3.6e-08 $X=1.188
+ $Y=0.135 $X2=1.2015 $Y2=0.135
r26 29 30 2.68168 $w=1.3e-08 $l=1.15e-08 $layer=M1 $thickness=3.6e-08 $X=1.1765
+ $Y=0.135 $X2=1.188 $Y2=0.135
r27 16 29 1.51573 $w=1.3e-08 $l=6.5e-09 $layer=M1 $thickness=3.6e-08 $X=1.17
+ $Y=0.135 $X2=1.1765 $Y2=0.135
r28 26 27 12.6539 $w=1.77815e-08 $l=2.7e-08 $layer=LIG $thickness=4.8e-08
+ $X=1.188 $Y=0.135 $X2=1.215 $Y2=0.135
r29 26 30 19.3796 $a=3.24e-16 $layer=V0LIG $X=1.188 $Y=0.135 $X2=1.188 $Y2=0.135
r30 1 21 6.54019 $w=2.09524e-08 $layer=Gate_1 $thickness=5.21905e-08 $X=1.161
+ $Y=0.135 $X2=1.161 $Y2=0.135
r31 1 26 12.6539 $w=1.77815e-08 $l=2.7e-08 $layer=LIG $thickness=4.8e-08
+ $X=1.161 $Y=0.135 $X2=1.188 $Y2=0.135
r32 23 22 16.4967 $w=2.1e-08 $l=4.85e-08 $layer=Gate_1 $thickness=5.6e-08
+ $X=1.161 $Y=0.2025 $X2=1.161 $Y2=0.154
r33 21 22 6.6497 $w=2.04211e-08 $l=1.9e-08 $layer=Gate_1 $thickness=5.6e-08
+ $X=1.161 $Y=0.135 $X2=1.161 $Y2=0.154
r34 20 21 6.6497 $w=2.04211e-08 $l=1.9e-08 $layer=Gate_1 $thickness=5.6e-08
+ $X=1.161 $Y=0.116 $X2=1.161 $Y2=0.135
r35 19 20 16.4967 $w=2.1e-08 $l=4.85e-08 $layer=Gate_1 $thickness=5.6e-08
+ $X=1.161 $Y=0.0675 $X2=1.161 $Y2=0.116
r36 19 9 14.6259 $w=2.1e-08 $l=4.3e-08 $layer=Gate_1 $thickness=5.6e-08
+ $X=1.161 $Y=0.0675 $X2=1.161 $Y2=0.0245
.ends

.subckt PM_CKINVDCx20_ASAP7_75t_R%8 vss 19 23 33 36 46 47 50 51 9 18 16 4 1 12
+ 13 10 3 15
c1 1 vss 0.006334f $X=1.593 $Y=0.135
c2 3 vss 0.00716972f $X=1.62 $Y=0.2025
c3 4 vss 0.00722437f $X=1.728 $Y=0.2025
c4 9 vss 0.0824116f $X=1.593 $Y=0.0245
c5 10 vss 0.0821971f $X=1.647 $Y=0.135
c6 11 vss 0.00679496f $X=1.6055 $Y=0.2025
c7 12 vss 0.00732063f $X=1.7135 $Y=0.2025
c8 13 vss 0.000210357f $X=1.647 $Y=0.135
c9 14 vss 0.000357205f $X=1.647 $Y=0.171
c10 15 vss 0.00132288f $X=1.6045 $Y=0.171
c11 16 vss 0.00069178f $X=1.602 $Y=0.135
c12 17 vss 0.000149615f $X=1.647 $Y=0.153
c13 18 vss 0.00259786f $X=1.674 $Y=0.171
r1 51 49 0.0308642 $w=8.1e-08 $l=2.5e-09 $layer=P_src_drn $thickness=1e-09
+ $X=1.7453 $Y=0.2025 $X2=1.7425 $Y2=0.2025
r2 4 49 0.179012 $w=8.1e-08 $l=1.45e-08 $layer=P_src_drn $thickness=1e-09
+ $X=1.728 $Y=0.2025 $X2=1.7425 $Y2=0.2025
r3 12 4 0.179012 $w=8.1e-08 $l=1.45e-08 $layer=P_src_drn $thickness=1e-09
+ $X=1.7135 $Y=0.2025 $X2=1.728 $Y2=0.2025
r4 50 12 0.0308642 $w=8.1e-08 $l=2.5e-09 $layer=P_src_drn $thickness=1e-09
+ $X=1.7106 $Y=0.2025 $X2=1.7135 $Y2=0.2025
r5 47 45 0.0308642 $w=8.1e-08 $l=2.5e-09 $layer=P_src_drn $thickness=1e-09
+ $X=1.6373 $Y=0.2025 $X2=1.6345 $Y2=0.2025
r6 3 45 0.179012 $w=8.1e-08 $l=1.45e-08 $layer=P_src_drn $thickness=1e-09
+ $X=1.62 $Y=0.2025 $X2=1.6345 $Y2=0.2025
r7 11 3 0.179012 $w=8.1e-08 $l=1.45e-08 $layer=P_src_drn $thickness=1e-09
+ $X=1.6055 $Y=0.2025 $X2=1.62 $Y2=0.2025
r8 46 11 0.0308642 $w=8.1e-08 $l=2.5e-09 $layer=P_src_drn $thickness=1e-09
+ $X=1.6026 $Y=0.2025 $X2=1.6055 $Y2=0.2025
r9 4 42 19.3796 $a=3.24e-16 $layer=V0LISD $X=1.728 $Y=0.2025 $X2=1.728 $Y2=0.171
r10 3 38 19.3796 $a=3.24e-16 $layer=V0LISD $X=1.62 $Y=0.2025 $X2=1.62 $Y2=0.171
r11 41 42 5.24677 $w=1.3e-08 $l=2.25e-08 $layer=M1 $thickness=3.6e-08 $X=1.7055
+ $Y=0.171 $X2=1.728 $Y2=0.171
r12 18 41 7.34548 $w=1.3e-08 $l=3.15e-08 $layer=M1 $thickness=3.6e-08 $X=1.674
+ $Y=0.171 $X2=1.7055 $Y2=0.171
r13 38 39 3.14806 $w=1.3e-08 $l=1.35e-08 $layer=M1 $thickness=3.6e-08 $X=1.62
+ $Y=0.171 $X2=1.6335 $Y2=0.171
r14 15 38 3.61444 $w=1.3e-08 $l=1.55e-08 $layer=M1 $thickness=3.6e-08 $X=1.6045
+ $Y=0.171 $X2=1.62 $Y2=0.171
r15 14 17 3.01711 $w=1.55e-08 $l=1.8e-08 $layer=M1 $thickness=3.6e-08 $X=1.647
+ $Y=0.171 $X2=1.647 $Y2=0.153
r16 14 39 1.96775 $w=1.63333e-08 $l=1.35e-08 $layer=M1 $thickness=3.6e-08
+ $X=1.647 $Y=0.171 $X2=1.6335 $Y2=0.171
r17 14 18 5.11582 $w=1.46667e-08 $l=2.7e-08 $layer=M1 $thickness=3.6e-08
+ $X=1.647 $Y=0.171 $X2=1.674 $Y2=0.171
r18 13 31 1.49895 $w=1.63333e-08 $l=1.35e-08 $layer=M1 $thickness=3.6e-08
+ $X=1.647 $Y=0.135 $X2=1.6335 $Y2=0.135
r19 13 17 2.5483 $w=1.79e-08 $l=1.8e-08 $layer=M1 $thickness=3.6e-08 $X=1.647
+ $Y=0.135 $X2=1.647 $Y2=0.153
r20 36 35 16.4967 $w=2.1e-08 $l=4.85e-08 $layer=Gate_1 $thickness=5.6e-08
+ $X=1.647 $Y=0.2025 $X2=1.647 $Y2=0.154
r21 33 34 16.4967 $w=2.1e-08 $l=4.85e-08 $layer=Gate_1 $thickness=5.6e-08
+ $X=1.647 $Y=0.0675 $X2=1.647 $Y2=0.116
r22 10 27 6.54019 $w=2.09524e-08 $layer=Gate_1 $thickness=5.21905e-08 $X=1.647
+ $Y=0.135 $X2=1.647 $Y2=0.135
r23 10 34 6.6497 $w=2.04211e-08 $l=1.9e-08 $layer=Gate_1 $thickness=5.6e-08
+ $X=1.647 $Y=0.135 $X2=1.647 $Y2=0.116
r24 10 35 6.6497 $w=2.04211e-08 $l=1.9e-08 $layer=Gate_1 $thickness=5.6e-08
+ $X=1.647 $Y=0.135 $X2=1.647 $Y2=0.154
r25 30 31 3.14806 $w=1.3e-08 $l=1.35e-08 $layer=M1 $thickness=3.6e-08 $X=1.62
+ $Y=0.135 $X2=1.6335 $Y2=0.135
r26 29 30 2.68168 $w=1.3e-08 $l=1.15e-08 $layer=M1 $thickness=3.6e-08 $X=1.6085
+ $Y=0.135 $X2=1.62 $Y2=0.135
r27 16 29 1.51573 $w=1.3e-08 $l=6.5e-09 $layer=M1 $thickness=3.6e-08 $X=1.602
+ $Y=0.135 $X2=1.6085 $Y2=0.135
r28 26 27 12.6539 $w=1.77815e-08 $l=2.7e-08 $layer=LIG $thickness=4.8e-08
+ $X=1.62 $Y=0.135 $X2=1.647 $Y2=0.135
r29 26 30 19.3796 $a=3.24e-16 $layer=V0LIG $X=1.62 $Y=0.135 $X2=1.62 $Y2=0.135
r30 1 21 6.54019 $w=2.09524e-08 $layer=Gate_1 $thickness=5.21905e-08 $X=1.593
+ $Y=0.135 $X2=1.593 $Y2=0.135
r31 1 26 12.6539 $w=1.77815e-08 $l=2.7e-08 $layer=LIG $thickness=4.8e-08
+ $X=1.593 $Y=0.135 $X2=1.62 $Y2=0.135
r32 23 22 16.4967 $w=2.1e-08 $l=4.85e-08 $layer=Gate_1 $thickness=5.6e-08
+ $X=1.593 $Y=0.2025 $X2=1.593 $Y2=0.154
r33 21 22 6.6497 $w=2.04211e-08 $l=1.9e-08 $layer=Gate_1 $thickness=5.6e-08
+ $X=1.593 $Y=0.135 $X2=1.593 $Y2=0.154
r34 20 21 6.6497 $w=2.04211e-08 $l=1.9e-08 $layer=Gate_1 $thickness=5.6e-08
+ $X=1.593 $Y=0.116 $X2=1.593 $Y2=0.135
r35 19 20 16.4967 $w=2.1e-08 $l=4.85e-08 $layer=Gate_1 $thickness=5.6e-08
+ $X=1.593 $Y=0.0675 $X2=1.593 $Y2=0.116
r36 19 9 14.6259 $w=2.1e-08 $l=4.3e-08 $layer=Gate_1 $thickness=5.6e-08
+ $X=1.593 $Y=0.0675 $X2=1.593 $Y2=0.0245
.ends

.subckt PM_CKINVDCx20_ASAP7_75t_R%A vss 107 61 67 83 86 94 97 100 103 156 159
+ 162 165 168 171 174 177 211 214 217 220 223 226 229 232 253 256 259 262 265
+ 268 271 274 296 299 302 305 308 311 315 319 36 19 46 1 47 48 49 2 20 51 23 50
+ 52 53 3 24 55 54 4 27 56 28 58 57 5 31 59 32 35 43 60 42 44 38 40 39 41 17 21
+ 30 37 45 18 22 25 26 29 33 16 34
c1 1 vss 0.0286045f $X=0.081 $Y=0.135
c2 2 vss 0.027798f $X=0.535 $Y=0.135
c3 3 vss 0.0267869f $X=0.9675 $Y=0.135
c4 4 vss 0.0279797f $X=1.3995 $Y=0.135
c5 5 vss 0.028492f $X=1.8315 $Y=0.135
c6 16 vss 0.0848248f $X=0.081 $Y=0.0245
c7 17 vss 0.0847527f $X=0.135 $Y=0.135
c8 18 vss 0.0847323f $X=0.189 $Y=0.135
c9 19 vss 0.0846899f $X=0.243 $Y=0.135
c10 20 vss 0.0846899f $X=0.513 $Y=0.135
c11 21 vss 0.0850127f $X=0.567 $Y=0.135
c12 22 vss 0.0850064f $X=0.621 $Y=0.135
c13 23 vss 0.0846899f $X=0.675 $Y=0.135
c14 24 vss 0.0846899f $X=0.945 $Y=0.135
c15 25 vss 0.0850064f $X=0.999 $Y=0.135
c16 26 vss 0.0850064f $X=1.053 $Y=0.135
c17 27 vss 0.0846899f $X=1.107 $Y=0.135
c18 28 vss 0.0846899f $X=1.377 $Y=0.135
c19 29 vss 0.0850125f $X=1.431 $Y=0.135
c20 30 vss 0.0850067f $X=1.485 $Y=0.135
c21 31 vss 0.0846899f $X=1.539 $Y=0.135
c22 32 vss 0.0846899f $X=1.809 $Y=0.135
c23 33 vss 0.0847121f $X=1.863 $Y=0.135
c24 34 vss 0.0847616f $X=1.917 $Y=0.135
c25 35 vss 0.0848266f $X=1.971 $Y=0.135
c26 36 vss 0.00558583f $X=0.135 $Y=0.135
c27 37 vss 0.00745321f $X=0.167 $Y=0.036
c28 38 vss 0.00660776f $X=0.593 $Y=0.036
c29 39 vss 0.00454388f $X=0.593 $Y=0.135
c30 40 vss 0.00660827f $X=1.026 $Y=0.036
c31 41 vss 0.00453912f $X=1.026 $Y=0.135
c32 42 vss 0.00513768f $X=1.453 $Y=0.135
c33 43 vss 0.00659713f $X=1.453 $Y=0.036
c34 44 vss 0.00513768f $X=1.885 $Y=0.135
c35 45 vss 0.00745321f $X=1.885 $Y=0.036
c36 46 vss 0.00687873f $X=0.167 $Y=0.1035
c37 47 vss 0.0411224f $X=0.189 $Y=0.036
c38 48 vss 0.00486463f $X=0.5595 $Y=0.135
c39 49 vss 0.00649992f $X=0.593 $Y=0.054
c40 50 vss 0.0428164f $X=0.618 $Y=0.036
c41 51 vss 0.00501315f $X=0.6115 $Y=0.135
c42 52 vss 0.0050284f $X=0.992 $Y=0.135
c43 53 vss 0.00635986f $X=1.026 $Y=0.054
c44 54 vss 0.0412133f $X=1.0505 $Y=0.036
c45 55 vss 0.0050284f $X=1.0445 $Y=0.135
c46 56 vss 0.00637918f $X=1.453 $Y=0.054
c47 57 vss 0.0429496f $X=1.48 $Y=0.036
c48 58 vss 0.0051486f $X=1.4745 $Y=0.135
c49 59 vss 0.00637918f $X=1.885 $Y=0.054
c50 60 vss 0.00505046f $X=1.9065 $Y=0.135
r1 319 318 14.6259 $w=2.1e-08 $l=4.3e-08 $layer=Gate_1 $thickness=5.6e-08
+ $X=1.971 $Y=0.2025 $X2=1.971 $Y2=0.1595
r2 317 318 2.89117 $w=2.1e-08 $l=8.5e-09 $layer=Gate_1 $thickness=5.6e-08
+ $X=1.971 $Y=0.151 $X2=1.971 $Y2=0.1595
r3 315 316 14.6259 $w=2.1e-08 $l=4.3e-08 $layer=Gate_1 $thickness=5.6e-08
+ $X=1.971 $Y=0.0675 $X2=1.971 $Y2=0.1105
r4 313 316 2.89117 $w=2.1e-08 $l=8.5e-09 $layer=Gate_1 $thickness=5.6e-08
+ $X=1.971 $Y=0.119 $X2=1.971 $Y2=0.1105
r5 35 293 6.74717 $w=2e-08 $layer=Gate_1 $thickness=5.2e-08 $X=1.971 $Y=0.135
+ $X2=1.971 $Y2=0.135
r6 35 313 5.61228 $w=2.0375e-08 $l=1.6e-08 $layer=Gate_1 $thickness=5.6e-08
+ $X=1.971 $Y=0.135 $X2=1.971 $Y2=0.119
r7 35 317 5.61228 $w=2.0375e-08 $l=1.6e-08 $layer=Gate_1 $thickness=5.6e-08
+ $X=1.971 $Y=0.135 $X2=1.971 $Y2=0.151
r8 311 310 16.6668 $w=2.1e-08 $l=4.9e-08 $layer=Gate_1 $thickness=5.6e-08
+ $X=1.917 $Y=0.2025 $X2=1.917 $Y2=0.1535
r9 308 309 16.6668 $w=2.1e-08 $l=4.9e-08 $layer=Gate_1 $thickness=5.6e-08
+ $X=1.917 $Y=0.0675 $X2=1.917 $Y2=0.1165
r10 34 290 3.57145 $w=2e-08 $layer=Gate_1 $thickness=5.6e-08 $X=1.917 $Y=0.135
+ $X2=1.917 $Y2=0.135
r11 34 309 6.46262 $w=2.04595e-08 $l=1.85e-08 $layer=Gate_1 $thickness=5.6e-08
+ $X=1.917 $Y=0.135 $X2=1.917 $Y2=0.1165
r12 34 310 6.46262 $w=2.04595e-08 $l=1.85e-08 $layer=Gate_1 $thickness=5.6e-08
+ $X=1.917 $Y=0.135 $X2=1.917 $Y2=0.1535
r13 305 304 16.6668 $w=2.1e-08 $l=4.9e-08 $layer=Gate_1 $thickness=5.6e-08
+ $X=1.863 $Y=0.2025 $X2=1.863 $Y2=0.1535
r14 302 303 16.6668 $w=2.1e-08 $l=4.9e-08 $layer=Gate_1 $thickness=5.6e-08
+ $X=1.863 $Y=0.0675 $X2=1.863 $Y2=0.1165
r15 33 286 3.57145 $w=2e-08 $layer=Gate_1 $thickness=5.6e-08 $X=1.863 $Y=0.135
+ $X2=1.863 $Y2=0.135
r16 33 303 6.46262 $w=2.04595e-08 $l=1.85e-08 $layer=Gate_1 $thickness=5.6e-08
+ $X=1.863 $Y=0.135 $X2=1.863 $Y2=0.1165
r17 33 304 6.46262 $w=2.04595e-08 $l=1.85e-08 $layer=Gate_1 $thickness=5.6e-08
+ $X=1.863 $Y=0.135 $X2=1.863 $Y2=0.1535
r18 299 298 16.6668 $w=2.1e-08 $l=4.9e-08 $layer=Gate_1 $thickness=5.6e-08
+ $X=1.809 $Y=0.2025 $X2=1.809 $Y2=0.1535
r19 296 297 16.6668 $w=2.1e-08 $l=4.9e-08 $layer=Gate_1 $thickness=5.6e-08
+ $X=1.809 $Y=0.0675 $X2=1.809 $Y2=0.1165
r20 32 282 6.74717 $w=2e-08 $layer=Gate_1 $thickness=5.2e-08 $X=1.809 $Y=0.135
+ $X2=1.809 $Y2=0.135
r21 32 297 6.46262 $w=2.04595e-08 $l=1.85e-08 $layer=Gate_1 $thickness=5.6e-08
+ $X=1.809 $Y=0.135 $X2=1.809 $Y2=0.1165
r22 32 298 6.46262 $w=2.04595e-08 $l=1.85e-08 $layer=Gate_1 $thickness=5.6e-08
+ $X=1.809 $Y=0.135 $X2=1.809 $Y2=0.1535
r23 292 293 15.1321 $w=1.63455e-08 $l=2.2e-08 $layer=LIG $thickness=4.8e-08
+ $X=1.949 $Y=0.135 $X2=1.971 $Y2=0.135
r24 291 292 16.9382 $w=1.33e-08 $l=1.7e-08 $layer=LIG $thickness=4.8e-08
+ $X=1.932 $Y=0.135 $X2=1.949 $Y2=0.135
r25 289 291 6.25213 $w=1.62778e-08 $l=9e-09 $layer=LIG $thickness=4.8e-08
+ $X=1.923 $Y=0.135 $X2=1.932 $Y2=0.135
r26 288 289 3.17572 $w=2e-08 $l=1e-08 $layer=LIG $thickness=4.8e-08 $X=1.913
+ $Y=0.135 $X2=1.923 $Y2=0.135
r27 288 290 1.90543 $w=2e-08 $l=4e-09 $layer=LIG $thickness=4.8e-08 $X=1.913
+ $Y=0.135 $X2=1.917 $Y2=0.135
r28 287 288 18.8437 $w=1.50478e-08 $l=2.3e-08 $layer=LIG $thickness=4.8e-08
+ $X=1.89 $Y=0.135 $X2=1.913 $Y2=0.135
r29 285 286 1.74665 $w=2e-08 $l=4.5e-09 $layer=LIG $thickness=4.8e-08 $X=1.8675
+ $Y=0.135 $X2=1.863 $Y2=0.135
r30 285 287 18.6849 $w=1.49378e-08 $l=2.25e-08 $layer=LIG $thickness=4.8e-08
+ $X=1.8675 $Y=0.135 $X2=1.89 $Y2=0.135
r31 284 285 3.17572 $w=2e-08 $l=1e-08 $layer=LIG $thickness=4.8e-08 $X=1.8575
+ $Y=0.135 $X2=1.8675 $Y2=0.135
r32 281 284 5.91273 $w=1.665e-08 $l=9e-09 $layer=LIG $thickness=4.8e-08
+ $X=1.8485 $Y=0.135 $X2=1.8575 $Y2=0.135
r33 5 281 16.9382 $w=1.33e-08 $l=1.7e-08 $layer=LIG $thickness=4.8e-08
+ $X=1.8315 $Y=0.135 $X2=1.8485 $Y2=0.135
r34 5 282 15.6303 $w=1.62778e-08 $l=2.25e-08 $layer=LIG $thickness=4.8e-08
+ $X=1.8315 $Y=0.135 $X2=1.809 $Y2=0.135
r35 279 291 19.3796 $a=3.24e-16 $layer=V0LIG $X=1.9245 $Y=0.135 $X2=1.932
+ $Y2=0.135
r36 60 279 4.19742 $w=1.3e-08 $l=1.8e-08 $layer=M1 $thickness=3.6e-08 $X=1.9065
+ $Y=0.135 $X2=1.9245 $Y2=0.135
r37 276 277 3.03147 $w=1.3e-08 $l=1.3e-08 $layer=M1 $thickness=3.6e-08 $X=1.856
+ $Y=0.135 $X2=1.869 $Y2=0.135
r38 276 281 19.3796 $a=3.24e-16 $layer=V0LIG $X=1.856 $Y=0.135 $X2=1.8485
+ $Y2=0.135
r39 44 251 6.16517 $w=1.44286e-08 $l=3.15e-08 $layer=M1 $thickness=3.6e-08
+ $X=1.885 $Y=0.135 $X2=1.885 $Y2=0.1035
r40 44 277 2.55073 $w=1.58125e-08 $l=1.6e-08 $layer=M1 $thickness=3.6e-08
+ $X=1.885 $Y=0.135 $X2=1.869 $Y2=0.135
r41 44 60 3.83327 $w=1.5093e-08 $l=2.15e-08 $layer=M1 $thickness=3.6e-08
+ $X=1.885 $Y=0.135 $X2=1.9065 $Y2=0.135
r42 274 273 16.6668 $w=2.1e-08 $l=4.9e-08 $layer=Gate_1 $thickness=5.6e-08
+ $X=1.539 $Y=0.2025 $X2=1.539 $Y2=0.1535
r43 271 272 16.6668 $w=2.1e-08 $l=4.9e-08 $layer=Gate_1 $thickness=5.6e-08
+ $X=1.539 $Y=0.0675 $X2=1.539 $Y2=0.1165
r44 31 248 6.74717 $w=2e-08 $layer=Gate_1 $thickness=5.2e-08 $X=1.539 $Y=0.135
+ $X2=1.539 $Y2=0.135
r45 31 272 6.46262 $w=2.04595e-08 $l=1.85e-08 $layer=Gate_1 $thickness=5.6e-08
+ $X=1.539 $Y=0.135 $X2=1.539 $Y2=0.1165
r46 31 273 6.46262 $w=2.04595e-08 $l=1.85e-08 $layer=Gate_1 $thickness=5.6e-08
+ $X=1.539 $Y=0.135 $X2=1.539 $Y2=0.1535
r47 268 267 16.6668 $w=2.1e-08 $l=4.9e-08 $layer=Gate_1 $thickness=5.6e-08
+ $X=1.485 $Y=0.2025 $X2=1.485 $Y2=0.1535
r48 265 266 16.6668 $w=2.1e-08 $l=4.9e-08 $layer=Gate_1 $thickness=5.6e-08
+ $X=1.485 $Y=0.0675 $X2=1.485 $Y2=0.1165
r49 30 245 3.57145 $w=2e-08 $layer=Gate_1 $thickness=5.6e-08 $X=1.485 $Y=0.135
+ $X2=1.485 $Y2=0.135
r50 30 266 6.46262 $w=2.04595e-08 $l=1.85e-08 $layer=Gate_1 $thickness=5.6e-08
+ $X=1.485 $Y=0.135 $X2=1.485 $Y2=0.1165
r51 30 267 6.46262 $w=2.04595e-08 $l=1.85e-08 $layer=Gate_1 $thickness=5.6e-08
+ $X=1.485 $Y=0.135 $X2=1.485 $Y2=0.1535
r52 262 261 16.6668 $w=2.1e-08 $l=4.9e-08 $layer=Gate_1 $thickness=5.6e-08
+ $X=1.431 $Y=0.2025 $X2=1.431 $Y2=0.1535
r53 259 260 16.6668 $w=2.1e-08 $l=4.9e-08 $layer=Gate_1 $thickness=5.6e-08
+ $X=1.431 $Y=0.0675 $X2=1.431 $Y2=0.1165
r54 29 241 3.57145 $w=2e-08 $layer=Gate_1 $thickness=5.6e-08 $X=1.431 $Y=0.135
+ $X2=1.431 $Y2=0.135
r55 29 260 6.46262 $w=2.04595e-08 $l=1.85e-08 $layer=Gate_1 $thickness=5.6e-08
+ $X=1.431 $Y=0.135 $X2=1.431 $Y2=0.1165
r56 29 261 6.46262 $w=2.04595e-08 $l=1.85e-08 $layer=Gate_1 $thickness=5.6e-08
+ $X=1.431 $Y=0.135 $X2=1.431 $Y2=0.1535
r57 256 255 16.6668 $w=2.1e-08 $l=4.9e-08 $layer=Gate_1 $thickness=5.6e-08
+ $X=1.377 $Y=0.2025 $X2=1.377 $Y2=0.1535
r58 253 254 16.6668 $w=2.1e-08 $l=4.9e-08 $layer=Gate_1 $thickness=5.6e-08
+ $X=1.377 $Y=0.0675 $X2=1.377 $Y2=0.1165
r59 28 237 6.74717 $w=2e-08 $layer=Gate_1 $thickness=5.2e-08 $X=1.377 $Y=0.135
+ $X2=1.377 $Y2=0.135
r60 28 254 6.46262 $w=2.04595e-08 $l=1.85e-08 $layer=Gate_1 $thickness=5.6e-08
+ $X=1.377 $Y=0.135 $X2=1.377 $Y2=0.1165
r61 28 255 6.46262 $w=2.04595e-08 $l=1.85e-08 $layer=Gate_1 $thickness=5.6e-08
+ $X=1.377 $Y=0.135 $X2=1.377 $Y2=0.1535
r62 250 251 7.34548 $w=1.3e-08 $l=3.15e-08 $layer=M1 $thickness=3.6e-08
+ $X=1.885 $Y=0.072 $X2=1.885 $Y2=0.1035
r63 59 250 4.19742 $w=1.3e-08 $l=1.8e-08 $layer=M1 $thickness=3.6e-08 $X=1.885
+ $Y=0.054 $X2=1.885 $Y2=0.072
r64 247 248 15.1321 $w=1.63455e-08 $l=2.2e-08 $layer=LIG $thickness=4.8e-08
+ $X=1.517 $Y=0.135 $X2=1.539 $Y2=0.135
r65 246 247 16.9382 $w=1.33e-08 $l=1.7e-08 $layer=LIG $thickness=4.8e-08 $X=1.5
+ $Y=0.135 $X2=1.517 $Y2=0.135
r66 244 246 6.25213 $w=1.62778e-08 $l=9e-09 $layer=LIG $thickness=4.8e-08
+ $X=1.491 $Y=0.135 $X2=1.5 $Y2=0.135
r67 243 244 3.17572 $w=2e-08 $l=1e-08 $layer=LIG $thickness=4.8e-08 $X=1.481
+ $Y=0.135 $X2=1.491 $Y2=0.135
r68 243 245 1.90543 $w=2e-08 $l=4e-09 $layer=LIG $thickness=4.8e-08 $X=1.481
+ $Y=0.135 $X2=1.485 $Y2=0.135
r69 242 243 18.8437 $w=1.50478e-08 $l=2.3e-08 $layer=LIG $thickness=4.8e-08
+ $X=1.458 $Y=0.135 $X2=1.481 $Y2=0.135
r70 240 241 1.74665 $w=2e-08 $l=4.5e-09 $layer=LIG $thickness=4.8e-08 $X=1.4355
+ $Y=0.135 $X2=1.431 $Y2=0.135
r71 240 242 18.6849 $w=1.49378e-08 $l=2.25e-08 $layer=LIG $thickness=4.8e-08
+ $X=1.4355 $Y=0.135 $X2=1.458 $Y2=0.135
r72 239 240 3.17572 $w=2e-08 $l=1e-08 $layer=LIG $thickness=4.8e-08 $X=1.4255
+ $Y=0.135 $X2=1.4355 $Y2=0.135
r73 236 239 5.91273 $w=1.665e-08 $l=9e-09 $layer=LIG $thickness=4.8e-08
+ $X=1.4165 $Y=0.135 $X2=1.4255 $Y2=0.135
r74 4 236 16.9382 $w=1.33e-08 $l=1.7e-08 $layer=LIG $thickness=4.8e-08
+ $X=1.3995 $Y=0.135 $X2=1.4165 $Y2=0.135
r75 4 237 15.6303 $w=1.62778e-08 $l=2.25e-08 $layer=LIG $thickness=4.8e-08
+ $X=1.3995 $Y=0.135 $X2=1.377 $Y2=0.135
r76 234 246 19.3796 $a=3.24e-16 $layer=V0LIG $X=1.4925 $Y=0.135 $X2=1.5
+ $Y2=0.135
r77 58 234 4.19742 $w=1.3e-08 $l=1.8e-08 $layer=M1 $thickness=3.6e-08 $X=1.4745
+ $Y=0.135 $X2=1.4925 $Y2=0.135
r78 232 231 16.6668 $w=2.1e-08 $l=4.9e-08 $layer=Gate_1 $thickness=5.6e-08
+ $X=1.107 $Y=0.2025 $X2=1.107 $Y2=0.1535
r79 229 230 16.6668 $w=2.1e-08 $l=4.9e-08 $layer=Gate_1 $thickness=5.6e-08
+ $X=1.107 $Y=0.0675 $X2=1.107 $Y2=0.1165
r80 27 205 6.74717 $w=2e-08 $layer=Gate_1 $thickness=5.2e-08 $X=1.107 $Y=0.135
+ $X2=1.107 $Y2=0.135
r81 27 230 6.46262 $w=2.04595e-08 $l=1.85e-08 $layer=Gate_1 $thickness=5.6e-08
+ $X=1.107 $Y=0.135 $X2=1.107 $Y2=0.1165
r82 27 231 6.46262 $w=2.04595e-08 $l=1.85e-08 $layer=Gate_1 $thickness=5.6e-08
+ $X=1.107 $Y=0.135 $X2=1.107 $Y2=0.1535
r83 226 225 16.6668 $w=2.1e-08 $l=4.9e-08 $layer=Gate_1 $thickness=5.6e-08
+ $X=1.053 $Y=0.2025 $X2=1.053 $Y2=0.1535
r84 223 224 16.6668 $w=2.1e-08 $l=4.9e-08 $layer=Gate_1 $thickness=5.6e-08
+ $X=1.053 $Y=0.0675 $X2=1.053 $Y2=0.1165
r85 26 202 3.57145 $w=2e-08 $layer=Gate_1 $thickness=5.6e-08 $X=1.053 $Y=0.135
+ $X2=1.053 $Y2=0.135
r86 26 224 6.46262 $w=2.04595e-08 $l=1.85e-08 $layer=Gate_1 $thickness=5.6e-08
+ $X=1.053 $Y=0.135 $X2=1.053 $Y2=0.1165
r87 26 225 6.46262 $w=2.04595e-08 $l=1.85e-08 $layer=Gate_1 $thickness=5.6e-08
+ $X=1.053 $Y=0.135 $X2=1.053 $Y2=0.1535
r88 220 219 16.6668 $w=2.1e-08 $l=4.9e-08 $layer=Gate_1 $thickness=5.6e-08
+ $X=0.999 $Y=0.2025 $X2=0.999 $Y2=0.1535
r89 217 218 16.6668 $w=2.1e-08 $l=4.9e-08 $layer=Gate_1 $thickness=5.6e-08
+ $X=0.999 $Y=0.0675 $X2=0.999 $Y2=0.1165
r90 25 198 3.57145 $w=2e-08 $layer=Gate_1 $thickness=5.6e-08 $X=0.999 $Y=0.135
+ $X2=0.999 $Y2=0.135
r91 25 218 6.46262 $w=2.04595e-08 $l=1.85e-08 $layer=Gate_1 $thickness=5.6e-08
+ $X=0.999 $Y=0.135 $X2=0.999 $Y2=0.1165
r92 25 219 6.46262 $w=2.04595e-08 $l=1.85e-08 $layer=Gate_1 $thickness=5.6e-08
+ $X=0.999 $Y=0.135 $X2=0.999 $Y2=0.1535
r93 214 213 16.6668 $w=2.1e-08 $l=4.9e-08 $layer=Gate_1 $thickness=5.6e-08
+ $X=0.945 $Y=0.2025 $X2=0.945 $Y2=0.1535
r94 211 212 16.6668 $w=2.1e-08 $l=4.9e-08 $layer=Gate_1 $thickness=5.6e-08
+ $X=0.945 $Y=0.0675 $X2=0.945 $Y2=0.1165
r95 24 194 6.74717 $w=2e-08 $layer=Gate_1 $thickness=5.2e-08 $X=0.945 $Y=0.135
+ $X2=0.945 $Y2=0.135
r96 24 212 6.46262 $w=2.04595e-08 $l=1.85e-08 $layer=Gate_1 $thickness=5.6e-08
+ $X=0.945 $Y=0.135 $X2=0.945 $Y2=0.1165
r97 24 213 6.46262 $w=2.04595e-08 $l=1.85e-08 $layer=Gate_1 $thickness=5.6e-08
+ $X=0.945 $Y=0.135 $X2=0.945 $Y2=0.1535
r98 45 192 3.48106 $w=1.50455e-08 $l=2.2e-08 $layer=M1 $thickness=3.6e-08
+ $X=1.885 $Y=0.036 $X2=1.863 $Y2=0.036
r99 45 59 2.5483 $w=1.79e-08 $l=1.8e-08 $layer=M1 $thickness=3.6e-08 $X=1.885
+ $Y=0.036 $X2=1.885 $Y2=0.054
r100 207 208 3.03147 $w=1.3e-08 $l=1.3e-08 $layer=M1 $thickness=3.6e-08
+ $X=1.424 $Y=0.135 $X2=1.437 $Y2=0.135
r101 207 236 19.3796 $a=3.24e-16 $layer=V0LIG $X=1.424 $Y=0.135 $X2=1.4165
+ $Y2=0.135
r102 42 184 6.16517 $w=1.44286e-08 $l=3.15e-08 $layer=M1 $thickness=3.6e-08
+ $X=1.453 $Y=0.135 $X2=1.453 $Y2=0.1035
r103 42 208 2.55073 $w=1.58125e-08 $l=1.6e-08 $layer=M1 $thickness=3.6e-08
+ $X=1.453 $Y=0.135 $X2=1.437 $Y2=0.135
r104 42 58 3.83327 $w=1.5093e-08 $l=2.15e-08 $layer=M1 $thickness=3.6e-08
+ $X=1.453 $Y=0.135 $X2=1.4745 $Y2=0.135
r105 204 205 15.6303 $w=1.62778e-08 $l=2.25e-08 $layer=LIG $thickness=4.8e-08
+ $X=1.0845 $Y=0.135 $X2=1.107 $Y2=0.135
r106 203 204 16.9382 $w=1.33e-08 $l=1.7e-08 $layer=LIG $thickness=4.8e-08
+ $X=1.0675 $Y=0.135 $X2=1.0845 $Y2=0.135
r107 201 203 5.91273 $w=1.665e-08 $l=9e-09 $layer=LIG $thickness=4.8e-08
+ $X=1.0585 $Y=0.135 $X2=1.0675 $Y2=0.135
r108 200 201 3.17572 $w=2e-08 $l=1e-08 $layer=LIG $thickness=4.8e-08 $X=1.0485
+ $Y=0.135 $X2=1.0585 $Y2=0.135
r109 200 202 1.74665 $w=2e-08 $l=4.5e-09 $layer=LIG $thickness=4.8e-08
+ $X=1.0485 $Y=0.135 $X2=1.053 $Y2=0.135
r110 199 200 18.6849 $w=1.49378e-08 $l=2.25e-08 $layer=LIG $thickness=4.8e-08
+ $X=1.026 $Y=0.135 $X2=1.0485 $Y2=0.135
r111 197 198 1.74665 $w=2e-08 $l=4.5e-09 $layer=LIG $thickness=4.8e-08
+ $X=1.0035 $Y=0.135 $X2=0.999 $Y2=0.135
r112 197 199 18.6849 $w=1.49378e-08 $l=2.25e-08 $layer=LIG $thickness=4.8e-08
+ $X=1.0035 $Y=0.135 $X2=1.026 $Y2=0.135
r113 196 197 3.17572 $w=2e-08 $l=1e-08 $layer=LIG $thickness=4.8e-08 $X=0.9935
+ $Y=0.135 $X2=1.0035 $Y2=0.135
r114 193 196 5.91273 $w=1.665e-08 $l=9e-09 $layer=LIG $thickness=4.8e-08
+ $X=0.9845 $Y=0.135 $X2=0.9935 $Y2=0.135
r115 3 193 16.9382 $w=1.33e-08 $l=1.7e-08 $layer=LIG $thickness=4.8e-08
+ $X=0.9675 $Y=0.135 $X2=0.9845 $Y2=0.135
r116 3 194 15.6303 $w=1.62778e-08 $l=2.25e-08 $layer=LIG $thickness=4.8e-08
+ $X=0.9675 $Y=0.135 $X2=0.945 $Y2=0.135
r117 191 192 8.86121 $w=1.3e-08 $l=3.8e-08 $layer=M1 $thickness=3.6e-08
+ $X=1.825 $Y=0.036 $X2=1.863 $Y2=0.036
r118 190 191 10.7267 $w=1.3e-08 $l=4.6e-08 $layer=M1 $thickness=3.6e-08
+ $X=1.779 $Y=0.036 $X2=1.825 $Y2=0.036
r119 189 190 22.6194 $w=1.3e-08 $l=9.7e-08 $layer=M1 $thickness=3.6e-08
+ $X=1.682 $Y=0.036 $X2=1.779 $Y2=0.036
r120 188 189 18.6552 $w=1.3e-08 $l=8e-08 $layer=M1 $thickness=3.6e-08 $X=1.602
+ $Y=0.036 $X2=1.682 $Y2=0.036
r121 187 188 2.2153 $w=1.3e-08 $l=9.5e-09 $layer=M1 $thickness=3.6e-08
+ $X=1.5925 $Y=0.036 $X2=1.602 $Y2=0.036
r122 186 187 5.82974 $w=1.3e-08 $l=2.5e-08 $layer=M1 $thickness=3.6e-08
+ $X=1.5675 $Y=0.036 $X2=1.5925 $Y2=0.036
r123 185 186 10.3769 $w=1.3e-08 $l=4.45e-08 $layer=M1 $thickness=3.6e-08
+ $X=1.523 $Y=0.036 $X2=1.5675 $Y2=0.036
r124 57 185 10.0272 $w=1.3e-08 $l=4.3e-08 $layer=M1 $thickness=3.6e-08 $X=1.48
+ $Y=0.036 $X2=1.523 $Y2=0.036
r125 183 184 7.34548 $w=1.3e-08 $l=3.15e-08 $layer=M1 $thickness=3.6e-08
+ $X=1.453 $Y=0.072 $X2=1.453 $Y2=0.1035
r126 56 183 4.19742 $w=1.3e-08 $l=1.8e-08 $layer=M1 $thickness=3.6e-08 $X=1.453
+ $Y=0.054 $X2=1.453 $Y2=0.072
r127 181 201 19.3796 $a=3.24e-16 $layer=V0LIG $X=1.06 $Y=0.135 $X2=1.0585
+ $Y2=0.135
r128 55 181 3.61444 $w=1.3e-08 $l=1.55e-08 $layer=M1 $thickness=3.6e-08
+ $X=1.0445 $Y=0.135 $X2=1.06 $Y2=0.135
r129 52 179 3.61444 $w=1.3e-08 $l=1.55e-08 $layer=M1 $thickness=3.6e-08
+ $X=0.992 $Y=0.135 $X2=1.0075 $Y2=0.135
r130 52 193 19.3796 $a=3.24e-16 $layer=V0LIG $X=0.992 $Y=0.135 $X2=0.9845
+ $Y2=0.135
r131 177 176 16.6668 $w=2.1e-08 $l=4.9e-08 $layer=Gate_1 $thickness=5.6e-08
+ $X=0.675 $Y=0.2025 $X2=0.675 $Y2=0.1535
r132 174 175 16.6668 $w=2.1e-08 $l=4.9e-08 $layer=Gate_1 $thickness=5.6e-08
+ $X=0.675 $Y=0.0675 $X2=0.675 $Y2=0.1165
r133 23 153 6.74717 $w=2e-08 $layer=Gate_1 $thickness=5.2e-08 $X=0.675 $Y=0.135
+ $X2=0.675 $Y2=0.135
r134 23 175 6.46262 $w=2.04595e-08 $l=1.85e-08 $layer=Gate_1 $thickness=5.6e-08
+ $X=0.675 $Y=0.135 $X2=0.675 $Y2=0.1165
r135 23 176 6.46262 $w=2.04595e-08 $l=1.85e-08 $layer=Gate_1 $thickness=5.6e-08
+ $X=0.675 $Y=0.135 $X2=0.675 $Y2=0.1535
r136 171 170 16.6668 $w=2.1e-08 $l=4.9e-08 $layer=Gate_1 $thickness=5.6e-08
+ $X=0.621 $Y=0.2025 $X2=0.621 $Y2=0.1535
r137 168 169 16.6668 $w=2.1e-08 $l=4.9e-08 $layer=Gate_1 $thickness=5.6e-08
+ $X=0.621 $Y=0.0675 $X2=0.621 $Y2=0.1165
r138 22 150 3.57145 $w=2e-08 $layer=Gate_1 $thickness=5.6e-08 $X=0.621 $Y=0.135
+ $X2=0.621 $Y2=0.135
r139 22 169 6.46262 $w=2.04595e-08 $l=1.85e-08 $layer=Gate_1 $thickness=5.6e-08
+ $X=0.621 $Y=0.135 $X2=0.621 $Y2=0.1165
r140 22 170 6.46262 $w=2.04595e-08 $l=1.85e-08 $layer=Gate_1 $thickness=5.6e-08
+ $X=0.621 $Y=0.135 $X2=0.621 $Y2=0.1535
r141 165 164 16.6668 $w=2.1e-08 $l=4.9e-08 $layer=Gate_1 $thickness=5.6e-08
+ $X=0.567 $Y=0.2025 $X2=0.567 $Y2=0.1535
r142 162 163 16.6668 $w=2.1e-08 $l=4.9e-08 $layer=Gate_1 $thickness=5.6e-08
+ $X=0.567 $Y=0.0675 $X2=0.567 $Y2=0.1165
r143 21 146 3.57145 $w=2e-08 $layer=Gate_1 $thickness=5.6e-08 $X=0.567 $Y=0.135
+ $X2=0.567 $Y2=0.135
r144 21 163 6.46262 $w=2.04595e-08 $l=1.85e-08 $layer=Gate_1 $thickness=5.6e-08
+ $X=0.567 $Y=0.135 $X2=0.567 $Y2=0.1165
r145 21 164 6.46262 $w=2.04595e-08 $l=1.85e-08 $layer=Gate_1 $thickness=5.6e-08
+ $X=0.567 $Y=0.135 $X2=0.567 $Y2=0.1535
r146 159 158 16.6668 $w=2.1e-08 $l=4.9e-08 $layer=Gate_1 $thickness=5.6e-08
+ $X=0.513 $Y=0.2025 $X2=0.513 $Y2=0.1535
r147 156 157 16.6668 $w=2.1e-08 $l=4.9e-08 $layer=Gate_1 $thickness=5.6e-08
+ $X=0.513 $Y=0.0675 $X2=0.513 $Y2=0.1165
r148 20 142 6.74717 $w=2e-08 $layer=Gate_1 $thickness=5.2e-08 $X=0.513 $Y=0.135
+ $X2=0.513 $Y2=0.135
r149 20 157 6.46262 $w=2.04595e-08 $l=1.85e-08 $layer=Gate_1 $thickness=5.6e-08
+ $X=0.513 $Y=0.135 $X2=0.513 $Y2=0.1165
r150 20 158 6.46262 $w=2.04595e-08 $l=1.85e-08 $layer=Gate_1 $thickness=5.6e-08
+ $X=0.513 $Y=0.135 $X2=0.513 $Y2=0.1535
r151 43 140 3.94987 $w=1.50455e-08 $l=2.2e-08 $layer=M1 $thickness=3.6e-08
+ $X=1.453 $Y=0.036 $X2=1.431 $Y2=0.036
r152 43 56 3.01711 $w=1.55e-08 $l=1.8e-08 $layer=M1 $thickness=3.6e-08 $X=1.453
+ $Y=0.036 $X2=1.453 $Y2=0.054
r153 43 57 5.11582 $w=1.46667e-08 $l=2.7e-08 $layer=M1 $thickness=3.6e-08
+ $X=1.453 $Y=0.036 $X2=1.48 $Y2=0.036
r154 41 132 6.16517 $w=1.44286e-08 $l=3.15e-08 $layer=M1 $thickness=3.6e-08
+ $X=1.026 $Y=0.135 $X2=1.026 $Y2=0.1035
r155 41 179 3.1337 $w=1.54324e-08 $l=1.85e-08 $layer=M1 $thickness=3.6e-08
+ $X=1.026 $Y=0.135 $X2=1.0075 $Y2=0.135
r156 41 55 3.1337 $w=1.54324e-08 $l=1.85e-08 $layer=M1 $thickness=3.6e-08
+ $X=1.026 $Y=0.135 $X2=1.0445 $Y2=0.135
r157 152 153 16.1285 $w=1.6213e-08 $l=2.3e-08 $layer=LIG $thickness=4.8e-08
+ $X=0.652 $Y=0.135 $X2=0.675 $Y2=0.135
r158 151 152 16.9382 $w=1.33e-08 $l=1.7e-08 $layer=LIG $thickness=4.8e-08
+ $X=0.635 $Y=0.135 $X2=0.652 $Y2=0.135
r159 149 150 1.58786 $w=2e-08 $l=5e-09 $layer=LIG $thickness=4.8e-08 $X=0.626
+ $Y=0.135 $X2=0.621 $Y2=0.135
r160 149 151 5.57333 $w=1.70222e-08 $l=9e-09 $layer=LIG $thickness=4.8e-08
+ $X=0.626 $Y=0.135 $X2=0.635 $Y2=0.135
r161 148 149 3.17572 $w=2e-08 $l=1e-08 $layer=LIG $thickness=4.8e-08 $X=0.616
+ $Y=0.135 $X2=0.626 $Y2=0.135
r162 147 148 18.5261 $w=1.48227e-08 $l=2.2e-08 $layer=LIG $thickness=4.8e-08
+ $X=0.594 $Y=0.135 $X2=0.616 $Y2=0.135
r163 145 146 1.90543 $w=2e-08 $l=4e-09 $layer=LIG $thickness=4.8e-08 $X=0.571
+ $Y=0.135 $X2=0.567 $Y2=0.135
r164 145 147 18.8437 $w=1.50478e-08 $l=2.3e-08 $layer=LIG $thickness=4.8e-08
+ $X=0.571 $Y=0.135 $X2=0.594 $Y2=0.135
r165 144 145 3.17572 $w=2e-08 $l=1e-08 $layer=LIG $thickness=4.8e-08 $X=0.561
+ $Y=0.135 $X2=0.571 $Y2=0.135
r166 141 144 6.25213 $w=1.62778e-08 $l=9e-09 $layer=LIG $thickness=4.8e-08
+ $X=0.552 $Y=0.135 $X2=0.561 $Y2=0.135
r167 2 141 16.9382 $w=1.33e-08 $l=1.7e-08 $layer=LIG $thickness=4.8e-08
+ $X=0.535 $Y=0.135 $X2=0.552 $Y2=0.135
r168 2 142 15.1321 $w=1.63455e-08 $l=2.2e-08 $layer=LIG $thickness=4.8e-08
+ $X=0.535 $Y=0.135 $X2=0.513 $Y2=0.135
r169 139 140 8.86121 $w=1.3e-08 $l=3.8e-08 $layer=M1 $thickness=3.6e-08
+ $X=1.393 $Y=0.036 $X2=1.431 $Y2=0.036
r170 138 139 10.7267 $w=1.3e-08 $l=4.6e-08 $layer=M1 $thickness=3.6e-08
+ $X=1.347 $Y=0.036 $X2=1.393 $Y2=0.036
r171 137 138 22.6194 $w=1.3e-08 $l=9.7e-08 $layer=M1 $thickness=3.6e-08 $X=1.25
+ $Y=0.036 $X2=1.347 $Y2=0.036
r172 136 137 18.6552 $w=1.3e-08 $l=8e-08 $layer=M1 $thickness=3.6e-08 $X=1.17
+ $Y=0.036 $X2=1.25 $Y2=0.036
r173 135 136 2.2153 $w=1.3e-08 $l=9.5e-09 $layer=M1 $thickness=3.6e-08
+ $X=1.1605 $Y=0.036 $X2=1.17 $Y2=0.036
r174 134 135 5.82974 $w=1.3e-08 $l=2.5e-08 $layer=M1 $thickness=3.6e-08
+ $X=1.1355 $Y=0.036 $X2=1.1605 $Y2=0.036
r175 133 134 10.3769 $w=1.3e-08 $l=4.45e-08 $layer=M1 $thickness=3.6e-08
+ $X=1.091 $Y=0.036 $X2=1.1355 $Y2=0.036
r176 54 133 9.44419 $w=1.3e-08 $l=4.05e-08 $layer=M1 $thickness=3.6e-08
+ $X=1.0505 $Y=0.036 $X2=1.091 $Y2=0.036
r177 131 132 7.34548 $w=1.3e-08 $l=3.15e-08 $layer=M1 $thickness=3.6e-08
+ $X=1.026 $Y=0.072 $X2=1.026 $Y2=0.1035
r178 53 131 4.19742 $w=1.3e-08 $l=1.8e-08 $layer=M1 $thickness=3.6e-08 $X=1.026
+ $Y=0.054 $X2=1.026 $Y2=0.072
r179 129 149 19.3796 $a=3.24e-16 $layer=V0LIG $X=0.6275 $Y=0.135 $X2=0.626
+ $Y2=0.135
r180 51 129 3.73104 $w=1.3e-08 $l=1.6e-08 $layer=M1 $thickness=3.6e-08
+ $X=0.6115 $Y=0.135 $X2=0.6275 $Y2=0.135
r181 48 127 3.49785 $w=1.3e-08 $l=1.5e-08 $layer=M1 $thickness=3.6e-08
+ $X=0.5595 $Y=0.135 $X2=0.5745 $Y2=0.135
r182 48 141 19.3796 $a=3.24e-16 $layer=V0LIG $X=0.5595 $Y=0.135 $X2=0.552
+ $Y2=0.135
r183 40 126 4.53284 $w=1.48367e-08 $l=2.45e-08 $layer=M1 $thickness=3.6e-08
+ $X=1.026 $Y=0.036 $X2=1.0015 $Y2=0.036
r184 40 53 3.01711 $w=1.55e-08 $l=1.8e-08 $layer=M1 $thickness=3.6e-08 $X=1.026
+ $Y=0.036 $X2=1.026 $Y2=0.054
r185 40 54 4.53284 $w=1.48367e-08 $l=2.45e-08 $layer=M1 $thickness=3.6e-08
+ $X=1.026 $Y=0.036 $X2=1.0505 $Y2=0.036
r186 39 118 6.16517 $w=1.44286e-08 $l=3.15e-08 $layer=M1 $thickness=3.6e-08
+ $X=0.593 $Y=0.135 $X2=0.593 $Y2=0.1035
r187 39 127 3.1337 $w=1.54324e-08 $l=1.85e-08 $layer=M1 $thickness=3.6e-08
+ $X=0.593 $Y=0.135 $X2=0.5745 $Y2=0.135
r188 39 51 3.1337 $w=1.54324e-08 $l=1.85e-08 $layer=M1 $thickness=3.6e-08
+ $X=0.593 $Y=0.135 $X2=0.6115 $Y2=0.135
r189 125 126 9.44419 $w=1.3e-08 $l=4.05e-08 $layer=M1 $thickness=3.6e-08
+ $X=0.961 $Y=0.036 $X2=1.0015 $Y2=0.036
r190 124 125 10.3769 $w=1.3e-08 $l=4.45e-08 $layer=M1 $thickness=3.6e-08
+ $X=0.9165 $Y=0.036 $X2=0.961 $Y2=0.036
r191 123 124 5.82974 $w=1.3e-08 $l=2.5e-08 $layer=M1 $thickness=3.6e-08
+ $X=0.8915 $Y=0.036 $X2=0.9165 $Y2=0.036
r192 122 123 2.2153 $w=1.3e-08 $l=9.5e-09 $layer=M1 $thickness=3.6e-08 $X=0.882
+ $Y=0.036 $X2=0.8915 $Y2=0.036
r193 121 122 18.6552 $w=1.3e-08 $l=8e-08 $layer=M1 $thickness=3.6e-08 $X=0.802
+ $Y=0.036 $X2=0.882 $Y2=0.036
r194 120 121 22.6194 $w=1.3e-08 $l=9.7e-08 $layer=M1 $thickness=3.6e-08
+ $X=0.705 $Y=0.036 $X2=0.802 $Y2=0.036
r195 119 120 10.7267 $w=1.3e-08 $l=4.6e-08 $layer=M1 $thickness=3.6e-08
+ $X=0.659 $Y=0.036 $X2=0.705 $Y2=0.036
r196 50 119 9.56078 $w=1.3e-08 $l=4.1e-08 $layer=M1 $thickness=3.6e-08 $X=0.618
+ $Y=0.036 $X2=0.659 $Y2=0.036
r197 117 118 7.34548 $w=1.3e-08 $l=3.15e-08 $layer=M1 $thickness=3.6e-08
+ $X=0.593 $Y=0.072 $X2=0.593 $Y2=0.1035
r198 49 117 4.19742 $w=1.3e-08 $l=1.8e-08 $layer=M1 $thickness=3.6e-08 $X=0.593
+ $Y=0.054 $X2=0.593 $Y2=0.072
r199 38 116 4.41625 $w=1.4875e-08 $l=2.4e-08 $layer=M1 $thickness=3.6e-08
+ $X=0.593 $Y=0.036 $X2=0.569 $Y2=0.036
r200 38 49 3.01711 $w=1.55e-08 $l=1.8e-08 $layer=M1 $thickness=3.6e-08 $X=0.593
+ $Y=0.036 $X2=0.593 $Y2=0.054
r201 38 50 4.64944 $w=1.48e-08 $l=2.5e-08 $layer=M1 $thickness=3.6e-08 $X=0.593
+ $Y=0.036 $X2=0.618 $Y2=0.036
r202 115 116 9.32759 $w=1.3e-08 $l=4e-08 $layer=M1 $thickness=3.6e-08 $X=0.529
+ $Y=0.036 $X2=0.569 $Y2=0.036
r203 114 115 10.3769 $w=1.3e-08 $l=4.45e-08 $layer=M1 $thickness=3.6e-08
+ $X=0.4845 $Y=0.036 $X2=0.529 $Y2=0.036
r204 113 114 5.82974 $w=1.3e-08 $l=2.5e-08 $layer=M1 $thickness=3.6e-08
+ $X=0.4595 $Y=0.036 $X2=0.4845 $Y2=0.036
r205 112 113 2.2153 $w=1.3e-08 $l=9.5e-09 $layer=M1 $thickness=3.6e-08 $X=0.45
+ $Y=0.036 $X2=0.4595 $Y2=0.036
r206 111 112 18.6552 $w=1.3e-08 $l=8e-08 $layer=M1 $thickness=3.6e-08 $X=0.37
+ $Y=0.036 $X2=0.45 $Y2=0.036
r207 110 111 22.6194 $w=1.3e-08 $l=9.7e-08 $layer=M1 $thickness=3.6e-08
+ $X=0.273 $Y=0.036 $X2=0.37 $Y2=0.036
r208 109 110 10.7267 $w=1.3e-08 $l=4.6e-08 $layer=M1 $thickness=3.6e-08
+ $X=0.227 $Y=0.036 $X2=0.273 $Y2=0.036
r209 47 109 8.86121 $w=1.3e-08 $l=3.8e-08 $layer=M1 $thickness=3.6e-08 $X=0.189
+ $Y=0.036 $X2=0.227 $Y2=0.036
r210 37 106 1.79044 $w=1.89797e-08 $l=1.47e-08 $layer=M1 $thickness=3.6e-08
+ $X=0.167 $Y=0.036 $X2=0.167 $Y2=0.0507
r211 37 47 3.48106 $w=1.50455e-08 $l=2.2e-08 $layer=M1 $thickness=3.6e-08
+ $X=0.167 $Y=0.036 $X2=0.189 $Y2=0.036
r212 107 108 0.757867 $w=1.3e-08 $l=3.2e-09 $layer=M1 $thickness=3.6e-08
+ $X=0.168 $Y=0.057 $X2=0.167 $Y2=0.0602
r213 107 106 1.45744 $w=1.3e-08 $l=6.3e-09 $layer=M1 $thickness=3.6e-08
+ $X=0.168 $Y=0.057 $X2=0.167 $Y2=0.0507
r214 105 108 2.73998 $w=1.3e-08 $l=1.18e-08 $layer=M1 $thickness=3.6e-08
+ $X=0.167 $Y=0.072 $X2=0.167 $Y2=0.0602
r215 46 89 6.16517 $w=1.44286e-08 $l=3.15e-08 $layer=M1 $thickness=3.6e-08
+ $X=0.167 $Y=0.1035 $X2=0.167 $Y2=0.135
r216 46 105 7.34548 $w=1.3e-08 $l=3.15e-08 $layer=M1 $thickness=3.6e-08
+ $X=0.167 $Y=0.1035 $X2=0.167 $Y2=0.072
r217 103 102 16.6668 $w=2.1e-08 $l=4.9e-08 $layer=Gate_1 $thickness=5.6e-08
+ $X=0.243 $Y=0.2025 $X2=0.243 $Y2=0.1535
r218 100 101 16.6668 $w=2.1e-08 $l=4.9e-08 $layer=Gate_1 $thickness=5.6e-08
+ $X=0.243 $Y=0.0675 $X2=0.243 $Y2=0.1165
r219 19 80 6.74717 $w=2e-08 $layer=Gate_1 $thickness=5.2e-08 $X=0.243 $Y=0.135
+ $X2=0.243 $Y2=0.135
r220 19 101 6.46262 $w=2.04595e-08 $l=1.85e-08 $layer=Gate_1 $thickness=5.6e-08
+ $X=0.243 $Y=0.135 $X2=0.243 $Y2=0.1165
r221 19 102 6.46262 $w=2.04595e-08 $l=1.85e-08 $layer=Gate_1 $thickness=5.6e-08
+ $X=0.243 $Y=0.135 $X2=0.243 $Y2=0.1535
r222 97 96 16.6668 $w=2.1e-08 $l=4.9e-08 $layer=Gate_1 $thickness=5.6e-08
+ $X=0.189 $Y=0.2025 $X2=0.189 $Y2=0.1535
r223 94 95 16.6668 $w=2.1e-08 $l=4.9e-08 $layer=Gate_1 $thickness=5.6e-08
+ $X=0.189 $Y=0.0675 $X2=0.189 $Y2=0.1165
r224 18 77 3.57145 $w=2e-08 $layer=Gate_1 $thickness=5.6e-08 $X=0.189 $Y=0.135
+ $X2=0.189 $Y2=0.135
r225 18 95 6.46262 $w=2.04595e-08 $l=1.85e-08 $layer=Gate_1 $thickness=5.6e-08
+ $X=0.189 $Y=0.135 $X2=0.189 $Y2=0.1165
r226 18 96 6.46262 $w=2.04595e-08 $l=1.85e-08 $layer=Gate_1 $thickness=5.6e-08
+ $X=0.189 $Y=0.135 $X2=0.189 $Y2=0.1535
r227 90 91 3.03147 $w=1.3e-08 $l=1.3e-08 $layer=M1 $thickness=3.6e-08 $X=0.183
+ $Y=0.135 $X2=0.196 $Y2=0.135
r228 89 90 2.55073 $w=1.58125e-08 $l=1.6e-08 $layer=M1 $thickness=3.6e-08
+ $X=0.167 $Y=0.135 $X2=0.183 $Y2=0.135
r229 88 89 2.55073 $w=1.58125e-08 $l=1.6e-08 $layer=M1 $thickness=3.6e-08
+ $X=0.151 $Y=0.135 $X2=0.167 $Y2=0.135
r230 36 88 3.73104 $w=1.3e-08 $l=1.6e-08 $layer=M1 $thickness=3.6e-08 $X=0.135
+ $Y=0.135 $X2=0.151 $Y2=0.135
r231 36 72 19.3796 $a=3.24e-16 $layer=V0LIG $X=0.135 $Y=0.135 $X2=0.135
+ $Y2=0.135
r232 86 85 16.6668 $w=2.1e-08 $l=4.9e-08 $layer=Gate_1 $thickness=5.6e-08
+ $X=0.135 $Y=0.2025 $X2=0.135 $Y2=0.1535
r233 83 84 16.6668 $w=2.1e-08 $l=4.9e-08 $layer=Gate_1 $thickness=5.6e-08
+ $X=0.135 $Y=0.0675 $X2=0.135 $Y2=0.1165
r234 17 72 6.4296 $w=2e-08 $layer=Gate_1 $thickness=5.22105e-08 $X=0.135
+ $Y=0.135 $X2=0.135 $Y2=0.135
r235 17 84 6.46262 $w=2.04595e-08 $l=1.85e-08 $layer=Gate_1 $thickness=5.6e-08
+ $X=0.135 $Y=0.135 $X2=0.135 $Y2=0.1165
r236 17 85 6.46262 $w=2.04595e-08 $l=1.85e-08 $layer=Gate_1 $thickness=5.6e-08
+ $X=0.135 $Y=0.135 $X2=0.135 $Y2=0.1535
r237 79 80 15.6303 $w=1.62778e-08 $l=2.25e-08 $layer=LIG $thickness=4.8e-08
+ $X=0.2205 $Y=0.135 $X2=0.243 $Y2=0.135
r238 78 79 16.9382 $w=1.33e-08 $l=1.7e-08 $layer=LIG $thickness=4.8e-08
+ $X=0.2035 $Y=0.135 $X2=0.2205 $Y2=0.135
r239 76 78 5.91273 $w=1.665e-08 $l=9e-09 $layer=LIG $thickness=4.8e-08
+ $X=0.1945 $Y=0.135 $X2=0.2035 $Y2=0.135
r240 76 91 19.3796 $a=3.24e-16 $layer=V0LIG $X=0.1945 $Y=0.135 $X2=0.196
+ $Y2=0.135
r241 75 76 3.17572 $w=2e-08 $l=1e-08 $layer=LIG $thickness=4.8e-08 $X=0.1845
+ $Y=0.135 $X2=0.1945 $Y2=0.135
r242 75 77 1.74665 $w=2e-08 $l=4.5e-09 $layer=LIG $thickness=4.8e-08 $X=0.1845
+ $Y=0.135 $X2=0.189 $Y2=0.135
r243 74 75 18.6849 $w=1.49378e-08 $l=2.25e-08 $layer=LIG $thickness=4.8e-08
+ $X=0.162 $Y=0.135 $X2=0.1845 $Y2=0.135
r244 73 74 17.097 $w=1.34914e-08 $l=1.75e-08 $layer=LIG $thickness=4.8e-08
+ $X=0.1445 $Y=0.135 $X2=0.162 $Y2=0.135
r245 72 73 3.01694 $w=2e-08 $l=9.5e-09 $layer=LIG $thickness=4.8e-08 $X=0.135
+ $Y=0.135 $X2=0.1445 $Y2=0.135
r246 71 72 3.01694 $w=2e-08 $l=9.5e-09 $layer=LIG $thickness=4.8e-08 $X=0.1255
+ $Y=0.135 $X2=0.135 $Y2=0.135
r247 70 71 17.097 $w=1.34914e-08 $l=1.75e-08 $layer=LIG $thickness=4.8e-08
+ $X=0.108 $Y=0.135 $X2=0.1255 $Y2=0.135
r248 1 64 6.74717 $w=2e-08 $layer=Gate_1 $thickness=5.2e-08 $X=0.081 $Y=0.135
+ $X2=0.081 $Y2=0.135
r249 1 70 20.114 $w=1.57815e-08 $l=2.7e-08 $layer=LIG $thickness=4.8e-08
+ $X=0.081 $Y=0.135 $X2=0.108 $Y2=0.135
r250 67 66 14.6259 $w=2.1e-08 $l=4.3e-08 $layer=Gate_1 $thickness=5.6e-08
+ $X=0.081 $Y=0.2025 $X2=0.081 $Y2=0.1595
r251 65 66 2.89117 $w=2.1e-08 $l=8.5e-09 $layer=Gate_1 $thickness=5.6e-08
+ $X=0.081 $Y=0.151 $X2=0.081 $Y2=0.1595
r252 64 65 5.61228 $w=2.0375e-08 $l=1.6e-08 $layer=Gate_1 $thickness=5.6e-08
+ $X=0.081 $Y=0.135 $X2=0.081 $Y2=0.151
r253 63 64 5.61228 $w=2.0375e-08 $l=1.6e-08 $layer=Gate_1 $thickness=5.6e-08
+ $X=0.081 $Y=0.119 $X2=0.081 $Y2=0.135
r254 62 63 2.89117 $w=2.1e-08 $l=8.5e-09 $layer=Gate_1 $thickness=5.6e-08
+ $X=0.081 $Y=0.1105 $X2=0.081 $Y2=0.119
r255 61 62 14.6259 $w=2.1e-08 $l=4.3e-08 $layer=Gate_1 $thickness=5.6e-08
+ $X=0.081 $Y=0.0675 $X2=0.081 $Y2=0.1105
r256 61 16 14.6259 $w=2.1e-08 $l=4.3e-08 $layer=Gate_1 $thickness=5.6e-08
+ $X=0.081 $Y=0.0675 $X2=0.081 $Y2=0.0245
.ends

.subckt PM_CKINVDCx20_ASAP7_75t_R%11 vss 19 23 33 36 46 47 50 51 15 1 4 3 17 10
+ 11 18 14 9
c1 1 vss 0.00633375f $X=1.269 $Y=0.135
c2 3 vss 0.00721073f $X=1.188 $Y=0.0675
c3 4 vss 0.00715163f $X=1.296 $Y=0.0675
c4 9 vss 0.0821595f $X=1.269 $Y=0.0245
c5 10 vss 0.0823551f $X=1.323 $Y=0.135
c6 11 vss 0.00686171f $X=1.1735 $Y=0.0675
c7 12 vss 0.00638763f $X=1.2815 $Y=0.0675
c8 13 vss 0.000348718f $X=1.269 $Y=0.099
c9 14 vss 0.00020733f $X=1.269 $Y=0.135
c10 15 vss 0.00247086f $X=1.242 $Y=0.099
c11 16 vss 0.000149605f $X=1.269 $Y=0.117
c12 17 vss 0.0012582f $X=1.2825 $Y=0.099
c13 18 vss 0.000609281f $X=1.2825 $Y=0.135
r1 51 49 0.0308642 $w=8.1e-08 $l=2.5e-09 $layer=N_src_drn $thickness=1e-09
+ $X=1.3133 $Y=0.0675 $X2=1.3105 $Y2=0.0675
r2 4 49 0.179012 $w=8.1e-08 $l=1.45e-08 $layer=N_src_drn $thickness=1e-09
+ $X=1.296 $Y=0.0675 $X2=1.3105 $Y2=0.0675
r3 12 4 0.179012 $w=8.1e-08 $l=1.45e-08 $layer=N_src_drn $thickness=1e-09
+ $X=1.2815 $Y=0.0675 $X2=1.296 $Y2=0.0675
r4 50 12 0.0308642 $w=8.1e-08 $l=2.5e-09 $layer=N_src_drn $thickness=1e-09
+ $X=1.2786 $Y=0.0675 $X2=1.2815 $Y2=0.0675
r5 47 45 0.0308642 $w=8.1e-08 $l=2.5e-09 $layer=N_src_drn $thickness=1e-09
+ $X=1.2053 $Y=0.0675 $X2=1.2025 $Y2=0.0675
r6 3 45 0.179012 $w=8.1e-08 $l=1.45e-08 $layer=N_src_drn $thickness=1e-09
+ $X=1.188 $Y=0.0675 $X2=1.2025 $Y2=0.0675
r7 11 3 0.179012 $w=8.1e-08 $l=1.45e-08 $layer=N_src_drn $thickness=1e-09
+ $X=1.1735 $Y=0.0675 $X2=1.188 $Y2=0.0675
r8 46 11 0.0308642 $w=8.1e-08 $l=2.5e-09 $layer=N_src_drn $thickness=1e-09
+ $X=1.1706 $Y=0.0675 $X2=1.1735 $Y2=0.0675
r9 4 41 19.3796 $a=3.24e-16 $layer=V0LISD $X=1.296 $Y=0.0675 $X2=1.296 $Y2=0.099
r10 3 39 19.3796 $a=3.24e-16 $layer=V0LISD $X=1.188 $Y=0.0675 $X2=1.188
+ $Y2=0.099
r11 17 41 3.14806 $w=1.3e-08 $l=1.35e-08 $layer=M1 $thickness=3.6e-08 $X=1.2825
+ $Y=0.099 $X2=1.296 $Y2=0.099
r12 39 40 5.24677 $w=1.3e-08 $l=2.25e-08 $layer=M1 $thickness=3.6e-08 $X=1.188
+ $Y=0.099 $X2=1.2105 $Y2=0.099
r13 15 40 7.34548 $w=1.3e-08 $l=3.15e-08 $layer=M1 $thickness=3.6e-08 $X=1.242
+ $Y=0.099 $X2=1.2105 $Y2=0.099
r14 13 16 3.01711 $w=1.55e-08 $l=1.8e-08 $layer=M1 $thickness=3.6e-08 $X=1.269
+ $Y=0.099 $X2=1.269 $Y2=0.117
r15 13 15 5.11582 $w=1.46667e-08 $l=2.7e-08 $layer=M1 $thickness=3.6e-08
+ $X=1.269 $Y=0.099 $X2=1.242 $Y2=0.099
r16 13 17 1.96775 $w=1.63333e-08 $l=1.35e-08 $layer=M1 $thickness=3.6e-08
+ $X=1.269 $Y=0.099 $X2=1.2825 $Y2=0.099
r17 14 18 1.49895 $w=1.63333e-08 $l=1.35e-08 $layer=M1 $thickness=3.6e-08
+ $X=1.269 $Y=0.135 $X2=1.2825 $Y2=0.135
r18 14 16 2.5483 $w=1.79e-08 $l=1.8e-08 $layer=M1 $thickness=3.6e-08 $X=1.269
+ $Y=0.135 $X2=1.269 $Y2=0.117
r19 36 35 16.4967 $w=2.1e-08 $l=4.85e-08 $layer=Gate_1 $thickness=5.6e-08
+ $X=1.323 $Y=0.2025 $X2=1.323 $Y2=0.154
r20 33 34 16.4967 $w=2.1e-08 $l=4.85e-08 $layer=Gate_1 $thickness=5.6e-08
+ $X=1.323 $Y=0.0675 $X2=1.323 $Y2=0.116
r21 10 27 6.54019 $w=2.09524e-08 $layer=Gate_1 $thickness=5.21905e-08 $X=1.323
+ $Y=0.135 $X2=1.323 $Y2=0.135
r22 10 34 6.6497 $w=2.04211e-08 $l=1.9e-08 $layer=Gate_1 $thickness=5.6e-08
+ $X=1.323 $Y=0.135 $X2=1.323 $Y2=0.116
r23 10 35 6.6497 $w=2.04211e-08 $l=1.9e-08 $layer=Gate_1 $thickness=5.6e-08
+ $X=1.323 $Y=0.135 $X2=1.323 $Y2=0.154
r24 18 29 3.14806 $w=1.3e-08 $l=1.35e-08 $layer=M1 $thickness=3.6e-08 $X=1.2825
+ $Y=0.135 $X2=1.296 $Y2=0.135
r25 26 27 12.6539 $w=1.77815e-08 $l=2.7e-08 $layer=LIG $thickness=4.8e-08
+ $X=1.296 $Y=0.135 $X2=1.323 $Y2=0.135
r26 26 29 19.3796 $a=3.24e-16 $layer=V0LIG $X=1.296 $Y=0.135 $X2=1.296 $Y2=0.135
r27 1 21 6.54019 $w=2.09524e-08 $layer=Gate_1 $thickness=5.21905e-08 $X=1.269
+ $Y=0.135 $X2=1.269 $Y2=0.135
r28 1 26 12.6539 $w=1.77815e-08 $l=2.7e-08 $layer=LIG $thickness=4.8e-08
+ $X=1.269 $Y=0.135 $X2=1.296 $Y2=0.135
r29 23 22 16.4967 $w=2.1e-08 $l=4.85e-08 $layer=Gate_1 $thickness=5.6e-08
+ $X=1.269 $Y=0.2025 $X2=1.269 $Y2=0.154
r30 21 22 6.6497 $w=2.04211e-08 $l=1.9e-08 $layer=Gate_1 $thickness=5.6e-08
+ $X=1.269 $Y=0.135 $X2=1.269 $Y2=0.154
r31 20 21 6.6497 $w=2.04211e-08 $l=1.9e-08 $layer=Gate_1 $thickness=5.6e-08
+ $X=1.269 $Y=0.116 $X2=1.269 $Y2=0.135
r32 19 20 16.4967 $w=2.1e-08 $l=4.85e-08 $layer=Gate_1 $thickness=5.6e-08
+ $X=1.269 $Y=0.0675 $X2=1.269 $Y2=0.116
r33 19 9 14.6259 $w=2.1e-08 $l=4.3e-08 $layer=Gate_1 $thickness=5.6e-08
+ $X=1.269 $Y=0.0675 $X2=1.269 $Y2=0.0245
.ends

.subckt PM_CKINVDCx20_ASAP7_75t_R%9 vss 19 23 33 36 46 47 50 51 15 1 4 3 17 10
+ 11 18 14 9
c1 1 vss 0.00633374f $X=1.701 $Y=0.135
c2 3 vss 0.00721028f $X=1.62 $Y=0.0675
c3 4 vss 0.00715102f $X=1.728 $Y=0.0675
c4 9 vss 0.0821583f $X=1.701 $Y=0.0245
c5 10 vss 0.0823532f $X=1.755 $Y=0.135
c6 11 vss 0.00684721f $X=1.6055 $Y=0.0675
c7 12 vss 0.00637443f $X=1.7135 $Y=0.0675
c8 13 vss 0.000348651f $X=1.701 $Y=0.099
c9 14 vss 0.000207229f $X=1.701 $Y=0.135
c10 15 vss 0.00242508f $X=1.674 $Y=0.099
c11 16 vss 0.000149605f $X=1.701 $Y=0.117
c12 17 vss 0.00125568f $X=1.7145 $Y=0.099
c13 18 vss 0.000607798f $X=1.7145 $Y=0.135
r1 51 49 0.0308642 $w=8.1e-08 $l=2.5e-09 $layer=N_src_drn $thickness=1e-09
+ $X=1.7453 $Y=0.0675 $X2=1.7425 $Y2=0.0675
r2 4 49 0.179012 $w=8.1e-08 $l=1.45e-08 $layer=N_src_drn $thickness=1e-09
+ $X=1.728 $Y=0.0675 $X2=1.7425 $Y2=0.0675
r3 12 4 0.179012 $w=8.1e-08 $l=1.45e-08 $layer=N_src_drn $thickness=1e-09
+ $X=1.7135 $Y=0.0675 $X2=1.728 $Y2=0.0675
r4 50 12 0.0308642 $w=8.1e-08 $l=2.5e-09 $layer=N_src_drn $thickness=1e-09
+ $X=1.7106 $Y=0.0675 $X2=1.7135 $Y2=0.0675
r5 47 45 0.0308642 $w=8.1e-08 $l=2.5e-09 $layer=N_src_drn $thickness=1e-09
+ $X=1.6373 $Y=0.0675 $X2=1.6345 $Y2=0.0675
r6 3 45 0.179012 $w=8.1e-08 $l=1.45e-08 $layer=N_src_drn $thickness=1e-09
+ $X=1.62 $Y=0.0675 $X2=1.6345 $Y2=0.0675
r7 11 3 0.179012 $w=8.1e-08 $l=1.45e-08 $layer=N_src_drn $thickness=1e-09
+ $X=1.6055 $Y=0.0675 $X2=1.62 $Y2=0.0675
r8 46 11 0.0308642 $w=8.1e-08 $l=2.5e-09 $layer=N_src_drn $thickness=1e-09
+ $X=1.6026 $Y=0.0675 $X2=1.6055 $Y2=0.0675
r9 4 41 19.3796 $a=3.24e-16 $layer=V0LISD $X=1.728 $Y=0.0675 $X2=1.728 $Y2=0.099
r10 3 39 19.3796 $a=3.24e-16 $layer=V0LISD $X=1.62 $Y=0.0675 $X2=1.62 $Y2=0.099
r11 17 41 3.14806 $w=1.3e-08 $l=1.35e-08 $layer=M1 $thickness=3.6e-08 $X=1.7145
+ $Y=0.099 $X2=1.728 $Y2=0.099
r12 39 40 5.24677 $w=1.3e-08 $l=2.25e-08 $layer=M1 $thickness=3.6e-08 $X=1.62
+ $Y=0.099 $X2=1.6425 $Y2=0.099
r13 15 40 7.34548 $w=1.3e-08 $l=3.15e-08 $layer=M1 $thickness=3.6e-08 $X=1.674
+ $Y=0.099 $X2=1.6425 $Y2=0.099
r14 13 16 3.01711 $w=1.55e-08 $l=1.8e-08 $layer=M1 $thickness=3.6e-08 $X=1.701
+ $Y=0.099 $X2=1.701 $Y2=0.117
r15 13 15 5.11582 $w=1.46667e-08 $l=2.7e-08 $layer=M1 $thickness=3.6e-08
+ $X=1.701 $Y=0.099 $X2=1.674 $Y2=0.099
r16 13 17 1.96775 $w=1.63333e-08 $l=1.35e-08 $layer=M1 $thickness=3.6e-08
+ $X=1.701 $Y=0.099 $X2=1.7145 $Y2=0.099
r17 14 18 1.49895 $w=1.63333e-08 $l=1.35e-08 $layer=M1 $thickness=3.6e-08
+ $X=1.701 $Y=0.135 $X2=1.7145 $Y2=0.135
r18 14 16 2.5483 $w=1.79e-08 $l=1.8e-08 $layer=M1 $thickness=3.6e-08 $X=1.701
+ $Y=0.135 $X2=1.701 $Y2=0.117
r19 36 35 16.4967 $w=2.1e-08 $l=4.85e-08 $layer=Gate_1 $thickness=5.6e-08
+ $X=1.755 $Y=0.2025 $X2=1.755 $Y2=0.154
r20 33 34 16.4967 $w=2.1e-08 $l=4.85e-08 $layer=Gate_1 $thickness=5.6e-08
+ $X=1.755 $Y=0.0675 $X2=1.755 $Y2=0.116
r21 10 27 6.54019 $w=2.09524e-08 $layer=Gate_1 $thickness=5.21905e-08 $X=1.755
+ $Y=0.135 $X2=1.755 $Y2=0.135
r22 10 34 6.6497 $w=2.04211e-08 $l=1.9e-08 $layer=Gate_1 $thickness=5.6e-08
+ $X=1.755 $Y=0.135 $X2=1.755 $Y2=0.116
r23 10 35 6.6497 $w=2.04211e-08 $l=1.9e-08 $layer=Gate_1 $thickness=5.6e-08
+ $X=1.755 $Y=0.135 $X2=1.755 $Y2=0.154
r24 18 29 3.14806 $w=1.3e-08 $l=1.35e-08 $layer=M1 $thickness=3.6e-08 $X=1.7145
+ $Y=0.135 $X2=1.728 $Y2=0.135
r25 26 27 12.6539 $w=1.77815e-08 $l=2.7e-08 $layer=LIG $thickness=4.8e-08
+ $X=1.728 $Y=0.135 $X2=1.755 $Y2=0.135
r26 26 29 19.3796 $a=3.24e-16 $layer=V0LIG $X=1.728 $Y=0.135 $X2=1.728 $Y2=0.135
r27 1 21 6.54019 $w=2.09524e-08 $layer=Gate_1 $thickness=5.21905e-08 $X=1.701
+ $Y=0.135 $X2=1.701 $Y2=0.135
r28 1 26 12.6539 $w=1.77815e-08 $l=2.7e-08 $layer=LIG $thickness=4.8e-08
+ $X=1.701 $Y=0.135 $X2=1.728 $Y2=0.135
r29 23 22 16.4967 $w=2.1e-08 $l=4.85e-08 $layer=Gate_1 $thickness=5.6e-08
+ $X=1.701 $Y=0.2025 $X2=1.701 $Y2=0.154
r30 21 22 6.6497 $w=2.04211e-08 $l=1.9e-08 $layer=Gate_1 $thickness=5.6e-08
+ $X=1.701 $Y=0.135 $X2=1.701 $Y2=0.154
r31 20 21 6.6497 $w=2.04211e-08 $l=1.9e-08 $layer=Gate_1 $thickness=5.6e-08
+ $X=1.701 $Y=0.116 $X2=1.701 $Y2=0.135
r32 19 20 16.4967 $w=2.1e-08 $l=4.85e-08 $layer=Gate_1 $thickness=5.6e-08
+ $X=1.701 $Y=0.0675 $X2=1.701 $Y2=0.116
r33 19 9 14.6259 $w=2.1e-08 $l=4.3e-08 $layer=Gate_1 $thickness=5.6e-08
+ $X=1.701 $Y=0.0675 $X2=1.701 $Y2=0.0245
.ends

.subckt PM_CKINVDCx20_ASAP7_75t_R%Y vss 140 122 123 138 139 154 155 173 174 181
+ 182 195 196 199 200 218 219 226 227 240 241 244 245 264 265 272 273 286 287
+ 290 291 310 311 318 319 324 325 328 329 336 337 73 90 92 96 84 94 98 88 87 91
+ 85 81 93 89 115 119 99 4 8 10 12 14 18 105 2 6 16 20 97 83 1 19 110 118 106
+ 102 114 72 74 75 76 77 78 79 62 63 64 65 66 67 68 69 71 80 61 70 9 11 7 15 5
+ 3 13 17 101 107 113 103 117 109 111 95 104 108 112 116
c1 1 vss 0.0078073f $X=0.108 $Y=0.0675
c2 2 vss 0.00817105f $X=0.108 $Y=0.2025
c3 3 vss 0.00682549f $X=0.216 $Y=0.0675
c4 4 vss 0.00802167f $X=0.216 $Y=0.2025
c5 5 vss 0.00679056f $X=0.54 $Y=0.0675
c6 6 vss 0.00801802f $X=0.54 $Y=0.2025
c7 7 vss 0.0067831f $X=0.648 $Y=0.0675
c8 8 vss 0.00801459f $X=0.648 $Y=0.2025
c9 9 vss 0.00678446f $X=0.972 $Y=0.0675
c10 10 vss 0.00801798f $X=0.972 $Y=0.2025
c11 11 vss 0.00678446f $X=1.08 $Y=0.0675
c12 12 vss 0.00801798f $X=1.08 $Y=0.2025
c13 13 vss 0.00677789f $X=1.404 $Y=0.0675
c14 14 vss 0.00801798f $X=1.404 $Y=0.2025
c15 15 vss 0.00678434f $X=1.512 $Y=0.0675
c16 16 vss 0.00801802f $X=1.512 $Y=0.2025
c17 17 vss 0.00677789f $X=1.836 $Y=0.0675
c18 18 vss 0.00801798f $X=1.836 $Y=0.2025
c19 19 vss 0.00780007f $X=1.944 $Y=0.0675
c20 20 vss 0.00817106f $X=1.944 $Y=0.2025
c21 61 vss 0.00439566f $X=0.0935 $Y=0.0675
c22 62 vss 0.00430898f $X=0.2015 $Y=0.0675
c23 63 vss 0.00430898f $X=0.5255 $Y=0.0675
c24 64 vss 0.00430877f $X=0.6335 $Y=0.0675
c25 65 vss 0.00430898f $X=0.9575 $Y=0.0675
c26 66 vss 0.00430898f $X=1.0655 $Y=0.0675
c27 67 vss 0.00430898f $X=1.3895 $Y=0.0675
c28 68 vss 0.00430898f $X=1.4975 $Y=0.0675
c29 69 vss 0.00430898f $X=1.8215 $Y=0.0675
c30 70 vss 0.00439566f $X=1.9295 $Y=0.0675
c31 71 vss 0.00420226f $X=0.0935 $Y=0.2025
c32 72 vss 0.00431159f $X=0.2015 $Y=0.2025
c33 73 vss 0.00431159f $X=0.5255 $Y=0.2025
c34 74 vss 0.00431157f $X=0.6335 $Y=0.2025
c35 75 vss 0.00431159f $X=0.9575 $Y=0.2025
c36 76 vss 0.00431159f $X=1.0655 $Y=0.2025
c37 77 vss 0.00431159f $X=1.3895 $Y=0.2025
c38 78 vss 0.00431159f $X=1.4975 $Y=0.2025
c39 79 vss 0.00431159f $X=1.8215 $Y=0.2025
c40 80 vss 0.004203f $X=1.9295 $Y=0.2025
c41 81 vss 0.00316609f $X=0.0945 $Y=0.072
c42 82 vss 0.00299274f $X=0.081 $Y=0.234
c43 83 vss 0.00102608f $X=0.243 $Y=0.072
c44 84 vss 0.00204978f $X=0.243 $Y=0.234
c45 85 vss 0.00116328f $X=0.513 $Y=0.072
c46 86 vss 0.00204969f $X=0.513 $Y=0.234
c47 87 vss 0.00112866f $X=0.675 $Y=0.072
c48 88 vss 0.00204978f $X=0.675 $Y=0.234
c49 89 vss 0.00115179f $X=0.945 $Y=0.072
c50 90 vss 0.00204969f $X=0.945 $Y=0.234
c51 91 vss 0.00115179f $X=1.107 $Y=0.072
c52 92 vss 0.00204969f $X=1.107 $Y=0.234
c53 93 vss 0.00102608f $X=1.377 $Y=0.072
c54 94 vss 0.00204978f $X=1.377 $Y=0.234
c55 95 vss 0.00113918f $X=1.539 $Y=0.072
c56 96 vss 0.00204969f $X=1.539 $Y=0.234
c57 97 vss 0.00102608f $X=1.809 $Y=0.072
c58 98 vss 0.00204978f $X=1.809 $Y=0.234
c59 99 vss 0.0032057f $X=1.971 $Y=0.072
c60 100 vss 0.00299273f $X=1.971 $Y=0.234
c61 101 vss 0.00567627f $X=0.081 $Y=0.1035
c62 102 vss 0.0118624f $X=0.0945 $Y=0.234
c63 103 vss 0.00306345f $X=0.243 $Y=0.1947
c64 104 vss 0.0226953f $X=0.273 $Y=0.234
c65 105 vss 0.00303274f $X=0.513 $Y=0.2025
c66 106 vss 0.0120859f $X=0.5265 $Y=0.234
c67 107 vss 0.00307035f $X=0.675 $Y=0.2025
c68 108 vss 0.0227424f $X=0.705 $Y=0.234
c69 109 vss 0.0030553f $X=0.945 $Y=0.2025
c70 110 vss 0.0119944f $X=0.9585 $Y=0.234
c71 111 vss 0.0030553f $X=1.107 $Y=0.2025
c72 112 vss 0.0227319f $X=1.1355 $Y=0.234
c73 113 vss 0.00310242f $X=1.377 $Y=0.2025
c74 114 vss 0.012201f $X=1.3905 $Y=0.234
c75 115 vss 0.00307453f $X=1.539 $Y=0.2025
c76 116 vss 0.0226953f $X=1.5675 $Y=0.234
c77 117 vss 0.00310242f $X=1.809 $Y=0.2025
c78 118 vss 0.0117529f $X=1.8225 $Y=0.234
c79 119 vss 0.00569734f $X=1.971 $Y=0.1845
r1 337 335 0.0308642 $w=8.1e-08 $l=2.5e-09 $layer=N_src_drn $thickness=1e-09
+ $X=1.9613 $Y=0.0675 $X2=1.9585 $Y2=0.0675
r2 19 335 0.179012 $w=8.1e-08 $l=1.45e-08 $layer=N_src_drn $thickness=1e-09
+ $X=1.944 $Y=0.0675 $X2=1.9585 $Y2=0.0675
r3 70 19 0.179012 $w=8.1e-08 $l=1.45e-08 $layer=N_src_drn $thickness=1e-09
+ $X=1.9295 $Y=0.0675 $X2=1.944 $Y2=0.0675
r4 336 70 0.0308642 $w=8.1e-08 $l=2.5e-09 $layer=N_src_drn $thickness=1e-09
+ $X=1.9266 $Y=0.0675 $X2=1.9295 $Y2=0.0675
r5 19 330 19.3796 $a=3.24e-16 $layer=V0LISD $X=1.944 $Y=0.0675 $X2=1.945
+ $Y2=0.072
r6 330 331 2.91487 $w=1.3e-08 $l=1.25e-08 $layer=M1 $thickness=3.6e-08 $X=1.945
+ $Y=0.072 $X2=1.9575 $Y2=0.072
r7 99 321 6.16517 $w=1.44286e-08 $l=3.15e-08 $layer=M1 $thickness=3.6e-08
+ $X=1.971 $Y=0.072 $X2=1.971 $Y2=0.1035
r8 99 331 1.96775 $w=1.63333e-08 $l=1.35e-08 $layer=M1 $thickness=3.6e-08
+ $X=1.971 $Y=0.072 $X2=1.9575 $Y2=0.072
r9 329 327 0.0308642 $w=8.1e-08 $l=2.5e-09 $layer=N_src_drn $thickness=1e-09
+ $X=1.8533 $Y=0.0675 $X2=1.8505 $Y2=0.0675
r10 17 327 0.179012 $w=8.1e-08 $l=1.45e-08 $layer=N_src_drn $thickness=1e-09
+ $X=1.836 $Y=0.0675 $X2=1.8505 $Y2=0.0675
r11 69 17 0.179012 $w=8.1e-08 $l=1.45e-08 $layer=N_src_drn $thickness=1e-09
+ $X=1.8215 $Y=0.0675 $X2=1.836 $Y2=0.0675
r12 328 69 0.0308642 $w=8.1e-08 $l=2.5e-09 $layer=N_src_drn $thickness=1e-09
+ $X=1.8186 $Y=0.0675 $X2=1.8215 $Y2=0.0675
r13 325 323 0.0308642 $w=8.1e-08 $l=2.5e-09 $layer=P_src_drn $thickness=1e-09
+ $X=1.9613 $Y=0.2025 $X2=1.9585 $Y2=0.2025
r14 20 323 0.179012 $w=8.1e-08 $l=1.45e-08 $layer=P_src_drn $thickness=1e-09
+ $X=1.944 $Y=0.2025 $X2=1.9585 $Y2=0.2025
r15 80 20 0.179012 $w=8.1e-08 $l=1.45e-08 $layer=P_src_drn $thickness=1e-09
+ $X=1.9295 $Y=0.2025 $X2=1.944 $Y2=0.2025
r16 324 80 0.0308642 $w=8.1e-08 $l=2.5e-09 $layer=P_src_drn $thickness=1e-09
+ $X=1.9266 $Y=0.2025 $X2=1.9295 $Y2=0.2025
r17 320 321 7.34548 $w=1.3e-08 $l=3.15e-08 $layer=M1 $thickness=3.6e-08
+ $X=1.971 $Y=0.135 $X2=1.971 $Y2=0.1035
r18 119 320 11.5429 $w=1.3e-08 $l=4.95e-08 $layer=M1 $thickness=3.6e-08
+ $X=1.971 $Y=0.1845 $X2=1.971 $Y2=0.135
r19 319 317 0.0308642 $w=8.1e-08 $l=2.5e-09 $layer=P_src_drn $thickness=1e-09
+ $X=1.8533 $Y=0.2025 $X2=1.8505 $Y2=0.2025
r20 18 317 0.179012 $w=8.1e-08 $l=1.45e-08 $layer=P_src_drn $thickness=1e-09
+ $X=1.836 $Y=0.2025 $X2=1.8505 $Y2=0.2025
r21 79 18 0.179012 $w=8.1e-08 $l=1.45e-08 $layer=P_src_drn $thickness=1e-09
+ $X=1.8215 $Y=0.2025 $X2=1.836 $Y2=0.2025
r22 318 79 0.0308642 $w=8.1e-08 $l=2.5e-09 $layer=P_src_drn $thickness=1e-09
+ $X=1.8186 $Y=0.2025 $X2=1.8215 $Y2=0.2025
r23 17 313 19.3796 $a=3.24e-16 $layer=V0LISD $X=1.836 $Y=0.0675 $X2=1.8355
+ $Y2=0.072
r24 20 306 19.3796 $a=3.24e-16 $layer=V0LISD $X=1.944 $Y=0.2025 $X2=1.945
+ $Y2=0.234
r25 100 307 1.49895 $w=1.63333e-08 $l=1.35e-08 $layer=M1 $thickness=3.6e-08
+ $X=1.971 $Y=0.234 $X2=1.9575 $Y2=0.234
r26 100 119 9.89378 $w=1.47818e-08 $l=4.95e-08 $layer=M1 $thickness=3.6e-08
+ $X=1.971 $Y=0.234 $X2=1.971 $Y2=0.1845
r27 18 302 19.3796 $a=3.24e-16 $layer=V0LISD $X=1.836 $Y=0.2025 $X2=1.8355
+ $Y2=0.234
r28 312 313 3.03147 $w=1.3e-08 $l=1.3e-08 $layer=M1 $thickness=3.6e-08
+ $X=1.8225 $Y=0.072 $X2=1.8355 $Y2=0.072
r29 97 301 1.96775 $w=1.63333e-08 $l=1.35e-08 $layer=M1 $thickness=3.6e-08
+ $X=1.809 $Y=0.072 $X2=1.809 $Y2=0.0855
r30 97 312 1.96775 $w=1.63333e-08 $l=1.35e-08 $layer=M1 $thickness=3.6e-08
+ $X=1.809 $Y=0.072 $X2=1.8225 $Y2=0.072
r31 311 309 0.0308642 $w=8.1e-08 $l=2.5e-09 $layer=N_src_drn $thickness=1e-09
+ $X=1.5293 $Y=0.0675 $X2=1.5265 $Y2=0.0675
r32 15 309 0.179012 $w=8.1e-08 $l=1.45e-08 $layer=N_src_drn $thickness=1e-09
+ $X=1.512 $Y=0.0675 $X2=1.5265 $Y2=0.0675
r33 68 15 0.179012 $w=8.1e-08 $l=1.45e-08 $layer=N_src_drn $thickness=1e-09
+ $X=1.4975 $Y=0.0675 $X2=1.512 $Y2=0.0675
r34 310 68 0.0308642 $w=8.1e-08 $l=2.5e-09 $layer=N_src_drn $thickness=1e-09
+ $X=1.4946 $Y=0.0675 $X2=1.4975 $Y2=0.0675
r35 306 307 2.91487 $w=1.3e-08 $l=1.25e-08 $layer=M1 $thickness=3.6e-08
+ $X=1.945 $Y=0.234 $X2=1.9575 $Y2=0.234
r36 305 306 2.09871 $w=1.3e-08 $l=9e-09 $layer=M1 $thickness=3.6e-08 $X=1.936
+ $Y=0.234 $X2=1.945 $Y2=0.234
r37 304 305 10.7267 $w=1.3e-08 $l=4.6e-08 $layer=M1 $thickness=3.6e-08 $X=1.89
+ $Y=0.234 $X2=1.936 $Y2=0.234
r38 303 304 10.6101 $w=1.3e-08 $l=4.55e-08 $layer=M1 $thickness=3.6e-08
+ $X=1.8445 $Y=0.234 $X2=1.89 $Y2=0.234
r39 302 303 2.09871 $w=1.3e-08 $l=9e-09 $layer=M1 $thickness=3.6e-08 $X=1.8355
+ $Y=0.234 $X2=1.8445 $Y2=0.234
r40 118 302 3.03147 $w=1.3e-08 $l=1.3e-08 $layer=M1 $thickness=3.6e-08
+ $X=1.8225 $Y=0.234 $X2=1.8355 $Y2=0.234
r41 300 301 3.14806 $w=1.3e-08 $l=1.35e-08 $layer=M1 $thickness=3.6e-08
+ $X=1.809 $Y=0.099 $X2=1.809 $Y2=0.0855
r42 299 300 4.19742 $w=1.3e-08 $l=1.8e-08 $layer=M1 $thickness=3.6e-08 $X=1.809
+ $Y=0.117 $X2=1.809 $Y2=0.099
r43 298 299 4.19742 $w=1.3e-08 $l=1.8e-08 $layer=M1 $thickness=3.6e-08 $X=1.809
+ $Y=0.135 $X2=1.809 $Y2=0.117
r44 297 298 4.19742 $w=1.3e-08 $l=1.8e-08 $layer=M1 $thickness=3.6e-08 $X=1.809
+ $Y=0.153 $X2=1.809 $Y2=0.135
r45 296 297 4.19742 $w=1.3e-08 $l=1.8e-08 $layer=M1 $thickness=3.6e-08 $X=1.809
+ $Y=0.171 $X2=1.809 $Y2=0.153
r46 117 296 7.34548 $w=1.3e-08 $l=3.15e-08 $layer=M1 $thickness=3.6e-08
+ $X=1.809 $Y=0.2025 $X2=1.809 $Y2=0.171
r47 15 292 19.3796 $a=3.24e-16 $layer=V0LISD $X=1.512 $Y=0.0675 $X2=1.513
+ $Y2=0.072
r48 98 283 5.81538 $w=1.45e-08 $l=3e-08 $layer=M1 $thickness=3.6e-08 $X=1.809
+ $Y=0.234 $X2=1.779 $Y2=0.234
r49 98 117 6.16517 $w=1.44286e-08 $l=3.15e-08 $layer=M1 $thickness=3.6e-08
+ $X=1.809 $Y=0.234 $X2=1.809 $Y2=0.2025
r50 98 118 1.96775 $w=1.63333e-08 $l=1.35e-08 $layer=M1 $thickness=3.6e-08
+ $X=1.809 $Y=0.234 $X2=1.8225 $Y2=0.234
r51 292 293 2.91487 $w=1.3e-08 $l=1.25e-08 $layer=M1 $thickness=3.6e-08
+ $X=1.513 $Y=0.072 $X2=1.5255 $Y2=0.072
r52 95 279 1.96775 $w=1.63333e-08 $l=1.35e-08 $layer=M1 $thickness=3.6e-08
+ $X=1.539 $Y=0.072 $X2=1.539 $Y2=0.0855
r53 95 293 1.96775 $w=1.63333e-08 $l=1.35e-08 $layer=M1 $thickness=3.6e-08
+ $X=1.539 $Y=0.072 $X2=1.5255 $Y2=0.072
r54 291 289 0.0308642 $w=8.1e-08 $l=2.5e-09 $layer=N_src_drn $thickness=1e-09
+ $X=1.4213 $Y=0.0675 $X2=1.4185 $Y2=0.0675
r55 13 289 0.179012 $w=8.1e-08 $l=1.45e-08 $layer=N_src_drn $thickness=1e-09
+ $X=1.404 $Y=0.0675 $X2=1.4185 $Y2=0.0675
r56 67 13 0.179012 $w=8.1e-08 $l=1.45e-08 $layer=N_src_drn $thickness=1e-09
+ $X=1.3895 $Y=0.0675 $X2=1.404 $Y2=0.0675
r57 290 67 0.0308642 $w=8.1e-08 $l=2.5e-09 $layer=N_src_drn $thickness=1e-09
+ $X=1.3866 $Y=0.0675 $X2=1.3895 $Y2=0.0675
r58 287 285 0.0308642 $w=8.1e-08 $l=2.5e-09 $layer=P_src_drn $thickness=1e-09
+ $X=1.5293 $Y=0.2025 $X2=1.5265 $Y2=0.2025
r59 16 285 0.179012 $w=8.1e-08 $l=1.45e-08 $layer=P_src_drn $thickness=1e-09
+ $X=1.512 $Y=0.2025 $X2=1.5265 $Y2=0.2025
r60 78 16 0.179012 $w=8.1e-08 $l=1.45e-08 $layer=P_src_drn $thickness=1e-09
+ $X=1.4975 $Y=0.2025 $X2=1.512 $Y2=0.2025
r61 286 78 0.0308642 $w=8.1e-08 $l=2.5e-09 $layer=P_src_drn $thickness=1e-09
+ $X=1.4946 $Y=0.2025 $X2=1.4975 $Y2=0.2025
r62 282 283 6.06293 $w=1.3e-08 $l=2.6e-08 $layer=M1 $thickness=3.6e-08 $X=1.753
+ $Y=0.234 $X2=1.779 $Y2=0.234
r63 281 282 1.86552 $w=1.3e-08 $l=8e-09 $layer=M1 $thickness=3.6e-08 $X=1.745
+ $Y=0.234 $X2=1.753 $Y2=0.234
r64 280 281 18.7718 $w=1.3e-08 $l=8.05e-08 $layer=M1 $thickness=3.6e-08
+ $X=1.6645 $Y=0.234 $X2=1.745 $Y2=0.234
r65 116 280 22.6194 $w=1.3e-08 $l=9.7e-08 $layer=M1 $thickness=3.6e-08
+ $X=1.5675 $Y=0.234 $X2=1.6645 $Y2=0.234
r66 278 279 3.14806 $w=1.3e-08 $l=1.35e-08 $layer=M1 $thickness=3.6e-08
+ $X=1.539 $Y=0.099 $X2=1.539 $Y2=0.0855
r67 277 278 4.19742 $w=1.3e-08 $l=1.8e-08 $layer=M1 $thickness=3.6e-08 $X=1.539
+ $Y=0.117 $X2=1.539 $Y2=0.099
r68 276 277 4.19742 $w=1.3e-08 $l=1.8e-08 $layer=M1 $thickness=3.6e-08 $X=1.539
+ $Y=0.135 $X2=1.539 $Y2=0.117
r69 275 276 4.19742 $w=1.3e-08 $l=1.8e-08 $layer=M1 $thickness=3.6e-08 $X=1.539
+ $Y=0.153 $X2=1.539 $Y2=0.135
r70 274 275 4.19742 $w=1.3e-08 $l=1.8e-08 $layer=M1 $thickness=3.6e-08 $X=1.539
+ $Y=0.171 $X2=1.539 $Y2=0.153
r71 115 274 7.34548 $w=1.3e-08 $l=3.15e-08 $layer=M1 $thickness=3.6e-08
+ $X=1.539 $Y=0.2025 $X2=1.539 $Y2=0.171
r72 273 271 0.0308642 $w=8.1e-08 $l=2.5e-09 $layer=P_src_drn $thickness=1e-09
+ $X=1.4213 $Y=0.2025 $X2=1.4185 $Y2=0.2025
r73 14 271 0.179012 $w=8.1e-08 $l=1.45e-08 $layer=P_src_drn $thickness=1e-09
+ $X=1.404 $Y=0.2025 $X2=1.4185 $Y2=0.2025
r74 77 14 0.179012 $w=8.1e-08 $l=1.45e-08 $layer=P_src_drn $thickness=1e-09
+ $X=1.3895 $Y=0.2025 $X2=1.404 $Y2=0.2025
r75 272 77 0.0308642 $w=8.1e-08 $l=2.5e-09 $layer=P_src_drn $thickness=1e-09
+ $X=1.3866 $Y=0.2025 $X2=1.3895 $Y2=0.2025
r76 13 267 19.3796 $a=3.24e-16 $layer=V0LISD $X=1.404 $Y=0.0675 $X2=1.4035
+ $Y2=0.072
r77 16 260 19.3796 $a=3.24e-16 $layer=V0LISD $X=1.512 $Y=0.2025 $X2=1.513
+ $Y2=0.234
r78 96 261 1.96775 $w=1.63333e-08 $l=1.35e-08 $layer=M1 $thickness=3.6e-08
+ $X=1.539 $Y=0.234 $X2=1.5255 $Y2=0.234
r79 96 115 6.16517 $w=1.44286e-08 $l=3.15e-08 $layer=M1 $thickness=3.6e-08
+ $X=1.539 $Y=0.234 $X2=1.539 $Y2=0.2025
r80 96 116 5.4656 $w=1.45789e-08 $l=2.85e-08 $layer=M1 $thickness=3.6e-08
+ $X=1.539 $Y=0.234 $X2=1.5675 $Y2=0.234
r81 14 256 19.3796 $a=3.24e-16 $layer=V0LISD $X=1.404 $Y=0.2025 $X2=1.4035
+ $Y2=0.234
r82 266 267 3.03147 $w=1.3e-08 $l=1.3e-08 $layer=M1 $thickness=3.6e-08
+ $X=1.3905 $Y=0.072 $X2=1.4035 $Y2=0.072
r83 93 255 1.96775 $w=1.63333e-08 $l=1.35e-08 $layer=M1 $thickness=3.6e-08
+ $X=1.377 $Y=0.072 $X2=1.377 $Y2=0.0855
r84 93 266 1.96775 $w=1.63333e-08 $l=1.35e-08 $layer=M1 $thickness=3.6e-08
+ $X=1.377 $Y=0.072 $X2=1.3905 $Y2=0.072
r85 265 263 0.0308642 $w=8.1e-08 $l=2.5e-09 $layer=N_src_drn $thickness=1e-09
+ $X=1.0973 $Y=0.0675 $X2=1.0945 $Y2=0.0675
r86 11 263 0.179012 $w=8.1e-08 $l=1.45e-08 $layer=N_src_drn $thickness=1e-09
+ $X=1.08 $Y=0.0675 $X2=1.0945 $Y2=0.0675
r87 66 11 0.179012 $w=8.1e-08 $l=1.45e-08 $layer=N_src_drn $thickness=1e-09
+ $X=1.0655 $Y=0.0675 $X2=1.08 $Y2=0.0675
r88 264 66 0.0308642 $w=8.1e-08 $l=2.5e-09 $layer=N_src_drn $thickness=1e-09
+ $X=1.0626 $Y=0.0675 $X2=1.0655 $Y2=0.0675
r89 260 261 2.91487 $w=1.3e-08 $l=1.25e-08 $layer=M1 $thickness=3.6e-08
+ $X=1.513 $Y=0.234 $X2=1.5255 $Y2=0.234
r90 259 260 2.09871 $w=1.3e-08 $l=9e-09 $layer=M1 $thickness=3.6e-08 $X=1.504
+ $Y=0.234 $X2=1.513 $Y2=0.234
r91 258 259 10.7267 $w=1.3e-08 $l=4.6e-08 $layer=M1 $thickness=3.6e-08 $X=1.458
+ $Y=0.234 $X2=1.504 $Y2=0.234
r92 257 258 10.6101 $w=1.3e-08 $l=4.55e-08 $layer=M1 $thickness=3.6e-08
+ $X=1.4125 $Y=0.234 $X2=1.458 $Y2=0.234
r93 256 257 2.09871 $w=1.3e-08 $l=9e-09 $layer=M1 $thickness=3.6e-08 $X=1.4035
+ $Y=0.234 $X2=1.4125 $Y2=0.234
r94 114 256 3.03147 $w=1.3e-08 $l=1.3e-08 $layer=M1 $thickness=3.6e-08
+ $X=1.3905 $Y=0.234 $X2=1.4035 $Y2=0.234
r95 254 255 3.14806 $w=1.3e-08 $l=1.35e-08 $layer=M1 $thickness=3.6e-08
+ $X=1.377 $Y=0.099 $X2=1.377 $Y2=0.0855
r96 253 254 4.19742 $w=1.3e-08 $l=1.8e-08 $layer=M1 $thickness=3.6e-08 $X=1.377
+ $Y=0.117 $X2=1.377 $Y2=0.099
r97 252 253 4.19742 $w=1.3e-08 $l=1.8e-08 $layer=M1 $thickness=3.6e-08 $X=1.377
+ $Y=0.135 $X2=1.377 $Y2=0.117
r98 251 252 4.19742 $w=1.3e-08 $l=1.8e-08 $layer=M1 $thickness=3.6e-08 $X=1.377
+ $Y=0.153 $X2=1.377 $Y2=0.135
r99 250 251 4.19742 $w=1.3e-08 $l=1.8e-08 $layer=M1 $thickness=3.6e-08 $X=1.377
+ $Y=0.171 $X2=1.377 $Y2=0.153
r100 113 250 7.34548 $w=1.3e-08 $l=3.15e-08 $layer=M1 $thickness=3.6e-08
+ $X=1.377 $Y=0.2025 $X2=1.377 $Y2=0.171
r101 11 246 19.3796 $a=3.24e-16 $layer=V0LISD $X=1.08 $Y=0.0675 $X2=1.0805
+ $Y2=0.072
r102 94 237 5.81538 $w=1.45e-08 $l=3e-08 $layer=M1 $thickness=3.6e-08 $X=1.377
+ $Y=0.234 $X2=1.347 $Y2=0.234
r103 94 113 6.16517 $w=1.44286e-08 $l=3.15e-08 $layer=M1 $thickness=3.6e-08
+ $X=1.377 $Y=0.234 $X2=1.377 $Y2=0.2025
r104 94 114 1.96775 $w=1.63333e-08 $l=1.35e-08 $layer=M1 $thickness=3.6e-08
+ $X=1.377 $Y=0.234 $X2=1.3905 $Y2=0.234
r105 246 247 3.03147 $w=1.3e-08 $l=1.3e-08 $layer=M1 $thickness=3.6e-08
+ $X=1.0805 $Y=0.072 $X2=1.0935 $Y2=0.072
r106 91 233 1.96775 $w=1.63333e-08 $l=1.35e-08 $layer=M1 $thickness=3.6e-08
+ $X=1.107 $Y=0.072 $X2=1.107 $Y2=0.0855
r107 91 247 1.96775 $w=1.63333e-08 $l=1.35e-08 $layer=M1 $thickness=3.6e-08
+ $X=1.107 $Y=0.072 $X2=1.0935 $Y2=0.072
r108 245 243 0.0308642 $w=8.1e-08 $l=2.5e-09 $layer=N_src_drn $thickness=1e-09
+ $X=0.9893 $Y=0.0675 $X2=0.9865 $Y2=0.0675
r109 9 243 0.179012 $w=8.1e-08 $l=1.45e-08 $layer=N_src_drn $thickness=1e-09
+ $X=0.972 $Y=0.0675 $X2=0.9865 $Y2=0.0675
r110 65 9 0.179012 $w=8.1e-08 $l=1.45e-08 $layer=N_src_drn $thickness=1e-09
+ $X=0.9575 $Y=0.0675 $X2=0.972 $Y2=0.0675
r111 244 65 0.0308642 $w=8.1e-08 $l=2.5e-09 $layer=N_src_drn $thickness=1e-09
+ $X=0.9546 $Y=0.0675 $X2=0.9575 $Y2=0.0675
r112 241 239 0.0308642 $w=8.1e-08 $l=2.5e-09 $layer=P_src_drn $thickness=1e-09
+ $X=1.0973 $Y=0.2025 $X2=1.0945 $Y2=0.2025
r113 12 239 0.179012 $w=8.1e-08 $l=1.45e-08 $layer=P_src_drn $thickness=1e-09
+ $X=1.08 $Y=0.2025 $X2=1.0945 $Y2=0.2025
r114 76 12 0.179012 $w=8.1e-08 $l=1.45e-08 $layer=P_src_drn $thickness=1e-09
+ $X=1.0655 $Y=0.2025 $X2=1.08 $Y2=0.2025
r115 240 76 0.0308642 $w=8.1e-08 $l=2.5e-09 $layer=P_src_drn $thickness=1e-09
+ $X=1.0626 $Y=0.2025 $X2=1.0655 $Y2=0.2025
r116 236 237 6.06293 $w=1.3e-08 $l=2.6e-08 $layer=M1 $thickness=3.6e-08
+ $X=1.321 $Y=0.234 $X2=1.347 $Y2=0.234
r117 235 236 1.86552 $w=1.3e-08 $l=8e-09 $layer=M1 $thickness=3.6e-08 $X=1.313
+ $Y=0.234 $X2=1.321 $Y2=0.234
r118 234 235 18.7718 $w=1.3e-08 $l=8.05e-08 $layer=M1 $thickness=3.6e-08
+ $X=1.2325 $Y=0.234 $X2=1.313 $Y2=0.234
r119 112 234 22.6194 $w=1.3e-08 $l=9.7e-08 $layer=M1 $thickness=3.6e-08
+ $X=1.1355 $Y=0.234 $X2=1.2325 $Y2=0.234
r120 232 233 3.14806 $w=1.3e-08 $l=1.35e-08 $layer=M1 $thickness=3.6e-08
+ $X=1.107 $Y=0.099 $X2=1.107 $Y2=0.0855
r121 231 232 4.19742 $w=1.3e-08 $l=1.8e-08 $layer=M1 $thickness=3.6e-08
+ $X=1.107 $Y=0.117 $X2=1.107 $Y2=0.099
r122 230 231 4.19742 $w=1.3e-08 $l=1.8e-08 $layer=M1 $thickness=3.6e-08
+ $X=1.107 $Y=0.135 $X2=1.107 $Y2=0.117
r123 229 230 4.19742 $w=1.3e-08 $l=1.8e-08 $layer=M1 $thickness=3.6e-08
+ $X=1.107 $Y=0.153 $X2=1.107 $Y2=0.135
r124 228 229 4.19742 $w=1.3e-08 $l=1.8e-08 $layer=M1 $thickness=3.6e-08
+ $X=1.107 $Y=0.171 $X2=1.107 $Y2=0.153
r125 111 228 7.34548 $w=1.3e-08 $l=3.15e-08 $layer=M1 $thickness=3.6e-08
+ $X=1.107 $Y=0.2025 $X2=1.107 $Y2=0.171
r126 227 225 0.0308642 $w=8.1e-08 $l=2.5e-09 $layer=P_src_drn $thickness=1e-09
+ $X=0.9893 $Y=0.2025 $X2=0.9865 $Y2=0.2025
r127 10 225 0.179012 $w=8.1e-08 $l=1.45e-08 $layer=P_src_drn $thickness=1e-09
+ $X=0.972 $Y=0.2025 $X2=0.9865 $Y2=0.2025
r128 75 10 0.179012 $w=8.1e-08 $l=1.45e-08 $layer=P_src_drn $thickness=1e-09
+ $X=0.9575 $Y=0.2025 $X2=0.972 $Y2=0.2025
r129 226 75 0.0308642 $w=8.1e-08 $l=2.5e-09 $layer=P_src_drn $thickness=1e-09
+ $X=0.9546 $Y=0.2025 $X2=0.9575 $Y2=0.2025
r130 9 221 19.3796 $a=3.24e-16 $layer=V0LISD $X=0.972 $Y=0.0675 $X2=0.9715
+ $Y2=0.072
r131 12 214 19.3796 $a=3.24e-16 $layer=V0LISD $X=1.08 $Y=0.2025 $X2=1.0805
+ $Y2=0.234
r132 92 215 1.96775 $w=1.63333e-08 $l=1.35e-08 $layer=M1 $thickness=3.6e-08
+ $X=1.107 $Y=0.234 $X2=1.0935 $Y2=0.234
r133 92 111 6.16517 $w=1.44286e-08 $l=3.15e-08 $layer=M1 $thickness=3.6e-08
+ $X=1.107 $Y=0.234 $X2=1.107 $Y2=0.2025
r134 92 112 5.4656 $w=1.45789e-08 $l=2.85e-08 $layer=M1 $thickness=3.6e-08
+ $X=1.107 $Y=0.234 $X2=1.1355 $Y2=0.234
r135 10 210 19.3796 $a=3.24e-16 $layer=V0LISD $X=0.972 $Y=0.2025 $X2=0.9715
+ $Y2=0.234
r136 220 221 3.03147 $w=1.3e-08 $l=1.3e-08 $layer=M1 $thickness=3.6e-08
+ $X=0.9585 $Y=0.072 $X2=0.9715 $Y2=0.072
r137 89 209 1.96775 $w=1.63333e-08 $l=1.35e-08 $layer=M1 $thickness=3.6e-08
+ $X=0.945 $Y=0.072 $X2=0.945 $Y2=0.0855
r138 89 220 1.96775 $w=1.63333e-08 $l=1.35e-08 $layer=M1 $thickness=3.6e-08
+ $X=0.945 $Y=0.072 $X2=0.9585 $Y2=0.072
r139 219 217 0.0308642 $w=8.1e-08 $l=2.5e-09 $layer=N_src_drn $thickness=1e-09
+ $X=0.6653 $Y=0.0675 $X2=0.6625 $Y2=0.0675
r140 7 217 0.179012 $w=8.1e-08 $l=1.45e-08 $layer=N_src_drn $thickness=1e-09
+ $X=0.648 $Y=0.0675 $X2=0.6625 $Y2=0.0675
r141 64 7 0.179012 $w=8.1e-08 $l=1.45e-08 $layer=N_src_drn $thickness=1e-09
+ $X=0.6335 $Y=0.0675 $X2=0.648 $Y2=0.0675
r142 218 64 0.0308642 $w=8.1e-08 $l=2.5e-09 $layer=N_src_drn $thickness=1e-09
+ $X=0.6306 $Y=0.0675 $X2=0.6335 $Y2=0.0675
r143 214 215 3.03147 $w=1.3e-08 $l=1.3e-08 $layer=M1 $thickness=3.6e-08
+ $X=1.0805 $Y=0.234 $X2=1.0935 $Y2=0.234
r144 213 214 2.09871 $w=1.3e-08 $l=9e-09 $layer=M1 $thickness=3.6e-08 $X=1.0715
+ $Y=0.234 $X2=1.0805 $Y2=0.234
r145 212 213 10.6101 $w=1.3e-08 $l=4.55e-08 $layer=M1 $thickness=3.6e-08
+ $X=1.026 $Y=0.234 $X2=1.0715 $Y2=0.234
r146 211 212 10.6101 $w=1.3e-08 $l=4.55e-08 $layer=M1 $thickness=3.6e-08
+ $X=0.9805 $Y=0.234 $X2=1.026 $Y2=0.234
r147 210 211 2.09871 $w=1.3e-08 $l=9e-09 $layer=M1 $thickness=3.6e-08 $X=0.9715
+ $Y=0.234 $X2=0.9805 $Y2=0.234
r148 110 210 3.03147 $w=1.3e-08 $l=1.3e-08 $layer=M1 $thickness=3.6e-08
+ $X=0.9585 $Y=0.234 $X2=0.9715 $Y2=0.234
r149 208 209 3.14806 $w=1.3e-08 $l=1.35e-08 $layer=M1 $thickness=3.6e-08
+ $X=0.945 $Y=0.099 $X2=0.945 $Y2=0.0855
r150 207 208 4.19742 $w=1.3e-08 $l=1.8e-08 $layer=M1 $thickness=3.6e-08
+ $X=0.945 $Y=0.117 $X2=0.945 $Y2=0.099
r151 206 207 4.19742 $w=1.3e-08 $l=1.8e-08 $layer=M1 $thickness=3.6e-08
+ $X=0.945 $Y=0.135 $X2=0.945 $Y2=0.117
r152 205 206 4.19742 $w=1.3e-08 $l=1.8e-08 $layer=M1 $thickness=3.6e-08
+ $X=0.945 $Y=0.153 $X2=0.945 $Y2=0.135
r153 204 205 4.19742 $w=1.3e-08 $l=1.8e-08 $layer=M1 $thickness=3.6e-08
+ $X=0.945 $Y=0.171 $X2=0.945 $Y2=0.153
r154 109 204 7.34548 $w=1.3e-08 $l=3.15e-08 $layer=M1 $thickness=3.6e-08
+ $X=0.945 $Y=0.2025 $X2=0.945 $Y2=0.171
r155 7 201 19.3796 $a=3.24e-16 $layer=V0LISD $X=0.648 $Y=0.0675 $X2=0.648
+ $Y2=0.072
r156 90 192 5.4656 $w=1.45789e-08 $l=2.85e-08 $layer=M1 $thickness=3.6e-08
+ $X=0.945 $Y=0.234 $X2=0.9165 $Y2=0.234
r157 90 109 6.16517 $w=1.44286e-08 $l=3.15e-08 $layer=M1 $thickness=3.6e-08
+ $X=0.945 $Y=0.234 $X2=0.945 $Y2=0.2025
r158 90 110 1.96775 $w=1.63333e-08 $l=1.35e-08 $layer=M1 $thickness=3.6e-08
+ $X=0.945 $Y=0.234 $X2=0.9585 $Y2=0.234
r159 201 202 3.14806 $w=1.3e-08 $l=1.35e-08 $layer=M1 $thickness=3.6e-08
+ $X=0.648 $Y=0.072 $X2=0.6615 $Y2=0.072
r160 87 188 1.96775 $w=1.63333e-08 $l=1.35e-08 $layer=M1 $thickness=3.6e-08
+ $X=0.675 $Y=0.072 $X2=0.675 $Y2=0.0855
r161 87 202 1.96775 $w=1.63333e-08 $l=1.35e-08 $layer=M1 $thickness=3.6e-08
+ $X=0.675 $Y=0.072 $X2=0.6615 $Y2=0.072
r162 200 198 0.0308642 $w=8.1e-08 $l=2.5e-09 $layer=N_src_drn $thickness=1e-09
+ $X=0.5573 $Y=0.0675 $X2=0.5545 $Y2=0.0675
r163 5 198 0.179012 $w=8.1e-08 $l=1.45e-08 $layer=N_src_drn $thickness=1e-09
+ $X=0.54 $Y=0.0675 $X2=0.5545 $Y2=0.0675
r164 63 5 0.179012 $w=8.1e-08 $l=1.45e-08 $layer=N_src_drn $thickness=1e-09
+ $X=0.5255 $Y=0.0675 $X2=0.54 $Y2=0.0675
r165 199 63 0.0308642 $w=8.1e-08 $l=2.5e-09 $layer=N_src_drn $thickness=1e-09
+ $X=0.5226 $Y=0.0675 $X2=0.5255 $Y2=0.0675
r166 196 194 0.0308642 $w=8.1e-08 $l=2.5e-09 $layer=P_src_drn $thickness=1e-09
+ $X=0.6653 $Y=0.2025 $X2=0.6625 $Y2=0.2025
r167 8 194 0.179012 $w=8.1e-08 $l=1.45e-08 $layer=P_src_drn $thickness=1e-09
+ $X=0.648 $Y=0.2025 $X2=0.6625 $Y2=0.2025
r168 74 8 0.179012 $w=8.1e-08 $l=1.45e-08 $layer=P_src_drn $thickness=1e-09
+ $X=0.6335 $Y=0.2025 $X2=0.648 $Y2=0.2025
r169 195 74 0.0308642 $w=8.1e-08 $l=2.5e-09 $layer=P_src_drn $thickness=1e-09
+ $X=0.6306 $Y=0.2025 $X2=0.6335 $Y2=0.2025
r170 191 192 22.6194 $w=1.3e-08 $l=9.7e-08 $layer=M1 $thickness=3.6e-08
+ $X=0.8195 $Y=0.234 $X2=0.9165 $Y2=0.234
r171 190 191 18.7718 $w=1.3e-08 $l=8.05e-08 $layer=M1 $thickness=3.6e-08
+ $X=0.739 $Y=0.234 $X2=0.8195 $Y2=0.234
r172 189 190 1.86552 $w=1.3e-08 $l=8e-09 $layer=M1 $thickness=3.6e-08 $X=0.731
+ $Y=0.234 $X2=0.739 $Y2=0.234
r173 108 189 6.06293 $w=1.3e-08 $l=2.6e-08 $layer=M1 $thickness=3.6e-08
+ $X=0.705 $Y=0.234 $X2=0.731 $Y2=0.234
r174 187 188 3.14806 $w=1.3e-08 $l=1.35e-08 $layer=M1 $thickness=3.6e-08
+ $X=0.675 $Y=0.099 $X2=0.675 $Y2=0.0855
r175 186 187 4.19742 $w=1.3e-08 $l=1.8e-08 $layer=M1 $thickness=3.6e-08
+ $X=0.675 $Y=0.117 $X2=0.675 $Y2=0.099
r176 185 186 4.19742 $w=1.3e-08 $l=1.8e-08 $layer=M1 $thickness=3.6e-08
+ $X=0.675 $Y=0.135 $X2=0.675 $Y2=0.117
r177 184 185 4.19742 $w=1.3e-08 $l=1.8e-08 $layer=M1 $thickness=3.6e-08
+ $X=0.675 $Y=0.153 $X2=0.675 $Y2=0.135
r178 183 184 4.19742 $w=1.3e-08 $l=1.8e-08 $layer=M1 $thickness=3.6e-08
+ $X=0.675 $Y=0.171 $X2=0.675 $Y2=0.153
r179 107 183 7.34548 $w=1.3e-08 $l=3.15e-08 $layer=M1 $thickness=3.6e-08
+ $X=0.675 $Y=0.2025 $X2=0.675 $Y2=0.171
r180 182 180 0.0308642 $w=8.1e-08 $l=2.5e-09 $layer=P_src_drn $thickness=1e-09
+ $X=0.5573 $Y=0.2025 $X2=0.5545 $Y2=0.2025
r181 6 180 0.179012 $w=8.1e-08 $l=1.45e-08 $layer=P_src_drn $thickness=1e-09
+ $X=0.54 $Y=0.2025 $X2=0.5545 $Y2=0.2025
r182 73 6 0.179012 $w=8.1e-08 $l=1.45e-08 $layer=P_src_drn $thickness=1e-09
+ $X=0.5255 $Y=0.2025 $X2=0.54 $Y2=0.2025
r183 181 73 0.0308642 $w=8.1e-08 $l=2.5e-09 $layer=P_src_drn $thickness=1e-09
+ $X=0.5226 $Y=0.2025 $X2=0.5255 $Y2=0.2025
r184 5 176 19.3796 $a=3.24e-16 $layer=V0LISD $X=0.54 $Y=0.0675 $X2=0.539
+ $Y2=0.072
r185 8 169 19.3796 $a=3.24e-16 $layer=V0LISD $X=0.648 $Y=0.2025 $X2=0.648
+ $Y2=0.234
r186 88 170 1.96775 $w=1.63333e-08 $l=1.35e-08 $layer=M1 $thickness=3.6e-08
+ $X=0.675 $Y=0.234 $X2=0.6615 $Y2=0.234
r187 88 107 6.16517 $w=1.44286e-08 $l=3.15e-08 $layer=M1 $thickness=3.6e-08
+ $X=0.675 $Y=0.234 $X2=0.675 $Y2=0.2025
r188 88 108 5.81538 $w=1.45e-08 $l=3e-08 $layer=M1 $thickness=3.6e-08 $X=0.675
+ $Y=0.234 $X2=0.705 $Y2=0.234
r189 6 166 19.3796 $a=3.24e-16 $layer=V0LISD $X=0.54 $Y=0.2025 $X2=0.539
+ $Y2=0.234
r190 175 176 2.91487 $w=1.3e-08 $l=1.25e-08 $layer=M1 $thickness=3.6e-08
+ $X=0.5265 $Y=0.072 $X2=0.539 $Y2=0.072
r191 85 165 1.96775 $w=1.63333e-08 $l=1.35e-08 $layer=M1 $thickness=3.6e-08
+ $X=0.513 $Y=0.072 $X2=0.513 $Y2=0.0855
r192 85 175 1.96775 $w=1.63333e-08 $l=1.35e-08 $layer=M1 $thickness=3.6e-08
+ $X=0.513 $Y=0.072 $X2=0.5265 $Y2=0.072
r193 174 172 0.0308642 $w=8.1e-08 $l=2.5e-09 $layer=N_src_drn $thickness=1e-09
+ $X=0.2333 $Y=0.0675 $X2=0.2305 $Y2=0.0675
r194 3 172 0.179012 $w=8.1e-08 $l=1.45e-08 $layer=N_src_drn $thickness=1e-09
+ $X=0.216 $Y=0.0675 $X2=0.2305 $Y2=0.0675
r195 62 3 0.179012 $w=8.1e-08 $l=1.45e-08 $layer=N_src_drn $thickness=1e-09
+ $X=0.2015 $Y=0.0675 $X2=0.216 $Y2=0.0675
r196 173 62 0.0308642 $w=8.1e-08 $l=2.5e-09 $layer=N_src_drn $thickness=1e-09
+ $X=0.1986 $Y=0.0675 $X2=0.2015 $Y2=0.0675
r197 169 170 3.14806 $w=1.3e-08 $l=1.35e-08 $layer=M1 $thickness=3.6e-08
+ $X=0.648 $Y=0.234 $X2=0.6615 $Y2=0.234
r198 168 169 12.5922 $w=1.3e-08 $l=5.4e-08 $layer=M1 $thickness=3.6e-08
+ $X=0.594 $Y=0.234 $X2=0.648 $Y2=0.234
r199 167 168 10.7267 $w=1.3e-08 $l=4.6e-08 $layer=M1 $thickness=3.6e-08
+ $X=0.548 $Y=0.234 $X2=0.594 $Y2=0.234
r200 166 167 2.09871 $w=1.3e-08 $l=9e-09 $layer=M1 $thickness=3.6e-08 $X=0.539
+ $Y=0.234 $X2=0.548 $Y2=0.234
r201 106 166 2.91487 $w=1.3e-08 $l=1.25e-08 $layer=M1 $thickness=3.6e-08
+ $X=0.5265 $Y=0.234 $X2=0.539 $Y2=0.234
r202 164 165 3.14806 $w=1.3e-08 $l=1.35e-08 $layer=M1 $thickness=3.6e-08
+ $X=0.513 $Y=0.099 $X2=0.513 $Y2=0.0855
r203 163 164 4.19742 $w=1.3e-08 $l=1.8e-08 $layer=M1 $thickness=3.6e-08
+ $X=0.513 $Y=0.117 $X2=0.513 $Y2=0.099
r204 162 163 4.19742 $w=1.3e-08 $l=1.8e-08 $layer=M1 $thickness=3.6e-08
+ $X=0.513 $Y=0.135 $X2=0.513 $Y2=0.117
r205 161 162 4.19742 $w=1.3e-08 $l=1.8e-08 $layer=M1 $thickness=3.6e-08
+ $X=0.513 $Y=0.153 $X2=0.513 $Y2=0.135
r206 160 161 4.19742 $w=1.3e-08 $l=1.8e-08 $layer=M1 $thickness=3.6e-08
+ $X=0.513 $Y=0.171 $X2=0.513 $Y2=0.153
r207 105 160 7.34548 $w=1.3e-08 $l=3.15e-08 $layer=M1 $thickness=3.6e-08
+ $X=0.513 $Y=0.2025 $X2=0.513 $Y2=0.171
r208 3 156 19.3796 $a=3.24e-16 $layer=V0LISD $X=0.216 $Y=0.0675 $X2=0.2165
+ $Y2=0.072
r209 86 151 5.4656 $w=1.45789e-08 $l=2.85e-08 $layer=M1 $thickness=3.6e-08
+ $X=0.513 $Y=0.234 $X2=0.4845 $Y2=0.234
r210 86 105 6.16517 $w=1.44286e-08 $l=3.15e-08 $layer=M1 $thickness=3.6e-08
+ $X=0.513 $Y=0.234 $X2=0.513 $Y2=0.2025
r211 86 106 1.96775 $w=1.63333e-08 $l=1.35e-08 $layer=M1 $thickness=3.6e-08
+ $X=0.513 $Y=0.234 $X2=0.5265 $Y2=0.234
r212 156 157 3.03147 $w=1.3e-08 $l=1.3e-08 $layer=M1 $thickness=3.6e-08
+ $X=0.2165 $Y=0.072 $X2=0.2295 $Y2=0.072
r213 83 147 1.96775 $w=1.63333e-08 $l=1.35e-08 $layer=M1 $thickness=3.6e-08
+ $X=0.243 $Y=0.072 $X2=0.243 $Y2=0.0855
r214 83 157 1.96775 $w=1.63333e-08 $l=1.35e-08 $layer=M1 $thickness=3.6e-08
+ $X=0.243 $Y=0.072 $X2=0.2295 $Y2=0.072
r215 155 153 0.0308642 $w=8.1e-08 $l=2.5e-09 $layer=P_src_drn $thickness=1e-09
+ $X=0.2333 $Y=0.2025 $X2=0.2305 $Y2=0.2025
r216 4 153 0.179012 $w=8.1e-08 $l=1.45e-08 $layer=P_src_drn $thickness=1e-09
+ $X=0.216 $Y=0.2025 $X2=0.2305 $Y2=0.2025
r217 72 4 0.179012 $w=8.1e-08 $l=1.45e-08 $layer=P_src_drn $thickness=1e-09
+ $X=0.2015 $Y=0.2025 $X2=0.216 $Y2=0.2025
r218 154 72 0.0308642 $w=8.1e-08 $l=2.5e-09 $layer=P_src_drn $thickness=1e-09
+ $X=0.1986 $Y=0.2025 $X2=0.2015 $Y2=0.2025
r219 150 151 22.6194 $w=1.3e-08 $l=9.7e-08 $layer=M1 $thickness=3.6e-08
+ $X=0.3875 $Y=0.234 $X2=0.4845 $Y2=0.234
r220 149 150 18.7718 $w=1.3e-08 $l=8.05e-08 $layer=M1 $thickness=3.6e-08
+ $X=0.307 $Y=0.234 $X2=0.3875 $Y2=0.234
r221 148 149 1.86552 $w=1.3e-08 $l=8e-09 $layer=M1 $thickness=3.6e-08 $X=0.299
+ $Y=0.234 $X2=0.307 $Y2=0.234
r222 104 148 6.06293 $w=1.3e-08 $l=2.6e-08 $layer=M1 $thickness=3.6e-08
+ $X=0.273 $Y=0.234 $X2=0.299 $Y2=0.234
r223 146 147 3.14806 $w=1.3e-08 $l=1.35e-08 $layer=M1 $thickness=3.6e-08
+ $X=0.243 $Y=0.099 $X2=0.243 $Y2=0.0855
r224 145 146 4.19742 $w=1.3e-08 $l=1.8e-08 $layer=M1 $thickness=3.6e-08
+ $X=0.243 $Y=0.117 $X2=0.243 $Y2=0.099
r225 144 145 4.19742 $w=1.3e-08 $l=1.8e-08 $layer=M1 $thickness=3.6e-08
+ $X=0.243 $Y=0.135 $X2=0.243 $Y2=0.117
r226 143 144 4.19742 $w=1.3e-08 $l=1.8e-08 $layer=M1 $thickness=3.6e-08
+ $X=0.243 $Y=0.153 $X2=0.243 $Y2=0.135
r227 142 143 4.19742 $w=1.3e-08 $l=1.8e-08 $layer=M1 $thickness=3.6e-08
+ $X=0.243 $Y=0.171 $X2=0.243 $Y2=0.153
r228 140 141 1.80722 $w=1.3e-08 $l=7.7e-09 $layer=M1 $thickness=3.6e-08
+ $X=0.243 $Y=0.21 $X2=0.243 $Y2=0.2177
r229 140 103 3.55614 $w=1.3e-08 $l=1.53e-08 $layer=M1 $thickness=3.6e-08
+ $X=0.243 $Y=0.21 $X2=0.243 $Y2=0.1947
r230 103 142 5.53826 $w=1.3e-08 $l=2.37e-08 $layer=M1 $thickness=3.6e-08
+ $X=0.243 $Y=0.1947 $X2=0.243 $Y2=0.171
r231 139 137 0.0308642 $w=8.1e-08 $l=2.5e-09 $layer=P_src_drn $thickness=1e-09
+ $X=0.1253 $Y=0.2025 $X2=0.1225 $Y2=0.2025
r232 2 137 0.179012 $w=8.1e-08 $l=1.45e-08 $layer=P_src_drn $thickness=1e-09
+ $X=0.108 $Y=0.2025 $X2=0.1225 $Y2=0.2025
r233 71 2 0.179012 $w=8.1e-08 $l=1.45e-08 $layer=P_src_drn $thickness=1e-09
+ $X=0.0935 $Y=0.2025 $X2=0.108 $Y2=0.2025
r234 138 71 0.0308642 $w=8.1e-08 $l=2.5e-09 $layer=P_src_drn $thickness=1e-09
+ $X=0.0906 $Y=0.2025 $X2=0.0935 $Y2=0.2025
r235 4 134 19.3796 $a=3.24e-16 $layer=V0LISD $X=0.216 $Y=0.2025 $X2=0.2165
+ $Y2=0.234
r236 84 135 1.96775 $w=1.63333e-08 $l=1.35e-08 $layer=M1 $thickness=3.6e-08
+ $X=0.243 $Y=0.234 $X2=0.2295 $Y2=0.234
r237 84 141 2.60903 $w=1.57692e-08 $l=1.63e-08 $layer=M1 $thickness=3.6e-08
+ $X=0.243 $Y=0.234 $X2=0.243 $Y2=0.2177
r238 84 104 5.81538 $w=1.45e-08 $l=3e-08 $layer=M1 $thickness=3.6e-08 $X=0.243
+ $Y=0.234 $X2=0.273 $Y2=0.234
r239 2 129 19.3796 $a=3.24e-16 $layer=V0LISD $X=0.108 $Y=0.2025 $X2=0.108
+ $Y2=0.234
r240 134 135 3.03147 $w=1.3e-08 $l=1.3e-08 $layer=M1 $thickness=3.6e-08
+ $X=0.2165 $Y=0.234 $X2=0.2295 $Y2=0.234
r241 133 134 2.09871 $w=1.3e-08 $l=9e-09 $layer=M1 $thickness=3.6e-08 $X=0.2075
+ $Y=0.234 $X2=0.2165 $Y2=0.234
r242 132 133 9.56078 $w=1.3e-08 $l=4.1e-08 $layer=M1 $thickness=3.6e-08
+ $X=0.1665 $Y=0.234 $X2=0.2075 $Y2=0.234
r243 131 132 9.91056 $w=1.3e-08 $l=4.25e-08 $layer=M1 $thickness=3.6e-08
+ $X=0.124 $Y=0.234 $X2=0.1665 $Y2=0.234
r244 130 131 1.04935 $w=1.3e-08 $l=4.5e-09 $layer=M1 $thickness=3.6e-08
+ $X=0.1195 $Y=0.234 $X2=0.124 $Y2=0.234
r245 129 130 2.68168 $w=1.3e-08 $l=1.15e-08 $layer=M1 $thickness=3.6e-08
+ $X=0.108 $Y=0.234 $X2=0.1195 $Y2=0.234
r246 102 129 3.14806 $w=1.3e-08 $l=1.35e-08 $layer=M1 $thickness=3.6e-08
+ $X=0.0945 $Y=0.234 $X2=0.108 $Y2=0.234
r247 82 128 9.89378 $w=1.47818e-08 $l=4.95e-08 $layer=M1 $thickness=3.6e-08
+ $X=0.081 $Y=0.234 $X2=0.081 $Y2=0.1845
r248 82 102 1.49895 $w=1.63333e-08 $l=1.35e-08 $layer=M1 $thickness=3.6e-08
+ $X=0.081 $Y=0.234 $X2=0.0945 $Y2=0.234
r249 127 128 11.5429 $w=1.3e-08 $l=4.95e-08 $layer=M1 $thickness=3.6e-08
+ $X=0.081 $Y=0.135 $X2=0.081 $Y2=0.1845
r250 101 126 6.16517 $w=1.44286e-08 $l=3.15e-08 $layer=M1 $thickness=3.6e-08
+ $X=0.081 $Y=0.1035 $X2=0.081 $Y2=0.072
r251 101 127 7.34548 $w=1.3e-08 $l=3.15e-08 $layer=M1 $thickness=3.6e-08
+ $X=0.081 $Y=0.1035 $X2=0.081 $Y2=0.135
r252 81 124 3.14806 $w=1.3e-08 $l=1.35e-08 $layer=M1 $thickness=3.6e-08
+ $X=0.0945 $Y=0.072 $X2=0.108 $Y2=0.072
r253 81 126 1.96775 $w=1.63333e-08 $l=1.35e-08 $layer=M1 $thickness=3.6e-08
+ $X=0.0945 $Y=0.072 $X2=0.081 $Y2=0.072
r254 1 124 19.3796 $a=3.24e-16 $layer=V0LISD $X=0.108 $Y=0.0675 $X2=0.108
+ $Y2=0.072
r255 123 121 0.0308642 $w=8.1e-08 $l=2.5e-09 $layer=N_src_drn $thickness=1e-09
+ $X=0.1253 $Y=0.0675 $X2=0.1225 $Y2=0.0675
r256 1 121 0.179012 $w=8.1e-08 $l=1.45e-08 $layer=N_src_drn $thickness=1e-09
+ $X=0.108 $Y=0.0675 $X2=0.1225 $Y2=0.0675
r257 61 1 0.179012 $w=8.1e-08 $l=1.45e-08 $layer=N_src_drn $thickness=1e-09
+ $X=0.0935 $Y=0.0675 $X2=0.108 $Y2=0.0675
r258 122 61 0.0308642 $w=8.1e-08 $l=2.5e-09 $layer=N_src_drn $thickness=1e-09
+ $X=0.0906 $Y=0.0675 $X2=0.0935 $Y2=0.0675
.ends

.subckt PM_CKINVDCx20_ASAP7_75t_R%5 vss 19 23 33 36 46 47 50 51 10 15 17 3 1 11
+ 13 9 4 18
c1 1 vss 0.00633096f $X=0.405 $Y=0.135
c2 3 vss 0.00722262f $X=0.324 $Y=0.2025
c3 4 vss 0.0071674f $X=0.432 $Y=0.2025
c4 9 vss 0.0821923f $X=0.405 $Y=0.0245
c5 10 vss 0.0824044f $X=0.459 $Y=0.135
c6 11 vss 0.00726485f $X=0.3095 $Y=0.2025
c7 12 vss 0.00674402f $X=0.4175 $Y=0.2025
c8 13 vss 0.000209968f $X=0.405 $Y=0.135
c9 14 vss 0.000356816f $X=0.405 $Y=0.171
c10 15 vss 0.00259f $X=0.378 $Y=0.171
c11 16 vss 0.000149614f $X=0.405 $Y=0.153
c12 17 vss 0.000708835f $X=0.4185 $Y=0.135
c13 18 vss 0.00134042f $X=0.4185 $Y=0.171
r1 51 49 0.0308642 $w=8.1e-08 $l=2.5e-09 $layer=P_src_drn $thickness=1e-09
+ $X=0.4493 $Y=0.2025 $X2=0.4465 $Y2=0.2025
r2 4 49 0.179012 $w=8.1e-08 $l=1.45e-08 $layer=P_src_drn $thickness=1e-09
+ $X=0.432 $Y=0.2025 $X2=0.4465 $Y2=0.2025
r3 12 4 0.179012 $w=8.1e-08 $l=1.45e-08 $layer=P_src_drn $thickness=1e-09
+ $X=0.4175 $Y=0.2025 $X2=0.432 $Y2=0.2025
r4 50 12 0.0308642 $w=8.1e-08 $l=2.5e-09 $layer=P_src_drn $thickness=1e-09
+ $X=0.4146 $Y=0.2025 $X2=0.4175 $Y2=0.2025
r5 47 45 0.0308642 $w=8.1e-08 $l=2.5e-09 $layer=P_src_drn $thickness=1e-09
+ $X=0.3413 $Y=0.2025 $X2=0.3385 $Y2=0.2025
r6 3 45 0.179012 $w=8.1e-08 $l=1.45e-08 $layer=P_src_drn $thickness=1e-09
+ $X=0.324 $Y=0.2025 $X2=0.3385 $Y2=0.2025
r7 11 3 0.179012 $w=8.1e-08 $l=1.45e-08 $layer=P_src_drn $thickness=1e-09
+ $X=0.3095 $Y=0.2025 $X2=0.324 $Y2=0.2025
r8 46 11 0.0308642 $w=8.1e-08 $l=2.5e-09 $layer=P_src_drn $thickness=1e-09
+ $X=0.3066 $Y=0.2025 $X2=0.3095 $Y2=0.2025
r9 4 41 19.3796 $a=3.24e-16 $layer=V0LISD $X=0.432 $Y=0.2025 $X2=0.432 $Y2=0.171
r10 3 39 19.3796 $a=3.24e-16 $layer=V0LISD $X=0.324 $Y=0.2025 $X2=0.324
+ $Y2=0.171
r11 18 41 3.14806 $w=1.3e-08 $l=1.35e-08 $layer=M1 $thickness=3.6e-08 $X=0.4185
+ $Y=0.171 $X2=0.432 $Y2=0.171
r12 39 40 5.24677 $w=1.3e-08 $l=2.25e-08 $layer=M1 $thickness=3.6e-08 $X=0.324
+ $Y=0.171 $X2=0.3465 $Y2=0.171
r13 15 40 7.34548 $w=1.3e-08 $l=3.15e-08 $layer=M1 $thickness=3.6e-08 $X=0.378
+ $Y=0.171 $X2=0.3465 $Y2=0.171
r14 14 16 3.01711 $w=1.55e-08 $l=1.8e-08 $layer=M1 $thickness=3.6e-08 $X=0.405
+ $Y=0.171 $X2=0.405 $Y2=0.153
r15 14 15 5.11582 $w=1.46667e-08 $l=2.7e-08 $layer=M1 $thickness=3.6e-08
+ $X=0.405 $Y=0.171 $X2=0.378 $Y2=0.171
r16 14 18 1.96775 $w=1.63333e-08 $l=1.35e-08 $layer=M1 $thickness=3.6e-08
+ $X=0.405 $Y=0.171 $X2=0.4185 $Y2=0.171
r17 13 17 1.49895 $w=1.63333e-08 $l=1.35e-08 $layer=M1 $thickness=3.6e-08
+ $X=0.405 $Y=0.135 $X2=0.4185 $Y2=0.135
r18 13 16 2.5483 $w=1.79e-08 $l=1.8e-08 $layer=M1 $thickness=3.6e-08 $X=0.405
+ $Y=0.135 $X2=0.405 $Y2=0.153
r19 36 35 16.4967 $w=2.1e-08 $l=4.85e-08 $layer=Gate_1 $thickness=5.6e-08
+ $X=0.459 $Y=0.2025 $X2=0.459 $Y2=0.154
r20 33 34 16.4967 $w=2.1e-08 $l=4.85e-08 $layer=Gate_1 $thickness=5.6e-08
+ $X=0.459 $Y=0.0675 $X2=0.459 $Y2=0.116
r21 10 27 6.54019 $w=2.09524e-08 $layer=Gate_1 $thickness=5.21905e-08 $X=0.459
+ $Y=0.135 $X2=0.459 $Y2=0.135
r22 10 34 6.6497 $w=2.04211e-08 $l=1.9e-08 $layer=Gate_1 $thickness=5.6e-08
+ $X=0.459 $Y=0.135 $X2=0.459 $Y2=0.116
r23 10 35 6.6497 $w=2.04211e-08 $l=1.9e-08 $layer=Gate_1 $thickness=5.6e-08
+ $X=0.459 $Y=0.135 $X2=0.459 $Y2=0.154
r24 17 29 3.14806 $w=1.3e-08 $l=1.35e-08 $layer=M1 $thickness=3.6e-08 $X=0.4185
+ $Y=0.135 $X2=0.432 $Y2=0.135
r25 26 27 12.6539 $w=1.77815e-08 $l=2.7e-08 $layer=LIG $thickness=4.8e-08
+ $X=0.432 $Y=0.135 $X2=0.459 $Y2=0.135
r26 26 29 19.3796 $a=3.24e-16 $layer=V0LIG $X=0.432 $Y=0.135 $X2=0.432 $Y2=0.135
r27 1 21 6.54019 $w=2.09524e-08 $layer=Gate_1 $thickness=5.21905e-08 $X=0.405
+ $Y=0.135 $X2=0.405 $Y2=0.135
r28 1 26 12.6539 $w=1.77815e-08 $l=2.7e-08 $layer=LIG $thickness=4.8e-08
+ $X=0.405 $Y=0.135 $X2=0.432 $Y2=0.135
r29 23 22 16.4967 $w=2.1e-08 $l=4.85e-08 $layer=Gate_1 $thickness=5.6e-08
+ $X=0.405 $Y=0.2025 $X2=0.405 $Y2=0.154
r30 21 22 6.6497 $w=2.04211e-08 $l=1.9e-08 $layer=Gate_1 $thickness=5.6e-08
+ $X=0.405 $Y=0.135 $X2=0.405 $Y2=0.154
r31 20 21 6.6497 $w=2.04211e-08 $l=1.9e-08 $layer=Gate_1 $thickness=5.6e-08
+ $X=0.405 $Y=0.116 $X2=0.405 $Y2=0.135
r32 19 20 16.4967 $w=2.1e-08 $l=4.85e-08 $layer=Gate_1 $thickness=5.6e-08
+ $X=0.405 $Y=0.0675 $X2=0.405 $Y2=0.116
r33 19 9 14.6259 $w=2.1e-08 $l=4.3e-08 $layer=Gate_1 $thickness=5.6e-08
+ $X=0.405 $Y=0.0675 $X2=0.405 $Y2=0.0245
.ends

.subckt PM_CKINVDCx20_ASAP7_75t_R%6 vss 19 23 33 36 46 47 50 51 18 1 3 4 15 9
+ 12 16 14 10
c1 1 vss 0.00633075f $X=0.729 $Y=0.135
c2 3 vss 0.00715361f $X=0.756 $Y=0.0675
c3 4 vss 0.00721223f $X=0.864 $Y=0.0675
c4 9 vss 0.0823613f $X=0.729 $Y=0.0245
c5 10 vss 0.0821636f $X=0.783 $Y=0.135
c6 11 vss 0.0064308f $X=0.7415 $Y=0.0675
c7 12 vss 0.00690911f $X=0.8495 $Y=0.0675
c8 13 vss 0.000348939f $X=0.783 $Y=0.099
c9 14 vss 0.000207662f $X=0.783 $Y=0.135
c10 15 vss 0.00126644f $X=0.7415 $Y=0.099
c11 16 vss 0.000609974f $X=0.739 $Y=0.135
c12 17 vss 0.000149606f $X=0.783 $Y=0.117
c13 18 vss 0.00243338f $X=0.81 $Y=0.099
r1 51 49 0.0308642 $w=8.1e-08 $l=2.5e-09 $layer=N_src_drn $thickness=1e-09
+ $X=0.8813 $Y=0.0675 $X2=0.8785 $Y2=0.0675
r2 4 49 0.179012 $w=8.1e-08 $l=1.45e-08 $layer=N_src_drn $thickness=1e-09
+ $X=0.864 $Y=0.0675 $X2=0.8785 $Y2=0.0675
r3 12 4 0.179012 $w=8.1e-08 $l=1.45e-08 $layer=N_src_drn $thickness=1e-09
+ $X=0.8495 $Y=0.0675 $X2=0.864 $Y2=0.0675
r4 50 12 0.0308642 $w=8.1e-08 $l=2.5e-09 $layer=N_src_drn $thickness=1e-09
+ $X=0.8466 $Y=0.0675 $X2=0.8495 $Y2=0.0675
r5 47 45 0.0308642 $w=8.1e-08 $l=2.5e-09 $layer=N_src_drn $thickness=1e-09
+ $X=0.7733 $Y=0.0675 $X2=0.7705 $Y2=0.0675
r6 3 45 0.179012 $w=8.1e-08 $l=1.45e-08 $layer=N_src_drn $thickness=1e-09
+ $X=0.756 $Y=0.0675 $X2=0.7705 $Y2=0.0675
r7 11 3 0.179012 $w=8.1e-08 $l=1.45e-08 $layer=N_src_drn $thickness=1e-09
+ $X=0.7415 $Y=0.0675 $X2=0.756 $Y2=0.0675
r8 46 11 0.0308642 $w=8.1e-08 $l=2.5e-09 $layer=N_src_drn $thickness=1e-09
+ $X=0.7386 $Y=0.0675 $X2=0.7415 $Y2=0.0675
r9 4 42 19.3796 $a=3.24e-16 $layer=V0LISD $X=0.864 $Y=0.0675 $X2=0.864 $Y2=0.099
r10 3 38 19.3796 $a=3.24e-16 $layer=V0LISD $X=0.756 $Y=0.0675 $X2=0.756
+ $Y2=0.099
r11 41 42 5.24677 $w=1.3e-08 $l=2.25e-08 $layer=M1 $thickness=3.6e-08 $X=0.8415
+ $Y=0.099 $X2=0.864 $Y2=0.099
r12 18 41 7.34548 $w=1.3e-08 $l=3.15e-08 $layer=M1 $thickness=3.6e-08 $X=0.81
+ $Y=0.099 $X2=0.8415 $Y2=0.099
r13 38 39 3.14806 $w=1.3e-08 $l=1.35e-08 $layer=M1 $thickness=3.6e-08 $X=0.756
+ $Y=0.099 $X2=0.7695 $Y2=0.099
r14 15 38 3.38125 $w=1.3e-08 $l=1.45e-08 $layer=M1 $thickness=3.6e-08 $X=0.7415
+ $Y=0.099 $X2=0.756 $Y2=0.099
r15 13 17 3.01711 $w=1.55e-08 $l=1.8e-08 $layer=M1 $thickness=3.6e-08 $X=0.783
+ $Y=0.099 $X2=0.783 $Y2=0.117
r16 13 39 1.96775 $w=1.63333e-08 $l=1.35e-08 $layer=M1 $thickness=3.6e-08
+ $X=0.783 $Y=0.099 $X2=0.7695 $Y2=0.099
r17 13 18 5.11582 $w=1.46667e-08 $l=2.7e-08 $layer=M1 $thickness=3.6e-08
+ $X=0.783 $Y=0.099 $X2=0.81 $Y2=0.099
r18 14 31 1.49895 $w=1.63333e-08 $l=1.35e-08 $layer=M1 $thickness=3.6e-08
+ $X=0.783 $Y=0.135 $X2=0.7695 $Y2=0.135
r19 14 17 2.5483 $w=1.79e-08 $l=1.8e-08 $layer=M1 $thickness=3.6e-08 $X=0.783
+ $Y=0.135 $X2=0.783 $Y2=0.117
r20 36 35 16.4967 $w=2.1e-08 $l=4.85e-08 $layer=Gate_1 $thickness=5.6e-08
+ $X=0.783 $Y=0.2025 $X2=0.783 $Y2=0.154
r21 33 34 16.4967 $w=2.1e-08 $l=4.85e-08 $layer=Gate_1 $thickness=5.6e-08
+ $X=0.783 $Y=0.0675 $X2=0.783 $Y2=0.116
r22 10 27 6.54019 $w=2.09524e-08 $layer=Gate_1 $thickness=5.21905e-08 $X=0.783
+ $Y=0.135 $X2=0.783 $Y2=0.135
r23 10 34 6.6497 $w=2.04211e-08 $l=1.9e-08 $layer=Gate_1 $thickness=5.6e-08
+ $X=0.783 $Y=0.135 $X2=0.783 $Y2=0.116
r24 10 35 6.6497 $w=2.04211e-08 $l=1.9e-08 $layer=Gate_1 $thickness=5.6e-08
+ $X=0.783 $Y=0.135 $X2=0.783 $Y2=0.154
r25 30 31 3.14806 $w=1.3e-08 $l=1.35e-08 $layer=M1 $thickness=3.6e-08 $X=0.756
+ $Y=0.135 $X2=0.7695 $Y2=0.135
r26 29 30 2.68168 $w=1.3e-08 $l=1.15e-08 $layer=M1 $thickness=3.6e-08 $X=0.7445
+ $Y=0.135 $X2=0.756 $Y2=0.135
r27 16 29 1.28254 $w=1.3e-08 $l=5.5e-09 $layer=M1 $thickness=3.6e-08 $X=0.739
+ $Y=0.135 $X2=0.7445 $Y2=0.135
r28 26 27 12.6539 $w=1.77815e-08 $l=2.7e-08 $layer=LIG $thickness=4.8e-08
+ $X=0.756 $Y=0.135 $X2=0.783 $Y2=0.135
r29 26 30 19.3796 $a=3.24e-16 $layer=V0LIG $X=0.756 $Y=0.135 $X2=0.756 $Y2=0.135
r30 1 21 6.54019 $w=2.09524e-08 $layer=Gate_1 $thickness=5.21905e-08 $X=0.729
+ $Y=0.135 $X2=0.729 $Y2=0.135
r31 1 26 12.6539 $w=1.77815e-08 $l=2.7e-08 $layer=LIG $thickness=4.8e-08
+ $X=0.729 $Y=0.135 $X2=0.756 $Y2=0.135
r32 23 22 16.4967 $w=2.1e-08 $l=4.85e-08 $layer=Gate_1 $thickness=5.6e-08
+ $X=0.729 $Y=0.2025 $X2=0.729 $Y2=0.154
r33 21 22 6.6497 $w=2.04211e-08 $l=1.9e-08 $layer=Gate_1 $thickness=5.6e-08
+ $X=0.729 $Y=0.135 $X2=0.729 $Y2=0.154
r34 20 21 6.6497 $w=2.04211e-08 $l=1.9e-08 $layer=Gate_1 $thickness=5.6e-08
+ $X=0.729 $Y=0.116 $X2=0.729 $Y2=0.135
r35 19 20 16.4967 $w=2.1e-08 $l=4.85e-08 $layer=Gate_1 $thickness=5.6e-08
+ $X=0.729 $Y=0.0675 $X2=0.729 $Y2=0.116
r36 19 9 14.6259 $w=2.1e-08 $l=4.3e-08 $layer=Gate_1 $thickness=5.6e-08
+ $X=0.729 $Y=0.0675 $X2=0.729 $Y2=0.0245
.ends

* End of included file CKINVDCx20_ASAP7_75t_R.pex.sp.pex

*
.subckt CKINVDCx20_ASAP7_75t_CUSTOM_4_25_0_7 VSS VDD A Y
*
* VSS VSS
* VDD VDD
* A A
* Y Y
*
*

M0 N_M0_d N_M0_g VSS VSS nmos_rvt L=2e-08 W=8.1e-08 nfin=3 $X=0.071 $Y=0.027
M1 N_M1_d N_M1_g VSS VSS nmos_rvt L=2e-08 W=8.1e-08 nfin=3 $X=0.125 $Y=0.027
M2 N_M2_d N_M2_g VSS VSS nmos_rvt L=2e-08 W=8.1e-08 nfin=3 $X=0.179 $Y=0.027
M3 N_M3_d N_M3_g VSS VSS nmos_rvt L=2e-08 W=8.1e-08 nfin=3 $X=0.233 $Y=0.027
M4 N_M4_d N_M4_g VSS VSS nmos_rvt L=2e-08 W=8.1e-08 nfin=3 $X=0.287 $Y=0.027
M5 N_M5_d N_M5_g VSS VSS nmos_rvt L=2e-08 W=8.1e-08 nfin=3 $X=0.341 $Y=0.027
M6 N_M6_d N_M6_g VSS VSS nmos_rvt L=2e-08 W=8.1e-08 nfin=3 $X=0.395 $Y=0.027
M7 N_M7_d N_M7_g VSS VSS nmos_rvt L=2e-08 W=8.1e-08 nfin=3 $X=0.449 $Y=0.027
M8 N_M8_d N_M8_g VSS VSS nmos_rvt L=2e-08 W=8.1e-08 nfin=3 $X=0.503 $Y=0.027
M9 N_M9_d N_M9_g VSS VSS nmos_rvt L=2e-08 W=8.1e-08 nfin=3 $X=0.557 $Y=0.027
M10 N_M10_d N_M10_g VSS VSS nmos_rvt L=2e-08 W=8.1e-08 nfin=3 $X=0.611 $Y=0.027
M11 N_M11_d N_M11_g VSS VSS nmos_rvt L=2e-08 W=8.1e-08 nfin=3 $X=0.665 $Y=0.027
M12 N_M12_d N_M12_g VSS VSS nmos_rvt L=2e-08 W=8.1e-08 nfin=3 $X=0.719 $Y=0.027
M13 N_M13_d N_M13_g VSS VSS nmos_rvt L=2e-08 W=8.1e-08 nfin=3 $X=0.773 $Y=0.027
M14 N_M14_d N_M14_g VSS VSS nmos_rvt L=2e-08 W=8.1e-08 nfin=3 $X=0.827 $Y=0.027
M15 N_M15_d N_M15_g VSS VSS nmos_rvt L=2e-08 W=8.1e-08 nfin=3 $X=0.881 $Y=0.027
M16 N_M16_d N_M16_g VSS VSS nmos_rvt L=2e-08 W=8.1e-08 nfin=3 $X=0.935 $Y=0.027
M17 N_M17_d N_M17_g VSS VSS nmos_rvt L=2e-08 W=8.1e-08 nfin=3 $X=0.989 $Y=0.027
M18 N_M18_d N_M18_g VSS VSS nmos_rvt L=2e-08 W=8.1e-08 nfin=3 $X=1.043 $Y=0.027
M19 N_M19_d N_M19_g VSS VSS nmos_rvt L=2e-08 W=8.1e-08 nfin=3 $X=1.097 $Y=0.027
M28 N_M28_d N_M28_g VSS VSS nmos_rvt L=2e-08 W=8.1e-08 nfin=3 $X=1.151 $Y=0.027
M29 N_M29_d N_M29_g VSS VSS nmos_rvt L=2e-08 W=8.1e-08 nfin=3 $X=1.205 $Y=0.027
M30 N_M30_d N_M30_g VSS VSS nmos_rvt L=2e-08 W=8.1e-08 nfin=3 $X=1.259 $Y=0.027
M31 N_M31_d N_M31_g VSS VSS nmos_rvt L=2e-08 W=8.1e-08 nfin=3 $X=1.313 $Y=0.027
M24 N_M24_d N_M24_g VSS VSS nmos_rvt L=2e-08 W=8.1e-08 nfin=3 $X=1.367 $Y=0.027
M25 N_M25_d N_M25_g VSS VSS nmos_rvt L=2e-08 W=8.1e-08 nfin=3 $X=1.421 $Y=0.027
M26 N_M26_d N_M26_g VSS VSS nmos_rvt L=2e-08 W=8.1e-08 nfin=3 $X=1.475 $Y=0.027
M27 N_M27_d N_M27_g VSS VSS nmos_rvt L=2e-08 W=8.1e-08 nfin=3 $X=1.529 $Y=0.027
M20 N_M20_d N_M20_g VSS VSS nmos_rvt L=2e-08 W=8.1e-08 nfin=3 $X=1.583 $Y=0.027
M21 N_M21_d N_M21_g VSS VSS nmos_rvt L=2e-08 W=8.1e-08 nfin=3 $X=1.637 $Y=0.027
M22 N_M22_d N_M22_g VSS VSS nmos_rvt L=2e-08 W=8.1e-08 nfin=3 $X=1.691 $Y=0.027
M23 N_M23_d N_M23_g VSS VSS nmos_rvt L=2e-08 W=8.1e-08 nfin=3 $X=1.745 $Y=0.027
M32 N_M32_d N_M32_g VSS VSS nmos_rvt L=2e-08 W=8.1e-08 nfin=3 $X=1.799 $Y=0.027
M33 N_M33_d N_M33_g VSS VSS nmos_rvt L=2e-08 W=8.1e-08 nfin=3 $X=1.853 $Y=0.027
M34 N_M34_d N_M34_g VSS VSS nmos_rvt L=2e-08 W=8.1e-08 nfin=3 $X=1.907 $Y=0.027
M35 N_M35_d N_M35_g VSS VSS nmos_rvt L=2e-08 W=8.1e-08 nfin=3 $X=1.961 $Y=0.027
M36 N_M36_d N_M36_g VDD VDD pmos_rvt L=2e-08 W=8.1e-08 nfin=3 $X=0.071 $Y=0.162
M37 N_M37_d N_M37_g VDD VDD pmos_rvt L=2e-08 W=8.1e-08 nfin=3 $X=0.125 $Y=0.162
M38 N_M38_d N_M38_g VDD VDD pmos_rvt L=2e-08 W=8.1e-08 nfin=3 $X=0.179 $Y=0.162
M39 N_M39_d N_M39_g VDD VDD pmos_rvt L=2e-08 W=8.1e-08 nfin=3 $X=0.233 $Y=0.162
M40 N_M40_d N_M40_g VDD VDD pmos_rvt L=2e-08 W=8.1e-08 nfin=3 $X=0.287 $Y=0.162
M41 N_M41_d N_M41_g VDD VDD pmos_rvt L=2e-08 W=8.1e-08 nfin=3 $X=0.341 $Y=0.162
M42 N_M42_d N_M42_g VDD VDD pmos_rvt L=2e-08 W=8.1e-08 nfin=3 $X=0.395 $Y=0.162
M43 N_M43_d N_M43_g VDD VDD pmos_rvt L=2e-08 W=8.1e-08 nfin=3 $X=0.449 $Y=0.162
M44 N_M44_d N_M44_g VDD VDD pmos_rvt L=2e-08 W=8.1e-08 nfin=3 $X=0.503 $Y=0.162
M45 N_M45_d N_M45_g VDD VDD pmos_rvt L=2e-08 W=8.1e-08 nfin=3 $X=0.557 $Y=0.162
M46 N_M46_d N_M46_g VDD VDD pmos_rvt L=2e-08 W=8.1e-08 nfin=3 $X=0.611 $Y=0.162
M47 N_M47_d N_M47_g VDD VDD pmos_rvt L=2e-08 W=8.1e-08 nfin=3 $X=0.665 $Y=0.162
M48 N_M48_d N_M48_g VDD VDD pmos_rvt L=2e-08 W=8.1e-08 nfin=3 $X=0.719 $Y=0.162
M49 N_M49_d N_M49_g VDD VDD pmos_rvt L=2e-08 W=8.1e-08 nfin=3 $X=0.773 $Y=0.162
M50 N_M50_d N_M50_g VDD VDD pmos_rvt L=2e-08 W=8.1e-08 nfin=3 $X=0.827 $Y=0.162
M51 N_M51_d N_M51_g VDD VDD pmos_rvt L=2e-08 W=8.1e-08 nfin=3 $X=0.881 $Y=0.162
M52 N_M52_d N_M52_g VDD VDD pmos_rvt L=2e-08 W=8.1e-08 nfin=3 $X=0.935 $Y=0.162
M53 N_M53_d N_M53_g VDD VDD pmos_rvt L=2e-08 W=8.1e-08 nfin=3 $X=0.989 $Y=0.162
M54 N_M54_d N_M54_g VDD VDD pmos_rvt L=2e-08 W=8.1e-08 nfin=3 $X=1.043 $Y=0.162
M55 N_M55_d N_M55_g VDD VDD pmos_rvt L=2e-08 W=8.1e-08 nfin=3 $X=1.097 $Y=0.162
M64 N_M64_d N_M64_g VDD VDD pmos_rvt L=2e-08 W=8.1e-08 nfin=3 $X=1.151 $Y=0.162
M65 N_M65_d N_M65_g VDD VDD pmos_rvt L=2e-08 W=8.1e-08 nfin=3 $X=1.205 $Y=0.162
M66 N_M66_d N_M66_g VDD VDD pmos_rvt L=2e-08 W=8.1e-08 nfin=3 $X=1.259 $Y=0.162
M67 N_M67_d N_M67_g VDD VDD pmos_rvt L=2e-08 W=8.1e-08 nfin=3 $X=1.313 $Y=0.162
M60 N_M60_d N_M60_g VDD VDD pmos_rvt L=2e-08 W=8.1e-08 nfin=3 $X=1.367 $Y=0.162
M61 N_M61_d N_M61_g VDD VDD pmos_rvt L=2e-08 W=8.1e-08 nfin=3 $X=1.421 $Y=0.162
M62 N_M62_d N_M62_g VDD VDD pmos_rvt L=2e-08 W=8.1e-08 nfin=3 $X=1.475 $Y=0.162
M63 N_M63_d N_M63_g VDD VDD pmos_rvt L=2e-08 W=8.1e-08 nfin=3 $X=1.529 $Y=0.162
M56 N_M56_d N_M56_g VDD VDD pmos_rvt L=2e-08 W=8.1e-08 nfin=3 $X=1.583 $Y=0.162
M57 N_M57_d N_M57_g VDD VDD pmos_rvt L=2e-08 W=8.1e-08 nfin=3 $X=1.637 $Y=0.162
M58 N_M58_d N_M58_g VDD VDD pmos_rvt L=2e-08 W=8.1e-08 nfin=3 $X=1.691 $Y=0.162
M59 N_M59_d N_M59_g VDD VDD pmos_rvt L=2e-08 W=8.1e-08 nfin=3 $X=1.745 $Y=0.162
M68 N_M68_d N_M68_g VDD VDD pmos_rvt L=2e-08 W=8.1e-08 nfin=3 $X=1.799 $Y=0.162
M69 N_M69_d N_M69_g VDD VDD pmos_rvt L=2e-08 W=8.1e-08 nfin=3 $X=1.853 $Y=0.162
M70 N_M70_d N_M70_g VDD VDD pmos_rvt L=2e-08 W=8.1e-08 nfin=3 $X=1.907 $Y=0.162
M71 N_M71_d N_M71_g VDD VDD pmos_rvt L=2e-08 W=8.1e-08 nfin=3 $X=1.961 $Y=0.162

* .include "CKINVDCx20_ASAP7_75t_R.pex.sp.pxi"

* Start of included file CKINVDCx20_ASAP7_75t_R.pex.sp.pxi
x_PM_CKINVDCx20_ASAP7_75t_R%4 vss N_M4_g N_M40_g N_M5_g N_M41_g N_M4_d N_M5_d
+ N_M6_d N_M7_d N_4_18 N_4_1 N_4_3 N_4_4 N_4_15 N_4_9 N_4_12 N_4_16 N_4_14
+ N_4_10 PM_CKINVDCx20_ASAP7_75t_R%4
cc_1 N_4_18 N_A_36 3.13121e-20 $X=0.378 $Y=0.099
cc_2 N_4_18 N_A_19 3.94007e-20 $X=0.378 $Y=0.099
cc_3 N_4_18 N_A_46 4.59707e-20 $X=0.378 $Y=0.099
cc_4 N_4_18 N_A_1 0.000602317f $X=0.378 $Y=0.099
cc_5 N_4_1 N_A_1 0.000587734f $X=0.297 $Y=0.135
cc_6 N_4_3 N_A_47 0.000743171f $X=0.324 $Y=0.0675
cc_7 N_4_4 N_A_47 0.000749204f $X=0.432 $Y=0.0675
cc_8 N_4_15 N_A_47 0.000811513f $X=0.3095 $Y=0.099
cc_9 N_4_9 N_A_19 0.00348613f $X=0.297 $Y=0.0245
cc_10 N_4_18 N_A_47 0.00644769f $X=0.378 $Y=0.099
x_PM_CKINVDCx20_ASAP7_75t_R%7 vss N_M14_g N_M50_g N_M15_g N_M51_g N_M48_d
+ N_M49_d N_M50_d N_M51_d N_7_10 N_7_15 N_7_17 N_7_3 N_7_1 N_7_11 N_7_13 N_7_9
+ N_7_4 N_7_18 PM_CKINVDCx20_ASAP7_75t_R%7
cc_11 N_7_10 N_A_52 3.09148e-20 $X=0.891 $Y=0.135
cc_12 N_7_10 N_A_50 3.38501e-20 $X=0.891 $Y=0.135
cc_13 N_7_10 N_A_53 3.84918e-20 $X=0.891 $Y=0.135
cc_14 N_7_10 N_A_2 9.14599e-20 $X=0.891 $Y=0.135
cc_15 N_7_10 N_A_3 0.00137958f $X=0.891 $Y=0.135
cc_16 N_7_10 N_A_24 0.00359047f $X=0.891 $Y=0.135
cc_17 N_7_10 N_6_12 0.0390725f $X=0.891 $Y=0.135
cc_18 N_7_15 N_6_16 0.00127775f $X=0.81 $Y=0.171
cc_19 N_7_17 N_6_18 0.00131876f $X=0.8505 $Y=0.135
cc_20 N_7_10 N_6_4 0.00143019f $X=0.891 $Y=0.135
cc_21 N_7_3 N_6_9 0.00143019f $X=0.756 $Y=0.2025
cc_22 N_7_3 N_6_1 0.00174171f $X=0.756 $Y=0.2025
cc_23 N_7_1 N_6_4 0.00174171f $X=0.837 $Y=0.135
cc_24 N_7_11 N_6_1 0.00298526f $X=0.7415 $Y=0.2025
cc_25 N_7_1 N_6_12 0.00298526f $X=0.837 $Y=0.135
cc_26 N_7_15 N_6_14 0.0037981f $X=0.81 $Y=0.171
cc_27 N_7_13 N_6_18 0.00381199f $X=0.837 $Y=0.135
cc_28 N_7_11 N_6_9 0.0192036f $X=0.7415 $Y=0.2025
cc_29 N_7_9 N_6_12 0.0314002f $X=0.837 $Y=0.0245
cc_30 N_7_11 N_6_10 0.0524317f $X=0.7415 $Y=0.2025
x_PM_CKINVDCx20_ASAP7_75t_R%10 vss N_M28_g N_M64_g N_M29_g N_M65_g N_M64_d
+ N_M65_d N_M66_d N_M67_d N_10_9 N_10_18 N_10_16 N_10_4 N_10_1 N_10_12 N_10_13
+ N_10_10 N_10_3 N_10_15 PM_CKINVDCx20_ASAP7_75t_R%10
cc_31 N_10_9 N_A_55 3.09148e-20 $X=1.161 $Y=0.0245
cc_32 N_10_9 N_A_54 3.38501e-20 $X=1.161 $Y=0.0245
cc_33 N_10_9 N_A_53 3.85567e-20 $X=1.161 $Y=0.0245
cc_34 N_10_9 N_A_3 0.0015153f $X=1.161 $Y=0.0245
cc_35 N_10_9 N_A_4 9.1261e-20 $X=1.161 $Y=0.0245
cc_36 N_10_9 N_A_27 0.00359538f $X=1.161 $Y=0.0245
x_PM_CKINVDCx20_ASAP7_75t_R%8 vss N_M20_g N_M56_g N_M21_g N_M57_g N_M56_d
+ N_M57_d N_M58_d N_M59_d N_8_9 N_8_18 N_8_16 N_8_4 N_8_1 N_8_12 N_8_13 N_8_10
+ N_8_3 N_8_15 PM_CKINVDCx20_ASAP7_75t_R%8
cc_37 N_8_9 N_A_58 3.29967e-20 $X=1.593 $Y=0.0245
cc_38 N_8_9 N_A_57 3.38501e-20 $X=1.593 $Y=0.0245
cc_39 N_8_9 N_A_4 0.00147804f $X=1.593 $Y=0.0245
cc_40 N_8_9 N_A_5 9.14599e-20 $X=1.593 $Y=0.0245
cc_41 N_8_9 N_A_31 0.0035372f $X=1.593 $Y=0.0245
x_PM_CKINVDCx20_ASAP7_75t_R%A vss A N_M0_g N_M36_g N_M1_g N_M37_g N_M2_g
+ N_M38_g N_M3_g N_M39_g N_M8_g N_M44_g N_M9_g N_M45_g N_M10_g N_M46_g N_M11_g
+ N_M47_g N_M16_g N_M52_g N_M17_g N_M53_g N_M18_g N_M54_g N_M19_g N_M55_g
+ N_M24_g N_M60_g N_M25_g N_M61_g N_M26_g N_M62_g N_M27_g N_M63_g N_M32_g
+ N_M68_g N_M33_g N_M69_g N_M34_g N_M70_g N_M35_g N_M71_g N_A_36 N_A_19 N_A_46
+ N_A_1 N_A_47 N_A_48 N_A_49 N_A_2 N_A_20 N_A_51 N_A_23 N_A_50 N_A_52 N_A_53
+ N_A_3 N_A_24 N_A_55 N_A_54 N_A_4 N_A_27 N_A_56 N_A_28 N_A_58 N_A_57 N_A_5
+ N_A_31 N_A_59 N_A_32 N_A_35 N_A_43 N_A_60 N_A_42 N_A_44 N_A_38 N_A_40 N_A_39
+ N_A_41 N_A_17 N_A_21 N_A_30 N_A_37 N_A_45 N_A_18 N_A_22 N_A_25 N_A_26 N_A_29
+ N_A_33 N_A_16 N_A_34 PM_CKINVDCx20_ASAP7_75t_R%A
x_PM_CKINVDCx20_ASAP7_75t_R%11 vss N_M30_g N_M66_g N_M31_g N_M67_g N_M28_d
+ N_M29_d N_M30_d N_M31_d N_11_15 N_11_1 N_11_4 N_11_3 N_11_17 N_11_10 N_11_11
+ N_11_18 N_11_14 N_11_9 PM_CKINVDCx20_ASAP7_75t_R%11
cc_42 N_11_15 N_A_56 3.6882e-20 $X=1.242 $Y=0.099
cc_43 N_11_15 N_A_28 3.94007e-20 $X=1.242 $Y=0.099
cc_44 N_11_15 N_A_4 0.00068618f $X=1.242 $Y=0.099
cc_45 N_11_1 N_A_4 0.000635745f $X=1.269 $Y=0.135
cc_46 N_11_4 N_A_54 0.000743171f $X=1.296 $Y=0.0675
cc_47 N_11_3 N_A_54 0.000749204f $X=1.188 $Y=0.0675
cc_48 N_11_17 N_A_54 0.000811513f $X=1.2825 $Y=0.099
cc_49 N_11_10 N_A_28 0.00348613f $X=1.323 $Y=0.135
cc_50 N_11_15 N_A_54 0.00649829f $X=1.242 $Y=0.099
cc_51 N_11_11 N_10_9 0.0390725f $X=1.1735 $Y=0.0675
cc_52 N_11_18 N_10_18 0.00127881f $X=1.2825 $Y=0.135
cc_53 N_11_15 N_10_16 0.00131881f $X=1.242 $Y=0.099
cc_54 N_11_10 N_10_4 0.00143019f $X=1.323 $Y=0.135
cc_55 N_11_3 N_10_9 0.00143019f $X=1.188 $Y=0.0675
cc_56 N_11_3 N_10_1 0.00173267f $X=1.188 $Y=0.0675
cc_57 N_11_1 N_10_4 0.00173267f $X=1.269 $Y=0.135
cc_58 N_11_11 N_10_1 0.0029725f $X=1.1735 $Y=0.0675
cc_59 N_11_1 N_10_12 0.0029725f $X=1.269 $Y=0.135
cc_60 N_11_14 N_10_18 0.00379805f $X=1.269 $Y=0.135
cc_61 N_11_15 N_10_13 0.00381199f $X=1.242 $Y=0.099
cc_62 N_11_10 N_10_12 0.0192036f $X=1.323 $Y=0.135
cc_63 N_11_11 N_10_10 0.0314002f $X=1.1735 $Y=0.0675
cc_64 N_11_9 N_10_12 0.0524317f $X=1.269 $Y=0.0245
x_PM_CKINVDCx20_ASAP7_75t_R%9 vss N_M22_g N_M58_g N_M23_g N_M59_g N_M20_d
+ N_M21_d N_M22_d N_M23_d N_9_15 N_9_1 N_9_4 N_9_3 N_9_17 N_9_10 N_9_11 N_9_18
+ N_9_14 N_9_9 PM_CKINVDCx20_ASAP7_75t_R%9
cc_65 N_9_15 N_A_59 3.69198e-20 $X=1.674 $Y=0.099
cc_66 N_9_15 N_A_32 3.94007e-20 $X=1.674 $Y=0.099
cc_67 N_9_15 N_A_5 0.00068335f $X=1.674 $Y=0.099
cc_68 N_9_1 N_A_5 0.000635745f $X=1.701 $Y=0.135
cc_69 N_9_4 N_A_57 0.000743171f $X=1.728 $Y=0.0675
cc_70 N_9_3 N_A_57 0.000749204f $X=1.62 $Y=0.0675
cc_71 N_9_17 N_A_57 0.000811513f $X=1.7145 $Y=0.099
cc_72 N_9_10 N_A_32 0.00348613f $X=1.755 $Y=0.135
cc_73 N_9_15 N_A_57 0.00650943f $X=1.674 $Y=0.099
cc_74 N_9_11 N_8_9 0.0390725f $X=1.6055 $Y=0.0675
cc_75 N_9_18 N_8_18 0.00127881f $X=1.7145 $Y=0.135
cc_76 N_9_15 N_8_16 0.00131886f $X=1.674 $Y=0.099
cc_77 N_9_10 N_8_4 0.00143019f $X=1.755 $Y=0.135
cc_78 N_9_3 N_8_9 0.00143019f $X=1.62 $Y=0.0675
cc_79 N_9_3 N_8_1 0.00173267f $X=1.62 $Y=0.0675
cc_80 N_9_1 N_8_4 0.00173267f $X=1.701 $Y=0.135
cc_81 N_9_11 N_8_1 0.0029725f $X=1.6055 $Y=0.0675
cc_82 N_9_1 N_8_12 0.0029725f $X=1.701 $Y=0.135
cc_83 N_9_14 N_8_18 0.0037981f $X=1.701 $Y=0.135
cc_84 N_9_15 N_8_13 0.00381199f $X=1.674 $Y=0.099
cc_85 N_9_10 N_8_12 0.0192036f $X=1.755 $Y=0.135
cc_86 N_9_11 N_8_10 0.0314002f $X=1.6055 $Y=0.0675
cc_87 N_9_9 N_8_12 0.0524317f $X=1.701 $Y=0.0245
x_PM_CKINVDCx20_ASAP7_75t_R%Y vss Y N_M0_d N_M1_d N_M36_d N_M37_d N_M38_d
+ N_M39_d N_M2_d N_M3_d N_M44_d N_M45_d N_M46_d N_M47_d N_M8_d N_M9_d N_M10_d
+ N_M11_d N_M52_d N_M53_d N_M54_d N_M55_d N_M16_d N_M17_d N_M18_d N_M19_d
+ N_M60_d N_M61_d N_M62_d N_M63_d N_M24_d N_M25_d N_M26_d N_M27_d N_M68_d
+ N_M69_d N_M70_d N_M71_d N_M32_d N_M33_d N_M34_d N_M35_d N_Y_73 N_Y_90 N_Y_92
+ N_Y_96 N_Y_84 N_Y_94 N_Y_98 N_Y_88 N_Y_87 N_Y_91 N_Y_85 N_Y_81 N_Y_93 N_Y_89
+ N_Y_115 N_Y_119 N_Y_99 N_Y_4 N_Y_8 N_Y_10 N_Y_12 N_Y_14 N_Y_18 N_Y_105 N_Y_2
+ N_Y_6 N_Y_16 N_Y_20 N_Y_97 N_Y_83 N_Y_1 N_Y_19 N_Y_110 N_Y_118 N_Y_106
+ N_Y_102 N_Y_114 N_Y_72 N_Y_74 N_Y_75 N_Y_76 N_Y_77 N_Y_78 N_Y_79 N_Y_62
+ N_Y_63 N_Y_64 N_Y_65 N_Y_66 N_Y_67 N_Y_68 N_Y_69 N_Y_71 N_Y_80 N_Y_61 N_Y_70
+ N_Y_9 N_Y_11 N_Y_7 N_Y_15 N_Y_5 N_Y_3 N_Y_13 N_Y_17 N_Y_101 N_Y_107 N_Y_113
+ N_Y_103 N_Y_117 N_Y_109 N_Y_111 N_Y_95 N_Y_104 N_Y_108 N_Y_112 N_Y_116
+ PM_CKINVDCx20_ASAP7_75t_R%Y
cc_88 N_Y_73 N_A_35 1.74634e-20 $X=0.5255 $Y=0.2025
cc_89 N_Y_73 N_A_43 2.21343e-20 $X=0.5255 $Y=0.2025
cc_90 N_Y_73 N_A_60 2.53245e-20 $X=0.5255 $Y=0.2025
cc_91 N_Y_73 N_A_36 2.53571e-20 $X=0.5255 $Y=0.2025
cc_92 N_Y_73 N_A_48 2.55128e-20 $X=0.5255 $Y=0.2025
cc_93 N_Y_90 N_A_52 2.55128e-20 $X=0.945 $Y=0.234
cc_94 N_Y_92 N_A_55 2.55128e-20 $X=1.107 $Y=0.234
cc_95 N_Y_96 N_A_58 2.55128e-20 $X=1.539 $Y=0.234
cc_96 N_Y_84 N_A_36 2.55257e-20 $X=0.243 $Y=0.234
cc_97 N_Y_94 N_A_42 2.55257e-20 $X=1.377 $Y=0.234
cc_98 N_Y_98 N_A_44 2.55257e-20 $X=1.809 $Y=0.234
cc_99 N_Y_88 N_A_51 2.55257e-20 $X=0.675 $Y=0.234
cc_100 N_Y_87 N_A_38 2.63025e-20 $X=0.675 $Y=0.072
cc_101 N_Y_91 N_A_40 2.75032e-20 $X=1.107 $Y=0.072
cc_102 N_Y_85 N_A_38 8.00482e-20 $X=0.513 $Y=0.072
cc_103 N_Y_81 N_A_36 8.23885e-20 $X=0.0945 $Y=0.072
cc_104 N_Y_93 N_A_43 8.34789e-20 $X=1.377 $Y=0.072
cc_105 N_Y_89 N_A_40 8.51538e-20 $X=0.945 $Y=0.072
cc_106 N_Y_115 N_A_42 8.75789e-20 $X=1.539 $Y=0.2025
cc_107 N_Y_119 N_A_44 8.75789e-20 $X=1.971 $Y=0.1845
cc_108 N_Y_99 N_A_60 9.07369e-20 $X=1.971 $Y=0.072
cc_109 N_Y_87 N_A_39 9.95227e-20 $X=0.675 $Y=0.072
cc_110 N_Y_4 N_A_19 0.000104472f $X=0.216 $Y=0.2025
cc_111 N_Y_8 N_A_23 0.000104472f $X=0.648 $Y=0.2025
cc_112 N_Y_10 N_A_24 0.00164931f $X=0.972 $Y=0.2025
cc_113 N_Y_12 N_A_27 0.00164931f $X=1.08 $Y=0.2025
cc_114 N_Y_14 N_A_28 0.00164931f $X=1.404 $Y=0.2025
cc_115 N_Y_18 N_A_32 0.00165083f $X=1.836 $Y=0.2025
cc_116 N_Y_89 N_A_41 0.000107233f $X=0.945 $Y=0.072
cc_117 N_Y_105 N_A_39 0.000114495f $X=0.513 $Y=0.2025
cc_118 N_Y_2 N_A_17 0.00161175f $X=0.108 $Y=0.2025
cc_119 N_Y_6 N_A_21 0.000122957f $X=0.54 $Y=0.2025
cc_120 N_Y_16 N_A_30 0.000122957f $X=1.512 $Y=0.2025
cc_121 N_Y_20 N_A_35 0.000122957f $X=1.944 $Y=0.2025
cc_122 N_Y_85 N_A_39 0.0002514f $X=0.513 $Y=0.072
cc_123 N_Y_93 N_A_42 0.00029088f $X=1.377 $Y=0.072
cc_124 N_Y_97 N_A_44 0.00029088f $X=1.809 $Y=0.072
cc_125 N_Y_83 N_A_36 0.000324307f $X=0.243 $Y=0.072
cc_126 N_Y_83 N_A_37 0.000350976f $X=0.243 $Y=0.072
cc_127 N_Y_97 N_A_45 0.000350976f $X=1.809 $Y=0.072
cc_128 N_Y_91 N_A_41 0.000366922f $X=1.107 $Y=0.072
cc_129 N_Y_1 N_A_46 0.000416136f $X=0.108 $Y=0.0675
cc_130 N_Y_19 N_A_59 0.00043961f $X=1.944 $Y=0.0675
cc_131 N_Y_110 N_A_41 0.000506858f $X=0.9585 $Y=0.234
cc_132 N_Y_118 N_A_44 0.000523774f $X=1.8225 $Y=0.234
cc_133 N_Y_106 N_A_39 0.000529906f $X=0.5265 $Y=0.234
cc_134 N_Y_102 N_A_36 0.000533505f $X=0.0945 $Y=0.234
cc_135 N_Y_114 N_A_42 0.000534532f $X=1.3905 $Y=0.234
cc_136 N_Y_72 N_A_18 0.0286542f $X=0.2015 $Y=0.2025
cc_137 N_Y_74 N_A_22 0.0107607f $X=0.6335 $Y=0.2025
cc_138 N_Y_75 N_A_25 0.0286542f $X=0.9575 $Y=0.2025
cc_139 N_Y_76 N_A_26 0.0286542f $X=1.0655 $Y=0.2025
cc_140 N_Y_77 N_A_29 0.0286542f $X=1.3895 $Y=0.2025
cc_141 N_Y_78 N_A_30 0.0286543f $X=1.4975 $Y=0.2025
cc_142 N_Y_79 N_A_33 0.0646003f $X=1.8215 $Y=0.2025
cc_143 N_Y_62 N_A_19 0.0107614f $X=0.2015 $Y=0.0675
cc_144 N_Y_63 N_A_20 0.046549f $X=0.5255 $Y=0.0675
cc_145 N_Y_64 N_A_23 0.046549f $X=0.6335 $Y=0.0675
cc_146 N_Y_65 N_A_24 0.0107614f $X=0.9575 $Y=0.0675
cc_147 N_Y_66 N_A_27 0.0107614f $X=1.0655 $Y=0.0675
cc_148 N_Y_67 N_A_28 0.0107614f $X=1.3895 $Y=0.0675
cc_149 N_Y_68 N_A_31 0.046549f $X=1.4975 $Y=0.0675
cc_150 N_Y_69 N_A_32 0.0107614f $X=1.8215 $Y=0.0675
cc_151 N_Y_81 N_A_46 0.000825906f $X=0.0945 $Y=0.072
cc_152 N_Y_71 N_A_16 0.028935f $X=0.0935 $Y=0.2025
cc_153 N_Y_80 N_A_35 0.0466741f $X=1.9295 $Y=0.2025
cc_154 N_Y_61 N_A_17 0.0189597f $X=0.0935 $Y=0.0675
cc_155 N_Y_70 N_A_34 0.0189601f $X=1.9295 $Y=0.0675
cc_156 N_Y_9 N_A_50 0.000848023f $X=0.972 $Y=0.0675
cc_157 N_Y_11 N_A_54 0.000848023f $X=1.08 $Y=0.0675
cc_158 N_Y_7 N_A_50 0.000848158f $X=0.648 $Y=0.0675
cc_159 N_Y_15 N_A_57 0.000852953f $X=1.512 $Y=0.0675
cc_160 N_Y_5 N_A_47 0.0008555f $X=0.54 $Y=0.0675
cc_161 N_Y_3 N_A_47 0.000867491f $X=0.216 $Y=0.0675
cc_162 N_Y_13 N_A_54 0.000867491f $X=1.404 $Y=0.0675
cc_163 N_Y_17 N_A_57 0.000867491f $X=1.836 $Y=0.0675
cc_164 N_Y_99 N_A_59 0.00093527f $X=1.971 $Y=0.072
cc_165 N_Y_2 N_A_1 0.00103436f $X=0.108 $Y=0.2025
cc_166 N_Y_13 N_A_4 0.00115633f $X=1.404 $Y=0.0675
cc_167 N_Y_17 N_A_5 0.00115633f $X=1.836 $Y=0.0675
cc_168 N_Y_7 N_A_2 0.00115664f $X=0.648 $Y=0.0675
cc_169 N_Y_3 N_A_1 0.00115759f $X=0.216 $Y=0.0675
cc_170 N_Y_9 N_A_3 0.00117238f $X=0.972 $Y=0.0675
cc_171 N_Y_11 N_A_3 0.00117238f $X=1.08 $Y=0.0675
cc_172 N_Y_5 N_A_2 0.00121361f $X=0.54 $Y=0.0675
cc_173 N_Y_15 N_A_4 0.00122082f $X=1.512 $Y=0.0675
cc_174 N_Y_19 N_A_5 0.00122082f $X=1.944 $Y=0.0675
cc_175 N_Y_20 N_A_34 0.00153721f $X=1.944 $Y=0.2025
cc_176 N_Y_8 N_A_22 0.0015388f $X=0.648 $Y=0.2025
cc_177 N_Y_6 N_A_20 0.00154482f $X=0.54 $Y=0.2025
cc_178 N_Y_16 N_A_31 0.00154482f $X=1.512 $Y=0.2025
cc_179 N_Y_4 N_A_18 0.001546f $X=0.216 $Y=0.2025
cc_180 N_Y_1 N_A_16 0.00161157f $X=0.108 $Y=0.0675
cc_181 N_Y_19 N_A_35 0.00165138f $X=1.944 $Y=0.0675
cc_182 N_Y_91 N_A_53 0.00172135f $X=1.107 $Y=0.072
cc_183 N_Y_85 N_A_49 0.00187679f $X=0.513 $Y=0.072
cc_184 N_Y_93 N_A_56 0.00192898f $X=1.377 $Y=0.072
cc_185 N_Y_97 N_A_59 0.00198009f $X=1.809 $Y=0.072
cc_186 N_Y_7 N_A_23 0.00204788f $X=0.648 $Y=0.0675
cc_187 N_Y_5 N_A_20 0.00205286f $X=0.54 $Y=0.0675
cc_188 N_Y_15 N_A_31 0.00205286f $X=1.512 $Y=0.0675
cc_189 N_Y_9 N_A_25 0.00206477f $X=0.972 $Y=0.0675
cc_190 N_Y_11 N_A_26 0.00206477f $X=1.08 $Y=0.0675
cc_191 N_Y_13 N_A_29 0.00206477f $X=1.404 $Y=0.0675
cc_192 N_Y_17 N_A_33 0.00206543f $X=1.836 $Y=0.0675
cc_193 N_Y_3 N_A_19 0.00207612f $X=0.216 $Y=0.0675
cc_194 N_Y_83 N_A_46 0.00210535f $X=0.243 $Y=0.072
cc_195 N_Y_89 N_A_50 0.00304266f $X=0.945 $Y=0.072
cc_196 N_Y_93 N_A_54 0.00305251f $X=1.377 $Y=0.072
cc_197 N_Y_83 N_A_47 0.00305255f $X=0.243 $Y=0.072
cc_198 N_Y_97 N_A_57 0.00305255f $X=1.809 $Y=0.072
cc_199 N_Y_101 N_A_36 0.00311943f $X=0.081 $Y=0.1035
cc_200 N_Y_107 N_A_51 0.00365792f $X=0.675 $Y=0.2025
cc_201 N_Y_113 N_A_42 0.00377331f $X=1.377 $Y=0.2025
cc_202 N_Y_103 N_A_36 0.00378461f $X=0.243 $Y=0.1947
cc_203 N_Y_117 N_A_44 0.00383303f $X=1.809 $Y=0.2025
cc_204 N_Y_109 N_A_52 0.00386238f $X=0.945 $Y=0.2025
cc_205 N_Y_119 N_A_60 0.00386714f $X=1.971 $Y=0.1845
cc_206 N_Y_105 N_A_48 0.00387271f $X=0.513 $Y=0.2025
cc_207 N_Y_111 N_A_55 0.00388813f $X=1.107 $Y=0.2025
cc_208 N_Y_115 N_A_58 0.00397027f $X=1.539 $Y=0.2025
cc_209 N_Y_65 N_A_3 0.00764418f $X=0.9575 $Y=0.0675
cc_210 N_Y_78 N_A_4 0.00821636f $X=1.4975 $Y=0.2025
cc_211 N_Y_73 N_A_2 0.00822594f $X=0.5255 $Y=0.2025
cc_212 N_Y_80 N_A_5 0.00829859f $X=1.9295 $Y=0.2025
cc_213 N_Y_72 N_A_1 0.00848078f $X=0.2015 $Y=0.2025
cc_214 N_Y_95 N_A_57 0.00908935f $X=1.539 $Y=0.072
cc_215 N_Y_87 N_A_50 0.00915254f $X=0.675 $Y=0.072
cc_216 N_Y_91 N_A_54 0.00920578f $X=1.107 $Y=0.072
cc_217 N_Y_85 N_A_47 0.00932155f $X=0.513 $Y=0.072
cc_218 N_Y_70 N_A_35 0.0100752f $X=1.9295 $Y=0.0675
cc_219 N_Y_74 N_A_23 0.0178934f $X=0.6335 $Y=0.2025
cc_220 N_Y_64 N_A_22 0.0540006f $X=0.6335 $Y=0.0675
cc_221 N_Y_65 N_A_25 0.0540007f $X=0.9575 $Y=0.0675
cc_222 N_Y_66 N_A_26 0.0540007f $X=1.0655 $Y=0.0675
cc_223 N_Y_67 N_A_29 0.0539975f $X=1.3895 $Y=0.0675
cc_224 N_Y_62 N_A_18 0.0538702f $X=0.2015 $Y=0.0675
cc_225 N_Y_69 N_A_33 0.0179249f $X=1.8215 $Y=0.0675
cc_226 N_Y_63 N_A_21 0.017925f $X=0.5255 $Y=0.0675
cc_227 N_Y_68 N_A_30 0.054001f $X=1.4975 $Y=0.0675
cc_228 N_Y_80 N_A_34 0.0539736f $X=1.9295 $Y=0.2025
cc_229 N_Y_72 N_A_19 0.0357876f $X=0.2015 $Y=0.2025
cc_230 N_Y_75 N_A_24 0.0357876f $X=0.9575 $Y=0.2025
cc_231 N_Y_76 N_A_27 0.0357876f $X=1.0655 $Y=0.2025
cc_232 N_Y_77 N_A_28 0.0357876f $X=1.3895 $Y=0.2025
cc_233 N_Y_79 N_A_32 0.0357876f $X=1.8215 $Y=0.2025
cc_234 N_Y_71 N_A_17 0.0359494f $X=0.0935 $Y=0.2025
cc_235 N_Y_61 N_A_16 0.0458295f $X=0.0935 $Y=0.0675
cc_236 N_Y_73 N_A_21 0.0647831f $X=0.5255 $Y=0.2025
cc_237 N_Y_5 N_4_16 7.51019e-20 $X=0.54 $Y=0.0675
cc_238 N_Y_3 N_4_16 8.68152e-20 $X=0.216 $Y=0.0675
cc_239 N_Y_85 N_4_16 0.000307938f $X=0.513 $Y=0.072
cc_240 N_Y_105 N_4_16 0.00016035f $X=0.513 $Y=0.2025
cc_241 N_Y_83 N_4_16 0.000497826f $X=0.243 $Y=0.072
cc_242 N_Y_104 N_4_16 0.000215152f $X=0.273 $Y=0.234
cc_243 N_Y_103 N_4_15 0.000679359f $X=0.243 $Y=0.1947
cc_244 N_Y_105 N_4_18 0.000826549f $X=0.513 $Y=0.2025
cc_245 N_Y_103 N_4_16 0.00210281f $X=0.243 $Y=0.1947
cc_246 N_Y_4 N_5_15 7.82837e-20 $X=0.216 $Y=0.2025
cc_247 N_Y_6 N_5_15 9.44557e-20 $X=0.54 $Y=0.2025
cc_248 N_Y_85 N_5_15 0.000101268f $X=0.513 $Y=0.072
cc_249 N_Y_105 N_5_15 0.000354675f $X=0.513 $Y=0.2025
cc_250 N_Y_103 N_5_15 0.000457083f $X=0.243 $Y=0.1947
cc_251 N_Y_105 N_5_17 0.000474819f $X=0.513 $Y=0.2025
cc_252 N_Y_104 N_5_4 0.000865761f $X=0.273 $Y=0.234
cc_253 N_Y_104 N_5_3 0.000891358f $X=0.273 $Y=0.234
cc_254 N_Y_105 N_5_18 0.00121102f $X=0.513 $Y=0.2025
cc_255 N_Y_104 N_5_18 0.00145626f $X=0.273 $Y=0.234
cc_256 N_Y_104 N_5_15 0.00688247f $X=0.273 $Y=0.234
cc_257 N_Y_7 N_6_16 9.11314e-20 $X=0.648 $Y=0.0675
cc_258 N_Y_89 N_6_16 0.000315979f $X=0.945 $Y=0.072
cc_259 N_Y_109 N_6_16 0.00016035f $X=0.945 $Y=0.2025
cc_260 N_Y_87 N_6_16 0.000506574f $X=0.675 $Y=0.072
cc_261 N_Y_108 N_6_16 0.000214402f $X=0.705 $Y=0.234
cc_262 N_Y_107 N_6_15 0.000679359f $X=0.675 $Y=0.2025
cc_263 N_Y_109 N_6_18 0.00082428f $X=0.945 $Y=0.2025
cc_264 N_Y_107 N_6_16 0.00209752f $X=0.675 $Y=0.2025
cc_265 N_Y_8 N_7_15 7.74074e-20 $X=0.648 $Y=0.2025
cc_266 N_Y_9 N_7_15 9.37316e-20 $X=0.972 $Y=0.0675
cc_267 N_Y_10 N_7_15 9.43857e-20 $X=0.972 $Y=0.2025
cc_268 N_Y_109 N_7_15 0.000354675f $X=0.945 $Y=0.2025
cc_269 N_Y_89 N_7_15 0.000121442f $X=0.945 $Y=0.072
cc_270 N_Y_107 N_7_15 0.000455788f $X=0.675 $Y=0.2025
cc_271 N_Y_109 N_7_17 0.000477301f $X=0.945 $Y=0.2025
cc_272 N_Y_108 N_7_4 0.000865761f $X=0.705 $Y=0.234
cc_273 N_Y_108 N_7_3 0.000891358f $X=0.705 $Y=0.234
cc_274 N_Y_109 N_7_18 0.0012442f $X=0.945 $Y=0.2025
cc_275 N_Y_108 N_7_18 0.00145626f $X=0.705 $Y=0.234
cc_276 N_Y_108 N_7_15 0.00690038f $X=0.705 $Y=0.234
cc_277 N_Y_111 N_10_18 0.000251296f $X=1.107 $Y=0.2025
cc_278 N_Y_11 N_10_18 9.37316e-20 $X=1.08 $Y=0.0675
cc_279 N_Y_12 N_10_18 9.43857e-20 $X=1.08 $Y=0.2025
cc_280 N_Y_91 N_10_18 0.00012039f $X=1.107 $Y=0.072
cc_281 N_Y_113 N_10_18 0.000456274f $X=1.377 $Y=0.2025
cc_282 N_Y_111 N_10_16 0.000477301f $X=1.107 $Y=0.2025
cc_283 N_Y_112 N_10_3 0.000865761f $X=1.1355 $Y=0.234
cc_284 N_Y_112 N_10_4 0.000891358f $X=1.1355 $Y=0.234
cc_285 N_Y_111 N_10_15 0.00124433f $X=1.107 $Y=0.2025
cc_286 N_Y_112 N_10_15 0.00145626f $X=1.1355 $Y=0.234
cc_287 N_Y_112 N_10_18 0.0069001f $X=1.1355 $Y=0.234
cc_288 N_Y_13 N_11_18 9.09892e-20 $X=1.404 $Y=0.0675
cc_289 N_Y_14 N_11_18 9.73061e-20 $X=1.404 $Y=0.2025
cc_290 N_Y_91 N_11_18 0.000315094f $X=1.107 $Y=0.072
cc_291 N_Y_111 N_11_18 0.00016035f $X=1.107 $Y=0.2025
cc_292 N_Y_93 N_11_18 0.000495638f $X=1.377 $Y=0.072
cc_293 N_Y_112 N_11_18 0.000214316f $X=1.1355 $Y=0.234
cc_294 N_Y_113 N_11_17 0.000679359f $X=1.377 $Y=0.2025
cc_295 N_Y_111 N_11_15 0.000822331f $X=1.107 $Y=0.2025
cc_296 N_Y_113 N_11_18 0.00200047f $X=1.377 $Y=0.2025
cc_297 N_Y_16 N_8_18 9.44557e-20 $X=1.512 $Y=0.2025
cc_298 N_Y_95 N_8_18 0.000108384f $X=1.539 $Y=0.072
cc_299 N_Y_115 N_8_18 0.000199628f $X=1.539 $Y=0.2025
cc_300 N_Y_117 N_8_18 0.000456277f $X=1.809 $Y=0.2025
cc_301 N_Y_115 N_8_16 0.000474819f $X=1.539 $Y=0.2025
cc_302 N_Y_116 N_8_3 0.000865761f $X=1.5675 $Y=0.234
cc_303 N_Y_116 N_8_4 0.000891358f $X=1.5675 $Y=0.234
cc_304 N_Y_115 N_8_15 0.0012111f $X=1.539 $Y=0.2025
cc_305 N_Y_116 N_8_15 0.00145626f $X=1.5675 $Y=0.234
cc_306 N_Y_116 N_8_18 0.00693414f $X=1.5675 $Y=0.234
cc_307 N_Y_15 N_9_18 7.51019e-20 $X=1.512 $Y=0.0675
cc_308 N_Y_17 N_9_18 9.09892e-20 $X=1.836 $Y=0.0675
cc_309 N_Y_18 N_9_18 9.73061e-20 $X=1.836 $Y=0.2025
cc_310 N_Y_95 N_9_18 0.000303431f $X=1.539 $Y=0.072
cc_311 N_Y_115 N_9_18 0.00016035f $X=1.539 $Y=0.2025
cc_312 N_Y_97 N_9_18 0.000497826f $X=1.809 $Y=0.072
cc_313 N_Y_116 N_9_18 0.000215152f $X=1.5675 $Y=0.234
cc_314 N_Y_117 N_9_17 0.000679359f $X=1.809 $Y=0.2025
cc_315 N_Y_115 N_9_15 0.000826639f $X=1.539 $Y=0.2025
cc_316 N_Y_117 N_9_18 0.00200314f $X=1.809 $Y=0.2025
x_PM_CKINVDCx20_ASAP7_75t_R%5 vss N_M6_g N_M42_g N_M7_g N_M43_g N_M40_d N_M41_d
+ N_M42_d N_M43_d N_5_10 N_5_15 N_5_17 N_5_3 N_5_1 N_5_11 N_5_13 N_5_9 N_5_4
+ N_5_18 PM_CKINVDCx20_ASAP7_75t_R%5
cc_317 N_5_10 N_A_48 3.18036e-20 $X=0.459 $Y=0.135
cc_318 N_5_10 N_A_47 3.38501e-20 $X=0.459 $Y=0.135
cc_319 N_5_10 N_A_49 4.29131e-20 $X=0.459 $Y=0.135
cc_320 N_5_10 N_A_1 9.14599e-20 $X=0.459 $Y=0.135
cc_321 N_5_10 N_A_2 0.00133356f $X=0.459 $Y=0.135
cc_322 N_5_10 N_A_20 0.00355429f $X=0.459 $Y=0.135
cc_323 N_5_10 N_4_12 0.0390725f $X=0.459 $Y=0.135
cc_324 N_5_15 N_4_16 0.0012788f $X=0.378 $Y=0.171
cc_325 N_5_17 N_4_18 0.00131886f $X=0.4185 $Y=0.135
cc_326 N_5_10 N_4_4 0.00143019f $X=0.459 $Y=0.135
cc_327 N_5_3 N_4_9 0.00143019f $X=0.324 $Y=0.2025
cc_328 N_5_3 N_4_1 0.00174171f $X=0.324 $Y=0.2025
cc_329 N_5_1 N_4_4 0.00174171f $X=0.405 $Y=0.135
cc_330 N_5_11 N_4_1 0.00298526f $X=0.3095 $Y=0.2025
cc_331 N_5_1 N_4_12 0.00298526f $X=0.405 $Y=0.135
cc_332 N_5_15 N_4_14 0.0037981f $X=0.378 $Y=0.171
cc_333 N_5_13 N_4_18 0.00381199f $X=0.405 $Y=0.135
cc_334 N_5_11 N_4_9 0.0192036f $X=0.3095 $Y=0.2025
cc_335 N_5_9 N_4_12 0.0314002f $X=0.405 $Y=0.0245
cc_336 N_5_11 N_4_10 0.0524317f $X=0.3095 $Y=0.2025
x_PM_CKINVDCx20_ASAP7_75t_R%6 vss N_M12_g N_M48_g N_M13_g N_M49_g N_M12_d
+ N_M13_d N_M14_d N_M15_d N_6_18 N_6_1 N_6_3 N_6_4 N_6_15 N_6_9 N_6_12 N_6_16
+ N_6_14 N_6_10 PM_CKINVDCx20_ASAP7_75t_R%6
cc_337 N_6_18 N_A_51 2.76851e-20 $X=0.81 $Y=0.099
cc_338 N_6_18 N_A_23 3.94007e-20 $X=0.81 $Y=0.099
cc_339 N_6_18 N_A_49 5.2583e-20 $X=0.81 $Y=0.099
cc_340 N_6_18 N_A_2 0.000611365f $X=0.81 $Y=0.099
cc_341 N_6_1 N_A_2 0.000587734f $X=0.729 $Y=0.135
cc_342 N_6_3 N_A_50 0.000743171f $X=0.756 $Y=0.0675
cc_343 N_6_4 N_A_50 0.000749204f $X=0.864 $Y=0.0675
cc_344 N_6_15 N_A_50 0.000811513f $X=0.7415 $Y=0.099
cc_345 N_6_9 N_A_23 0.00348613f $X=0.729 $Y=0.0245
cc_346 N_6_18 N_A_50 0.00649333f $X=0.81 $Y=0.099

* End of included file CKINVDCx20_ASAP7_75t_R.pex.sp.pxi
.ends

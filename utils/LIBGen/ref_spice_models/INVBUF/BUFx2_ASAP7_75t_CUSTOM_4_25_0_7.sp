.subckt PM_BUFx2_ASAP7_75t_R%Y vss 23 16 17 30 31 8 11 12 13 1 2 7
c1 1 vss 0.00900524f $X=0.162 $Y=0.0675
c2 2 vss 0.00908327f $X=0.162 $Y=0.2025
c3 7 vss 0.00552144f $X=0.1475 $Y=0.0675
c4 8 vss 0.00550348f $X=0.1475 $Y=0.2025
c5 9 vss 0.00325094f $X=0.243 $Y=0.036
c6 10 vss 0.00325521f $X=0.243 $Y=0.234
c7 11 vss 0.00918994f $X=0.149 $Y=0.036
c8 12 vss 0.00918994f $X=0.2185 $Y=0.234
c9 13 vss 0.0103772f $X=0.243 $Y=0.0855
r1 31 29 0.0308642 $w=8.1e-08 $l=2.5e-09 $layer=P_src_drn $thickness=1e-09
+ $X=0.1793 $Y=0.2025 $X2=0.1765 $Y2=0.2025
r2 2 29 0.179012 $w=8.1e-08 $l=1.45e-08 $layer=P_src_drn $thickness=1e-09
+ $X=0.162 $Y=0.2025 $X2=0.1765 $Y2=0.2025
r3 8 2 0.179012 $w=8.1e-08 $l=1.45e-08 $layer=P_src_drn $thickness=1e-09
+ $X=0.1475 $Y=0.2025 $X2=0.162 $Y2=0.2025
r4 30 8 0.0308642 $w=8.1e-08 $l=2.5e-09 $layer=P_src_drn $thickness=1e-09
+ $X=0.1446 $Y=0.2025 $X2=0.1475 $Y2=0.2025
r5 2 26 19.3796 $a=3.24e-16 $layer=V0LISD $X=0.162 $Y=0.2025 $X2=0.162 $Y2=0.234
r6 26 27 5.82974 $w=1.3e-08 $l=2.5e-08 $layer=M1 $thickness=3.6e-08 $X=0.162
+ $Y=0.234 $X2=0.187 $Y2=0.234
r7 12 27 7.34548 $w=1.3e-08 $l=3.15e-08 $layer=M1 $thickness=3.6e-08 $X=0.2185
+ $Y=0.234 $X2=0.187 $Y2=0.234
r8 10 24 9.19421 $w=1.48968e-08 $l=4.65e-08 $layer=M1 $thickness=3.6e-08
+ $X=0.243 $Y=0.234 $X2=0.243 $Y2=0.1875
r9 10 12 4.06404 $w=1.48367e-08 $l=2.45e-08 $layer=M1 $thickness=3.6e-08
+ $X=0.243 $Y=0.234 $X2=0.2185 $Y2=0.234
r10 23 24 8.86121 $w=1.3e-08 $l=3.8e-08 $layer=M1 $thickness=3.6e-08 $X=0.244
+ $Y=0.1495 $X2=0.243 $Y2=0.1875
r11 23 22 0.699569 $w=1.3e-08 $l=3e-09 $layer=M1 $thickness=3.6e-08 $X=0.244
+ $Y=0.1495 $X2=0.243 $Y2=0.1465
r12 21 22 2.68168 $w=1.3e-08 $l=1.15e-08 $layer=M1 $thickness=3.6e-08 $X=0.243
+ $Y=0.135 $X2=0.243 $Y2=0.1465
r13 13 21 11.5429 $w=1.3e-08 $l=4.95e-08 $layer=M1 $thickness=3.6e-08 $X=0.243
+ $Y=0.0855 $X2=0.243 $Y2=0.135
r14 9 20 4.06404 $w=1.48367e-08 $l=2.45e-08 $layer=M1 $thickness=3.6e-08
+ $X=0.243 $Y=0.036 $X2=0.2185 $Y2=0.036
r15 9 13 9.89378 $w=1.47818e-08 $l=4.95e-08 $layer=M1 $thickness=3.6e-08
+ $X=0.243 $Y=0.036 $X2=0.243 $Y2=0.0855
r16 19 20 7.34548 $w=1.3e-08 $l=3.15e-08 $layer=M1 $thickness=3.6e-08 $X=0.187
+ $Y=0.036 $X2=0.2185 $Y2=0.036
r17 18 19 5.82974 $w=1.3e-08 $l=2.5e-08 $layer=M1 $thickness=3.6e-08 $X=0.162
+ $Y=0.036 $X2=0.187 $Y2=0.036
r18 11 18 3.03147 $w=1.3e-08 $l=1.3e-08 $layer=M1 $thickness=3.6e-08 $X=0.149
+ $Y=0.036 $X2=0.162 $Y2=0.036
r19 1 18 19.3796 $a=3.24e-16 $layer=V0LISD $X=0.162 $Y=0.0675 $X2=0.162
+ $Y2=0.036
r20 17 15 0.0308642 $w=8.1e-08 $l=2.5e-09 $layer=N_src_drn $thickness=1e-09
+ $X=0.1793 $Y=0.0675 $X2=0.1765 $Y2=0.0675
r21 1 15 0.179012 $w=8.1e-08 $l=1.45e-08 $layer=N_src_drn $thickness=1e-09
+ $X=0.162 $Y=0.0675 $X2=0.1765 $Y2=0.0675
r22 7 1 0.179012 $w=8.1e-08 $l=1.45e-08 $layer=N_src_drn $thickness=1e-09
+ $X=0.1475 $Y=0.0675 $X2=0.162 $Y2=0.0675
r23 16 7 0.0308642 $w=8.1e-08 $l=2.5e-09 $layer=N_src_drn $thickness=1e-09
+ $X=0.1446 $Y=0.0675 $X2=0.1475 $Y2=0.0675
.ends

.subckt PM_BUFx2_ASAP7_75t_R%A vss 22 10 16 3 4 6 1
c1 1 vss 0.00474992f $X=0.072 $Y=0.135
c2 3 vss 0.109842f $X=0.081 $Y=0.0245
c3 4 vss 0.00346621f $X=0.027 $Y=0.072
c4 5 vss 0.00122413f $X=0.027 $Y=0.135
c5 6 vss 0.00346621f $X=0.027 $Y=0.198
c6 7 vss 0.00345316f $X=0.027 $Y=0.1035
c7 8 vss 0.00345316f $X=0.027 $Y=0.1665
c8 9 vss 0.00117213f $X=0.0455 $Y=0.135
r1 6 8 6.16517 $w=1.44286e-08 $l=3.15e-08 $layer=M1 $thickness=3.6e-08 $X=0.027
+ $Y=0.198 $X2=0.027 $Y2=0.1665
r2 4 7 6.16517 $w=1.44286e-08 $l=3.15e-08 $layer=M1 $thickness=3.6e-08 $X=0.027
+ $Y=0.072 $X2=0.027 $Y2=0.1035
r3 5 9 3.1337 $w=1.54324e-08 $l=1.85e-08 $layer=M1 $thickness=3.6e-08 $X=0.027
+ $Y=0.135 $X2=0.0455 $Y2=0.135
r4 5 7 6.16517 $w=1.44286e-08 $l=3.15e-08 $layer=M1 $thickness=3.6e-08 $X=0.027
+ $Y=0.135 $X2=0.027 $Y2=0.1035
r5 5 8 6.16517 $w=1.44286e-08 $l=3.15e-08 $layer=M1 $thickness=3.6e-08 $X=0.027
+ $Y=0.135 $X2=0.027 $Y2=0.1665
r6 22 9 4.31401 $w=1.3e-08 $l=1.85e-08 $layer=M1 $thickness=3.6e-08 $X=0.061
+ $Y=0.1335 $X2=0.0455 $Y2=0.135
r7 22 20 19.3796 $a=3.24e-16 $layer=V0LIG $X=0.061 $Y=0.1335 $X2=0.063 $Y2=0.135
r8 1 18 2.6116 $w=2.2e-08 $l=1e-08 $layer=LIG $thickness=4.8e-08 $X=0.072
+ $Y=0.135 $X2=0.082 $Y2=0.135
r9 1 20 4.98695 $w=1.60444e-08 $l=9e-09 $layer=LIG $thickness=4.8e-08 $X=0.072
+ $Y=0.135 $X2=0.063 $Y2=0.135
r10 16 15 14.6259 $w=2.1e-08 $l=4.3e-08 $layer=Gate_1 $thickness=5.6e-08
+ $X=0.081 $Y=0.216 $X2=0.081 $Y2=0.173
r11 14 15 7.31297 $w=2.1e-08 $l=2.15e-08 $layer=Gate_1 $thickness=5.6e-08
+ $X=0.081 $Y=0.1515 $X2=0.081 $Y2=0.173
r12 13 14 5.79936 $w=2.03333e-08 $l=1.65e-08 $layer=Gate_1 $thickness=5.6e-08
+ $X=0.081 $Y=0.135 $X2=0.081 $Y2=0.1515
r13 13 18 6.27904 $w=2.09e-08 $l=1e-09 $layer=Gate_1 $thickness=5.24e-08
+ $X=0.081 $Y=0.135 $X2=0.082 $Y2=0.135
r14 12 13 5.79936 $w=2.03333e-08 $l=1.65e-08 $layer=Gate_1 $thickness=5.6e-08
+ $X=0.081 $Y=0.1185 $X2=0.081 $Y2=0.135
r15 11 12 7.31297 $w=2.1e-08 $l=2.15e-08 $layer=Gate_1 $thickness=5.6e-08
+ $X=0.081 $Y=0.097 $X2=0.081 $Y2=0.1185
r16 10 11 14.6259 $w=2.1e-08 $l=4.3e-08 $layer=Gate_1 $thickness=5.6e-08
+ $X=0.081 $Y=0.054 $X2=0.081 $Y2=0.097
r17 10 3 10.0341 $w=2.1e-08 $l=2.95e-08 $layer=Gate_1 $thickness=5.6e-08
+ $X=0.081 $Y=0.054 $X2=0.081 $Y2=0.0245
.ends

.subckt PM_BUFx2_ASAP7_75t_R%4 vss 23 27 40 44 55 57 5 6 20 21 11 16 18 19 13
+ 14 1 2 15 17 22 12
c1 1 vss 0.00357656f $X=0.135 $Y=0.135
c2 2 vss 0.00439922f $X=0.189 $Y=0.135
c3 5 vss 0.0086176f $X=0.054 $Y=0.0675
c4 6 vss 0.0086176f $X=0.054 $Y=0.2025
c5 11 vss 0.0982728f $X=0.135 $Y=0.0245
c6 12 vss 0.0830379f $X=0.189 $Y=0.135
c7 13 vss 0.0367705f $X=0.056 $Y=0.054
c8 14 vss 0.0369506f $X=0.056 $Y=0.216
c9 15 vss 0.00279504f $X=0.111 $Y=0.036
c10 16 vss 0.000189045f $X=0.111 $Y=0.135
c11 17 vss 0.00279504f $X=0.111 $Y=0.234
c12 18 vss 0.00650048f $X=0.0875 $Y=0.036
c13 19 vss 0.00650048f $X=0.0875 $Y=0.234
c14 20 vss 0.00309136f $X=0.111 $Y=0.1035
c15 21 vss 0.00309136f $X=0.111 $Y=0.1665
c16 22 vss 0.00182386f $X=0.123 $Y=0.135
r1 57 56 0.0462963 $w=5.4e-08 $l=2.5e-09 $layer=P_src_drn $thickness=1e-09
+ $X=0.0713 $Y=0.216 $X2=0.0685 $Y2=0.216
r2 14 56 0.231482 $w=5.4e-08 $l=1.25e-08 $layer=P_src_drn $thickness=1e-09
+ $X=0.056 $Y=0.216 $X2=0.0685 $Y2=0.216
r3 55 54 0.0462963 $w=5.4e-08 $l=2.5e-09 $layer=N_src_drn $thickness=1e-09
+ $X=0.0713 $Y=0.054 $X2=0.0685 $Y2=0.054
r4 13 54 0.231482 $w=5.4e-08 $l=1.25e-08 $layer=N_src_drn $thickness=1e-09
+ $X=0.056 $Y=0.054 $X2=0.0685 $Y2=0.054
r5 6 53 19.3796 $a=3.24e-16 $layer=V0LISD $X=0.054 $Y=0.2025 $X2=0.05 $Y2=0.234
r6 5 49 19.3796 $a=3.24e-16 $layer=V0LISD $X=0.054 $Y=0.0675 $X2=0.05 $Y2=0.036
r7 50 51 2.09871 $w=1.3e-08 $l=9e-09 $layer=M1 $thickness=3.6e-08 $X=0.059
+ $Y=0.234 $X2=0.068 $Y2=0.234
r8 50 53 2.09871 $w=1.3e-08 $l=9e-09 $layer=M1 $thickness=3.6e-08 $X=0.059
+ $Y=0.234 $X2=0.05 $Y2=0.234
r9 19 51 4.5472 $w=1.3e-08 $l=1.95e-08 $layer=M1 $thickness=3.6e-08 $X=0.0875
+ $Y=0.234 $X2=0.068 $Y2=0.234
r10 46 47 2.09871 $w=1.3e-08 $l=9e-09 $layer=M1 $thickness=3.6e-08 $X=0.059
+ $Y=0.036 $X2=0.068 $Y2=0.036
r11 46 49 2.09871 $w=1.3e-08 $l=9e-09 $layer=M1 $thickness=3.6e-08 $X=0.059
+ $Y=0.036 $X2=0.05 $Y2=0.036
r12 18 47 4.5472 $w=1.3e-08 $l=1.95e-08 $layer=M1 $thickness=3.6e-08 $X=0.0875
+ $Y=0.036 $X2=0.068 $Y2=0.036
r13 17 37 2.5483 $w=1.79e-08 $l=1.8e-08 $layer=M1 $thickness=3.6e-08 $X=0.111
+ $Y=0.234 $X2=0.111 $Y2=0.216
r14 17 19 3.83085 $w=1.49149e-08 $l=2.35e-08 $layer=M1 $thickness=3.6e-08
+ $X=0.111 $Y=0.234 $X2=0.0875 $Y2=0.234
r15 15 35 2.5483 $w=1.79e-08 $l=1.8e-08 $layer=M1 $thickness=3.6e-08 $X=0.111
+ $Y=0.036 $X2=0.111 $Y2=0.054
r16 15 18 3.83085 $w=1.49149e-08 $l=2.35e-08 $layer=M1 $thickness=3.6e-08
+ $X=0.111 $Y=0.036 $X2=0.0875 $Y2=0.036
r17 44 43 14.6259 $w=2.1e-08 $l=4.3e-08 $layer=Gate_1 $thickness=5.6e-08
+ $X=0.189 $Y=0.2025 $X2=0.189 $Y2=0.1595
r18 42 43 2.7211 $w=2.1e-08 $l=8e-09 $layer=Gate_1 $thickness=5.6e-08 $X=0.189
+ $Y=0.1515 $X2=0.189 $Y2=0.1595
r19 40 41 14.6259 $w=2.1e-08 $l=4.3e-08 $layer=Gate_1 $thickness=5.6e-08
+ $X=0.189 $Y=0.0675 $X2=0.189 $Y2=0.1105
r20 38 41 2.7211 $w=2.1e-08 $l=8e-09 $layer=Gate_1 $thickness=5.6e-08 $X=0.189
+ $Y=0.1185 $X2=0.189 $Y2=0.1105
r21 12 38 5.79936 $w=2.03333e-08 $l=1.65e-08 $layer=Gate_1 $thickness=5.6e-08
+ $X=0.189 $Y=0.135 $X2=0.189 $Y2=0.1185
r22 12 42 5.79936 $w=2.03333e-08 $l=1.65e-08 $layer=Gate_1 $thickness=5.6e-08
+ $X=0.189 $Y=0.135 $X2=0.189 $Y2=0.1515
r23 36 37 4.19742 $w=1.3e-08 $l=1.8e-08 $layer=M1 $thickness=3.6e-08 $X=0.111
+ $Y=0.198 $X2=0.111 $Y2=0.216
r24 21 36 7.34548 $w=1.3e-08 $l=3.15e-08 $layer=M1 $thickness=3.6e-08 $X=0.111
+ $Y=0.1665 $X2=0.111 $Y2=0.198
r25 34 35 4.19742 $w=1.3e-08 $l=1.8e-08 $layer=M1 $thickness=3.6e-08 $X=0.111
+ $Y=0.072 $X2=0.111 $Y2=0.054
r26 20 34 7.34548 $w=1.3e-08 $l=3.15e-08 $layer=M1 $thickness=3.6e-08 $X=0.111
+ $Y=0.1035 $X2=0.111 $Y2=0.072
r27 2 32 19.3796 $a=3.24e-16 $layer=V0LIG $X=0.189 $Y=0.135 $X2=0.189 $Y2=0.135
r28 2 12 10.4265 $w=1.765e-08 $layer=LIG $thickness=5.2e-08 $X=0.189 $Y=0.135
+ $X2=0.189 $Y2=0.135
r29 16 22 1.61797 $w=1.675e-08 $l=1.2e-08 $layer=M1 $thickness=3.6e-08 $X=0.111
+ $Y=0.135 $X2=0.123 $Y2=0.135
r30 16 20 6.16517 $w=1.44286e-08 $l=3.15e-08 $layer=M1 $thickness=3.6e-08
+ $X=0.111 $Y=0.135 $X2=0.111 $Y2=0.1035
r31 16 21 6.16517 $w=1.44286e-08 $l=3.15e-08 $layer=M1 $thickness=3.6e-08
+ $X=0.111 $Y=0.135 $X2=0.111 $Y2=0.1665
r32 31 32 6.17953 $w=1.3e-08 $l=2.65e-08 $layer=M1 $thickness=3.6e-08 $X=0.1625
+ $Y=0.135 $X2=0.189 $Y2=0.135
r33 30 31 4.19742 $w=1.3e-08 $l=1.8e-08 $layer=M1 $thickness=3.6e-08 $X=0.1445
+ $Y=0.135 $X2=0.1625 $Y2=0.135
r34 29 30 2.2153 $w=1.3e-08 $l=9.5e-09 $layer=M1 $thickness=3.6e-08 $X=0.135
+ $Y=0.135 $X2=0.1445 $Y2=0.135
r35 22 29 2.79828 $w=1.3e-08 $l=1.2e-08 $layer=M1 $thickness=3.6e-08 $X=0.123
+ $Y=0.135 $X2=0.135 $Y2=0.135
r36 1 25 10.4265 $w=1.765e-08 $layer=LIG $thickness=5.2e-08 $X=0.135 $Y=0.135
+ $X2=0.135 $Y2=0.135
r37 1 29 19.3796 $a=3.24e-16 $layer=V0LIG $X=0.135 $Y=0.135 $X2=0.135 $Y2=0.135
r38 27 26 16.4967 $w=2.1e-08 $l=4.85e-08 $layer=Gate_1 $thickness=5.6e-08
+ $X=0.135 $Y=0.2025 $X2=0.135 $Y2=0.154
r39 25 26 6.6497 $w=2.04211e-08 $l=1.9e-08 $layer=Gate_1 $thickness=5.6e-08
+ $X=0.135 $Y=0.135 $X2=0.135 $Y2=0.154
r40 24 25 6.6497 $w=2.04211e-08 $l=1.9e-08 $layer=Gate_1 $thickness=5.6e-08
+ $X=0.135 $Y=0.116 $X2=0.135 $Y2=0.135
r41 23 24 16.4967 $w=2.1e-08 $l=4.85e-08 $layer=Gate_1 $thickness=5.6e-08
+ $X=0.135 $Y=0.0675 $X2=0.135 $Y2=0.116
r42 23 11 14.6259 $w=2.1e-08 $l=4.3e-08 $layer=Gate_1 $thickness=5.6e-08
+ $X=0.135 $Y=0.0675 $X2=0.135 $Y2=0.0245
r43 6 14 1e-05 $l=1.36473e-08 $X=0.054 $Y=0.2025 $X2=0.056 $Y2=0.216
r44 5 13 1e-05 $l=1.36473e-08 $X=0.054 $Y=0.0675 $X2=0.056 $Y2=0.054
.ends

* End of included file BUFx2_ASAP7_75t_R.pex.sp.pex

*
.subckt BUFx2_ASAP7_75t_CUSTOM_4_25_0_7 VSS VDD A Y
*
* VSS VSS
* VDD VDD
* A A
* Y Y
*
*

M0 VSS N_M0_g N_M0_s VSS nmos_rvt L=2e-08 W=5.4e-08 nfin=2 $X=0.071 $Y=0.027
M1 N_M1_d N_M1_g VSS VSS nmos_rvt L=2e-08 W=8.1e-08 nfin=3 $X=0.125 $Y=0.027
M2 N_M2_d N_M2_g VSS VSS nmos_rvt L=2e-08 W=8.1e-08 nfin=3 $X=0.179 $Y=0.027
M3 VDD N_M3_g N_M3_s VDD pmos_rvt L=2e-08 W=5.4e-08 nfin=2 $X=0.071 $Y=0.189
M4 N_M4_d N_M4_g VDD VDD pmos_rvt L=2e-08 W=8.1e-08 nfin=3 $X=0.125 $Y=0.162
M5 N_M5_d N_M5_g VDD VDD pmos_rvt L=2e-08 W=8.1e-08 nfin=3 $X=0.179 $Y=0.162

* .include "BUFx2_ASAP7_75t_R.pex.sp.pxi"

* Start of included file BUFx2_ASAP7_75t_R.pex.sp.pxi
x_PM_BUFx2_ASAP7_75t_R%Y vss Y N_M1_d N_M2_d N_M4_d N_M5_d N_Y_8 N_Y_11 N_Y_12
+ N_Y_13 N_Y_1 N_Y_2 N_Y_7 PM_BUFx2_ASAP7_75t_R%Y
cc_1 N_Y_8 N_4_11 0.0272351f $X=0.1475 $Y=0.2025
cc_2 N_Y_8 N_4_20 0.000986935f $X=0.1475 $Y=0.2025
cc_3 N_Y_8 N_4_21 0.000986935f $X=0.1475 $Y=0.2025
cc_4 N_Y_8 N_4_1 0.00137717f $X=0.1475 $Y=0.2025
cc_5 N_Y_8 N_4_2 0.00149005f $X=0.1475 $Y=0.2025
cc_6 N_Y_11 N_4_15 0.0016779f $X=0.149 $Y=0.036
cc_7 N_Y_12 N_4_17 0.0016779f $X=0.2185 $Y=0.234
cc_8 N_Y_13 N_4_22 0.00174561f $X=0.243 $Y=0.0855
cc_9 N_Y_1 N_4_11 0.00193056f $X=0.162 $Y=0.0675
cc_10 N_Y_2 N_4_11 0.00193056f $X=0.162 $Y=0.2025
cc_11 N_Y_1 N_4_22 0.0020869f $X=0.162 $Y=0.0675
cc_12 N_Y_7 N_4_11 0.0106046f $X=0.1475 $Y=0.0675
cc_13 N_Y_7 N_4_12 0.0188248f $X=0.1475 $Y=0.0675
cc_14 N_Y_8 N_4_12 0.0708374f $X=0.1475 $Y=0.2025
x_PM_BUFx2_ASAP7_75t_R%A vss A N_M0_g N_M3_g N_A_3 N_A_4 N_A_6 N_A_1
+ PM_BUFx2_ASAP7_75t_R%A
x_PM_BUFx2_ASAP7_75t_R%4 vss N_M1_g N_M4_g N_M2_g N_M5_g N_M0_s N_M3_s N_4_5
+ N_4_6 N_4_20 N_4_21 N_4_11 N_4_16 N_4_18 N_4_19 N_4_13 N_4_14 N_4_1 N_4_2
+ N_4_15 N_4_17 N_4_22 N_4_12 PM_BUFx2_ASAP7_75t_R%4
cc_15 N_4_5 N_A_3 0.00287445f $X=0.054 $Y=0.0675
cc_16 N_4_6 N_A_3 0.00407726f $X=0.054 $Y=0.2025
cc_17 N_4_20 N_A_3 0.00103593f $X=0.111 $Y=0.1035
cc_18 N_4_21 N_A_3 0.00103593f $X=0.111 $Y=0.1665
cc_19 N_4_11 N_A_3 0.00155507f $X=0.135 $Y=0.0245
cc_20 N_4_16 N_A_3 0.00182555f $X=0.111 $Y=0.135
cc_21 N_4_18 N_A_4 0.003412f $X=0.0875 $Y=0.036
cc_22 N_4_19 N_A_6 0.003412f $X=0.0875 $Y=0.234
cc_23 N_4_13 N_A_3 0.0147093f $X=0.056 $Y=0.054
cc_24 N_4_14 N_A_1 0.00416619f $X=0.056 $Y=0.216
cc_25 N_4_14 N_A_3 0.0536214f $X=0.056 $Y=0.216

* End of included file BUFx2_ASAP7_75t_R.pex.sp.pxi
.ends

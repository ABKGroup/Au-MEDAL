.subckt PM_CKINVDCx6p67_ASAP7_75t_R%9 vss 19 23 33 36 46 47 50 51 3 15 4 1 18 9
+ 12 16 14 10
c1 1 vss 0.00658398f $X=0.189 $Y=0.135
c2 3 vss 0.00739986f $X=0.216 $Y=0.0675
c3 4 vss 0.00728176f $X=0.324 $Y=0.0675
c4 9 vss 0.104009f $X=0.189 $Y=0.0245
c5 10 vss 0.0822589f $X=0.243 $Y=0.135
c6 11 vss 0.00655241f $X=0.2015 $Y=0.0675
c7 12 vss 0.00710978f $X=0.3095 $Y=0.0675
c8 13 vss 0.000371493f $X=0.243 $Y=0.099
c9 14 vss 0.000487193f $X=0.243 $Y=0.135
c10 15 vss 0.00236428f $X=0.2015 $Y=0.099
c11 16 vss 0.0020612f $X=0.199 $Y=0.135
c12 17 vss 0.000218686f $X=0.243 $Y=0.117
c13 18 vss 0.00261695f $X=0.27 $Y=0.099
r1 51 49 0.0308642 $w=8.1e-08 $l=2.5e-09 $layer=N_src_drn $thickness=1e-09
+ $X=0.3413 $Y=0.0675 $X2=0.3385 $Y2=0.0675
r2 4 49 0.179012 $w=8.1e-08 $l=1.45e-08 $layer=N_src_drn $thickness=1e-09
+ $X=0.324 $Y=0.0675 $X2=0.3385 $Y2=0.0675
r3 12 4 0.179012 $w=8.1e-08 $l=1.45e-08 $layer=N_src_drn $thickness=1e-09
+ $X=0.3095 $Y=0.0675 $X2=0.324 $Y2=0.0675
r4 50 12 0.0308642 $w=8.1e-08 $l=2.5e-09 $layer=N_src_drn $thickness=1e-09
+ $X=0.3066 $Y=0.0675 $X2=0.3095 $Y2=0.0675
r5 47 45 0.0308642 $w=8.1e-08 $l=2.5e-09 $layer=N_src_drn $thickness=1e-09
+ $X=0.2333 $Y=0.0675 $X2=0.2305 $Y2=0.0675
r6 3 45 0.179012 $w=8.1e-08 $l=1.45e-08 $layer=N_src_drn $thickness=1e-09
+ $X=0.216 $Y=0.0675 $X2=0.2305 $Y2=0.0675
r7 11 3 0.179012 $w=8.1e-08 $l=1.45e-08 $layer=N_src_drn $thickness=1e-09
+ $X=0.2015 $Y=0.0675 $X2=0.216 $Y2=0.0675
r8 46 11 0.0308642 $w=8.1e-08 $l=2.5e-09 $layer=N_src_drn $thickness=1e-09
+ $X=0.1986 $Y=0.0675 $X2=0.2015 $Y2=0.0675
r9 4 42 19.3796 $a=3.24e-16 $layer=V0LISD $X=0.324 $Y=0.0675 $X2=0.324 $Y2=0.099
r10 3 38 19.3796 $a=3.24e-16 $layer=V0LISD $X=0.216 $Y=0.0675 $X2=0.216
+ $Y2=0.099
r11 41 42 5.24677 $w=1.3e-08 $l=2.25e-08 $layer=M1 $thickness=3.6e-08 $X=0.3015
+ $Y=0.099 $X2=0.324 $Y2=0.099
r12 18 41 7.34548 $w=1.3e-08 $l=3.15e-08 $layer=M1 $thickness=3.6e-08 $X=0.27
+ $Y=0.099 $X2=0.3015 $Y2=0.099
r13 38 39 3.14806 $w=1.3e-08 $l=1.35e-08 $layer=M1 $thickness=3.6e-08 $X=0.216
+ $Y=0.099 $X2=0.2295 $Y2=0.099
r14 15 38 3.38125 $w=1.3e-08 $l=1.45e-08 $layer=M1 $thickness=3.6e-08 $X=0.2015
+ $Y=0.099 $X2=0.216 $Y2=0.099
r15 13 17 3.01711 $w=1.55e-08 $l=1.8e-08 $layer=M1 $thickness=3.6e-08 $X=0.243
+ $Y=0.099 $X2=0.243 $Y2=0.117
r16 13 39 1.96775 $w=1.63333e-08 $l=1.35e-08 $layer=M1 $thickness=3.6e-08
+ $X=0.243 $Y=0.099 $X2=0.2295 $Y2=0.099
r17 13 18 5.11582 $w=1.46667e-08 $l=2.7e-08 $layer=M1 $thickness=3.6e-08
+ $X=0.243 $Y=0.099 $X2=0.27 $Y2=0.099
r18 14 31 1.49895 $w=1.63333e-08 $l=1.35e-08 $layer=M1 $thickness=3.6e-08
+ $X=0.243 $Y=0.135 $X2=0.2295 $Y2=0.135
r19 14 17 2.5483 $w=1.79e-08 $l=1.8e-08 $layer=M1 $thickness=3.6e-08 $X=0.243
+ $Y=0.135 $X2=0.243 $Y2=0.117
r20 36 35 16.4967 $w=2.1e-08 $l=4.85e-08 $layer=Gate_1 $thickness=5.6e-08
+ $X=0.243 $Y=0.2025 $X2=0.243 $Y2=0.154
r21 33 34 16.4967 $w=2.1e-08 $l=4.85e-08 $layer=Gate_1 $thickness=5.6e-08
+ $X=0.243 $Y=0.0675 $X2=0.243 $Y2=0.116
r22 10 27 6.54019 $w=2.09524e-08 $layer=Gate_1 $thickness=5.21905e-08 $X=0.243
+ $Y=0.135 $X2=0.243 $Y2=0.135
r23 10 34 6.6497 $w=2.04211e-08 $l=1.9e-08 $layer=Gate_1 $thickness=5.6e-08
+ $X=0.243 $Y=0.135 $X2=0.243 $Y2=0.116
r24 10 35 6.6497 $w=2.04211e-08 $l=1.9e-08 $layer=Gate_1 $thickness=5.6e-08
+ $X=0.243 $Y=0.135 $X2=0.243 $Y2=0.154
r25 30 31 3.14806 $w=1.3e-08 $l=1.35e-08 $layer=M1 $thickness=3.6e-08 $X=0.216
+ $Y=0.135 $X2=0.2295 $Y2=0.135
r26 29 30 2.68168 $w=1.3e-08 $l=1.15e-08 $layer=M1 $thickness=3.6e-08 $X=0.2045
+ $Y=0.135 $X2=0.216 $Y2=0.135
r27 16 29 1.28254 $w=1.3e-08 $l=5.5e-09 $layer=M1 $thickness=3.6e-08 $X=0.199
+ $Y=0.135 $X2=0.2045 $Y2=0.135
r28 26 27 12.6539 $w=1.77815e-08 $l=2.7e-08 $layer=LIG $thickness=4.8e-08
+ $X=0.216 $Y=0.135 $X2=0.243 $Y2=0.135
r29 26 30 19.3796 $a=3.24e-16 $layer=V0LIG $X=0.216 $Y=0.135 $X2=0.216 $Y2=0.135
r30 1 21 6.54019 $w=2.09524e-08 $layer=Gate_1 $thickness=5.21905e-08 $X=0.189
+ $Y=0.135 $X2=0.189 $Y2=0.135
r31 1 26 12.6539 $w=1.77815e-08 $l=2.7e-08 $layer=LIG $thickness=4.8e-08
+ $X=0.189 $Y=0.135 $X2=0.216 $Y2=0.135
r32 23 22 16.4967 $w=2.1e-08 $l=4.85e-08 $layer=Gate_1 $thickness=5.6e-08
+ $X=0.189 $Y=0.2025 $X2=0.189 $Y2=0.154
r33 21 22 6.6497 $w=2.04211e-08 $l=1.9e-08 $layer=Gate_1 $thickness=5.6e-08
+ $X=0.189 $Y=0.135 $X2=0.189 $Y2=0.154
r34 20 21 6.6497 $w=2.04211e-08 $l=1.9e-08 $layer=Gate_1 $thickness=5.6e-08
+ $X=0.189 $Y=0.116 $X2=0.189 $Y2=0.135
r35 19 20 16.4967 $w=2.1e-08 $l=4.85e-08 $layer=Gate_1 $thickness=5.6e-08
+ $X=0.189 $Y=0.0675 $X2=0.189 $Y2=0.116
r36 19 9 14.6259 $w=2.1e-08 $l=4.3e-08 $layer=Gate_1 $thickness=5.6e-08
+ $X=0.189 $Y=0.0675 $X2=0.189 $Y2=0.0245
.ends

.subckt PM_CKINVDCx6p67_ASAP7_75t_R%6 vss 19 23 33 36 46 47 50 51 18 3 15 1 9
+ 12 16 4 14 10
c1 1 vss 0.00633981f $X=0.513 $Y=0.135
c2 3 vss 0.0071568f $X=0.54 $Y=0.0675
c3 4 vss 0.00729887f $X=0.648 $Y=0.0675
c4 9 vss 0.105735f $X=0.513 $Y=0.0245
c5 10 vss 0.0822522f $X=0.567 $Y=0.135
c6 11 vss 0.00647523f $X=0.5255 $Y=0.0675
c7 12 vss 0.00696056f $X=0.6335 $Y=0.0675
c8 13 vss 0.000349076f $X=0.567 $Y=0.099
c9 14 vss 0.000207927f $X=0.567 $Y=0.135
c10 15 vss 0.00129564f $X=0.5255 $Y=0.099
c11 16 vss 0.000607305f $X=0.523 $Y=0.135
c12 17 vss 0.000149607f $X=0.567 $Y=0.117
c13 18 vss 0.00255695f $X=0.594 $Y=0.099
r1 51 49 0.0308642 $w=8.1e-08 $l=2.5e-09 $layer=N_src_drn $thickness=1e-09
+ $X=0.6653 $Y=0.0675 $X2=0.6625 $Y2=0.0675
r2 4 49 0.179012 $w=8.1e-08 $l=1.45e-08 $layer=N_src_drn $thickness=1e-09
+ $X=0.648 $Y=0.0675 $X2=0.6625 $Y2=0.0675
r3 12 4 0.179012 $w=8.1e-08 $l=1.45e-08 $layer=N_src_drn $thickness=1e-09
+ $X=0.6335 $Y=0.0675 $X2=0.648 $Y2=0.0675
r4 50 12 0.0308642 $w=8.1e-08 $l=2.5e-09 $layer=N_src_drn $thickness=1e-09
+ $X=0.6306 $Y=0.0675 $X2=0.6335 $Y2=0.0675
r5 47 45 0.0308642 $w=8.1e-08 $l=2.5e-09 $layer=N_src_drn $thickness=1e-09
+ $X=0.5573 $Y=0.0675 $X2=0.5545 $Y2=0.0675
r6 3 45 0.179012 $w=8.1e-08 $l=1.45e-08 $layer=N_src_drn $thickness=1e-09
+ $X=0.54 $Y=0.0675 $X2=0.5545 $Y2=0.0675
r7 11 3 0.179012 $w=8.1e-08 $l=1.45e-08 $layer=N_src_drn $thickness=1e-09
+ $X=0.5255 $Y=0.0675 $X2=0.54 $Y2=0.0675
r8 46 11 0.0308642 $w=8.1e-08 $l=2.5e-09 $layer=N_src_drn $thickness=1e-09
+ $X=0.5226 $Y=0.0675 $X2=0.5255 $Y2=0.0675
r9 4 42 19.3796 $a=3.24e-16 $layer=V0LISD $X=0.648 $Y=0.0675 $X2=0.648 $Y2=0.099
r10 3 38 19.3796 $a=3.24e-16 $layer=V0LISD $X=0.54 $Y=0.0675 $X2=0.54 $Y2=0.099
r11 41 42 5.24677 $w=1.3e-08 $l=2.25e-08 $layer=M1 $thickness=3.6e-08 $X=0.6255
+ $Y=0.099 $X2=0.648 $Y2=0.099
r12 18 41 7.34548 $w=1.3e-08 $l=3.15e-08 $layer=M1 $thickness=3.6e-08 $X=0.594
+ $Y=0.099 $X2=0.6255 $Y2=0.099
r13 38 39 3.14806 $w=1.3e-08 $l=1.35e-08 $layer=M1 $thickness=3.6e-08 $X=0.54
+ $Y=0.099 $X2=0.5535 $Y2=0.099
r14 15 38 3.38125 $w=1.3e-08 $l=1.45e-08 $layer=M1 $thickness=3.6e-08 $X=0.5255
+ $Y=0.099 $X2=0.54 $Y2=0.099
r15 13 17 3.01711 $w=1.55e-08 $l=1.8e-08 $layer=M1 $thickness=3.6e-08 $X=0.567
+ $Y=0.099 $X2=0.567 $Y2=0.117
r16 13 39 1.96775 $w=1.63333e-08 $l=1.35e-08 $layer=M1 $thickness=3.6e-08
+ $X=0.567 $Y=0.099 $X2=0.5535 $Y2=0.099
r17 13 18 5.11582 $w=1.46667e-08 $l=2.7e-08 $layer=M1 $thickness=3.6e-08
+ $X=0.567 $Y=0.099 $X2=0.594 $Y2=0.099
r18 14 31 1.49895 $w=1.63333e-08 $l=1.35e-08 $layer=M1 $thickness=3.6e-08
+ $X=0.567 $Y=0.135 $X2=0.5535 $Y2=0.135
r19 14 17 2.5483 $w=1.79e-08 $l=1.8e-08 $layer=M1 $thickness=3.6e-08 $X=0.567
+ $Y=0.135 $X2=0.567 $Y2=0.117
r20 36 35 16.4967 $w=2.1e-08 $l=4.85e-08 $layer=Gate_1 $thickness=5.6e-08
+ $X=0.567 $Y=0.2025 $X2=0.567 $Y2=0.154
r21 33 34 16.4967 $w=2.1e-08 $l=4.85e-08 $layer=Gate_1 $thickness=5.6e-08
+ $X=0.567 $Y=0.0675 $X2=0.567 $Y2=0.116
r22 10 27 6.54019 $w=2.09524e-08 $layer=Gate_1 $thickness=5.21905e-08 $X=0.567
+ $Y=0.135 $X2=0.567 $Y2=0.135
r23 10 34 6.6497 $w=2.04211e-08 $l=1.9e-08 $layer=Gate_1 $thickness=5.6e-08
+ $X=0.567 $Y=0.135 $X2=0.567 $Y2=0.116
r24 10 35 6.6497 $w=2.04211e-08 $l=1.9e-08 $layer=Gate_1 $thickness=5.6e-08
+ $X=0.567 $Y=0.135 $X2=0.567 $Y2=0.154
r25 30 31 3.14806 $w=1.3e-08 $l=1.35e-08 $layer=M1 $thickness=3.6e-08 $X=0.54
+ $Y=0.135 $X2=0.5535 $Y2=0.135
r26 29 30 2.68168 $w=1.3e-08 $l=1.15e-08 $layer=M1 $thickness=3.6e-08 $X=0.5285
+ $Y=0.135 $X2=0.54 $Y2=0.135
r27 16 29 1.28254 $w=1.3e-08 $l=5.5e-09 $layer=M1 $thickness=3.6e-08 $X=0.523
+ $Y=0.135 $X2=0.5285 $Y2=0.135
r28 26 27 12.6539 $w=1.77815e-08 $l=2.7e-08 $layer=LIG $thickness=4.8e-08
+ $X=0.54 $Y=0.135 $X2=0.567 $Y2=0.135
r29 26 30 19.3796 $a=3.24e-16 $layer=V0LIG $X=0.54 $Y=0.135 $X2=0.54 $Y2=0.135
r30 1 21 6.54019 $w=2.09524e-08 $layer=Gate_1 $thickness=5.21905e-08 $X=0.513
+ $Y=0.135 $X2=0.513 $Y2=0.135
r31 1 26 12.6539 $w=1.77815e-08 $l=2.7e-08 $layer=LIG $thickness=4.8e-08
+ $X=0.513 $Y=0.135 $X2=0.54 $Y2=0.135
r32 23 22 16.4967 $w=2.1e-08 $l=4.85e-08 $layer=Gate_1 $thickness=5.6e-08
+ $X=0.513 $Y=0.2025 $X2=0.513 $Y2=0.154
r33 21 22 6.6497 $w=2.04211e-08 $l=1.9e-08 $layer=Gate_1 $thickness=5.6e-08
+ $X=0.513 $Y=0.135 $X2=0.513 $Y2=0.154
r34 20 21 6.6497 $w=2.04211e-08 $l=1.9e-08 $layer=Gate_1 $thickness=5.6e-08
+ $X=0.513 $Y=0.116 $X2=0.513 $Y2=0.135
r35 19 20 16.4967 $w=2.1e-08 $l=4.85e-08 $layer=Gate_1 $thickness=5.6e-08
+ $X=0.513 $Y=0.0675 $X2=0.513 $Y2=0.116
r36 19 9 14.6259 $w=2.1e-08 $l=4.3e-08 $layer=Gate_1 $thickness=5.6e-08
+ $X=0.513 $Y=0.0675 $X2=0.513 $Y2=0.0245
.ends

.subckt PM_CKINVDCx6p67_ASAP7_75t_R%4 vss 19 23 33 36 46 47 50 51 4 1 15 17 10
+ 3 11 18 14 9
c1 1 vss 0.00633205f $X=0.945 $Y=0.135
c2 3 vss 0.00722626f $X=0.864 $Y=0.0675
c3 4 vss 0.0071507f $X=0.972 $Y=0.0675
c4 9 vss 0.0822407f $X=0.945 $Y=0.0245
c5 10 vss 0.116077f $X=0.999 $Y=0.135
c6 11 vss 0.00681472f $X=0.8495 $Y=0.0675
c7 12 vss 0.00634277f $X=0.9575 $Y=0.0675
c8 13 vss 0.000348397f $X=0.945 $Y=0.099
c9 14 vss 0.000206905f $X=0.945 $Y=0.135
c10 15 vss 0.00237577f $X=0.918 $Y=0.099
c11 16 vss 0.000149603f $X=0.945 $Y=0.117
c12 17 vss 0.00127163f $X=0.9585 $Y=0.099
c13 18 vss 0.000592757f $X=0.9585 $Y=0.135
r1 51 49 0.0308642 $w=8.1e-08 $l=2.5e-09 $layer=N_src_drn $thickness=1e-09
+ $X=0.9893 $Y=0.0675 $X2=0.9865 $Y2=0.0675
r2 4 49 0.179012 $w=8.1e-08 $l=1.45e-08 $layer=N_src_drn $thickness=1e-09
+ $X=0.972 $Y=0.0675 $X2=0.9865 $Y2=0.0675
r3 12 4 0.179012 $w=8.1e-08 $l=1.45e-08 $layer=N_src_drn $thickness=1e-09
+ $X=0.9575 $Y=0.0675 $X2=0.972 $Y2=0.0675
r4 50 12 0.0308642 $w=8.1e-08 $l=2.5e-09 $layer=N_src_drn $thickness=1e-09
+ $X=0.9546 $Y=0.0675 $X2=0.9575 $Y2=0.0675
r5 47 45 0.0308642 $w=8.1e-08 $l=2.5e-09 $layer=N_src_drn $thickness=1e-09
+ $X=0.8813 $Y=0.0675 $X2=0.8785 $Y2=0.0675
r6 3 45 0.179012 $w=8.1e-08 $l=1.45e-08 $layer=N_src_drn $thickness=1e-09
+ $X=0.864 $Y=0.0675 $X2=0.8785 $Y2=0.0675
r7 11 3 0.179012 $w=8.1e-08 $l=1.45e-08 $layer=N_src_drn $thickness=1e-09
+ $X=0.8495 $Y=0.0675 $X2=0.864 $Y2=0.0675
r8 46 11 0.0308642 $w=8.1e-08 $l=2.5e-09 $layer=N_src_drn $thickness=1e-09
+ $X=0.8466 $Y=0.0675 $X2=0.8495 $Y2=0.0675
r9 4 41 19.3796 $a=3.24e-16 $layer=V0LISD $X=0.972 $Y=0.0675 $X2=0.972 $Y2=0.099
r10 3 39 19.3796 $a=3.24e-16 $layer=V0LISD $X=0.864 $Y=0.0675 $X2=0.864
+ $Y2=0.099
r11 17 41 3.14806 $w=1.3e-08 $l=1.35e-08 $layer=M1 $thickness=3.6e-08 $X=0.9585
+ $Y=0.099 $X2=0.972 $Y2=0.099
r12 39 40 5.24677 $w=1.3e-08 $l=2.25e-08 $layer=M1 $thickness=3.6e-08 $X=0.864
+ $Y=0.099 $X2=0.8865 $Y2=0.099
r13 15 40 7.34548 $w=1.3e-08 $l=3.15e-08 $layer=M1 $thickness=3.6e-08 $X=0.918
+ $Y=0.099 $X2=0.8865 $Y2=0.099
r14 13 16 3.01711 $w=1.55e-08 $l=1.8e-08 $layer=M1 $thickness=3.6e-08 $X=0.945
+ $Y=0.099 $X2=0.945 $Y2=0.117
r15 13 15 5.11582 $w=1.46667e-08 $l=2.7e-08 $layer=M1 $thickness=3.6e-08
+ $X=0.945 $Y=0.099 $X2=0.918 $Y2=0.099
r16 13 17 1.96775 $w=1.63333e-08 $l=1.35e-08 $layer=M1 $thickness=3.6e-08
+ $X=0.945 $Y=0.099 $X2=0.9585 $Y2=0.099
r17 14 18 1.49895 $w=1.63333e-08 $l=1.35e-08 $layer=M1 $thickness=3.6e-08
+ $X=0.945 $Y=0.135 $X2=0.9585 $Y2=0.135
r18 14 16 2.5483 $w=1.79e-08 $l=1.8e-08 $layer=M1 $thickness=3.6e-08 $X=0.945
+ $Y=0.135 $X2=0.945 $Y2=0.117
r19 36 35 16.4967 $w=2.1e-08 $l=4.85e-08 $layer=Gate_1 $thickness=5.6e-08
+ $X=0.999 $Y=0.2025 $X2=0.999 $Y2=0.154
r20 33 34 16.4967 $w=2.1e-08 $l=4.85e-08 $layer=Gate_1 $thickness=5.6e-08
+ $X=0.999 $Y=0.0675 $X2=0.999 $Y2=0.116
r21 10 27 6.54019 $w=2.09524e-08 $layer=Gate_1 $thickness=5.21905e-08 $X=0.999
+ $Y=0.135 $X2=0.999 $Y2=0.135
r22 10 34 6.6497 $w=2.04211e-08 $l=1.9e-08 $layer=Gate_1 $thickness=5.6e-08
+ $X=0.999 $Y=0.135 $X2=0.999 $Y2=0.116
r23 10 35 6.6497 $w=2.04211e-08 $l=1.9e-08 $layer=Gate_1 $thickness=5.6e-08
+ $X=0.999 $Y=0.135 $X2=0.999 $Y2=0.154
r24 18 29 3.14806 $w=1.3e-08 $l=1.35e-08 $layer=M1 $thickness=3.6e-08 $X=0.9585
+ $Y=0.135 $X2=0.972 $Y2=0.135
r25 26 27 12.6539 $w=1.77815e-08 $l=2.7e-08 $layer=LIG $thickness=4.8e-08
+ $X=0.972 $Y=0.135 $X2=0.999 $Y2=0.135
r26 26 29 19.3796 $a=3.24e-16 $layer=V0LIG $X=0.972 $Y=0.135 $X2=0.972 $Y2=0.135
r27 1 21 6.54019 $w=2.09524e-08 $layer=Gate_1 $thickness=5.21905e-08 $X=0.945
+ $Y=0.135 $X2=0.945 $Y2=0.135
r28 1 26 12.6539 $w=1.77815e-08 $l=2.7e-08 $layer=LIG $thickness=4.8e-08
+ $X=0.945 $Y=0.135 $X2=0.972 $Y2=0.135
r29 23 22 16.4967 $w=2.1e-08 $l=4.85e-08 $layer=Gate_1 $thickness=5.6e-08
+ $X=0.945 $Y=0.2025 $X2=0.945 $Y2=0.154
r30 21 22 6.6497 $w=2.04211e-08 $l=1.9e-08 $layer=Gate_1 $thickness=5.6e-08
+ $X=0.945 $Y=0.135 $X2=0.945 $Y2=0.154
r31 20 21 6.6497 $w=2.04211e-08 $l=1.9e-08 $layer=Gate_1 $thickness=5.6e-08
+ $X=0.945 $Y=0.116 $X2=0.945 $Y2=0.135
r32 19 20 16.4967 $w=2.1e-08 $l=4.85e-08 $layer=Gate_1 $thickness=5.6e-08
+ $X=0.945 $Y=0.0675 $X2=0.945 $Y2=0.116
r33 19 9 14.6259 $w=2.1e-08 $l=4.3e-08 $layer=Gate_1 $thickness=5.6e-08
+ $X=0.945 $Y=0.0675 $X2=0.945 $Y2=0.0245
.ends

.subckt PM_CKINVDCx6p67_ASAP7_75t_R%8 vss 19 23 33 36 46 47 50 51 10 18 1 17 9
+ 15 3 11 13 14 4
c1 1 vss 0.00632591f $X=0.297 $Y=0.135
c2 3 vss 0.00729412f $X=0.216 $Y=0.2025
c3 4 vss 0.00731395f $X=0.324 $Y=0.2025
c4 9 vss 0.0822467f $X=0.297 $Y=0.0245
c5 10 vss 0.0985246f $X=0.351 $Y=0.135
c6 11 vss 0.00682202f $X=0.2015 $Y=0.2025
c7 12 vss 0.00645159f $X=0.3095 $Y=0.2025
c8 13 vss 0.000219885f $X=0.297 $Y=0.135
c9 14 vss 0.00036796f $X=0.297 $Y=0.171
c10 15 vss 0.00258538f $X=0.27 $Y=0.171
c11 16 vss 0.000156065f $X=0.297 $Y=0.153
c12 17 vss 0.000416681f $X=0.3105 $Y=0.135
c13 18 vss 0.0013109f $X=0.3105 $Y=0.171
r1 51 49 0.0308642 $w=8.1e-08 $l=2.5e-09 $layer=P_src_drn $thickness=1e-09
+ $X=0.3413 $Y=0.2025 $X2=0.3385 $Y2=0.2025
r2 4 49 0.179012 $w=8.1e-08 $l=1.45e-08 $layer=P_src_drn $thickness=1e-09
+ $X=0.324 $Y=0.2025 $X2=0.3385 $Y2=0.2025
r3 12 4 0.179012 $w=8.1e-08 $l=1.45e-08 $layer=P_src_drn $thickness=1e-09
+ $X=0.3095 $Y=0.2025 $X2=0.324 $Y2=0.2025
r4 50 12 0.0308642 $w=8.1e-08 $l=2.5e-09 $layer=P_src_drn $thickness=1e-09
+ $X=0.3066 $Y=0.2025 $X2=0.3095 $Y2=0.2025
r5 47 45 0.0308642 $w=8.1e-08 $l=2.5e-09 $layer=P_src_drn $thickness=1e-09
+ $X=0.2333 $Y=0.2025 $X2=0.2305 $Y2=0.2025
r6 3 45 0.179012 $w=8.1e-08 $l=1.45e-08 $layer=P_src_drn $thickness=1e-09
+ $X=0.216 $Y=0.2025 $X2=0.2305 $Y2=0.2025
r7 11 3 0.179012 $w=8.1e-08 $l=1.45e-08 $layer=P_src_drn $thickness=1e-09
+ $X=0.2015 $Y=0.2025 $X2=0.216 $Y2=0.2025
r8 46 11 0.0308642 $w=8.1e-08 $l=2.5e-09 $layer=P_src_drn $thickness=1e-09
+ $X=0.1986 $Y=0.2025 $X2=0.2015 $Y2=0.2025
r9 4 41 19.3796 $a=3.24e-16 $layer=V0LISD $X=0.324 $Y=0.2025 $X2=0.324 $Y2=0.171
r10 3 39 19.3796 $a=3.24e-16 $layer=V0LISD $X=0.216 $Y=0.2025 $X2=0.216
+ $Y2=0.171
r11 18 41 3.14806 $w=1.3e-08 $l=1.35e-08 $layer=M1 $thickness=3.6e-08 $X=0.3105
+ $Y=0.171 $X2=0.324 $Y2=0.171
r12 39 40 5.24677 $w=1.3e-08 $l=2.25e-08 $layer=M1 $thickness=3.6e-08 $X=0.216
+ $Y=0.171 $X2=0.2385 $Y2=0.171
r13 15 40 7.34548 $w=1.3e-08 $l=3.15e-08 $layer=M1 $thickness=3.6e-08 $X=0.27
+ $Y=0.171 $X2=0.2385 $Y2=0.171
r14 14 16 3.01711 $w=1.55e-08 $l=1.8e-08 $layer=M1 $thickness=3.6e-08 $X=0.297
+ $Y=0.171 $X2=0.297 $Y2=0.153
r15 14 15 5.11582 $w=1.46667e-08 $l=2.7e-08 $layer=M1 $thickness=3.6e-08
+ $X=0.297 $Y=0.171 $X2=0.27 $Y2=0.171
r16 14 18 1.96775 $w=1.63333e-08 $l=1.35e-08 $layer=M1 $thickness=3.6e-08
+ $X=0.297 $Y=0.171 $X2=0.3105 $Y2=0.171
r17 13 17 1.49895 $w=1.63333e-08 $l=1.35e-08 $layer=M1 $thickness=3.6e-08
+ $X=0.297 $Y=0.135 $X2=0.3105 $Y2=0.135
r18 13 16 2.5483 $w=1.79e-08 $l=1.8e-08 $layer=M1 $thickness=3.6e-08 $X=0.297
+ $Y=0.135 $X2=0.297 $Y2=0.153
r19 36 35 16.4967 $w=2.1e-08 $l=4.85e-08 $layer=Gate_1 $thickness=5.6e-08
+ $X=0.351 $Y=0.2025 $X2=0.351 $Y2=0.154
r20 33 34 16.4967 $w=2.1e-08 $l=4.85e-08 $layer=Gate_1 $thickness=5.6e-08
+ $X=0.351 $Y=0.0675 $X2=0.351 $Y2=0.116
r21 10 27 6.54019 $w=2.09524e-08 $layer=Gate_1 $thickness=5.21905e-08 $X=0.351
+ $Y=0.135 $X2=0.351 $Y2=0.135
r22 10 34 6.6497 $w=2.04211e-08 $l=1.9e-08 $layer=Gate_1 $thickness=5.6e-08
+ $X=0.351 $Y=0.135 $X2=0.351 $Y2=0.116
r23 10 35 6.6497 $w=2.04211e-08 $l=1.9e-08 $layer=Gate_1 $thickness=5.6e-08
+ $X=0.351 $Y=0.135 $X2=0.351 $Y2=0.154
r24 17 29 3.14806 $w=1.3e-08 $l=1.35e-08 $layer=M1 $thickness=3.6e-08 $X=0.3105
+ $Y=0.135 $X2=0.324 $Y2=0.135
r25 26 27 12.6539 $w=1.77815e-08 $l=2.7e-08 $layer=LIG $thickness=4.8e-08
+ $X=0.324 $Y=0.135 $X2=0.351 $Y2=0.135
r26 26 29 19.3796 $a=3.24e-16 $layer=V0LIG $X=0.324 $Y=0.135 $X2=0.324 $Y2=0.135
r27 1 21 6.54019 $w=2.09524e-08 $layer=Gate_1 $thickness=5.21905e-08 $X=0.297
+ $Y=0.135 $X2=0.297 $Y2=0.135
r28 1 26 12.6539 $w=1.77815e-08 $l=2.7e-08 $layer=LIG $thickness=4.8e-08
+ $X=0.297 $Y=0.135 $X2=0.324 $Y2=0.135
r29 23 22 16.4967 $w=2.1e-08 $l=4.85e-08 $layer=Gate_1 $thickness=5.6e-08
+ $X=0.297 $Y=0.2025 $X2=0.297 $Y2=0.154
r30 21 22 6.6497 $w=2.04211e-08 $l=1.9e-08 $layer=Gate_1 $thickness=5.6e-08
+ $X=0.297 $Y=0.135 $X2=0.297 $Y2=0.154
r31 20 21 6.6497 $w=2.04211e-08 $l=1.9e-08 $layer=Gate_1 $thickness=5.6e-08
+ $X=0.297 $Y=0.116 $X2=0.297 $Y2=0.135
r32 19 20 16.4967 $w=2.1e-08 $l=4.85e-08 $layer=Gate_1 $thickness=5.6e-08
+ $X=0.297 $Y=0.0675 $X2=0.297 $Y2=0.116
r33 19 9 14.6259 $w=2.1e-08 $l=4.3e-08 $layer=Gate_1 $thickness=5.6e-08
+ $X=0.297 $Y=0.0675 $X2=0.297 $Y2=0.0245
.ends

.subckt PM_CKINVDCx6p67_ASAP7_75t_R%Y vss 75 62 63 93 94 107 108 130 131 140
+ 141 157 158 168 169 174 175 178 179 186 187 31 2 4 6 8 41 10 42 47 43 45 9 58
+ 52 36 38 37 32 33 34 39 35 40 56 5 49 1 3 7 59 53 51 55 57 54
c1 1 vss 0.00747724f $X=0.108 $Y=0.054
c2 2 vss 0.0088274f $X=0.108 $Y=0.1755
c3 3 vss 0.0073931f $X=0.432 $Y=0.054
c4 4 vss 0.00859953f $X=0.432 $Y=0.1755
c5 5 vss 0.00729305f $X=0.756 $Y=0.054
c6 6 vss 0.00859953f $X=0.756 $Y=0.1755
c7 7 vss 0.00731021f $X=1.08 $Y=0.054
c8 8 vss 0.00853699f $X=1.08 $Y=0.1755
c9 9 vss 0.00828185f $X=1.188 $Y=0.054
c10 10 vss 0.00863556f $X=1.188 $Y=0.1755
c11 31 vss 0.00354475f $X=0.0935 $Y=0.054
c12 32 vss 0.00353899f $X=0.4175 $Y=0.054
c13 33 vss 0.00353899f $X=0.7415 $Y=0.054
c14 34 vss 0.00352832f $X=1.0655 $Y=0.054
c15 35 vss 0.00349318f $X=1.1735 $Y=0.054
c16 36 vss 0.00354863f $X=0.0935 $Y=0.216
c17 37 vss 0.00351659f $X=0.4175 $Y=0.216
c18 38 vss 0.00353621f $X=0.7415 $Y=0.216
c19 39 vss 0.00348025f $X=1.0655 $Y=0.216
c20 40 vss 0.00347772f $X=1.1735 $Y=0.216
c21 41 vss 0.00152257f $X=0.0965 $Y=0.072
c22 42 vss 0.00536816f $X=0.135 $Y=0.234
c23 43 vss 0.00126443f $X=0.459 $Y=0.072
c24 44 vss 0.00203788f $X=0.459 $Y=0.234
c25 45 vss 0.00102673f $X=0.729 $Y=0.072
c26 46 vss 0.00203753f $X=0.729 $Y=0.234
c27 47 vss 0.0010373f $X=1.053 $Y=0.072
c28 48 vss 0.00203788f $X=1.053 $Y=0.234
c29 49 vss 0.00317633f $X=1.215 $Y=0.072
c30 50 vss 0.00301628f $X=1.215 $Y=0.234
c31 51 vss 0.00597709f $X=0.135 $Y=0.0855
c32 52 vss 0.0269263f $X=0.165 $Y=0.234
c33 53 vss 0.00307188f $X=0.459 $Y=0.2025
c34 54 vss 0.0228398f $X=0.489 $Y=0.234
c35 55 vss 0.0031113f $X=0.729 $Y=0.2025
c36 56 vss 0.026934f $X=0.7425 $Y=0.234
c37 57 vss 0.00312004f $X=1.053 $Y=0.2025
c38 58 vss 0.0118952f $X=1.0665 $Y=0.234
c39 59 vss 0.00572486f $X=1.215 $Y=0.1845
r1 187 185 0.0462963 $w=5.4e-08 $l=2.5e-09 $layer=N_src_drn $thickness=1e-09
+ $X=1.2053 $Y=0.054 $X2=1.2025 $Y2=0.054
r2 9 185 0.268519 $w=5.4e-08 $l=1.45e-08 $layer=N_src_drn $thickness=1e-09
+ $X=1.188 $Y=0.054 $X2=1.2025 $Y2=0.054
r3 35 9 0.268519 $w=5.4e-08 $l=1.45e-08 $layer=N_src_drn $thickness=1e-09
+ $X=1.1735 $Y=0.054 $X2=1.188 $Y2=0.054
r4 186 35 0.0462963 $w=5.4e-08 $l=2.5e-09 $layer=N_src_drn $thickness=1e-09
+ $X=1.1706 $Y=0.054 $X2=1.1735 $Y2=0.054
r5 9 181 19.3796 $a=3.24e-16 $layer=V0LISD $X=1.188 $Y=0.054 $X2=1.188 $Y2=0.072
r6 181 182 3.14806 $w=1.3e-08 $l=1.35e-08 $layer=M1 $thickness=3.6e-08 $X=1.188
+ $Y=0.072 $X2=1.2015 $Y2=0.072
r7 49 171 6.16517 $w=1.44286e-08 $l=3.15e-08 $layer=M1 $thickness=3.6e-08
+ $X=1.215 $Y=0.072 $X2=1.215 $Y2=0.1035
r8 49 182 1.96775 $w=1.63333e-08 $l=1.35e-08 $layer=M1 $thickness=3.6e-08
+ $X=1.215 $Y=0.072 $X2=1.2015 $Y2=0.072
r9 179 177 0.0462963 $w=5.4e-08 $l=2.5e-09 $layer=N_src_drn $thickness=1e-09
+ $X=1.0973 $Y=0.054 $X2=1.0945 $Y2=0.054
r10 7 177 0.268519 $w=5.4e-08 $l=1.45e-08 $layer=N_src_drn $thickness=1e-09
+ $X=1.08 $Y=0.054 $X2=1.0945 $Y2=0.054
r11 34 7 0.268519 $w=5.4e-08 $l=1.45e-08 $layer=N_src_drn $thickness=1e-09
+ $X=1.0655 $Y=0.054 $X2=1.08 $Y2=0.054
r12 178 34 0.0462963 $w=5.4e-08 $l=2.5e-09 $layer=N_src_drn $thickness=1e-09
+ $X=1.0626 $Y=0.054 $X2=1.0655 $Y2=0.054
r13 175 173 0.0462963 $w=5.4e-08 $l=2.5e-09 $layer=P_src_drn $thickness=1e-09
+ $X=1.2053 $Y=0.216 $X2=1.2025 $Y2=0.216
r14 164 173 0.268519 $w=5.4e-08 $l=1.45e-08 $layer=P_src_drn $thickness=1e-09
+ $X=1.188 $Y=0.216 $X2=1.2025 $Y2=0.216
r15 40 164 0.268519 $w=5.4e-08 $l=1.45e-08 $layer=P_src_drn $thickness=1e-09
+ $X=1.1735 $Y=0.216 $X2=1.188 $Y2=0.216
r16 174 40 0.0462963 $w=5.4e-08 $l=2.5e-09 $layer=P_src_drn $thickness=1e-09
+ $X=1.1706 $Y=0.216 $X2=1.1735 $Y2=0.216
r17 170 171 7.34548 $w=1.3e-08 $l=3.15e-08 $layer=M1 $thickness=3.6e-08
+ $X=1.215 $Y=0.135 $X2=1.215 $Y2=0.1035
r18 59 170 11.5429 $w=1.3e-08 $l=4.95e-08 $layer=M1 $thickness=3.6e-08 $X=1.215
+ $Y=0.1845 $X2=1.215 $Y2=0.135
r19 169 167 0.0462963 $w=5.4e-08 $l=2.5e-09 $layer=P_src_drn $thickness=1e-09
+ $X=1.0973 $Y=0.216 $X2=1.0945 $Y2=0.216
r20 163 167 0.268519 $w=5.4e-08 $l=1.45e-08 $layer=P_src_drn $thickness=1e-09
+ $X=1.08 $Y=0.216 $X2=1.0945 $Y2=0.216
r21 39 163 0.268519 $w=5.4e-08 $l=1.45e-08 $layer=P_src_drn $thickness=1e-09
+ $X=1.0655 $Y=0.216 $X2=1.08 $Y2=0.216
r22 168 39 0.0462963 $w=5.4e-08 $l=2.5e-09 $layer=P_src_drn $thickness=1e-09
+ $X=1.0626 $Y=0.216 $X2=1.0655 $Y2=0.216
r23 7 160 19.3796 $a=3.24e-16 $layer=V0LISD $X=1.08 $Y=0.054 $X2=1.0795
+ $Y2=0.072
r24 10 164 23.8708 $w=2.02e-08 $l=4.05e-08 $layer=LISD $thickness=2.7e-08
+ $X=1.188 $Y=0.1755 $X2=1.188 $Y2=0.216
r25 50 154 1.49895 $w=1.63333e-08 $l=1.35e-08 $layer=M1 $thickness=3.6e-08
+ $X=1.215 $Y=0.234 $X2=1.2015 $Y2=0.234
r26 50 59 9.89378 $w=1.47818e-08 $l=4.95e-08 $layer=M1 $thickness=3.6e-08
+ $X=1.215 $Y=0.234 $X2=1.215 $Y2=0.1845
r27 8 163 23.8708 $w=2.02e-08 $l=4.05e-08 $layer=LISD $thickness=2.7e-08
+ $X=1.08 $Y=0.1755 $X2=1.08 $Y2=0.216
r28 159 160 3.03147 $w=1.3e-08 $l=1.3e-08 $layer=M1 $thickness=3.6e-08
+ $X=1.0665 $Y=0.072 $X2=1.0795 $Y2=0.072
r29 47 147 1.96775 $w=1.63333e-08 $l=1.35e-08 $layer=M1 $thickness=3.6e-08
+ $X=1.053 $Y=0.072 $X2=1.053 $Y2=0.0855
r30 47 159 1.96775 $w=1.63333e-08 $l=1.35e-08 $layer=M1 $thickness=3.6e-08
+ $X=1.053 $Y=0.072 $X2=1.0665 $Y2=0.072
r31 158 156 0.0462963 $w=5.4e-08 $l=2.5e-09 $layer=N_src_drn $thickness=1e-09
+ $X=0.7733 $Y=0.054 $X2=0.7705 $Y2=0.054
r32 5 156 0.268519 $w=5.4e-08 $l=1.45e-08 $layer=N_src_drn $thickness=1e-09
+ $X=0.756 $Y=0.054 $X2=0.7705 $Y2=0.054
r33 33 5 0.268519 $w=5.4e-08 $l=1.45e-08 $layer=N_src_drn $thickness=1e-09
+ $X=0.7415 $Y=0.054 $X2=0.756 $Y2=0.054
r34 157 33 0.0462963 $w=5.4e-08 $l=2.5e-09 $layer=N_src_drn $thickness=1e-09
+ $X=0.7386 $Y=0.054 $X2=0.7415 $Y2=0.054
r35 153 154 3.14806 $w=1.3e-08 $l=1.35e-08 $layer=M1 $thickness=3.6e-08
+ $X=1.188 $Y=0.234 $X2=1.2015 $Y2=0.234
r36 153 164 19.3796 $a=3.24e-16 $layer=V0LISD $X=1.188 $Y=0.234 $X2=1.188
+ $Y2=0.216
r37 152 153 2.68168 $w=1.3e-08 $l=1.15e-08 $layer=M1 $thickness=3.6e-08
+ $X=1.1765 $Y=0.234 $X2=1.188 $Y2=0.234
r38 151 152 1.04935 $w=1.3e-08 $l=4.5e-09 $layer=M1 $thickness=3.6e-08 $X=1.172
+ $Y=0.234 $X2=1.1765 $Y2=0.234
r39 150 151 9.91056 $w=1.3e-08 $l=4.25e-08 $layer=M1 $thickness=3.6e-08
+ $X=1.1295 $Y=0.234 $X2=1.172 $Y2=0.234
r40 149 150 9.56078 $w=1.3e-08 $l=4.1e-08 $layer=M1 $thickness=3.6e-08
+ $X=1.0885 $Y=0.234 $X2=1.1295 $Y2=0.234
r41 148 149 2.09871 $w=1.3e-08 $l=9e-09 $layer=M1 $thickness=3.6e-08 $X=1.0795
+ $Y=0.234 $X2=1.0885 $Y2=0.234
r42 148 163 19.3796 $a=3.24e-16 $layer=V0LISD $X=1.0795 $Y=0.234 $X2=1.08
+ $Y2=0.216
r43 58 148 3.03147 $w=1.3e-08 $l=1.3e-08 $layer=M1 $thickness=3.6e-08 $X=1.0665
+ $Y=0.234 $X2=1.0795 $Y2=0.234
r44 146 147 3.14806 $w=1.3e-08 $l=1.35e-08 $layer=M1 $thickness=3.6e-08
+ $X=1.053 $Y=0.099 $X2=1.053 $Y2=0.0855
r45 145 146 4.19742 $w=1.3e-08 $l=1.8e-08 $layer=M1 $thickness=3.6e-08 $X=1.053
+ $Y=0.117 $X2=1.053 $Y2=0.099
r46 144 145 4.19742 $w=1.3e-08 $l=1.8e-08 $layer=M1 $thickness=3.6e-08 $X=1.053
+ $Y=0.135 $X2=1.053 $Y2=0.117
r47 143 144 4.19742 $w=1.3e-08 $l=1.8e-08 $layer=M1 $thickness=3.6e-08 $X=1.053
+ $Y=0.153 $X2=1.053 $Y2=0.135
r48 142 143 4.19742 $w=1.3e-08 $l=1.8e-08 $layer=M1 $thickness=3.6e-08 $X=1.053
+ $Y=0.171 $X2=1.053 $Y2=0.153
r49 57 142 7.34548 $w=1.3e-08 $l=3.15e-08 $layer=M1 $thickness=3.6e-08 $X=1.053
+ $Y=0.2025 $X2=1.053 $Y2=0.171
r50 141 139 0.0462963 $w=5.4e-08 $l=2.5e-09 $layer=P_src_drn $thickness=1e-09
+ $X=0.7733 $Y=0.216 $X2=0.7705 $Y2=0.216
r51 136 139 0.268519 $w=5.4e-08 $l=1.45e-08 $layer=P_src_drn $thickness=1e-09
+ $X=0.756 $Y=0.216 $X2=0.7705 $Y2=0.216
r52 38 136 0.268519 $w=5.4e-08 $l=1.45e-08 $layer=P_src_drn $thickness=1e-09
+ $X=0.7415 $Y=0.216 $X2=0.756 $Y2=0.216
r53 140 38 0.0462963 $w=5.4e-08 $l=2.5e-09 $layer=P_src_drn $thickness=1e-09
+ $X=0.7386 $Y=0.216 $X2=0.7415 $Y2=0.216
r54 5 133 19.3796 $a=3.24e-16 $layer=V0LISD $X=0.756 $Y=0.054 $X2=0.7555
+ $Y2=0.072
r55 48 127 5.81538 $w=1.45e-08 $l=3e-08 $layer=M1 $thickness=3.6e-08 $X=1.053
+ $Y=0.234 $X2=1.023 $Y2=0.234
r56 48 57 6.16517 $w=1.44286e-08 $l=3.15e-08 $layer=M1 $thickness=3.6e-08
+ $X=1.053 $Y=0.234 $X2=1.053 $Y2=0.2025
r57 48 58 1.96775 $w=1.63333e-08 $l=1.35e-08 $layer=M1 $thickness=3.6e-08
+ $X=1.053 $Y=0.234 $X2=1.0665 $Y2=0.234
r58 6 136 23.8708 $w=2.02e-08 $l=4.05e-08 $layer=LISD $thickness=2.7e-08
+ $X=0.756 $Y=0.1755 $X2=0.756 $Y2=0.216
r59 132 133 3.03147 $w=1.3e-08 $l=1.3e-08 $layer=M1 $thickness=3.6e-08
+ $X=0.7425 $Y=0.072 $X2=0.7555 $Y2=0.072
r60 45 119 1.96775 $w=1.63333e-08 $l=1.35e-08 $layer=M1 $thickness=3.6e-08
+ $X=0.729 $Y=0.072 $X2=0.729 $Y2=0.0855
r61 45 132 1.96775 $w=1.63333e-08 $l=1.35e-08 $layer=M1 $thickness=3.6e-08
+ $X=0.729 $Y=0.072 $X2=0.7425 $Y2=0.072
r62 131 129 0.0462963 $w=5.4e-08 $l=2.5e-09 $layer=N_src_drn $thickness=1e-09
+ $X=0.4493 $Y=0.054 $X2=0.4465 $Y2=0.054
r63 3 129 0.268519 $w=5.4e-08 $l=1.45e-08 $layer=N_src_drn $thickness=1e-09
+ $X=0.432 $Y=0.054 $X2=0.4465 $Y2=0.054
r64 32 3 0.268519 $w=5.4e-08 $l=1.45e-08 $layer=N_src_drn $thickness=1e-09
+ $X=0.4175 $Y=0.054 $X2=0.432 $Y2=0.054
r65 130 32 0.0462963 $w=5.4e-08 $l=2.5e-09 $layer=N_src_drn $thickness=1e-09
+ $X=0.4146 $Y=0.054 $X2=0.4175 $Y2=0.054
r66 126 127 6.06293 $w=1.3e-08 $l=2.6e-08 $layer=M1 $thickness=3.6e-08 $X=0.997
+ $Y=0.234 $X2=1.023 $Y2=0.234
r67 125 126 1.86552 $w=1.3e-08 $l=8e-09 $layer=M1 $thickness=3.6e-08 $X=0.989
+ $Y=0.234 $X2=0.997 $Y2=0.234
r68 124 125 18.7718 $w=1.3e-08 $l=8.05e-08 $layer=M1 $thickness=3.6e-08
+ $X=0.9085 $Y=0.234 $X2=0.989 $Y2=0.234
r69 123 124 20.0543 $w=1.3e-08 $l=8.6e-08 $layer=M1 $thickness=3.6e-08
+ $X=0.8225 $Y=0.234 $X2=0.9085 $Y2=0.234
r70 122 123 7.69526 $w=1.3e-08 $l=3.3e-08 $layer=M1 $thickness=3.6e-08
+ $X=0.7895 $Y=0.234 $X2=0.8225 $Y2=0.234
r71 121 122 5.82974 $w=1.3e-08 $l=2.5e-08 $layer=M1 $thickness=3.6e-08
+ $X=0.7645 $Y=0.234 $X2=0.7895 $Y2=0.234
r72 120 121 2.09871 $w=1.3e-08 $l=9e-09 $layer=M1 $thickness=3.6e-08 $X=0.7555
+ $Y=0.234 $X2=0.7645 $Y2=0.234
r73 120 136 19.3796 $a=3.24e-16 $layer=V0LISD $X=0.7555 $Y=0.234 $X2=0.756
+ $Y2=0.216
r74 56 120 3.03147 $w=1.3e-08 $l=1.3e-08 $layer=M1 $thickness=3.6e-08 $X=0.7425
+ $Y=0.234 $X2=0.7555 $Y2=0.234
r75 118 119 3.14806 $w=1.3e-08 $l=1.35e-08 $layer=M1 $thickness=3.6e-08
+ $X=0.729 $Y=0.099 $X2=0.729 $Y2=0.0855
r76 117 118 4.19742 $w=1.3e-08 $l=1.8e-08 $layer=M1 $thickness=3.6e-08 $X=0.729
+ $Y=0.117 $X2=0.729 $Y2=0.099
r77 116 117 4.19742 $w=1.3e-08 $l=1.8e-08 $layer=M1 $thickness=3.6e-08 $X=0.729
+ $Y=0.135 $X2=0.729 $Y2=0.117
r78 115 116 4.19742 $w=1.3e-08 $l=1.8e-08 $layer=M1 $thickness=3.6e-08 $X=0.729
+ $Y=0.153 $X2=0.729 $Y2=0.135
r79 114 115 4.19742 $w=1.3e-08 $l=1.8e-08 $layer=M1 $thickness=3.6e-08 $X=0.729
+ $Y=0.171 $X2=0.729 $Y2=0.153
r80 55 114 7.34548 $w=1.3e-08 $l=3.15e-08 $layer=M1 $thickness=3.6e-08 $X=0.729
+ $Y=0.2025 $X2=0.729 $Y2=0.171
r81 3 109 19.3796 $a=3.24e-16 $layer=V0LISD $X=0.432 $Y=0.054 $X2=0.4325
+ $Y2=0.072
r82 46 104 5.4656 $w=1.45789e-08 $l=2.85e-08 $layer=M1 $thickness=3.6e-08
+ $X=0.729 $Y=0.234 $X2=0.7005 $Y2=0.234
r83 46 55 6.16517 $w=1.44286e-08 $l=3.15e-08 $layer=M1 $thickness=3.6e-08
+ $X=0.729 $Y=0.234 $X2=0.729 $Y2=0.2025
r84 46 56 1.96775 $w=1.63333e-08 $l=1.35e-08 $layer=M1 $thickness=3.6e-08
+ $X=0.729 $Y=0.234 $X2=0.7425 $Y2=0.234
r85 109 110 3.03147 $w=1.3e-08 $l=1.3e-08 $layer=M1 $thickness=3.6e-08
+ $X=0.4325 $Y=0.072 $X2=0.4455 $Y2=0.072
r86 43 100 1.96775 $w=1.63333e-08 $l=1.35e-08 $layer=M1 $thickness=3.6e-08
+ $X=0.459 $Y=0.072 $X2=0.459 $Y2=0.0855
r87 43 110 1.96775 $w=1.63333e-08 $l=1.35e-08 $layer=M1 $thickness=3.6e-08
+ $X=0.459 $Y=0.072 $X2=0.4455 $Y2=0.072
r88 108 106 0.0462963 $w=5.4e-08 $l=2.5e-09 $layer=P_src_drn $thickness=1e-09
+ $X=0.4493 $Y=0.216 $X2=0.4465 $Y2=0.216
r89 90 106 0.268519 $w=5.4e-08 $l=1.45e-08 $layer=P_src_drn $thickness=1e-09
+ $X=0.432 $Y=0.216 $X2=0.4465 $Y2=0.216
r90 37 90 0.268519 $w=5.4e-08 $l=1.45e-08 $layer=P_src_drn $thickness=1e-09
+ $X=0.4175 $Y=0.216 $X2=0.432 $Y2=0.216
r91 107 37 0.0462963 $w=5.4e-08 $l=2.5e-09 $layer=P_src_drn $thickness=1e-09
+ $X=0.4146 $Y=0.216 $X2=0.4175 $Y2=0.216
r92 103 104 22.6194 $w=1.3e-08 $l=9.7e-08 $layer=M1 $thickness=3.6e-08
+ $X=0.6035 $Y=0.234 $X2=0.7005 $Y2=0.234
r93 102 103 18.7718 $w=1.3e-08 $l=8.05e-08 $layer=M1 $thickness=3.6e-08
+ $X=0.523 $Y=0.234 $X2=0.6035 $Y2=0.234
r94 101 102 1.86552 $w=1.3e-08 $l=8e-09 $layer=M1 $thickness=3.6e-08 $X=0.515
+ $Y=0.234 $X2=0.523 $Y2=0.234
r95 54 101 6.06293 $w=1.3e-08 $l=2.6e-08 $layer=M1 $thickness=3.6e-08 $X=0.489
+ $Y=0.234 $X2=0.515 $Y2=0.234
r96 99 100 3.14806 $w=1.3e-08 $l=1.35e-08 $layer=M1 $thickness=3.6e-08 $X=0.459
+ $Y=0.099 $X2=0.459 $Y2=0.0855
r97 98 99 4.19742 $w=1.3e-08 $l=1.8e-08 $layer=M1 $thickness=3.6e-08 $X=0.459
+ $Y=0.117 $X2=0.459 $Y2=0.099
r98 97 98 4.19742 $w=1.3e-08 $l=1.8e-08 $layer=M1 $thickness=3.6e-08 $X=0.459
+ $Y=0.135 $X2=0.459 $Y2=0.117
r99 96 97 4.19742 $w=1.3e-08 $l=1.8e-08 $layer=M1 $thickness=3.6e-08 $X=0.459
+ $Y=0.153 $X2=0.459 $Y2=0.135
r100 95 96 4.19742 $w=1.3e-08 $l=1.8e-08 $layer=M1 $thickness=3.6e-08 $X=0.459
+ $Y=0.171 $X2=0.459 $Y2=0.153
r101 53 95 7.34548 $w=1.3e-08 $l=3.15e-08 $layer=M1 $thickness=3.6e-08 $X=0.459
+ $Y=0.2025 $X2=0.459 $Y2=0.171
r102 94 92 0.0462963 $w=5.4e-08 $l=2.5e-09 $layer=P_src_drn $thickness=1e-09
+ $X=0.1253 $Y=0.216 $X2=0.1225 $Y2=0.216
r103 89 92 0.268519 $w=5.4e-08 $l=1.45e-08 $layer=P_src_drn $thickness=1e-09
+ $X=0.108 $Y=0.216 $X2=0.1225 $Y2=0.216
r104 36 89 0.268519 $w=5.4e-08 $l=1.45e-08 $layer=P_src_drn $thickness=1e-09
+ $X=0.0935 $Y=0.216 $X2=0.108 $Y2=0.216
r105 93 36 0.0462963 $w=5.4e-08 $l=2.5e-09 $layer=P_src_drn $thickness=1e-09
+ $X=0.0906 $Y=0.216 $X2=0.0935 $Y2=0.216
r106 4 90 23.8708 $w=2.02e-08 $l=4.05e-08 $layer=LISD $thickness=2.7e-08
+ $X=0.432 $Y=0.1755 $X2=0.432 $Y2=0.216
r107 44 88 1.96775 $w=1.63333e-08 $l=1.35e-08 $layer=M1 $thickness=3.6e-08
+ $X=0.459 $Y=0.234 $X2=0.4455 $Y2=0.234
r108 44 53 6.16517 $w=1.44286e-08 $l=3.15e-08 $layer=M1 $thickness=3.6e-08
+ $X=0.459 $Y=0.234 $X2=0.459 $Y2=0.2025
r109 44 54 5.81538 $w=1.45e-08 $l=3e-08 $layer=M1 $thickness=3.6e-08 $X=0.459
+ $Y=0.234 $X2=0.489 $Y2=0.234
r110 2 89 23.8708 $w=2.02e-08 $l=4.05e-08 $layer=LISD $thickness=2.7e-08
+ $X=0.108 $Y=0.1755 $X2=0.108 $Y2=0.216
r111 87 88 3.03147 $w=1.3e-08 $l=1.3e-08 $layer=M1 $thickness=3.6e-08 $X=0.4325
+ $Y=0.234 $X2=0.4455 $Y2=0.234
r112 87 90 19.3796 $a=3.24e-16 $layer=V0LISD $X=0.4325 $Y=0.234 $X2=0.432
+ $Y2=0.216
r113 86 87 2.09871 $w=1.3e-08 $l=9e-09 $layer=M1 $thickness=3.6e-08 $X=0.4235
+ $Y=0.234 $X2=0.4325 $Y2=0.234
r114 85 86 5.82974 $w=1.3e-08 $l=2.5e-08 $layer=M1 $thickness=3.6e-08 $X=0.3985
+ $Y=0.234 $X2=0.4235 $Y2=0.234
r115 84 85 7.69526 $w=1.3e-08 $l=3.3e-08 $layer=M1 $thickness=3.6e-08 $X=0.3655
+ $Y=0.234 $X2=0.3985 $Y2=0.234
r116 83 84 20.0543 $w=1.3e-08 $l=8.6e-08 $layer=M1 $thickness=3.6e-08 $X=0.2795
+ $Y=0.234 $X2=0.3655 $Y2=0.234
r117 82 83 18.7718 $w=1.3e-08 $l=8.05e-08 $layer=M1 $thickness=3.6e-08 $X=0.199
+ $Y=0.234 $X2=0.2795 $Y2=0.234
r118 81 82 1.86552 $w=1.3e-08 $l=8e-09 $layer=M1 $thickness=3.6e-08 $X=0.191
+ $Y=0.234 $X2=0.199 $Y2=0.234
r119 52 81 6.06293 $w=1.3e-08 $l=2.6e-08 $layer=M1 $thickness=3.6e-08 $X=0.165
+ $Y=0.234 $X2=0.191 $Y2=0.234
r120 77 78 3.03147 $w=1.3e-08 $l=1.3e-08 $layer=M1 $thickness=3.6e-08 $X=0.1085
+ $Y=0.234 $X2=0.1215 $Y2=0.234
r121 77 89 19.3796 $a=3.24e-16 $layer=V0LISD $X=0.1085 $Y=0.234 $X2=0.108
+ $Y2=0.216
r122 42 76 2.60903 $w=1.57692e-08 $l=1.63e-08 $layer=M1 $thickness=3.6e-08
+ $X=0.135 $Y=0.234 $X2=0.135 $Y2=0.2177
r123 42 78 1.96775 $w=1.63333e-08 $l=1.35e-08 $layer=M1 $thickness=3.6e-08
+ $X=0.135 $Y=0.234 $X2=0.1215 $Y2=0.234
r124 42 52 5.81538 $w=1.45e-08 $l=3e-08 $layer=M1 $thickness=3.6e-08 $X=0.135
+ $Y=0.234 $X2=0.165 $Y2=0.234
r125 75 76 1.80722 $w=1.3e-08 $l=7.7e-09 $layer=M1 $thickness=3.6e-08 $X=0.135
+ $Y=0.21 $X2=0.135 $Y2=0.2177
r126 75 74 3.55614 $w=1.3e-08 $l=1.53e-08 $layer=M1 $thickness=3.6e-08 $X=0.135
+ $Y=0.21 $X2=0.135 $Y2=0.1947
r127 73 74 5.53826 $w=1.3e-08 $l=2.37e-08 $layer=M1 $thickness=3.6e-08 $X=0.135
+ $Y=0.171 $X2=0.135 $Y2=0.1947
r128 72 73 4.19742 $w=1.3e-08 $l=1.8e-08 $layer=M1 $thickness=3.6e-08 $X=0.135
+ $Y=0.153 $X2=0.135 $Y2=0.171
r129 71 72 4.19742 $w=1.3e-08 $l=1.8e-08 $layer=M1 $thickness=3.6e-08 $X=0.135
+ $Y=0.135 $X2=0.135 $Y2=0.153
r130 70 71 4.19742 $w=1.3e-08 $l=1.8e-08 $layer=M1 $thickness=3.6e-08 $X=0.135
+ $Y=0.117 $X2=0.135 $Y2=0.135
r131 69 70 4.19742 $w=1.3e-08 $l=1.8e-08 $layer=M1 $thickness=3.6e-08 $X=0.135
+ $Y=0.099 $X2=0.135 $Y2=0.117
r132 51 68 1.96775 $w=1.63333e-08 $l=1.35e-08 $layer=M1 $thickness=3.6e-08
+ $X=0.135 $Y=0.0855 $X2=0.135 $Y2=0.072
r133 51 69 3.14806 $w=1.3e-08 $l=1.35e-08 $layer=M1 $thickness=3.6e-08 $X=0.135
+ $Y=0.0855 $X2=0.135 $Y2=0.099
r134 67 68 1.96775 $w=1.63333e-08 $l=1.35e-08 $layer=M1 $thickness=3.6e-08
+ $X=0.1215 $Y=0.072 $X2=0.135 $Y2=0.072
r135 66 67 3.03147 $w=1.3e-08 $l=1.3e-08 $layer=M1 $thickness=3.6e-08 $X=0.1085
+ $Y=0.072 $X2=0.1215 $Y2=0.072
r136 65 66 2.09871 $w=1.3e-08 $l=9e-09 $layer=M1 $thickness=3.6e-08 $X=0.0995
+ $Y=0.072 $X2=0.1085 $Y2=0.072
r137 41 65 0.699569 $w=1.3e-08 $l=3e-09 $layer=M1 $thickness=3.6e-08 $X=0.0965
+ $Y=0.072 $X2=0.0995 $Y2=0.072
r138 1 66 19.3796 $a=3.24e-16 $layer=V0LISD $X=0.108 $Y=0.054 $X2=0.1085
+ $Y2=0.072
r139 63 61 0.0462963 $w=5.4e-08 $l=2.5e-09 $layer=N_src_drn $thickness=1e-09
+ $X=0.1253 $Y=0.054 $X2=0.1225 $Y2=0.054
r140 1 61 0.268519 $w=5.4e-08 $l=1.45e-08 $layer=N_src_drn $thickness=1e-09
+ $X=0.108 $Y=0.054 $X2=0.1225 $Y2=0.054
r141 31 1 0.268519 $w=5.4e-08 $l=1.45e-08 $layer=N_src_drn $thickness=1e-09
+ $X=0.0935 $Y=0.054 $X2=0.108 $Y2=0.054
r142 62 31 0.0462963 $w=5.4e-08 $l=2.5e-09 $layer=N_src_drn $thickness=1e-09
+ $X=0.0906 $Y=0.054 $X2=0.0935 $Y2=0.054
.ends

.subckt PM_CKINVDCx6p67_ASAP7_75t_R%A vss 60 35 41 53 56 101 104 107 110 125
+ 128 131 134 155 158 161 164 167 170 174 178 21 1 23 30 29 11 2 12 31 13 3 14
+ 4 24 33 32 15 16 22 25 26 10 17 20 19 27 34 28 18
c1 1 vss 0.0134323f $X=0.0765 $Y=0.135
c2 2 vss 0.0123877f $X=0.4005 $Y=0.135
c3 3 vss 0.0123877f $X=0.7515 $Y=0.135
c4 4 vss 0.0231454f $X=1.0755 $Y=0.135
c5 10 vss 0.0697915f $X=0.081 $Y=0.0245
c6 11 vss 0.0863868f $X=0.135 $Y=0.135
c7 12 vss 0.0880497f $X=0.405 $Y=0.135
c8 13 vss 0.0880537f $X=0.459 $Y=0.135
c9 14 vss 0.0880537f $X=0.729 $Y=0.135
c10 15 vss 0.0880497f $X=0.783 $Y=0.135
c11 16 vss 0.0879635f $X=1.053 $Y=0.135
c12 17 vss 0.06366f $X=1.107 $Y=0.135
c13 18 vss 0.0635963f $X=1.161 $Y=0.135
c14 19 vss 0.0698197f $X=1.215 $Y=0.135
c15 20 vss 0.00624515f $X=0.059 $Y=0.036
c16 21 vss 0.00504978f $X=0.075 $Y=0.135
c17 22 vss 0.00525162f $X=0.383 $Y=0.036
c18 23 vss 0.00385267f $X=0.383 $Y=0.135
c19 24 vss 0.00385267f $X=0.805 $Y=0.135
c20 25 vss 0.00525162f $X=0.805 $Y=0.036
c21 26 vss 0.00422318f $X=1.129 $Y=0.135
c22 27 vss 0.00613075f $X=1.129 $Y=0.036
c23 28 vss 0.00707107f $X=0.059 $Y=0.1035
c24 29 vss 0.0306451f $X=0.081 $Y=0.036
c25 30 vss 0.00525115f $X=0.383 $Y=0.054
c26 31 vss 0.0392613f $X=0.405 $Y=0.036
c27 32 vss 0.00525115f $X=0.805 $Y=0.054
c28 33 vss 0.0306713f $X=0.8225 $Y=0.036
c29 34 vss 0.00545466f $X=1.129 $Y=0.054
r1 178 177 14.6259 $w=2.1e-08 $l=4.3e-08 $layer=Gate_1 $thickness=5.6e-08
+ $X=1.215 $Y=0.216 $X2=1.215 $Y2=0.173
r2 176 177 7.48304 $w=2.1e-08 $l=2.2e-08 $layer=Gate_1 $thickness=5.6e-08
+ $X=1.215 $Y=0.151 $X2=1.215 $Y2=0.173
r3 174 175 14.6259 $w=2.1e-08 $l=4.3e-08 $layer=Gate_1 $thickness=5.6e-08
+ $X=1.215 $Y=0.054 $X2=1.215 $Y2=0.097
r4 172 175 7.48304 $w=2.1e-08 $l=2.2e-08 $layer=Gate_1 $thickness=5.6e-08
+ $X=1.215 $Y=0.119 $X2=1.215 $Y2=0.097
r5 19 152 6.74717 $w=2e-08 $layer=Gate_1 $thickness=5.2e-08 $X=1.215 $Y=0.135
+ $X2=1.215 $Y2=0.135
r6 19 172 5.61228 $w=2.0375e-08 $l=1.6e-08 $layer=Gate_1 $thickness=5.6e-08
+ $X=1.215 $Y=0.135 $X2=1.215 $Y2=0.119
r7 19 176 5.61228 $w=2.0375e-08 $l=1.6e-08 $layer=Gate_1 $thickness=5.6e-08
+ $X=1.215 $Y=0.135 $X2=1.215 $Y2=0.151
r8 170 169 16.6668 $w=2.1e-08 $l=4.9e-08 $layer=Gate_1 $thickness=5.6e-08
+ $X=1.161 $Y=0.216 $X2=1.161 $Y2=0.167
r9 167 168 16.6668 $w=2.1e-08 $l=4.9e-08 $layer=Gate_1 $thickness=5.6e-08
+ $X=1.161 $Y=0.054 $X2=1.161 $Y2=0.103
r10 18 149 6.4296 $w=2e-08 $layer=Gate_1 $thickness=5.22105e-08 $X=1.161
+ $Y=0.135 $X2=1.161 $Y2=0.135
r11 18 168 11.0545 $w=2.06875e-08 $l=3.2e-08 $layer=Gate_1 $thickness=5.6e-08
+ $X=1.161 $Y=0.135 $X2=1.161 $Y2=0.103
r12 18 169 11.0545 $w=2.06875e-08 $l=3.2e-08 $layer=Gate_1 $thickness=5.6e-08
+ $X=1.161 $Y=0.135 $X2=1.161 $Y2=0.167
r13 164 163 16.6668 $w=2.1e-08 $l=4.9e-08 $layer=Gate_1 $thickness=5.6e-08
+ $X=1.107 $Y=0.216 $X2=1.107 $Y2=0.167
r14 161 162 16.6668 $w=2.1e-08 $l=4.9e-08 $layer=Gate_1 $thickness=5.6e-08
+ $X=1.107 $Y=0.054 $X2=1.107 $Y2=0.103
r15 17 146 3.57145 $w=2e-08 $layer=Gate_1 $thickness=5.6e-08 $X=1.107 $Y=0.135
+ $X2=1.107 $Y2=0.135
r16 17 162 11.0545 $w=2.06875e-08 $l=3.2e-08 $layer=Gate_1 $thickness=5.6e-08
+ $X=1.107 $Y=0.135 $X2=1.107 $Y2=0.103
r17 17 163 11.0545 $w=2.06875e-08 $l=3.2e-08 $layer=Gate_1 $thickness=5.6e-08
+ $X=1.107 $Y=0.135 $X2=1.107 $Y2=0.167
r18 158 157 16.6668 $w=2.1e-08 $l=4.9e-08 $layer=Gate_1 $thickness=5.6e-08
+ $X=1.053 $Y=0.216 $X2=1.053 $Y2=0.167
r19 155 156 16.6668 $w=2.1e-08 $l=4.9e-08 $layer=Gate_1 $thickness=5.6e-08
+ $X=1.053 $Y=0.054 $X2=1.053 $Y2=0.103
r20 16 142 6.74717 $w=2e-08 $layer=Gate_1 $thickness=5.2e-08 $X=1.053 $Y=0.135
+ $X2=1.053 $Y2=0.135
r21 16 156 11.0545 $w=2.06875e-08 $l=3.2e-08 $layer=Gate_1 $thickness=5.6e-08
+ $X=1.053 $Y=0.135 $X2=1.053 $Y2=0.103
r22 16 157 11.0545 $w=2.06875e-08 $l=3.2e-08 $layer=Gate_1 $thickness=5.6e-08
+ $X=1.053 $Y=0.135 $X2=1.053 $Y2=0.167
r23 151 152 20.114 $w=1.57815e-08 $l=2.7e-08 $layer=LIG $thickness=4.8e-08
+ $X=1.188 $Y=0.135 $X2=1.215 $Y2=0.135
r24 150 151 17.097 $w=1.34914e-08 $l=1.75e-08 $layer=LIG $thickness=4.8e-08
+ $X=1.1705 $Y=0.135 $X2=1.188 $Y2=0.135
r25 149 150 3.01694 $w=2e-08 $l=9.5e-09 $layer=LIG $thickness=4.8e-08 $X=1.161
+ $Y=0.135 $X2=1.1705 $Y2=0.135
r26 148 149 3.01694 $w=2e-08 $l=9.5e-09 $layer=LIG $thickness=4.8e-08 $X=1.1515
+ $Y=0.135 $X2=1.161 $Y2=0.135
r27 147 148 17.097 $w=1.34914e-08 $l=1.75e-08 $layer=LIG $thickness=4.8e-08
+ $X=1.134 $Y=0.135 $X2=1.1515 $Y2=0.135
r28 145 146 1.74665 $w=2e-08 $l=4.5e-09 $layer=LIG $thickness=4.8e-08 $X=1.1115
+ $Y=0.135 $X2=1.107 $Y2=0.135
r29 145 147 18.6849 $w=1.49378e-08 $l=2.25e-08 $layer=LIG $thickness=4.8e-08
+ $X=1.1115 $Y=0.135 $X2=1.134 $Y2=0.135
r30 144 145 3.17572 $w=2e-08 $l=1e-08 $layer=LIG $thickness=4.8e-08 $X=1.1015
+ $Y=0.135 $X2=1.1115 $Y2=0.135
r31 141 144 5.91273 $w=1.665e-08 $l=9e-09 $layer=LIG $thickness=4.8e-08
+ $X=1.0925 $Y=0.135 $X2=1.1015 $Y2=0.135
r32 4 141 16.9382 $w=1.33e-08 $l=1.7e-08 $layer=LIG $thickness=4.8e-08
+ $X=1.0755 $Y=0.135 $X2=1.0925 $Y2=0.135
r33 4 142 15.6303 $w=1.62778e-08 $l=2.25e-08 $layer=LIG $thickness=4.8e-08
+ $X=1.0755 $Y=0.135 $X2=1.053 $Y2=0.135
r34 140 149 19.3796 $a=3.24e-16 $layer=V0LIG $X=1.161 $Y=0.135 $X2=1.161
+ $Y2=0.135
r35 139 140 3.73104 $w=1.3e-08 $l=1.6e-08 $layer=M1 $thickness=3.6e-08 $X=1.145
+ $Y=0.135 $X2=1.161 $Y2=0.135
r36 136 137 3.03147 $w=1.3e-08 $l=1.3e-08 $layer=M1 $thickness=3.6e-08 $X=1.1
+ $Y=0.135 $X2=1.113 $Y2=0.135
r37 136 141 19.3796 $a=3.24e-16 $layer=V0LIG $X=1.1 $Y=0.135 $X2=1.0925
+ $Y2=0.135
r38 26 123 6.16517 $w=1.44286e-08 $l=3.15e-08 $layer=M1 $thickness=3.6e-08
+ $X=1.129 $Y=0.135 $X2=1.129 $Y2=0.1035
r39 26 137 2.55073 $w=1.58125e-08 $l=1.6e-08 $layer=M1 $thickness=3.6e-08
+ $X=1.129 $Y=0.135 $X2=1.113 $Y2=0.135
r40 26 139 2.55073 $w=1.58125e-08 $l=1.6e-08 $layer=M1 $thickness=3.6e-08
+ $X=1.129 $Y=0.135 $X2=1.145 $Y2=0.135
r41 134 133 16.6668 $w=2.1e-08 $l=4.9e-08 $layer=Gate_1 $thickness=5.6e-08
+ $X=0.783 $Y=0.216 $X2=0.783 $Y2=0.167
r42 131 132 16.6668 $w=2.1e-08 $l=4.9e-08 $layer=Gate_1 $thickness=5.6e-08
+ $X=0.783 $Y=0.054 $X2=0.783 $Y2=0.103
r43 15 120 3.57145 $w=2e-08 $layer=Gate_1 $thickness=5.6e-08 $X=0.783 $Y=0.135
+ $X2=0.783 $Y2=0.135
r44 15 132 11.0545 $w=2.06875e-08 $l=3.2e-08 $layer=Gate_1 $thickness=5.6e-08
+ $X=0.783 $Y=0.135 $X2=0.783 $Y2=0.103
r45 15 133 11.0545 $w=2.06875e-08 $l=3.2e-08 $layer=Gate_1 $thickness=5.6e-08
+ $X=0.783 $Y=0.135 $X2=0.783 $Y2=0.167
r46 128 127 16.6668 $w=2.1e-08 $l=4.9e-08 $layer=Gate_1 $thickness=5.6e-08
+ $X=0.729 $Y=0.216 $X2=0.729 $Y2=0.167
r47 125 126 16.6668 $w=2.1e-08 $l=4.9e-08 $layer=Gate_1 $thickness=5.6e-08
+ $X=0.729 $Y=0.054 $X2=0.729 $Y2=0.103
r48 14 116 6.74717 $w=2e-08 $layer=Gate_1 $thickness=5.2e-08 $X=0.729 $Y=0.135
+ $X2=0.729 $Y2=0.135
r49 14 126 11.0545 $w=2.06875e-08 $l=3.2e-08 $layer=Gate_1 $thickness=5.6e-08
+ $X=0.729 $Y=0.135 $X2=0.729 $Y2=0.103
r50 14 127 11.0545 $w=2.06875e-08 $l=3.2e-08 $layer=Gate_1 $thickness=5.6e-08
+ $X=0.729 $Y=0.135 $X2=0.729 $Y2=0.167
r51 122 123 7.34548 $w=1.3e-08 $l=3.15e-08 $layer=M1 $thickness=3.6e-08
+ $X=1.129 $Y=0.072 $X2=1.129 $Y2=0.1035
r52 34 122 4.19742 $w=1.3e-08 $l=1.8e-08 $layer=M1 $thickness=3.6e-08 $X=1.129
+ $Y=0.054 $X2=1.129 $Y2=0.072
r53 119 120 1.74665 $w=2e-08 $l=4.5e-09 $layer=LIG $thickness=4.8e-08 $X=0.7875
+ $Y=0.135 $X2=0.783 $Y2=0.135
r54 118 119 3.17572 $w=2e-08 $l=1e-08 $layer=LIG $thickness=4.8e-08 $X=0.7775
+ $Y=0.135 $X2=0.7875 $Y2=0.135
r55 115 118 5.91273 $w=1.665e-08 $l=9e-09 $layer=LIG $thickness=4.8e-08
+ $X=0.7685 $Y=0.135 $X2=0.7775 $Y2=0.135
r56 3 115 16.9382 $w=1.33e-08 $l=1.7e-08 $layer=LIG $thickness=4.8e-08
+ $X=0.7515 $Y=0.135 $X2=0.7685 $Y2=0.135
r57 3 116 15.6303 $w=1.62778e-08 $l=2.25e-08 $layer=LIG $thickness=4.8e-08
+ $X=0.7515 $Y=0.135 $X2=0.729 $Y2=0.135
r58 27 99 3.48106 $w=1.50455e-08 $l=2.2e-08 $layer=M1 $thickness=3.6e-08
+ $X=1.129 $Y=0.036 $X2=1.107 $Y2=0.036
r59 27 34 2.5483 $w=1.79e-08 $l=1.8e-08 $layer=M1 $thickness=3.6e-08 $X=1.129
+ $Y=0.036 $X2=1.129 $Y2=0.054
r60 112 113 3.03147 $w=1.3e-08 $l=1.3e-08 $layer=M1 $thickness=3.6e-08 $X=0.776
+ $Y=0.135 $X2=0.789 $Y2=0.135
r61 112 115 19.3796 $a=3.24e-16 $layer=V0LIG $X=0.776 $Y=0.135 $X2=0.7685
+ $Y2=0.135
r62 24 93 3.01711 $w=1.55e-08 $l=1.8e-08 $layer=M1 $thickness=3.6e-08 $X=0.805
+ $Y=0.135 $X2=0.805 $Y2=0.117
r63 24 113 2.55073 $w=1.58125e-08 $l=1.6e-08 $layer=M1 $thickness=3.6e-08
+ $X=0.805 $Y=0.135 $X2=0.789 $Y2=0.135
r64 110 109 16.6668 $w=2.1e-08 $l=4.9e-08 $layer=Gate_1 $thickness=5.6e-08
+ $X=0.459 $Y=0.216 $X2=0.459 $Y2=0.167
r65 107 108 16.6668 $w=2.1e-08 $l=4.9e-08 $layer=Gate_1 $thickness=5.6e-08
+ $X=0.459 $Y=0.054 $X2=0.459 $Y2=0.103
r66 13 88 6.74717 $w=2e-08 $layer=Gate_1 $thickness=5.2e-08 $X=0.459 $Y=0.135
+ $X2=0.459 $Y2=0.135
r67 13 108 11.0545 $w=2.06875e-08 $l=3.2e-08 $layer=Gate_1 $thickness=5.6e-08
+ $X=0.459 $Y=0.135 $X2=0.459 $Y2=0.103
r68 13 109 11.0545 $w=2.06875e-08 $l=3.2e-08 $layer=Gate_1 $thickness=5.6e-08
+ $X=0.459 $Y=0.135 $X2=0.459 $Y2=0.167
r69 104 103 16.6668 $w=2.1e-08 $l=4.9e-08 $layer=Gate_1 $thickness=5.6e-08
+ $X=0.405 $Y=0.216 $X2=0.405 $Y2=0.167
r70 101 102 16.6668 $w=2.1e-08 $l=4.9e-08 $layer=Gate_1 $thickness=5.6e-08
+ $X=0.405 $Y=0.054 $X2=0.405 $Y2=0.103
r71 12 84 3.57145 $w=2e-08 $layer=Gate_1 $thickness=5.6e-08 $X=0.405 $Y=0.135
+ $X2=0.405 $Y2=0.135
r72 12 102 11.0545 $w=2.06875e-08 $l=3.2e-08 $layer=Gate_1 $thickness=5.6e-08
+ $X=0.405 $Y=0.135 $X2=0.405 $Y2=0.103
r73 12 103 11.0545 $w=2.06875e-08 $l=3.2e-08 $layer=Gate_1 $thickness=5.6e-08
+ $X=0.405 $Y=0.135 $X2=0.405 $Y2=0.167
r74 98 99 8.86121 $w=1.3e-08 $l=3.8e-08 $layer=M1 $thickness=3.6e-08 $X=1.069
+ $Y=0.036 $X2=1.107 $Y2=0.036
r75 97 98 10.7267 $w=1.3e-08 $l=4.6e-08 $layer=M1 $thickness=3.6e-08 $X=1.023
+ $Y=0.036 $X2=1.069 $Y2=0.036
r76 96 97 22.6194 $w=1.3e-08 $l=9.7e-08 $layer=M1 $thickness=3.6e-08 $X=0.926
+ $Y=0.036 $X2=1.023 $Y2=0.036
r77 95 96 18.6552 $w=1.3e-08 $l=8e-08 $layer=M1 $thickness=3.6e-08 $X=0.846
+ $Y=0.036 $X2=0.926 $Y2=0.036
r78 94 95 2.2153 $w=1.3e-08 $l=9.5e-09 $layer=M1 $thickness=3.6e-08 $X=0.8365
+ $Y=0.036 $X2=0.846 $Y2=0.036
r79 33 94 3.26466 $w=1.3e-08 $l=1.4e-08 $layer=M1 $thickness=3.6e-08 $X=0.8225
+ $Y=0.036 $X2=0.8365 $Y2=0.036
r80 92 93 4.19742 $w=1.3e-08 $l=1.8e-08 $layer=M1 $thickness=3.6e-08 $X=0.805
+ $Y=0.099 $X2=0.805 $Y2=0.117
r81 91 92 3.14806 $w=1.3e-08 $l=1.35e-08 $layer=M1 $thickness=3.6e-08 $X=0.805
+ $Y=0.0855 $X2=0.805 $Y2=0.099
r82 90 91 3.14806 $w=1.3e-08 $l=1.35e-08 $layer=M1 $thickness=3.6e-08 $X=0.805
+ $Y=0.072 $X2=0.805 $Y2=0.0855
r83 32 90 4.19742 $w=1.3e-08 $l=1.8e-08 $layer=M1 $thickness=3.6e-08 $X=0.805
+ $Y=0.054 $X2=0.805 $Y2=0.072
r84 87 88 15.6303 $w=1.62778e-08 $l=2.25e-08 $layer=LIG $thickness=4.8e-08
+ $X=0.4365 $Y=0.135 $X2=0.459 $Y2=0.135
r85 86 87 16.9382 $w=1.33e-08 $l=1.7e-08 $layer=LIG $thickness=4.8e-08
+ $X=0.4195 $Y=0.135 $X2=0.4365 $Y2=0.135
r86 83 86 5.91273 $w=1.665e-08 $l=9e-09 $layer=LIG $thickness=4.8e-08 $X=0.4105
+ $Y=0.135 $X2=0.4195 $Y2=0.135
r87 2 83 3.17572 $w=2e-08 $l=1e-08 $layer=LIG $thickness=4.8e-08 $X=0.4005
+ $Y=0.135 $X2=0.4105 $Y2=0.135
r88 2 84 1.74665 $w=2e-08 $l=4.5e-09 $layer=LIG $thickness=4.8e-08 $X=0.4005
+ $Y=0.135 $X2=0.405 $Y2=0.135
r89 25 79 3.94987 $w=1.50455e-08 $l=2.2e-08 $layer=M1 $thickness=3.6e-08
+ $X=0.805 $Y=0.036 $X2=0.783 $Y2=0.036
r90 25 32 3.01711 $w=1.55e-08 $l=1.8e-08 $layer=M1 $thickness=3.6e-08 $X=0.805
+ $Y=0.036 $X2=0.805 $Y2=0.054
r91 25 33 2.90051 $w=1.55714e-08 $l=1.75e-08 $layer=M1 $thickness=3.6e-08
+ $X=0.805 $Y=0.036 $X2=0.8225 $Y2=0.036
r92 81 83 19.3796 $a=3.24e-16 $layer=V0LIG $X=0.412 $Y=0.135 $X2=0.4105
+ $Y2=0.135
r93 80 81 3.03147 $w=1.3e-08 $l=1.3e-08 $layer=M1 $thickness=3.6e-08 $X=0.399
+ $Y=0.135 $X2=0.412 $Y2=0.135
r94 23 71 3.01711 $w=1.55e-08 $l=1.8e-08 $layer=M1 $thickness=3.6e-08 $X=0.383
+ $Y=0.135 $X2=0.383 $Y2=0.117
r95 23 80 2.55073 $w=1.58125e-08 $l=1.6e-08 $layer=M1 $thickness=3.6e-08
+ $X=0.383 $Y=0.135 $X2=0.399 $Y2=0.135
r96 78 79 8.86121 $w=1.3e-08 $l=3.8e-08 $layer=M1 $thickness=3.6e-08 $X=0.745
+ $Y=0.036 $X2=0.783 $Y2=0.036
r97 77 78 10.3769 $w=1.3e-08 $l=4.45e-08 $layer=M1 $thickness=3.6e-08 $X=0.7005
+ $Y=0.036 $X2=0.745 $Y2=0.036
r98 76 77 5.82974 $w=1.3e-08 $l=2.5e-08 $layer=M1 $thickness=3.6e-08 $X=0.6755
+ $Y=0.036 $X2=0.7005 $Y2=0.036
r99 75 76 2.2153 $w=1.3e-08 $l=9.5e-09 $layer=M1 $thickness=3.6e-08 $X=0.666
+ $Y=0.036 $X2=0.6755 $Y2=0.036
r100 74 75 18.6552 $w=1.3e-08 $l=8e-08 $layer=M1 $thickness=3.6e-08 $X=0.586
+ $Y=0.036 $X2=0.666 $Y2=0.036
r101 73 74 22.6194 $w=1.3e-08 $l=9.7e-08 $layer=M1 $thickness=3.6e-08 $X=0.489
+ $Y=0.036 $X2=0.586 $Y2=0.036
r102 72 73 10.7267 $w=1.3e-08 $l=4.6e-08 $layer=M1 $thickness=3.6e-08 $X=0.443
+ $Y=0.036 $X2=0.489 $Y2=0.036
r103 31 72 8.86121 $w=1.3e-08 $l=3.8e-08 $layer=M1 $thickness=3.6e-08 $X=0.405
+ $Y=0.036 $X2=0.443 $Y2=0.036
r104 70 71 4.19742 $w=1.3e-08 $l=1.8e-08 $layer=M1 $thickness=3.6e-08 $X=0.383
+ $Y=0.099 $X2=0.383 $Y2=0.117
r105 69 70 3.14806 $w=1.3e-08 $l=1.35e-08 $layer=M1 $thickness=3.6e-08 $X=0.383
+ $Y=0.0855 $X2=0.383 $Y2=0.099
r106 68 69 3.14806 $w=1.3e-08 $l=1.35e-08 $layer=M1 $thickness=3.6e-08 $X=0.383
+ $Y=0.072 $X2=0.383 $Y2=0.0855
r107 30 68 4.19742 $w=1.3e-08 $l=1.8e-08 $layer=M1 $thickness=3.6e-08 $X=0.383
+ $Y=0.054 $X2=0.383 $Y2=0.072
r108 22 67 2.90051 $w=1.55714e-08 $l=1.75e-08 $layer=M1 $thickness=3.6e-08
+ $X=0.383 $Y=0.036 $X2=0.3655 $Y2=0.036
r109 22 30 3.01711 $w=1.55e-08 $l=1.8e-08 $layer=M1 $thickness=3.6e-08 $X=0.383
+ $Y=0.036 $X2=0.383 $Y2=0.054
r110 22 31 3.94987 $w=1.50455e-08 $l=2.2e-08 $layer=M1 $thickness=3.6e-08
+ $X=0.383 $Y=0.036 $X2=0.405 $Y2=0.036
r111 66 67 3.26466 $w=1.3e-08 $l=1.4e-08 $layer=M1 $thickness=3.6e-08 $X=0.3515
+ $Y=0.036 $X2=0.3655 $Y2=0.036
r112 65 66 2.2153 $w=1.3e-08 $l=9.5e-09 $layer=M1 $thickness=3.6e-08 $X=0.342
+ $Y=0.036 $X2=0.3515 $Y2=0.036
r113 64 65 18.6552 $w=1.3e-08 $l=8e-08 $layer=M1 $thickness=3.6e-08 $X=0.262
+ $Y=0.036 $X2=0.342 $Y2=0.036
r114 63 64 22.6194 $w=1.3e-08 $l=9.7e-08 $layer=M1 $thickness=3.6e-08 $X=0.165
+ $Y=0.036 $X2=0.262 $Y2=0.036
r115 62 63 10.7267 $w=1.3e-08 $l=4.6e-08 $layer=M1 $thickness=3.6e-08 $X=0.119
+ $Y=0.036 $X2=0.165 $Y2=0.036
r116 29 62 8.86121 $w=1.3e-08 $l=3.8e-08 $layer=M1 $thickness=3.6e-08 $X=0.081
+ $Y=0.036 $X2=0.119 $Y2=0.036
r117 20 59 1.79044 $w=1.89797e-08 $l=1.47e-08 $layer=M1 $thickness=3.6e-08
+ $X=0.059 $Y=0.036 $X2=0.059 $Y2=0.0507
r118 20 29 3.48106 $w=1.50455e-08 $l=2.2e-08 $layer=M1 $thickness=3.6e-08
+ $X=0.059 $Y=0.036 $X2=0.081 $Y2=0.036
r119 60 61 0.757867 $w=1.3e-08 $l=3.2e-09 $layer=M1 $thickness=3.6e-08 $X=0.06
+ $Y=0.057 $X2=0.059 $Y2=0.0602
r120 60 59 1.45744 $w=1.3e-08 $l=6.3e-09 $layer=M1 $thickness=3.6e-08 $X=0.06
+ $Y=0.057 $X2=0.059 $Y2=0.0507
r121 58 61 2.73998 $w=1.3e-08 $l=1.18e-08 $layer=M1 $thickness=3.6e-08 $X=0.059
+ $Y=0.072 $X2=0.059 $Y2=0.0602
r122 28 50 6.16517 $w=1.44286e-08 $l=3.15e-08 $layer=M1 $thickness=3.6e-08
+ $X=0.059 $Y=0.1035 $X2=0.059 $Y2=0.135
r123 28 58 7.34548 $w=1.3e-08 $l=3.15e-08 $layer=M1 $thickness=3.6e-08 $X=0.059
+ $Y=0.1035 $X2=0.059 $Y2=0.072
r124 56 55 16.6668 $w=2.1e-08 $l=4.9e-08 $layer=Gate_1 $thickness=5.6e-08
+ $X=0.135 $Y=0.216 $X2=0.135 $Y2=0.167
r125 53 54 16.6668 $w=2.1e-08 $l=4.9e-08 $layer=Gate_1 $thickness=5.6e-08
+ $X=0.135 $Y=0.054 $X2=0.135 $Y2=0.103
r126 11 47 6.74717 $w=2e-08 $layer=Gate_1 $thickness=5.2e-08 $X=0.135 $Y=0.135
+ $X2=0.135 $Y2=0.135
r127 11 54 11.0545 $w=2.06875e-08 $l=3.2e-08 $layer=Gate_1 $thickness=5.6e-08
+ $X=0.135 $Y=0.135 $X2=0.135 $Y2=0.103
r128 11 55 11.0545 $w=2.06875e-08 $l=3.2e-08 $layer=Gate_1 $thickness=5.6e-08
+ $X=0.135 $Y=0.135 $X2=0.135 $Y2=0.167
r129 21 49 3.03147 $w=1.3e-08 $l=1.3e-08 $layer=M1 $thickness=3.6e-08 $X=0.075
+ $Y=0.135 $X2=0.088 $Y2=0.135
r130 21 50 2.55073 $w=1.58125e-08 $l=1.6e-08 $layer=M1 $thickness=3.6e-08
+ $X=0.075 $Y=0.135 $X2=0.059 $Y2=0.135
r131 46 47 15.6303 $w=1.62778e-08 $l=2.25e-08 $layer=LIG $thickness=4.8e-08
+ $X=0.1125 $Y=0.135 $X2=0.135 $Y2=0.135
r132 45 46 16.9382 $w=1.33e-08 $l=1.7e-08 $layer=LIG $thickness=4.8e-08
+ $X=0.0955 $Y=0.135 $X2=0.1125 $Y2=0.135
r133 43 45 5.91273 $w=1.665e-08 $l=9e-09 $layer=LIG $thickness=4.8e-08
+ $X=0.0865 $Y=0.135 $X2=0.0955 $Y2=0.135
r134 43 49 19.3796 $a=3.24e-16 $layer=V0LIG $X=0.0865 $Y=0.135 $X2=0.088
+ $Y2=0.135
r135 1 43 3.17572 $w=2e-08 $l=1e-08 $layer=LIG $thickness=4.8e-08 $X=0.0765
+ $Y=0.135 $X2=0.0865 $Y2=0.135
r136 1 38 5.3181 $w=2e-08 $l=4.5e-09 $layer=Gate_1 $thickness=5.31613e-08
+ $X=0.0765 $Y=0.135 $X2=0.081 $Y2=0.135
r137 41 40 14.6259 $w=2.1e-08 $l=4.3e-08 $layer=Gate_1 $thickness=5.6e-08
+ $X=0.081 $Y=0.216 $X2=0.081 $Y2=0.173
r138 39 40 7.48304 $w=2.1e-08 $l=2.2e-08 $layer=Gate_1 $thickness=5.6e-08
+ $X=0.081 $Y=0.151 $X2=0.081 $Y2=0.173
r139 38 39 5.61228 $w=2.0375e-08 $l=1.6e-08 $layer=Gate_1 $thickness=5.6e-08
+ $X=0.081 $Y=0.135 $X2=0.081 $Y2=0.151
r140 38 43 5.00052 $w=2e-08 $l=5.5e-09 $layer=Gate_1 $thickness=5.35172e-08
+ $X=0.081 $Y=0.135 $X2=0.0865 $Y2=0.135
r141 37 38 5.61228 $w=2.0375e-08 $l=1.6e-08 $layer=Gate_1 $thickness=5.6e-08
+ $X=0.081 $Y=0.119 $X2=0.081 $Y2=0.135
r142 36 37 7.48304 $w=2.1e-08 $l=2.2e-08 $layer=Gate_1 $thickness=5.6e-08
+ $X=0.081 $Y=0.097 $X2=0.081 $Y2=0.119
r143 35 36 14.6259 $w=2.1e-08 $l=4.3e-08 $layer=Gate_1 $thickness=5.6e-08
+ $X=0.081 $Y=0.054 $X2=0.081 $Y2=0.097
r144 35 10 10.0341 $w=2.1e-08 $l=2.95e-08 $layer=Gate_1 $thickness=5.6e-08
+ $X=0.081 $Y=0.054 $X2=0.081 $Y2=0.0245
.ends

.subckt PM_CKINVDCx6p67_ASAP7_75t_R%7 vss 19 23 33 36 46 47 50 51 10 9 15 17 3
+ 1 11 13 4 18
c1 1 vss 0.00634002f $X=0.621 $Y=0.135
c2 3 vss 0.00731161f $X=0.54 $Y=0.2025
c3 4 vss 0.0071647f $X=0.648 $Y=0.2025
c4 9 vss 0.0822671f $X=0.621 $Y=0.0245
c5 10 vss 0.105741f $X=0.675 $Y=0.135
c6 11 vss 0.00707569f $X=0.5255 $Y=0.2025
c7 12 vss 0.00668897f $X=0.6335 $Y=0.2025
c8 13 vss 0.000209249f $X=0.621 $Y=0.135
c9 14 vss 0.000356037f $X=0.621 $Y=0.171
c10 15 vss 0.00267443f $X=0.594 $Y=0.171
c11 16 vss 0.000149611f $X=0.621 $Y=0.153
c12 17 vss 0.000711436f $X=0.6345 $Y=0.135
c13 18 vss 0.00136962f $X=0.6345 $Y=0.171
r1 51 49 0.0308642 $w=8.1e-08 $l=2.5e-09 $layer=P_src_drn $thickness=1e-09
+ $X=0.6653 $Y=0.2025 $X2=0.6625 $Y2=0.2025
r2 4 49 0.179012 $w=8.1e-08 $l=1.45e-08 $layer=P_src_drn $thickness=1e-09
+ $X=0.648 $Y=0.2025 $X2=0.6625 $Y2=0.2025
r3 12 4 0.179012 $w=8.1e-08 $l=1.45e-08 $layer=P_src_drn $thickness=1e-09
+ $X=0.6335 $Y=0.2025 $X2=0.648 $Y2=0.2025
r4 50 12 0.0308642 $w=8.1e-08 $l=2.5e-09 $layer=P_src_drn $thickness=1e-09
+ $X=0.6306 $Y=0.2025 $X2=0.6335 $Y2=0.2025
r5 47 45 0.0308642 $w=8.1e-08 $l=2.5e-09 $layer=P_src_drn $thickness=1e-09
+ $X=0.5573 $Y=0.2025 $X2=0.5545 $Y2=0.2025
r6 3 45 0.179012 $w=8.1e-08 $l=1.45e-08 $layer=P_src_drn $thickness=1e-09
+ $X=0.54 $Y=0.2025 $X2=0.5545 $Y2=0.2025
r7 11 3 0.179012 $w=8.1e-08 $l=1.45e-08 $layer=P_src_drn $thickness=1e-09
+ $X=0.5255 $Y=0.2025 $X2=0.54 $Y2=0.2025
r8 46 11 0.0308642 $w=8.1e-08 $l=2.5e-09 $layer=P_src_drn $thickness=1e-09
+ $X=0.5226 $Y=0.2025 $X2=0.5255 $Y2=0.2025
r9 4 41 19.3796 $a=3.24e-16 $layer=V0LISD $X=0.648 $Y=0.2025 $X2=0.648 $Y2=0.171
r10 3 39 19.3796 $a=3.24e-16 $layer=V0LISD $X=0.54 $Y=0.2025 $X2=0.54 $Y2=0.171
r11 18 41 3.14806 $w=1.3e-08 $l=1.35e-08 $layer=M1 $thickness=3.6e-08 $X=0.6345
+ $Y=0.171 $X2=0.648 $Y2=0.171
r12 39 40 5.24677 $w=1.3e-08 $l=2.25e-08 $layer=M1 $thickness=3.6e-08 $X=0.54
+ $Y=0.171 $X2=0.5625 $Y2=0.171
r13 15 40 7.34548 $w=1.3e-08 $l=3.15e-08 $layer=M1 $thickness=3.6e-08 $X=0.594
+ $Y=0.171 $X2=0.5625 $Y2=0.171
r14 14 16 3.01711 $w=1.55e-08 $l=1.8e-08 $layer=M1 $thickness=3.6e-08 $X=0.621
+ $Y=0.171 $X2=0.621 $Y2=0.153
r15 14 15 5.11582 $w=1.46667e-08 $l=2.7e-08 $layer=M1 $thickness=3.6e-08
+ $X=0.621 $Y=0.171 $X2=0.594 $Y2=0.171
r16 14 18 1.96775 $w=1.63333e-08 $l=1.35e-08 $layer=M1 $thickness=3.6e-08
+ $X=0.621 $Y=0.171 $X2=0.6345 $Y2=0.171
r17 13 17 1.49895 $w=1.63333e-08 $l=1.35e-08 $layer=M1 $thickness=3.6e-08
+ $X=0.621 $Y=0.135 $X2=0.6345 $Y2=0.135
r18 13 16 2.5483 $w=1.79e-08 $l=1.8e-08 $layer=M1 $thickness=3.6e-08 $X=0.621
+ $Y=0.135 $X2=0.621 $Y2=0.153
r19 36 35 16.4967 $w=2.1e-08 $l=4.85e-08 $layer=Gate_1 $thickness=5.6e-08
+ $X=0.675 $Y=0.2025 $X2=0.675 $Y2=0.154
r20 33 34 16.4967 $w=2.1e-08 $l=4.85e-08 $layer=Gate_1 $thickness=5.6e-08
+ $X=0.675 $Y=0.0675 $X2=0.675 $Y2=0.116
r21 10 27 6.54019 $w=2.09524e-08 $layer=Gate_1 $thickness=5.21905e-08 $X=0.675
+ $Y=0.135 $X2=0.675 $Y2=0.135
r22 10 34 6.6497 $w=2.04211e-08 $l=1.9e-08 $layer=Gate_1 $thickness=5.6e-08
+ $X=0.675 $Y=0.135 $X2=0.675 $Y2=0.116
r23 10 35 6.6497 $w=2.04211e-08 $l=1.9e-08 $layer=Gate_1 $thickness=5.6e-08
+ $X=0.675 $Y=0.135 $X2=0.675 $Y2=0.154
r24 17 29 3.14806 $w=1.3e-08 $l=1.35e-08 $layer=M1 $thickness=3.6e-08 $X=0.6345
+ $Y=0.135 $X2=0.648 $Y2=0.135
r25 26 27 12.6539 $w=1.77815e-08 $l=2.7e-08 $layer=LIG $thickness=4.8e-08
+ $X=0.648 $Y=0.135 $X2=0.675 $Y2=0.135
r26 26 29 19.3796 $a=3.24e-16 $layer=V0LIG $X=0.648 $Y=0.135 $X2=0.648 $Y2=0.135
r27 1 21 6.54019 $w=2.09524e-08 $layer=Gate_1 $thickness=5.21905e-08 $X=0.621
+ $Y=0.135 $X2=0.621 $Y2=0.135
r28 1 26 12.6539 $w=1.77815e-08 $l=2.7e-08 $layer=LIG $thickness=4.8e-08
+ $X=0.621 $Y=0.135 $X2=0.648 $Y2=0.135
r29 23 22 16.4967 $w=2.1e-08 $l=4.85e-08 $layer=Gate_1 $thickness=5.6e-08
+ $X=0.621 $Y=0.2025 $X2=0.621 $Y2=0.154
r30 21 22 6.6497 $w=2.04211e-08 $l=1.9e-08 $layer=Gate_1 $thickness=5.6e-08
+ $X=0.621 $Y=0.135 $X2=0.621 $Y2=0.154
r31 20 21 6.6497 $w=2.04211e-08 $l=1.9e-08 $layer=Gate_1 $thickness=5.6e-08
+ $X=0.621 $Y=0.116 $X2=0.621 $Y2=0.135
r32 19 20 16.4967 $w=2.1e-08 $l=4.85e-08 $layer=Gate_1 $thickness=5.6e-08
+ $X=0.621 $Y=0.0675 $X2=0.621 $Y2=0.116
r33 19 9 14.6259 $w=2.1e-08 $l=4.3e-08 $layer=Gate_1 $thickness=5.6e-08
+ $X=0.621 $Y=0.0675 $X2=0.621 $Y2=0.0245
.ends

.subckt PM_CKINVDCx6p67_ASAP7_75t_R%5 vss 19 23 33 36 46 47 50 51 9 15 1 16 10
+ 18 4 12 13 14 3
c1 1 vss 0.00632742f $X=0.837 $Y=0.135
c2 3 vss 0.00733028f $X=0.864 $Y=0.2025
c3 4 vss 0.00721435f $X=0.972 $Y=0.2025
c4 9 vss 0.098528f $X=0.837 $Y=0.0245
c5 10 vss 0.0822572f $X=0.891 $Y=0.135
c6 11 vss 0.00657446f $X=0.8495 $Y=0.2025
c7 12 vss 0.00695332f $X=0.9575 $Y=0.2025
c8 13 vss 0.000220907f $X=0.891 $Y=0.135
c9 14 vss 0.000369541f $X=0.891 $Y=0.171
c10 15 vss 0.00137945f $X=0.8485 $Y=0.171
c11 16 vss 0.000417235f $X=0.846 $Y=0.135
c12 17 vss 0.000156068f $X=0.891 $Y=0.153
c13 18 vss 0.00261836f $X=0.918 $Y=0.171
r1 51 49 0.0308642 $w=8.1e-08 $l=2.5e-09 $layer=P_src_drn $thickness=1e-09
+ $X=0.9893 $Y=0.2025 $X2=0.9865 $Y2=0.2025
r2 4 49 0.179012 $w=8.1e-08 $l=1.45e-08 $layer=P_src_drn $thickness=1e-09
+ $X=0.972 $Y=0.2025 $X2=0.9865 $Y2=0.2025
r3 12 4 0.179012 $w=8.1e-08 $l=1.45e-08 $layer=P_src_drn $thickness=1e-09
+ $X=0.9575 $Y=0.2025 $X2=0.972 $Y2=0.2025
r4 50 12 0.0308642 $w=8.1e-08 $l=2.5e-09 $layer=P_src_drn $thickness=1e-09
+ $X=0.9546 $Y=0.2025 $X2=0.9575 $Y2=0.2025
r5 47 45 0.0308642 $w=8.1e-08 $l=2.5e-09 $layer=P_src_drn $thickness=1e-09
+ $X=0.8813 $Y=0.2025 $X2=0.8785 $Y2=0.2025
r6 3 45 0.179012 $w=8.1e-08 $l=1.45e-08 $layer=P_src_drn $thickness=1e-09
+ $X=0.864 $Y=0.2025 $X2=0.8785 $Y2=0.2025
r7 11 3 0.179012 $w=8.1e-08 $l=1.45e-08 $layer=P_src_drn $thickness=1e-09
+ $X=0.8495 $Y=0.2025 $X2=0.864 $Y2=0.2025
r8 46 11 0.0308642 $w=8.1e-08 $l=2.5e-09 $layer=P_src_drn $thickness=1e-09
+ $X=0.8466 $Y=0.2025 $X2=0.8495 $Y2=0.2025
r9 4 42 19.3796 $a=3.24e-16 $layer=V0LISD $X=0.972 $Y=0.2025 $X2=0.972 $Y2=0.171
r10 3 38 19.3796 $a=3.24e-16 $layer=V0LISD $X=0.864 $Y=0.2025 $X2=0.864
+ $Y2=0.171
r11 41 42 5.24677 $w=1.3e-08 $l=2.25e-08 $layer=M1 $thickness=3.6e-08 $X=0.9495
+ $Y=0.171 $X2=0.972 $Y2=0.171
r12 18 41 7.34548 $w=1.3e-08 $l=3.15e-08 $layer=M1 $thickness=3.6e-08 $X=0.918
+ $Y=0.171 $X2=0.9495 $Y2=0.171
r13 38 39 3.14806 $w=1.3e-08 $l=1.35e-08 $layer=M1 $thickness=3.6e-08 $X=0.864
+ $Y=0.171 $X2=0.8775 $Y2=0.171
r14 15 38 3.61444 $w=1.3e-08 $l=1.55e-08 $layer=M1 $thickness=3.6e-08 $X=0.8485
+ $Y=0.171 $X2=0.864 $Y2=0.171
r15 14 17 3.01711 $w=1.55e-08 $l=1.8e-08 $layer=M1 $thickness=3.6e-08 $X=0.891
+ $Y=0.171 $X2=0.891 $Y2=0.153
r16 14 39 1.96775 $w=1.63333e-08 $l=1.35e-08 $layer=M1 $thickness=3.6e-08
+ $X=0.891 $Y=0.171 $X2=0.8775 $Y2=0.171
r17 14 18 5.11582 $w=1.46667e-08 $l=2.7e-08 $layer=M1 $thickness=3.6e-08
+ $X=0.891 $Y=0.171 $X2=0.918 $Y2=0.171
r18 13 31 1.49895 $w=1.63333e-08 $l=1.35e-08 $layer=M1 $thickness=3.6e-08
+ $X=0.891 $Y=0.135 $X2=0.8775 $Y2=0.135
r19 13 17 2.5483 $w=1.79e-08 $l=1.8e-08 $layer=M1 $thickness=3.6e-08 $X=0.891
+ $Y=0.135 $X2=0.891 $Y2=0.153
r20 36 35 16.4967 $w=2.1e-08 $l=4.85e-08 $layer=Gate_1 $thickness=5.6e-08
+ $X=0.891 $Y=0.2025 $X2=0.891 $Y2=0.154
r21 33 34 16.4967 $w=2.1e-08 $l=4.85e-08 $layer=Gate_1 $thickness=5.6e-08
+ $X=0.891 $Y=0.0675 $X2=0.891 $Y2=0.116
r22 10 27 6.54019 $w=2.09524e-08 $layer=Gate_1 $thickness=5.21905e-08 $X=0.891
+ $Y=0.135 $X2=0.891 $Y2=0.135
r23 10 34 6.6497 $w=2.04211e-08 $l=1.9e-08 $layer=Gate_1 $thickness=5.6e-08
+ $X=0.891 $Y=0.135 $X2=0.891 $Y2=0.116
r24 10 35 6.6497 $w=2.04211e-08 $l=1.9e-08 $layer=Gate_1 $thickness=5.6e-08
+ $X=0.891 $Y=0.135 $X2=0.891 $Y2=0.154
r25 30 31 3.14806 $w=1.3e-08 $l=1.35e-08 $layer=M1 $thickness=3.6e-08 $X=0.864
+ $Y=0.135 $X2=0.8775 $Y2=0.135
r26 29 30 2.68168 $w=1.3e-08 $l=1.15e-08 $layer=M1 $thickness=3.6e-08 $X=0.8525
+ $Y=0.135 $X2=0.864 $Y2=0.135
r27 16 29 1.51573 $w=1.3e-08 $l=6.5e-09 $layer=M1 $thickness=3.6e-08 $X=0.846
+ $Y=0.135 $X2=0.8525 $Y2=0.135
r28 26 27 12.6539 $w=1.77815e-08 $l=2.7e-08 $layer=LIG $thickness=4.8e-08
+ $X=0.864 $Y=0.135 $X2=0.891 $Y2=0.135
r29 26 30 19.3796 $a=3.24e-16 $layer=V0LIG $X=0.864 $Y=0.135 $X2=0.864 $Y2=0.135
r30 1 21 6.54019 $w=2.09524e-08 $layer=Gate_1 $thickness=5.21905e-08 $X=0.837
+ $Y=0.135 $X2=0.837 $Y2=0.135
r31 1 26 12.6539 $w=1.77815e-08 $l=2.7e-08 $layer=LIG $thickness=4.8e-08
+ $X=0.837 $Y=0.135 $X2=0.864 $Y2=0.135
r32 23 22 16.4967 $w=2.1e-08 $l=4.85e-08 $layer=Gate_1 $thickness=5.6e-08
+ $X=0.837 $Y=0.2025 $X2=0.837 $Y2=0.154
r33 21 22 6.6497 $w=2.04211e-08 $l=1.9e-08 $layer=Gate_1 $thickness=5.6e-08
+ $X=0.837 $Y=0.135 $X2=0.837 $Y2=0.154
r34 20 21 6.6497 $w=2.04211e-08 $l=1.9e-08 $layer=Gate_1 $thickness=5.6e-08
+ $X=0.837 $Y=0.116 $X2=0.837 $Y2=0.135
r35 19 20 16.4967 $w=2.1e-08 $l=4.85e-08 $layer=Gate_1 $thickness=5.6e-08
+ $X=0.837 $Y=0.0675 $X2=0.837 $Y2=0.116
r36 19 9 14.6259 $w=2.1e-08 $l=4.3e-08 $layer=Gate_1 $thickness=5.6e-08
+ $X=0.837 $Y=0.0675 $X2=0.837 $Y2=0.0245
.ends

* End of included file CKINVDCx6p67_ASAP7_75t_R.pex.sp.pex

*
.subckt CKINVDCx6p67_ASAP7_75t_CUSTOM_4_25_0_7 VSS VDD A Y
*
* VSS VSS
* VDD VDD
* A A
* Y Y
*
*

M0 N_M0_d N_M0_g VSS VSS nmos_rvt L=2e-08 W=5.4e-08 nfin=2 $X=0.071 $Y=0.027
M1 N_M1_d N_M1_g VSS VSS nmos_rvt L=2e-08 W=5.4e-08 nfin=2 $X=0.125 $Y=0.027
M16 N_M16_d N_M16_g VSS VSS nmos_rvt L=2e-08 W=8.1e-08 nfin=3 $X=0.179 $Y=0.027
M17 N_M17_d N_M17_g VSS VSS nmos_rvt L=2e-08 W=8.1e-08 nfin=3 $X=0.233 $Y=0.027
M14 N_M14_d N_M14_g VSS VSS nmos_rvt L=2e-08 W=8.1e-08 nfin=3 $X=0.287 $Y=0.027
M15 N_M15_d N_M15_g VSS VSS nmos_rvt L=2e-08 W=8.1e-08 nfin=3 $X=0.341 $Y=0.027
M6 N_M6_d N_M6_g VSS VSS nmos_rvt L=2e-08 W=5.4e-08 nfin=2 $X=0.395 $Y=0.027
M7 N_M7_d N_M7_g VSS VSS nmos_rvt L=2e-08 W=5.4e-08 nfin=2 $X=0.449 $Y=0.027
M8 N_M8_d N_M8_g VSS VSS nmos_rvt L=2e-08 W=8.1e-08 nfin=3 $X=0.503 $Y=0.027
M9 N_M9_d N_M9_g VSS VSS nmos_rvt L=2e-08 W=8.1e-08 nfin=3 $X=0.557 $Y=0.027
M10 N_M10_d N_M10_g VSS VSS nmos_rvt L=2e-08 W=8.1e-08 nfin=3 $X=0.611 $Y=0.027
M11 N_M11_d N_M11_g VSS VSS nmos_rvt L=2e-08 W=8.1e-08 nfin=3 $X=0.665 $Y=0.027
M12 N_M12_d N_M12_g VSS VSS nmos_rvt L=2e-08 W=5.4e-08 nfin=2 $X=0.719 $Y=0.027
M13 N_M13_d N_M13_g VSS VSS nmos_rvt L=2e-08 W=5.4e-08 nfin=2 $X=0.773 $Y=0.027
M4 N_M4_d N_M4_g VSS VSS nmos_rvt L=2e-08 W=8.1e-08 nfin=3 $X=0.827 $Y=0.027
M5 N_M5_d N_M5_g VSS VSS nmos_rvt L=2e-08 W=8.1e-08 nfin=3 $X=0.881 $Y=0.027
M2 N_M2_d N_M2_g VSS VSS nmos_rvt L=2e-08 W=8.1e-08 nfin=3 $X=0.935 $Y=0.027
M3 N_M3_d N_M3_g VSS VSS nmos_rvt L=2e-08 W=8.1e-08 nfin=3 $X=0.989 $Y=0.027
M18 N_M18_d N_M18_g VSS VSS nmos_rvt L=2e-08 W=5.4e-08 nfin=2 $X=1.043 $Y=0.027
M19 N_M19_d N_M19_g VSS VSS nmos_rvt L=2e-08 W=5.4e-08 nfin=2 $X=1.097 $Y=0.027
M20 N_M20_d N_M20_g VSS VSS nmos_rvt L=2e-08 W=5.4e-08 nfin=2 $X=1.151 $Y=0.027
M21 N_M21_d N_M21_g VSS VSS nmos_rvt L=2e-08 W=5.4e-08 nfin=2 $X=1.205 $Y=0.027
M22 N_M22_d N_M22_g VDD VDD pmos_rvt L=2e-08 W=5.4e-08 nfin=2 $X=0.071 $Y=0.189
M23 N_M23_d N_M23_g VDD VDD pmos_rvt L=2e-08 W=5.4e-08 nfin=2 $X=0.125 $Y=0.189
M38 N_M38_d N_M38_g VDD VDD pmos_rvt L=2e-08 W=8.1e-08 nfin=3 $X=0.179 $Y=0.162
M39 N_M39_d N_M39_g VDD VDD pmos_rvt L=2e-08 W=8.1e-08 nfin=3 $X=0.233 $Y=0.162
M36 N_M36_d N_M36_g VDD VDD pmos_rvt L=2e-08 W=8.1e-08 nfin=3 $X=0.287 $Y=0.162
M37 N_M37_d N_M37_g VDD VDD pmos_rvt L=2e-08 W=8.1e-08 nfin=3 $X=0.341 $Y=0.162
M28 N_M28_d N_M28_g VDD VDD pmos_rvt L=2e-08 W=5.4e-08 nfin=2 $X=0.395 $Y=0.189
M29 N_M29_d N_M29_g VDD VDD pmos_rvt L=2e-08 W=5.4e-08 nfin=2 $X=0.449 $Y=0.189
M30 N_M30_d N_M30_g VDD VDD pmos_rvt L=2e-08 W=8.1e-08 nfin=3 $X=0.503 $Y=0.162
M31 N_M31_d N_M31_g VDD VDD pmos_rvt L=2e-08 W=8.1e-08 nfin=3 $X=0.557 $Y=0.162
M32 N_M32_d N_M32_g VDD VDD pmos_rvt L=2e-08 W=8.1e-08 nfin=3 $X=0.611 $Y=0.162
M33 N_M33_d N_M33_g VDD VDD pmos_rvt L=2e-08 W=8.1e-08 nfin=3 $X=0.665 $Y=0.162
M34 N_M34_d N_M34_g VDD VDD pmos_rvt L=2e-08 W=5.4e-08 nfin=2 $X=0.719 $Y=0.189
M35 N_M35_d N_M35_g VDD VDD pmos_rvt L=2e-08 W=5.4e-08 nfin=2 $X=0.773 $Y=0.189
M26 N_M26_d N_M26_g VDD VDD pmos_rvt L=2e-08 W=8.1e-08 nfin=3 $X=0.827 $Y=0.162
M27 N_M27_d N_M27_g VDD VDD pmos_rvt L=2e-08 W=8.1e-08 nfin=3 $X=0.881 $Y=0.162
M24 N_M24_d N_M24_g VDD VDD pmos_rvt L=2e-08 W=8.1e-08 nfin=3 $X=0.935 $Y=0.162
M25 N_M25_d N_M25_g VDD VDD pmos_rvt L=2e-08 W=8.1e-08 nfin=3 $X=0.989 $Y=0.162
M40 N_M40_d N_M40_g VDD VDD pmos_rvt L=2e-08 W=5.4e-08 nfin=2 $X=1.043 $Y=0.189
M41 N_M41_d N_M41_g VDD VDD pmos_rvt L=2e-08 W=5.4e-08 nfin=2 $X=1.097 $Y=0.189
M42 N_M42_d N_M42_g VDD VDD pmos_rvt L=2e-08 W=5.4e-08 nfin=2 $X=1.151 $Y=0.189
M43 N_M43_d N_M43_g VDD VDD pmos_rvt L=2e-08 W=5.4e-08 nfin=2 $X=1.205 $Y=0.189

* .include "CKINVDCx6p67_ASAP7_75t_R.pex.sp.pxi"

* Start of included file CKINVDCx6p67_ASAP7_75t_R.pex.sp.pxi
x_PM_CKINVDCx6p67_ASAP7_75t_R%9 vss N_M16_g N_M38_g N_M17_g N_M39_g N_M16_d
+ N_M17_d N_M14_d N_M15_d N_9_3 N_9_15 N_9_4 N_9_1 N_9_18 N_9_9 N_9_12 N_9_16
+ N_9_14 N_9_10 PM_CKINVDCx6p67_ASAP7_75t_R%9
cc_1 N_9_3 N_A_21 4.85766e-20 $X=0.216 $Y=0.0675
cc_2 N_9_3 N_A_1 0.000207923f $X=0.216 $Y=0.0675
cc_3 N_9_3 N_A_23 0.000167599f $X=0.216 $Y=0.0675
cc_4 N_9_3 N_A_30 0.00118367f $X=0.216 $Y=0.0675
cc_5 N_9_15 N_A_29 0.000797216f $X=0.2015 $Y=0.099
cc_6 N_9_4 N_A_29 0.00090899f $X=0.324 $Y=0.0675
cc_7 N_9_1 N_A_1 0.00109175f $X=0.189 $Y=0.135
cc_8 N_9_18 N_A_29 0.00183917f $X=0.27 $Y=0.099
cc_9 N_9_9 N_A_11 0.00326714f $X=0.189 $Y=0.0245
cc_10 N_9_3 N_A_29 0.00557214f $X=0.216 $Y=0.0675
x_PM_CKINVDCx6p67_ASAP7_75t_R%6 vss N_M8_g N_M30_g N_M9_g N_M31_g N_M8_d N_M9_d
+ N_M10_d N_M11_d N_6_18 N_6_3 N_6_15 N_6_1 N_6_9 N_6_12 N_6_16 N_6_4 N_6_14
+ N_6_10 PM_CKINVDCx6p67_ASAP7_75t_R%6
cc_11 N_6_18 N_A_2 0.000207923f $X=0.594 $Y=0.099
cc_12 N_6_3 N_A_31 0.000762714f $X=0.54 $Y=0.0675
cc_13 N_6_15 N_A_31 0.000797216f $X=0.5255 $Y=0.099
cc_14 N_6_1 N_A_2 0.00110385f $X=0.513 $Y=0.135
cc_15 N_6_9 N_A_13 0.00327691f $X=0.513 $Y=0.0245
cc_16 N_6_18 N_A_31 0.00730235f $X=0.594 $Y=0.099
x_PM_CKINVDCx6p67_ASAP7_75t_R%4 vss N_M2_g N_M24_g N_M3_g N_M25_g N_M4_d N_M5_d
+ N_M2_d N_M3_d N_4_4 N_4_1 N_4_15 N_4_17 N_4_10 N_4_3 N_4_11 N_4_18 N_4_14
+ N_4_9 PM_CKINVDCx6p67_ASAP7_75t_R%4
cc_17 N_4_4 N_A_4 0.000127028f $X=0.972 $Y=0.0675
cc_18 N_4_4 N_A_24 0.000167599f $X=0.972 $Y=0.0675
cc_19 N_4_4 N_A_32 0.000442219f $X=0.972 $Y=0.0675
cc_20 N_4_1 N_A_4 0.000587628f $X=0.945 $Y=0.135
cc_21 N_4_15 N_A_32 0.000741448f $X=0.918 $Y=0.099
cc_22 N_4_17 N_A_33 0.000797216f $X=0.9585 $Y=0.099
cc_23 N_4_10 N_A_4 0.000846926f $X=0.999 $Y=0.135
cc_24 N_4_3 N_A_33 0.00090899f $X=0.864 $Y=0.0675
cc_25 N_4_15 N_A_33 0.00183917f $X=0.918 $Y=0.099
cc_26 N_4_10 N_A_16 0.00321394f $X=0.999 $Y=0.135
cc_27 N_4_4 N_A_33 0.00555999f $X=0.972 $Y=0.0675
cc_28 N_4_11 N_5_10 0.0322877f $X=0.8495 $Y=0.0675
cc_29 N_4_15 N_5_16 0.00114063f $X=0.918 $Y=0.099
cc_30 N_4_18 N_5_18 0.00130158f $X=0.9585 $Y=0.135
cc_31 N_4_10 N_5_4 0.00143003f $X=0.999 $Y=0.135
cc_32 N_4_3 N_5_9 0.00143003f $X=0.864 $Y=0.0675
cc_33 N_4_3 N_5_1 0.00170816f $X=0.864 $Y=0.0675
cc_34 N_4_1 N_5_4 0.00174175f $X=0.945 $Y=0.135
cc_35 N_4_11 N_5_1 0.00297733f $X=0.8495 $Y=0.0675
cc_36 N_4_1 N_5_12 0.00299711f $X=0.945 $Y=0.135
cc_37 N_4_15 N_5_13 0.00373504f $X=0.918 $Y=0.099
cc_38 N_4_14 N_5_18 0.00376346f $X=0.945 $Y=0.135
cc_39 N_4_10 N_5_12 0.0426133f $X=0.999 $Y=0.135
cc_40 N_4_9 N_5_12 0.0209185f $X=0.945 $Y=0.0245
cc_41 N_4_11 N_5_9 0.034163f $X=0.8495 $Y=0.0675
x_PM_CKINVDCx6p67_ASAP7_75t_R%8 vss N_M14_g N_M36_g N_M15_g N_M37_g N_M38_d
+ N_M39_d N_M36_d N_M37_d N_8_10 N_8_18 N_8_1 N_8_17 N_8_9 N_8_15 N_8_3 N_8_11
+ N_8_13 N_8_14 N_8_4 PM_CKINVDCx6p67_ASAP7_75t_R%8
cc_42 N_8_10 N_A_1 9.8336e-20 $X=0.351 $Y=0.135
cc_43 N_8_10 N_A_23 0.000431645f $X=0.351 $Y=0.135
cc_44 N_8_10 N_A_2 0.000232856f $X=0.351 $Y=0.135
cc_45 N_8_10 N_A_29 0.000305204f $X=0.351 $Y=0.135
cc_46 N_8_10 N_A_30 0.000537689f $X=0.351 $Y=0.135
cc_47 N_8_18 N_A_23 0.000834759f $X=0.3105 $Y=0.171
cc_48 N_8_1 N_A_2 0.00119989f $X=0.297 $Y=0.135
cc_49 N_8_17 N_A_23 0.00175611f $X=0.3105 $Y=0.135
cc_50 N_8_10 N_A_12 0.00344531f $X=0.351 $Y=0.135
cc_51 N_8_9 N_9_12 0.0322877f $X=0.297 $Y=0.0245
cc_52 N_8_17 N_9_18 0.00114063f $X=0.3105 $Y=0.135
cc_53 N_8_15 N_9_16 0.00130161f $X=0.27 $Y=0.171
cc_54 N_8_10 N_9_4 0.00143003f $X=0.351 $Y=0.135
cc_55 N_8_3 N_9_9 0.00143003f $X=0.216 $Y=0.2025
cc_56 N_8_1 N_9_4 0.00170826f $X=0.297 $Y=0.135
cc_57 N_8_3 N_9_1 0.0017327f $X=0.216 $Y=0.2025
cc_58 N_8_1 N_9_12 0.00296468f $X=0.297 $Y=0.135
cc_59 N_8_11 N_9_1 0.0029964f $X=0.2015 $Y=0.2025
cc_60 N_8_13 N_9_18 0.00373504f $X=0.297 $Y=0.135
cc_61 N_8_15 N_9_14 0.00376346f $X=0.27 $Y=0.171
cc_62 N_8_11 N_9_9 0.0425883f $X=0.2015 $Y=0.2025
cc_63 N_8_11 N_9_10 0.0209185f $X=0.2015 $Y=0.2025
cc_64 N_8_10 N_9_12 0.0341631f $X=0.351 $Y=0.135
x_PM_CKINVDCx6p67_ASAP7_75t_R%Y vss Y N_M0_d N_M1_d N_M22_d N_M23_d N_M28_d
+ N_M29_d N_M6_d N_M7_d N_M34_d N_M35_d N_M12_d N_M13_d N_M40_d N_M41_d N_M42_d
+ N_M43_d N_M18_d N_M19_d N_M20_d N_M21_d N_Y_31 N_Y_2 N_Y_4 N_Y_6 N_Y_8 N_Y_41
+ N_Y_10 N_Y_42 N_Y_47 N_Y_43 N_Y_45 N_Y_9 N_Y_58 N_Y_52 N_Y_36 N_Y_38 N_Y_37
+ N_Y_32 N_Y_33 N_Y_34 N_Y_39 N_Y_35 N_Y_40 N_Y_56 N_Y_5 N_Y_49 N_Y_1 N_Y_3
+ N_Y_7 N_Y_59 N_Y_53 N_Y_51 N_Y_55 N_Y_57 N_Y_54 PM_CKINVDCx6p67_ASAP7_75t_R%Y
cc_65 N_Y_31 N_A_22 6.59864e-20 $X=0.0935 $Y=0.054
cc_66 N_Y_31 N_A_25 6.59864e-20 $X=0.0935 $Y=0.054
cc_67 N_Y_31 N_A_26 8.87331e-20 $X=0.0935 $Y=0.054
cc_68 N_Y_2 N_A_10 0.00247044f $X=0.108 $Y=0.1755
cc_69 N_Y_4 N_A_13 0.000105319f $X=0.432 $Y=0.1755
cc_70 N_Y_6 N_A_15 0.00245869f $X=0.756 $Y=0.1755
cc_71 N_Y_8 N_A_17 0.000105319f $X=1.08 $Y=0.1755
cc_72 N_Y_41 N_A_20 0.000107713f $X=0.0965 $Y=0.072
cc_73 N_Y_10 N_A_19 0.00242669f $X=1.188 $Y=0.1755
cc_74 N_Y_42 N_A_21 0.000152484f $X=0.135 $Y=0.234
cc_75 N_Y_41 N_A_21 0.000204957f $X=0.0965 $Y=0.072
cc_76 N_Y_47 N_A_26 0.000326716f $X=1.053 $Y=0.072
cc_77 N_Y_43 N_A_23 0.000339404f $X=0.459 $Y=0.072
cc_78 N_Y_45 N_A_24 0.000339404f $X=0.729 $Y=0.072
cc_79 N_Y_47 N_A_27 0.000361032f $X=1.053 $Y=0.072
cc_80 N_Y_9 N_A_34 0.000421339f $X=1.188 $Y=0.054
cc_81 N_Y_58 N_A_26 0.000518799f $X=1.0665 $Y=0.234
cc_82 N_Y_52 N_A_23 0.000603837f $X=0.165 $Y=0.234
cc_83 N_Y_36 N_A_10 0.0398615f $X=0.0935 $Y=0.216
cc_84 N_Y_31 N_A_10 0.000611138f $X=0.0935 $Y=0.054
cc_85 N_Y_38 N_A_14 0.0282931f $X=0.7415 $Y=0.216
cc_86 N_Y_37 N_A_13 0.0406721f $X=0.4175 $Y=0.216
cc_87 N_Y_32 N_A_12 0.0406712f $X=0.4175 $Y=0.054
cc_88 N_Y_33 N_A_14 0.00815582f $X=0.7415 $Y=0.054
cc_89 N_Y_34 N_A_16 0.028311f $X=1.0655 $Y=0.054
cc_90 N_Y_39 N_A_17 0.0397439f $X=1.0655 $Y=0.216
cc_91 N_Y_35 N_A_19 0.0345725f $X=1.1735 $Y=0.054
cc_92 N_Y_40 N_A_19 0.0203549f $X=1.1735 $Y=0.216
cc_93 N_Y_56 N_A_24 0.000685564f $X=0.7425 $Y=0.234
cc_94 N_Y_5 N_A_31 0.000873289f $X=0.756 $Y=0.054
cc_95 N_Y_49 N_A_34 0.000875499f $X=1.215 $Y=0.072
cc_96 N_Y_1 N_A_29 0.000876693f $X=0.108 $Y=0.054
cc_97 N_Y_3 N_A_31 0.000876693f $X=0.432 $Y=0.054
cc_98 N_Y_7 N_A_33 0.000876693f $X=1.08 $Y=0.054
cc_99 N_Y_10 N_A_4 0.00103974f $X=1.188 $Y=0.1755
cc_100 N_Y_43 N_A_30 0.00114034f $X=0.459 $Y=0.072
cc_101 N_Y_45 N_A_32 0.00114034f $X=0.729 $Y=0.072
cc_102 N_Y_3 N_A_2 0.00494327f $X=0.432 $Y=0.054
cc_103 N_Y_5 N_A_3 0.00494327f $X=0.756 $Y=0.054
cc_104 N_Y_1 N_A_1 0.00115381f $X=0.108 $Y=0.054
cc_105 N_Y_7 N_A_4 0.00116512f $X=1.08 $Y=0.054
cc_106 N_Y_41 N_A_28 0.00123062f $X=0.0965 $Y=0.072
cc_107 N_Y_47 N_A_34 0.00204675f $X=1.053 $Y=0.072
cc_108 N_Y_8 N_A_16 0.00234803f $X=1.08 $Y=0.1755
cc_109 N_Y_4 N_A_12 0.00235337f $X=0.432 $Y=0.1755
cc_110 N_Y_9 N_A_19 0.00252474f $X=1.188 $Y=0.054
cc_111 N_Y_3 N_A_13 0.00292444f $X=0.432 $Y=0.054
cc_112 N_Y_5 N_A_14 0.00292444f $X=0.756 $Y=0.054
cc_113 N_Y_7 N_A_16 0.00295027f $X=1.08 $Y=0.054
cc_114 N_Y_1 N_A_11 0.00295522f $X=0.108 $Y=0.054
cc_115 N_Y_45 N_A_31 0.00312067f $X=0.729 $Y=0.072
cc_116 N_Y_59 N_A_26 0.00315728f $X=1.215 $Y=0.1845
cc_117 N_Y_53 N_A_23 0.0036f $X=0.459 $Y=0.2025
cc_118 N_Y_51 N_A_21 0.00362002f $X=0.135 $Y=0.0855
cc_119 N_Y_55 N_A_24 0.00365691f $X=0.729 $Y=0.2025
cc_120 N_Y_57 N_A_26 0.0038396f $X=1.053 $Y=0.2025
cc_121 N_Y_2 N_A_1 0.00388225f $X=0.108 $Y=0.1755
cc_122 N_Y_41 N_A_29 0.00623207f $X=0.0965 $Y=0.072
cc_123 N_Y_47 N_A_33 0.00637687f $X=1.053 $Y=0.072
cc_124 N_Y_36 N_A_11 0.00731064f $X=0.0935 $Y=0.216
cc_125 N_Y_34 N_A_17 0.0197376f $X=1.0655 $Y=0.054
cc_126 N_Y_39 N_A_16 0.00732768f $X=1.0655 $Y=0.216
cc_127 N_Y_37 N_A_12 0.0075281f $X=0.4175 $Y=0.216
cc_128 N_Y_38 N_A_15 0.019896f $X=0.7415 $Y=0.216
cc_129 N_Y_32 N_A_13 0.00752829f $X=0.4175 $Y=0.054
cc_130 N_Y_9 N_A_4 0.00809054f $X=1.188 $Y=0.054
cc_131 N_Y_43 N_A_31 0.00919348f $X=0.459 $Y=0.072
cc_132 N_Y_35 N_A_18 0.0123861f $X=1.1735 $Y=0.054
cc_133 N_Y_33 N_A_15 0.0400437f $X=0.7415 $Y=0.054
cc_134 N_Y_40 N_A_18 0.0267349f $X=1.1735 $Y=0.216
cc_135 N_Y_31 N_A_11 0.047297f $X=0.0935 $Y=0.054
cc_136 N_Y_2 N_8_14 8.17701e-20 $X=0.108 $Y=0.1755
cc_137 N_Y_4 N_8_14 0.000171012f $X=0.432 $Y=0.1755
cc_138 N_Y_53 N_8_14 0.000269333f $X=0.459 $Y=0.2025
cc_139 N_Y_51 N_8_14 0.000451785f $X=0.135 $Y=0.0855
cc_140 N_Y_52 N_8_4 0.000821735f $X=0.165 $Y=0.234
cc_141 N_Y_52 N_8_3 0.000868677f $X=0.165 $Y=0.234
cc_142 N_Y_52 N_8_18 0.000999126f $X=0.165 $Y=0.234
cc_143 N_Y_52 N_8_15 0.00161046f $X=0.165 $Y=0.234
cc_144 N_Y_52 N_8_14 0.00534446f $X=0.165 $Y=0.234
cc_145 N_Y_4 N_6_16 0.000104739f $X=0.432 $Y=0.1755
cc_146 N_Y_45 N_6_16 0.000286414f $X=0.729 $Y=0.072
cc_147 N_Y_43 N_6_16 0.000467386f $X=0.459 $Y=0.072
cc_148 N_Y_55 N_6_16 0.000161316f $X=0.729 $Y=0.2025
cc_149 N_Y_54 N_6_16 0.000220457f $X=0.489 $Y=0.234
cc_150 N_Y_53 N_6_15 0.000687005f $X=0.459 $Y=0.2025
cc_151 N_Y_55 N_6_18 0.000810165f $X=0.729 $Y=0.2025
cc_152 N_Y_53 N_6_16 0.00210843f $X=0.459 $Y=0.2025
cc_153 N_Y_6 N_7_15 0.000101803f $X=0.756 $Y=0.1755
cc_154 N_Y_55 N_7_15 0.000193017f $X=0.729 $Y=0.2025
cc_155 N_Y_53 N_7_15 0.000485137f $X=0.459 $Y=0.2025
cc_156 N_Y_55 N_7_17 0.000489569f $X=0.729 $Y=0.2025
cc_157 N_Y_54 N_7_3 0.000868677f $X=0.489 $Y=0.234
cc_158 N_Y_54 N_7_4 0.000872291f $X=0.489 $Y=0.234
cc_159 N_Y_55 N_7_18 0.00129259f $X=0.729 $Y=0.2025
cc_160 N_Y_54 N_7_18 0.00145159f $X=0.489 $Y=0.234
cc_161 N_Y_54 N_7_15 0.00716481f $X=0.489 $Y=0.234
cc_162 N_Y_55 N_5_14 0.000154258f $X=0.729 $Y=0.2025
cc_163 N_Y_6 N_5_14 0.000171012f $X=0.756 $Y=0.1755
cc_164 N_Y_57 N_5_14 0.000483888f $X=1.053 $Y=0.2025
cc_165 N_Y_56 N_5_3 0.000821735f $X=0.7425 $Y=0.234
cc_166 N_Y_56 N_5_4 0.00089936f $X=0.7425 $Y=0.234
cc_167 N_Y_56 N_5_15 0.000981207f $X=0.7425 $Y=0.234
cc_168 N_Y_56 N_5_18 0.00161046f $X=0.7425 $Y=0.234
cc_169 N_Y_56 N_5_14 0.00519282f $X=0.7425 $Y=0.234
cc_170 N_Y_47 N_4_18 0.000485114f $X=1.053 $Y=0.072
cc_171 N_Y_45 N_4_18 0.000258254f $X=0.729 $Y=0.072
cc_172 N_Y_56 N_4_18 0.000448028f $X=0.7425 $Y=0.234
cc_173 N_Y_57 N_4_17 0.000687005f $X=1.053 $Y=0.2025
cc_174 N_Y_57 N_4_18 0.00227765f $X=1.053 $Y=0.2025
x_PM_CKINVDCx6p67_ASAP7_75t_R%A vss A N_M0_g N_M22_g N_M1_g N_M23_g N_M6_g
+ N_M28_g N_M7_g N_M29_g N_M12_g N_M34_g N_M13_g N_M35_g N_M18_g N_M40_g
+ N_M19_g N_M41_g N_M20_g N_M42_g N_M21_g N_M43_g N_A_21 N_A_1 N_A_23 N_A_30
+ N_A_29 N_A_11 N_A_2 N_A_12 N_A_31 N_A_13 N_A_3 N_A_14 N_A_4 N_A_24 N_A_33
+ N_A_32 N_A_15 N_A_16 N_A_22 N_A_25 N_A_26 N_A_10 N_A_17 N_A_20 N_A_19 N_A_27
+ N_A_34 N_A_28 N_A_18 PM_CKINVDCx6p67_ASAP7_75t_R%A
x_PM_CKINVDCx6p67_ASAP7_75t_R%7 vss N_M10_g N_M32_g N_M11_g N_M33_g N_M30_d
+ N_M31_d N_M32_d N_M33_d N_7_10 N_7_9 N_7_15 N_7_17 N_7_3 N_7_1 N_7_11 N_7_13
+ N_7_4 N_7_18 PM_CKINVDCx6p67_ASAP7_75t_R%7
cc_175 N_7_10 N_A_3 0.00140364f $X=0.675 $Y=0.135
cc_176 N_7_10 N_A_14 0.00340095f $X=0.675 $Y=0.135
cc_177 N_7_9 N_6_12 0.0322877f $X=0.621 $Y=0.0245
cc_178 N_7_15 N_6_16 0.00130161f $X=0.594 $Y=0.171
cc_179 N_7_17 N_6_18 0.00132094f $X=0.6345 $Y=0.135
cc_180 N_7_10 N_6_4 0.00143003f $X=0.675 $Y=0.135
cc_181 N_7_3 N_6_9 0.00143003f $X=0.54 $Y=0.2025
cc_182 N_7_3 N_6_1 0.0017327f $X=0.54 $Y=0.2025
cc_183 N_7_1 N_6_4 0.0017327f $X=0.621 $Y=0.135
cc_184 N_7_11 N_6_1 0.0029964f $X=0.5255 $Y=0.2025
cc_185 N_7_1 N_6_12 0.0029964f $X=0.621 $Y=0.135
cc_186 N_7_15 N_6_14 0.00378928f $X=0.594 $Y=0.171
cc_187 N_7_13 N_6_18 0.00381378f $X=0.621 $Y=0.135
cc_188 N_7_11 N_6_9 0.0426576f $X=0.5255 $Y=0.2025
cc_189 N_7_11 N_6_10 0.0209185f $X=0.5255 $Y=0.2025
cc_190 N_7_10 N_6_12 0.0341786f $X=0.675 $Y=0.135
x_PM_CKINVDCx6p67_ASAP7_75t_R%5 vss N_M4_g N_M26_g N_M5_g N_M27_g N_M26_d
+ N_M27_d N_M24_d N_M25_d N_5_9 N_5_15 N_5_1 N_5_16 N_5_10 N_5_18 N_5_4 N_5_12
+ N_5_13 N_5_14 N_5_3 PM_CKINVDCx6p67_ASAP7_75t_R%5
cc_191 N_5_9 N_A_4 9.32237e-20 $X=0.837 $Y=0.0245
cc_192 N_5_9 N_A_24 0.000431711f $X=0.837 $Y=0.0245
cc_193 N_5_9 N_A_3 0.000232856f $X=0.837 $Y=0.0245
cc_194 N_5_9 N_A_33 0.000297066f $X=0.837 $Y=0.0245
cc_195 N_5_9 N_A_32 0.000537689f $X=0.837 $Y=0.0245
cc_196 N_5_15 N_A_24 0.000834726f $X=0.8485 $Y=0.171
cc_197 N_5_1 N_A_3 0.00120019f $X=0.837 $Y=0.135
cc_198 N_5_16 N_A_24 0.00175611f $X=0.846 $Y=0.135
cc_199 N_5_9 N_A_15 0.003429f $X=0.837 $Y=0.0245

* End of included file CKINVDCx6p67_ASAP7_75t_R.pex.sp.pxi
.ends

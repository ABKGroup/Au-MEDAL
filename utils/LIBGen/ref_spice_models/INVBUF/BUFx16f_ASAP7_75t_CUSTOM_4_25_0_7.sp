.subckt PM_BUFx16f_ASAP7_75t_R%A vss 30 10 16 33 36 39 42 45 48 3 6 8 7 5 4 9 1
c1 1 vss 0.0295742f $X=0.081 $Y=0.135
c2 3 vss 0.0914167f $X=0.081 $Y=0.0245
c3 4 vss 0.0807714f $X=0.135 $Y=0.135
c4 5 vss 0.0804004f $X=0.189 $Y=0.135
c5 6 vss 0.0818678f $X=0.243 $Y=0.135
c6 7 vss 0.0100067f $X=0.027 $Y=0.036
c7 8 vss 0.00986078f $X=0.027 $Y=0.234
c8 9 vss 0.0252362f $X=0.027 $Y=0.086
r1 8 31 9.66302 $w=1.39677e-08 $l=4.65e-08 $layer=M1 $thickness=3.6e-08
+ $X=0.027 $Y=0.234 $X2=0.027 $Y2=0.1875
r2 7 9 10.4792 $w=1.39e-08 $l=5e-08 $layer=M1 $thickness=3.6e-08 $X=0.027
+ $Y=0.036 $X2=0.027 $Y2=0.086
r3 48 47 17.0069 $w=2.1e-08 $l=5e-08 $layer=Gate_1 $thickness=5.6e-08 $X=0.243
+ $Y=0.2025 $X2=0.243 $Y2=0.1525
r4 45 46 17.0069 $w=2.1e-08 $l=5e-08 $layer=Gate_1 $thickness=5.6e-08 $X=0.243
+ $Y=0.0675 $X2=0.243 $Y2=0.1175
r5 6 26 7.58422 $w=1.77778e-08 $layer=LIG $thickness=5.15556e-08 $X=0.243
+ $Y=0.135 $X2=0.243 $Y2=0.135
r6 6 46 6.08847 $w=2.05429e-08 $l=1.75e-08 $layer=Gate_1 $thickness=5.6e-08
+ $X=0.243 $Y=0.135 $X2=0.243 $Y2=0.1175
r7 6 47 6.08847 $w=2.05429e-08 $l=1.75e-08 $layer=Gate_1 $thickness=5.6e-08
+ $X=0.243 $Y=0.135 $X2=0.243 $Y2=0.1525
r8 42 41 17.0069 $w=2.1e-08 $l=5e-08 $layer=Gate_1 $thickness=5.6e-08 $X=0.189
+ $Y=0.2025 $X2=0.189 $Y2=0.1525
r9 39 40 17.0069 $w=2.1e-08 $l=5e-08 $layer=Gate_1 $thickness=5.6e-08 $X=0.189
+ $Y=0.0675 $X2=0.189 $Y2=0.1175
r10 5 24 7.58422 $w=1.77778e-08 $layer=LIG $thickness=5.15556e-08 $X=0.189
+ $Y=0.135 $X2=0.189 $Y2=0.135
r11 5 40 6.08847 $w=2.05429e-08 $l=1.75e-08 $layer=Gate_1 $thickness=5.6e-08
+ $X=0.189 $Y=0.135 $X2=0.189 $Y2=0.1175
r12 5 41 6.08847 $w=2.05429e-08 $l=1.75e-08 $layer=Gate_1 $thickness=5.6e-08
+ $X=0.189 $Y=0.135 $X2=0.189 $Y2=0.1525
r13 36 35 17.0069 $w=2.1e-08 $l=5e-08 $layer=Gate_1 $thickness=5.6e-08 $X=0.135
+ $Y=0.2025 $X2=0.135 $Y2=0.1525
r14 33 34 17.0069 $w=2.1e-08 $l=5e-08 $layer=Gate_1 $thickness=5.6e-08 $X=0.135
+ $Y=0.0675 $X2=0.135 $Y2=0.1175
r15 4 22 7.58422 $w=1.77778e-08 $layer=LIG $thickness=5.15556e-08 $X=0.135
+ $Y=0.135 $X2=0.135 $Y2=0.135
r16 4 34 6.08847 $w=2.05429e-08 $l=1.75e-08 $layer=Gate_1 $thickness=5.6e-08
+ $X=0.135 $Y=0.135 $X2=0.135 $Y2=0.1175
r17 4 35 6.08847 $w=2.05429e-08 $l=1.75e-08 $layer=Gate_1 $thickness=5.6e-08
+ $X=0.135 $Y=0.135 $X2=0.135 $Y2=0.1525
r18 30 31 8.86121 $w=1.3e-08 $l=3.8e-08 $layer=M1 $thickness=3.6e-08 $X=0.026
+ $Y=0.1495 $X2=0.027 $Y2=0.1875
r19 30 29 0.816164 $w=1.3e-08 $l=3.5e-09 $layer=M1 $thickness=3.6e-08 $X=0.026
+ $Y=0.1495 $X2=0.027 $Y2=0.146
r20 28 29 2.56509 $w=1.3e-08 $l=1.1e-08 $layer=M1 $thickness=3.6e-08 $X=0.027
+ $Y=0.135 $X2=0.027 $Y2=0.146
r21 9 28 11.4263 $w=1.3e-08 $l=4.9e-08 $layer=M1 $thickness=3.6e-08 $X=0.027
+ $Y=0.086 $X2=0.027 $Y2=0.135
r22 25 26 44.3552 $w=1.17815e-08 $l=2.7e-08 $layer=LIG $thickness=4.8e-08
+ $X=0.216 $Y=0.135 $X2=0.243 $Y2=0.135
r23 24 25 44.3552 $w=1.17815e-08 $l=2.7e-08 $layer=LIG $thickness=4.8e-08
+ $X=0.189 $Y=0.135 $X2=0.216 $Y2=0.135
r24 23 24 44.3552 $w=1.17815e-08 $l=2.7e-08 $layer=LIG $thickness=4.8e-08
+ $X=0.162 $Y=0.135 $X2=0.189 $Y2=0.135
r25 22 23 44.3552 $w=1.17815e-08 $l=2.7e-08 $layer=LIG $thickness=4.8e-08
+ $X=0.135 $Y=0.135 $X2=0.162 $Y2=0.135
r26 21 22 44.3552 $w=1.17815e-08 $l=2.7e-08 $layer=LIG $thickness=4.8e-08
+ $X=0.108 $Y=0.135 $X2=0.135 $Y2=0.135
r27 19 20 61.7733 $w=9.3e-09 $l=2.65e-08 $layer=LIG $thickness=4.8e-08 $X=0.027
+ $Y=0.135 $X2=0.0535 $Y2=0.135
r28 19 28 28.9687 $a=2.88e-16 $layer=V0LIG $X=0.027 $Y=0.135 $X2=0.027 $Y2=0.135
r29 1 13 7.58422 $w=1.77778e-08 $layer=LIG $thickness=5.15556e-08 $X=0.081
+ $Y=0.135 $X2=0.081 $Y2=0.135
r30 1 20 45.5208 $w=1.17364e-08 $l=2.75e-08 $layer=LIG $thickness=4.8e-08
+ $X=0.081 $Y=0.135 $X2=0.0535 $Y2=0.135
r31 1 21 44.3552 $w=1.17815e-08 $l=2.7e-08 $layer=LIG $thickness=4.8e-08
+ $X=0.081 $Y=0.135 $X2=0.108 $Y2=0.135
r32 16 15 14.6259 $w=2.1e-08 $l=4.3e-08 $layer=Gate_1 $thickness=5.6e-08
+ $X=0.081 $Y=0.2025 $X2=0.081 $Y2=0.1595
r33 14 15 3.23131 $w=2.1e-08 $l=9.5e-09 $layer=Gate_1 $thickness=5.6e-08
+ $X=0.081 $Y=0.15 $X2=0.081 $Y2=0.1595
r34 13 14 5.23813 $w=2.04667e-08 $l=1.5e-08 $layer=Gate_1 $thickness=5.6e-08
+ $X=0.081 $Y=0.135 $X2=0.081 $Y2=0.15
r35 12 13 5.23813 $w=2.04667e-08 $l=1.5e-08 $layer=Gate_1 $thickness=5.6e-08
+ $X=0.081 $Y=0.12 $X2=0.081 $Y2=0.135
r36 11 12 3.23131 $w=2.1e-08 $l=9.5e-09 $layer=Gate_1 $thickness=5.6e-08
+ $X=0.081 $Y=0.1105 $X2=0.081 $Y2=0.12
r37 10 11 14.6259 $w=2.1e-08 $l=4.3e-08 $layer=Gate_1 $thickness=5.6e-08
+ $X=0.081 $Y=0.0675 $X2=0.081 $Y2=0.1105
r38 10 3 14.6259 $w=2.1e-08 $l=4.3e-08 $layer=Gate_1 $thickness=5.6e-08
+ $X=0.081 $Y=0.0675 $X2=0.081 $Y2=0.0245
.ends

.subckt PM_BUFx16f_ASAP7_75t_R%4 vss 58 62 162 165 168 171 174 177 180 183 186
+ 189 192 195 198 201 204 207 210 213 216 219 222 225 228 231 234 237 240 243
+ 247 251 263 264 267 268 271 272 275 276 51 57 18 19 55 56 1 54 53 49 47 46 20
+ 21 30 48 32 34 36 38 40 42 44 50 52 33 35 37 39 41 43 45 31
c1 1 vss 0.129891f $X=0.6115 $Y=0.135
c2 18 vss 0.01567f $X=0.108 $Y=0.0675
c3 19 vss 0.01567f $X=0.108 $Y=0.2025
c4 20 vss 0.0148463f $X=0.216 $Y=0.0675
c5 21 vss 0.0148463f $X=0.216 $Y=0.2025
c6 30 vss 0.0834936f $X=0.297 $Y=0.135
c7 31 vss 0.0836628f $X=0.351 $Y=0.135
c8 32 vss 0.083657f $X=0.405 $Y=0.135
c9 33 vss 0.083657f $X=0.459 $Y=0.135
c10 34 vss 0.083657f $X=0.513 $Y=0.135
c11 35 vss 0.083657f $X=0.567 $Y=0.135
c12 36 vss 0.083657f $X=0.621 $Y=0.0245
c13 37 vss 0.083657f $X=0.675 $Y=0.135
c14 38 vss 0.083657f $X=0.729 $Y=0.135
c15 39 vss 0.083657f $X=0.783 $Y=0.135
c16 40 vss 0.083657f $X=0.837 $Y=0.135
c17 41 vss 0.083657f $X=0.891 $Y=0.135
c18 42 vss 0.083657f $X=0.945 $Y=0.135
c19 43 vss 0.0835169f $X=0.999 $Y=0.135
c20 44 vss 0.0839678f $X=1.053 $Y=0.135
c21 45 vss 0.0836674f $X=1.107 $Y=0.135
c22 46 vss 0.0138732f $X=0.0935 $Y=0.0675
c23 47 vss 0.013986f $X=0.2015 $Y=0.0675
c24 48 vss 0.0138726f $X=0.0935 $Y=0.2025
c25 49 vss 0.0139582f $X=0.2015 $Y=0.2025
c26 50 vss 0.00622723f $X=0.243 $Y=0.036
c27 51 vss 0.00338524f $X=0.243 $Y=0.135
c28 52 vss 0.00622723f $X=0.243 $Y=0.234
c29 53 vss 0.0164043f $X=0.0965 $Y=0.036
c30 54 vss 0.0164043f $X=0.0965 $Y=0.234
c31 55 vss 0.00617904f $X=0.243 $Y=0.0855
c32 56 vss 0.00617904f $X=0.243 $Y=0.1845
c33 57 vss 0.0206034f $X=0.27 $Y=0.135
r1 276 274 0.0308642 $w=8.1e-08 $l=2.5e-09 $layer=P_src_drn $thickness=1e-09
+ $X=0.2333 $Y=0.2025 $X2=0.2305 $Y2=0.2025
r2 21 274 0.179012 $w=8.1e-08 $l=1.45e-08 $layer=P_src_drn $thickness=1e-09
+ $X=0.216 $Y=0.2025 $X2=0.2305 $Y2=0.2025
r3 49 21 0.179012 $w=8.1e-08 $l=1.45e-08 $layer=P_src_drn $thickness=1e-09
+ $X=0.2015 $Y=0.2025 $X2=0.216 $Y2=0.2025
r4 275 49 0.0308642 $w=8.1e-08 $l=2.5e-09 $layer=P_src_drn $thickness=1e-09
+ $X=0.1986 $Y=0.2025 $X2=0.2015 $Y2=0.2025
r5 272 270 0.0308642 $w=8.1e-08 $l=2.5e-09 $layer=P_src_drn $thickness=1e-09
+ $X=0.1253 $Y=0.2025 $X2=0.1225 $Y2=0.2025
r6 19 270 0.179012 $w=8.1e-08 $l=1.45e-08 $layer=P_src_drn $thickness=1e-09
+ $X=0.108 $Y=0.2025 $X2=0.1225 $Y2=0.2025
r7 48 19 0.179012 $w=8.1e-08 $l=1.45e-08 $layer=P_src_drn $thickness=1e-09
+ $X=0.0935 $Y=0.2025 $X2=0.108 $Y2=0.2025
r8 271 48 0.0308642 $w=8.1e-08 $l=2.5e-09 $layer=P_src_drn $thickness=1e-09
+ $X=0.0906 $Y=0.2025 $X2=0.0935 $Y2=0.2025
r9 268 266 0.0308642 $w=8.1e-08 $l=2.5e-09 $layer=N_src_drn $thickness=1e-09
+ $X=0.2333 $Y=0.0675 $X2=0.2305 $Y2=0.0675
r10 20 266 0.179012 $w=8.1e-08 $l=1.45e-08 $layer=N_src_drn $thickness=1e-09
+ $X=0.216 $Y=0.0675 $X2=0.2305 $Y2=0.0675
r11 47 20 0.179012 $w=8.1e-08 $l=1.45e-08 $layer=N_src_drn $thickness=1e-09
+ $X=0.2015 $Y=0.0675 $X2=0.216 $Y2=0.0675
r12 267 47 0.0308642 $w=8.1e-08 $l=2.5e-09 $layer=N_src_drn $thickness=1e-09
+ $X=0.1986 $Y=0.0675 $X2=0.2015 $Y2=0.0675
r13 264 262 0.0308642 $w=8.1e-08 $l=2.5e-09 $layer=N_src_drn $thickness=1e-09
+ $X=0.1253 $Y=0.0675 $X2=0.1225 $Y2=0.0675
r14 18 262 0.179012 $w=8.1e-08 $l=1.45e-08 $layer=N_src_drn $thickness=1e-09
+ $X=0.108 $Y=0.0675 $X2=0.1225 $Y2=0.0675
r15 46 18 0.179012 $w=8.1e-08 $l=1.45e-08 $layer=N_src_drn $thickness=1e-09
+ $X=0.0935 $Y=0.0675 $X2=0.108 $Y2=0.0675
r16 263 46 0.0308642 $w=8.1e-08 $l=2.5e-09 $layer=N_src_drn $thickness=1e-09
+ $X=0.0906 $Y=0.0675 $X2=0.0935 $Y2=0.0675
r17 21 259 19.3796 $a=3.24e-16 $layer=V0LISD $X=0.216 $Y=0.2025 $X2=0.216
+ $Y2=0.234
r18 19 257 19.3796 $a=3.24e-16 $layer=V0LISD $X=0.108 $Y=0.2025 $X2=0.108
+ $Y2=0.234
r19 20 255 19.3796 $a=3.24e-16 $layer=V0LISD $X=0.216 $Y=0.0675 $X2=0.216
+ $Y2=0.036
r20 18 253 19.3796 $a=3.24e-16 $layer=V0LISD $X=0.108 $Y=0.0675 $X2=0.108
+ $Y2=0.036
r21 259 260 3.14806 $w=1.3e-08 $l=1.35e-08 $layer=M1 $thickness=3.6e-08
+ $X=0.216 $Y=0.234 $X2=0.2295 $Y2=0.234
r22 258 259 12.5922 $w=1.3e-08 $l=5.4e-08 $layer=M1 $thickness=3.6e-08 $X=0.162
+ $Y=0.234 $X2=0.216 $Y2=0.234
r23 257 258 12.5922 $w=1.3e-08 $l=5.4e-08 $layer=M1 $thickness=3.6e-08 $X=0.108
+ $Y=0.234 $X2=0.162 $Y2=0.234
r24 54 257 2.68168 $w=1.3e-08 $l=1.15e-08 $layer=M1 $thickness=3.6e-08
+ $X=0.0965 $Y=0.234 $X2=0.108 $Y2=0.234
r25 255 256 3.14806 $w=1.3e-08 $l=1.35e-08 $layer=M1 $thickness=3.6e-08
+ $X=0.216 $Y=0.036 $X2=0.2295 $Y2=0.036
r26 254 255 12.5922 $w=1.3e-08 $l=5.4e-08 $layer=M1 $thickness=3.6e-08 $X=0.162
+ $Y=0.036 $X2=0.216 $Y2=0.036
r27 253 254 12.5922 $w=1.3e-08 $l=5.4e-08 $layer=M1 $thickness=3.6e-08 $X=0.108
+ $Y=0.036 $X2=0.162 $Y2=0.036
r28 53 253 2.68168 $w=1.3e-08 $l=1.15e-08 $layer=M1 $thickness=3.6e-08
+ $X=0.0965 $Y=0.036 $X2=0.108 $Y2=0.036
r29 52 56 9.89378 $w=1.47818e-08 $l=4.95e-08 $layer=M1 $thickness=3.6e-08
+ $X=0.243 $Y=0.234 $X2=0.243 $Y2=0.1845
r30 52 260 1.49895 $w=1.63333e-08 $l=1.35e-08 $layer=M1 $thickness=3.6e-08
+ $X=0.243 $Y=0.234 $X2=0.2295 $Y2=0.234
r31 50 55 9.89378 $w=1.47818e-08 $l=4.95e-08 $layer=M1 $thickness=3.6e-08
+ $X=0.243 $Y=0.036 $X2=0.243 $Y2=0.0855
r32 50 256 1.49895 $w=1.63333e-08 $l=1.35e-08 $layer=M1 $thickness=3.6e-08
+ $X=0.243 $Y=0.036 $X2=0.2295 $Y2=0.036
r33 51 57 5.11582 $w=1.46667e-08 $l=2.7e-08 $layer=M1 $thickness=3.6e-08
+ $X=0.243 $Y=0.135 $X2=0.27 $Y2=0.135
r34 51 55 10.3626 $w=1.39091e-08 $l=4.95e-08 $layer=M1 $thickness=3.6e-08
+ $X=0.243 $Y=0.135 $X2=0.243 $Y2=0.0855
r35 51 56 10.3626 $w=1.39091e-08 $l=4.95e-08 $layer=M1 $thickness=3.6e-08
+ $X=0.243 $Y=0.135 $X2=0.243 $Y2=0.1845
r36 251 250 14.6259 $w=2.1e-08 $l=4.3e-08 $layer=Gate_1 $thickness=5.6e-08
+ $X=1.107 $Y=0.2025 $X2=1.107 $Y2=0.1595
r37 249 250 2.7211 $w=2.1e-08 $l=8e-09 $layer=Gate_1 $thickness=5.6e-08
+ $X=1.107 $Y=0.1515 $X2=1.107 $Y2=0.1595
r38 247 248 14.6259 $w=2.1e-08 $l=4.3e-08 $layer=Gate_1 $thickness=5.6e-08
+ $X=1.107 $Y=0.0675 $X2=1.107 $Y2=0.1105
r39 245 248 2.7211 $w=2.1e-08 $l=8e-09 $layer=Gate_1 $thickness=5.6e-08
+ $X=1.107 $Y=0.1185 $X2=1.107 $Y2=0.1105
r40 45 125 6.27904 $w=2.09e-08 $layer=Gate_1 $thickness=5.24e-08 $X=1.107
+ $Y=0.135 $X2=1.107 $Y2=0.135
r41 45 245 5.79936 $w=2.03333e-08 $l=1.65e-08 $layer=Gate_1 $thickness=5.6e-08
+ $X=1.107 $Y=0.135 $X2=1.107 $Y2=0.1185
r42 45 249 5.79936 $w=2.03333e-08 $l=1.65e-08 $layer=Gate_1 $thickness=5.6e-08
+ $X=1.107 $Y=0.135 $X2=1.107 $Y2=0.1515
r43 243 242 16.4967 $w=2.1e-08 $l=4.85e-08 $layer=Gate_1 $thickness=5.6e-08
+ $X=1.053 $Y=0.2025 $X2=1.053 $Y2=0.154
r44 240 241 16.4967 $w=2.1e-08 $l=4.85e-08 $layer=Gate_1 $thickness=5.6e-08
+ $X=1.053 $Y=0.0675 $X2=1.053 $Y2=0.116
r45 44 121 6.27904 $w=2.09e-08 $layer=Gate_1 $thickness=5.24e-08 $X=1.053
+ $Y=0.135 $X2=1.053 $Y2=0.135
r46 44 241 6.6497 $w=2.04211e-08 $l=1.9e-08 $layer=Gate_1 $thickness=5.6e-08
+ $X=1.053 $Y=0.135 $X2=1.053 $Y2=0.116
r47 44 242 6.6497 $w=2.04211e-08 $l=1.9e-08 $layer=Gate_1 $thickness=5.6e-08
+ $X=1.053 $Y=0.135 $X2=1.053 $Y2=0.154
r48 237 236 16.4967 $w=2.1e-08 $l=4.85e-08 $layer=Gate_1 $thickness=5.6e-08
+ $X=0.999 $Y=0.2025 $X2=0.999 $Y2=0.154
r49 234 235 16.4967 $w=2.1e-08 $l=4.85e-08 $layer=Gate_1 $thickness=5.6e-08
+ $X=0.999 $Y=0.0675 $X2=0.999 $Y2=0.116
r50 43 117 6.27904 $w=2.09e-08 $layer=Gate_1 $thickness=5.24e-08 $X=0.999
+ $Y=0.135 $X2=0.999 $Y2=0.135
r51 43 235 6.6497 $w=2.04211e-08 $l=1.9e-08 $layer=Gate_1 $thickness=5.6e-08
+ $X=0.999 $Y=0.135 $X2=0.999 $Y2=0.116
r52 43 236 6.6497 $w=2.04211e-08 $l=1.9e-08 $layer=Gate_1 $thickness=5.6e-08
+ $X=0.999 $Y=0.135 $X2=0.999 $Y2=0.154
r53 231 230 16.4967 $w=2.1e-08 $l=4.85e-08 $layer=Gate_1 $thickness=5.6e-08
+ $X=0.945 $Y=0.2025 $X2=0.945 $Y2=0.154
r54 228 229 16.4967 $w=2.1e-08 $l=4.85e-08 $layer=Gate_1 $thickness=5.6e-08
+ $X=0.945 $Y=0.0675 $X2=0.945 $Y2=0.116
r55 42 113 6.27904 $w=2.09e-08 $layer=Gate_1 $thickness=5.24e-08 $X=0.945
+ $Y=0.135 $X2=0.945 $Y2=0.135
r56 42 229 6.6497 $w=2.04211e-08 $l=1.9e-08 $layer=Gate_1 $thickness=5.6e-08
+ $X=0.945 $Y=0.135 $X2=0.945 $Y2=0.116
r57 42 230 6.6497 $w=2.04211e-08 $l=1.9e-08 $layer=Gate_1 $thickness=5.6e-08
+ $X=0.945 $Y=0.135 $X2=0.945 $Y2=0.154
r58 225 224 16.4967 $w=2.1e-08 $l=4.85e-08 $layer=Gate_1 $thickness=5.6e-08
+ $X=0.891 $Y=0.2025 $X2=0.891 $Y2=0.154
r59 222 223 16.4967 $w=2.1e-08 $l=4.85e-08 $layer=Gate_1 $thickness=5.6e-08
+ $X=0.891 $Y=0.0675 $X2=0.891 $Y2=0.116
r60 41 109 6.27904 $w=2.09e-08 $layer=Gate_1 $thickness=5.24e-08 $X=0.891
+ $Y=0.135 $X2=0.891 $Y2=0.135
r61 41 223 6.6497 $w=2.04211e-08 $l=1.9e-08 $layer=Gate_1 $thickness=5.6e-08
+ $X=0.891 $Y=0.135 $X2=0.891 $Y2=0.116
r62 41 224 6.6497 $w=2.04211e-08 $l=1.9e-08 $layer=Gate_1 $thickness=5.6e-08
+ $X=0.891 $Y=0.135 $X2=0.891 $Y2=0.154
r63 219 218 16.4967 $w=2.1e-08 $l=4.85e-08 $layer=Gate_1 $thickness=5.6e-08
+ $X=0.837 $Y=0.2025 $X2=0.837 $Y2=0.154
r64 216 217 16.4967 $w=2.1e-08 $l=4.85e-08 $layer=Gate_1 $thickness=5.6e-08
+ $X=0.837 $Y=0.0675 $X2=0.837 $Y2=0.116
r65 40 105 6.27904 $w=2.09e-08 $layer=Gate_1 $thickness=5.24e-08 $X=0.837
+ $Y=0.135 $X2=0.837 $Y2=0.135
r66 40 217 6.6497 $w=2.04211e-08 $l=1.9e-08 $layer=Gate_1 $thickness=5.6e-08
+ $X=0.837 $Y=0.135 $X2=0.837 $Y2=0.116
r67 40 218 6.6497 $w=2.04211e-08 $l=1.9e-08 $layer=Gate_1 $thickness=5.6e-08
+ $X=0.837 $Y=0.135 $X2=0.837 $Y2=0.154
r68 213 212 16.4967 $w=2.1e-08 $l=4.85e-08 $layer=Gate_1 $thickness=5.6e-08
+ $X=0.783 $Y=0.2025 $X2=0.783 $Y2=0.154
r69 210 211 16.4967 $w=2.1e-08 $l=4.85e-08 $layer=Gate_1 $thickness=5.6e-08
+ $X=0.783 $Y=0.0675 $X2=0.783 $Y2=0.116
r70 39 101 6.27904 $w=2.09e-08 $layer=Gate_1 $thickness=5.24e-08 $X=0.783
+ $Y=0.135 $X2=0.783 $Y2=0.135
r71 39 211 6.6497 $w=2.04211e-08 $l=1.9e-08 $layer=Gate_1 $thickness=5.6e-08
+ $X=0.783 $Y=0.135 $X2=0.783 $Y2=0.116
r72 39 212 6.6497 $w=2.04211e-08 $l=1.9e-08 $layer=Gate_1 $thickness=5.6e-08
+ $X=0.783 $Y=0.135 $X2=0.783 $Y2=0.154
r73 207 206 16.4967 $w=2.1e-08 $l=4.85e-08 $layer=Gate_1 $thickness=5.6e-08
+ $X=0.729 $Y=0.2025 $X2=0.729 $Y2=0.154
r74 204 205 16.4967 $w=2.1e-08 $l=4.85e-08 $layer=Gate_1 $thickness=5.6e-08
+ $X=0.729 $Y=0.0675 $X2=0.729 $Y2=0.116
r75 38 97 6.27904 $w=2.09e-08 $layer=Gate_1 $thickness=5.24e-08 $X=0.729
+ $Y=0.135 $X2=0.729 $Y2=0.135
r76 38 205 6.6497 $w=2.04211e-08 $l=1.9e-08 $layer=Gate_1 $thickness=5.6e-08
+ $X=0.729 $Y=0.135 $X2=0.729 $Y2=0.116
r77 38 206 6.6497 $w=2.04211e-08 $l=1.9e-08 $layer=Gate_1 $thickness=5.6e-08
+ $X=0.729 $Y=0.135 $X2=0.729 $Y2=0.154
r78 201 200 16.4967 $w=2.1e-08 $l=4.85e-08 $layer=Gate_1 $thickness=5.6e-08
+ $X=0.675 $Y=0.2025 $X2=0.675 $Y2=0.154
r79 198 199 16.4967 $w=2.1e-08 $l=4.85e-08 $layer=Gate_1 $thickness=5.6e-08
+ $X=0.675 $Y=0.0675 $X2=0.675 $Y2=0.116
r80 37 93 6.27904 $w=2.09e-08 $layer=Gate_1 $thickness=5.24e-08 $X=0.675
+ $Y=0.135 $X2=0.675 $Y2=0.135
r81 37 199 6.6497 $w=2.04211e-08 $l=1.9e-08 $layer=Gate_1 $thickness=5.6e-08
+ $X=0.675 $Y=0.135 $X2=0.675 $Y2=0.116
r82 37 200 6.6497 $w=2.04211e-08 $l=1.9e-08 $layer=Gate_1 $thickness=5.6e-08
+ $X=0.675 $Y=0.135 $X2=0.675 $Y2=0.154
r83 195 194 16.4967 $w=2.1e-08 $l=4.85e-08 $layer=Gate_1 $thickness=5.6e-08
+ $X=0.297 $Y=0.2025 $X2=0.297 $Y2=0.154
r84 192 193 16.4967 $w=2.1e-08 $l=4.85e-08 $layer=Gate_1 $thickness=5.6e-08
+ $X=0.297 $Y=0.0675 $X2=0.297 $Y2=0.116
r85 30 88 6.27904 $w=2.09e-08 $layer=Gate_1 $thickness=5.24e-08 $X=0.297
+ $Y=0.135 $X2=0.297 $Y2=0.135
r86 30 193 6.6497 $w=2.04211e-08 $l=1.9e-08 $layer=Gate_1 $thickness=5.6e-08
+ $X=0.297 $Y=0.135 $X2=0.297 $Y2=0.116
r87 30 194 6.6497 $w=2.04211e-08 $l=1.9e-08 $layer=Gate_1 $thickness=5.6e-08
+ $X=0.297 $Y=0.135 $X2=0.297 $Y2=0.154
r88 189 188 16.4967 $w=2.1e-08 $l=4.85e-08 $layer=Gate_1 $thickness=5.6e-08
+ $X=0.351 $Y=0.2025 $X2=0.351 $Y2=0.154
r89 186 187 16.4967 $w=2.1e-08 $l=4.85e-08 $layer=Gate_1 $thickness=5.6e-08
+ $X=0.351 $Y=0.0675 $X2=0.351 $Y2=0.116
r90 31 84 6.27904 $w=2.09e-08 $layer=Gate_1 $thickness=5.24e-08 $X=0.351
+ $Y=0.135 $X2=0.351 $Y2=0.135
r91 31 187 6.6497 $w=2.04211e-08 $l=1.9e-08 $layer=Gate_1 $thickness=5.6e-08
+ $X=0.351 $Y=0.135 $X2=0.351 $Y2=0.116
r92 31 188 6.6497 $w=2.04211e-08 $l=1.9e-08 $layer=Gate_1 $thickness=5.6e-08
+ $X=0.351 $Y=0.135 $X2=0.351 $Y2=0.154
r93 183 182 16.4967 $w=2.1e-08 $l=4.85e-08 $layer=Gate_1 $thickness=5.6e-08
+ $X=0.405 $Y=0.2025 $X2=0.405 $Y2=0.154
r94 180 181 16.4967 $w=2.1e-08 $l=4.85e-08 $layer=Gate_1 $thickness=5.6e-08
+ $X=0.405 $Y=0.0675 $X2=0.405 $Y2=0.116
r95 32 80 6.27904 $w=2.09e-08 $layer=Gate_1 $thickness=5.24e-08 $X=0.405
+ $Y=0.135 $X2=0.405 $Y2=0.135
r96 32 181 6.6497 $w=2.04211e-08 $l=1.9e-08 $layer=Gate_1 $thickness=5.6e-08
+ $X=0.405 $Y=0.135 $X2=0.405 $Y2=0.116
r97 32 182 6.6497 $w=2.04211e-08 $l=1.9e-08 $layer=Gate_1 $thickness=5.6e-08
+ $X=0.405 $Y=0.135 $X2=0.405 $Y2=0.154
r98 177 176 16.4967 $w=2.1e-08 $l=4.85e-08 $layer=Gate_1 $thickness=5.6e-08
+ $X=0.459 $Y=0.2025 $X2=0.459 $Y2=0.154
r99 174 175 16.4967 $w=2.1e-08 $l=4.85e-08 $layer=Gate_1 $thickness=5.6e-08
+ $X=0.459 $Y=0.0675 $X2=0.459 $Y2=0.116
r100 33 76 6.27904 $w=2.09e-08 $layer=Gate_1 $thickness=5.24e-08 $X=0.459
+ $Y=0.135 $X2=0.459 $Y2=0.135
r101 33 175 6.6497 $w=2.04211e-08 $l=1.9e-08 $layer=Gate_1 $thickness=5.6e-08
+ $X=0.459 $Y=0.135 $X2=0.459 $Y2=0.116
r102 33 176 6.6497 $w=2.04211e-08 $l=1.9e-08 $layer=Gate_1 $thickness=5.6e-08
+ $X=0.459 $Y=0.135 $X2=0.459 $Y2=0.154
r103 171 170 16.4967 $w=2.1e-08 $l=4.85e-08 $layer=Gate_1 $thickness=5.6e-08
+ $X=0.513 $Y=0.2025 $X2=0.513 $Y2=0.154
r104 168 169 16.4967 $w=2.1e-08 $l=4.85e-08 $layer=Gate_1 $thickness=5.6e-08
+ $X=0.513 $Y=0.0675 $X2=0.513 $Y2=0.116
r105 34 72 6.27904 $w=2.09e-08 $layer=Gate_1 $thickness=5.24e-08 $X=0.513
+ $Y=0.135 $X2=0.513 $Y2=0.135
r106 34 169 6.6497 $w=2.04211e-08 $l=1.9e-08 $layer=Gate_1 $thickness=5.6e-08
+ $X=0.513 $Y=0.135 $X2=0.513 $Y2=0.116
r107 34 170 6.6497 $w=2.04211e-08 $l=1.9e-08 $layer=Gate_1 $thickness=5.6e-08
+ $X=0.513 $Y=0.135 $X2=0.513 $Y2=0.154
r108 165 164 16.4967 $w=2.1e-08 $l=4.85e-08 $layer=Gate_1 $thickness=5.6e-08
+ $X=0.567 $Y=0.2025 $X2=0.567 $Y2=0.154
r109 162 163 16.4967 $w=2.1e-08 $l=4.85e-08 $layer=Gate_1 $thickness=5.6e-08
+ $X=0.567 $Y=0.0675 $X2=0.567 $Y2=0.116
r110 35 68 6.27904 $w=2.09e-08 $layer=Gate_1 $thickness=5.24e-08 $X=0.567
+ $Y=0.135 $X2=0.567 $Y2=0.135
r111 35 163 6.6497 $w=2.04211e-08 $l=1.9e-08 $layer=Gate_1 $thickness=5.6e-08
+ $X=0.567 $Y=0.135 $X2=0.567 $Y2=0.116
r112 35 164 6.6497 $w=2.04211e-08 $l=1.9e-08 $layer=Gate_1 $thickness=5.6e-08
+ $X=0.567 $Y=0.135 $X2=0.567 $Y2=0.154
r113 158 159 6.29612 $w=1.3e-08 $l=2.7e-08 $layer=M1 $thickness=3.6e-08 $X=1.08
+ $Y=0.135 $X2=1.107 $Y2=0.135
r114 157 158 6.29612 $w=1.3e-08 $l=2.7e-08 $layer=M1 $thickness=3.6e-08
+ $X=1.053 $Y=0.135 $X2=1.08 $Y2=0.135
r115 156 157 6.29612 $w=1.3e-08 $l=2.7e-08 $layer=M1 $thickness=3.6e-08
+ $X=1.026 $Y=0.135 $X2=1.053 $Y2=0.135
r116 155 156 6.29612 $w=1.3e-08 $l=2.7e-08 $layer=M1 $thickness=3.6e-08
+ $X=0.999 $Y=0.135 $X2=1.026 $Y2=0.135
r117 154 155 6.29612 $w=1.3e-08 $l=2.7e-08 $layer=M1 $thickness=3.6e-08
+ $X=0.972 $Y=0.135 $X2=0.999 $Y2=0.135
r118 153 154 6.29612 $w=1.3e-08 $l=2.7e-08 $layer=M1 $thickness=3.6e-08
+ $X=0.945 $Y=0.135 $X2=0.972 $Y2=0.135
r119 152 153 6.29612 $w=1.3e-08 $l=2.7e-08 $layer=M1 $thickness=3.6e-08
+ $X=0.918 $Y=0.135 $X2=0.945 $Y2=0.135
r120 151 152 6.29612 $w=1.3e-08 $l=2.7e-08 $layer=M1 $thickness=3.6e-08
+ $X=0.891 $Y=0.135 $X2=0.918 $Y2=0.135
r121 150 151 6.29612 $w=1.3e-08 $l=2.7e-08 $layer=M1 $thickness=3.6e-08
+ $X=0.864 $Y=0.135 $X2=0.891 $Y2=0.135
r122 149 150 6.29612 $w=1.3e-08 $l=2.7e-08 $layer=M1 $thickness=3.6e-08
+ $X=0.837 $Y=0.135 $X2=0.864 $Y2=0.135
r123 148 149 6.29612 $w=1.3e-08 $l=2.7e-08 $layer=M1 $thickness=3.6e-08 $X=0.81
+ $Y=0.135 $X2=0.837 $Y2=0.135
r124 147 148 6.29612 $w=1.3e-08 $l=2.7e-08 $layer=M1 $thickness=3.6e-08
+ $X=0.783 $Y=0.135 $X2=0.81 $Y2=0.135
r125 146 147 6.29612 $w=1.3e-08 $l=2.7e-08 $layer=M1 $thickness=3.6e-08
+ $X=0.756 $Y=0.135 $X2=0.783 $Y2=0.135
r126 145 146 6.29612 $w=1.3e-08 $l=2.7e-08 $layer=M1 $thickness=3.6e-08
+ $X=0.729 $Y=0.135 $X2=0.756 $Y2=0.135
r127 144 145 6.29612 $w=1.3e-08 $l=2.7e-08 $layer=M1 $thickness=3.6e-08
+ $X=0.702 $Y=0.135 $X2=0.729 $Y2=0.135
r128 143 144 6.29612 $w=1.3e-08 $l=2.7e-08 $layer=M1 $thickness=3.6e-08
+ $X=0.675 $Y=0.135 $X2=0.702 $Y2=0.135
r129 142 143 6.29612 $w=1.3e-08 $l=2.7e-08 $layer=M1 $thickness=3.6e-08
+ $X=0.648 $Y=0.135 $X2=0.675 $Y2=0.135
r130 141 142 6.29612 $w=1.3e-08 $l=2.7e-08 $layer=M1 $thickness=3.6e-08
+ $X=0.621 $Y=0.135 $X2=0.648 $Y2=0.135
r131 140 141 6.29612 $w=1.3e-08 $l=2.7e-08 $layer=M1 $thickness=3.6e-08
+ $X=0.594 $Y=0.135 $X2=0.621 $Y2=0.135
r132 139 140 6.29612 $w=1.3e-08 $l=2.7e-08 $layer=M1 $thickness=3.6e-08
+ $X=0.567 $Y=0.135 $X2=0.594 $Y2=0.135
r133 138 139 6.29612 $w=1.3e-08 $l=2.7e-08 $layer=M1 $thickness=3.6e-08 $X=0.54
+ $Y=0.135 $X2=0.567 $Y2=0.135
r134 137 138 6.29612 $w=1.3e-08 $l=2.7e-08 $layer=M1 $thickness=3.6e-08
+ $X=0.513 $Y=0.135 $X2=0.54 $Y2=0.135
r135 136 137 6.29612 $w=1.3e-08 $l=2.7e-08 $layer=M1 $thickness=3.6e-08
+ $X=0.486 $Y=0.135 $X2=0.513 $Y2=0.135
r136 135 136 6.29612 $w=1.3e-08 $l=2.7e-08 $layer=M1 $thickness=3.6e-08
+ $X=0.459 $Y=0.135 $X2=0.486 $Y2=0.135
r137 134 135 6.29612 $w=1.3e-08 $l=2.7e-08 $layer=M1 $thickness=3.6e-08
+ $X=0.432 $Y=0.135 $X2=0.459 $Y2=0.135
r138 133 134 6.29612 $w=1.3e-08 $l=2.7e-08 $layer=M1 $thickness=3.6e-08
+ $X=0.405 $Y=0.135 $X2=0.432 $Y2=0.135
r139 132 133 6.29612 $w=1.3e-08 $l=2.7e-08 $layer=M1 $thickness=3.6e-08
+ $X=0.378 $Y=0.135 $X2=0.405 $Y2=0.135
r140 131 132 6.29612 $w=1.3e-08 $l=2.7e-08 $layer=M1 $thickness=3.6e-08
+ $X=0.351 $Y=0.135 $X2=0.378 $Y2=0.135
r141 130 131 5.82974 $w=1.3e-08 $l=2.5e-08 $layer=M1 $thickness=3.6e-08
+ $X=0.326 $Y=0.135 $X2=0.351 $Y2=0.135
r142 129 130 4.19742 $w=1.3e-08 $l=1.8e-08 $layer=M1 $thickness=3.6e-08
+ $X=0.308 $Y=0.135 $X2=0.326 $Y2=0.135
r143 128 129 2.56509 $w=1.3e-08 $l=1.1e-08 $layer=M1 $thickness=3.6e-08
+ $X=0.297 $Y=0.135 $X2=0.308 $Y2=0.135
r144 57 128 6.29612 $w=1.3e-08 $l=2.7e-08 $layer=M1 $thickness=3.6e-08 $X=0.27
+ $Y=0.135 $X2=0.297 $Y2=0.135
r145 125 159 19.3796 $a=3.24e-16 $layer=V0LIG $X=1.107 $Y=0.135 $X2=1.107
+ $Y2=0.135
r146 124 125 2.48102 $w=2.2e-08 $l=9.5e-09 $layer=LIG $thickness=4.8e-08
+ $X=1.0975 $Y=0.135 $X2=1.107 $Y2=0.135
r147 123 124 10.1729 $w=1.54914e-08 $l=1.75e-08 $layer=LIG $thickness=4.8e-08
+ $X=1.08 $Y=0.135 $X2=1.0975 $Y2=0.135
r148 122 123 10.1729 $w=1.54914e-08 $l=1.75e-08 $layer=LIG $thickness=4.8e-08
+ $X=1.0625 $Y=0.135 $X2=1.08 $Y2=0.135
r149 121 122 2.48102 $w=2.2e-08 $l=9.5e-09 $layer=LIG $thickness=4.8e-08
+ $X=1.053 $Y=0.135 $X2=1.0625 $Y2=0.135
r150 121 157 19.3796 $a=3.24e-16 $layer=V0LIG $X=1.053 $Y=0.135 $X2=1.053
+ $Y2=0.135
r151 120 121 2.48102 $w=2.2e-08 $l=9.5e-09 $layer=LIG $thickness=4.8e-08
+ $X=1.0435 $Y=0.135 $X2=1.053 $Y2=0.135
r152 119 120 10.1729 $w=1.54914e-08 $l=1.75e-08 $layer=LIG $thickness=4.8e-08
+ $X=1.026 $Y=0.135 $X2=1.0435 $Y2=0.135
r153 118 119 10.1729 $w=1.54914e-08 $l=1.75e-08 $layer=LIG $thickness=4.8e-08
+ $X=1.0085 $Y=0.135 $X2=1.026 $Y2=0.135
r154 117 118 2.48102 $w=2.2e-08 $l=9.5e-09 $layer=LIG $thickness=4.8e-08
+ $X=0.999 $Y=0.135 $X2=1.0085 $Y2=0.135
r155 117 155 19.3796 $a=3.24e-16 $layer=V0LIG $X=0.999 $Y=0.135 $X2=0.999
+ $Y2=0.135
r156 116 117 2.48102 $w=2.2e-08 $l=9.5e-09 $layer=LIG $thickness=4.8e-08
+ $X=0.9895 $Y=0.135 $X2=0.999 $Y2=0.135
r157 115 116 10.1729 $w=1.54914e-08 $l=1.75e-08 $layer=LIG $thickness=4.8e-08
+ $X=0.972 $Y=0.135 $X2=0.9895 $Y2=0.135
r158 114 115 10.1729 $w=1.54914e-08 $l=1.75e-08 $layer=LIG $thickness=4.8e-08
+ $X=0.9545 $Y=0.135 $X2=0.972 $Y2=0.135
r159 113 114 2.48102 $w=2.2e-08 $l=9.5e-09 $layer=LIG $thickness=4.8e-08
+ $X=0.945 $Y=0.135 $X2=0.9545 $Y2=0.135
r160 113 153 19.3796 $a=3.24e-16 $layer=V0LIG $X=0.945 $Y=0.135 $X2=0.945
+ $Y2=0.135
r161 112 113 2.48102 $w=2.2e-08 $l=9.5e-09 $layer=LIG $thickness=4.8e-08
+ $X=0.9355 $Y=0.135 $X2=0.945 $Y2=0.135
r162 111 112 10.1729 $w=1.54914e-08 $l=1.75e-08 $layer=LIG $thickness=4.8e-08
+ $X=0.918 $Y=0.135 $X2=0.9355 $Y2=0.135
r163 110 111 10.1729 $w=1.54914e-08 $l=1.75e-08 $layer=LIG $thickness=4.8e-08
+ $X=0.9005 $Y=0.135 $X2=0.918 $Y2=0.135
r164 109 110 2.48102 $w=2.2e-08 $l=9.5e-09 $layer=LIG $thickness=4.8e-08
+ $X=0.891 $Y=0.135 $X2=0.9005 $Y2=0.135
r165 109 151 19.3796 $a=3.24e-16 $layer=V0LIG $X=0.891 $Y=0.135 $X2=0.891
+ $Y2=0.135
r166 108 109 2.48102 $w=2.2e-08 $l=9.5e-09 $layer=LIG $thickness=4.8e-08
+ $X=0.8815 $Y=0.135 $X2=0.891 $Y2=0.135
r167 107 108 10.1729 $w=1.54914e-08 $l=1.75e-08 $layer=LIG $thickness=4.8e-08
+ $X=0.864 $Y=0.135 $X2=0.8815 $Y2=0.135
r168 106 107 10.1729 $w=1.54914e-08 $l=1.75e-08 $layer=LIG $thickness=4.8e-08
+ $X=0.8465 $Y=0.135 $X2=0.864 $Y2=0.135
r169 105 106 2.48102 $w=2.2e-08 $l=9.5e-09 $layer=LIG $thickness=4.8e-08
+ $X=0.837 $Y=0.135 $X2=0.8465 $Y2=0.135
r170 105 149 19.3796 $a=3.24e-16 $layer=V0LIG $X=0.837 $Y=0.135 $X2=0.837
+ $Y2=0.135
r171 104 105 2.48102 $w=2.2e-08 $l=9.5e-09 $layer=LIG $thickness=4.8e-08
+ $X=0.8275 $Y=0.135 $X2=0.837 $Y2=0.135
r172 103 104 10.1729 $w=1.54914e-08 $l=1.75e-08 $layer=LIG $thickness=4.8e-08
+ $X=0.81 $Y=0.135 $X2=0.8275 $Y2=0.135
r173 102 103 10.1729 $w=1.54914e-08 $l=1.75e-08 $layer=LIG $thickness=4.8e-08
+ $X=0.7925 $Y=0.135 $X2=0.81 $Y2=0.135
r174 101 102 2.48102 $w=2.2e-08 $l=9.5e-09 $layer=LIG $thickness=4.8e-08
+ $X=0.783 $Y=0.135 $X2=0.7925 $Y2=0.135
r175 101 147 19.3796 $a=3.24e-16 $layer=V0LIG $X=0.783 $Y=0.135 $X2=0.783
+ $Y2=0.135
r176 100 101 2.48102 $w=2.2e-08 $l=9.5e-09 $layer=LIG $thickness=4.8e-08
+ $X=0.7735 $Y=0.135 $X2=0.783 $Y2=0.135
r177 99 100 10.1729 $w=1.54914e-08 $l=1.75e-08 $layer=LIG $thickness=4.8e-08
+ $X=0.756 $Y=0.135 $X2=0.7735 $Y2=0.135
r178 98 99 10.1729 $w=1.54914e-08 $l=1.75e-08 $layer=LIG $thickness=4.8e-08
+ $X=0.7385 $Y=0.135 $X2=0.756 $Y2=0.135
r179 97 98 2.48102 $w=2.2e-08 $l=9.5e-09 $layer=LIG $thickness=4.8e-08 $X=0.729
+ $Y=0.135 $X2=0.7385 $Y2=0.135
r180 97 145 19.3796 $a=3.24e-16 $layer=V0LIG $X=0.729 $Y=0.135 $X2=0.729
+ $Y2=0.135
r181 96 97 2.48102 $w=2.2e-08 $l=9.5e-09 $layer=LIG $thickness=4.8e-08
+ $X=0.7195 $Y=0.135 $X2=0.729 $Y2=0.135
r182 95 96 10.1729 $w=1.54914e-08 $l=1.75e-08 $layer=LIG $thickness=4.8e-08
+ $X=0.702 $Y=0.135 $X2=0.7195 $Y2=0.135
r183 94 95 10.1729 $w=1.54914e-08 $l=1.75e-08 $layer=LIG $thickness=4.8e-08
+ $X=0.6845 $Y=0.135 $X2=0.702 $Y2=0.135
r184 93 94 2.48102 $w=2.2e-08 $l=9.5e-09 $layer=LIG $thickness=4.8e-08 $X=0.675
+ $Y=0.135 $X2=0.6845 $Y2=0.135
r185 93 143 19.3796 $a=3.24e-16 $layer=V0LIG $X=0.675 $Y=0.135 $X2=0.675
+ $Y2=0.135
r186 92 93 2.48102 $w=2.2e-08 $l=9.5e-09 $layer=LIG $thickness=4.8e-08
+ $X=0.6655 $Y=0.135 $X2=0.675 $Y2=0.135
r187 91 92 10.1729 $w=1.54914e-08 $l=1.75e-08 $layer=LIG $thickness=4.8e-08
+ $X=0.648 $Y=0.135 $X2=0.6655 $Y2=0.135
r188 88 89 2.48102 $w=2.2e-08 $l=9.5e-09 $layer=LIG $thickness=4.8e-08 $X=0.297
+ $Y=0.135 $X2=0.3065 $Y2=0.135
r189 88 128 19.3796 $a=3.24e-16 $layer=V0LIG $X=0.297 $Y=0.135 $X2=0.297
+ $Y2=0.135
r190 86 89 10.1729 $w=1.54914e-08 $l=1.75e-08 $layer=LIG $thickness=4.8e-08
+ $X=0.324 $Y=0.135 $X2=0.3065 $Y2=0.135
r191 84 85 2.48102 $w=2.2e-08 $l=9.5e-09 $layer=LIG $thickness=4.8e-08 $X=0.351
+ $Y=0.135 $X2=0.3605 $Y2=0.135
r192 84 131 19.3796 $a=3.24e-16 $layer=V0LIG $X=0.351 $Y=0.135 $X2=0.351
+ $Y2=0.135
r193 83 84 2.48102 $w=2.2e-08 $l=9.5e-09 $layer=LIG $thickness=4.8e-08
+ $X=0.3415 $Y=0.135 $X2=0.351 $Y2=0.135
r194 83 86 10.1729 $w=1.54914e-08 $l=1.75e-08 $layer=LIG $thickness=4.8e-08
+ $X=0.3415 $Y=0.135 $X2=0.324 $Y2=0.135
r195 82 85 10.1729 $w=1.54914e-08 $l=1.75e-08 $layer=LIG $thickness=4.8e-08
+ $X=0.378 $Y=0.135 $X2=0.3605 $Y2=0.135
r196 80 81 2.48102 $w=2.2e-08 $l=9.5e-09 $layer=LIG $thickness=4.8e-08 $X=0.405
+ $Y=0.135 $X2=0.4145 $Y2=0.135
r197 80 133 19.3796 $a=3.24e-16 $layer=V0LIG $X=0.405 $Y=0.135 $X2=0.405
+ $Y2=0.135
r198 79 80 2.48102 $w=2.2e-08 $l=9.5e-09 $layer=LIG $thickness=4.8e-08
+ $X=0.3955 $Y=0.135 $X2=0.405 $Y2=0.135
r199 79 82 10.1729 $w=1.54914e-08 $l=1.75e-08 $layer=LIG $thickness=4.8e-08
+ $X=0.3955 $Y=0.135 $X2=0.378 $Y2=0.135
r200 78 81 10.1729 $w=1.54914e-08 $l=1.75e-08 $layer=LIG $thickness=4.8e-08
+ $X=0.432 $Y=0.135 $X2=0.4145 $Y2=0.135
r201 76 77 2.48102 $w=2.2e-08 $l=9.5e-09 $layer=LIG $thickness=4.8e-08 $X=0.459
+ $Y=0.135 $X2=0.4685 $Y2=0.135
r202 76 135 19.3796 $a=3.24e-16 $layer=V0LIG $X=0.459 $Y=0.135 $X2=0.459
+ $Y2=0.135
r203 75 76 2.48102 $w=2.2e-08 $l=9.5e-09 $layer=LIG $thickness=4.8e-08
+ $X=0.4495 $Y=0.135 $X2=0.459 $Y2=0.135
r204 75 78 10.1729 $w=1.54914e-08 $l=1.75e-08 $layer=LIG $thickness=4.8e-08
+ $X=0.4495 $Y=0.135 $X2=0.432 $Y2=0.135
r205 74 77 10.1729 $w=1.54914e-08 $l=1.75e-08 $layer=LIG $thickness=4.8e-08
+ $X=0.486 $Y=0.135 $X2=0.4685 $Y2=0.135
r206 72 73 2.48102 $w=2.2e-08 $l=9.5e-09 $layer=LIG $thickness=4.8e-08 $X=0.513
+ $Y=0.135 $X2=0.5225 $Y2=0.135
r207 72 137 19.3796 $a=3.24e-16 $layer=V0LIG $X=0.513 $Y=0.135 $X2=0.513
+ $Y2=0.135
r208 71 72 2.48102 $w=2.2e-08 $l=9.5e-09 $layer=LIG $thickness=4.8e-08
+ $X=0.5035 $Y=0.135 $X2=0.513 $Y2=0.135
r209 71 74 10.1729 $w=1.54914e-08 $l=1.75e-08 $layer=LIG $thickness=4.8e-08
+ $X=0.5035 $Y=0.135 $X2=0.486 $Y2=0.135
r210 70 73 10.1729 $w=1.54914e-08 $l=1.75e-08 $layer=LIG $thickness=4.8e-08
+ $X=0.54 $Y=0.135 $X2=0.5225 $Y2=0.135
r211 68 69 2.48102 $w=2.2e-08 $l=9.5e-09 $layer=LIG $thickness=4.8e-08 $X=0.567
+ $Y=0.135 $X2=0.5765 $Y2=0.135
r212 68 139 19.3796 $a=3.24e-16 $layer=V0LIG $X=0.567 $Y=0.135 $X2=0.567
+ $Y2=0.135
r213 67 68 2.48102 $w=2.2e-08 $l=9.5e-09 $layer=LIG $thickness=4.8e-08
+ $X=0.5575 $Y=0.135 $X2=0.567 $Y2=0.135
r214 67 70 10.1729 $w=1.54914e-08 $l=1.75e-08 $layer=LIG $thickness=4.8e-08
+ $X=0.5575 $Y=0.135 $X2=0.54 $Y2=0.135
r215 66 69 10.1729 $w=1.54914e-08 $l=1.75e-08 $layer=LIG $thickness=4.8e-08
+ $X=0.594 $Y=0.135 $X2=0.5765 $Y2=0.135
r216 65 91 10.1729 $w=1.54914e-08 $l=1.75e-08 $layer=LIG $thickness=4.8e-08
+ $X=0.6305 $Y=0.135 $X2=0.648 $Y2=0.135
r217 64 65 2.48102 $w=2.2e-08 $l=9.5e-09 $layer=LIG $thickness=4.8e-08 $X=0.621
+ $Y=0.135 $X2=0.6305 $Y2=0.135
r218 64 141 19.3796 $a=3.24e-16 $layer=V0LIG $X=0.621 $Y=0.135 $X2=0.621
+ $Y2=0.135
r219 1 64 2.48102 $w=2.2e-08 $l=9.5e-09 $layer=LIG $thickness=4.8e-08 $X=0.6115
+ $Y=0.135 $X2=0.621 $Y2=0.135
r220 1 66 10.1729 $w=1.54914e-08 $l=1.75e-08 $layer=LIG $thickness=4.8e-08
+ $X=0.6115 $Y=0.135 $X2=0.594 $Y2=0.135
r221 62 61 16.4967 $w=2.1e-08 $l=4.85e-08 $layer=Gate_1 $thickness=5.6e-08
+ $X=0.621 $Y=0.2025 $X2=0.621 $Y2=0.154
r222 60 61 6.6497 $w=2.04211e-08 $l=1.9e-08 $layer=Gate_1 $thickness=5.6e-08
+ $X=0.621 $Y=0.135 $X2=0.621 $Y2=0.154
r223 60 65 4.05918 $w=2.0087e-08 $l=9.5e-09 $layer=Gate_1
+ $thickness=5.56522e-08 $X=0.621 $Y=0.135 $X2=0.6305 $Y2=0.135
r224 60 64 6.27904 $w=2.09e-08 $layer=Gate_1 $thickness=5.24e-08 $X=0.621
+ $Y=0.135 $X2=0.621 $Y2=0.135
r225 59 60 6.6497 $w=2.04211e-08 $l=1.9e-08 $layer=Gate_1 $thickness=5.6e-08
+ $X=0.621 $Y=0.116 $X2=0.621 $Y2=0.135
r226 58 59 16.4967 $w=2.1e-08 $l=4.85e-08 $layer=Gate_1 $thickness=5.6e-08
+ $X=0.621 $Y=0.0675 $X2=0.621 $Y2=0.116
r227 58 36 14.6259 $w=2.1e-08 $l=4.3e-08 $layer=Gate_1 $thickness=5.6e-08
+ $X=0.621 $Y=0.0675 $X2=0.621 $Y2=0.0245
.ends

.subckt PM_BUFx16f_ASAP7_75t_R%Y vss 121 72 73 93 94 97 98 101 102 105 106 109
+ 110 113 114 117 118 142 143 146 147 150 151 154 155 158 159 162 163 166 167
+ 170 171 57 67 68 1 3 5 7 9 11 13 15 16 49 50 51 52 53 54 55 58 59 60 61 62 63
+ 56 64 69 4 6 8 10 12 14 2
c1 1 vss 0.00819893f $X=0.324 $Y=0.0675
c2 2 vss 0.00819893f $X=0.324 $Y=0.2025
c3 3 vss 0.00814219f $X=0.432 $Y=0.0675
c4 4 vss 0.00814219f $X=0.432 $Y=0.2025
c5 5 vss 0.00814219f $X=0.54 $Y=0.0675
c6 6 vss 0.00814219f $X=0.54 $Y=0.2025
c7 7 vss 0.00814219f $X=0.648 $Y=0.0675
c8 8 vss 0.00814219f $X=0.648 $Y=0.2025
c9 9 vss 0.00814219f $X=0.756 $Y=0.0675
c10 10 vss 0.00814219f $X=0.756 $Y=0.2025
c11 11 vss 0.00814219f $X=0.864 $Y=0.0675
c12 12 vss 0.00814219f $X=0.864 $Y=0.2025
c13 13 vss 0.00814219f $X=0.972 $Y=0.0675
c14 14 vss 0.00814219f $X=0.972 $Y=0.2025
c15 15 vss 0.00822589f $X=1.08 $Y=0.0675
c16 16 vss 0.00822589f $X=1.08 $Y=0.2025
c17 49 vss 0.00428847f $X=0.3095 $Y=0.0675
c18 50 vss 0.00406499f $X=0.4175 $Y=0.0675
c19 51 vss 0.00406499f $X=0.5255 $Y=0.0675
c20 52 vss 0.00406499f $X=0.6335 $Y=0.0675
c21 53 vss 0.00406499f $X=0.7415 $Y=0.0675
c22 54 vss 0.00406499f $X=0.8495 $Y=0.0675
c23 55 vss 0.00406499f $X=0.9575 $Y=0.0675
c24 56 vss 0.00419428f $X=1.0655 $Y=0.0675
c25 57 vss 0.00430386f $X=0.3095 $Y=0.2025
c26 58 vss 0.00406446f $X=0.4175 $Y=0.2025
c27 59 vss 0.00406446f $X=0.5255 $Y=0.2025
c28 60 vss 0.00406446f $X=0.6335 $Y=0.2025
c29 61 vss 0.00406446f $X=0.7415 $Y=0.2025
c30 62 vss 0.00406446f $X=0.8495 $Y=0.2025
c31 63 vss 0.00406446f $X=0.9575 $Y=0.2025
c32 64 vss 0.00420589f $X=1.0655 $Y=0.2025
c33 65 vss 0.00283249f $X=1.161 $Y=0.036
c34 66 vss 0.00283249f $X=1.161 $Y=0.234
c35 67 vss 0.0720671f $X=0.3125 $Y=0.036
c36 68 vss 0.0720671f $X=1.138 $Y=0.234
c37 69 vss 0.00780494f $X=1.161 $Y=0.0855
r1 171 169 0.0308642 $w=8.1e-08 $l=2.5e-09 $layer=P_src_drn $thickness=1e-09
+ $X=1.0973 $Y=0.2025 $X2=1.0945 $Y2=0.2025
r2 16 169 0.179012 $w=8.1e-08 $l=1.45e-08 $layer=P_src_drn $thickness=1e-09
+ $X=1.08 $Y=0.2025 $X2=1.0945 $Y2=0.2025
r3 64 16 0.179012 $w=8.1e-08 $l=1.45e-08 $layer=P_src_drn $thickness=1e-09
+ $X=1.0655 $Y=0.2025 $X2=1.08 $Y2=0.2025
r4 170 64 0.0308642 $w=8.1e-08 $l=2.5e-09 $layer=P_src_drn $thickness=1e-09
+ $X=1.0626 $Y=0.2025 $X2=1.0655 $Y2=0.2025
r5 167 165 0.0308642 $w=8.1e-08 $l=2.5e-09 $layer=P_src_drn $thickness=1e-09
+ $X=0.9893 $Y=0.2025 $X2=0.9865 $Y2=0.2025
r6 14 165 0.179012 $w=8.1e-08 $l=1.45e-08 $layer=P_src_drn $thickness=1e-09
+ $X=0.972 $Y=0.2025 $X2=0.9865 $Y2=0.2025
r7 63 14 0.179012 $w=8.1e-08 $l=1.45e-08 $layer=P_src_drn $thickness=1e-09
+ $X=0.9575 $Y=0.2025 $X2=0.972 $Y2=0.2025
r8 166 63 0.0308642 $w=8.1e-08 $l=2.5e-09 $layer=P_src_drn $thickness=1e-09
+ $X=0.9546 $Y=0.2025 $X2=0.9575 $Y2=0.2025
r9 163 161 0.0308642 $w=8.1e-08 $l=2.5e-09 $layer=P_src_drn $thickness=1e-09
+ $X=0.8813 $Y=0.2025 $X2=0.8785 $Y2=0.2025
r10 12 161 0.179012 $w=8.1e-08 $l=1.45e-08 $layer=P_src_drn $thickness=1e-09
+ $X=0.864 $Y=0.2025 $X2=0.8785 $Y2=0.2025
r11 62 12 0.179012 $w=8.1e-08 $l=1.45e-08 $layer=P_src_drn $thickness=1e-09
+ $X=0.8495 $Y=0.2025 $X2=0.864 $Y2=0.2025
r12 162 62 0.0308642 $w=8.1e-08 $l=2.5e-09 $layer=P_src_drn $thickness=1e-09
+ $X=0.8466 $Y=0.2025 $X2=0.8495 $Y2=0.2025
r13 159 157 0.0308642 $w=8.1e-08 $l=2.5e-09 $layer=P_src_drn $thickness=1e-09
+ $X=0.7733 $Y=0.2025 $X2=0.7705 $Y2=0.2025
r14 10 157 0.179012 $w=8.1e-08 $l=1.45e-08 $layer=P_src_drn $thickness=1e-09
+ $X=0.756 $Y=0.2025 $X2=0.7705 $Y2=0.2025
r15 61 10 0.179012 $w=8.1e-08 $l=1.45e-08 $layer=P_src_drn $thickness=1e-09
+ $X=0.7415 $Y=0.2025 $X2=0.756 $Y2=0.2025
r16 158 61 0.0308642 $w=8.1e-08 $l=2.5e-09 $layer=P_src_drn $thickness=1e-09
+ $X=0.7386 $Y=0.2025 $X2=0.7415 $Y2=0.2025
r17 155 153 0.0308642 $w=8.1e-08 $l=2.5e-09 $layer=P_src_drn $thickness=1e-09
+ $X=0.6653 $Y=0.2025 $X2=0.6625 $Y2=0.2025
r18 8 153 0.179012 $w=8.1e-08 $l=1.45e-08 $layer=P_src_drn $thickness=1e-09
+ $X=0.648 $Y=0.2025 $X2=0.6625 $Y2=0.2025
r19 60 8 0.179012 $w=8.1e-08 $l=1.45e-08 $layer=P_src_drn $thickness=1e-09
+ $X=0.6335 $Y=0.2025 $X2=0.648 $Y2=0.2025
r20 154 60 0.0308642 $w=8.1e-08 $l=2.5e-09 $layer=P_src_drn $thickness=1e-09
+ $X=0.6306 $Y=0.2025 $X2=0.6335 $Y2=0.2025
r21 151 149 0.0308642 $w=8.1e-08 $l=2.5e-09 $layer=P_src_drn $thickness=1e-09
+ $X=0.5573 $Y=0.2025 $X2=0.5545 $Y2=0.2025
r22 6 149 0.179012 $w=8.1e-08 $l=1.45e-08 $layer=P_src_drn $thickness=1e-09
+ $X=0.54 $Y=0.2025 $X2=0.5545 $Y2=0.2025
r23 59 6 0.179012 $w=8.1e-08 $l=1.45e-08 $layer=P_src_drn $thickness=1e-09
+ $X=0.5255 $Y=0.2025 $X2=0.54 $Y2=0.2025
r24 150 59 0.0308642 $w=8.1e-08 $l=2.5e-09 $layer=P_src_drn $thickness=1e-09
+ $X=0.5226 $Y=0.2025 $X2=0.5255 $Y2=0.2025
r25 147 145 0.0308642 $w=8.1e-08 $l=2.5e-09 $layer=P_src_drn $thickness=1e-09
+ $X=0.4493 $Y=0.2025 $X2=0.4465 $Y2=0.2025
r26 4 145 0.179012 $w=8.1e-08 $l=1.45e-08 $layer=P_src_drn $thickness=1e-09
+ $X=0.432 $Y=0.2025 $X2=0.4465 $Y2=0.2025
r27 58 4 0.179012 $w=8.1e-08 $l=1.45e-08 $layer=P_src_drn $thickness=1e-09
+ $X=0.4175 $Y=0.2025 $X2=0.432 $Y2=0.2025
r28 146 58 0.0308642 $w=8.1e-08 $l=2.5e-09 $layer=P_src_drn $thickness=1e-09
+ $X=0.4146 $Y=0.2025 $X2=0.4175 $Y2=0.2025
r29 143 141 0.0308642 $w=8.1e-08 $l=2.5e-09 $layer=P_src_drn $thickness=1e-09
+ $X=0.3413 $Y=0.2025 $X2=0.3385 $Y2=0.2025
r30 2 141 0.179012 $w=8.1e-08 $l=1.45e-08 $layer=P_src_drn $thickness=1e-09
+ $X=0.324 $Y=0.2025 $X2=0.3385 $Y2=0.2025
r31 57 2 0.179012 $w=8.1e-08 $l=1.45e-08 $layer=P_src_drn $thickness=1e-09
+ $X=0.3095 $Y=0.2025 $X2=0.324 $Y2=0.2025
r32 142 57 0.0308642 $w=8.1e-08 $l=2.5e-09 $layer=P_src_drn $thickness=1e-09
+ $X=0.3066 $Y=0.2025 $X2=0.3095 $Y2=0.2025
r33 16 138 19.3796 $a=3.24e-16 $layer=V0LISD $X=1.08 $Y=0.2025 $X2=1.08
+ $Y2=0.234
r34 14 136 19.3796 $a=3.24e-16 $layer=V0LISD $X=0.972 $Y=0.2025 $X2=0.972
+ $Y2=0.234
r35 12 134 19.3796 $a=3.24e-16 $layer=V0LISD $X=0.864 $Y=0.2025 $X2=0.864
+ $Y2=0.234
r36 10 132 19.3796 $a=3.24e-16 $layer=V0LISD $X=0.756 $Y=0.2025 $X2=0.756
+ $Y2=0.234
r37 8 130 19.3796 $a=3.24e-16 $layer=V0LISD $X=0.648 $Y=0.2025 $X2=0.648
+ $Y2=0.234
r38 6 128 19.3796 $a=3.24e-16 $layer=V0LISD $X=0.54 $Y=0.2025 $X2=0.54 $Y2=0.234
r39 4 126 19.3796 $a=3.24e-16 $layer=V0LISD $X=0.432 $Y=0.2025 $X2=0.432
+ $Y2=0.234
r40 2 124 19.3796 $a=3.24e-16 $layer=V0LISD $X=0.324 $Y=0.2025 $X2=0.324
+ $Y2=0.234
r41 138 139 6.17953 $w=1.3e-08 $l=2.65e-08 $layer=M1 $thickness=3.6e-08 $X=1.08
+ $Y=0.234 $X2=1.1065 $Y2=0.234
r42 137 138 12.5922 $w=1.3e-08 $l=5.4e-08 $layer=M1 $thickness=3.6e-08 $X=1.026
+ $Y=0.234 $X2=1.08 $Y2=0.234
r43 136 137 12.5922 $w=1.3e-08 $l=5.4e-08 $layer=M1 $thickness=3.6e-08 $X=0.972
+ $Y=0.234 $X2=1.026 $Y2=0.234
r44 135 136 12.5922 $w=1.3e-08 $l=5.4e-08 $layer=M1 $thickness=3.6e-08 $X=0.918
+ $Y=0.234 $X2=0.972 $Y2=0.234
r45 134 135 12.5922 $w=1.3e-08 $l=5.4e-08 $layer=M1 $thickness=3.6e-08 $X=0.864
+ $Y=0.234 $X2=0.918 $Y2=0.234
r46 133 134 12.5922 $w=1.3e-08 $l=5.4e-08 $layer=M1 $thickness=3.6e-08 $X=0.81
+ $Y=0.234 $X2=0.864 $Y2=0.234
r47 132 133 12.5922 $w=1.3e-08 $l=5.4e-08 $layer=M1 $thickness=3.6e-08 $X=0.756
+ $Y=0.234 $X2=0.81 $Y2=0.234
r48 131 132 12.5922 $w=1.3e-08 $l=5.4e-08 $layer=M1 $thickness=3.6e-08 $X=0.702
+ $Y=0.234 $X2=0.756 $Y2=0.234
r49 130 131 12.5922 $w=1.3e-08 $l=5.4e-08 $layer=M1 $thickness=3.6e-08 $X=0.648
+ $Y=0.234 $X2=0.702 $Y2=0.234
r50 129 130 12.5922 $w=1.3e-08 $l=5.4e-08 $layer=M1 $thickness=3.6e-08 $X=0.594
+ $Y=0.234 $X2=0.648 $Y2=0.234
r51 128 129 12.5922 $w=1.3e-08 $l=5.4e-08 $layer=M1 $thickness=3.6e-08 $X=0.54
+ $Y=0.234 $X2=0.594 $Y2=0.234
r52 127 128 12.5922 $w=1.3e-08 $l=5.4e-08 $layer=M1 $thickness=3.6e-08 $X=0.486
+ $Y=0.234 $X2=0.54 $Y2=0.234
r53 126 127 12.5922 $w=1.3e-08 $l=5.4e-08 $layer=M1 $thickness=3.6e-08 $X=0.432
+ $Y=0.234 $X2=0.486 $Y2=0.234
r54 125 126 12.5922 $w=1.3e-08 $l=5.4e-08 $layer=M1 $thickness=3.6e-08 $X=0.378
+ $Y=0.234 $X2=0.432 $Y2=0.234
r55 124 125 12.5922 $w=1.3e-08 $l=5.4e-08 $layer=M1 $thickness=3.6e-08 $X=0.324
+ $Y=0.234 $X2=0.378 $Y2=0.234
r56 68 139 7.34548 $w=1.3e-08 $l=3.15e-08 $layer=M1 $thickness=3.6e-08 $X=1.138
+ $Y=0.234 $X2=1.1065 $Y2=0.234
r57 66 122 9.19421 $w=1.48968e-08 $l=4.65e-08 $layer=M1 $thickness=3.6e-08
+ $X=1.161 $Y=0.234 $X2=1.161 $Y2=0.1875
r58 66 68 3.71425 $w=1.49565e-08 $l=2.3e-08 $layer=M1 $thickness=3.6e-08
+ $X=1.161 $Y=0.234 $X2=1.138 $Y2=0.234
r59 121 122 8.86121 $w=1.3e-08 $l=3.8e-08 $layer=M1 $thickness=3.6e-08 $X=1.16
+ $Y=0.1495 $X2=1.161 $Y2=0.1875
r60 121 120 0.699569 $w=1.3e-08 $l=3e-09 $layer=M1 $thickness=3.6e-08 $X=1.16
+ $Y=0.1495 $X2=1.161 $Y2=0.1465
r61 119 120 2.68168 $w=1.3e-08 $l=1.15e-08 $layer=M1 $thickness=3.6e-08
+ $X=1.161 $Y=0.135 $X2=1.161 $Y2=0.1465
r62 69 119 11.5429 $w=1.3e-08 $l=4.95e-08 $layer=M1 $thickness=3.6e-08 $X=1.161
+ $Y=0.0855 $X2=1.161 $Y2=0.135
r63 118 116 0.0308642 $w=8.1e-08 $l=2.5e-09 $layer=N_src_drn $thickness=1e-09
+ $X=1.0973 $Y=0.0675 $X2=1.0945 $Y2=0.0675
r64 15 116 0.179012 $w=8.1e-08 $l=1.45e-08 $layer=N_src_drn $thickness=1e-09
+ $X=1.08 $Y=0.0675 $X2=1.0945 $Y2=0.0675
r65 56 15 0.179012 $w=8.1e-08 $l=1.45e-08 $layer=N_src_drn $thickness=1e-09
+ $X=1.0655 $Y=0.0675 $X2=1.08 $Y2=0.0675
r66 117 56 0.0308642 $w=8.1e-08 $l=2.5e-09 $layer=N_src_drn $thickness=1e-09
+ $X=1.0626 $Y=0.0675 $X2=1.0655 $Y2=0.0675
r67 114 112 0.0308642 $w=8.1e-08 $l=2.5e-09 $layer=N_src_drn $thickness=1e-09
+ $X=0.9893 $Y=0.0675 $X2=0.9865 $Y2=0.0675
r68 13 112 0.179012 $w=8.1e-08 $l=1.45e-08 $layer=N_src_drn $thickness=1e-09
+ $X=0.972 $Y=0.0675 $X2=0.9865 $Y2=0.0675
r69 55 13 0.179012 $w=8.1e-08 $l=1.45e-08 $layer=N_src_drn $thickness=1e-09
+ $X=0.9575 $Y=0.0675 $X2=0.972 $Y2=0.0675
r70 113 55 0.0308642 $w=8.1e-08 $l=2.5e-09 $layer=N_src_drn $thickness=1e-09
+ $X=0.9546 $Y=0.0675 $X2=0.9575 $Y2=0.0675
r71 110 108 0.0308642 $w=8.1e-08 $l=2.5e-09 $layer=N_src_drn $thickness=1e-09
+ $X=0.8813 $Y=0.0675 $X2=0.8785 $Y2=0.0675
r72 11 108 0.179012 $w=8.1e-08 $l=1.45e-08 $layer=N_src_drn $thickness=1e-09
+ $X=0.864 $Y=0.0675 $X2=0.8785 $Y2=0.0675
r73 54 11 0.179012 $w=8.1e-08 $l=1.45e-08 $layer=N_src_drn $thickness=1e-09
+ $X=0.8495 $Y=0.0675 $X2=0.864 $Y2=0.0675
r74 109 54 0.0308642 $w=8.1e-08 $l=2.5e-09 $layer=N_src_drn $thickness=1e-09
+ $X=0.8466 $Y=0.0675 $X2=0.8495 $Y2=0.0675
r75 106 104 0.0308642 $w=8.1e-08 $l=2.5e-09 $layer=N_src_drn $thickness=1e-09
+ $X=0.7733 $Y=0.0675 $X2=0.7705 $Y2=0.0675
r76 9 104 0.179012 $w=8.1e-08 $l=1.45e-08 $layer=N_src_drn $thickness=1e-09
+ $X=0.756 $Y=0.0675 $X2=0.7705 $Y2=0.0675
r77 53 9 0.179012 $w=8.1e-08 $l=1.45e-08 $layer=N_src_drn $thickness=1e-09
+ $X=0.7415 $Y=0.0675 $X2=0.756 $Y2=0.0675
r78 105 53 0.0308642 $w=8.1e-08 $l=2.5e-09 $layer=N_src_drn $thickness=1e-09
+ $X=0.7386 $Y=0.0675 $X2=0.7415 $Y2=0.0675
r79 102 100 0.0308642 $w=8.1e-08 $l=2.5e-09 $layer=N_src_drn $thickness=1e-09
+ $X=0.5573 $Y=0.0675 $X2=0.5545 $Y2=0.0675
r80 5 100 0.179012 $w=8.1e-08 $l=1.45e-08 $layer=N_src_drn $thickness=1e-09
+ $X=0.54 $Y=0.0675 $X2=0.5545 $Y2=0.0675
r81 51 5 0.179012 $w=8.1e-08 $l=1.45e-08 $layer=N_src_drn $thickness=1e-09
+ $X=0.5255 $Y=0.0675 $X2=0.54 $Y2=0.0675
r82 101 51 0.0308642 $w=8.1e-08 $l=2.5e-09 $layer=N_src_drn $thickness=1e-09
+ $X=0.5226 $Y=0.0675 $X2=0.5255 $Y2=0.0675
r83 98 96 0.0308642 $w=8.1e-08 $l=2.5e-09 $layer=N_src_drn $thickness=1e-09
+ $X=0.4493 $Y=0.0675 $X2=0.4465 $Y2=0.0675
r84 3 96 0.179012 $w=8.1e-08 $l=1.45e-08 $layer=N_src_drn $thickness=1e-09
+ $X=0.432 $Y=0.0675 $X2=0.4465 $Y2=0.0675
r85 50 3 0.179012 $w=8.1e-08 $l=1.45e-08 $layer=N_src_drn $thickness=1e-09
+ $X=0.4175 $Y=0.0675 $X2=0.432 $Y2=0.0675
r86 97 50 0.0308642 $w=8.1e-08 $l=2.5e-09 $layer=N_src_drn $thickness=1e-09
+ $X=0.4146 $Y=0.0675 $X2=0.4175 $Y2=0.0675
r87 94 92 0.0308642 $w=8.1e-08 $l=2.5e-09 $layer=N_src_drn $thickness=1e-09
+ $X=0.3413 $Y=0.0675 $X2=0.3385 $Y2=0.0675
r88 1 92 0.179012 $w=8.1e-08 $l=1.45e-08 $layer=N_src_drn $thickness=1e-09
+ $X=0.324 $Y=0.0675 $X2=0.3385 $Y2=0.0675
r89 49 1 0.179012 $w=8.1e-08 $l=1.45e-08 $layer=N_src_drn $thickness=1e-09
+ $X=0.3095 $Y=0.0675 $X2=0.324 $Y2=0.0675
r90 93 49 0.0308642 $w=8.1e-08 $l=2.5e-09 $layer=N_src_drn $thickness=1e-09
+ $X=0.3066 $Y=0.0675 $X2=0.3095 $Y2=0.0675
r91 65 90 3.71425 $w=1.49565e-08 $l=2.3e-08 $layer=M1 $thickness=3.6e-08
+ $X=1.161 $Y=0.036 $X2=1.138 $Y2=0.036
r92 65 69 9.89378 $w=1.47818e-08 $l=4.95e-08 $layer=M1 $thickness=3.6e-08
+ $X=1.161 $Y=0.036 $X2=1.161 $Y2=0.0855
r93 15 88 19.3796 $a=3.24e-16 $layer=V0LISD $X=1.08 $Y=0.0675 $X2=1.08 $Y2=0.036
r94 13 86 19.3796 $a=3.24e-16 $layer=V0LISD $X=0.972 $Y=0.0675 $X2=0.972
+ $Y2=0.036
r95 11 84 19.3796 $a=3.24e-16 $layer=V0LISD $X=0.864 $Y=0.0675 $X2=0.864
+ $Y2=0.036
r96 9 82 19.3796 $a=3.24e-16 $layer=V0LISD $X=0.756 $Y=0.0675 $X2=0.756
+ $Y2=0.036
r97 5 78 19.3796 $a=3.24e-16 $layer=V0LISD $X=0.54 $Y=0.0675 $X2=0.54 $Y2=0.036
r98 3 76 19.3796 $a=3.24e-16 $layer=V0LISD $X=0.432 $Y=0.0675 $X2=0.432
+ $Y2=0.036
r99 1 74 19.3796 $a=3.24e-16 $layer=V0LISD $X=0.324 $Y=0.0675 $X2=0.324
+ $Y2=0.036
r100 89 90 7.34548 $w=1.3e-08 $l=3.15e-08 $layer=M1 $thickness=3.6e-08
+ $X=1.1065 $Y=0.036 $X2=1.138 $Y2=0.036
r101 88 89 6.17953 $w=1.3e-08 $l=2.65e-08 $layer=M1 $thickness=3.6e-08 $X=1.08
+ $Y=0.036 $X2=1.1065 $Y2=0.036
r102 87 88 12.5922 $w=1.3e-08 $l=5.4e-08 $layer=M1 $thickness=3.6e-08 $X=1.026
+ $Y=0.036 $X2=1.08 $Y2=0.036
r103 86 87 12.5922 $w=1.3e-08 $l=5.4e-08 $layer=M1 $thickness=3.6e-08 $X=0.972
+ $Y=0.036 $X2=1.026 $Y2=0.036
r104 85 86 12.5922 $w=1.3e-08 $l=5.4e-08 $layer=M1 $thickness=3.6e-08 $X=0.918
+ $Y=0.036 $X2=0.972 $Y2=0.036
r105 84 85 12.5922 $w=1.3e-08 $l=5.4e-08 $layer=M1 $thickness=3.6e-08 $X=0.864
+ $Y=0.036 $X2=0.918 $Y2=0.036
r106 83 84 12.5922 $w=1.3e-08 $l=5.4e-08 $layer=M1 $thickness=3.6e-08 $X=0.81
+ $Y=0.036 $X2=0.864 $Y2=0.036
r107 82 83 12.5922 $w=1.3e-08 $l=5.4e-08 $layer=M1 $thickness=3.6e-08 $X=0.756
+ $Y=0.036 $X2=0.81 $Y2=0.036
r108 81 82 12.5922 $w=1.3e-08 $l=5.4e-08 $layer=M1 $thickness=3.6e-08 $X=0.702
+ $Y=0.036 $X2=0.756 $Y2=0.036
r109 80 81 12.5922 $w=1.3e-08 $l=5.4e-08 $layer=M1 $thickness=3.6e-08 $X=0.648
+ $Y=0.036 $X2=0.702 $Y2=0.036
r110 79 80 12.5922 $w=1.3e-08 $l=5.4e-08 $layer=M1 $thickness=3.6e-08 $X=0.594
+ $Y=0.036 $X2=0.648 $Y2=0.036
r111 78 79 12.5922 $w=1.3e-08 $l=5.4e-08 $layer=M1 $thickness=3.6e-08 $X=0.54
+ $Y=0.036 $X2=0.594 $Y2=0.036
r112 77 78 12.5922 $w=1.3e-08 $l=5.4e-08 $layer=M1 $thickness=3.6e-08 $X=0.486
+ $Y=0.036 $X2=0.54 $Y2=0.036
r113 76 77 12.5922 $w=1.3e-08 $l=5.4e-08 $layer=M1 $thickness=3.6e-08 $X=0.432
+ $Y=0.036 $X2=0.486 $Y2=0.036
r114 75 76 12.5922 $w=1.3e-08 $l=5.4e-08 $layer=M1 $thickness=3.6e-08 $X=0.378
+ $Y=0.036 $X2=0.432 $Y2=0.036
r115 74 75 12.5922 $w=1.3e-08 $l=5.4e-08 $layer=M1 $thickness=3.6e-08 $X=0.324
+ $Y=0.036 $X2=0.378 $Y2=0.036
r116 67 74 2.68168 $w=1.3e-08 $l=1.15e-08 $layer=M1 $thickness=3.6e-08
+ $X=0.3125 $Y=0.036 $X2=0.324 $Y2=0.036
r117 7 80 19.3796 $a=3.24e-16 $layer=V0LISD $X=0.648 $Y=0.0675 $X2=0.648
+ $Y2=0.036
r118 73 71 0.0308642 $w=8.1e-08 $l=2.5e-09 $layer=N_src_drn $thickness=1e-09
+ $X=0.6653 $Y=0.0675 $X2=0.6625 $Y2=0.0675
r119 7 71 0.179012 $w=8.1e-08 $l=1.45e-08 $layer=N_src_drn $thickness=1e-09
+ $X=0.648 $Y=0.0675 $X2=0.6625 $Y2=0.0675
r120 52 7 0.179012 $w=8.1e-08 $l=1.45e-08 $layer=N_src_drn $thickness=1e-09
+ $X=0.6335 $Y=0.0675 $X2=0.648 $Y2=0.0675
r121 72 52 0.0308642 $w=8.1e-08 $l=2.5e-09 $layer=N_src_drn $thickness=1e-09
+ $X=0.6306 $Y=0.0675 $X2=0.6335 $Y2=0.0675
.ends

* End of included file BUFx16f_ASAP7_75t_R.pex.sp.pex

*
.subckt BUFx16f_ASAP7_75t_CUSTOM_4_25_0_7 A VSS VDD Y
*
* A A
* VSS VSS
* VDD VDD
* Y Y
*
*

M0 N_M0_d N_M0_g VSS VSS nmos_rvt L=2e-08 W=8.1e-08 nfin=3 $X=0.071 $Y=0.027
M1 N_M1_d N_M1_g VSS VSS nmos_rvt L=2e-08 W=8.1e-08 nfin=3 $X=0.125 $Y=0.027
M2 N_M2_d N_M2_g VSS VSS nmos_rvt L=2e-08 W=8.1e-08 nfin=3 $X=0.179 $Y=0.027
M3 N_M3_d N_M3_g VSS VSS nmos_rvt L=2e-08 W=8.1e-08 nfin=3 $X=0.233 $Y=0.027
M4 N_M4_d N_M4_g VSS VSS nmos_rvt L=2e-08 W=8.1e-08 nfin=3 $X=0.287 $Y=0.027
M5 N_M5_d N_M5_g VSS VSS nmos_rvt L=2e-08 W=8.1e-08 nfin=3 $X=0.341 $Y=0.027
M6 N_M6_d N_M6_g VSS VSS nmos_rvt L=2e-08 W=8.1e-08 nfin=3 $X=0.395 $Y=0.027
M7 N_M7_d N_M7_g VSS VSS nmos_rvt L=2e-08 W=8.1e-08 nfin=3 $X=0.449 $Y=0.027
M8 N_M8_d N_M8_g VSS VSS nmos_rvt L=2e-08 W=8.1e-08 nfin=3 $X=0.503 $Y=0.027
M9 N_M9_d N_M9_g VSS VSS nmos_rvt L=2e-08 W=8.1e-08 nfin=3 $X=0.557 $Y=0.027
M10 N_M10_d N_M10_g VSS VSS nmos_rvt L=2e-08 W=8.1e-08 nfin=3 $X=0.611 $Y=0.027
M11 N_M11_d N_M11_g VSS VSS nmos_rvt L=2e-08 W=8.1e-08 nfin=3 $X=0.665 $Y=0.027
M12 N_M12_d N_M12_g VSS VSS nmos_rvt L=2e-08 W=8.1e-08 nfin=3 $X=0.719 $Y=0.027
M13 N_M13_d N_M13_g VSS VSS nmos_rvt L=2e-08 W=8.1e-08 nfin=3 $X=0.773 $Y=0.027
M14 N_M14_d N_M14_g VSS VSS nmos_rvt L=2e-08 W=8.1e-08 nfin=3 $X=0.827 $Y=0.027
M15 N_M15_d N_M15_g VSS VSS nmos_rvt L=2e-08 W=8.1e-08 nfin=3 $X=0.881 $Y=0.027
M16 N_M16_d N_M16_g VSS VSS nmos_rvt L=2e-08 W=8.1e-08 nfin=3 $X=0.935 $Y=0.027
M17 N_M17_d N_M17_g VSS VSS nmos_rvt L=2e-08 W=8.1e-08 nfin=3 $X=0.989 $Y=0.027
M18 N_M18_d N_M18_g VSS VSS nmos_rvt L=2e-08 W=8.1e-08 nfin=3 $X=1.043 $Y=0.027
M19 N_M19_d N_M19_g VSS VSS nmos_rvt L=2e-08 W=8.1e-08 nfin=3 $X=1.097 $Y=0.027
M20 N_M20_d N_M20_g VDD VDD pmos_rvt L=2e-08 W=8.1e-08 nfin=3 $X=0.071 $Y=0.162
M21 N_M21_d N_M21_g VDD VDD pmos_rvt L=2e-08 W=8.1e-08 nfin=3 $X=0.125 $Y=0.162
M22 N_M22_d N_M22_g VDD VDD pmos_rvt L=2e-08 W=8.1e-08 nfin=3 $X=0.179 $Y=0.162
M23 N_M23_d N_M23_g VDD VDD pmos_rvt L=2e-08 W=8.1e-08 nfin=3 $X=0.233 $Y=0.162
M24 N_M24_d N_M24_g VDD VDD pmos_rvt L=2e-08 W=8.1e-08 nfin=3 $X=0.287 $Y=0.162
M25 N_M25_d N_M25_g VDD VDD pmos_rvt L=2e-08 W=8.1e-08 nfin=3 $X=0.341 $Y=0.162
M26 N_M26_d N_M26_g VDD VDD pmos_rvt L=2e-08 W=8.1e-08 nfin=3 $X=0.395 $Y=0.162
M27 N_M27_d N_M27_g VDD VDD pmos_rvt L=2e-08 W=8.1e-08 nfin=3 $X=0.449 $Y=0.162
M28 N_M28_d N_M28_g VDD VDD pmos_rvt L=2e-08 W=8.1e-08 nfin=3 $X=0.503 $Y=0.162
M29 N_M29_d N_M29_g VDD VDD pmos_rvt L=2e-08 W=8.1e-08 nfin=3 $X=0.557 $Y=0.162
M30 N_M30_d N_M30_g VDD VDD pmos_rvt L=2e-08 W=8.1e-08 nfin=3 $X=0.611 $Y=0.162
M31 N_M31_d N_M31_g VDD VDD pmos_rvt L=2e-08 W=8.1e-08 nfin=3 $X=0.665 $Y=0.162
M32 N_M32_d N_M32_g VDD VDD pmos_rvt L=2e-08 W=8.1e-08 nfin=3 $X=0.719 $Y=0.162
M33 N_M33_d N_M33_g VDD VDD pmos_rvt L=2e-08 W=8.1e-08 nfin=3 $X=0.773 $Y=0.162
M34 N_M34_d N_M34_g VDD VDD pmos_rvt L=2e-08 W=8.1e-08 nfin=3 $X=0.827 $Y=0.162
M35 N_M35_d N_M35_g VDD VDD pmos_rvt L=2e-08 W=8.1e-08 nfin=3 $X=0.881 $Y=0.162
M36 N_M36_d N_M36_g VDD VDD pmos_rvt L=2e-08 W=8.1e-08 nfin=3 $X=0.935 $Y=0.162
M37 N_M37_d N_M37_g VDD VDD pmos_rvt L=2e-08 W=8.1e-08 nfin=3 $X=0.989 $Y=0.162
M38 N_M38_d N_M38_g VDD VDD pmos_rvt L=2e-08 W=8.1e-08 nfin=3 $X=1.043 $Y=0.162
M39 N_M39_d N_M39_g VDD VDD pmos_rvt L=2e-08 W=8.1e-08 nfin=3 $X=1.097 $Y=0.162

* .include "BUFx16f_ASAP7_75t_R.pex.sp.pxi"

* Start of included file BUFx16f_ASAP7_75t_R.pex.sp.pxi
x_PM_BUFx16f_ASAP7_75t_R%A vss A N_M0_g N_M20_g N_M1_g N_M21_g N_M2_g N_M22_g
+ N_M3_g N_M23_g N_A_3 N_A_6 N_A_8 N_A_7 N_A_5 N_A_4 N_A_9 N_A_1
+ PM_BUFx16f_ASAP7_75t_R%A
x_PM_BUFx16f_ASAP7_75t_R%4 vss N_M10_g N_M30_g N_M9_g N_M29_g N_M8_g N_M28_g
+ N_M7_g N_M27_g N_M6_g N_M26_g N_M5_g N_M25_g N_M4_g N_M24_g N_M11_g N_M31_g
+ N_M12_g N_M32_g N_M13_g N_M33_g N_M14_g N_M34_g N_M15_g N_M35_g N_M16_g
+ N_M36_g N_M17_g N_M37_g N_M18_g N_M38_g N_M19_g N_M39_g N_M0_d N_M1_d N_M2_d
+ N_M3_d N_M20_d N_M21_d N_M22_d N_M23_d N_4_51 N_4_57 N_4_18 N_4_19 N_4_55
+ N_4_56 N_4_1 N_4_54 N_4_53 N_4_49 N_4_47 N_4_46 N_4_20 N_4_21 N_4_30 N_4_48
+ N_4_32 N_4_34 N_4_36 N_4_38 N_4_40 N_4_42 N_4_44 N_4_50 N_4_52 N_4_33 N_4_35
+ N_4_37 N_4_39 N_4_41 N_4_43 N_4_45 N_4_31 PM_BUFx16f_ASAP7_75t_R%4
cc_1 N_4_51 N_A_3 0.000170149f $X=0.243 $Y=0.135
cc_2 N_4_57 N_A_3 0.000174118f $X=0.27 $Y=0.135
cc_3 N_4_18 N_A_3 0.000318955f $X=0.108 $Y=0.0675
cc_4 N_4_19 N_A_3 0.000318955f $X=0.108 $Y=0.2025
cc_5 N_4_55 N_A_3 0.000403521f $X=0.243 $Y=0.0855
cc_6 N_4_56 N_A_3 0.000403521f $X=0.243 $Y=0.1845
cc_7 N_4_1 N_A_6 0.000423131f $X=0.6115 $Y=0.135
cc_8 N_4_54 N_A_8 0.000596393f $X=0.0965 $Y=0.234
cc_9 N_4_53 N_A_7 0.000597025f $X=0.0965 $Y=0.036
cc_10 N_4_53 N_A_5 0.000843625f $X=0.0965 $Y=0.036
cc_11 N_4_54 N_A_5 0.000843625f $X=0.0965 $Y=0.234
cc_12 N_4_49 N_A_6 0.0113488f $X=0.2015 $Y=0.2025
cc_13 N_4_47 N_A_5 0.0113494f $X=0.2015 $Y=0.0675
cc_14 N_4_46 N_A_4 0.0114855f $X=0.0935 $Y=0.0675
cc_15 N_4_18 N_A_9 0.00104645f $X=0.108 $Y=0.0675
cc_16 N_4_20 N_A_5 0.00156681f $X=0.216 $Y=0.0675
cc_17 N_4_21 N_A_5 0.00156681f $X=0.216 $Y=0.2025
cc_18 N_4_18 N_A_4 0.00171488f $X=0.108 $Y=0.0675
cc_19 N_4_19 N_A_4 0.00171488f $X=0.108 $Y=0.2025
cc_20 N_4_30 N_A_6 0.00174782f $X=0.297 $Y=0.135
cc_21 N_4_46 N_A_1 0.00970045f $X=0.0935 $Y=0.0675
cc_22 N_4_48 N_A_4 0.0565929f $X=0.0935 $Y=0.2025
cc_23 N_4_47 N_A_6 0.0584448f $X=0.2015 $Y=0.0675
cc_24 N_4_46 N_A_3 0.0188531f $X=0.0935 $Y=0.0675
cc_25 N_4_49 N_A_5 0.0570791f $X=0.2015 $Y=0.2025
cc_26 N_4_48 N_A_3 0.0498382f $X=0.0935 $Y=0.2025
x_PM_BUFx16f_ASAP7_75t_R%Y vss Y N_M10_d N_M11_d N_M4_d N_M5_d N_M6_d N_M7_d
+ N_M8_d N_M9_d N_M12_d N_M13_d N_M14_d N_M15_d N_M16_d N_M17_d N_M18_d N_M19_d
+ N_M24_d N_M25_d N_M26_d N_M27_d N_M28_d N_M29_d N_M30_d N_M31_d N_M32_d
+ N_M33_d N_M34_d N_M35_d N_M36_d N_M37_d N_M38_d N_M39_d N_Y_57 N_Y_67 N_Y_68
+ N_Y_1 N_Y_3 N_Y_5 N_Y_7 N_Y_9 N_Y_11 N_Y_13 N_Y_15 N_Y_16 N_Y_49 N_Y_50
+ N_Y_51 N_Y_52 N_Y_53 N_Y_54 N_Y_55 N_Y_58 N_Y_59 N_Y_60 N_Y_61 N_Y_62 N_Y_63
+ N_Y_56 N_Y_64 N_Y_69 N_Y_4 N_Y_6 N_Y_8 N_Y_10 N_Y_12 N_Y_14 N_Y_2
+ PM_BUFx16f_ASAP7_75t_R%Y
cc_27 N_Y_57 N_4_30 0.018003f $X=0.3095 $Y=0.2025
cc_28 N_Y_57 N_4_32 0.000187388f $X=0.3095 $Y=0.2025
cc_29 N_Y_57 N_4_34 0.000187388f $X=0.3095 $Y=0.2025
cc_30 N_Y_57 N_4_36 0.000187388f $X=0.3095 $Y=0.2025
cc_31 N_Y_57 N_4_38 0.000187388f $X=0.3095 $Y=0.2025
cc_32 N_Y_57 N_4_40 0.000187388f $X=0.3095 $Y=0.2025
cc_33 N_Y_57 N_4_42 0.000187388f $X=0.3095 $Y=0.2025
cc_34 N_Y_57 N_4_44 0.000187388f $X=0.3095 $Y=0.2025
cc_35 N_Y_57 N_4_53 0.000103048f $X=0.3095 $Y=0.2025
cc_36 N_Y_57 N_4_54 0.000103048f $X=0.3095 $Y=0.2025
cc_37 N_Y_57 N_4_50 0.000141953f $X=0.3095 $Y=0.2025
cc_38 N_Y_57 N_4_52 0.000141953f $X=0.3095 $Y=0.2025
cc_39 N_Y_67 N_4_55 0.000404652f $X=0.3125 $Y=0.036
cc_40 N_Y_68 N_4_56 0.000404652f $X=1.138 $Y=0.234
cc_41 N_Y_1 N_4_1 0.000837202f $X=0.324 $Y=0.0675
cc_42 N_Y_3 N_4_1 0.00110788f $X=0.432 $Y=0.0675
cc_43 N_Y_5 N_4_1 0.00110788f $X=0.54 $Y=0.0675
cc_44 N_Y_7 N_4_1 0.00110788f $X=0.648 $Y=0.0675
cc_45 N_Y_9 N_4_1 0.00110788f $X=0.756 $Y=0.0675
cc_46 N_Y_11 N_4_1 0.00110788f $X=0.864 $Y=0.0675
cc_47 N_Y_13 N_4_1 0.00110788f $X=0.972 $Y=0.0675
cc_48 N_Y_15 N_4_1 0.000676211f $X=1.08 $Y=0.0675
cc_49 N_Y_16 N_4_1 0.000727756f $X=1.08 $Y=0.2025
cc_50 N_Y_49 N_4_30 0.0640956f $X=0.3095 $Y=0.0675
cc_51 N_Y_50 N_4_33 0.0186552f $X=0.4175 $Y=0.0675
cc_52 N_Y_51 N_4_35 0.0186552f $X=0.5255 $Y=0.0675
cc_53 N_Y_52 N_4_37 0.0186552f $X=0.6335 $Y=0.0675
cc_54 N_Y_53 N_4_39 0.0186552f $X=0.7415 $Y=0.0675
cc_55 N_Y_54 N_4_41 0.0186552f $X=0.8495 $Y=0.0675
cc_56 N_Y_55 N_4_43 0.0543356f $X=0.9575 $Y=0.0675
cc_57 N_Y_58 N_4_33 0.0544117f $X=0.4175 $Y=0.2025
cc_58 N_Y_59 N_4_35 0.0544117f $X=0.5255 $Y=0.2025
cc_59 N_Y_60 N_4_37 0.0544117f $X=0.6335 $Y=0.2025
cc_60 N_Y_61 N_4_39 0.0544117f $X=0.7415 $Y=0.2025
cc_61 N_Y_62 N_4_41 0.0544117f $X=0.8495 $Y=0.2025
cc_62 N_Y_63 N_4_43 0.0186541f $X=0.9575 $Y=0.2025
cc_63 N_Y_56 N_4_44 0.0186898f $X=1.0655 $Y=0.0675
cc_64 N_Y_64 N_4_45 0.0463665f $X=1.0655 $Y=0.2025
cc_65 N_Y_69 N_4_57 0.00170032f $X=1.161 $Y=0.0855
cc_66 N_Y_15 N_4_45 0.00183478f $X=1.08 $Y=0.0675
cc_67 N_Y_16 N_4_45 0.00183478f $X=1.08 $Y=0.2025
cc_68 N_Y_3 N_4_32 0.00189932f $X=0.432 $Y=0.0675
cc_69 N_Y_4 N_4_33 0.00189932f $X=0.432 $Y=0.2025
cc_70 N_Y_5 N_4_34 0.00189932f $X=0.54 $Y=0.0675
cc_71 N_Y_6 N_4_35 0.00189932f $X=0.54 $Y=0.2025
cc_72 N_Y_7 N_4_36 0.00189932f $X=0.648 $Y=0.0675
cc_73 N_Y_8 N_4_37 0.00189932f $X=0.648 $Y=0.2025
cc_74 N_Y_9 N_4_38 0.00189932f $X=0.756 $Y=0.0675
cc_75 N_Y_10 N_4_39 0.00189932f $X=0.756 $Y=0.2025
cc_76 N_Y_11 N_4_40 0.00189932f $X=0.864 $Y=0.0675
cc_77 N_Y_12 N_4_41 0.00189932f $X=0.864 $Y=0.2025
cc_78 N_Y_13 N_4_42 0.00189932f $X=0.972 $Y=0.0675
cc_79 N_Y_14 N_4_43 0.00189932f $X=0.972 $Y=0.2025
cc_80 N_Y_1 N_4_30 0.00206575f $X=0.324 $Y=0.0675
cc_81 N_Y_2 N_4_30 0.00206575f $X=0.324 $Y=0.2025
cc_82 N_Y_68 N_4_57 0.00656866f $X=1.138 $Y=0.234
cc_83 N_Y_67 N_4_57 0.00656876f $X=0.3125 $Y=0.036
cc_84 N_Y_4 N_4_57 0.00709585f $X=0.432 $Y=0.2025
cc_85 N_Y_11 N_4_57 0.00909368f $X=0.864 $Y=0.0675
cc_86 N_Y_59 N_4_34 0.00990016f $X=0.5255 $Y=0.2025
cc_87 N_Y_60 N_4_36 0.00990016f $X=0.6335 $Y=0.2025
cc_88 N_Y_61 N_4_38 0.00990016f $X=0.7415 $Y=0.2025
cc_89 N_Y_62 N_4_40 0.00990016f $X=0.8495 $Y=0.2025
cc_90 N_Y_63 N_4_42 0.00990016f $X=0.9575 $Y=0.2025
cc_91 N_Y_50 N_4_32 0.00990066f $X=0.4175 $Y=0.0675
cc_92 N_Y_56 N_4_45 0.0101136f $X=1.0655 $Y=0.0675
cc_93 N_Y_51 N_4_1 0.0165366f $X=0.5255 $Y=0.0675
cc_94 N_Y_54 N_4_1 0.0165803f $X=0.8495 $Y=0.0675
cc_95 N_Y_64 N_4_44 0.0537604f $X=1.0655 $Y=0.2025
cc_96 N_Y_58 N_4_32 0.0456564f $X=0.4175 $Y=0.2025
cc_97 N_Y_51 N_4_34 0.0456583f $X=0.5255 $Y=0.0675
cc_98 N_Y_52 N_4_36 0.0456583f $X=0.6335 $Y=0.0675
cc_99 N_Y_53 N_4_38 0.0456583f $X=0.7415 $Y=0.0675
cc_100 N_Y_54 N_4_40 0.0456583f $X=0.8495 $Y=0.0675
cc_101 N_Y_55 N_4_42 0.0456583f $X=0.9575 $Y=0.0675
cc_102 N_Y_57 N_4_31 0.0469818f $X=0.3095 $Y=0.2025

* End of included file BUFx16f_ASAP7_75t_R.pex.sp.pxi
.ends

.subckt PM_CKINVDCx16_ASAP7_75t_R%8 vss 19 23 33 36 46 47 50 51 10 15 17 3 1 11
+ 13 9 4 18
c1 1 vss 0.00633094f $X=0.405 $Y=0.135
c2 3 vss 0.00722185f $X=0.324 $Y=0.2025
c3 4 vss 0.00716638f $X=0.432 $Y=0.2025
c4 9 vss 0.0821902f $X=0.405 $Y=0.0245
c5 10 vss 0.0824012f $X=0.459 $Y=0.135
c6 11 vss 0.00724598f $X=0.3095 $Y=0.2025
c7 12 vss 0.00672171f $X=0.4175 $Y=0.2025
c8 13 vss 0.000209797f $X=0.405 $Y=0.135
c9 14 vss 0.000356645f $X=0.405 $Y=0.171
c10 15 vss 0.00261753f $X=0.378 $Y=0.171
c11 16 vss 0.000149613f $X=0.405 $Y=0.153
c12 17 vss 0.000704628f $X=0.4185 $Y=0.135
c13 18 vss 0.00134268f $X=0.4185 $Y=0.171
r1 51 49 0.0308642 $w=8.1e-08 $l=2.5e-09 $layer=P_src_drn $thickness=1e-09
+ $X=0.4493 $Y=0.2025 $X2=0.4465 $Y2=0.2025
r2 4 49 0.179012 $w=8.1e-08 $l=1.45e-08 $layer=P_src_drn $thickness=1e-09
+ $X=0.432 $Y=0.2025 $X2=0.4465 $Y2=0.2025
r3 12 4 0.179012 $w=8.1e-08 $l=1.45e-08 $layer=P_src_drn $thickness=1e-09
+ $X=0.4175 $Y=0.2025 $X2=0.432 $Y2=0.2025
r4 50 12 0.0308642 $w=8.1e-08 $l=2.5e-09 $layer=P_src_drn $thickness=1e-09
+ $X=0.4146 $Y=0.2025 $X2=0.4175 $Y2=0.2025
r5 47 45 0.0308642 $w=8.1e-08 $l=2.5e-09 $layer=P_src_drn $thickness=1e-09
+ $X=0.3413 $Y=0.2025 $X2=0.3385 $Y2=0.2025
r6 3 45 0.179012 $w=8.1e-08 $l=1.45e-08 $layer=P_src_drn $thickness=1e-09
+ $X=0.324 $Y=0.2025 $X2=0.3385 $Y2=0.2025
r7 11 3 0.179012 $w=8.1e-08 $l=1.45e-08 $layer=P_src_drn $thickness=1e-09
+ $X=0.3095 $Y=0.2025 $X2=0.324 $Y2=0.2025
r8 46 11 0.0308642 $w=8.1e-08 $l=2.5e-09 $layer=P_src_drn $thickness=1e-09
+ $X=0.3066 $Y=0.2025 $X2=0.3095 $Y2=0.2025
r9 4 41 19.3796 $a=3.24e-16 $layer=V0LISD $X=0.432 $Y=0.2025 $X2=0.432 $Y2=0.171
r10 3 39 19.3796 $a=3.24e-16 $layer=V0LISD $X=0.324 $Y=0.2025 $X2=0.324
+ $Y2=0.171
r11 18 41 3.14806 $w=1.3e-08 $l=1.35e-08 $layer=M1 $thickness=3.6e-08 $X=0.4185
+ $Y=0.171 $X2=0.432 $Y2=0.171
r12 39 40 5.24677 $w=1.3e-08 $l=2.25e-08 $layer=M1 $thickness=3.6e-08 $X=0.324
+ $Y=0.171 $X2=0.3465 $Y2=0.171
r13 15 40 7.34548 $w=1.3e-08 $l=3.15e-08 $layer=M1 $thickness=3.6e-08 $X=0.378
+ $Y=0.171 $X2=0.3465 $Y2=0.171
r14 14 16 3.01711 $w=1.55e-08 $l=1.8e-08 $layer=M1 $thickness=3.6e-08 $X=0.405
+ $Y=0.171 $X2=0.405 $Y2=0.153
r15 14 15 5.11582 $w=1.46667e-08 $l=2.7e-08 $layer=M1 $thickness=3.6e-08
+ $X=0.405 $Y=0.171 $X2=0.378 $Y2=0.171
r16 14 18 1.96775 $w=1.63333e-08 $l=1.35e-08 $layer=M1 $thickness=3.6e-08
+ $X=0.405 $Y=0.171 $X2=0.4185 $Y2=0.171
r17 13 17 1.49895 $w=1.63333e-08 $l=1.35e-08 $layer=M1 $thickness=3.6e-08
+ $X=0.405 $Y=0.135 $X2=0.4185 $Y2=0.135
r18 13 16 2.5483 $w=1.79e-08 $l=1.8e-08 $layer=M1 $thickness=3.6e-08 $X=0.405
+ $Y=0.135 $X2=0.405 $Y2=0.153
r19 36 35 16.4967 $w=2.1e-08 $l=4.85e-08 $layer=Gate_1 $thickness=5.6e-08
+ $X=0.459 $Y=0.2025 $X2=0.459 $Y2=0.154
r20 33 34 16.4967 $w=2.1e-08 $l=4.85e-08 $layer=Gate_1 $thickness=5.6e-08
+ $X=0.459 $Y=0.0675 $X2=0.459 $Y2=0.116
r21 10 27 6.54019 $w=2.09524e-08 $layer=Gate_1 $thickness=5.21905e-08 $X=0.459
+ $Y=0.135 $X2=0.459 $Y2=0.135
r22 10 34 6.6497 $w=2.04211e-08 $l=1.9e-08 $layer=Gate_1 $thickness=5.6e-08
+ $X=0.459 $Y=0.135 $X2=0.459 $Y2=0.116
r23 10 35 6.6497 $w=2.04211e-08 $l=1.9e-08 $layer=Gate_1 $thickness=5.6e-08
+ $X=0.459 $Y=0.135 $X2=0.459 $Y2=0.154
r24 17 29 3.14806 $w=1.3e-08 $l=1.35e-08 $layer=M1 $thickness=3.6e-08 $X=0.4185
+ $Y=0.135 $X2=0.432 $Y2=0.135
r25 26 27 12.6539 $w=1.77815e-08 $l=2.7e-08 $layer=LIG $thickness=4.8e-08
+ $X=0.432 $Y=0.135 $X2=0.459 $Y2=0.135
r26 26 29 19.3796 $a=3.24e-16 $layer=V0LIG $X=0.432 $Y=0.135 $X2=0.432 $Y2=0.135
r27 1 21 6.54019 $w=2.09524e-08 $layer=Gate_1 $thickness=5.21905e-08 $X=0.405
+ $Y=0.135 $X2=0.405 $Y2=0.135
r28 1 26 12.6539 $w=1.77815e-08 $l=2.7e-08 $layer=LIG $thickness=4.8e-08
+ $X=0.405 $Y=0.135 $X2=0.432 $Y2=0.135
r29 23 22 16.4967 $w=2.1e-08 $l=4.85e-08 $layer=Gate_1 $thickness=5.6e-08
+ $X=0.405 $Y=0.2025 $X2=0.405 $Y2=0.154
r30 21 22 6.6497 $w=2.04211e-08 $l=1.9e-08 $layer=Gate_1 $thickness=5.6e-08
+ $X=0.405 $Y=0.135 $X2=0.405 $Y2=0.154
r31 20 21 6.6497 $w=2.04211e-08 $l=1.9e-08 $layer=Gate_1 $thickness=5.6e-08
+ $X=0.405 $Y=0.116 $X2=0.405 $Y2=0.135
r32 19 20 16.4967 $w=2.1e-08 $l=4.85e-08 $layer=Gate_1 $thickness=5.6e-08
+ $X=0.405 $Y=0.0675 $X2=0.405 $Y2=0.116
r33 19 9 14.6259 $w=2.1e-08 $l=4.3e-08 $layer=Gate_1 $thickness=5.6e-08
+ $X=0.405 $Y=0.0675 $X2=0.405 $Y2=0.0245
.ends

.subckt PM_CKINVDCx16_ASAP7_75t_R%7 vss 19 23 33 36 46 47 50 51 10 15 17 3 1 11
+ 13 9 4 18
c1 1 vss 0.00633087f $X=0.837 $Y=0.135
c2 3 vss 0.00721837f $X=0.756 $Y=0.2025
c3 4 vss 0.00716176f $X=0.864 $Y=0.2025
c4 9 vss 0.0821806f $X=0.837 $Y=0.0245
c5 10 vss 0.0823867f $X=0.891 $Y=0.135
c6 11 vss 0.00713508f $X=0.7415 $Y=0.2025
c7 12 vss 0.00662055f $X=0.8495 $Y=0.2025
c8 13 vss 0.000209025f $X=0.837 $Y=0.135
c9 14 vss 0.000355873f $X=0.837 $Y=0.171
c10 15 vss 0.00259974f $X=0.81 $Y=0.171
c11 16 vss 0.00014961f $X=0.837 $Y=0.153
c12 17 vss 0.000653431f $X=0.8505 $Y=0.135
c13 18 vss 0.00130261f $X=0.8505 $Y=0.171
r1 51 49 0.0308642 $w=8.1e-08 $l=2.5e-09 $layer=P_src_drn $thickness=1e-09
+ $X=0.8813 $Y=0.2025 $X2=0.8785 $Y2=0.2025
r2 4 49 0.179012 $w=8.1e-08 $l=1.45e-08 $layer=P_src_drn $thickness=1e-09
+ $X=0.864 $Y=0.2025 $X2=0.8785 $Y2=0.2025
r3 12 4 0.179012 $w=8.1e-08 $l=1.45e-08 $layer=P_src_drn $thickness=1e-09
+ $X=0.8495 $Y=0.2025 $X2=0.864 $Y2=0.2025
r4 50 12 0.0308642 $w=8.1e-08 $l=2.5e-09 $layer=P_src_drn $thickness=1e-09
+ $X=0.8466 $Y=0.2025 $X2=0.8495 $Y2=0.2025
r5 47 45 0.0308642 $w=8.1e-08 $l=2.5e-09 $layer=P_src_drn $thickness=1e-09
+ $X=0.7733 $Y=0.2025 $X2=0.7705 $Y2=0.2025
r6 3 45 0.179012 $w=8.1e-08 $l=1.45e-08 $layer=P_src_drn $thickness=1e-09
+ $X=0.756 $Y=0.2025 $X2=0.7705 $Y2=0.2025
r7 11 3 0.179012 $w=8.1e-08 $l=1.45e-08 $layer=P_src_drn $thickness=1e-09
+ $X=0.7415 $Y=0.2025 $X2=0.756 $Y2=0.2025
r8 46 11 0.0308642 $w=8.1e-08 $l=2.5e-09 $layer=P_src_drn $thickness=1e-09
+ $X=0.7386 $Y=0.2025 $X2=0.7415 $Y2=0.2025
r9 4 41 19.3796 $a=3.24e-16 $layer=V0LISD $X=0.864 $Y=0.2025 $X2=0.864 $Y2=0.171
r10 3 39 19.3796 $a=3.24e-16 $layer=V0LISD $X=0.756 $Y=0.2025 $X2=0.756
+ $Y2=0.171
r11 18 41 3.14806 $w=1.3e-08 $l=1.35e-08 $layer=M1 $thickness=3.6e-08 $X=0.8505
+ $Y=0.171 $X2=0.864 $Y2=0.171
r12 39 40 5.24677 $w=1.3e-08 $l=2.25e-08 $layer=M1 $thickness=3.6e-08 $X=0.756
+ $Y=0.171 $X2=0.7785 $Y2=0.171
r13 15 40 7.34548 $w=1.3e-08 $l=3.15e-08 $layer=M1 $thickness=3.6e-08 $X=0.81
+ $Y=0.171 $X2=0.7785 $Y2=0.171
r14 14 16 3.01711 $w=1.55e-08 $l=1.8e-08 $layer=M1 $thickness=3.6e-08 $X=0.837
+ $Y=0.171 $X2=0.837 $Y2=0.153
r15 14 15 5.11582 $w=1.46667e-08 $l=2.7e-08 $layer=M1 $thickness=3.6e-08
+ $X=0.837 $Y=0.171 $X2=0.81 $Y2=0.171
r16 14 18 1.96775 $w=1.63333e-08 $l=1.35e-08 $layer=M1 $thickness=3.6e-08
+ $X=0.837 $Y=0.171 $X2=0.8505 $Y2=0.171
r17 13 17 1.49895 $w=1.63333e-08 $l=1.35e-08 $layer=M1 $thickness=3.6e-08
+ $X=0.837 $Y=0.135 $X2=0.8505 $Y2=0.135
r18 13 16 2.5483 $w=1.79e-08 $l=1.8e-08 $layer=M1 $thickness=3.6e-08 $X=0.837
+ $Y=0.135 $X2=0.837 $Y2=0.153
r19 36 35 16.4967 $w=2.1e-08 $l=4.85e-08 $layer=Gate_1 $thickness=5.6e-08
+ $X=0.891 $Y=0.2025 $X2=0.891 $Y2=0.154
r20 33 34 16.4967 $w=2.1e-08 $l=4.85e-08 $layer=Gate_1 $thickness=5.6e-08
+ $X=0.891 $Y=0.0675 $X2=0.891 $Y2=0.116
r21 10 27 6.54019 $w=2.09524e-08 $layer=Gate_1 $thickness=5.21905e-08 $X=0.891
+ $Y=0.135 $X2=0.891 $Y2=0.135
r22 10 34 6.6497 $w=2.04211e-08 $l=1.9e-08 $layer=Gate_1 $thickness=5.6e-08
+ $X=0.891 $Y=0.135 $X2=0.891 $Y2=0.116
r23 10 35 6.6497 $w=2.04211e-08 $l=1.9e-08 $layer=Gate_1 $thickness=5.6e-08
+ $X=0.891 $Y=0.135 $X2=0.891 $Y2=0.154
r24 17 29 3.14806 $w=1.3e-08 $l=1.35e-08 $layer=M1 $thickness=3.6e-08 $X=0.8505
+ $Y=0.135 $X2=0.864 $Y2=0.135
r25 26 27 12.6539 $w=1.77815e-08 $l=2.7e-08 $layer=LIG $thickness=4.8e-08
+ $X=0.864 $Y=0.135 $X2=0.891 $Y2=0.135
r26 26 29 19.3796 $a=3.24e-16 $layer=V0LIG $X=0.864 $Y=0.135 $X2=0.864 $Y2=0.135
r27 1 21 6.54019 $w=2.09524e-08 $layer=Gate_1 $thickness=5.21905e-08 $X=0.837
+ $Y=0.135 $X2=0.837 $Y2=0.135
r28 1 26 12.6539 $w=1.77815e-08 $l=2.7e-08 $layer=LIG $thickness=4.8e-08
+ $X=0.837 $Y=0.135 $X2=0.864 $Y2=0.135
r29 23 22 16.4967 $w=2.1e-08 $l=4.85e-08 $layer=Gate_1 $thickness=5.6e-08
+ $X=0.837 $Y=0.2025 $X2=0.837 $Y2=0.154
r30 21 22 6.6497 $w=2.04211e-08 $l=1.9e-08 $layer=Gate_1 $thickness=5.6e-08
+ $X=0.837 $Y=0.135 $X2=0.837 $Y2=0.154
r31 20 21 6.6497 $w=2.04211e-08 $l=1.9e-08 $layer=Gate_1 $thickness=5.6e-08
+ $X=0.837 $Y=0.116 $X2=0.837 $Y2=0.135
r32 19 20 16.4967 $w=2.1e-08 $l=4.85e-08 $layer=Gate_1 $thickness=5.6e-08
+ $X=0.837 $Y=0.0675 $X2=0.837 $Y2=0.116
r33 19 9 14.6259 $w=2.1e-08 $l=4.3e-08 $layer=Gate_1 $thickness=5.6e-08
+ $X=0.837 $Y=0.0675 $X2=0.837 $Y2=0.0245
.ends

.subckt PM_CKINVDCx16_ASAP7_75t_R%5 vss 19 23 33 36 46 47 50 51 9 18 16 4 1 12
+ 13 10 3 15
c1 1 vss 0.0063317f $X=1.161 $Y=0.135
c2 3 vss 0.00716232f $X=1.188 $Y=0.2025
c3 4 vss 0.0072188f $X=1.296 $Y=0.2025
c4 9 vss 0.0823885f $X=1.161 $Y=0.0245
c5 10 vss 0.0821817f $X=1.215 $Y=0.135
c6 11 vss 0.00663289f $X=1.1735 $Y=0.2025
c7 12 vss 0.00714861f $X=1.2815 $Y=0.2025
c8 13 vss 0.000209119f $X=1.215 $Y=0.135
c9 14 vss 0.000355967f $X=1.215 $Y=0.171
c10 15 vss 0.0013044f $X=1.1725 $Y=0.171
c11 16 vss 0.000653135f $X=1.17 $Y=0.135
c12 17 vss 0.000149611f $X=1.215 $Y=0.153
c13 18 vss 0.00260235f $X=1.242 $Y=0.171
r1 51 49 0.0308642 $w=8.1e-08 $l=2.5e-09 $layer=P_src_drn $thickness=1e-09
+ $X=1.3133 $Y=0.2025 $X2=1.3105 $Y2=0.2025
r2 4 49 0.179012 $w=8.1e-08 $l=1.45e-08 $layer=P_src_drn $thickness=1e-09
+ $X=1.296 $Y=0.2025 $X2=1.3105 $Y2=0.2025
r3 12 4 0.179012 $w=8.1e-08 $l=1.45e-08 $layer=P_src_drn $thickness=1e-09
+ $X=1.2815 $Y=0.2025 $X2=1.296 $Y2=0.2025
r4 50 12 0.0308642 $w=8.1e-08 $l=2.5e-09 $layer=P_src_drn $thickness=1e-09
+ $X=1.2786 $Y=0.2025 $X2=1.2815 $Y2=0.2025
r5 47 45 0.0308642 $w=8.1e-08 $l=2.5e-09 $layer=P_src_drn $thickness=1e-09
+ $X=1.2053 $Y=0.2025 $X2=1.2025 $Y2=0.2025
r6 3 45 0.179012 $w=8.1e-08 $l=1.45e-08 $layer=P_src_drn $thickness=1e-09
+ $X=1.188 $Y=0.2025 $X2=1.2025 $Y2=0.2025
r7 11 3 0.179012 $w=8.1e-08 $l=1.45e-08 $layer=P_src_drn $thickness=1e-09
+ $X=1.1735 $Y=0.2025 $X2=1.188 $Y2=0.2025
r8 46 11 0.0308642 $w=8.1e-08 $l=2.5e-09 $layer=P_src_drn $thickness=1e-09
+ $X=1.1706 $Y=0.2025 $X2=1.1735 $Y2=0.2025
r9 4 42 19.3796 $a=3.24e-16 $layer=V0LISD $X=1.296 $Y=0.2025 $X2=1.296 $Y2=0.171
r10 3 38 19.3796 $a=3.24e-16 $layer=V0LISD $X=1.188 $Y=0.2025 $X2=1.188
+ $Y2=0.171
r11 41 42 5.24677 $w=1.3e-08 $l=2.25e-08 $layer=M1 $thickness=3.6e-08 $X=1.2735
+ $Y=0.171 $X2=1.296 $Y2=0.171
r12 18 41 7.34548 $w=1.3e-08 $l=3.15e-08 $layer=M1 $thickness=3.6e-08 $X=1.242
+ $Y=0.171 $X2=1.2735 $Y2=0.171
r13 38 39 3.14806 $w=1.3e-08 $l=1.35e-08 $layer=M1 $thickness=3.6e-08 $X=1.188
+ $Y=0.171 $X2=1.2015 $Y2=0.171
r14 15 38 3.61444 $w=1.3e-08 $l=1.55e-08 $layer=M1 $thickness=3.6e-08 $X=1.1725
+ $Y=0.171 $X2=1.188 $Y2=0.171
r15 14 17 3.01711 $w=1.55e-08 $l=1.8e-08 $layer=M1 $thickness=3.6e-08 $X=1.215
+ $Y=0.171 $X2=1.215 $Y2=0.153
r16 14 39 1.96775 $w=1.63333e-08 $l=1.35e-08 $layer=M1 $thickness=3.6e-08
+ $X=1.215 $Y=0.171 $X2=1.2015 $Y2=0.171
r17 14 18 5.11582 $w=1.46667e-08 $l=2.7e-08 $layer=M1 $thickness=3.6e-08
+ $X=1.215 $Y=0.171 $X2=1.242 $Y2=0.171
r18 13 31 1.49895 $w=1.63333e-08 $l=1.35e-08 $layer=M1 $thickness=3.6e-08
+ $X=1.215 $Y=0.135 $X2=1.2015 $Y2=0.135
r19 13 17 2.5483 $w=1.79e-08 $l=1.8e-08 $layer=M1 $thickness=3.6e-08 $X=1.215
+ $Y=0.135 $X2=1.215 $Y2=0.153
r20 36 35 16.4967 $w=2.1e-08 $l=4.85e-08 $layer=Gate_1 $thickness=5.6e-08
+ $X=1.215 $Y=0.2025 $X2=1.215 $Y2=0.154
r21 33 34 16.4967 $w=2.1e-08 $l=4.85e-08 $layer=Gate_1 $thickness=5.6e-08
+ $X=1.215 $Y=0.0675 $X2=1.215 $Y2=0.116
r22 10 27 6.54019 $w=2.09524e-08 $layer=Gate_1 $thickness=5.21905e-08 $X=1.215
+ $Y=0.135 $X2=1.215 $Y2=0.135
r23 10 34 6.6497 $w=2.04211e-08 $l=1.9e-08 $layer=Gate_1 $thickness=5.6e-08
+ $X=1.215 $Y=0.135 $X2=1.215 $Y2=0.116
r24 10 35 6.6497 $w=2.04211e-08 $l=1.9e-08 $layer=Gate_1 $thickness=5.6e-08
+ $X=1.215 $Y=0.135 $X2=1.215 $Y2=0.154
r25 30 31 3.14806 $w=1.3e-08 $l=1.35e-08 $layer=M1 $thickness=3.6e-08 $X=1.188
+ $Y=0.135 $X2=1.2015 $Y2=0.135
r26 29 30 2.68168 $w=1.3e-08 $l=1.15e-08 $layer=M1 $thickness=3.6e-08 $X=1.1765
+ $Y=0.135 $X2=1.188 $Y2=0.135
r27 16 29 1.51573 $w=1.3e-08 $l=6.5e-09 $layer=M1 $thickness=3.6e-08 $X=1.17
+ $Y=0.135 $X2=1.1765 $Y2=0.135
r28 26 27 12.6539 $w=1.77815e-08 $l=2.7e-08 $layer=LIG $thickness=4.8e-08
+ $X=1.188 $Y=0.135 $X2=1.215 $Y2=0.135
r29 26 30 19.3796 $a=3.24e-16 $layer=V0LIG $X=1.188 $Y=0.135 $X2=1.188 $Y2=0.135
r30 1 21 6.54019 $w=2.09524e-08 $layer=Gate_1 $thickness=5.21905e-08 $X=1.161
+ $Y=0.135 $X2=1.161 $Y2=0.135
r31 1 26 12.6539 $w=1.77815e-08 $l=2.7e-08 $layer=LIG $thickness=4.8e-08
+ $X=1.161 $Y=0.135 $X2=1.188 $Y2=0.135
r32 23 22 16.4967 $w=2.1e-08 $l=4.85e-08 $layer=Gate_1 $thickness=5.6e-08
+ $X=1.161 $Y=0.2025 $X2=1.161 $Y2=0.154
r33 21 22 6.6497 $w=2.04211e-08 $l=1.9e-08 $layer=Gate_1 $thickness=5.6e-08
+ $X=1.161 $Y=0.135 $X2=1.161 $Y2=0.154
r34 20 21 6.6497 $w=2.04211e-08 $l=1.9e-08 $layer=Gate_1 $thickness=5.6e-08
+ $X=1.161 $Y=0.116 $X2=1.161 $Y2=0.135
r35 19 20 16.4967 $w=2.1e-08 $l=4.85e-08 $layer=Gate_1 $thickness=5.6e-08
+ $X=1.161 $Y=0.0675 $X2=1.161 $Y2=0.116
r36 19 9 14.6259 $w=2.1e-08 $l=4.3e-08 $layer=Gate_1 $thickness=5.6e-08
+ $X=1.161 $Y=0.0675 $X2=1.161 $Y2=0.0245
.ends

.subckt PM_CKINVDCx16_ASAP7_75t_R%4 vss 19 23 33 36 46 47 50 51 15 1 4 3 17 10
+ 11 18 14 9
c1 1 vss 0.00633157f $X=1.269 $Y=0.135
c2 3 vss 0.00721254f $X=1.188 $Y=0.0675
c3 4 vss 0.00715402f $X=1.296 $Y=0.0675
c4 9 vss 0.0821645f $X=1.269 $Y=0.0245
c5 10 vss 0.0823626f $X=1.323 $Y=0.135
c6 11 vss 0.00694198f $X=1.1735 $Y=0.0675
c7 12 vss 0.00643989f $X=1.2815 $Y=0.0675
c8 13 vss 0.000348985f $X=1.269 $Y=0.099
c9 14 vss 0.000207731f $X=1.269 $Y=0.135
c10 15 vss 0.00250107f $X=1.242 $Y=0.099
c11 16 vss 0.000149606f $X=1.269 $Y=0.117
c12 17 vss 0.0012954f $X=1.2825 $Y=0.099
c13 18 vss 0.000607481f $X=1.2825 $Y=0.135
r1 51 49 0.0308642 $w=8.1e-08 $l=2.5e-09 $layer=N_src_drn $thickness=1e-09
+ $X=1.3133 $Y=0.0675 $X2=1.3105 $Y2=0.0675
r2 4 49 0.179012 $w=8.1e-08 $l=1.45e-08 $layer=N_src_drn $thickness=1e-09
+ $X=1.296 $Y=0.0675 $X2=1.3105 $Y2=0.0675
r3 12 4 0.179012 $w=8.1e-08 $l=1.45e-08 $layer=N_src_drn $thickness=1e-09
+ $X=1.2815 $Y=0.0675 $X2=1.296 $Y2=0.0675
r4 50 12 0.0308642 $w=8.1e-08 $l=2.5e-09 $layer=N_src_drn $thickness=1e-09
+ $X=1.2786 $Y=0.0675 $X2=1.2815 $Y2=0.0675
r5 47 45 0.0308642 $w=8.1e-08 $l=2.5e-09 $layer=N_src_drn $thickness=1e-09
+ $X=1.2053 $Y=0.0675 $X2=1.2025 $Y2=0.0675
r6 3 45 0.179012 $w=8.1e-08 $l=1.45e-08 $layer=N_src_drn $thickness=1e-09
+ $X=1.188 $Y=0.0675 $X2=1.2025 $Y2=0.0675
r7 11 3 0.179012 $w=8.1e-08 $l=1.45e-08 $layer=N_src_drn $thickness=1e-09
+ $X=1.1735 $Y=0.0675 $X2=1.188 $Y2=0.0675
r8 46 11 0.0308642 $w=8.1e-08 $l=2.5e-09 $layer=N_src_drn $thickness=1e-09
+ $X=1.1706 $Y=0.0675 $X2=1.1735 $Y2=0.0675
r9 4 41 19.3796 $a=3.24e-16 $layer=V0LISD $X=1.296 $Y=0.0675 $X2=1.296 $Y2=0.099
r10 3 39 19.3796 $a=3.24e-16 $layer=V0LISD $X=1.188 $Y=0.0675 $X2=1.188
+ $Y2=0.099
r11 17 41 3.14806 $w=1.3e-08 $l=1.35e-08 $layer=M1 $thickness=3.6e-08 $X=1.2825
+ $Y=0.099 $X2=1.296 $Y2=0.099
r12 39 40 5.24677 $w=1.3e-08 $l=2.25e-08 $layer=M1 $thickness=3.6e-08 $X=1.188
+ $Y=0.099 $X2=1.2105 $Y2=0.099
r13 15 40 7.34548 $w=1.3e-08 $l=3.15e-08 $layer=M1 $thickness=3.6e-08 $X=1.242
+ $Y=0.099 $X2=1.2105 $Y2=0.099
r14 13 16 3.01711 $w=1.55e-08 $l=1.8e-08 $layer=M1 $thickness=3.6e-08 $X=1.269
+ $Y=0.099 $X2=1.269 $Y2=0.117
r15 13 15 5.11582 $w=1.46667e-08 $l=2.7e-08 $layer=M1 $thickness=3.6e-08
+ $X=1.269 $Y=0.099 $X2=1.242 $Y2=0.099
r16 13 17 1.96775 $w=1.63333e-08 $l=1.35e-08 $layer=M1 $thickness=3.6e-08
+ $X=1.269 $Y=0.099 $X2=1.2825 $Y2=0.099
r17 14 18 1.49895 $w=1.63333e-08 $l=1.35e-08 $layer=M1 $thickness=3.6e-08
+ $X=1.269 $Y=0.135 $X2=1.2825 $Y2=0.135
r18 14 16 2.5483 $w=1.79e-08 $l=1.8e-08 $layer=M1 $thickness=3.6e-08 $X=1.269
+ $Y=0.135 $X2=1.269 $Y2=0.117
r19 36 35 16.4967 $w=2.1e-08 $l=4.85e-08 $layer=Gate_1 $thickness=5.6e-08
+ $X=1.323 $Y=0.2025 $X2=1.323 $Y2=0.154
r20 33 34 16.4967 $w=2.1e-08 $l=4.85e-08 $layer=Gate_1 $thickness=5.6e-08
+ $X=1.323 $Y=0.0675 $X2=1.323 $Y2=0.116
r21 10 27 6.54019 $w=2.09524e-08 $layer=Gate_1 $thickness=5.21905e-08 $X=1.323
+ $Y=0.135 $X2=1.323 $Y2=0.135
r22 10 34 6.6497 $w=2.04211e-08 $l=1.9e-08 $layer=Gate_1 $thickness=5.6e-08
+ $X=1.323 $Y=0.135 $X2=1.323 $Y2=0.116
r23 10 35 6.6497 $w=2.04211e-08 $l=1.9e-08 $layer=Gate_1 $thickness=5.6e-08
+ $X=1.323 $Y=0.135 $X2=1.323 $Y2=0.154
r24 18 29 3.14806 $w=1.3e-08 $l=1.35e-08 $layer=M1 $thickness=3.6e-08 $X=1.2825
+ $Y=0.135 $X2=1.296 $Y2=0.135
r25 26 27 12.6539 $w=1.77815e-08 $l=2.7e-08 $layer=LIG $thickness=4.8e-08
+ $X=1.296 $Y=0.135 $X2=1.323 $Y2=0.135
r26 26 29 19.3796 $a=3.24e-16 $layer=V0LIG $X=1.296 $Y=0.135 $X2=1.296 $Y2=0.135
r27 1 21 6.54019 $w=2.09524e-08 $layer=Gate_1 $thickness=5.21905e-08 $X=1.269
+ $Y=0.135 $X2=1.269 $Y2=0.135
r28 1 26 12.6539 $w=1.77815e-08 $l=2.7e-08 $layer=LIG $thickness=4.8e-08
+ $X=1.269 $Y=0.135 $X2=1.296 $Y2=0.135
r29 23 22 16.4967 $w=2.1e-08 $l=4.85e-08 $layer=Gate_1 $thickness=5.6e-08
+ $X=1.269 $Y=0.2025 $X2=1.269 $Y2=0.154
r30 21 22 6.6497 $w=2.04211e-08 $l=1.9e-08 $layer=Gate_1 $thickness=5.6e-08
+ $X=1.269 $Y=0.135 $X2=1.269 $Y2=0.154
r31 20 21 6.6497 $w=2.04211e-08 $l=1.9e-08 $layer=Gate_1 $thickness=5.6e-08
+ $X=1.269 $Y=0.116 $X2=1.269 $Y2=0.135
r32 19 20 16.4967 $w=2.1e-08 $l=4.85e-08 $layer=Gate_1 $thickness=5.6e-08
+ $X=1.269 $Y=0.0675 $X2=1.269 $Y2=0.116
r33 19 9 14.6259 $w=2.1e-08 $l=4.3e-08 $layer=Gate_1 $thickness=5.6e-08
+ $X=1.269 $Y=0.0675 $X2=1.269 $Y2=0.0245
.ends

.subckt PM_CKINVDCx16_ASAP7_75t_R%A vss 95 49 55 71 74 82 85 88 91 144 147 150
+ 153 156 159 162 165 191 194 197 200 203 206 209 212 231 234 237 240 243 246
+ 250 254 37 1 38 16 40 2 17 41 20 44 3 21 4 24 25 45 39 43 46 29 35 42 31 33
+ 48 32 34 14 18 28 30 36 47 15 19 22 26 23 13 27
c1 1 vss 0.0286879f $X=0.081 $Y=0.135
c2 2 vss 0.0267381f $X=0.535 $Y=0.135
c3 3 vss 0.0268702f $X=0.9675 $Y=0.135
c4 4 vss 0.0285755f $X=1.3995 $Y=0.135
c5 13 vss 0.0848526f $X=0.081 $Y=0.0245
c6 14 vss 0.0847805f $X=0.135 $Y=0.135
c7 15 vss 0.0847601f $X=0.189 $Y=0.135
c8 16 vss 0.0847177f $X=0.243 $Y=0.135
c9 17 vss 0.0846294f $X=0.513 $Y=0.135
c10 18 vss 0.0850405f $X=0.567 $Y=0.135
c11 19 vss 0.0850342f $X=0.621 $Y=0.135
c12 20 vss 0.0847177f $X=0.675 $Y=0.135
c13 21 vss 0.0847177f $X=0.945 $Y=0.135
c14 22 vss 0.0850342f $X=0.999 $Y=0.135
c15 23 vss 0.0850342f $X=1.053 $Y=0.135
c16 24 vss 0.0847177f $X=1.107 $Y=0.135
c17 25 vss 0.0847177f $X=1.377 $Y=0.135
c18 26 vss 0.0847398f $X=1.431 $Y=0.135
c19 27 vss 0.0847894f $X=1.485 $Y=0.135
c20 28 vss 0.0848544f $X=1.539 $Y=0.135
c21 29 vss 0.00561264f $X=0.135 $Y=0.135
c22 30 vss 0.0075078f $X=0.167 $Y=0.036
c23 31 vss 0.00663554f $X=0.593 $Y=0.036
c24 32 vss 0.00457166f $X=0.593 $Y=0.135
c25 33 vss 0.00663605f $X=1.026 $Y=0.036
c26 34 vss 0.00456691f $X=1.026 $Y=0.135
c27 35 vss 0.00504387f $X=1.453 $Y=0.135
c28 36 vss 0.0075078f $X=1.453 $Y=0.036
c29 37 vss 0.00684286f $X=0.167 $Y=0.1035
c30 38 vss 0.0410388f $X=0.189 $Y=0.036
c31 39 vss 0.00502983f $X=0.5595 $Y=0.135
c32 40 vss 0.0065277f $X=0.593 $Y=0.054
c33 41 vss 0.0419703f $X=0.618 $Y=0.036
c34 42 vss 0.00504094f $X=0.6115 $Y=0.135
c35 43 vss 0.00504666f $X=0.992 $Y=0.135
c36 44 vss 0.00638765f $X=1.026 $Y=0.054
c37 45 vss 0.0411317f $X=1.0505 $Y=0.036
c38 46 vss 0.00504666f $X=1.0445 $Y=0.135
c39 47 vss 0.00694268f $X=1.453 $Y=0.054
c40 48 vss 0.00508443f $X=1.4745 $Y=0.135
r1 254 253 14.6259 $w=2.1e-08 $l=4.3e-08 $layer=Gate_1 $thickness=5.6e-08
+ $X=1.539 $Y=0.2025 $X2=1.539 $Y2=0.1595
r2 252 253 2.89117 $w=2.1e-08 $l=8.5e-09 $layer=Gate_1 $thickness=5.6e-08
+ $X=1.539 $Y=0.151 $X2=1.539 $Y2=0.1595
r3 250 251 14.6259 $w=2.1e-08 $l=4.3e-08 $layer=Gate_1 $thickness=5.6e-08
+ $X=1.539 $Y=0.0675 $X2=1.539 $Y2=0.1105
r4 248 251 2.89117 $w=2.1e-08 $l=8.5e-09 $layer=Gate_1 $thickness=5.6e-08
+ $X=1.539 $Y=0.119 $X2=1.539 $Y2=0.1105
r5 28 228 6.74717 $w=2e-08 $layer=Gate_1 $thickness=5.2e-08 $X=1.539 $Y=0.135
+ $X2=1.539 $Y2=0.135
r6 28 248 5.61228 $w=2.0375e-08 $l=1.6e-08 $layer=Gate_1 $thickness=5.6e-08
+ $X=1.539 $Y=0.135 $X2=1.539 $Y2=0.119
r7 28 252 5.61228 $w=2.0375e-08 $l=1.6e-08 $layer=Gate_1 $thickness=5.6e-08
+ $X=1.539 $Y=0.135 $X2=1.539 $Y2=0.151
r8 246 245 16.6668 $w=2.1e-08 $l=4.9e-08 $layer=Gate_1 $thickness=5.6e-08
+ $X=1.485 $Y=0.2025 $X2=1.485 $Y2=0.1535
r9 243 244 16.6668 $w=2.1e-08 $l=4.9e-08 $layer=Gate_1 $thickness=5.6e-08
+ $X=1.485 $Y=0.0675 $X2=1.485 $Y2=0.1165
r10 27 225 3.57145 $w=2e-08 $layer=Gate_1 $thickness=5.6e-08 $X=1.485 $Y=0.135
+ $X2=1.485 $Y2=0.135
r11 27 244 6.46262 $w=2.04595e-08 $l=1.85e-08 $layer=Gate_1 $thickness=5.6e-08
+ $X=1.485 $Y=0.135 $X2=1.485 $Y2=0.1165
r12 27 245 6.46262 $w=2.04595e-08 $l=1.85e-08 $layer=Gate_1 $thickness=5.6e-08
+ $X=1.485 $Y=0.135 $X2=1.485 $Y2=0.1535
r13 240 239 16.6668 $w=2.1e-08 $l=4.9e-08 $layer=Gate_1 $thickness=5.6e-08
+ $X=1.431 $Y=0.2025 $X2=1.431 $Y2=0.1535
r14 237 238 16.6668 $w=2.1e-08 $l=4.9e-08 $layer=Gate_1 $thickness=5.6e-08
+ $X=1.431 $Y=0.0675 $X2=1.431 $Y2=0.1165
r15 26 221 3.57145 $w=2e-08 $layer=Gate_1 $thickness=5.6e-08 $X=1.431 $Y=0.135
+ $X2=1.431 $Y2=0.135
r16 26 238 6.46262 $w=2.04595e-08 $l=1.85e-08 $layer=Gate_1 $thickness=5.6e-08
+ $X=1.431 $Y=0.135 $X2=1.431 $Y2=0.1165
r17 26 239 6.46262 $w=2.04595e-08 $l=1.85e-08 $layer=Gate_1 $thickness=5.6e-08
+ $X=1.431 $Y=0.135 $X2=1.431 $Y2=0.1535
r18 234 233 16.6668 $w=2.1e-08 $l=4.9e-08 $layer=Gate_1 $thickness=5.6e-08
+ $X=1.377 $Y=0.2025 $X2=1.377 $Y2=0.1535
r19 231 232 16.6668 $w=2.1e-08 $l=4.9e-08 $layer=Gate_1 $thickness=5.6e-08
+ $X=1.377 $Y=0.0675 $X2=1.377 $Y2=0.1165
r20 25 217 6.74717 $w=2e-08 $layer=Gate_1 $thickness=5.2e-08 $X=1.377 $Y=0.135
+ $X2=1.377 $Y2=0.135
r21 25 232 6.46262 $w=2.04595e-08 $l=1.85e-08 $layer=Gate_1 $thickness=5.6e-08
+ $X=1.377 $Y=0.135 $X2=1.377 $Y2=0.1165
r22 25 233 6.46262 $w=2.04595e-08 $l=1.85e-08 $layer=Gate_1 $thickness=5.6e-08
+ $X=1.377 $Y=0.135 $X2=1.377 $Y2=0.1535
r23 227 228 15.1321 $w=1.63455e-08 $l=2.2e-08 $layer=LIG $thickness=4.8e-08
+ $X=1.517 $Y=0.135 $X2=1.539 $Y2=0.135
r24 226 227 16.9382 $w=1.33e-08 $l=1.7e-08 $layer=LIG $thickness=4.8e-08 $X=1.5
+ $Y=0.135 $X2=1.517 $Y2=0.135
r25 224 226 6.25213 $w=1.62778e-08 $l=9e-09 $layer=LIG $thickness=4.8e-08
+ $X=1.491 $Y=0.135 $X2=1.5 $Y2=0.135
r26 223 224 3.17572 $w=2e-08 $l=1e-08 $layer=LIG $thickness=4.8e-08 $X=1.481
+ $Y=0.135 $X2=1.491 $Y2=0.135
r27 223 225 1.90543 $w=2e-08 $l=4e-09 $layer=LIG $thickness=4.8e-08 $X=1.481
+ $Y=0.135 $X2=1.485 $Y2=0.135
r28 222 223 18.8437 $w=1.50478e-08 $l=2.3e-08 $layer=LIG $thickness=4.8e-08
+ $X=1.458 $Y=0.135 $X2=1.481 $Y2=0.135
r29 220 221 1.74665 $w=2e-08 $l=4.5e-09 $layer=LIG $thickness=4.8e-08 $X=1.4355
+ $Y=0.135 $X2=1.431 $Y2=0.135
r30 220 222 18.6849 $w=1.49378e-08 $l=2.25e-08 $layer=LIG $thickness=4.8e-08
+ $X=1.4355 $Y=0.135 $X2=1.458 $Y2=0.135
r31 219 220 3.17572 $w=2e-08 $l=1e-08 $layer=LIG $thickness=4.8e-08 $X=1.4255
+ $Y=0.135 $X2=1.4355 $Y2=0.135
r32 216 219 5.91273 $w=1.665e-08 $l=9e-09 $layer=LIG $thickness=4.8e-08
+ $X=1.4165 $Y=0.135 $X2=1.4255 $Y2=0.135
r33 4 216 16.9382 $w=1.33e-08 $l=1.7e-08 $layer=LIG $thickness=4.8e-08
+ $X=1.3995 $Y=0.135 $X2=1.4165 $Y2=0.135
r34 4 217 15.6303 $w=1.62778e-08 $l=2.25e-08 $layer=LIG $thickness=4.8e-08
+ $X=1.3995 $Y=0.135 $X2=1.377 $Y2=0.135
r35 214 226 19.3796 $a=3.24e-16 $layer=V0LIG $X=1.4925 $Y=0.135 $X2=1.5
+ $Y2=0.135
r36 48 214 4.19742 $w=1.3e-08 $l=1.8e-08 $layer=M1 $thickness=3.6e-08 $X=1.4745
+ $Y=0.135 $X2=1.4925 $Y2=0.135
r37 212 211 16.6668 $w=2.1e-08 $l=4.9e-08 $layer=Gate_1 $thickness=5.6e-08
+ $X=1.107 $Y=0.2025 $X2=1.107 $Y2=0.1535
r38 209 210 16.6668 $w=2.1e-08 $l=4.9e-08 $layer=Gate_1 $thickness=5.6e-08
+ $X=1.107 $Y=0.0675 $X2=1.107 $Y2=0.1165
r39 24 185 6.74717 $w=2e-08 $layer=Gate_1 $thickness=5.2e-08 $X=1.107 $Y=0.135
+ $X2=1.107 $Y2=0.135
r40 24 210 6.46262 $w=2.04595e-08 $l=1.85e-08 $layer=Gate_1 $thickness=5.6e-08
+ $X=1.107 $Y=0.135 $X2=1.107 $Y2=0.1165
r41 24 211 6.46262 $w=2.04595e-08 $l=1.85e-08 $layer=Gate_1 $thickness=5.6e-08
+ $X=1.107 $Y=0.135 $X2=1.107 $Y2=0.1535
r42 206 205 16.6668 $w=2.1e-08 $l=4.9e-08 $layer=Gate_1 $thickness=5.6e-08
+ $X=1.053 $Y=0.2025 $X2=1.053 $Y2=0.1535
r43 203 204 16.6668 $w=2.1e-08 $l=4.9e-08 $layer=Gate_1 $thickness=5.6e-08
+ $X=1.053 $Y=0.0675 $X2=1.053 $Y2=0.1165
r44 23 182 3.57145 $w=2e-08 $layer=Gate_1 $thickness=5.6e-08 $X=1.053 $Y=0.135
+ $X2=1.053 $Y2=0.135
r45 23 204 6.46262 $w=2.04595e-08 $l=1.85e-08 $layer=Gate_1 $thickness=5.6e-08
+ $X=1.053 $Y=0.135 $X2=1.053 $Y2=0.1165
r46 23 205 6.46262 $w=2.04595e-08 $l=1.85e-08 $layer=Gate_1 $thickness=5.6e-08
+ $X=1.053 $Y=0.135 $X2=1.053 $Y2=0.1535
r47 200 199 16.6668 $w=2.1e-08 $l=4.9e-08 $layer=Gate_1 $thickness=5.6e-08
+ $X=0.999 $Y=0.2025 $X2=0.999 $Y2=0.1535
r48 197 198 16.6668 $w=2.1e-08 $l=4.9e-08 $layer=Gate_1 $thickness=5.6e-08
+ $X=0.999 $Y=0.0675 $X2=0.999 $Y2=0.1165
r49 22 178 3.57145 $w=2e-08 $layer=Gate_1 $thickness=5.6e-08 $X=0.999 $Y=0.135
+ $X2=0.999 $Y2=0.135
r50 22 198 6.46262 $w=2.04595e-08 $l=1.85e-08 $layer=Gate_1 $thickness=5.6e-08
+ $X=0.999 $Y=0.135 $X2=0.999 $Y2=0.1165
r51 22 199 6.46262 $w=2.04595e-08 $l=1.85e-08 $layer=Gate_1 $thickness=5.6e-08
+ $X=0.999 $Y=0.135 $X2=0.999 $Y2=0.1535
r52 194 193 16.6668 $w=2.1e-08 $l=4.9e-08 $layer=Gate_1 $thickness=5.6e-08
+ $X=0.945 $Y=0.2025 $X2=0.945 $Y2=0.1535
r53 191 192 16.6668 $w=2.1e-08 $l=4.9e-08 $layer=Gate_1 $thickness=5.6e-08
+ $X=0.945 $Y=0.0675 $X2=0.945 $Y2=0.1165
r54 21 174 6.74717 $w=2e-08 $layer=Gate_1 $thickness=5.2e-08 $X=0.945 $Y=0.135
+ $X2=0.945 $Y2=0.135
r55 21 192 6.46262 $w=2.04595e-08 $l=1.85e-08 $layer=Gate_1 $thickness=5.6e-08
+ $X=0.945 $Y=0.135 $X2=0.945 $Y2=0.1165
r56 21 193 6.46262 $w=2.04595e-08 $l=1.85e-08 $layer=Gate_1 $thickness=5.6e-08
+ $X=0.945 $Y=0.135 $X2=0.945 $Y2=0.1535
r57 187 188 3.03147 $w=1.3e-08 $l=1.3e-08 $layer=M1 $thickness=3.6e-08 $X=1.424
+ $Y=0.135 $X2=1.437 $Y2=0.135
r58 187 216 19.3796 $a=3.24e-16 $layer=V0LIG $X=1.424 $Y=0.135 $X2=1.4165
+ $Y2=0.135
r59 35 172 6.16517 $w=1.44286e-08 $l=3.15e-08 $layer=M1 $thickness=3.6e-08
+ $X=1.453 $Y=0.135 $X2=1.453 $Y2=0.1035
r60 35 188 2.55073 $w=1.58125e-08 $l=1.6e-08 $layer=M1 $thickness=3.6e-08
+ $X=1.453 $Y=0.135 $X2=1.437 $Y2=0.135
r61 35 48 3.83327 $w=1.5093e-08 $l=2.15e-08 $layer=M1 $thickness=3.6e-08
+ $X=1.453 $Y=0.135 $X2=1.4745 $Y2=0.135
r62 184 185 15.6303 $w=1.62778e-08 $l=2.25e-08 $layer=LIG $thickness=4.8e-08
+ $X=1.0845 $Y=0.135 $X2=1.107 $Y2=0.135
r63 183 184 16.9382 $w=1.33e-08 $l=1.7e-08 $layer=LIG $thickness=4.8e-08
+ $X=1.0675 $Y=0.135 $X2=1.0845 $Y2=0.135
r64 181 183 5.91273 $w=1.665e-08 $l=9e-09 $layer=LIG $thickness=4.8e-08
+ $X=1.0585 $Y=0.135 $X2=1.0675 $Y2=0.135
r65 180 181 3.17572 $w=2e-08 $l=1e-08 $layer=LIG $thickness=4.8e-08 $X=1.0485
+ $Y=0.135 $X2=1.0585 $Y2=0.135
r66 180 182 1.74665 $w=2e-08 $l=4.5e-09 $layer=LIG $thickness=4.8e-08 $X=1.0485
+ $Y=0.135 $X2=1.053 $Y2=0.135
r67 179 180 18.6849 $w=1.49378e-08 $l=2.25e-08 $layer=LIG $thickness=4.8e-08
+ $X=1.026 $Y=0.135 $X2=1.0485 $Y2=0.135
r68 177 178 1.74665 $w=2e-08 $l=4.5e-09 $layer=LIG $thickness=4.8e-08 $X=1.0035
+ $Y=0.135 $X2=0.999 $Y2=0.135
r69 177 179 18.6849 $w=1.49378e-08 $l=2.25e-08 $layer=LIG $thickness=4.8e-08
+ $X=1.0035 $Y=0.135 $X2=1.026 $Y2=0.135
r70 176 177 3.17572 $w=2e-08 $l=1e-08 $layer=LIG $thickness=4.8e-08 $X=0.9935
+ $Y=0.135 $X2=1.0035 $Y2=0.135
r71 173 176 5.91273 $w=1.665e-08 $l=9e-09 $layer=LIG $thickness=4.8e-08
+ $X=0.9845 $Y=0.135 $X2=0.9935 $Y2=0.135
r72 3 173 16.9382 $w=1.33e-08 $l=1.7e-08 $layer=LIG $thickness=4.8e-08
+ $X=0.9675 $Y=0.135 $X2=0.9845 $Y2=0.135
r73 3 174 15.6303 $w=1.62778e-08 $l=2.25e-08 $layer=LIG $thickness=4.8e-08
+ $X=0.9675 $Y=0.135 $X2=0.945 $Y2=0.135
r74 171 172 7.34548 $w=1.3e-08 $l=3.15e-08 $layer=M1 $thickness=3.6e-08
+ $X=1.453 $Y=0.072 $X2=1.453 $Y2=0.1035
r75 47 171 4.19742 $w=1.3e-08 $l=1.8e-08 $layer=M1 $thickness=3.6e-08 $X=1.453
+ $Y=0.054 $X2=1.453 $Y2=0.072
r76 169 181 19.3796 $a=3.24e-16 $layer=V0LIG $X=1.06 $Y=0.135 $X2=1.0585
+ $Y2=0.135
r77 46 169 3.61444 $w=1.3e-08 $l=1.55e-08 $layer=M1 $thickness=3.6e-08
+ $X=1.0445 $Y=0.135 $X2=1.06 $Y2=0.135
r78 43 167 3.61444 $w=1.3e-08 $l=1.55e-08 $layer=M1 $thickness=3.6e-08 $X=0.992
+ $Y=0.135 $X2=1.0075 $Y2=0.135
r79 43 173 19.3796 $a=3.24e-16 $layer=V0LIG $X=0.992 $Y=0.135 $X2=0.9845
+ $Y2=0.135
r80 165 164 16.6668 $w=2.1e-08 $l=4.9e-08 $layer=Gate_1 $thickness=5.6e-08
+ $X=0.675 $Y=0.2025 $X2=0.675 $Y2=0.1535
r81 162 163 16.6668 $w=2.1e-08 $l=4.9e-08 $layer=Gate_1 $thickness=5.6e-08
+ $X=0.675 $Y=0.0675 $X2=0.675 $Y2=0.1165
r82 20 141 6.74717 $w=2e-08 $layer=Gate_1 $thickness=5.2e-08 $X=0.675 $Y=0.135
+ $X2=0.675 $Y2=0.135
r83 20 163 6.46262 $w=2.04595e-08 $l=1.85e-08 $layer=Gate_1 $thickness=5.6e-08
+ $X=0.675 $Y=0.135 $X2=0.675 $Y2=0.1165
r84 20 164 6.46262 $w=2.04595e-08 $l=1.85e-08 $layer=Gate_1 $thickness=5.6e-08
+ $X=0.675 $Y=0.135 $X2=0.675 $Y2=0.1535
r85 159 158 16.6668 $w=2.1e-08 $l=4.9e-08 $layer=Gate_1 $thickness=5.6e-08
+ $X=0.621 $Y=0.2025 $X2=0.621 $Y2=0.1535
r86 156 157 16.6668 $w=2.1e-08 $l=4.9e-08 $layer=Gate_1 $thickness=5.6e-08
+ $X=0.621 $Y=0.0675 $X2=0.621 $Y2=0.1165
r87 19 138 3.57145 $w=2e-08 $layer=Gate_1 $thickness=5.6e-08 $X=0.621 $Y=0.135
+ $X2=0.621 $Y2=0.135
r88 19 157 6.46262 $w=2.04595e-08 $l=1.85e-08 $layer=Gate_1 $thickness=5.6e-08
+ $X=0.621 $Y=0.135 $X2=0.621 $Y2=0.1165
r89 19 158 6.46262 $w=2.04595e-08 $l=1.85e-08 $layer=Gate_1 $thickness=5.6e-08
+ $X=0.621 $Y=0.135 $X2=0.621 $Y2=0.1535
r90 153 152 16.6668 $w=2.1e-08 $l=4.9e-08 $layer=Gate_1 $thickness=5.6e-08
+ $X=0.567 $Y=0.2025 $X2=0.567 $Y2=0.1535
r91 150 151 16.6668 $w=2.1e-08 $l=4.9e-08 $layer=Gate_1 $thickness=5.6e-08
+ $X=0.567 $Y=0.0675 $X2=0.567 $Y2=0.1165
r92 18 134 3.57145 $w=2e-08 $layer=Gate_1 $thickness=5.6e-08 $X=0.567 $Y=0.135
+ $X2=0.567 $Y2=0.135
r93 18 151 6.46262 $w=2.04595e-08 $l=1.85e-08 $layer=Gate_1 $thickness=5.6e-08
+ $X=0.567 $Y=0.135 $X2=0.567 $Y2=0.1165
r94 18 152 6.46262 $w=2.04595e-08 $l=1.85e-08 $layer=Gate_1 $thickness=5.6e-08
+ $X=0.567 $Y=0.135 $X2=0.567 $Y2=0.1535
r95 147 146 16.6668 $w=2.1e-08 $l=4.9e-08 $layer=Gate_1 $thickness=5.6e-08
+ $X=0.513 $Y=0.2025 $X2=0.513 $Y2=0.1535
r96 144 145 16.6668 $w=2.1e-08 $l=4.9e-08 $layer=Gate_1 $thickness=5.6e-08
+ $X=0.513 $Y=0.0675 $X2=0.513 $Y2=0.1165
r97 17 130 6.74717 $w=2e-08 $layer=Gate_1 $thickness=5.2e-08 $X=0.513 $Y=0.135
+ $X2=0.513 $Y2=0.135
r98 17 145 6.46262 $w=2.04595e-08 $l=1.85e-08 $layer=Gate_1 $thickness=5.6e-08
+ $X=0.513 $Y=0.135 $X2=0.513 $Y2=0.1165
r99 17 146 6.46262 $w=2.04595e-08 $l=1.85e-08 $layer=Gate_1 $thickness=5.6e-08
+ $X=0.513 $Y=0.135 $X2=0.513 $Y2=0.1535
r100 36 128 3.48106 $w=1.50455e-08 $l=2.2e-08 $layer=M1 $thickness=3.6e-08
+ $X=1.453 $Y=0.036 $X2=1.431 $Y2=0.036
r101 36 47 2.5483 $w=1.79e-08 $l=1.8e-08 $layer=M1 $thickness=3.6e-08 $X=1.453
+ $Y=0.036 $X2=1.453 $Y2=0.054
r102 34 120 6.16517 $w=1.44286e-08 $l=3.15e-08 $layer=M1 $thickness=3.6e-08
+ $X=1.026 $Y=0.135 $X2=1.026 $Y2=0.1035
r103 34 167 3.1337 $w=1.54324e-08 $l=1.85e-08 $layer=M1 $thickness=3.6e-08
+ $X=1.026 $Y=0.135 $X2=1.0075 $Y2=0.135
r104 34 46 3.1337 $w=1.54324e-08 $l=1.85e-08 $layer=M1 $thickness=3.6e-08
+ $X=1.026 $Y=0.135 $X2=1.0445 $Y2=0.135
r105 140 141 16.1285 $w=1.6213e-08 $l=2.3e-08 $layer=LIG $thickness=4.8e-08
+ $X=0.652 $Y=0.135 $X2=0.675 $Y2=0.135
r106 139 140 16.9382 $w=1.33e-08 $l=1.7e-08 $layer=LIG $thickness=4.8e-08
+ $X=0.635 $Y=0.135 $X2=0.652 $Y2=0.135
r107 137 138 1.58786 $w=2e-08 $l=5e-09 $layer=LIG $thickness=4.8e-08 $X=0.626
+ $Y=0.135 $X2=0.621 $Y2=0.135
r108 137 139 5.57333 $w=1.70222e-08 $l=9e-09 $layer=LIG $thickness=4.8e-08
+ $X=0.626 $Y=0.135 $X2=0.635 $Y2=0.135
r109 136 137 3.17572 $w=2e-08 $l=1e-08 $layer=LIG $thickness=4.8e-08 $X=0.616
+ $Y=0.135 $X2=0.626 $Y2=0.135
r110 135 136 18.5261 $w=1.48227e-08 $l=2.2e-08 $layer=LIG $thickness=4.8e-08
+ $X=0.594 $Y=0.135 $X2=0.616 $Y2=0.135
r111 133 134 1.90543 $w=2e-08 $l=4e-09 $layer=LIG $thickness=4.8e-08 $X=0.571
+ $Y=0.135 $X2=0.567 $Y2=0.135
r112 133 135 18.8437 $w=1.50478e-08 $l=2.3e-08 $layer=LIG $thickness=4.8e-08
+ $X=0.571 $Y=0.135 $X2=0.594 $Y2=0.135
r113 132 133 3.17572 $w=2e-08 $l=1e-08 $layer=LIG $thickness=4.8e-08 $X=0.561
+ $Y=0.135 $X2=0.571 $Y2=0.135
r114 129 132 6.25213 $w=1.62778e-08 $l=9e-09 $layer=LIG $thickness=4.8e-08
+ $X=0.552 $Y=0.135 $X2=0.561 $Y2=0.135
r115 2 129 16.9382 $w=1.33e-08 $l=1.7e-08 $layer=LIG $thickness=4.8e-08
+ $X=0.535 $Y=0.135 $X2=0.552 $Y2=0.135
r116 2 130 15.1321 $w=1.63455e-08 $l=2.2e-08 $layer=LIG $thickness=4.8e-08
+ $X=0.535 $Y=0.135 $X2=0.513 $Y2=0.135
r117 127 128 8.86121 $w=1.3e-08 $l=3.8e-08 $layer=M1 $thickness=3.6e-08
+ $X=1.393 $Y=0.036 $X2=1.431 $Y2=0.036
r118 126 127 10.7267 $w=1.3e-08 $l=4.6e-08 $layer=M1 $thickness=3.6e-08
+ $X=1.347 $Y=0.036 $X2=1.393 $Y2=0.036
r119 125 126 22.6194 $w=1.3e-08 $l=9.7e-08 $layer=M1 $thickness=3.6e-08 $X=1.25
+ $Y=0.036 $X2=1.347 $Y2=0.036
r120 124 125 18.6552 $w=1.3e-08 $l=8e-08 $layer=M1 $thickness=3.6e-08 $X=1.17
+ $Y=0.036 $X2=1.25 $Y2=0.036
r121 123 124 2.2153 $w=1.3e-08 $l=9.5e-09 $layer=M1 $thickness=3.6e-08
+ $X=1.1605 $Y=0.036 $X2=1.17 $Y2=0.036
r122 122 123 5.82974 $w=1.3e-08 $l=2.5e-08 $layer=M1 $thickness=3.6e-08
+ $X=1.1355 $Y=0.036 $X2=1.1605 $Y2=0.036
r123 121 122 10.3769 $w=1.3e-08 $l=4.45e-08 $layer=M1 $thickness=3.6e-08
+ $X=1.091 $Y=0.036 $X2=1.1355 $Y2=0.036
r124 45 121 9.44419 $w=1.3e-08 $l=4.05e-08 $layer=M1 $thickness=3.6e-08
+ $X=1.0505 $Y=0.036 $X2=1.091 $Y2=0.036
r125 119 120 7.34548 $w=1.3e-08 $l=3.15e-08 $layer=M1 $thickness=3.6e-08
+ $X=1.026 $Y=0.072 $X2=1.026 $Y2=0.1035
r126 44 119 4.19742 $w=1.3e-08 $l=1.8e-08 $layer=M1 $thickness=3.6e-08 $X=1.026
+ $Y=0.054 $X2=1.026 $Y2=0.072
r127 117 137 19.3796 $a=3.24e-16 $layer=V0LIG $X=0.6275 $Y=0.135 $X2=0.626
+ $Y2=0.135
r128 42 117 3.73104 $w=1.3e-08 $l=1.6e-08 $layer=M1 $thickness=3.6e-08
+ $X=0.6115 $Y=0.135 $X2=0.6275 $Y2=0.135
r129 39 115 3.49785 $w=1.3e-08 $l=1.5e-08 $layer=M1 $thickness=3.6e-08
+ $X=0.5595 $Y=0.135 $X2=0.5745 $Y2=0.135
r130 39 129 19.3796 $a=3.24e-16 $layer=V0LIG $X=0.5595 $Y=0.135 $X2=0.552
+ $Y2=0.135
r131 33 114 4.53284 $w=1.48367e-08 $l=2.45e-08 $layer=M1 $thickness=3.6e-08
+ $X=1.026 $Y=0.036 $X2=1.0015 $Y2=0.036
r132 33 44 3.01711 $w=1.55e-08 $l=1.8e-08 $layer=M1 $thickness=3.6e-08 $X=1.026
+ $Y=0.036 $X2=1.026 $Y2=0.054
r133 33 45 4.53284 $w=1.48367e-08 $l=2.45e-08 $layer=M1 $thickness=3.6e-08
+ $X=1.026 $Y=0.036 $X2=1.0505 $Y2=0.036
r134 32 106 6.16517 $w=1.44286e-08 $l=3.15e-08 $layer=M1 $thickness=3.6e-08
+ $X=0.593 $Y=0.135 $X2=0.593 $Y2=0.1035
r135 32 115 3.1337 $w=1.54324e-08 $l=1.85e-08 $layer=M1 $thickness=3.6e-08
+ $X=0.593 $Y=0.135 $X2=0.5745 $Y2=0.135
r136 32 42 3.1337 $w=1.54324e-08 $l=1.85e-08 $layer=M1 $thickness=3.6e-08
+ $X=0.593 $Y=0.135 $X2=0.6115 $Y2=0.135
r137 113 114 9.44419 $w=1.3e-08 $l=4.05e-08 $layer=M1 $thickness=3.6e-08
+ $X=0.961 $Y=0.036 $X2=1.0015 $Y2=0.036
r138 112 113 10.3769 $w=1.3e-08 $l=4.45e-08 $layer=M1 $thickness=3.6e-08
+ $X=0.9165 $Y=0.036 $X2=0.961 $Y2=0.036
r139 111 112 5.82974 $w=1.3e-08 $l=2.5e-08 $layer=M1 $thickness=3.6e-08
+ $X=0.8915 $Y=0.036 $X2=0.9165 $Y2=0.036
r140 110 111 2.2153 $w=1.3e-08 $l=9.5e-09 $layer=M1 $thickness=3.6e-08 $X=0.882
+ $Y=0.036 $X2=0.8915 $Y2=0.036
r141 109 110 18.6552 $w=1.3e-08 $l=8e-08 $layer=M1 $thickness=3.6e-08 $X=0.802
+ $Y=0.036 $X2=0.882 $Y2=0.036
r142 108 109 22.6194 $w=1.3e-08 $l=9.7e-08 $layer=M1 $thickness=3.6e-08
+ $X=0.705 $Y=0.036 $X2=0.802 $Y2=0.036
r143 107 108 10.7267 $w=1.3e-08 $l=4.6e-08 $layer=M1 $thickness=3.6e-08
+ $X=0.659 $Y=0.036 $X2=0.705 $Y2=0.036
r144 41 107 9.56078 $w=1.3e-08 $l=4.1e-08 $layer=M1 $thickness=3.6e-08 $X=0.618
+ $Y=0.036 $X2=0.659 $Y2=0.036
r145 105 106 7.34548 $w=1.3e-08 $l=3.15e-08 $layer=M1 $thickness=3.6e-08
+ $X=0.593 $Y=0.072 $X2=0.593 $Y2=0.1035
r146 40 105 4.19742 $w=1.3e-08 $l=1.8e-08 $layer=M1 $thickness=3.6e-08 $X=0.593
+ $Y=0.054 $X2=0.593 $Y2=0.072
r147 31 104 4.41625 $w=1.4875e-08 $l=2.4e-08 $layer=M1 $thickness=3.6e-08
+ $X=0.593 $Y=0.036 $X2=0.569 $Y2=0.036
r148 31 40 3.01711 $w=1.55e-08 $l=1.8e-08 $layer=M1 $thickness=3.6e-08 $X=0.593
+ $Y=0.036 $X2=0.593 $Y2=0.054
r149 31 41 4.64944 $w=1.48e-08 $l=2.5e-08 $layer=M1 $thickness=3.6e-08 $X=0.593
+ $Y=0.036 $X2=0.618 $Y2=0.036
r150 103 104 9.32759 $w=1.3e-08 $l=4e-08 $layer=M1 $thickness=3.6e-08 $X=0.529
+ $Y=0.036 $X2=0.569 $Y2=0.036
r151 102 103 10.3769 $w=1.3e-08 $l=4.45e-08 $layer=M1 $thickness=3.6e-08
+ $X=0.4845 $Y=0.036 $X2=0.529 $Y2=0.036
r152 101 102 5.82974 $w=1.3e-08 $l=2.5e-08 $layer=M1 $thickness=3.6e-08
+ $X=0.4595 $Y=0.036 $X2=0.4845 $Y2=0.036
r153 100 101 2.2153 $w=1.3e-08 $l=9.5e-09 $layer=M1 $thickness=3.6e-08 $X=0.45
+ $Y=0.036 $X2=0.4595 $Y2=0.036
r154 99 100 18.6552 $w=1.3e-08 $l=8e-08 $layer=M1 $thickness=3.6e-08 $X=0.37
+ $Y=0.036 $X2=0.45 $Y2=0.036
r155 98 99 22.6194 $w=1.3e-08 $l=9.7e-08 $layer=M1 $thickness=3.6e-08 $X=0.273
+ $Y=0.036 $X2=0.37 $Y2=0.036
r156 97 98 10.7267 $w=1.3e-08 $l=4.6e-08 $layer=M1 $thickness=3.6e-08 $X=0.227
+ $Y=0.036 $X2=0.273 $Y2=0.036
r157 38 97 8.86121 $w=1.3e-08 $l=3.8e-08 $layer=M1 $thickness=3.6e-08 $X=0.189
+ $Y=0.036 $X2=0.227 $Y2=0.036
r158 30 94 1.79044 $w=1.89797e-08 $l=1.47e-08 $layer=M1 $thickness=3.6e-08
+ $X=0.167 $Y=0.036 $X2=0.167 $Y2=0.0507
r159 30 38 3.48106 $w=1.50455e-08 $l=2.2e-08 $layer=M1 $thickness=3.6e-08
+ $X=0.167 $Y=0.036 $X2=0.189 $Y2=0.036
r160 95 96 0.757867 $w=1.3e-08 $l=3.2e-09 $layer=M1 $thickness=3.6e-08 $X=0.168
+ $Y=0.057 $X2=0.167 $Y2=0.0602
r161 95 94 1.45744 $w=1.3e-08 $l=6.3e-09 $layer=M1 $thickness=3.6e-08 $X=0.168
+ $Y=0.057 $X2=0.167 $Y2=0.0507
r162 93 96 2.73998 $w=1.3e-08 $l=1.18e-08 $layer=M1 $thickness=3.6e-08 $X=0.167
+ $Y=0.072 $X2=0.167 $Y2=0.0602
r163 37 77 6.16517 $w=1.44286e-08 $l=3.15e-08 $layer=M1 $thickness=3.6e-08
+ $X=0.167 $Y=0.1035 $X2=0.167 $Y2=0.135
r164 37 93 7.34548 $w=1.3e-08 $l=3.15e-08 $layer=M1 $thickness=3.6e-08 $X=0.167
+ $Y=0.1035 $X2=0.167 $Y2=0.072
r165 91 90 16.6668 $w=2.1e-08 $l=4.9e-08 $layer=Gate_1 $thickness=5.6e-08
+ $X=0.243 $Y=0.2025 $X2=0.243 $Y2=0.1535
r166 88 89 16.6668 $w=2.1e-08 $l=4.9e-08 $layer=Gate_1 $thickness=5.6e-08
+ $X=0.243 $Y=0.0675 $X2=0.243 $Y2=0.1165
r167 16 68 6.74717 $w=2e-08 $layer=Gate_1 $thickness=5.2e-08 $X=0.243 $Y=0.135
+ $X2=0.243 $Y2=0.135
r168 16 89 6.46262 $w=2.04595e-08 $l=1.85e-08 $layer=Gate_1 $thickness=5.6e-08
+ $X=0.243 $Y=0.135 $X2=0.243 $Y2=0.1165
r169 16 90 6.46262 $w=2.04595e-08 $l=1.85e-08 $layer=Gate_1 $thickness=5.6e-08
+ $X=0.243 $Y=0.135 $X2=0.243 $Y2=0.1535
r170 85 84 16.6668 $w=2.1e-08 $l=4.9e-08 $layer=Gate_1 $thickness=5.6e-08
+ $X=0.189 $Y=0.2025 $X2=0.189 $Y2=0.1535
r171 82 83 16.6668 $w=2.1e-08 $l=4.9e-08 $layer=Gate_1 $thickness=5.6e-08
+ $X=0.189 $Y=0.0675 $X2=0.189 $Y2=0.1165
r172 15 65 3.57145 $w=2e-08 $layer=Gate_1 $thickness=5.6e-08 $X=0.189 $Y=0.135
+ $X2=0.189 $Y2=0.135
r173 15 83 6.46262 $w=2.04595e-08 $l=1.85e-08 $layer=Gate_1 $thickness=5.6e-08
+ $X=0.189 $Y=0.135 $X2=0.189 $Y2=0.1165
r174 15 84 6.46262 $w=2.04595e-08 $l=1.85e-08 $layer=Gate_1 $thickness=5.6e-08
+ $X=0.189 $Y=0.135 $X2=0.189 $Y2=0.1535
r175 78 79 3.03147 $w=1.3e-08 $l=1.3e-08 $layer=M1 $thickness=3.6e-08 $X=0.183
+ $Y=0.135 $X2=0.196 $Y2=0.135
r176 77 78 2.55073 $w=1.58125e-08 $l=1.6e-08 $layer=M1 $thickness=3.6e-08
+ $X=0.167 $Y=0.135 $X2=0.183 $Y2=0.135
r177 76 77 2.55073 $w=1.58125e-08 $l=1.6e-08 $layer=M1 $thickness=3.6e-08
+ $X=0.151 $Y=0.135 $X2=0.167 $Y2=0.135
r178 29 76 3.73104 $w=1.3e-08 $l=1.6e-08 $layer=M1 $thickness=3.6e-08 $X=0.135
+ $Y=0.135 $X2=0.151 $Y2=0.135
r179 29 60 19.3796 $a=3.24e-16 $layer=V0LIG $X=0.135 $Y=0.135 $X2=0.135
+ $Y2=0.135
r180 74 73 16.6668 $w=2.1e-08 $l=4.9e-08 $layer=Gate_1 $thickness=5.6e-08
+ $X=0.135 $Y=0.2025 $X2=0.135 $Y2=0.1535
r181 71 72 16.6668 $w=2.1e-08 $l=4.9e-08 $layer=Gate_1 $thickness=5.6e-08
+ $X=0.135 $Y=0.0675 $X2=0.135 $Y2=0.1165
r182 14 60 6.4296 $w=2e-08 $layer=Gate_1 $thickness=5.22105e-08 $X=0.135
+ $Y=0.135 $X2=0.135 $Y2=0.135
r183 14 72 6.46262 $w=2.04595e-08 $l=1.85e-08 $layer=Gate_1 $thickness=5.6e-08
+ $X=0.135 $Y=0.135 $X2=0.135 $Y2=0.1165
r184 14 73 6.46262 $w=2.04595e-08 $l=1.85e-08 $layer=Gate_1 $thickness=5.6e-08
+ $X=0.135 $Y=0.135 $X2=0.135 $Y2=0.1535
r185 67 68 15.6303 $w=1.62778e-08 $l=2.25e-08 $layer=LIG $thickness=4.8e-08
+ $X=0.2205 $Y=0.135 $X2=0.243 $Y2=0.135
r186 66 67 16.9382 $w=1.33e-08 $l=1.7e-08 $layer=LIG $thickness=4.8e-08
+ $X=0.2035 $Y=0.135 $X2=0.2205 $Y2=0.135
r187 64 66 5.91273 $w=1.665e-08 $l=9e-09 $layer=LIG $thickness=4.8e-08
+ $X=0.1945 $Y=0.135 $X2=0.2035 $Y2=0.135
r188 64 79 19.3796 $a=3.24e-16 $layer=V0LIG $X=0.1945 $Y=0.135 $X2=0.196
+ $Y2=0.135
r189 63 64 3.17572 $w=2e-08 $l=1e-08 $layer=LIG $thickness=4.8e-08 $X=0.1845
+ $Y=0.135 $X2=0.1945 $Y2=0.135
r190 63 65 1.74665 $w=2e-08 $l=4.5e-09 $layer=LIG $thickness=4.8e-08 $X=0.1845
+ $Y=0.135 $X2=0.189 $Y2=0.135
r191 62 63 18.6849 $w=1.49378e-08 $l=2.25e-08 $layer=LIG $thickness=4.8e-08
+ $X=0.162 $Y=0.135 $X2=0.1845 $Y2=0.135
r192 61 62 17.097 $w=1.34914e-08 $l=1.75e-08 $layer=LIG $thickness=4.8e-08
+ $X=0.1445 $Y=0.135 $X2=0.162 $Y2=0.135
r193 60 61 3.01694 $w=2e-08 $l=9.5e-09 $layer=LIG $thickness=4.8e-08 $X=0.135
+ $Y=0.135 $X2=0.1445 $Y2=0.135
r194 59 60 3.01694 $w=2e-08 $l=9.5e-09 $layer=LIG $thickness=4.8e-08 $X=0.1255
+ $Y=0.135 $X2=0.135 $Y2=0.135
r195 58 59 17.097 $w=1.34914e-08 $l=1.75e-08 $layer=LIG $thickness=4.8e-08
+ $X=0.108 $Y=0.135 $X2=0.1255 $Y2=0.135
r196 1 52 6.74717 $w=2e-08 $layer=Gate_1 $thickness=5.2e-08 $X=0.081 $Y=0.135
+ $X2=0.081 $Y2=0.135
r197 1 58 20.114 $w=1.57815e-08 $l=2.7e-08 $layer=LIG $thickness=4.8e-08
+ $X=0.081 $Y=0.135 $X2=0.108 $Y2=0.135
r198 55 54 14.6259 $w=2.1e-08 $l=4.3e-08 $layer=Gate_1 $thickness=5.6e-08
+ $X=0.081 $Y=0.2025 $X2=0.081 $Y2=0.1595
r199 53 54 2.89117 $w=2.1e-08 $l=8.5e-09 $layer=Gate_1 $thickness=5.6e-08
+ $X=0.081 $Y=0.151 $X2=0.081 $Y2=0.1595
r200 52 53 5.61228 $w=2.0375e-08 $l=1.6e-08 $layer=Gate_1 $thickness=5.6e-08
+ $X=0.081 $Y=0.135 $X2=0.081 $Y2=0.151
r201 51 52 5.61228 $w=2.0375e-08 $l=1.6e-08 $layer=Gate_1 $thickness=5.6e-08
+ $X=0.081 $Y=0.119 $X2=0.081 $Y2=0.135
r202 50 51 2.89117 $w=2.1e-08 $l=8.5e-09 $layer=Gate_1 $thickness=5.6e-08
+ $X=0.081 $Y=0.1105 $X2=0.081 $Y2=0.119
r203 49 50 14.6259 $w=2.1e-08 $l=4.3e-08 $layer=Gate_1 $thickness=5.6e-08
+ $X=0.081 $Y=0.0675 $X2=0.081 $Y2=0.1105
r204 49 13 14.6259 $w=2.1e-08 $l=4.3e-08 $layer=Gate_1 $thickness=5.6e-08
+ $X=0.081 $Y=0.0675 $X2=0.081 $Y2=0.0245
.ends

.subckt PM_CKINVDCx16_ASAP7_75t_R%Y vss 116 98 99 114 115 130 131 149 150 157
+ 158 171 172 175 176 194 195 202 203 216 217 220 221 240 241 248 249 254 255
+ 258 259 266 267 54 71 75 69 65 79 73 4 8 10 12 14 85 2 6 16 77 67 1 15 90 82
+ 86 94 50 51 52 53 55 58 59 60 61 62 63 57 64 49 56 9 11 7 5 3 13 81 87 83 93
+ 89 95 91 84 88 92
c1 1 vss 0.00781266f $X=0.108 $Y=0.0675
c2 2 vss 0.00817666f $X=0.108 $Y=0.2025
c3 3 vss 0.00683017f $X=0.216 $Y=0.0675
c4 4 vss 0.00802718f $X=0.216 $Y=0.2025
c5 5 vss 0.00679532f $X=0.54 $Y=0.0675
c6 6 vss 0.00802349f $X=0.54 $Y=0.2025
c7 7 vss 0.00678776f $X=0.648 $Y=0.0675
c8 8 vss 0.00802009f $X=0.648 $Y=0.2025
c9 9 vss 0.00683687f $X=0.972 $Y=0.0675
c10 10 vss 0.00802349f $X=0.972 $Y=0.2025
c11 11 vss 0.00683687f $X=1.08 $Y=0.0675
c12 12 vss 0.00802349f $X=1.08 $Y=0.2025
c13 13 vss 0.0068303f $X=1.404 $Y=0.0675
c14 14 vss 0.00802349f $X=1.404 $Y=0.2025
c15 15 vss 0.00780543f $X=1.512 $Y=0.0675
c16 16 vss 0.00817667f $X=1.512 $Y=0.2025
c17 49 vss 0.00439868f $X=0.0935 $Y=0.0675
c18 50 vss 0.00431417f $X=0.2015 $Y=0.0675
c19 51 vss 0.00431417f $X=0.5255 $Y=0.0675
c20 52 vss 0.00431396f $X=0.6335 $Y=0.0675
c21 53 vss 0.00431417f $X=0.9575 $Y=0.0675
c22 54 vss 0.00431417f $X=1.0655 $Y=0.0675
c23 55 vss 0.00431417f $X=1.3895 $Y=0.0675
c24 56 vss 0.00439868f $X=1.4975 $Y=0.0675
c25 57 vss 0.00420515f $X=0.0935 $Y=0.2025
c26 58 vss 0.00431455f $X=0.2015 $Y=0.2025
c27 59 vss 0.00431455f $X=0.5255 $Y=0.2025
c28 60 vss 0.00431453f $X=0.6335 $Y=0.2025
c29 61 vss 0.00431455f $X=0.9575 $Y=0.2025
c30 62 vss 0.00431455f $X=1.0655 $Y=0.2025
c31 63 vss 0.00431455f $X=1.3895 $Y=0.2025
c32 64 vss 0.00420589f $X=1.4975 $Y=0.2025
c33 65 vss 0.00314705f $X=0.0945 $Y=0.072
c34 66 vss 0.00299479f $X=0.081 $Y=0.234
c35 67 vss 0.00103603f $X=0.243 $Y=0.072
c36 68 vss 0.00205118f $X=0.243 $Y=0.234
c37 69 vss 0.00116408f $X=0.513 $Y=0.072
c38 70 vss 0.00205109f $X=0.513 $Y=0.234
c39 71 vss 0.00112429f $X=0.675 $Y=0.072
c40 72 vss 0.00205118f $X=0.675 $Y=0.234
c41 73 vss 0.00113865f $X=0.945 $Y=0.072
c42 74 vss 0.00205109f $X=0.945 $Y=0.234
c43 75 vss 0.00113865f $X=1.107 $Y=0.072
c44 76 vss 0.00205109f $X=1.107 $Y=0.234
c45 77 vss 0.00103603f $X=1.377 $Y=0.072
c46 78 vss 0.00205118f $X=1.377 $Y=0.234
c47 79 vss 0.00320735f $X=1.539 $Y=0.072
c48 80 vss 0.00299478f $X=1.539 $Y=0.234
c49 81 vss 0.00568544f $X=0.081 $Y=0.1035
c50 82 vss 0.0118149f $X=0.0945 $Y=0.234
c51 83 vss 0.00306246f $X=0.243 $Y=0.1947
c52 84 vss 0.0226345f $X=0.273 $Y=0.234
c53 85 vss 0.00305807f $X=0.513 $Y=0.2025
c54 86 vss 0.0120837f $X=0.5265 $Y=0.234
c55 87 vss 0.00306463f $X=0.675 $Y=0.2025
c56 88 vss 0.0227191f $X=0.705 $Y=0.234
c57 89 vss 0.00303896f $X=0.945 $Y=0.2025
c58 90 vss 0.0119944f $X=0.9585 $Y=0.234
c59 91 vss 0.00303896f $X=1.107 $Y=0.2025
c60 92 vss 0.0227022f $X=1.1355 $Y=0.234
c61 93 vss 0.00306156f $X=1.377 $Y=0.2025
c62 94 vss 0.0118445f $X=1.3905 $Y=0.234
c63 95 vss 0.00569777f $X=1.539 $Y=0.1845
r1 267 265 0.0308642 $w=8.1e-08 $l=2.5e-09 $layer=N_src_drn $thickness=1e-09
+ $X=1.5293 $Y=0.0675 $X2=1.5265 $Y2=0.0675
r2 15 265 0.179012 $w=8.1e-08 $l=1.45e-08 $layer=N_src_drn $thickness=1e-09
+ $X=1.512 $Y=0.0675 $X2=1.5265 $Y2=0.0675
r3 56 15 0.179012 $w=8.1e-08 $l=1.45e-08 $layer=N_src_drn $thickness=1e-09
+ $X=1.4975 $Y=0.0675 $X2=1.512 $Y2=0.0675
r4 266 56 0.0308642 $w=8.1e-08 $l=2.5e-09 $layer=N_src_drn $thickness=1e-09
+ $X=1.4946 $Y=0.0675 $X2=1.4975 $Y2=0.0675
r5 15 260 19.3796 $a=3.24e-16 $layer=V0LISD $X=1.512 $Y=0.0675 $X2=1.513
+ $Y2=0.072
r6 260 261 2.91487 $w=1.3e-08 $l=1.25e-08 $layer=M1 $thickness=3.6e-08 $X=1.513
+ $Y=0.072 $X2=1.5255 $Y2=0.072
r7 79 251 6.16517 $w=1.44286e-08 $l=3.15e-08 $layer=M1 $thickness=3.6e-08
+ $X=1.539 $Y=0.072 $X2=1.539 $Y2=0.1035
r8 79 261 1.96775 $w=1.63333e-08 $l=1.35e-08 $layer=M1 $thickness=3.6e-08
+ $X=1.539 $Y=0.072 $X2=1.5255 $Y2=0.072
r9 259 257 0.0308642 $w=8.1e-08 $l=2.5e-09 $layer=N_src_drn $thickness=1e-09
+ $X=1.4213 $Y=0.0675 $X2=1.4185 $Y2=0.0675
r10 13 257 0.179012 $w=8.1e-08 $l=1.45e-08 $layer=N_src_drn $thickness=1e-09
+ $X=1.404 $Y=0.0675 $X2=1.4185 $Y2=0.0675
r11 55 13 0.179012 $w=8.1e-08 $l=1.45e-08 $layer=N_src_drn $thickness=1e-09
+ $X=1.3895 $Y=0.0675 $X2=1.404 $Y2=0.0675
r12 258 55 0.0308642 $w=8.1e-08 $l=2.5e-09 $layer=N_src_drn $thickness=1e-09
+ $X=1.3866 $Y=0.0675 $X2=1.3895 $Y2=0.0675
r13 255 253 0.0308642 $w=8.1e-08 $l=2.5e-09 $layer=P_src_drn $thickness=1e-09
+ $X=1.5293 $Y=0.2025 $X2=1.5265 $Y2=0.2025
r14 16 253 0.179012 $w=8.1e-08 $l=1.45e-08 $layer=P_src_drn $thickness=1e-09
+ $X=1.512 $Y=0.2025 $X2=1.5265 $Y2=0.2025
r15 64 16 0.179012 $w=8.1e-08 $l=1.45e-08 $layer=P_src_drn $thickness=1e-09
+ $X=1.4975 $Y=0.2025 $X2=1.512 $Y2=0.2025
r16 254 64 0.0308642 $w=8.1e-08 $l=2.5e-09 $layer=P_src_drn $thickness=1e-09
+ $X=1.4946 $Y=0.2025 $X2=1.4975 $Y2=0.2025
r17 250 251 7.34548 $w=1.3e-08 $l=3.15e-08 $layer=M1 $thickness=3.6e-08
+ $X=1.539 $Y=0.135 $X2=1.539 $Y2=0.1035
r18 95 250 11.5429 $w=1.3e-08 $l=4.95e-08 $layer=M1 $thickness=3.6e-08 $X=1.539
+ $Y=0.1845 $X2=1.539 $Y2=0.135
r19 249 247 0.0308642 $w=8.1e-08 $l=2.5e-09 $layer=P_src_drn $thickness=1e-09
+ $X=1.4213 $Y=0.2025 $X2=1.4185 $Y2=0.2025
r20 14 247 0.179012 $w=8.1e-08 $l=1.45e-08 $layer=P_src_drn $thickness=1e-09
+ $X=1.404 $Y=0.2025 $X2=1.4185 $Y2=0.2025
r21 63 14 0.179012 $w=8.1e-08 $l=1.45e-08 $layer=P_src_drn $thickness=1e-09
+ $X=1.3895 $Y=0.2025 $X2=1.404 $Y2=0.2025
r22 248 63 0.0308642 $w=8.1e-08 $l=2.5e-09 $layer=P_src_drn $thickness=1e-09
+ $X=1.3866 $Y=0.2025 $X2=1.3895 $Y2=0.2025
r23 13 243 19.3796 $a=3.24e-16 $layer=V0LISD $X=1.404 $Y=0.0675 $X2=1.4035
+ $Y2=0.072
r24 16 236 19.3796 $a=3.24e-16 $layer=V0LISD $X=1.512 $Y=0.2025 $X2=1.513
+ $Y2=0.234
r25 80 237 1.49895 $w=1.63333e-08 $l=1.35e-08 $layer=M1 $thickness=3.6e-08
+ $X=1.539 $Y=0.234 $X2=1.5255 $Y2=0.234
r26 80 95 9.89378 $w=1.47818e-08 $l=4.95e-08 $layer=M1 $thickness=3.6e-08
+ $X=1.539 $Y=0.234 $X2=1.539 $Y2=0.1845
r27 14 232 19.3796 $a=3.24e-16 $layer=V0LISD $X=1.404 $Y=0.2025 $X2=1.4035
+ $Y2=0.234
r28 242 243 3.03147 $w=1.3e-08 $l=1.3e-08 $layer=M1 $thickness=3.6e-08
+ $X=1.3905 $Y=0.072 $X2=1.4035 $Y2=0.072
r29 77 231 1.96775 $w=1.63333e-08 $l=1.35e-08 $layer=M1 $thickness=3.6e-08
+ $X=1.377 $Y=0.072 $X2=1.377 $Y2=0.0855
r30 77 242 1.96775 $w=1.63333e-08 $l=1.35e-08 $layer=M1 $thickness=3.6e-08
+ $X=1.377 $Y=0.072 $X2=1.3905 $Y2=0.072
r31 241 239 0.0308642 $w=8.1e-08 $l=2.5e-09 $layer=N_src_drn $thickness=1e-09
+ $X=1.0973 $Y=0.0675 $X2=1.0945 $Y2=0.0675
r32 11 239 0.179012 $w=8.1e-08 $l=1.45e-08 $layer=N_src_drn $thickness=1e-09
+ $X=1.08 $Y=0.0675 $X2=1.0945 $Y2=0.0675
r33 54 11 0.179012 $w=8.1e-08 $l=1.45e-08 $layer=N_src_drn $thickness=1e-09
+ $X=1.0655 $Y=0.0675 $X2=1.08 $Y2=0.0675
r34 240 54 0.0308642 $w=8.1e-08 $l=2.5e-09 $layer=N_src_drn $thickness=1e-09
+ $X=1.0626 $Y=0.0675 $X2=1.0655 $Y2=0.0675
r35 236 237 2.91487 $w=1.3e-08 $l=1.25e-08 $layer=M1 $thickness=3.6e-08
+ $X=1.513 $Y=0.234 $X2=1.5255 $Y2=0.234
r36 235 236 2.09871 $w=1.3e-08 $l=9e-09 $layer=M1 $thickness=3.6e-08 $X=1.504
+ $Y=0.234 $X2=1.513 $Y2=0.234
r37 234 235 10.7267 $w=1.3e-08 $l=4.6e-08 $layer=M1 $thickness=3.6e-08 $X=1.458
+ $Y=0.234 $X2=1.504 $Y2=0.234
r38 233 234 10.6101 $w=1.3e-08 $l=4.55e-08 $layer=M1 $thickness=3.6e-08
+ $X=1.4125 $Y=0.234 $X2=1.458 $Y2=0.234
r39 232 233 2.09871 $w=1.3e-08 $l=9e-09 $layer=M1 $thickness=3.6e-08 $X=1.4035
+ $Y=0.234 $X2=1.4125 $Y2=0.234
r40 94 232 3.03147 $w=1.3e-08 $l=1.3e-08 $layer=M1 $thickness=3.6e-08 $X=1.3905
+ $Y=0.234 $X2=1.4035 $Y2=0.234
r41 230 231 3.14806 $w=1.3e-08 $l=1.35e-08 $layer=M1 $thickness=3.6e-08
+ $X=1.377 $Y=0.099 $X2=1.377 $Y2=0.0855
r42 229 230 4.19742 $w=1.3e-08 $l=1.8e-08 $layer=M1 $thickness=3.6e-08 $X=1.377
+ $Y=0.117 $X2=1.377 $Y2=0.099
r43 228 229 4.19742 $w=1.3e-08 $l=1.8e-08 $layer=M1 $thickness=3.6e-08 $X=1.377
+ $Y=0.135 $X2=1.377 $Y2=0.117
r44 227 228 4.19742 $w=1.3e-08 $l=1.8e-08 $layer=M1 $thickness=3.6e-08 $X=1.377
+ $Y=0.153 $X2=1.377 $Y2=0.135
r45 226 227 4.19742 $w=1.3e-08 $l=1.8e-08 $layer=M1 $thickness=3.6e-08 $X=1.377
+ $Y=0.171 $X2=1.377 $Y2=0.153
r46 93 226 7.34548 $w=1.3e-08 $l=3.15e-08 $layer=M1 $thickness=3.6e-08 $X=1.377
+ $Y=0.2025 $X2=1.377 $Y2=0.171
r47 11 222 19.3796 $a=3.24e-16 $layer=V0LISD $X=1.08 $Y=0.0675 $X2=1.0805
+ $Y2=0.072
r48 78 213 5.81538 $w=1.45e-08 $l=3e-08 $layer=M1 $thickness=3.6e-08 $X=1.377
+ $Y=0.234 $X2=1.347 $Y2=0.234
r49 78 93 6.16517 $w=1.44286e-08 $l=3.15e-08 $layer=M1 $thickness=3.6e-08
+ $X=1.377 $Y=0.234 $X2=1.377 $Y2=0.2025
r50 78 94 1.96775 $w=1.63333e-08 $l=1.35e-08 $layer=M1 $thickness=3.6e-08
+ $X=1.377 $Y=0.234 $X2=1.3905 $Y2=0.234
r51 222 223 3.03147 $w=1.3e-08 $l=1.3e-08 $layer=M1 $thickness=3.6e-08
+ $X=1.0805 $Y=0.072 $X2=1.0935 $Y2=0.072
r52 75 209 1.96775 $w=1.63333e-08 $l=1.35e-08 $layer=M1 $thickness=3.6e-08
+ $X=1.107 $Y=0.072 $X2=1.107 $Y2=0.0855
r53 75 223 1.96775 $w=1.63333e-08 $l=1.35e-08 $layer=M1 $thickness=3.6e-08
+ $X=1.107 $Y=0.072 $X2=1.0935 $Y2=0.072
r54 221 219 0.0308642 $w=8.1e-08 $l=2.5e-09 $layer=N_src_drn $thickness=1e-09
+ $X=0.9893 $Y=0.0675 $X2=0.9865 $Y2=0.0675
r55 9 219 0.179012 $w=8.1e-08 $l=1.45e-08 $layer=N_src_drn $thickness=1e-09
+ $X=0.972 $Y=0.0675 $X2=0.9865 $Y2=0.0675
r56 53 9 0.179012 $w=8.1e-08 $l=1.45e-08 $layer=N_src_drn $thickness=1e-09
+ $X=0.9575 $Y=0.0675 $X2=0.972 $Y2=0.0675
r57 220 53 0.0308642 $w=8.1e-08 $l=2.5e-09 $layer=N_src_drn $thickness=1e-09
+ $X=0.9546 $Y=0.0675 $X2=0.9575 $Y2=0.0675
r58 217 215 0.0308642 $w=8.1e-08 $l=2.5e-09 $layer=P_src_drn $thickness=1e-09
+ $X=1.0973 $Y=0.2025 $X2=1.0945 $Y2=0.2025
r59 12 215 0.179012 $w=8.1e-08 $l=1.45e-08 $layer=P_src_drn $thickness=1e-09
+ $X=1.08 $Y=0.2025 $X2=1.0945 $Y2=0.2025
r60 62 12 0.179012 $w=8.1e-08 $l=1.45e-08 $layer=P_src_drn $thickness=1e-09
+ $X=1.0655 $Y=0.2025 $X2=1.08 $Y2=0.2025
r61 216 62 0.0308642 $w=8.1e-08 $l=2.5e-09 $layer=P_src_drn $thickness=1e-09
+ $X=1.0626 $Y=0.2025 $X2=1.0655 $Y2=0.2025
r62 212 213 6.06293 $w=1.3e-08 $l=2.6e-08 $layer=M1 $thickness=3.6e-08 $X=1.321
+ $Y=0.234 $X2=1.347 $Y2=0.234
r63 211 212 1.86552 $w=1.3e-08 $l=8e-09 $layer=M1 $thickness=3.6e-08 $X=1.313
+ $Y=0.234 $X2=1.321 $Y2=0.234
r64 210 211 18.7718 $w=1.3e-08 $l=8.05e-08 $layer=M1 $thickness=3.6e-08
+ $X=1.2325 $Y=0.234 $X2=1.313 $Y2=0.234
r65 92 210 22.6194 $w=1.3e-08 $l=9.7e-08 $layer=M1 $thickness=3.6e-08 $X=1.1355
+ $Y=0.234 $X2=1.2325 $Y2=0.234
r66 208 209 3.14806 $w=1.3e-08 $l=1.35e-08 $layer=M1 $thickness=3.6e-08
+ $X=1.107 $Y=0.099 $X2=1.107 $Y2=0.0855
r67 207 208 4.19742 $w=1.3e-08 $l=1.8e-08 $layer=M1 $thickness=3.6e-08 $X=1.107
+ $Y=0.117 $X2=1.107 $Y2=0.099
r68 206 207 4.19742 $w=1.3e-08 $l=1.8e-08 $layer=M1 $thickness=3.6e-08 $X=1.107
+ $Y=0.135 $X2=1.107 $Y2=0.117
r69 205 206 4.19742 $w=1.3e-08 $l=1.8e-08 $layer=M1 $thickness=3.6e-08 $X=1.107
+ $Y=0.153 $X2=1.107 $Y2=0.135
r70 204 205 4.19742 $w=1.3e-08 $l=1.8e-08 $layer=M1 $thickness=3.6e-08 $X=1.107
+ $Y=0.171 $X2=1.107 $Y2=0.153
r71 91 204 7.34548 $w=1.3e-08 $l=3.15e-08 $layer=M1 $thickness=3.6e-08 $X=1.107
+ $Y=0.2025 $X2=1.107 $Y2=0.171
r72 203 201 0.0308642 $w=8.1e-08 $l=2.5e-09 $layer=P_src_drn $thickness=1e-09
+ $X=0.9893 $Y=0.2025 $X2=0.9865 $Y2=0.2025
r73 10 201 0.179012 $w=8.1e-08 $l=1.45e-08 $layer=P_src_drn $thickness=1e-09
+ $X=0.972 $Y=0.2025 $X2=0.9865 $Y2=0.2025
r74 61 10 0.179012 $w=8.1e-08 $l=1.45e-08 $layer=P_src_drn $thickness=1e-09
+ $X=0.9575 $Y=0.2025 $X2=0.972 $Y2=0.2025
r75 202 61 0.0308642 $w=8.1e-08 $l=2.5e-09 $layer=P_src_drn $thickness=1e-09
+ $X=0.9546 $Y=0.2025 $X2=0.9575 $Y2=0.2025
r76 9 197 19.3796 $a=3.24e-16 $layer=V0LISD $X=0.972 $Y=0.0675 $X2=0.9715
+ $Y2=0.072
r77 12 190 19.3796 $a=3.24e-16 $layer=V0LISD $X=1.08 $Y=0.2025 $X2=1.0805
+ $Y2=0.234
r78 76 191 1.96775 $w=1.63333e-08 $l=1.35e-08 $layer=M1 $thickness=3.6e-08
+ $X=1.107 $Y=0.234 $X2=1.0935 $Y2=0.234
r79 76 91 6.16517 $w=1.44286e-08 $l=3.15e-08 $layer=M1 $thickness=3.6e-08
+ $X=1.107 $Y=0.234 $X2=1.107 $Y2=0.2025
r80 76 92 5.4656 $w=1.45789e-08 $l=2.85e-08 $layer=M1 $thickness=3.6e-08
+ $X=1.107 $Y=0.234 $X2=1.1355 $Y2=0.234
r81 10 186 19.3796 $a=3.24e-16 $layer=V0LISD $X=0.972 $Y=0.2025 $X2=0.9715
+ $Y2=0.234
r82 196 197 3.03147 $w=1.3e-08 $l=1.3e-08 $layer=M1 $thickness=3.6e-08
+ $X=0.9585 $Y=0.072 $X2=0.9715 $Y2=0.072
r83 73 185 1.96775 $w=1.63333e-08 $l=1.35e-08 $layer=M1 $thickness=3.6e-08
+ $X=0.945 $Y=0.072 $X2=0.945 $Y2=0.0855
r84 73 196 1.96775 $w=1.63333e-08 $l=1.35e-08 $layer=M1 $thickness=3.6e-08
+ $X=0.945 $Y=0.072 $X2=0.9585 $Y2=0.072
r85 195 193 0.0308642 $w=8.1e-08 $l=2.5e-09 $layer=N_src_drn $thickness=1e-09
+ $X=0.6653 $Y=0.0675 $X2=0.6625 $Y2=0.0675
r86 7 193 0.179012 $w=8.1e-08 $l=1.45e-08 $layer=N_src_drn $thickness=1e-09
+ $X=0.648 $Y=0.0675 $X2=0.6625 $Y2=0.0675
r87 52 7 0.179012 $w=8.1e-08 $l=1.45e-08 $layer=N_src_drn $thickness=1e-09
+ $X=0.6335 $Y=0.0675 $X2=0.648 $Y2=0.0675
r88 194 52 0.0308642 $w=8.1e-08 $l=2.5e-09 $layer=N_src_drn $thickness=1e-09
+ $X=0.6306 $Y=0.0675 $X2=0.6335 $Y2=0.0675
r89 190 191 3.03147 $w=1.3e-08 $l=1.3e-08 $layer=M1 $thickness=3.6e-08
+ $X=1.0805 $Y=0.234 $X2=1.0935 $Y2=0.234
r90 189 190 2.09871 $w=1.3e-08 $l=9e-09 $layer=M1 $thickness=3.6e-08 $X=1.0715
+ $Y=0.234 $X2=1.0805 $Y2=0.234
r91 188 189 10.6101 $w=1.3e-08 $l=4.55e-08 $layer=M1 $thickness=3.6e-08
+ $X=1.026 $Y=0.234 $X2=1.0715 $Y2=0.234
r92 187 188 10.6101 $w=1.3e-08 $l=4.55e-08 $layer=M1 $thickness=3.6e-08
+ $X=0.9805 $Y=0.234 $X2=1.026 $Y2=0.234
r93 186 187 2.09871 $w=1.3e-08 $l=9e-09 $layer=M1 $thickness=3.6e-08 $X=0.9715
+ $Y=0.234 $X2=0.9805 $Y2=0.234
r94 90 186 3.03147 $w=1.3e-08 $l=1.3e-08 $layer=M1 $thickness=3.6e-08 $X=0.9585
+ $Y=0.234 $X2=0.9715 $Y2=0.234
r95 184 185 3.14806 $w=1.3e-08 $l=1.35e-08 $layer=M1 $thickness=3.6e-08
+ $X=0.945 $Y=0.099 $X2=0.945 $Y2=0.0855
r96 183 184 4.19742 $w=1.3e-08 $l=1.8e-08 $layer=M1 $thickness=3.6e-08 $X=0.945
+ $Y=0.117 $X2=0.945 $Y2=0.099
r97 182 183 4.19742 $w=1.3e-08 $l=1.8e-08 $layer=M1 $thickness=3.6e-08 $X=0.945
+ $Y=0.135 $X2=0.945 $Y2=0.117
r98 181 182 4.19742 $w=1.3e-08 $l=1.8e-08 $layer=M1 $thickness=3.6e-08 $X=0.945
+ $Y=0.153 $X2=0.945 $Y2=0.135
r99 180 181 4.19742 $w=1.3e-08 $l=1.8e-08 $layer=M1 $thickness=3.6e-08 $X=0.945
+ $Y=0.171 $X2=0.945 $Y2=0.153
r100 89 180 7.34548 $w=1.3e-08 $l=3.15e-08 $layer=M1 $thickness=3.6e-08
+ $X=0.945 $Y=0.2025 $X2=0.945 $Y2=0.171
r101 7 177 19.3796 $a=3.24e-16 $layer=V0LISD $X=0.648 $Y=0.0675 $X2=0.648
+ $Y2=0.072
r102 74 168 5.4656 $w=1.45789e-08 $l=2.85e-08 $layer=M1 $thickness=3.6e-08
+ $X=0.945 $Y=0.234 $X2=0.9165 $Y2=0.234
r103 74 89 6.16517 $w=1.44286e-08 $l=3.15e-08 $layer=M1 $thickness=3.6e-08
+ $X=0.945 $Y=0.234 $X2=0.945 $Y2=0.2025
r104 74 90 1.96775 $w=1.63333e-08 $l=1.35e-08 $layer=M1 $thickness=3.6e-08
+ $X=0.945 $Y=0.234 $X2=0.9585 $Y2=0.234
r105 177 178 3.14806 $w=1.3e-08 $l=1.35e-08 $layer=M1 $thickness=3.6e-08
+ $X=0.648 $Y=0.072 $X2=0.6615 $Y2=0.072
r106 71 164 1.96775 $w=1.63333e-08 $l=1.35e-08 $layer=M1 $thickness=3.6e-08
+ $X=0.675 $Y=0.072 $X2=0.675 $Y2=0.0855
r107 71 178 1.96775 $w=1.63333e-08 $l=1.35e-08 $layer=M1 $thickness=3.6e-08
+ $X=0.675 $Y=0.072 $X2=0.6615 $Y2=0.072
r108 176 174 0.0308642 $w=8.1e-08 $l=2.5e-09 $layer=N_src_drn $thickness=1e-09
+ $X=0.5573 $Y=0.0675 $X2=0.5545 $Y2=0.0675
r109 5 174 0.179012 $w=8.1e-08 $l=1.45e-08 $layer=N_src_drn $thickness=1e-09
+ $X=0.54 $Y=0.0675 $X2=0.5545 $Y2=0.0675
r110 51 5 0.179012 $w=8.1e-08 $l=1.45e-08 $layer=N_src_drn $thickness=1e-09
+ $X=0.5255 $Y=0.0675 $X2=0.54 $Y2=0.0675
r111 175 51 0.0308642 $w=8.1e-08 $l=2.5e-09 $layer=N_src_drn $thickness=1e-09
+ $X=0.5226 $Y=0.0675 $X2=0.5255 $Y2=0.0675
r112 172 170 0.0308642 $w=8.1e-08 $l=2.5e-09 $layer=P_src_drn $thickness=1e-09
+ $X=0.6653 $Y=0.2025 $X2=0.6625 $Y2=0.2025
r113 8 170 0.179012 $w=8.1e-08 $l=1.45e-08 $layer=P_src_drn $thickness=1e-09
+ $X=0.648 $Y=0.2025 $X2=0.6625 $Y2=0.2025
r114 60 8 0.179012 $w=8.1e-08 $l=1.45e-08 $layer=P_src_drn $thickness=1e-09
+ $X=0.6335 $Y=0.2025 $X2=0.648 $Y2=0.2025
r115 171 60 0.0308642 $w=8.1e-08 $l=2.5e-09 $layer=P_src_drn $thickness=1e-09
+ $X=0.6306 $Y=0.2025 $X2=0.6335 $Y2=0.2025
r116 167 168 22.6194 $w=1.3e-08 $l=9.7e-08 $layer=M1 $thickness=3.6e-08
+ $X=0.8195 $Y=0.234 $X2=0.9165 $Y2=0.234
r117 166 167 18.7718 $w=1.3e-08 $l=8.05e-08 $layer=M1 $thickness=3.6e-08
+ $X=0.739 $Y=0.234 $X2=0.8195 $Y2=0.234
r118 165 166 1.86552 $w=1.3e-08 $l=8e-09 $layer=M1 $thickness=3.6e-08 $X=0.731
+ $Y=0.234 $X2=0.739 $Y2=0.234
r119 88 165 6.06293 $w=1.3e-08 $l=2.6e-08 $layer=M1 $thickness=3.6e-08 $X=0.705
+ $Y=0.234 $X2=0.731 $Y2=0.234
r120 163 164 3.14806 $w=1.3e-08 $l=1.35e-08 $layer=M1 $thickness=3.6e-08
+ $X=0.675 $Y=0.099 $X2=0.675 $Y2=0.0855
r121 162 163 4.19742 $w=1.3e-08 $l=1.8e-08 $layer=M1 $thickness=3.6e-08
+ $X=0.675 $Y=0.117 $X2=0.675 $Y2=0.099
r122 161 162 4.19742 $w=1.3e-08 $l=1.8e-08 $layer=M1 $thickness=3.6e-08
+ $X=0.675 $Y=0.135 $X2=0.675 $Y2=0.117
r123 160 161 4.19742 $w=1.3e-08 $l=1.8e-08 $layer=M1 $thickness=3.6e-08
+ $X=0.675 $Y=0.153 $X2=0.675 $Y2=0.135
r124 159 160 4.19742 $w=1.3e-08 $l=1.8e-08 $layer=M1 $thickness=3.6e-08
+ $X=0.675 $Y=0.171 $X2=0.675 $Y2=0.153
r125 87 159 7.34548 $w=1.3e-08 $l=3.15e-08 $layer=M1 $thickness=3.6e-08
+ $X=0.675 $Y=0.2025 $X2=0.675 $Y2=0.171
r126 158 156 0.0308642 $w=8.1e-08 $l=2.5e-09 $layer=P_src_drn $thickness=1e-09
+ $X=0.5573 $Y=0.2025 $X2=0.5545 $Y2=0.2025
r127 6 156 0.179012 $w=8.1e-08 $l=1.45e-08 $layer=P_src_drn $thickness=1e-09
+ $X=0.54 $Y=0.2025 $X2=0.5545 $Y2=0.2025
r128 59 6 0.179012 $w=8.1e-08 $l=1.45e-08 $layer=P_src_drn $thickness=1e-09
+ $X=0.5255 $Y=0.2025 $X2=0.54 $Y2=0.2025
r129 157 59 0.0308642 $w=8.1e-08 $l=2.5e-09 $layer=P_src_drn $thickness=1e-09
+ $X=0.5226 $Y=0.2025 $X2=0.5255 $Y2=0.2025
r130 5 152 19.3796 $a=3.24e-16 $layer=V0LISD $X=0.54 $Y=0.0675 $X2=0.539
+ $Y2=0.072
r131 8 145 19.3796 $a=3.24e-16 $layer=V0LISD $X=0.648 $Y=0.2025 $X2=0.648
+ $Y2=0.234
r132 72 146 1.96775 $w=1.63333e-08 $l=1.35e-08 $layer=M1 $thickness=3.6e-08
+ $X=0.675 $Y=0.234 $X2=0.6615 $Y2=0.234
r133 72 87 6.16517 $w=1.44286e-08 $l=3.15e-08 $layer=M1 $thickness=3.6e-08
+ $X=0.675 $Y=0.234 $X2=0.675 $Y2=0.2025
r134 72 88 5.81538 $w=1.45e-08 $l=3e-08 $layer=M1 $thickness=3.6e-08 $X=0.675
+ $Y=0.234 $X2=0.705 $Y2=0.234
r135 6 142 19.3796 $a=3.24e-16 $layer=V0LISD $X=0.54 $Y=0.2025 $X2=0.539
+ $Y2=0.234
r136 151 152 2.91487 $w=1.3e-08 $l=1.25e-08 $layer=M1 $thickness=3.6e-08
+ $X=0.5265 $Y=0.072 $X2=0.539 $Y2=0.072
r137 69 141 1.96775 $w=1.63333e-08 $l=1.35e-08 $layer=M1 $thickness=3.6e-08
+ $X=0.513 $Y=0.072 $X2=0.513 $Y2=0.0855
r138 69 151 1.96775 $w=1.63333e-08 $l=1.35e-08 $layer=M1 $thickness=3.6e-08
+ $X=0.513 $Y=0.072 $X2=0.5265 $Y2=0.072
r139 150 148 0.0308642 $w=8.1e-08 $l=2.5e-09 $layer=N_src_drn $thickness=1e-09
+ $X=0.2333 $Y=0.0675 $X2=0.2305 $Y2=0.0675
r140 3 148 0.179012 $w=8.1e-08 $l=1.45e-08 $layer=N_src_drn $thickness=1e-09
+ $X=0.216 $Y=0.0675 $X2=0.2305 $Y2=0.0675
r141 50 3 0.179012 $w=8.1e-08 $l=1.45e-08 $layer=N_src_drn $thickness=1e-09
+ $X=0.2015 $Y=0.0675 $X2=0.216 $Y2=0.0675
r142 149 50 0.0308642 $w=8.1e-08 $l=2.5e-09 $layer=N_src_drn $thickness=1e-09
+ $X=0.1986 $Y=0.0675 $X2=0.2015 $Y2=0.0675
r143 145 146 3.14806 $w=1.3e-08 $l=1.35e-08 $layer=M1 $thickness=3.6e-08
+ $X=0.648 $Y=0.234 $X2=0.6615 $Y2=0.234
r144 144 145 12.5922 $w=1.3e-08 $l=5.4e-08 $layer=M1 $thickness=3.6e-08
+ $X=0.594 $Y=0.234 $X2=0.648 $Y2=0.234
r145 143 144 10.7267 $w=1.3e-08 $l=4.6e-08 $layer=M1 $thickness=3.6e-08
+ $X=0.548 $Y=0.234 $X2=0.594 $Y2=0.234
r146 142 143 2.09871 $w=1.3e-08 $l=9e-09 $layer=M1 $thickness=3.6e-08 $X=0.539
+ $Y=0.234 $X2=0.548 $Y2=0.234
r147 86 142 2.91487 $w=1.3e-08 $l=1.25e-08 $layer=M1 $thickness=3.6e-08
+ $X=0.5265 $Y=0.234 $X2=0.539 $Y2=0.234
r148 140 141 3.14806 $w=1.3e-08 $l=1.35e-08 $layer=M1 $thickness=3.6e-08
+ $X=0.513 $Y=0.099 $X2=0.513 $Y2=0.0855
r149 139 140 4.19742 $w=1.3e-08 $l=1.8e-08 $layer=M1 $thickness=3.6e-08
+ $X=0.513 $Y=0.117 $X2=0.513 $Y2=0.099
r150 138 139 4.19742 $w=1.3e-08 $l=1.8e-08 $layer=M1 $thickness=3.6e-08
+ $X=0.513 $Y=0.135 $X2=0.513 $Y2=0.117
r151 137 138 4.19742 $w=1.3e-08 $l=1.8e-08 $layer=M1 $thickness=3.6e-08
+ $X=0.513 $Y=0.153 $X2=0.513 $Y2=0.135
r152 136 137 4.19742 $w=1.3e-08 $l=1.8e-08 $layer=M1 $thickness=3.6e-08
+ $X=0.513 $Y=0.171 $X2=0.513 $Y2=0.153
r153 85 136 7.34548 $w=1.3e-08 $l=3.15e-08 $layer=M1 $thickness=3.6e-08
+ $X=0.513 $Y=0.2025 $X2=0.513 $Y2=0.171
r154 3 132 19.3796 $a=3.24e-16 $layer=V0LISD $X=0.216 $Y=0.0675 $X2=0.2165
+ $Y2=0.072
r155 70 127 5.4656 $w=1.45789e-08 $l=2.85e-08 $layer=M1 $thickness=3.6e-08
+ $X=0.513 $Y=0.234 $X2=0.4845 $Y2=0.234
r156 70 85 6.16517 $w=1.44286e-08 $l=3.15e-08 $layer=M1 $thickness=3.6e-08
+ $X=0.513 $Y=0.234 $X2=0.513 $Y2=0.2025
r157 70 86 1.96775 $w=1.63333e-08 $l=1.35e-08 $layer=M1 $thickness=3.6e-08
+ $X=0.513 $Y=0.234 $X2=0.5265 $Y2=0.234
r158 132 133 3.03147 $w=1.3e-08 $l=1.3e-08 $layer=M1 $thickness=3.6e-08
+ $X=0.2165 $Y=0.072 $X2=0.2295 $Y2=0.072
r159 67 123 1.96775 $w=1.63333e-08 $l=1.35e-08 $layer=M1 $thickness=3.6e-08
+ $X=0.243 $Y=0.072 $X2=0.243 $Y2=0.0855
r160 67 133 1.96775 $w=1.63333e-08 $l=1.35e-08 $layer=M1 $thickness=3.6e-08
+ $X=0.243 $Y=0.072 $X2=0.2295 $Y2=0.072
r161 131 129 0.0308642 $w=8.1e-08 $l=2.5e-09 $layer=P_src_drn $thickness=1e-09
+ $X=0.2333 $Y=0.2025 $X2=0.2305 $Y2=0.2025
r162 4 129 0.179012 $w=8.1e-08 $l=1.45e-08 $layer=P_src_drn $thickness=1e-09
+ $X=0.216 $Y=0.2025 $X2=0.2305 $Y2=0.2025
r163 58 4 0.179012 $w=8.1e-08 $l=1.45e-08 $layer=P_src_drn $thickness=1e-09
+ $X=0.2015 $Y=0.2025 $X2=0.216 $Y2=0.2025
r164 130 58 0.0308642 $w=8.1e-08 $l=2.5e-09 $layer=P_src_drn $thickness=1e-09
+ $X=0.1986 $Y=0.2025 $X2=0.2015 $Y2=0.2025
r165 126 127 22.6194 $w=1.3e-08 $l=9.7e-08 $layer=M1 $thickness=3.6e-08
+ $X=0.3875 $Y=0.234 $X2=0.4845 $Y2=0.234
r166 125 126 18.7718 $w=1.3e-08 $l=8.05e-08 $layer=M1 $thickness=3.6e-08
+ $X=0.307 $Y=0.234 $X2=0.3875 $Y2=0.234
r167 124 125 1.86552 $w=1.3e-08 $l=8e-09 $layer=M1 $thickness=3.6e-08 $X=0.299
+ $Y=0.234 $X2=0.307 $Y2=0.234
r168 84 124 6.06293 $w=1.3e-08 $l=2.6e-08 $layer=M1 $thickness=3.6e-08 $X=0.273
+ $Y=0.234 $X2=0.299 $Y2=0.234
r169 122 123 3.14806 $w=1.3e-08 $l=1.35e-08 $layer=M1 $thickness=3.6e-08
+ $X=0.243 $Y=0.099 $X2=0.243 $Y2=0.0855
r170 121 122 4.19742 $w=1.3e-08 $l=1.8e-08 $layer=M1 $thickness=3.6e-08
+ $X=0.243 $Y=0.117 $X2=0.243 $Y2=0.099
r171 120 121 4.19742 $w=1.3e-08 $l=1.8e-08 $layer=M1 $thickness=3.6e-08
+ $X=0.243 $Y=0.135 $X2=0.243 $Y2=0.117
r172 119 120 4.19742 $w=1.3e-08 $l=1.8e-08 $layer=M1 $thickness=3.6e-08
+ $X=0.243 $Y=0.153 $X2=0.243 $Y2=0.135
r173 118 119 4.19742 $w=1.3e-08 $l=1.8e-08 $layer=M1 $thickness=3.6e-08
+ $X=0.243 $Y=0.171 $X2=0.243 $Y2=0.153
r174 116 117 1.80722 $w=1.3e-08 $l=7.7e-09 $layer=M1 $thickness=3.6e-08
+ $X=0.243 $Y=0.21 $X2=0.243 $Y2=0.2177
r175 116 83 3.55614 $w=1.3e-08 $l=1.53e-08 $layer=M1 $thickness=3.6e-08
+ $X=0.243 $Y=0.21 $X2=0.243 $Y2=0.1947
r176 83 118 5.53826 $w=1.3e-08 $l=2.37e-08 $layer=M1 $thickness=3.6e-08
+ $X=0.243 $Y=0.1947 $X2=0.243 $Y2=0.171
r177 115 113 0.0308642 $w=8.1e-08 $l=2.5e-09 $layer=P_src_drn $thickness=1e-09
+ $X=0.1253 $Y=0.2025 $X2=0.1225 $Y2=0.2025
r178 2 113 0.179012 $w=8.1e-08 $l=1.45e-08 $layer=P_src_drn $thickness=1e-09
+ $X=0.108 $Y=0.2025 $X2=0.1225 $Y2=0.2025
r179 57 2 0.179012 $w=8.1e-08 $l=1.45e-08 $layer=P_src_drn $thickness=1e-09
+ $X=0.0935 $Y=0.2025 $X2=0.108 $Y2=0.2025
r180 114 57 0.0308642 $w=8.1e-08 $l=2.5e-09 $layer=P_src_drn $thickness=1e-09
+ $X=0.0906 $Y=0.2025 $X2=0.0935 $Y2=0.2025
r181 4 110 19.3796 $a=3.24e-16 $layer=V0LISD $X=0.216 $Y=0.2025 $X2=0.2165
+ $Y2=0.234
r182 68 111 1.96775 $w=1.63333e-08 $l=1.35e-08 $layer=M1 $thickness=3.6e-08
+ $X=0.243 $Y=0.234 $X2=0.2295 $Y2=0.234
r183 68 117 2.60903 $w=1.57692e-08 $l=1.63e-08 $layer=M1 $thickness=3.6e-08
+ $X=0.243 $Y=0.234 $X2=0.243 $Y2=0.2177
r184 68 84 5.81538 $w=1.45e-08 $l=3e-08 $layer=M1 $thickness=3.6e-08 $X=0.243
+ $Y=0.234 $X2=0.273 $Y2=0.234
r185 2 105 19.3796 $a=3.24e-16 $layer=V0LISD $X=0.108 $Y=0.2025 $X2=0.108
+ $Y2=0.234
r186 110 111 3.03147 $w=1.3e-08 $l=1.3e-08 $layer=M1 $thickness=3.6e-08
+ $X=0.2165 $Y=0.234 $X2=0.2295 $Y2=0.234
r187 109 110 2.09871 $w=1.3e-08 $l=9e-09 $layer=M1 $thickness=3.6e-08 $X=0.2075
+ $Y=0.234 $X2=0.2165 $Y2=0.234
r188 108 109 9.56078 $w=1.3e-08 $l=4.1e-08 $layer=M1 $thickness=3.6e-08
+ $X=0.1665 $Y=0.234 $X2=0.2075 $Y2=0.234
r189 107 108 9.91056 $w=1.3e-08 $l=4.25e-08 $layer=M1 $thickness=3.6e-08
+ $X=0.124 $Y=0.234 $X2=0.1665 $Y2=0.234
r190 106 107 1.04935 $w=1.3e-08 $l=4.5e-09 $layer=M1 $thickness=3.6e-08
+ $X=0.1195 $Y=0.234 $X2=0.124 $Y2=0.234
r191 105 106 2.68168 $w=1.3e-08 $l=1.15e-08 $layer=M1 $thickness=3.6e-08
+ $X=0.108 $Y=0.234 $X2=0.1195 $Y2=0.234
r192 82 105 3.14806 $w=1.3e-08 $l=1.35e-08 $layer=M1 $thickness=3.6e-08
+ $X=0.0945 $Y=0.234 $X2=0.108 $Y2=0.234
r193 66 104 9.89378 $w=1.47818e-08 $l=4.95e-08 $layer=M1 $thickness=3.6e-08
+ $X=0.081 $Y=0.234 $X2=0.081 $Y2=0.1845
r194 66 82 1.49895 $w=1.63333e-08 $l=1.35e-08 $layer=M1 $thickness=3.6e-08
+ $X=0.081 $Y=0.234 $X2=0.0945 $Y2=0.234
r195 103 104 11.5429 $w=1.3e-08 $l=4.95e-08 $layer=M1 $thickness=3.6e-08
+ $X=0.081 $Y=0.135 $X2=0.081 $Y2=0.1845
r196 81 102 6.16517 $w=1.44286e-08 $l=3.15e-08 $layer=M1 $thickness=3.6e-08
+ $X=0.081 $Y=0.1035 $X2=0.081 $Y2=0.072
r197 81 103 7.34548 $w=1.3e-08 $l=3.15e-08 $layer=M1 $thickness=3.6e-08
+ $X=0.081 $Y=0.1035 $X2=0.081 $Y2=0.135
r198 65 100 3.14806 $w=1.3e-08 $l=1.35e-08 $layer=M1 $thickness=3.6e-08
+ $X=0.0945 $Y=0.072 $X2=0.108 $Y2=0.072
r199 65 102 1.96775 $w=1.63333e-08 $l=1.35e-08 $layer=M1 $thickness=3.6e-08
+ $X=0.0945 $Y=0.072 $X2=0.081 $Y2=0.072
r200 1 100 19.3796 $a=3.24e-16 $layer=V0LISD $X=0.108 $Y=0.0675 $X2=0.108
+ $Y2=0.072
r201 99 97 0.0308642 $w=8.1e-08 $l=2.5e-09 $layer=N_src_drn $thickness=1e-09
+ $X=0.1253 $Y=0.0675 $X2=0.1225 $Y2=0.0675
r202 1 97 0.179012 $w=8.1e-08 $l=1.45e-08 $layer=N_src_drn $thickness=1e-09
+ $X=0.108 $Y=0.0675 $X2=0.1225 $Y2=0.0675
r203 49 1 0.179012 $w=8.1e-08 $l=1.45e-08 $layer=N_src_drn $thickness=1e-09
+ $X=0.0935 $Y=0.0675 $X2=0.108 $Y2=0.0675
r204 98 49 0.0308642 $w=8.1e-08 $l=2.5e-09 $layer=N_src_drn $thickness=1e-09
+ $X=0.0906 $Y=0.0675 $X2=0.0935 $Y2=0.0675
.ends

.subckt PM_CKINVDCx16_ASAP7_75t_R%9 vss 19 23 33 36 46 47 50 51 18 1 3 4 15 9
+ 12 16 14 10
c1 1 vss 0.00633072f $X=0.297 $Y=0.135
c2 3 vss 0.00715145f $X=0.324 $Y=0.0675
c3 4 vss 0.0072106f $X=0.432 $Y=0.0675
c4 9 vss 0.0823545f $X=0.297 $Y=0.0245
c5 10 vss 0.0821592f $X=0.351 $Y=0.135
c6 11 vss 0.00638381f $X=0.3095 $Y=0.0675
c7 12 vss 0.00688031f $X=0.4175 $Y=0.0675
c8 13 vss 0.000348699f $X=0.351 $Y=0.099
c9 14 vss 0.000207301f $X=0.351 $Y=0.135
c10 15 vss 0.00129223f $X=0.3095 $Y=0.099
c11 16 vss 0.000601459f $X=0.307 $Y=0.135
c12 17 vss 0.000149605f $X=0.351 $Y=0.117
c13 18 vss 0.00245978f $X=0.378 $Y=0.099
r1 51 49 0.0308642 $w=8.1e-08 $l=2.5e-09 $layer=N_src_drn $thickness=1e-09
+ $X=0.4493 $Y=0.0675 $X2=0.4465 $Y2=0.0675
r2 4 49 0.179012 $w=8.1e-08 $l=1.45e-08 $layer=N_src_drn $thickness=1e-09
+ $X=0.432 $Y=0.0675 $X2=0.4465 $Y2=0.0675
r3 12 4 0.179012 $w=8.1e-08 $l=1.45e-08 $layer=N_src_drn $thickness=1e-09
+ $X=0.4175 $Y=0.0675 $X2=0.432 $Y2=0.0675
r4 50 12 0.0308642 $w=8.1e-08 $l=2.5e-09 $layer=N_src_drn $thickness=1e-09
+ $X=0.4146 $Y=0.0675 $X2=0.4175 $Y2=0.0675
r5 47 45 0.0308642 $w=8.1e-08 $l=2.5e-09 $layer=N_src_drn $thickness=1e-09
+ $X=0.3413 $Y=0.0675 $X2=0.3385 $Y2=0.0675
r6 3 45 0.179012 $w=8.1e-08 $l=1.45e-08 $layer=N_src_drn $thickness=1e-09
+ $X=0.324 $Y=0.0675 $X2=0.3385 $Y2=0.0675
r7 11 3 0.179012 $w=8.1e-08 $l=1.45e-08 $layer=N_src_drn $thickness=1e-09
+ $X=0.3095 $Y=0.0675 $X2=0.324 $Y2=0.0675
r8 46 11 0.0308642 $w=8.1e-08 $l=2.5e-09 $layer=N_src_drn $thickness=1e-09
+ $X=0.3066 $Y=0.0675 $X2=0.3095 $Y2=0.0675
r9 4 42 19.3796 $a=3.24e-16 $layer=V0LISD $X=0.432 $Y=0.0675 $X2=0.432 $Y2=0.099
r10 3 38 19.3796 $a=3.24e-16 $layer=V0LISD $X=0.324 $Y=0.0675 $X2=0.324
+ $Y2=0.099
r11 41 42 5.24677 $w=1.3e-08 $l=2.25e-08 $layer=M1 $thickness=3.6e-08 $X=0.4095
+ $Y=0.099 $X2=0.432 $Y2=0.099
r12 18 41 7.34548 $w=1.3e-08 $l=3.15e-08 $layer=M1 $thickness=3.6e-08 $X=0.378
+ $Y=0.099 $X2=0.4095 $Y2=0.099
r13 38 39 3.14806 $w=1.3e-08 $l=1.35e-08 $layer=M1 $thickness=3.6e-08 $X=0.324
+ $Y=0.099 $X2=0.3375 $Y2=0.099
r14 15 38 3.38125 $w=1.3e-08 $l=1.45e-08 $layer=M1 $thickness=3.6e-08 $X=0.3095
+ $Y=0.099 $X2=0.324 $Y2=0.099
r15 13 17 3.01711 $w=1.55e-08 $l=1.8e-08 $layer=M1 $thickness=3.6e-08 $X=0.351
+ $Y=0.099 $X2=0.351 $Y2=0.117
r16 13 39 1.96775 $w=1.63333e-08 $l=1.35e-08 $layer=M1 $thickness=3.6e-08
+ $X=0.351 $Y=0.099 $X2=0.3375 $Y2=0.099
r17 13 18 5.11582 $w=1.46667e-08 $l=2.7e-08 $layer=M1 $thickness=3.6e-08
+ $X=0.351 $Y=0.099 $X2=0.378 $Y2=0.099
r18 14 31 1.49895 $w=1.63333e-08 $l=1.35e-08 $layer=M1 $thickness=3.6e-08
+ $X=0.351 $Y=0.135 $X2=0.3375 $Y2=0.135
r19 14 17 2.5483 $w=1.79e-08 $l=1.8e-08 $layer=M1 $thickness=3.6e-08 $X=0.351
+ $Y=0.135 $X2=0.351 $Y2=0.117
r20 36 35 16.4967 $w=2.1e-08 $l=4.85e-08 $layer=Gate_1 $thickness=5.6e-08
+ $X=0.351 $Y=0.2025 $X2=0.351 $Y2=0.154
r21 33 34 16.4967 $w=2.1e-08 $l=4.85e-08 $layer=Gate_1 $thickness=5.6e-08
+ $X=0.351 $Y=0.0675 $X2=0.351 $Y2=0.116
r22 10 27 6.54019 $w=2.09524e-08 $layer=Gate_1 $thickness=5.21905e-08 $X=0.351
+ $Y=0.135 $X2=0.351 $Y2=0.135
r23 10 34 6.6497 $w=2.04211e-08 $l=1.9e-08 $layer=Gate_1 $thickness=5.6e-08
+ $X=0.351 $Y=0.135 $X2=0.351 $Y2=0.116
r24 10 35 6.6497 $w=2.04211e-08 $l=1.9e-08 $layer=Gate_1 $thickness=5.6e-08
+ $X=0.351 $Y=0.135 $X2=0.351 $Y2=0.154
r25 30 31 3.14806 $w=1.3e-08 $l=1.35e-08 $layer=M1 $thickness=3.6e-08 $X=0.324
+ $Y=0.135 $X2=0.3375 $Y2=0.135
r26 29 30 2.68168 $w=1.3e-08 $l=1.15e-08 $layer=M1 $thickness=3.6e-08 $X=0.3125
+ $Y=0.135 $X2=0.324 $Y2=0.135
r27 16 29 1.28254 $w=1.3e-08 $l=5.5e-09 $layer=M1 $thickness=3.6e-08 $X=0.307
+ $Y=0.135 $X2=0.3125 $Y2=0.135
r28 26 27 12.6539 $w=1.77815e-08 $l=2.7e-08 $layer=LIG $thickness=4.8e-08
+ $X=0.324 $Y=0.135 $X2=0.351 $Y2=0.135
r29 26 30 19.3796 $a=3.24e-16 $layer=V0LIG $X=0.324 $Y=0.135 $X2=0.324 $Y2=0.135
r30 1 21 6.54019 $w=2.09524e-08 $layer=Gate_1 $thickness=5.21905e-08 $X=0.297
+ $Y=0.135 $X2=0.297 $Y2=0.135
r31 1 26 12.6539 $w=1.77815e-08 $l=2.7e-08 $layer=LIG $thickness=4.8e-08
+ $X=0.297 $Y=0.135 $X2=0.324 $Y2=0.135
r32 23 22 16.4967 $w=2.1e-08 $l=4.85e-08 $layer=Gate_1 $thickness=5.6e-08
+ $X=0.297 $Y=0.2025 $X2=0.297 $Y2=0.154
r33 21 22 6.6497 $w=2.04211e-08 $l=1.9e-08 $layer=Gate_1 $thickness=5.6e-08
+ $X=0.297 $Y=0.135 $X2=0.297 $Y2=0.154
r34 20 21 6.6497 $w=2.04211e-08 $l=1.9e-08 $layer=Gate_1 $thickness=5.6e-08
+ $X=0.297 $Y=0.116 $X2=0.297 $Y2=0.135
r35 19 20 16.4967 $w=2.1e-08 $l=4.85e-08 $layer=Gate_1 $thickness=5.6e-08
+ $X=0.297 $Y=0.0675 $X2=0.297 $Y2=0.116
r36 19 9 14.6259 $w=2.1e-08 $l=4.3e-08 $layer=Gate_1 $thickness=5.6e-08
+ $X=0.297 $Y=0.0675 $X2=0.297 $Y2=0.0245
.ends

.subckt PM_CKINVDCx16_ASAP7_75t_R%6 vss 19 23 33 36 46 47 50 51 18 1 3 4 15 9
+ 12 16 14 10
c1 1 vss 0.00633078f $X=0.729 $Y=0.135
c2 3 vss 0.00715548f $X=0.756 $Y=0.0675
c3 4 vss 0.00721364f $X=0.864 $Y=0.0675
c4 9 vss 0.0823672f $X=0.729 $Y=0.0245
c5 10 vss 0.0821675f $X=0.783 $Y=0.135
c6 11 vss 0.00647166f $X=0.7415 $Y=0.0675
c7 12 vss 0.00697693f $X=0.8495 $Y=0.0675
c8 13 vss 0.000349147f $X=0.783 $Y=0.099
c9 14 vss 0.000207975f $X=0.783 $Y=0.135
c10 15 vss 0.00130112f $X=0.7415 $Y=0.099
c11 16 vss 0.000612008f $X=0.739 $Y=0.135
c12 17 vss 0.000149607f $X=0.783 $Y=0.117
c13 18 vss 0.00247523f $X=0.81 $Y=0.099
r1 51 49 0.0308642 $w=8.1e-08 $l=2.5e-09 $layer=N_src_drn $thickness=1e-09
+ $X=0.8813 $Y=0.0675 $X2=0.8785 $Y2=0.0675
r2 4 49 0.179012 $w=8.1e-08 $l=1.45e-08 $layer=N_src_drn $thickness=1e-09
+ $X=0.864 $Y=0.0675 $X2=0.8785 $Y2=0.0675
r3 12 4 0.179012 $w=8.1e-08 $l=1.45e-08 $layer=N_src_drn $thickness=1e-09
+ $X=0.8495 $Y=0.0675 $X2=0.864 $Y2=0.0675
r4 50 12 0.0308642 $w=8.1e-08 $l=2.5e-09 $layer=N_src_drn $thickness=1e-09
+ $X=0.8466 $Y=0.0675 $X2=0.8495 $Y2=0.0675
r5 47 45 0.0308642 $w=8.1e-08 $l=2.5e-09 $layer=N_src_drn $thickness=1e-09
+ $X=0.7733 $Y=0.0675 $X2=0.7705 $Y2=0.0675
r6 3 45 0.179012 $w=8.1e-08 $l=1.45e-08 $layer=N_src_drn $thickness=1e-09
+ $X=0.756 $Y=0.0675 $X2=0.7705 $Y2=0.0675
r7 11 3 0.179012 $w=8.1e-08 $l=1.45e-08 $layer=N_src_drn $thickness=1e-09
+ $X=0.7415 $Y=0.0675 $X2=0.756 $Y2=0.0675
r8 46 11 0.0308642 $w=8.1e-08 $l=2.5e-09 $layer=N_src_drn $thickness=1e-09
+ $X=0.7386 $Y=0.0675 $X2=0.7415 $Y2=0.0675
r9 4 42 19.3796 $a=3.24e-16 $layer=V0LISD $X=0.864 $Y=0.0675 $X2=0.864 $Y2=0.099
r10 3 38 19.3796 $a=3.24e-16 $layer=V0LISD $X=0.756 $Y=0.0675 $X2=0.756
+ $Y2=0.099
r11 41 42 5.24677 $w=1.3e-08 $l=2.25e-08 $layer=M1 $thickness=3.6e-08 $X=0.8415
+ $Y=0.099 $X2=0.864 $Y2=0.099
r12 18 41 7.34548 $w=1.3e-08 $l=3.15e-08 $layer=M1 $thickness=3.6e-08 $X=0.81
+ $Y=0.099 $X2=0.8415 $Y2=0.099
r13 38 39 3.14806 $w=1.3e-08 $l=1.35e-08 $layer=M1 $thickness=3.6e-08 $X=0.756
+ $Y=0.099 $X2=0.7695 $Y2=0.099
r14 15 38 3.38125 $w=1.3e-08 $l=1.45e-08 $layer=M1 $thickness=3.6e-08 $X=0.7415
+ $Y=0.099 $X2=0.756 $Y2=0.099
r15 13 17 3.01711 $w=1.55e-08 $l=1.8e-08 $layer=M1 $thickness=3.6e-08 $X=0.783
+ $Y=0.099 $X2=0.783 $Y2=0.117
r16 13 39 1.96775 $w=1.63333e-08 $l=1.35e-08 $layer=M1 $thickness=3.6e-08
+ $X=0.783 $Y=0.099 $X2=0.7695 $Y2=0.099
r17 13 18 5.11582 $w=1.46667e-08 $l=2.7e-08 $layer=M1 $thickness=3.6e-08
+ $X=0.783 $Y=0.099 $X2=0.81 $Y2=0.099
r18 14 31 1.49895 $w=1.63333e-08 $l=1.35e-08 $layer=M1 $thickness=3.6e-08
+ $X=0.783 $Y=0.135 $X2=0.7695 $Y2=0.135
r19 14 17 2.5483 $w=1.79e-08 $l=1.8e-08 $layer=M1 $thickness=3.6e-08 $X=0.783
+ $Y=0.135 $X2=0.783 $Y2=0.117
r20 36 35 16.4967 $w=2.1e-08 $l=4.85e-08 $layer=Gate_1 $thickness=5.6e-08
+ $X=0.783 $Y=0.2025 $X2=0.783 $Y2=0.154
r21 33 34 16.4967 $w=2.1e-08 $l=4.85e-08 $layer=Gate_1 $thickness=5.6e-08
+ $X=0.783 $Y=0.0675 $X2=0.783 $Y2=0.116
r22 10 27 6.54019 $w=2.09524e-08 $layer=Gate_1 $thickness=5.21905e-08 $X=0.783
+ $Y=0.135 $X2=0.783 $Y2=0.135
r23 10 34 6.6497 $w=2.04211e-08 $l=1.9e-08 $layer=Gate_1 $thickness=5.6e-08
+ $X=0.783 $Y=0.135 $X2=0.783 $Y2=0.116
r24 10 35 6.6497 $w=2.04211e-08 $l=1.9e-08 $layer=Gate_1 $thickness=5.6e-08
+ $X=0.783 $Y=0.135 $X2=0.783 $Y2=0.154
r25 30 31 3.14806 $w=1.3e-08 $l=1.35e-08 $layer=M1 $thickness=3.6e-08 $X=0.756
+ $Y=0.135 $X2=0.7695 $Y2=0.135
r26 29 30 2.68168 $w=1.3e-08 $l=1.15e-08 $layer=M1 $thickness=3.6e-08 $X=0.7445
+ $Y=0.135 $X2=0.756 $Y2=0.135
r27 16 29 1.28254 $w=1.3e-08 $l=5.5e-09 $layer=M1 $thickness=3.6e-08 $X=0.739
+ $Y=0.135 $X2=0.7445 $Y2=0.135
r28 26 27 12.6539 $w=1.77815e-08 $l=2.7e-08 $layer=LIG $thickness=4.8e-08
+ $X=0.756 $Y=0.135 $X2=0.783 $Y2=0.135
r29 26 30 19.3796 $a=3.24e-16 $layer=V0LIG $X=0.756 $Y=0.135 $X2=0.756 $Y2=0.135
r30 1 21 6.54019 $w=2.09524e-08 $layer=Gate_1 $thickness=5.21905e-08 $X=0.729
+ $Y=0.135 $X2=0.729 $Y2=0.135
r31 1 26 12.6539 $w=1.77815e-08 $l=2.7e-08 $layer=LIG $thickness=4.8e-08
+ $X=0.729 $Y=0.135 $X2=0.756 $Y2=0.135
r32 23 22 16.4967 $w=2.1e-08 $l=4.85e-08 $layer=Gate_1 $thickness=5.6e-08
+ $X=0.729 $Y=0.2025 $X2=0.729 $Y2=0.154
r33 21 22 6.6497 $w=2.04211e-08 $l=1.9e-08 $layer=Gate_1 $thickness=5.6e-08
+ $X=0.729 $Y=0.135 $X2=0.729 $Y2=0.154
r34 20 21 6.6497 $w=2.04211e-08 $l=1.9e-08 $layer=Gate_1 $thickness=5.6e-08
+ $X=0.729 $Y=0.116 $X2=0.729 $Y2=0.135
r35 19 20 16.4967 $w=2.1e-08 $l=4.85e-08 $layer=Gate_1 $thickness=5.6e-08
+ $X=0.729 $Y=0.0675 $X2=0.729 $Y2=0.116
r36 19 9 14.6259 $w=2.1e-08 $l=4.3e-08 $layer=Gate_1 $thickness=5.6e-08
+ $X=0.729 $Y=0.0675 $X2=0.729 $Y2=0.0245
.ends

* End of included file CKINVDCx16_ASAP7_75t_R.pex.sp.pex

*
.subckt CKINVDCx16_ASAP7_75t_CUSTOM_4_25_0_7 VSS VDD A Y
*
* VSS VSS
* VDD VDD
* A A
* Y Y
*
*

M0 N_M0_d N_M0_g VSS VSS nmos_rvt L=2e-08 W=8.1e-08 nfin=3 $X=0.071 $Y=0.027
M1 N_M1_d N_M1_g VSS VSS nmos_rvt L=2e-08 W=8.1e-08 nfin=3 $X=0.125 $Y=0.027
M2 N_M2_d N_M2_g VSS VSS nmos_rvt L=2e-08 W=8.1e-08 nfin=3 $X=0.179 $Y=0.027
M3 N_M3_d N_M3_g VSS VSS nmos_rvt L=2e-08 W=8.1e-08 nfin=3 $X=0.233 $Y=0.027
M22 N_M22_d N_M22_g VSS VSS nmos_rvt L=2e-08 W=8.1e-08 nfin=3 $X=0.287 $Y=0.027
M23 N_M23_d N_M23_g VSS VSS nmos_rvt L=2e-08 W=8.1e-08 nfin=3 $X=0.341 $Y=0.027
M20 N_M20_d N_M20_g VSS VSS nmos_rvt L=2e-08 W=8.1e-08 nfin=3 $X=0.395 $Y=0.027
M21 N_M21_d N_M21_g VSS VSS nmos_rvt L=2e-08 W=8.1e-08 nfin=3 $X=0.449 $Y=0.027
M8 N_M8_d N_M8_g VSS VSS nmos_rvt L=2e-08 W=8.1e-08 nfin=3 $X=0.503 $Y=0.027
M9 N_M9_d N_M9_g VSS VSS nmos_rvt L=2e-08 W=8.1e-08 nfin=3 $X=0.557 $Y=0.027
M10 N_M10_d N_M10_g VSS VSS nmos_rvt L=2e-08 W=8.1e-08 nfin=3 $X=0.611 $Y=0.027
M11 N_M11_d N_M11_g VSS VSS nmos_rvt L=2e-08 W=8.1e-08 nfin=3 $X=0.665 $Y=0.027
M12 N_M12_d N_M12_g VSS VSS nmos_rvt L=2e-08 W=8.1e-08 nfin=3 $X=0.719 $Y=0.027
M13 N_M13_d N_M13_g VSS VSS nmos_rvt L=2e-08 W=8.1e-08 nfin=3 $X=0.773 $Y=0.027
M14 N_M14_d N_M14_g VSS VSS nmos_rvt L=2e-08 W=8.1e-08 nfin=3 $X=0.827 $Y=0.027
M15 N_M15_d N_M15_g VSS VSS nmos_rvt L=2e-08 W=8.1e-08 nfin=3 $X=0.881 $Y=0.027
M16 N_M16_d N_M16_g VSS VSS nmos_rvt L=2e-08 W=8.1e-08 nfin=3 $X=0.935 $Y=0.027
M17 N_M17_d N_M17_g VSS VSS nmos_rvt L=2e-08 W=8.1e-08 nfin=3 $X=0.989 $Y=0.027
M18 N_M18_d N_M18_g VSS VSS nmos_rvt L=2e-08 W=8.1e-08 nfin=3 $X=1.043 $Y=0.027
M19 N_M19_d N_M19_g VSS VSS nmos_rvt L=2e-08 W=8.1e-08 nfin=3 $X=1.097 $Y=0.027
M6 N_M6_d N_M6_g VSS VSS nmos_rvt L=2e-08 W=8.1e-08 nfin=3 $X=1.151 $Y=0.027
M7 N_M7_d N_M7_g VSS VSS nmos_rvt L=2e-08 W=8.1e-08 nfin=3 $X=1.205 $Y=0.027
M4 N_M4_d N_M4_g VSS VSS nmos_rvt L=2e-08 W=8.1e-08 nfin=3 $X=1.259 $Y=0.027
M5 N_M5_d N_M5_g VSS VSS nmos_rvt L=2e-08 W=8.1e-08 nfin=3 $X=1.313 $Y=0.027
M24 N_M24_d N_M24_g VSS VSS nmos_rvt L=2e-08 W=8.1e-08 nfin=3 $X=1.367 $Y=0.027
M25 N_M25_d N_M25_g VSS VSS nmos_rvt L=2e-08 W=8.1e-08 nfin=3 $X=1.421 $Y=0.027
M26 N_M26_d N_M26_g VSS VSS nmos_rvt L=2e-08 W=8.1e-08 nfin=3 $X=1.475 $Y=0.027
M27 N_M27_d N_M27_g VSS VSS nmos_rvt L=2e-08 W=8.1e-08 nfin=3 $X=1.529 $Y=0.027
M28 N_M28_d N_M28_g VDD VDD pmos_rvt L=2e-08 W=8.1e-08 nfin=3 $X=0.071 $Y=0.162
M29 N_M29_d N_M29_g VDD VDD pmos_rvt L=2e-08 W=8.1e-08 nfin=3 $X=0.125 $Y=0.162
M30 N_M30_d N_M30_g VDD VDD pmos_rvt L=2e-08 W=8.1e-08 nfin=3 $X=0.179 $Y=0.162
M31 N_M31_d N_M31_g VDD VDD pmos_rvt L=2e-08 W=8.1e-08 nfin=3 $X=0.233 $Y=0.162
M50 N_M50_d N_M50_g VDD VDD pmos_rvt L=2e-08 W=8.1e-08 nfin=3 $X=0.287 $Y=0.162
M51 N_M51_d N_M51_g VDD VDD pmos_rvt L=2e-08 W=8.1e-08 nfin=3 $X=0.341 $Y=0.162
M48 N_M48_d N_M48_g VDD VDD pmos_rvt L=2e-08 W=8.1e-08 nfin=3 $X=0.395 $Y=0.162
M49 N_M49_d N_M49_g VDD VDD pmos_rvt L=2e-08 W=8.1e-08 nfin=3 $X=0.449 $Y=0.162
M36 N_M36_d N_M36_g VDD VDD pmos_rvt L=2e-08 W=8.1e-08 nfin=3 $X=0.503 $Y=0.162
M37 N_M37_d N_M37_g VDD VDD pmos_rvt L=2e-08 W=8.1e-08 nfin=3 $X=0.557 $Y=0.162
M38 N_M38_d N_M38_g VDD VDD pmos_rvt L=2e-08 W=8.1e-08 nfin=3 $X=0.611 $Y=0.162
M39 N_M39_d N_M39_g VDD VDD pmos_rvt L=2e-08 W=8.1e-08 nfin=3 $X=0.665 $Y=0.162
M40 N_M40_d N_M40_g VDD VDD pmos_rvt L=2e-08 W=8.1e-08 nfin=3 $X=0.719 $Y=0.162
M41 N_M41_d N_M41_g VDD VDD pmos_rvt L=2e-08 W=8.1e-08 nfin=3 $X=0.773 $Y=0.162
M42 N_M42_d N_M42_g VDD VDD pmos_rvt L=2e-08 W=8.1e-08 nfin=3 $X=0.827 $Y=0.162
M43 N_M43_d N_M43_g VDD VDD pmos_rvt L=2e-08 W=8.1e-08 nfin=3 $X=0.881 $Y=0.162
M44 N_M44_d N_M44_g VDD VDD pmos_rvt L=2e-08 W=8.1e-08 nfin=3 $X=0.935 $Y=0.162
M45 N_M45_d N_M45_g VDD VDD pmos_rvt L=2e-08 W=8.1e-08 nfin=3 $X=0.989 $Y=0.162
M46 N_M46_d N_M46_g VDD VDD pmos_rvt L=2e-08 W=8.1e-08 nfin=3 $X=1.043 $Y=0.162
M47 N_M47_d N_M47_g VDD VDD pmos_rvt L=2e-08 W=8.1e-08 nfin=3 $X=1.097 $Y=0.162
M34 N_M34_d N_M34_g VDD VDD pmos_rvt L=2e-08 W=8.1e-08 nfin=3 $X=1.151 $Y=0.162
M35 N_M35_d N_M35_g VDD VDD pmos_rvt L=2e-08 W=8.1e-08 nfin=3 $X=1.205 $Y=0.162
M32 N_M32_d N_M32_g VDD VDD pmos_rvt L=2e-08 W=8.1e-08 nfin=3 $X=1.259 $Y=0.162
M33 N_M33_d N_M33_g VDD VDD pmos_rvt L=2e-08 W=8.1e-08 nfin=3 $X=1.313 $Y=0.162
M52 N_M52_d N_M52_g VDD VDD pmos_rvt L=2e-08 W=8.1e-08 nfin=3 $X=1.367 $Y=0.162
M53 N_M53_d N_M53_g VDD VDD pmos_rvt L=2e-08 W=8.1e-08 nfin=3 $X=1.421 $Y=0.162
M54 N_M54_d N_M54_g VDD VDD pmos_rvt L=2e-08 W=8.1e-08 nfin=3 $X=1.475 $Y=0.162
M55 N_M55_d N_M55_g VDD VDD pmos_rvt L=2e-08 W=8.1e-08 nfin=3 $X=1.529 $Y=0.162

* .include "CKINVDCx16_ASAP7_75t_R.pex.sp.pxi"

* Start of included file CKINVDCx16_ASAP7_75t_R.pex.sp.pxi
x_PM_CKINVDCx16_ASAP7_75t_R%8 vss N_M20_g N_M48_g N_M21_g N_M49_g N_M50_d
+ N_M51_d N_M48_d N_M49_d N_8_10 N_8_15 N_8_17 N_8_3 N_8_1 N_8_11 N_8_13 N_8_9
+ N_8_4 N_8_18 PM_CKINVDCx16_ASAP7_75t_R%8
cc_1 N_8_10 N_A_38 3.38501e-20 $X=0.459 $Y=0.135
cc_2 N_8_10 N_A_40 4.29131e-20 $X=0.459 $Y=0.135
cc_3 N_8_10 N_A_1 9.07519e-20 $X=0.459 $Y=0.135
cc_4 N_8_10 N_A_2 0.00137093f $X=0.459 $Y=0.135
cc_5 N_8_10 N_A_17 0.00359162f $X=0.459 $Y=0.135
cc_6 N_8_10 N_9_12 0.0390725f $X=0.459 $Y=0.135
cc_7 N_8_15 N_9_16 0.00127431f $X=0.378 $Y=0.171
cc_8 N_8_17 N_9_18 0.00131895f $X=0.4185 $Y=0.135
cc_9 N_8_10 N_9_4 0.00143019f $X=0.459 $Y=0.135
cc_10 N_8_3 N_9_9 0.00143019f $X=0.324 $Y=0.2025
cc_11 N_8_3 N_9_1 0.00174171f $X=0.324 $Y=0.2025
cc_12 N_8_1 N_9_4 0.00174171f $X=0.405 $Y=0.135
cc_13 N_8_11 N_9_1 0.00298526f $X=0.3095 $Y=0.2025
cc_14 N_8_1 N_9_12 0.00298526f $X=0.405 $Y=0.135
cc_15 N_8_15 N_9_14 0.00379838f $X=0.378 $Y=0.171
cc_16 N_8_13 N_9_18 0.003812f $X=0.405 $Y=0.135
cc_17 N_8_11 N_9_9 0.0192036f $X=0.3095 $Y=0.2025
cc_18 N_8_9 N_9_12 0.0315253f $X=0.405 $Y=0.0245
cc_19 N_8_11 N_9_10 0.0524381f $X=0.3095 $Y=0.2025
x_PM_CKINVDCx16_ASAP7_75t_R%7 vss N_M14_g N_M42_g N_M15_g N_M43_g N_M40_d
+ N_M41_d N_M42_d N_M43_d N_7_10 N_7_15 N_7_17 N_7_3 N_7_1 N_7_11 N_7_13 N_7_9
+ N_7_4 N_7_18 PM_CKINVDCx16_ASAP7_75t_R%7
cc_20 N_7_10 N_A_44 3.84918e-20 $X=0.891 $Y=0.135
cc_21 N_7_10 N_A_2 9.07519e-20 $X=0.891 $Y=0.135
cc_22 N_7_10 N_A_3 0.00136714f $X=0.891 $Y=0.135
cc_23 N_7_10 N_A_21 0.00365525f $X=0.891 $Y=0.135
cc_24 N_7_10 N_6_12 0.0390725f $X=0.891 $Y=0.135
cc_25 N_7_15 N_6_16 0.00126287f $X=0.81 $Y=0.171
cc_26 N_7_17 N_6_18 0.00131996f $X=0.8505 $Y=0.135
cc_27 N_7_10 N_6_4 0.00143019f $X=0.891 $Y=0.135
cc_28 N_7_3 N_6_9 0.00143019f $X=0.756 $Y=0.2025
cc_29 N_7_3 N_6_1 0.00174171f $X=0.756 $Y=0.2025
cc_30 N_7_1 N_6_4 0.00174171f $X=0.837 $Y=0.135
cc_31 N_7_11 N_6_1 0.00298526f $X=0.7415 $Y=0.2025
cc_32 N_7_1 N_6_12 0.00298526f $X=0.837 $Y=0.135
cc_33 N_7_15 N_6_14 0.00379838f $X=0.81 $Y=0.171
cc_34 N_7_13 N_6_18 0.003812f $X=0.837 $Y=0.135
cc_35 N_7_11 N_6_9 0.0192036f $X=0.7415 $Y=0.2025
cc_36 N_7_9 N_6_12 0.0315253f $X=0.837 $Y=0.0245
cc_37 N_7_11 N_6_10 0.0524407f $X=0.7415 $Y=0.2025
x_PM_CKINVDCx16_ASAP7_75t_R%5 vss N_M6_g N_M34_g N_M7_g N_M35_g N_M34_d N_M35_d
+ N_M32_d N_M33_d N_5_9 N_5_18 N_5_16 N_5_4 N_5_1 N_5_12 N_5_13 N_5_10 N_5_3
+ N_5_15 PM_CKINVDCx16_ASAP7_75t_R%5
cc_38 N_5_9 N_A_44 3.85567e-20 $X=1.161 $Y=0.0245
cc_39 N_5_9 N_A_3 0.00149475f $X=1.161 $Y=0.0245
cc_40 N_5_9 N_A_4 9.06434e-20 $X=1.161 $Y=0.0245
cc_41 N_5_9 N_A_24 0.00366115f $X=1.161 $Y=0.0245
x_PM_CKINVDCx16_ASAP7_75t_R%4 vss N_M4_g N_M32_g N_M5_g N_M33_g N_M6_d N_M7_d
+ N_M4_d N_M5_d N_4_15 N_4_1 N_4_4 N_4_3 N_4_17 N_4_10 N_4_11 N_4_18 N_4_14
+ N_4_9 PM_CKINVDCx16_ASAP7_75t_R%4
cc_42 N_4_15 N_A_25 3.94007e-20 $X=1.242 $Y=0.099
cc_43 N_4_15 N_A_4 0.000685255f $X=1.242 $Y=0.099
cc_44 N_4_1 N_A_4 0.000634033f $X=1.269 $Y=0.135
cc_45 N_4_4 N_A_45 0.000743171f $X=1.296 $Y=0.0675
cc_46 N_4_3 N_A_45 0.000749204f $X=1.188 $Y=0.0675
cc_47 N_4_17 N_A_45 0.00080179f $X=1.2825 $Y=0.099
cc_48 N_4_10 N_A_25 0.00348613f $X=1.323 $Y=0.135
cc_49 N_4_15 N_A_45 0.00649292f $X=1.242 $Y=0.099
cc_50 N_4_11 N_5_9 0.0390725f $X=1.1735 $Y=0.0675
cc_51 N_4_18 N_5_18 0.00127432f $X=1.2825 $Y=0.135
cc_52 N_4_15 N_5_16 0.00132001f $X=1.242 $Y=0.099
cc_53 N_4_10 N_5_4 0.00143019f $X=1.323 $Y=0.135
cc_54 N_4_3 N_5_9 0.00143019f $X=1.188 $Y=0.0675
cc_55 N_4_3 N_5_1 0.00173267f $X=1.188 $Y=0.0675
cc_56 N_4_1 N_5_4 0.00173267f $X=1.269 $Y=0.135
cc_57 N_4_11 N_5_1 0.00298389f $X=1.1735 $Y=0.0675
cc_58 N_4_1 N_5_12 0.00298389f $X=1.269 $Y=0.135
cc_59 N_4_14 N_5_18 0.00379834f $X=1.269 $Y=0.135
cc_60 N_4_15 N_5_13 0.003812f $X=1.242 $Y=0.099
cc_61 N_4_10 N_5_12 0.0192036f $X=1.323 $Y=0.135
cc_62 N_4_11 N_5_10 0.0315253f $X=1.1735 $Y=0.0675
cc_63 N_4_9 N_5_12 0.0524407f $X=1.269 $Y=0.0245
x_PM_CKINVDCx16_ASAP7_75t_R%A vss A N_M0_g N_M28_g N_M1_g N_M29_g N_M2_g
+ N_M30_g N_M3_g N_M31_g N_M8_g N_M36_g N_M9_g N_M37_g N_M10_g N_M38_g N_M11_g
+ N_M39_g N_M16_g N_M44_g N_M17_g N_M45_g N_M18_g N_M46_g N_M19_g N_M47_g
+ N_M24_g N_M52_g N_M25_g N_M53_g N_M26_g N_M54_g N_M27_g N_M55_g N_A_37 N_A_1
+ N_A_38 N_A_16 N_A_40 N_A_2 N_A_17 N_A_41 N_A_20 N_A_44 N_A_3 N_A_21 N_A_4
+ N_A_24 N_A_25 N_A_45 N_A_39 N_A_43 N_A_46 N_A_29 N_A_35 N_A_42 N_A_31 N_A_33
+ N_A_48 N_A_32 N_A_34 N_A_14 N_A_18 N_A_28 N_A_30 N_A_36 N_A_47 N_A_15 N_A_19
+ N_A_22 N_A_26 N_A_23 N_A_13 N_A_27 PM_CKINVDCx16_ASAP7_75t_R%A
x_PM_CKINVDCx16_ASAP7_75t_R%Y vss Y N_M0_d N_M1_d N_M28_d N_M29_d N_M30_d
+ N_M31_d N_M2_d N_M3_d N_M36_d N_M37_d N_M38_d N_M39_d N_M8_d N_M9_d N_M10_d
+ N_M11_d N_M44_d N_M45_d N_M46_d N_M47_d N_M16_d N_M17_d N_M18_d N_M19_d
+ N_M52_d N_M53_d N_M54_d N_M55_d N_M24_d N_M25_d N_M26_d N_M27_d N_Y_54 N_Y_71
+ N_Y_75 N_Y_69 N_Y_65 N_Y_79 N_Y_73 N_Y_4 N_Y_8 N_Y_10 N_Y_12 N_Y_14 N_Y_85
+ N_Y_2 N_Y_6 N_Y_16 N_Y_77 N_Y_67 N_Y_1 N_Y_15 N_Y_90 N_Y_82 N_Y_86 N_Y_94
+ N_Y_50 N_Y_51 N_Y_52 N_Y_53 N_Y_55 N_Y_58 N_Y_59 N_Y_60 N_Y_61 N_Y_62 N_Y_63
+ N_Y_57 N_Y_64 N_Y_49 N_Y_56 N_Y_9 N_Y_11 N_Y_7 N_Y_5 N_Y_3 N_Y_13 N_Y_81
+ N_Y_87 N_Y_83 N_Y_93 N_Y_89 N_Y_95 N_Y_91 N_Y_84 N_Y_88 N_Y_92
+ PM_CKINVDCx16_ASAP7_75t_R%Y
cc_64 N_Y_54 N_A_39 2.55303e-20 $X=1.0655 $Y=0.0675
cc_65 N_Y_54 N_A_43 2.55303e-20 $X=1.0655 $Y=0.0675
cc_66 N_Y_54 N_A_46 2.55303e-20 $X=1.0655 $Y=0.0675
cc_67 N_Y_54 N_A_29 2.55433e-20 $X=1.0655 $Y=0.0675
cc_68 N_Y_54 N_A_35 2.55433e-20 $X=1.0655 $Y=0.0675
cc_69 N_Y_54 N_A_42 2.55433e-20 $X=1.0655 $Y=0.0675
cc_70 N_Y_71 N_A_31 2.63205e-20 $X=0.675 $Y=0.072
cc_71 N_Y_75 N_A_33 2.75221e-20 $X=1.107 $Y=0.072
cc_72 N_Y_69 N_A_31 8.01032e-20 $X=0.513 $Y=0.072
cc_73 N_Y_65 N_A_29 8.22286e-20 $X=0.0945 $Y=0.072
cc_74 N_Y_79 N_A_48 8.49574e-20 $X=1.539 $Y=0.072
cc_75 N_Y_73 N_A_33 8.52123e-20 $X=0.945 $Y=0.072
cc_76 N_Y_71 N_A_32 9.95911e-20 $X=0.675 $Y=0.072
cc_77 N_Y_79 N_A_35 0.000102822f $X=1.539 $Y=0.072
cc_78 N_Y_4 N_A_16 0.000104544f $X=0.216 $Y=0.2025
cc_79 N_Y_8 N_A_20 0.0016444f $X=0.648 $Y=0.2025
cc_80 N_Y_10 N_A_21 0.000104544f $X=0.972 $Y=0.2025
cc_81 N_Y_12 N_A_24 0.000104544f $X=1.08 $Y=0.2025
cc_82 N_Y_14 N_A_25 0.000104544f $X=1.404 $Y=0.2025
cc_83 N_Y_73 N_A_34 0.000107306f $X=0.945 $Y=0.072
cc_84 N_Y_85 N_A_32 0.000114573f $X=0.513 $Y=0.2025
cc_85 N_Y_2 N_A_14 0.00161286f $X=0.108 $Y=0.2025
cc_86 N_Y_6 N_A_18 0.000123041f $X=0.54 $Y=0.2025
cc_87 N_Y_16 N_A_28 0.000123041f $X=1.512 $Y=0.2025
cc_88 N_Y_69 N_A_32 0.000251572f $X=0.513 $Y=0.072
cc_89 N_Y_77 N_A_35 0.000295622f $X=1.377 $Y=0.072
cc_90 N_Y_67 N_A_29 0.00032453f $X=0.243 $Y=0.072
cc_91 N_Y_67 N_A_30 0.000354847f $X=0.243 $Y=0.072
cc_92 N_Y_77 N_A_36 0.000354847f $X=1.377 $Y=0.072
cc_93 N_Y_75 N_A_34 0.000367174f $X=1.107 $Y=0.072
cc_94 N_Y_1 N_A_37 0.000416422f $X=0.108 $Y=0.0675
cc_95 N_Y_15 N_A_47 0.000439912f $X=1.512 $Y=0.0675
cc_96 N_Y_90 N_A_34 0.0005198f $X=0.9585 $Y=0.234
cc_97 N_Y_82 N_A_29 0.000524276f $X=0.0945 $Y=0.234
cc_98 N_Y_86 N_A_32 0.000530438f $X=0.5265 $Y=0.234
cc_99 N_Y_94 N_A_35 0.00054581f $X=1.3905 $Y=0.234
cc_100 N_Y_50 N_A_15 0.0646703f $X=0.2015 $Y=0.0675
cc_101 N_Y_51 N_A_18 0.0287004f $X=0.5255 $Y=0.0675
cc_102 N_Y_52 N_A_19 0.0648008f $X=0.6335 $Y=0.0675
cc_103 N_Y_53 N_A_22 0.0648009f $X=0.9575 $Y=0.0675
cc_104 N_Y_55 N_A_26 0.0287003f $X=1.3895 $Y=0.0675
cc_105 N_Y_58 N_A_15 0.0187151f $X=0.2015 $Y=0.2025
cc_106 N_Y_59 N_A_18 0.0548129f $X=0.5255 $Y=0.2025
cc_107 N_Y_60 N_A_19 0.000809382f $X=0.6335 $Y=0.2025
cc_108 N_Y_61 N_A_22 0.0187151f $X=0.9575 $Y=0.2025
cc_109 N_Y_62 N_A_23 0.0187151f $X=1.0655 $Y=0.2025
cc_110 N_Y_63 N_A_26 0.0546859f $X=1.3895 $Y=0.2025
cc_111 N_Y_65 N_A_37 0.000827255f $X=0.0945 $Y=0.072
cc_112 N_Y_57 N_A_13 0.0289548f $X=0.0935 $Y=0.2025
cc_113 N_Y_64 N_A_28 0.0467061f $X=1.4975 $Y=0.2025
cc_114 N_Y_49 N_A_14 0.0189727f $X=0.0935 $Y=0.0675
cc_115 N_Y_56 N_A_27 0.0189731f $X=1.4975 $Y=0.0675
cc_116 N_Y_9 N_A_41 0.000848606f $X=0.972 $Y=0.0675
cc_117 N_Y_11 N_A_45 0.000848606f $X=1.08 $Y=0.0675
cc_118 N_Y_7 N_A_41 0.000848741f $X=0.648 $Y=0.0675
cc_119 N_Y_5 N_A_38 0.000856088f $X=0.54 $Y=0.0675
cc_120 N_Y_3 N_A_38 0.000868086f $X=0.216 $Y=0.0675
cc_121 N_Y_13 N_A_45 0.000868086f $X=1.404 $Y=0.0675
cc_122 N_Y_79 N_A_47 0.000935912f $X=1.539 $Y=0.072
cc_123 N_Y_2 N_A_1 0.00103507f $X=0.108 $Y=0.2025
cc_124 N_Y_7 N_A_2 0.00115744f $X=0.648 $Y=0.0675
cc_125 N_Y_13 N_A_4 0.00115818f $X=1.404 $Y=0.0675
cc_126 N_Y_3 N_A_1 0.00115838f $X=0.216 $Y=0.0675
cc_127 N_Y_9 N_A_3 0.00117319f $X=0.972 $Y=0.0675
cc_128 N_Y_11 N_A_3 0.00117319f $X=1.08 $Y=0.0675
cc_129 N_Y_5 N_A_2 0.00121444f $X=0.54 $Y=0.0675
cc_130 N_Y_15 N_A_4 0.00122166f $X=1.512 $Y=0.0675
cc_131 N_Y_16 N_A_27 0.00153827f $X=1.512 $Y=0.2025
cc_132 N_Y_6 N_A_17 0.0015459f $X=0.54 $Y=0.2025
cc_133 N_Y_10 N_A_22 0.0015459f $X=0.972 $Y=0.2025
cc_134 N_Y_12 N_A_23 0.0015459f $X=1.08 $Y=0.2025
cc_135 N_Y_4 N_A_15 0.00154706f $X=0.216 $Y=0.2025
cc_136 N_Y_14 N_A_26 0.00154742f $X=1.404 $Y=0.2025
cc_137 N_Y_1 N_A_13 0.00161268f $X=0.108 $Y=0.0675
cc_138 N_Y_15 N_A_28 0.00165251f $X=1.512 $Y=0.0675
cc_139 N_Y_75 N_A_44 0.00172253f $X=1.107 $Y=0.072
cc_140 N_Y_69 N_A_40 0.00187808f $X=0.513 $Y=0.072
cc_141 N_Y_67 N_A_37 0.0020312f $X=0.243 $Y=0.072
cc_142 N_Y_7 N_A_20 0.00204928f $X=0.648 $Y=0.0675
cc_143 N_Y_5 N_A_18 0.00205432f $X=0.54 $Y=0.0675
cc_144 N_Y_3 N_A_16 0.00207755f $X=0.216 $Y=0.0675
cc_145 N_Y_9 N_A_22 0.00207763f $X=0.972 $Y=0.0675
cc_146 N_Y_11 N_A_23 0.00207763f $X=1.08 $Y=0.0675
cc_147 N_Y_13 N_A_26 0.00207763f $X=1.404 $Y=0.0675
cc_148 N_Y_77 N_A_47 0.00208858f $X=1.377 $Y=0.072
cc_149 N_Y_73 N_A_41 0.00304389f $X=0.945 $Y=0.072
cc_150 N_Y_67 N_A_38 0.00306102f $X=0.243 $Y=0.072
cc_151 N_Y_77 N_A_45 0.00306102f $X=1.377 $Y=0.072
cc_152 N_Y_81 N_A_29 0.00312439f $X=0.081 $Y=0.1035
cc_153 N_Y_87 N_A_42 0.00365795f $X=0.675 $Y=0.2025
cc_154 N_Y_83 N_A_29 0.0037867f $X=0.243 $Y=0.1947
cc_155 N_Y_93 N_A_35 0.00378994f $X=1.377 $Y=0.2025
cc_156 N_Y_85 N_A_39 0.00385887f $X=0.513 $Y=0.2025
cc_157 N_Y_89 N_A_43 0.0038621f $X=0.945 $Y=0.2025
cc_158 N_Y_95 N_A_48 0.00387806f $X=1.539 $Y=0.1845
cc_159 N_Y_91 N_A_46 0.00388748f $X=1.107 $Y=0.2025
cc_160 N_Y_53 N_A_3 0.00764943f $X=0.9575 $Y=0.0675
cc_161 N_Y_52 N_A_2 0.00765516f $X=0.6335 $Y=0.0675
cc_162 N_Y_64 N_A_4 0.00830429f $X=1.4975 $Y=0.2025
cc_163 N_Y_58 N_A_1 0.00848661f $X=0.2015 $Y=0.2025
cc_164 N_Y_69 N_A_38 0.00937129f $X=0.513 $Y=0.072
cc_165 N_Y_71 N_A_41 0.00940103f $X=0.675 $Y=0.072
cc_166 N_Y_75 N_A_45 0.00941811f $X=1.107 $Y=0.072
cc_167 N_Y_59 N_A_17 0.00995876f $X=0.5255 $Y=0.2025
cc_168 N_Y_56 N_A_28 0.0100821f $X=1.4975 $Y=0.0675
cc_169 N_Y_60 N_A_20 0.0636766f $X=0.6335 $Y=0.2025
cc_170 N_Y_64 N_A_27 0.0540106f $X=1.4975 $Y=0.2025
cc_171 N_Y_51 N_A_17 0.0358f $X=0.5255 $Y=0.0675
cc_172 N_Y_57 N_A_14 0.0359741f $X=0.0935 $Y=0.2025
cc_173 N_Y_58 N_A_16 0.0457709f $X=0.2015 $Y=0.2025
cc_174 N_Y_61 N_A_21 0.0457709f $X=0.9575 $Y=0.2025
cc_175 N_Y_62 N_A_24 0.0457709f $X=1.0655 $Y=0.2025
cc_176 N_Y_63 N_A_25 0.0457709f $X=1.3895 $Y=0.2025
cc_177 N_Y_49 N_A_13 0.045861f $X=0.0935 $Y=0.0675
cc_178 N_Y_54 N_A_23 0.0649154f $X=1.0655 $Y=0.0675
cc_179 N_Y_3 N_9_16 8.68748e-20 $X=0.216 $Y=0.0675
cc_180 N_Y_69 N_9_16 0.00030815f $X=0.513 $Y=0.072
cc_181 N_Y_85 N_9_16 0.00016046f $X=0.513 $Y=0.2025
cc_182 N_Y_67 N_9_16 0.000501404f $X=0.243 $Y=0.072
cc_183 N_Y_84 N_9_16 0.000434992f $X=0.273 $Y=0.234
cc_184 N_Y_83 N_9_15 0.000674787f $X=0.243 $Y=0.1947
cc_185 N_Y_85 N_9_18 0.000821373f $X=0.513 $Y=0.2025
cc_186 N_Y_83 N_9_16 0.00218212f $X=0.243 $Y=0.1947
cc_187 N_Y_69 N_8_15 0.000101337f $X=0.513 $Y=0.072
cc_188 N_Y_85 N_8_15 0.000354919f $X=0.513 $Y=0.2025
cc_189 N_Y_83 N_8_15 0.000457412f $X=0.243 $Y=0.1947
cc_190 N_Y_85 N_8_17 0.000474971f $X=0.513 $Y=0.2025
cc_191 N_Y_84 N_8_4 0.000866356f $X=0.273 $Y=0.234
cc_192 N_Y_84 N_8_3 0.00089197f $X=0.273 $Y=0.234
cc_193 N_Y_85 N_8_18 0.00121225f $X=0.513 $Y=0.2025
cc_194 N_Y_84 N_8_18 0.00145587f $X=0.273 $Y=0.234
cc_195 N_Y_84 N_8_15 0.00690052f $X=0.273 $Y=0.234
cc_196 N_Y_7 N_6_16 9.1194e-20 $X=0.648 $Y=0.0675
cc_197 N_Y_73 N_6_16 0.000315562f $X=0.945 $Y=0.072
cc_198 N_Y_89 N_6_16 0.00016046f $X=0.945 $Y=0.2025
cc_199 N_Y_71 N_6_16 0.000506427f $X=0.675 $Y=0.072
cc_200 N_Y_88 N_6_16 0.000214192f $X=0.705 $Y=0.234
cc_201 N_Y_87 N_6_15 0.000674787f $X=0.675 $Y=0.2025
cc_202 N_Y_89 N_6_18 0.000820325f $X=0.945 $Y=0.2025
cc_203 N_Y_87 N_6_16 0.00213145f $X=0.675 $Y=0.2025
cc_204 N_Y_9 N_7_15 8.95473e-20 $X=0.972 $Y=0.0675
cc_205 N_Y_10 N_7_15 9.44505e-20 $X=0.972 $Y=0.2025
cc_206 N_Y_89 N_7_15 0.000354919f $X=0.945 $Y=0.2025
cc_207 N_Y_73 N_7_15 0.000123042f $X=0.945 $Y=0.072
cc_208 N_Y_87 N_7_15 0.00045691f $X=0.675 $Y=0.2025
cc_209 N_Y_89 N_7_17 0.00049674f $X=0.945 $Y=0.2025
cc_210 N_Y_88 N_7_4 0.000866356f $X=0.705 $Y=0.234
cc_211 N_Y_88 N_7_3 0.00089197f $X=0.705 $Y=0.234
cc_212 N_Y_89 N_7_18 0.00124595f $X=0.945 $Y=0.2025
cc_213 N_Y_88 N_7_18 0.00145587f $X=0.705 $Y=0.234
cc_214 N_Y_88 N_7_15 0.00697658f $X=0.705 $Y=0.234
cc_215 N_Y_12 N_5_18 9.44505e-20 $X=1.08 $Y=0.2025
cc_216 N_Y_75 N_5_18 0.000123042f $X=1.107 $Y=0.072
cc_217 N_Y_91 N_5_18 0.000194725f $X=1.107 $Y=0.2025
cc_218 N_Y_93 N_5_18 0.00045639f $X=1.377 $Y=0.2025
cc_219 N_Y_91 N_5_16 0.00049674f $X=1.107 $Y=0.2025
cc_220 N_Y_92 N_5_3 0.000866356f $X=1.1355 $Y=0.234
cc_221 N_Y_92 N_5_4 0.00089197f $X=1.1355 $Y=0.234
cc_222 N_Y_91 N_5_15 0.00124608f $X=1.107 $Y=0.2025
cc_223 N_Y_92 N_5_15 0.00145587f $X=1.1355 $Y=0.234
cc_224 N_Y_92 N_5_18 0.00704108f $X=1.1355 $Y=0.234
cc_225 N_Y_13 N_4_18 8.68455e-20 $X=1.404 $Y=0.0675
cc_226 N_Y_14 N_4_18 9.7373e-20 $X=1.404 $Y=0.2025
cc_227 N_Y_75 N_4_18 0.000315562f $X=1.107 $Y=0.072
cc_228 N_Y_91 N_4_18 0.00016046f $X=1.107 $Y=0.2025
cc_229 N_Y_77 N_4_18 0.000499153f $X=1.377 $Y=0.072
cc_230 N_Y_92 N_4_18 0.00021499f $X=1.1355 $Y=0.234
cc_231 N_Y_93 N_4_17 0.000674787f $X=1.377 $Y=0.2025
cc_232 N_Y_91 N_4_15 0.000820357f $X=1.107 $Y=0.2025
cc_233 N_Y_93 N_4_18 0.00199887f $X=1.377 $Y=0.2025
x_PM_CKINVDCx16_ASAP7_75t_R%9 vss N_M22_g N_M50_g N_M23_g N_M51_g N_M22_d
+ N_M23_d N_M20_d N_M21_d N_9_18 N_9_1 N_9_3 N_9_4 N_9_15 N_9_9 N_9_12 N_9_16
+ N_9_14 N_9_10 PM_CKINVDCx16_ASAP7_75t_R%9
cc_234 N_9_18 N_A_37 3.97481e-20 $X=0.378 $Y=0.099
cc_235 N_9_18 N_A_1 0.000604221f $X=0.378 $Y=0.099
cc_236 N_9_1 N_A_1 0.000587734f $X=0.297 $Y=0.135
cc_237 N_9_3 N_A_38 0.000743171f $X=0.324 $Y=0.0675
cc_238 N_9_4 N_A_38 0.000749204f $X=0.432 $Y=0.0675
cc_239 N_9_15 N_A_38 0.00080179f $X=0.3095 $Y=0.099
cc_240 N_9_9 N_A_16 0.00348613f $X=0.297 $Y=0.0245
cc_241 N_9_18 N_A_38 0.00651538f $X=0.378 $Y=0.099
x_PM_CKINVDCx16_ASAP7_75t_R%6 vss N_M12_g N_M40_g N_M13_g N_M41_g N_M12_d
+ N_M13_d N_M14_d N_M15_d N_6_18 N_6_1 N_6_3 N_6_4 N_6_15 N_6_9 N_6_12 N_6_16
+ N_6_14 N_6_10 PM_CKINVDCx16_ASAP7_75t_R%6
cc_242 N_6_18 N_A_40 5.2583e-20 $X=0.81 $Y=0.099
cc_243 N_6_18 N_A_2 0.000642533f $X=0.81 $Y=0.099
cc_244 N_6_1 N_A_2 0.000587734f $X=0.729 $Y=0.135
cc_245 N_6_3 N_A_41 0.000743171f $X=0.756 $Y=0.0675
cc_246 N_6_4 N_A_41 0.000749204f $X=0.864 $Y=0.0675
cc_247 N_6_15 N_A_41 0.00080179f $X=0.7415 $Y=0.099
cc_248 N_6_9 N_A_20 0.00348613f $X=0.729 $Y=0.0245
cc_249 N_6_18 N_A_41 0.00652324f $X=0.81 $Y=0.099

* End of included file CKINVDCx16_ASAP7_75t_R.pex.sp.pxi
.ends

.subckt PM_BUFx3_ASAP7_75t_R%A vss 22 10 16 3 9 4 6 1
c1 1 vss 0.00465636f $X=0.072 $Y=0.135
c2 3 vss 0.0869593f $X=0.081 $Y=0.0245
c3 4 vss 0.00326774f $X=0.027 $Y=0.072
c4 5 vss 0.0011763f $X=0.027 $Y=0.135
c5 6 vss 0.00326774f $X=0.027 $Y=0.198
c6 7 vss 0.00332448f $X=0.027 $Y=0.1035
c7 8 vss 0.00332722f $X=0.027 $Y=0.1665
c8 9 vss 0.00111872f $X=0.0455 $Y=0.135
r1 6 8 6.16517 $w=1.44286e-08 $l=3.15e-08 $layer=M1 $thickness=3.6e-08 $X=0.027
+ $Y=0.198 $X2=0.027 $Y2=0.1665
r2 4 7 6.16517 $w=1.44286e-08 $l=3.15e-08 $layer=M1 $thickness=3.6e-08 $X=0.027
+ $Y=0.072 $X2=0.027 $Y2=0.1035
r3 5 9 3.1337 $w=1.54324e-08 $l=1.85e-08 $layer=M1 $thickness=3.6e-08 $X=0.027
+ $Y=0.135 $X2=0.0455 $Y2=0.135
r4 5 7 6.16517 $w=1.44286e-08 $l=3.15e-08 $layer=M1 $thickness=3.6e-08 $X=0.027
+ $Y=0.135 $X2=0.027 $Y2=0.1035
r5 5 8 6.16517 $w=1.44286e-08 $l=3.15e-08 $layer=M1 $thickness=3.6e-08 $X=0.027
+ $Y=0.135 $X2=0.027 $Y2=0.1665
r6 22 9 4.31401 $w=1.3e-08 $l=1.85e-08 $layer=M1 $thickness=3.6e-08 $X=0.061
+ $Y=0.1335 $X2=0.0455 $Y2=0.135
r7 22 20 19.3796 $a=3.24e-16 $layer=V0LIG $X=0.061 $Y=0.1335 $X2=0.063 $Y2=0.135
r8 1 18 2.6116 $w=2.2e-08 $l=1e-08 $layer=LIG $thickness=4.8e-08 $X=0.072
+ $Y=0.135 $X2=0.082 $Y2=0.135
r9 1 20 4.98695 $w=1.60444e-08 $l=9e-09 $layer=LIG $thickness=4.8e-08 $X=0.072
+ $Y=0.135 $X2=0.063 $Y2=0.135
r10 16 15 14.6259 $w=2.1e-08 $l=4.3e-08 $layer=Gate_1 $thickness=5.6e-08
+ $X=0.081 $Y=0.2025 $X2=0.081 $Y2=0.1595
r11 14 15 2.7211 $w=2.1e-08 $l=8e-09 $layer=Gate_1 $thickness=5.6e-08 $X=0.081
+ $Y=0.1515 $X2=0.081 $Y2=0.1595
r12 13 14 5.79936 $w=2.03333e-08 $l=1.65e-08 $layer=Gate_1 $thickness=5.6e-08
+ $X=0.081 $Y=0.135 $X2=0.081 $Y2=0.1515
r13 13 18 6.27904 $w=2.09e-08 $l=1e-09 $layer=Gate_1 $thickness=5.24e-08
+ $X=0.081 $Y=0.135 $X2=0.082 $Y2=0.135
r14 12 13 5.79936 $w=2.03333e-08 $l=1.65e-08 $layer=Gate_1 $thickness=5.6e-08
+ $X=0.081 $Y=0.1185 $X2=0.081 $Y2=0.135
r15 11 12 2.7211 $w=2.1e-08 $l=8e-09 $layer=Gate_1 $thickness=5.6e-08 $X=0.081
+ $Y=0.1105 $X2=0.081 $Y2=0.1185
r16 10 11 14.6259 $w=2.1e-08 $l=4.3e-08 $layer=Gate_1 $thickness=5.6e-08
+ $X=0.081 $Y=0.0675 $X2=0.081 $Y2=0.1105
r17 10 3 14.6259 $w=2.1e-08 $l=4.3e-08 $layer=Gate_1 $thickness=5.6e-08
+ $X=0.081 $Y=0.0675 $X2=0.081 $Y2=0.0245
.ends

.subckt PM_BUFx3_ASAP7_75t_R%Y vss 31 24 25 36 43 46 47 15 3 13 19 20 16 21 1 2
+ 14
c1 1 vss 0.00859125f $X=0.162 $Y=0.0675
c2 2 vss 0.00863771f $X=0.162 $Y=0.2025
c3 3 vss 0.00800705f $X=0.27 $Y=0.0675
c4 4 vss 0.00800705f $X=0.27 $Y=0.2025
c5 13 vss 0.00442031f $X=0.1475 $Y=0.0675
c6 14 vss 0.0371291f $X=0.2555 $Y=0.0675
c7 15 vss 0.00441726f $X=0.1475 $Y=0.2025
c8 16 vss 0.0371381f $X=0.2555 $Y=0.2025
c9 17 vss 0.00264623f $X=0.297 $Y=0.036
c10 18 vss 0.00264623f $X=0.297 $Y=0.234
c11 19 vss 0.0126107f $X=0.149 $Y=0.036
c12 20 vss 0.0126107f $X=0.2605 $Y=0.234
c13 21 vss 0.0044786f $X=0.297 $Y=0.0795
r1 47 45 0.0308642 $w=8.1e-08 $l=2.5e-09 $layer=P_src_drn $thickness=1e-09
+ $X=0.1793 $Y=0.2025 $X2=0.1765 $Y2=0.2025
r2 2 45 0.179012 $w=8.1e-08 $l=1.45e-08 $layer=P_src_drn $thickness=1e-09
+ $X=0.162 $Y=0.2025 $X2=0.1765 $Y2=0.2025
r3 15 2 0.179012 $w=8.1e-08 $l=1.45e-08 $layer=P_src_drn $thickness=1e-09
+ $X=0.1475 $Y=0.2025 $X2=0.162 $Y2=0.2025
r4 46 15 0.0308642 $w=8.1e-08 $l=2.5e-09 $layer=P_src_drn $thickness=1e-09
+ $X=0.1446 $Y=0.2025 $X2=0.1475 $Y2=0.2025
r5 16 4 0.154321 $w=8.1e-08 $l=1.25e-08 $layer=P_src_drn $thickness=1e-09
+ $X=0.2555 $Y=0.2025 $X2=0.27 $Y2=0.2025
r6 43 16 0.0308642 $w=8.1e-08 $l=2.5e-09 $layer=P_src_drn $thickness=1e-09
+ $X=0.2526 $Y=0.2025 $X2=0.2555 $Y2=0.2025
r7 2 40 19.3796 $a=3.24e-16 $layer=V0LISD $X=0.162 $Y=0.2025 $X2=0.162 $Y2=0.234
r8 4 37 19.3796 $a=3.24e-16 $layer=V0LISD $X=0.27 $Y=0.2025 $X2=0.27 $Y2=0.234
r9 40 41 12.4757 $w=1.3e-08 $l=5.35e-08 $layer=M1 $thickness=3.6e-08 $X=0.162
+ $Y=0.234 $X2=0.2155 $Y2=0.234
r10 37 38 3.14806 $w=1.3e-08 $l=1.35e-08 $layer=M1 $thickness=3.6e-08 $X=0.27
+ $Y=0.234 $X2=0.2835 $Y2=0.234
r11 20 37 2.2153 $w=1.3e-08 $l=9.5e-09 $layer=M1 $thickness=3.6e-08 $X=0.2605
+ $Y=0.234 $X2=0.27 $Y2=0.234
r12 20 41 10.4935 $w=1.3e-08 $l=4.5e-08 $layer=M1 $thickness=3.6e-08 $X=0.2605
+ $Y=0.234 $X2=0.2155 $Y2=0.234
r13 18 34 9.89378 $w=1.47818e-08 $l=4.95e-08 $layer=M1 $thickness=3.6e-08
+ $X=0.297 $Y=0.234 $X2=0.297 $Y2=0.1845
r14 18 38 1.49895 $w=1.63333e-08 $l=1.35e-08 $layer=M1 $thickness=3.6e-08
+ $X=0.297 $Y=0.234 $X2=0.2835 $Y2=0.234
r15 14 3 0.154321 $w=8.1e-08 $l=1.25e-08 $layer=N_src_drn $thickness=1e-09
+ $X=0.2555 $Y=0.0675 $X2=0.27 $Y2=0.0675
r16 36 14 0.0308642 $w=8.1e-08 $l=2.5e-09 $layer=N_src_drn $thickness=1e-09
+ $X=0.2526 $Y=0.0675 $X2=0.2555 $Y2=0.0675
r17 33 34 11.5429 $w=1.3e-08 $l=4.95e-08 $layer=M1 $thickness=3.6e-08 $X=0.297
+ $Y=0.135 $X2=0.297 $Y2=0.1845
r18 32 33 3.38125 $w=1.3e-08 $l=1.45e-08 $layer=M1 $thickness=3.6e-08 $X=0.297
+ $Y=0.1205 $X2=0.297 $Y2=0.135
r19 31 32 1.39914 $w=1.3e-08 $l=6e-09 $layer=M1 $thickness=3.6e-08 $X=0.2965
+ $Y=0.1145 $X2=0.297 $Y2=0.1205
r20 31 21 8.16164 $w=1.3e-08 $l=3.5e-08 $layer=M1 $thickness=3.6e-08 $X=0.2965
+ $Y=0.1145 $X2=0.297 $Y2=0.0795
r21 3 29 19.3796 $a=3.24e-16 $layer=V0LISD $X=0.27 $Y=0.0675 $X2=0.27 $Y2=0.036
r22 17 30 1.49895 $w=1.63333e-08 $l=1.35e-08 $layer=M1 $thickness=3.6e-08
+ $X=0.297 $Y=0.036 $X2=0.2835 $Y2=0.036
r23 17 21 8.49464 $w=1.50276e-08 $l=4.35e-08 $layer=M1 $thickness=3.6e-08
+ $X=0.297 $Y=0.036 $X2=0.297 $Y2=0.0795
r24 29 30 3.14806 $w=1.3e-08 $l=1.35e-08 $layer=M1 $thickness=3.6e-08 $X=0.27
+ $Y=0.036 $X2=0.2835 $Y2=0.036
r25 28 29 2.2153 $w=1.3e-08 $l=9.5e-09 $layer=M1 $thickness=3.6e-08 $X=0.2605
+ $Y=0.036 $X2=0.27 $Y2=0.036
r26 27 28 10.4935 $w=1.3e-08 $l=4.5e-08 $layer=M1 $thickness=3.6e-08 $X=0.2155
+ $Y=0.036 $X2=0.2605 $Y2=0.036
r27 26 27 12.4757 $w=1.3e-08 $l=5.35e-08 $layer=M1 $thickness=3.6e-08 $X=0.162
+ $Y=0.036 $X2=0.2155 $Y2=0.036
r28 19 26 3.03147 $w=1.3e-08 $l=1.3e-08 $layer=M1 $thickness=3.6e-08 $X=0.149
+ $Y=0.036 $X2=0.162 $Y2=0.036
r29 1 26 19.3796 $a=3.24e-16 $layer=V0LISD $X=0.162 $Y=0.0675 $X2=0.162
+ $Y2=0.036
r30 25 23 0.0308642 $w=8.1e-08 $l=2.5e-09 $layer=N_src_drn $thickness=1e-09
+ $X=0.1793 $Y=0.0675 $X2=0.1765 $Y2=0.0675
r31 1 23 0.179012 $w=8.1e-08 $l=1.45e-08 $layer=N_src_drn $thickness=1e-09
+ $X=0.162 $Y=0.0675 $X2=0.1765 $Y2=0.0675
r32 13 1 0.179012 $w=8.1e-08 $l=1.45e-08 $layer=N_src_drn $thickness=1e-09
+ $X=0.1475 $Y=0.0675 $X2=0.162 $Y2=0.0675
r33 24 13 0.0308642 $w=8.1e-08 $l=2.5e-09 $layer=N_src_drn $thickness=1e-09
+ $X=0.1446 $Y=0.0675 $X2=0.1475 $Y2=0.0675
.ends

.subckt PM_BUFx3_ASAP7_75t_R%4 vss 26 30 44 47 51 55 66 68 8 7 23 24 13 19 21
+ 22 16 17 15 18 20 2 14 3 25 1
c1 1 vss 0.00369987f $X=0.135 $Y=0.135
c2 2 vss 0.00334411f $X=0.189 $Y=0.135
c3 3 vss 0.00358038f $X=0.243 $Y=0.135
c4 7 vss 0.00927072f $X=0.054 $Y=0.0675
c5 8 vss 0.00927072f $X=0.054 $Y=0.2025
c6 13 vss 0.0806725f $X=0.135 $Y=0.0245
c7 14 vss 0.0805435f $X=0.189 $Y=0.135
c8 15 vss 0.0877258f $X=0.243 $Y=0.135
c9 16 vss 0.0435694f $X=0.056 $Y=0.0675
c10 17 vss 0.0434197f $X=0.056 $Y=0.2025
c11 18 vss 0.00283362f $X=0.111 $Y=0.036
c12 19 vss 0.000273005f $X=0.111 $Y=0.135
c13 20 vss 0.00283362f $X=0.111 $Y=0.234
c14 21 vss 0.00798043f $X=0.0875 $Y=0.036
c15 22 vss 0.00798043f $X=0.0875 $Y=0.234
c16 23 vss 0.00413737f $X=0.111 $Y=0.1035
c17 24 vss 0.00413737f $X=0.111 $Y=0.1665
c18 25 vss 0.00559229f $X=0.123 $Y=0.135
r1 68 67 0.0308642 $w=8.1e-08 $l=2.5e-09 $layer=P_src_drn $thickness=1e-09
+ $X=0.0713 $Y=0.2025 $X2=0.0685 $Y2=0.2025
r2 17 67 0.154321 $w=8.1e-08 $l=1.25e-08 $layer=P_src_drn $thickness=1e-09
+ $X=0.056 $Y=0.2025 $X2=0.0685 $Y2=0.2025
r3 66 65 0.0308642 $w=8.1e-08 $l=2.5e-09 $layer=N_src_drn $thickness=1e-09
+ $X=0.0713 $Y=0.0675 $X2=0.0685 $Y2=0.0675
r4 16 65 0.154321 $w=8.1e-08 $l=1.25e-08 $layer=N_src_drn $thickness=1e-09
+ $X=0.056 $Y=0.0675 $X2=0.0685 $Y2=0.0675
r5 8 64 19.3796 $a=3.24e-16 $layer=V0LISD $X=0.054 $Y=0.2025 $X2=0.05 $Y2=0.234
r6 7 60 19.3796 $a=3.24e-16 $layer=V0LISD $X=0.054 $Y=0.0675 $X2=0.05 $Y2=0.036
r7 61 62 2.09871 $w=1.3e-08 $l=9e-09 $layer=M1 $thickness=3.6e-08 $X=0.059
+ $Y=0.234 $X2=0.068 $Y2=0.234
r8 61 64 2.09871 $w=1.3e-08 $l=9e-09 $layer=M1 $thickness=3.6e-08 $X=0.059
+ $Y=0.234 $X2=0.05 $Y2=0.234
r9 22 62 4.5472 $w=1.3e-08 $l=1.95e-08 $layer=M1 $thickness=3.6e-08 $X=0.0875
+ $Y=0.234 $X2=0.068 $Y2=0.234
r10 57 58 2.09871 $w=1.3e-08 $l=9e-09 $layer=M1 $thickness=3.6e-08 $X=0.059
+ $Y=0.036 $X2=0.068 $Y2=0.036
r11 57 60 2.09871 $w=1.3e-08 $l=9e-09 $layer=M1 $thickness=3.6e-08 $X=0.059
+ $Y=0.036 $X2=0.05 $Y2=0.036
r12 21 58 4.5472 $w=1.3e-08 $l=1.95e-08 $layer=M1 $thickness=3.6e-08 $X=0.0875
+ $Y=0.036 $X2=0.068 $Y2=0.036
r13 20 42 2.5483 $w=1.79e-08 $l=1.8e-08 $layer=M1 $thickness=3.6e-08 $X=0.111
+ $Y=0.234 $X2=0.111 $Y2=0.216
r14 20 22 3.83085 $w=1.49149e-08 $l=2.35e-08 $layer=M1 $thickness=3.6e-08
+ $X=0.111 $Y=0.234 $X2=0.0875 $Y2=0.234
r15 18 40 2.5483 $w=1.79e-08 $l=1.8e-08 $layer=M1 $thickness=3.6e-08 $X=0.111
+ $Y=0.036 $X2=0.111 $Y2=0.054
r16 18 21 3.83085 $w=1.49149e-08 $l=2.35e-08 $layer=M1 $thickness=3.6e-08
+ $X=0.111 $Y=0.036 $X2=0.0875 $Y2=0.036
r17 55 54 14.6259 $w=2.1e-08 $l=4.3e-08 $layer=Gate_1 $thickness=5.6e-08
+ $X=0.243 $Y=0.2025 $X2=0.243 $Y2=0.1595
r18 53 54 2.7211 $w=2.1e-08 $l=8e-09 $layer=Gate_1 $thickness=5.6e-08 $X=0.243
+ $Y=0.1515 $X2=0.243 $Y2=0.1595
r19 51 52 14.6259 $w=2.1e-08 $l=4.3e-08 $layer=Gate_1 $thickness=5.6e-08
+ $X=0.243 $Y=0.0675 $X2=0.243 $Y2=0.1105
r20 49 52 2.7211 $w=2.1e-08 $l=8e-09 $layer=Gate_1 $thickness=5.6e-08 $X=0.243
+ $Y=0.1185 $X2=0.243 $Y2=0.1105
r21 15 49 5.79936 $w=2.03333e-08 $l=1.65e-08 $layer=Gate_1 $thickness=5.6e-08
+ $X=0.243 $Y=0.135 $X2=0.243 $Y2=0.1185
r22 15 53 5.79936 $w=2.03333e-08 $l=1.65e-08 $layer=Gate_1 $thickness=5.6e-08
+ $X=0.243 $Y=0.135 $X2=0.243 $Y2=0.1515
r23 47 46 16.4967 $w=2.1e-08 $l=4.85e-08 $layer=Gate_1 $thickness=5.6e-08
+ $X=0.189 $Y=0.2025 $X2=0.189 $Y2=0.154
r24 44 45 16.4967 $w=2.1e-08 $l=4.85e-08 $layer=Gate_1 $thickness=5.6e-08
+ $X=0.189 $Y=0.0675 $X2=0.189 $Y2=0.116
r25 14 45 6.6497 $w=2.04211e-08 $l=1.9e-08 $layer=Gate_1 $thickness=5.6e-08
+ $X=0.189 $Y=0.135 $X2=0.189 $Y2=0.116
r26 14 46 6.6497 $w=2.04211e-08 $l=1.9e-08 $layer=Gate_1 $thickness=5.6e-08
+ $X=0.189 $Y=0.135 $X2=0.189 $Y2=0.154
r27 41 42 4.19742 $w=1.3e-08 $l=1.8e-08 $layer=M1 $thickness=3.6e-08 $X=0.111
+ $Y=0.198 $X2=0.111 $Y2=0.216
r28 24 41 7.34548 $w=1.3e-08 $l=3.15e-08 $layer=M1 $thickness=3.6e-08 $X=0.111
+ $Y=0.1665 $X2=0.111 $Y2=0.198
r29 39 40 4.19742 $w=1.3e-08 $l=1.8e-08 $layer=M1 $thickness=3.6e-08 $X=0.111
+ $Y=0.072 $X2=0.111 $Y2=0.054
r30 23 39 7.34548 $w=1.3e-08 $l=3.15e-08 $layer=M1 $thickness=3.6e-08 $X=0.111
+ $Y=0.1035 $X2=0.111 $Y2=0.072
r31 3 37 19.3796 $a=3.24e-16 $layer=V0LIG $X=0.243 $Y=0.135 $X2=0.243 $Y2=0.135
r32 3 15 10.4265 $w=1.765e-08 $layer=LIG $thickness=5.2e-08 $X=0.243 $Y=0.135
+ $X2=0.243 $Y2=0.135
r33 2 35 19.3796 $a=3.24e-16 $layer=V0LIG $X=0.189 $Y=0.135 $X2=0.189 $Y2=0.135
r34 2 14 10.4265 $w=1.765e-08 $layer=LIG $thickness=5.2e-08 $X=0.189 $Y=0.135
+ $X2=0.189 $Y2=0.135
r35 19 25 1.61797 $w=1.675e-08 $l=1.2e-08 $layer=M1 $thickness=3.6e-08 $X=0.111
+ $Y=0.135 $X2=0.123 $Y2=0.135
r36 19 23 6.16517 $w=1.44286e-08 $l=3.15e-08 $layer=M1 $thickness=3.6e-08
+ $X=0.111 $Y=0.135 $X2=0.111 $Y2=0.1035
r37 19 24 6.16517 $w=1.44286e-08 $l=3.15e-08 $layer=M1 $thickness=3.6e-08
+ $X=0.111 $Y=0.135 $X2=0.111 $Y2=0.1665
r38 36 37 6.29612 $w=1.3e-08 $l=2.7e-08 $layer=M1 $thickness=3.6e-08 $X=0.216
+ $Y=0.135 $X2=0.243 $Y2=0.135
r39 35 36 6.29612 $w=1.3e-08 $l=2.7e-08 $layer=M1 $thickness=3.6e-08 $X=0.189
+ $Y=0.135 $X2=0.216 $Y2=0.135
r40 34 35 6.17953 $w=1.3e-08 $l=2.65e-08 $layer=M1 $thickness=3.6e-08 $X=0.1625
+ $Y=0.135 $X2=0.189 $Y2=0.135
r41 33 34 4.19742 $w=1.3e-08 $l=1.8e-08 $layer=M1 $thickness=3.6e-08 $X=0.1445
+ $Y=0.135 $X2=0.1625 $Y2=0.135
r42 32 33 2.2153 $w=1.3e-08 $l=9.5e-09 $layer=M1 $thickness=3.6e-08 $X=0.135
+ $Y=0.135 $X2=0.1445 $Y2=0.135
r43 25 32 2.79828 $w=1.3e-08 $l=1.2e-08 $layer=M1 $thickness=3.6e-08 $X=0.123
+ $Y=0.135 $X2=0.135 $Y2=0.135
r44 1 28 10.4265 $w=1.765e-08 $layer=LIG $thickness=5.2e-08 $X=0.135 $Y=0.135
+ $X2=0.135 $Y2=0.135
r45 1 32 19.3796 $a=3.24e-16 $layer=V0LIG $X=0.135 $Y=0.135 $X2=0.135 $Y2=0.135
r46 30 29 16.4967 $w=2.1e-08 $l=4.85e-08 $layer=Gate_1 $thickness=5.6e-08
+ $X=0.135 $Y=0.2025 $X2=0.135 $Y2=0.154
r47 28 29 6.6497 $w=2.04211e-08 $l=1.9e-08 $layer=Gate_1 $thickness=5.6e-08
+ $X=0.135 $Y=0.135 $X2=0.135 $Y2=0.154
r48 27 28 6.6497 $w=2.04211e-08 $l=1.9e-08 $layer=Gate_1 $thickness=5.6e-08
+ $X=0.135 $Y=0.116 $X2=0.135 $Y2=0.135
r49 26 27 16.4967 $w=2.1e-08 $l=4.85e-08 $layer=Gate_1 $thickness=5.6e-08
+ $X=0.135 $Y=0.0675 $X2=0.135 $Y2=0.116
r50 26 13 14.6259 $w=2.1e-08 $l=4.3e-08 $layer=Gate_1 $thickness=5.6e-08
+ $X=0.135 $Y=0.0675 $X2=0.135 $Y2=0.0245
r51 8 17 1e-05 $l=2e-09 $X=0.054 $Y=0.2025 $X2=0.056 $Y2=0.2025
r52 7 16 1e-05 $l=2e-09 $X=0.054 $Y=0.0675 $X2=0.056 $Y2=0.0675
.ends

* End of included file BUFx3_ASAP7_75t_R.pex.sp.pex

*
.subckt BUFx3_ASAP7_75t_CUSTOM_4_25_0_7 VSS VDD A Y
*
* VSS VSS
* VDD VDD
* A A
* Y Y
*
*

M0 VSS N_M0_g N_M0_s VSS nmos_rvt L=2e-08 W=8.1e-08 nfin=3 $X=0.071 $Y=0.027
M1 N_M1_d N_M1_g VSS VSS nmos_rvt L=2e-08 W=8.1e-08 nfin=3 $X=0.125 $Y=0.027
M2 N_M2_d N_M2_g VSS VSS nmos_rvt L=2e-08 W=8.1e-08 nfin=3 $X=0.179 $Y=0.027
M3 N_M3_d N_M3_g VSS VSS nmos_rvt L=2e-08 W=8.1e-08 nfin=3 $X=0.233 $Y=0.027
M4 VDD N_M4_g N_M4_s VDD pmos_rvt L=2e-08 W=8.1e-08 nfin=3 $X=0.071 $Y=0.162
M5 N_M5_d N_M5_g VDD VDD pmos_rvt L=2e-08 W=8.1e-08 nfin=3 $X=0.125 $Y=0.162
M6 N_M6_d N_M6_g VDD VDD pmos_rvt L=2e-08 W=8.1e-08 nfin=3 $X=0.179 $Y=0.162
M7 N_M7_d N_M7_g VDD VDD pmos_rvt L=2e-08 W=8.1e-08 nfin=3 $X=0.233 $Y=0.162

* .include "BUFx3_ASAP7_75t_R.pex.sp.pxi"

* Start of included file BUFx3_ASAP7_75t_R.pex.sp.pxi
x_PM_BUFx3_ASAP7_75t_R%A vss A N_M0_g N_M4_g N_A_3 N_A_9 N_A_4 N_A_6 N_A_1
+ PM_BUFx3_ASAP7_75t_R%A
x_PM_BUFx3_ASAP7_75t_R%Y vss Y N_M1_d N_M2_d N_M3_d N_M7_d N_M5_d N_M6_d N_Y_15
+ N_Y_3 N_Y_13 N_Y_19 N_Y_20 N_Y_16 N_Y_21 N_Y_1 N_Y_2 N_Y_14
+ PM_BUFx3_ASAP7_75t_R%Y
cc_1 N_Y_15 N_4_15 0.00284329f $X=0.1475 $Y=0.2025
cc_2 N_Y_15 N_4_18 0.000527814f $X=0.1475 $Y=0.2025
cc_3 N_Y_15 N_4_20 0.000527814f $X=0.1475 $Y=0.2025
cc_4 N_Y_15 N_4_2 0.000692511f $X=0.1475 $Y=0.2025
cc_5 N_Y_15 N_4_14 0.01925f $X=0.1475 $Y=0.2025
cc_6 N_Y_15 N_4_23 0.000957911f $X=0.1475 $Y=0.2025
cc_7 N_Y_15 N_4_24 0.000957911f $X=0.1475 $Y=0.2025
cc_8 N_Y_3 N_4_3 0.00101872f $X=0.27 $Y=0.0675
cc_9 N_Y_13 N_4_2 0.00134199f $X=0.1475 $Y=0.0675
cc_10 N_Y_19 N_4_25 0.00158858f $X=0.149 $Y=0.036
cc_11 N_Y_20 N_4_25 0.00158858f $X=0.2605 $Y=0.234
cc_12 N_Y_15 N_4_1 0.0016824f $X=0.1475 $Y=0.2025
cc_13 N_Y_16 N_4_3 0.0016824f $X=0.2555 $Y=0.2025
cc_14 N_Y_21 N_4_25 0.00176295f $X=0.297 $Y=0.0795
cc_15 N_Y_1 N_4_13 0.00191772f $X=0.162 $Y=0.0675
cc_16 N_Y_2 N_4_13 0.00191772f $X=0.162 $Y=0.2025
cc_17 N_Y_2 N_4_25 0.00335921f $X=0.162 $Y=0.2025
cc_18 N_Y_14 N_4_15 0.0145626f $X=0.2555 $Y=0.0675
cc_19 N_Y_16 N_4_15 0.0518753f $X=0.2555 $Y=0.2025
cc_20 N_Y_13 N_4_13 0.0102632f $X=0.1475 $Y=0.0675
cc_21 N_Y_13 N_4_14 0.055341f $X=0.1475 $Y=0.0675
cc_22 N_Y_15 N_4_13 0.0498962f $X=0.1475 $Y=0.2025
x_PM_BUFx3_ASAP7_75t_R%4 vss N_M1_g N_M5_g N_M2_g N_M6_g N_M3_g N_M7_g N_M0_s
+ N_M4_s N_4_8 N_4_7 N_4_23 N_4_24 N_4_13 N_4_19 N_4_21 N_4_22 N_4_16 N_4_17
+ N_4_15 N_4_18 N_4_20 N_4_2 N_4_14 N_4_3 N_4_25 N_4_1 PM_BUFx3_ASAP7_75t_R%4
cc_23 N_4_8 N_A_3 0.00462109f $X=0.054 $Y=0.2025
cc_24 N_4_7 N_A_3 0.00296919f $X=0.054 $Y=0.0675
cc_25 N_4_23 N_A_3 0.001004f $X=0.111 $Y=0.1035
cc_26 N_4_24 N_A_3 0.001004f $X=0.111 $Y=0.1665
cc_27 N_4_13 N_A_3 0.0016755f $X=0.135 $Y=0.0245
cc_28 N_4_19 N_A_9 0.00187424f $X=0.111 $Y=0.135
cc_29 N_4_21 N_A_4 0.0034254f $X=0.0875 $Y=0.036
cc_30 N_4_22 N_A_6 0.0034254f $X=0.0875 $Y=0.234
cc_31 N_4_16 N_A_1 0.0041877f $X=0.056 $Y=0.0675
cc_32 N_4_17 N_A_3 0.0152058f $X=0.056 $Y=0.2025
cc_33 N_4_16 N_A_3 0.0570425f $X=0.056 $Y=0.0675

* End of included file BUFx3_ASAP7_75t_R.pex.sp.pxi
.ends

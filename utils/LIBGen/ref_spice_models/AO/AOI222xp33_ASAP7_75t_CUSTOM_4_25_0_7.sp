.subckt PM_AOI222xp33_ASAP7_75t_R%C2 vss 15 5 11 3
c1 1 vss 0.00622722f $X=0.459 $Y=0.135
c2 3 vss 0.133836f $X=0.459 $Y=0.0245
c3 4 vss 0.0159682f $X=0.459 $Y=0.098
r1 15 14 0.408082 $w=1.3e-08 $l=1.8e-09 $layer=M1 $thickness=3.6e-08 $X=0.459
+ $Y=0.147 $X2=0.459 $Y2=0.1452
r2 13 14 2.3902 $w=1.3e-08 $l=1.02e-08 $layer=M1 $thickness=3.6e-08 $X=0.459
+ $Y=0.135 $X2=0.459 $Y2=0.1452
r3 4 13 8.62802 $w=1.3e-08 $l=3.7e-08 $layer=M1 $thickness=3.6e-08 $X=0.459
+ $Y=0.098 $X2=0.459 $Y2=0.135
r4 1 8 10.4265 $w=1.765e-08 $layer=LIG $thickness=5.2e-08 $X=0.459 $Y=0.135
+ $X2=0.459 $Y2=0.135
r5 1 13 19.3796 $a=3.24e-16 $layer=V0LIG $X=0.459 $Y=0.135 $X2=0.459 $Y2=0.135
r6 11 10 14.6259 $w=2.1e-08 $l=4.3e-08 $layer=Gate_1 $thickness=5.6e-08
+ $X=0.459 $Y=0.2025 $X2=0.459 $Y2=0.1595
r7 9 10 2.7211 $w=2.1e-08 $l=8e-09 $layer=Gate_1 $thickness=5.6e-08 $X=0.459
+ $Y=0.1515 $X2=0.459 $Y2=0.1595
r8 8 9 5.79936 $w=2.03333e-08 $l=1.65e-08 $layer=Gate_1 $thickness=5.6e-08
+ $X=0.459 $Y=0.135 $X2=0.459 $Y2=0.1515
r9 7 8 5.79936 $w=2.03333e-08 $l=1.65e-08 $layer=Gate_1 $thickness=5.6e-08
+ $X=0.459 $Y=0.1185 $X2=0.459 $Y2=0.135
r10 6 7 7.31297 $w=2.1e-08 $l=2.15e-08 $layer=Gate_1 $thickness=5.6e-08
+ $X=0.459 $Y=0.097 $X2=0.459 $Y2=0.1185
r11 5 6 14.6259 $w=2.1e-08 $l=4.3e-08 $layer=Gate_1 $thickness=5.6e-08 $X=0.459
+ $Y=0.054 $X2=0.459 $Y2=0.097
r12 5 3 10.0341 $w=2.1e-08 $l=2.95e-08 $layer=Gate_1 $thickness=5.6e-08
+ $X=0.459 $Y=0.054 $X2=0.459 $Y2=0.0245
.ends

.subckt PM_AOI222xp33_ASAP7_75t_R%B2 vss 13 5 9 4 3
c1 1 vss 0.00480581f $X=0.189 $Y=0.135
c2 3 vss 0.128987f $X=0.189 $Y=0.0245
c3 4 vss 0.0048385f $X=0.189 $Y=0.098
r1 13 12 0.874462 $w=1.3e-08 $l=3.8e-09 $layer=M1 $thickness=3.6e-08 $X=0.189
+ $Y=0.151 $X2=0.189 $Y2=0.1472
r2 11 12 2.85657 $w=1.3e-08 $l=1.22e-08 $layer=M1 $thickness=3.6e-08 $X=0.189
+ $Y=0.135 $X2=0.189 $Y2=0.1472
r3 4 11 8.62802 $w=1.3e-08 $l=3.7e-08 $layer=M1 $thickness=3.6e-08 $X=0.189
+ $Y=0.098 $X2=0.189 $Y2=0.135
r4 1 7 10.4265 $w=1.765e-08 $layer=LIG $thickness=5.2e-08 $X=0.189 $Y=0.135
+ $X2=0.189 $Y2=0.135
r5 1 11 19.3796 $a=3.24e-16 $layer=V0LIG $X=0.189 $Y=0.135 $X2=0.189 $Y2=0.135
r6 9 8 16.4967 $w=2.1e-08 $l=4.85e-08 $layer=Gate_1 $thickness=5.6e-08 $X=0.189
+ $Y=0.2025 $X2=0.189 $Y2=0.154
r7 7 8 6.6497 $w=2.04211e-08 $l=1.9e-08 $layer=Gate_1 $thickness=5.6e-08
+ $X=0.189 $Y=0.135 $X2=0.189 $Y2=0.154
r8 6 7 11.2416 $w=2.06615e-08 $l=3.25e-08 $layer=Gate_1 $thickness=5.6e-08
+ $X=0.189 $Y=0.1025 $X2=0.189 $Y2=0.135
r9 5 6 16.4967 $w=2.1e-08 $l=4.85e-08 $layer=Gate_1 $thickness=5.6e-08 $X=0.189
+ $Y=0.054 $X2=0.189 $Y2=0.1025
r10 5 3 10.0341 $w=2.1e-08 $l=2.95e-08 $layer=Gate_1 $thickness=5.6e-08
+ $X=0.189 $Y=0.054 $X2=0.189 $Y2=0.0245
.ends

.subckt PM_AOI222xp33_ASAP7_75t_R%B1 vss 13 5 11 4 3
c1 1 vss 0.00578639f $X=0.243 $Y=0.135
c2 3 vss 0.106413f $X=0.243 $Y=0.0245
c3 4 vss 0.00779728f $X=0.243 $Y=0.0837
r1 14 15 5.30507 $w=1.3e-08 $l=2.28e-08 $layer=M1 $thickness=3.6e-08 $X=0.243
+ $Y=0.1122 $X2=0.243 $Y2=0.135
r2 13 14 3.32295 $w=1.3e-08 $l=1.42e-08 $layer=M1 $thickness=3.6e-08 $X=0.243
+ $Y=0.098 $X2=0.243 $Y2=0.1122
r3 13 4 3.32295 $w=1.3e-08 $l=1.43e-08 $layer=M1 $thickness=3.6e-08 $X=0.243
+ $Y=0.098 $X2=0.243 $Y2=0.0837
r4 1 8 10.4265 $w=1.765e-08 $layer=LIG $thickness=5.2e-08 $X=0.243 $Y=0.135
+ $X2=0.243 $Y2=0.135
r5 1 15 19.3796 $a=3.24e-16 $layer=V0LIG $X=0.243 $Y=0.135 $X2=0.243 $Y2=0.135
r6 11 10 14.6259 $w=2.1e-08 $l=4.3e-08 $layer=Gate_1 $thickness=5.6e-08
+ $X=0.243 $Y=0.2025 $X2=0.243 $Y2=0.1595
r7 9 10 2.7211 $w=2.1e-08 $l=8e-09 $layer=Gate_1 $thickness=5.6e-08 $X=0.243
+ $Y=0.1515 $X2=0.243 $Y2=0.1595
r8 8 9 5.79936 $w=2.03333e-08 $l=1.65e-08 $layer=Gate_1 $thickness=5.6e-08
+ $X=0.243 $Y=0.135 $X2=0.243 $Y2=0.1515
r9 7 8 5.79936 $w=2.03333e-08 $l=1.65e-08 $layer=Gate_1 $thickness=5.6e-08
+ $X=0.243 $Y=0.1185 $X2=0.243 $Y2=0.135
r10 6 7 7.31297 $w=2.1e-08 $l=2.15e-08 $layer=Gate_1 $thickness=5.6e-08
+ $X=0.243 $Y=0.097 $X2=0.243 $Y2=0.1185
r11 5 6 14.6259 $w=2.1e-08 $l=4.3e-08 $layer=Gate_1 $thickness=5.6e-08 $X=0.243
+ $Y=0.054 $X2=0.243 $Y2=0.097
r12 5 3 10.0341 $w=2.1e-08 $l=2.95e-08 $layer=Gate_1 $thickness=5.6e-08
+ $X=0.243 $Y=0.054 $X2=0.243 $Y2=0.0245
.ends

.subckt PM_AOI222xp33_ASAP7_75t_R%C1 vss 13 5 11 4 3
c1 1 vss 0.00531719f $X=0.405 $Y=0.135
c2 3 vss 0.106548f $X=0.405 $Y=0.0245
c3 4 vss 0.0110095f $X=0.405 $Y=0.0817
r1 14 15 5.77145 $w=1.3e-08 $l=2.48e-08 $layer=M1 $thickness=3.6e-08 $X=0.405
+ $Y=0.1102 $X2=0.405 $Y2=0.135
r2 13 14 3.78933 $w=1.3e-08 $l=1.62e-08 $layer=M1 $thickness=3.6e-08 $X=0.405
+ $Y=0.094 $X2=0.405 $Y2=0.1102
r3 13 4 2.85657 $w=1.3e-08 $l=1.23e-08 $layer=M1 $thickness=3.6e-08 $X=0.405
+ $Y=0.094 $X2=0.405 $Y2=0.0817
r4 1 8 10.4265 $w=1.765e-08 $layer=LIG $thickness=5.2e-08 $X=0.405 $Y=0.135
+ $X2=0.405 $Y2=0.135
r5 1 15 19.3796 $a=3.24e-16 $layer=V0LIG $X=0.405 $Y=0.135 $X2=0.405 $Y2=0.135
r6 11 10 14.6259 $w=2.1e-08 $l=4.3e-08 $layer=Gate_1 $thickness=5.6e-08
+ $X=0.405 $Y=0.2025 $X2=0.405 $Y2=0.1595
r7 9 10 2.7211 $w=2.1e-08 $l=8e-09 $layer=Gate_1 $thickness=5.6e-08 $X=0.405
+ $Y=0.1515 $X2=0.405 $Y2=0.1595
r8 8 9 5.79936 $w=2.03333e-08 $l=1.65e-08 $layer=Gate_1 $thickness=5.6e-08
+ $X=0.405 $Y=0.135 $X2=0.405 $Y2=0.1515
r9 7 8 5.79936 $w=2.03333e-08 $l=1.65e-08 $layer=Gate_1 $thickness=5.6e-08
+ $X=0.405 $Y=0.1185 $X2=0.405 $Y2=0.135
r10 6 7 7.31297 $w=2.1e-08 $l=2.15e-08 $layer=Gate_1 $thickness=5.6e-08
+ $X=0.405 $Y=0.097 $X2=0.405 $Y2=0.1185
r11 5 6 14.6259 $w=2.1e-08 $l=4.3e-08 $layer=Gate_1 $thickness=5.6e-08 $X=0.405
+ $Y=0.054 $X2=0.405 $Y2=0.097
r12 5 3 10.0341 $w=2.1e-08 $l=2.95e-08 $layer=Gate_1 $thickness=5.6e-08
+ $X=0.405 $Y=0.054 $X2=0.405 $Y2=0.0245
.ends

.subckt PM_AOI222xp33_ASAP7_75t_R%Y vss 43 23 47 49 57 58 2 1 21 20 16 13 19 3
+ 14 4 15
c1 1 vss 0.00608386f $X=0.054 $Y=0.054
c2 2 vss 0.00984089f $X=0.108 $Y=0.2025
c3 3 vss 0.0060921f $X=0.27 $Y=0.054
c4 4 vss 0.00704578f $X=0.378 $Y=0.054
c5 13 vss 0.0275669f $X=0.056 $Y=0.054
c6 14 vss 0.0273094f $X=0.2555 $Y=0.054
c7 15 vss 0.0273705f $X=0.38 $Y=0.054
c8 16 vss 0.00460091f $X=0.0935 $Y=0.2025
c9 17 vss 0.00267643f $X=0.027 $Y=0.036
c10 18 vss 0.0023459f $X=0.027 $Y=0.198
c11 19 vss 0.00468157f $X=0.027 $Y=0.0575
c12 20 vss 0.0302009f $X=0.0405 $Y=0.036
c13 21 vss 0.00816151f $X=0.038 $Y=0.198
r1 58 56 0.0308642 $w=8.1e-08 $l=2.5e-09 $layer=P_src_drn $thickness=1e-09
+ $X=0.1253 $Y=0.2025 $X2=0.1225 $Y2=0.2025
r2 2 56 0.179012 $w=8.1e-08 $l=1.45e-08 $layer=P_src_drn $thickness=1e-09
+ $X=0.108 $Y=0.2025 $X2=0.1225 $Y2=0.2025
r3 16 2 0.179012 $w=8.1e-08 $l=1.45e-08 $layer=P_src_drn $thickness=1e-09
+ $X=0.0935 $Y=0.2025 $X2=0.108 $Y2=0.2025
r4 57 16 0.0308642 $w=8.1e-08 $l=2.5e-09 $layer=P_src_drn $thickness=1e-09
+ $X=0.0906 $Y=0.2025 $X2=0.0935 $Y2=0.2025
r5 2 53 19.3796 $a=3.24e-16 $layer=V0LISD $X=0.108 $Y=0.2025 $X2=0.108 $Y2=0.198
r6 52 53 3.14806 $w=1.3e-08 $l=1.35e-08 $layer=M1 $thickness=3.6e-08 $X=0.0945
+ $Y=0.198 $X2=0.108 $Y2=0.198
r7 51 52 3.14806 $w=1.3e-08 $l=1.35e-08 $layer=M1 $thickness=3.6e-08 $X=0.081
+ $Y=0.198 $X2=0.0945 $Y2=0.198
r8 50 51 5.82974 $w=1.3e-08 $l=2.5e-08 $layer=M1 $thickness=3.6e-08 $X=0.056
+ $Y=0.198 $X2=0.081 $Y2=0.198
r9 21 50 4.19742 $w=1.3e-08 $l=1.8e-08 $layer=M1 $thickness=3.6e-08 $X=0.038
+ $Y=0.198 $X2=0.056 $Y2=0.198
r10 18 45 3.36447 $w=1.71023e-08 $l=2.15e-08 $layer=M1 $thickness=3.6e-08
+ $X=0.027 $Y=0.198 $X2=0.027 $Y2=0.1765
r11 18 21 0.915974 $w=1.70909e-08 $l=1.1e-08 $layer=M1 $thickness=3.6e-08
+ $X=0.027 $Y=0.198 $X2=0.038 $Y2=0.198
r12 49 48 0.0462963 $w=5.4e-08 $l=2.5e-09 $layer=N_src_drn $thickness=1e-09
+ $X=0.3953 $Y=0.054 $X2=0.3925 $Y2=0.054
r13 15 48 0.231482 $w=5.4e-08 $l=1.25e-08 $layer=N_src_drn $thickness=1e-09
+ $X=0.38 $Y=0.054 $X2=0.3925 $Y2=0.054
r14 14 3 0.231482 $w=5.4e-08 $l=1.25e-08 $layer=N_src_drn $thickness=1e-09
+ $X=0.2555 $Y=0.054 $X2=0.27 $Y2=0.054
r15 47 14 0.0462963 $w=5.4e-08 $l=2.5e-09 $layer=N_src_drn $thickness=1e-09
+ $X=0.2526 $Y=0.054 $X2=0.2555 $Y2=0.054
r16 44 45 4.83869 $w=1.3e-08 $l=2.08e-08 $layer=M1 $thickness=3.6e-08 $X=0.027
+ $Y=0.1557 $X2=0.027 $Y2=0.1765
r17 43 44 2.04041 $w=1.3e-08 $l=8.7e-09 $layer=M1 $thickness=3.6e-08 $X=0.02
+ $Y=0.147 $X2=0.027 $Y2=0.1557
r18 43 42 9.0361 $w=1.3e-08 $l=3.88e-08 $layer=M1 $thickness=3.6e-08 $X=0.02
+ $Y=0.147 $X2=0.027 $Y2=0.1082
r19 19 42 11.8344 $w=1.3e-08 $l=5.07e-08 $layer=M1 $thickness=3.6e-08 $X=0.027
+ $Y=0.0575 $X2=0.027 $Y2=0.1082
r20 4 39 19.3796 $a=3.24e-16 $layer=V0LISD $X=0.378 $Y=0.054 $X2=0.378 $Y2=0.036
r21 3 36 19.3796 $a=3.24e-16 $layer=V0LISD $X=0.27 $Y=0.054 $X2=0.27 $Y2=0.036
r22 17 20 1.49895 $w=1.63333e-08 $l=1.35e-08 $layer=M1 $thickness=3.6e-08
+ $X=0.027 $Y=0.036 $X2=0.0405 $Y2=0.036
r23 17 19 3.36447 $w=1.71023e-08 $l=2.15e-08 $layer=M1 $thickness=3.6e-08
+ $X=0.027 $Y=0.036 $X2=0.027 $Y2=0.0575
r24 38 39 3.14806 $w=1.3e-08 $l=1.35e-08 $layer=M1 $thickness=3.6e-08 $X=0.3645
+ $Y=0.036 $X2=0.378 $Y2=0.036
r25 37 38 10.4935 $w=1.3e-08 $l=4.5e-08 $layer=M1 $thickness=3.6e-08 $X=0.3195
+ $Y=0.036 $X2=0.3645 $Y2=0.036
r26 36 37 11.5429 $w=1.3e-08 $l=4.95e-08 $layer=M1 $thickness=3.6e-08 $X=0.27
+ $Y=0.036 $X2=0.3195 $Y2=0.036
r27 35 36 3.14806 $w=1.3e-08 $l=1.35e-08 $layer=M1 $thickness=3.6e-08 $X=0.2565
+ $Y=0.036 $X2=0.27 $Y2=0.036
r28 34 35 3.14806 $w=1.3e-08 $l=1.35e-08 $layer=M1 $thickness=3.6e-08 $X=0.243
+ $Y=0.036 $X2=0.2565 $Y2=0.036
r29 33 34 5.82974 $w=1.3e-08 $l=2.5e-08 $layer=M1 $thickness=3.6e-08 $X=0.218
+ $Y=0.036 $X2=0.243 $Y2=0.036
r30 32 33 4.19742 $w=1.3e-08 $l=1.8e-08 $layer=M1 $thickness=3.6e-08 $X=0.2
+ $Y=0.036 $X2=0.218 $Y2=0.036
r31 31 32 2.56509 $w=1.3e-08 $l=1.1e-08 $layer=M1 $thickness=3.6e-08 $X=0.189
+ $Y=0.036 $X2=0.2 $Y2=0.036
r32 30 31 6.29612 $w=1.3e-08 $l=2.7e-08 $layer=M1 $thickness=3.6e-08 $X=0.162
+ $Y=0.036 $X2=0.189 $Y2=0.036
r33 29 30 6.29612 $w=1.3e-08 $l=2.7e-08 $layer=M1 $thickness=3.6e-08 $X=0.135
+ $Y=0.036 $X2=0.162 $Y2=0.036
r34 28 29 2.56509 $w=1.3e-08 $l=1.1e-08 $layer=M1 $thickness=3.6e-08 $X=0.124
+ $Y=0.036 $X2=0.135 $Y2=0.036
r35 27 28 4.19742 $w=1.3e-08 $l=1.8e-08 $layer=M1 $thickness=3.6e-08 $X=0.106
+ $Y=0.036 $X2=0.124 $Y2=0.036
r36 26 27 5.82974 $w=1.3e-08 $l=2.5e-08 $layer=M1 $thickness=3.6e-08 $X=0.081
+ $Y=0.036 $X2=0.106 $Y2=0.036
r37 25 26 3.14806 $w=1.3e-08 $l=1.35e-08 $layer=M1 $thickness=3.6e-08 $X=0.0675
+ $Y=0.036 $X2=0.081 $Y2=0.036
r38 24 25 3.14806 $w=1.3e-08 $l=1.35e-08 $layer=M1 $thickness=3.6e-08 $X=0.054
+ $Y=0.036 $X2=0.0675 $Y2=0.036
r39 20 24 3.14806 $w=1.3e-08 $l=1.35e-08 $layer=M1 $thickness=3.6e-08 $X=0.0405
+ $Y=0.036 $X2=0.054 $Y2=0.036
r40 1 24 19.3796 $a=3.24e-16 $layer=V0LISD $X=0.054 $Y=0.054 $X2=0.054 $Y2=0.036
r41 23 22 0.0462963 $w=5.4e-08 $l=2.5e-09 $layer=N_src_drn $thickness=1e-09
+ $X=0.0713 $Y=0.054 $X2=0.0685 $Y2=0.054
r42 13 22 0.231482 $w=5.4e-08 $l=1.25e-08 $layer=N_src_drn $thickness=1e-09
+ $X=0.056 $Y=0.054 $X2=0.0685 $Y2=0.054
r43 4 15 1e-05 $l=2e-09 $X=0.378 $Y=0.054 $X2=0.38 $Y2=0.054
r44 1 13 1e-05 $l=2e-09 $X=0.054 $Y=0.054 $X2=0.056 $Y2=0.054
.ends

.subckt PM_AOI222xp33_ASAP7_75t_R%A1 vss 15 5 11 4 3 1
c1 1 vss 0.00336879f $X=0.081 $Y=0.135
c2 3 vss 0.0697291f $X=0.081 $Y=0.0245
c3 4 vss 0.00590129f $X=0.081 $Y=0.098
r1 15 14 0.408082 $w=1.3e-08 $l=1.8e-09 $layer=M1 $thickness=3.6e-08 $X=0.081
+ $Y=0.147 $X2=0.081 $Y2=0.1452
r2 13 14 2.39019 $w=1.3e-08 $l=1.02e-08 $layer=M1 $thickness=3.6e-08 $X=0.081
+ $Y=0.135 $X2=0.081 $Y2=0.1452
r3 4 13 8.62802 $w=1.3e-08 $l=3.7e-08 $layer=M1 $thickness=3.6e-08 $X=0.081
+ $Y=0.098 $X2=0.081 $Y2=0.135
r4 1 8 10.4265 $w=1.765e-08 $layer=LIG $thickness=5.2e-08 $X=0.081 $Y=0.135
+ $X2=0.081 $Y2=0.135
r5 1 13 19.3796 $a=3.24e-16 $layer=V0LIG $X=0.081 $Y=0.135 $X2=0.081 $Y2=0.135
r6 11 10 14.6259 $w=2.1e-08 $l=4.3e-08 $layer=Gate_1 $thickness=5.6e-08
+ $X=0.081 $Y=0.2025 $X2=0.081 $Y2=0.1595
r7 9 10 2.7211 $w=2.1e-08 $l=8e-09 $layer=Gate_1 $thickness=5.6e-08 $X=0.081
+ $Y=0.1515 $X2=0.081 $Y2=0.1595
r8 8 9 5.79936 $w=2.03333e-08 $l=1.65e-08 $layer=Gate_1 $thickness=5.6e-08
+ $X=0.081 $Y=0.135 $X2=0.081 $Y2=0.1515
r9 7 8 5.79936 $w=2.03333e-08 $l=1.65e-08 $layer=Gate_1 $thickness=5.6e-08
+ $X=0.081 $Y=0.1185 $X2=0.081 $Y2=0.135
r10 6 7 7.31297 $w=2.1e-08 $l=2.15e-08 $layer=Gate_1 $thickness=5.6e-08
+ $X=0.081 $Y=0.097 $X2=0.081 $Y2=0.1185
r11 5 6 14.6259 $w=2.1e-08 $l=4.3e-08 $layer=Gate_1 $thickness=5.6e-08 $X=0.081
+ $Y=0.054 $X2=0.081 $Y2=0.097
r12 5 3 10.0341 $w=2.1e-08 $l=2.95e-08 $layer=Gate_1 $thickness=5.6e-08
+ $X=0.081 $Y=0.054 $X2=0.081 $Y2=0.0245
.ends

.subckt PM_AOI222xp33_ASAP7_75t_R%A2 vss 11 5 9 4 3 1
c1 1 vss 0.00609595f $X=0.135 $Y=0.135
c2 3 vss 0.0903075f $X=0.135 $Y=0.0245
c3 4 vss 0.00437904f $X=0.135 $Y=0.0877
r1 12 13 4.37231 $w=1.3e-08 $l=1.88e-08 $layer=M1 $thickness=3.6e-08 $X=0.135
+ $Y=0.1162 $X2=0.135 $Y2=0.135
r2 11 12 2.39019 $w=1.3e-08 $l=1.02e-08 $layer=M1 $thickness=3.6e-08 $X=0.135
+ $Y=0.106 $X2=0.135 $Y2=0.1162
r3 11 4 4.25571 $w=1.3e-08 $l=1.83e-08 $layer=M1 $thickness=3.6e-08 $X=0.135
+ $Y=0.106 $X2=0.135 $Y2=0.0877
r4 1 7 10.4265 $w=1.765e-08 $layer=LIG $thickness=5.2e-08 $X=0.135 $Y=0.135
+ $X2=0.135 $Y2=0.135
r5 1 13 19.3796 $a=3.24e-16 $layer=V0LIG $X=0.135 $Y=0.135 $X2=0.135 $Y2=0.135
r6 9 8 16.4967 $w=2.1e-08 $l=4.85e-08 $layer=Gate_1 $thickness=5.6e-08 $X=0.135
+ $Y=0.2025 $X2=0.135 $Y2=0.154
r7 7 8 6.6497 $w=2.04211e-08 $l=1.9e-08 $layer=Gate_1 $thickness=5.6e-08
+ $X=0.135 $Y=0.135 $X2=0.135 $Y2=0.154
r8 6 7 11.2416 $w=2.06615e-08 $l=3.25e-08 $layer=Gate_1 $thickness=5.6e-08
+ $X=0.135 $Y=0.1025 $X2=0.135 $Y2=0.135
r9 5 6 16.4967 $w=2.1e-08 $l=4.85e-08 $layer=Gate_1 $thickness=5.6e-08 $X=0.135
+ $Y=0.054 $X2=0.135 $Y2=0.1025
r10 5 3 10.0341 $w=2.1e-08 $l=2.95e-08 $layer=Gate_1 $thickness=5.6e-08
+ $X=0.135 $Y=0.054 $X2=0.135 $Y2=0.0245
.ends

* End of included file AOI222xp33_ASAP7_75t_R.pex.sp.pex

*
.subckt AOI222xp33_ASAP7_75t_CUSTOM_4_25_0_7 VSS VDD A1 A2 B2 B1 C1 C2 Y
*
* VSS VSS
* VDD VDD
* A1 A1
* A2 A2
* B2 B2
* B1 B1
* C1 C1
* C2 C2
* Y Y
*
*

M0 noxref_12 N_M0_g N_M0_s VSS nmos_rvt L=2e-08 W=5.4e-08 nfin=2 $X=0.071
+ $Y=0.027
M1 VSS N_M1_g noxref_12 VSS nmos_rvt L=2e-08 W=5.4e-08 nfin=2 $X=0.125 $Y=0.027
M2 noxref_13 N_M2_g VSS VSS nmos_rvt L=2e-08 W=5.4e-08 nfin=2 $X=0.179 $Y=0.027
M3 N_M3_d N_M3_g noxref_13 VSS nmos_rvt L=2e-08 W=5.4e-08 nfin=2 $X=0.233
+ $Y=0.027
M4 noxref_14 N_M4_g N_M4_s VSS nmos_rvt L=2e-08 W=5.4e-08 nfin=2 $X=0.395
+ $Y=0.027
M5 VSS N_M5_g noxref_14 VSS nmos_rvt L=2e-08 W=5.4e-08 nfin=2 $X=0.449 $Y=0.027
M6 N_M6_d N_M6_g noxref_10 VDD pmos_rvt L=2e-08 W=8.1e-08 nfin=3 $X=0.071
+ $Y=0.162
M7 noxref_10 N_M7_g N_M7_s VDD pmos_rvt L=2e-08 W=8.1e-08 nfin=3 $X=0.125
+ $Y=0.162
M8 noxref_11 N_M8_g noxref_10 VDD pmos_rvt L=2e-08 W=8.1e-08 nfin=3 $X=0.179
+ $Y=0.162
M9 noxref_10 N_M9_g noxref_11 VDD pmos_rvt L=2e-08 W=8.1e-08 nfin=3 $X=0.233
+ $Y=0.162
M10 noxref_11 N_M10_g VDD VDD pmos_rvt L=2e-08 W=8.1e-08 nfin=3 $X=0.395
+ $Y=0.162
M11 VDD N_M11_g noxref_11 VDD pmos_rvt L=2e-08 W=8.1e-08 nfin=3 $X=0.449
+ $Y=0.162

* .include "AOI222xp33_ASAP7_75t_R.pex.sp.pxi"

* Start of included file AOI222xp33_ASAP7_75t_R.pex.sp.pxi
x_PM_AOI222xp33_ASAP7_75t_R%C2 vss C2 N_M5_g N_M11_g N_C2_3
+ PM_AOI222xp33_ASAP7_75t_R%C2
cc_1 N_C2_3 N_C1_4 0.00530268f $X=0.459 $Y=0.0245
cc_2 N_C2_3 N_C1_3 0.00877656f $X=0.459 $Y=0.0245
x_PM_AOI222xp33_ASAP7_75t_R%B2 vss B2 N_M2_g N_M8_g N_B2_4 N_B2_3
+ PM_AOI222xp33_ASAP7_75t_R%B2
cc_3 N_B2_4 N_A2_4 0.003364f $X=0.189 $Y=0.098
cc_4 N_B2_3 N_A2_3 0.00718288f $X=0.189 $Y=0.0245
x_PM_AOI222xp33_ASAP7_75t_R%B1 vss B1 N_M3_g N_M9_g N_B1_4 N_B1_3
+ PM_AOI222xp33_ASAP7_75t_R%B1
cc_5 N_B1_4 N_B2_4 0.00338515f $X=0.243 $Y=0.0837
cc_6 N_B1_3 N_B2_3 0.00861109f $X=0.243 $Y=0.0245
x_PM_AOI222xp33_ASAP7_75t_R%C1 vss C1 N_M4_g N_M10_g N_C1_4 N_C1_3
+ PM_AOI222xp33_ASAP7_75t_R%C1
x_PM_AOI222xp33_ASAP7_75t_R%Y vss Y N_M0_s N_M3_d N_M4_s N_M6_d N_M7_s N_Y_2
+ N_Y_1 N_Y_21 N_Y_20 N_Y_16 N_Y_13 N_Y_19 N_Y_3 N_Y_14 N_Y_4 N_Y_15
+ PM_AOI222xp33_ASAP7_75t_R%Y
cc_7 N_Y_2 N_A1_3 0.00157707f $X=0.108 $Y=0.2025
cc_8 N_Y_1 N_A1_3 0.0009069f $X=0.054 $Y=0.054
cc_9 N_Y_21 N_A1_4 0.000970564f $X=0.038 $Y=0.198
cc_10 N_Y_20 N_A1_4 0.00110237f $X=0.0405 $Y=0.036
cc_11 N_Y_16 N_A1_1 0.00125552f $X=0.0935 $Y=0.2025
cc_12 N_Y_13 N_A1_3 0.0108064f $X=0.056 $Y=0.054
cc_13 N_Y_19 N_A1_4 0.00655253f $X=0.027 $Y=0.0575
cc_14 N_Y_16 N_A1_3 0.0500873f $X=0.0935 $Y=0.2025
cc_15 N_Y_21 N_A2_3 0.000521195f $X=0.038 $Y=0.198
cc_16 N_Y_2 N_A2_3 0.000800688f $X=0.108 $Y=0.2025
cc_17 N_Y_16 N_A2_1 0.000849194f $X=0.0935 $Y=0.2025
cc_18 N_Y_20 N_A2_4 0.00127513f $X=0.0405 $Y=0.036
cc_19 N_Y_2 N_A2_4 0.0021456f $X=0.108 $Y=0.2025
cc_20 N_Y_16 N_A2_3 0.0360821f $X=0.0935 $Y=0.2025
cc_21 N_Y_20 N_B2_4 0.00354034f $X=0.0405 $Y=0.036
cc_22 N_Y_3 N_B1_3 0.000975153f $X=0.27 $Y=0.054
cc_23 N_Y_20 N_B1_3 0.00150045f $X=0.0405 $Y=0.036
cc_24 N_Y_3 N_B1_4 0.00208004f $X=0.27 $Y=0.054
cc_25 N_Y_14 N_B1_3 0.0266078f $X=0.2555 $Y=0.054
cc_26 N_Y_20 N_C1_3 0.000949788f $X=0.0405 $Y=0.036
cc_27 N_Y_4 N_C1_3 0.000975153f $X=0.378 $Y=0.054
cc_28 N_Y_4 N_C1_4 0.00156711f $X=0.378 $Y=0.054
cc_29 N_Y_15 N_C1_3 0.0265952f $X=0.38 $Y=0.054
x_PM_AOI222xp33_ASAP7_75t_R%A1 vss A1 N_M0_g N_M6_g N_A1_4 N_A1_3 N_A1_1
+ PM_AOI222xp33_ASAP7_75t_R%A1
x_PM_AOI222xp33_ASAP7_75t_R%A2 vss A2 N_M1_g N_M7_g N_A2_4 N_A2_3 N_A2_1
+ PM_AOI222xp33_ASAP7_75t_R%A2
cc_30 N_A2_4 N_A1_4 0.00337288f $X=0.135 $Y=0.0877
cc_31 N_A2_3 N_A1_3 0.00857845f $X=0.135 $Y=0.0245

* End of included file AOI222xp33_ASAP7_75t_R.pex.sp.pxi
.ends

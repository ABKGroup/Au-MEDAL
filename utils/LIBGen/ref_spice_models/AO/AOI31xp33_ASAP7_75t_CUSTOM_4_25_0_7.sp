.subckt PM_AOI31xp33_ASAP7_75t_R%A3 vss 15 5 11 3 4
c1 1 vss 0.00556312f $X=0.081 $Y=0.135
c2 3 vss 0.126045f $X=0.081 $Y=0.0245
c3 4 vss 0.0146331f $X=0.081 $Y=0.0795
r1 15 4 12.7088 $w=1.3e-08 $l=5.45e-08 $layer=M1 $thickness=3.6e-08 $X=0.0855
+ $Y=0.1355 $X2=0.081 $Y2=0.0795
r2 1 8 6.54019 $w=2.09524e-08 $layer=Gate_1 $thickness=5.21905e-08 $X=0.081
+ $Y=0.135 $X2=0.081 $Y2=0.135
r3 15 1 19.3796 $a=3.24e-16 $layer=V0LIG $X=0.0855 $Y=0.1355 $X2=0.081 $Y2=0.135
r4 11 10 14.6259 $w=2.1e-08 $l=4.3e-08 $layer=Gate_1 $thickness=5.6e-08
+ $X=0.081 $Y=0.216 $X2=0.081 $Y2=0.173
r5 9 10 7.31297 $w=2.1e-08 $l=2.15e-08 $layer=Gate_1 $thickness=5.6e-08
+ $X=0.081 $Y=0.1515 $X2=0.081 $Y2=0.173
r6 8 9 5.79936 $w=2.03333e-08 $l=1.65e-08 $layer=Gate_1 $thickness=5.6e-08
+ $X=0.081 $Y=0.135 $X2=0.081 $Y2=0.1515
r7 7 8 5.79936 $w=2.03333e-08 $l=1.65e-08 $layer=Gate_1 $thickness=5.6e-08
+ $X=0.081 $Y=0.1185 $X2=0.081 $Y2=0.135
r8 6 7 2.7211 $w=2.1e-08 $l=8e-09 $layer=Gate_1 $thickness=5.6e-08 $X=0.081
+ $Y=0.1105 $X2=0.081 $Y2=0.1185
r9 5 6 14.6259 $w=2.1e-08 $l=4.3e-08 $layer=Gate_1 $thickness=5.6e-08 $X=0.081
+ $Y=0.0675 $X2=0.081 $Y2=0.1105
r10 5 3 14.6259 $w=2.1e-08 $l=4.3e-08 $layer=Gate_1 $thickness=5.6e-08 $X=0.081
+ $Y=0.0675 $X2=0.081 $Y2=0.0245
.ends

.subckt PM_AOI31xp33_ASAP7_75t_R%A2 vss 13 5 9 1 4 3
c1 1 vss 0.00246529f $X=0.135 $Y=0.135
c2 3 vss 0.103195f $X=0.135 $Y=0.0245
c3 4 vss 0.00982664f $X=0.135 $Y=0.0975
r1 13 4 8.51143 $w=1.3e-08 $l=3.65e-08 $layer=M1 $thickness=3.6e-08 $X=0.1355
+ $Y=0.1355 $X2=0.135 $Y2=0.0975
r2 1 7 6.54019 $w=2.09524e-08 $layer=Gate_1 $thickness=5.21905e-08 $X=0.135
+ $Y=0.135 $X2=0.135 $Y2=0.135
r3 13 1 19.3796 $a=3.24e-16 $layer=V0LIG $X=0.1355 $Y=0.1355 $X2=0.135 $Y2=0.135
r4 9 8 16.4967 $w=2.1e-08 $l=4.85e-08 $layer=Gate_1 $thickness=5.6e-08 $X=0.135
+ $Y=0.216 $X2=0.135 $Y2=0.1675
r5 7 8 11.2416 $w=2.06615e-08 $l=3.25e-08 $layer=Gate_1 $thickness=5.6e-08
+ $X=0.135 $Y=0.135 $X2=0.135 $Y2=0.1675
r6 6 7 6.6497 $w=2.04211e-08 $l=1.9e-08 $layer=Gate_1 $thickness=5.6e-08
+ $X=0.135 $Y=0.116 $X2=0.135 $Y2=0.135
r7 5 6 16.4967 $w=2.1e-08 $l=4.85e-08 $layer=Gate_1 $thickness=5.6e-08 $X=0.135
+ $Y=0.0675 $X2=0.135 $Y2=0.116
r8 5 3 14.6259 $w=2.1e-08 $l=4.3e-08 $layer=Gate_1 $thickness=5.6e-08 $X=0.135
+ $Y=0.0675 $X2=0.135 $Y2=0.0245
.ends

.subckt PM_AOI31xp33_ASAP7_75t_R%B vss 15 5 11 4 3 1
c1 1 vss 0.0116774f $X=0.243 $Y=0.135
c2 3 vss 0.0728213f $X=0.243 $Y=0.0245
c3 4 vss 0.00669021f $X=0.243 $Y=0.0975
r1 15 4 8.51143 $w=1.3e-08 $l=3.65e-08 $layer=M1 $thickness=3.6e-08 $X=0.2405
+ $Y=0.1355 $X2=0.243 $Y2=0.0975
r2 1 8 6.54019 $w=2.09524e-08 $layer=Gate_1 $thickness=5.21905e-08 $X=0.243
+ $Y=0.135 $X2=0.243 $Y2=0.135
r3 15 1 19.3796 $a=3.24e-16 $layer=V0LIG $X=0.2405 $Y=0.1355 $X2=0.243 $Y2=0.135
r4 11 10 14.6259 $w=2.1e-08 $l=4.3e-08 $layer=Gate_1 $thickness=5.6e-08
+ $X=0.243 $Y=0.216 $X2=0.243 $Y2=0.173
r5 9 10 7.31297 $w=2.1e-08 $l=2.15e-08 $layer=Gate_1 $thickness=5.6e-08
+ $X=0.243 $Y=0.1515 $X2=0.243 $Y2=0.173
r6 8 9 5.79936 $w=2.03333e-08 $l=1.65e-08 $layer=Gate_1 $thickness=5.6e-08
+ $X=0.243 $Y=0.135 $X2=0.243 $Y2=0.1515
r7 7 8 5.79936 $w=2.03333e-08 $l=1.65e-08 $layer=Gate_1 $thickness=5.6e-08
+ $X=0.243 $Y=0.1185 $X2=0.243 $Y2=0.135
r8 6 7 7.31297 $w=2.1e-08 $l=2.15e-08 $layer=Gate_1 $thickness=5.6e-08 $X=0.243
+ $Y=0.097 $X2=0.243 $Y2=0.1185
r9 5 6 14.6259 $w=2.1e-08 $l=4.3e-08 $layer=Gate_1 $thickness=5.6e-08 $X=0.243
+ $Y=0.054 $X2=0.243 $Y2=0.097
r10 5 3 10.0341 $w=2.1e-08 $l=2.95e-08 $layer=Gate_1 $thickness=5.6e-08
+ $X=0.243 $Y=0.054 $X2=0.243 $Y2=0.0245
.ends

.subckt PM_AOI31xp33_ASAP7_75t_R%A1 vss 13 5 9 3 4
c1 1 vss 0.00977462f $X=0.189 $Y=0.135
c2 3 vss 0.0855645f $X=0.189 $Y=0.0245
c3 4 vss 0.00923656f $X=0.189 $Y=0.0975
r1 13 4 8.51143 $w=1.3e-08 $l=3.65e-08 $layer=M1 $thickness=3.6e-08 $X=0.1895
+ $Y=0.1355 $X2=0.189 $Y2=0.0975
r2 1 7 6.54019 $w=2.09524e-08 $layer=Gate_1 $thickness=5.21905e-08 $X=0.189
+ $Y=0.135 $X2=0.189 $Y2=0.135
r3 13 1 19.3796 $a=3.24e-16 $layer=V0LIG $X=0.1895 $Y=0.1355 $X2=0.189 $Y2=0.135
r4 9 8 16.4967 $w=2.1e-08 $l=4.85e-08 $layer=Gate_1 $thickness=5.6e-08 $X=0.189
+ $Y=0.216 $X2=0.189 $Y2=0.1675
r5 7 8 11.2416 $w=2.06615e-08 $l=3.25e-08 $layer=Gate_1 $thickness=5.6e-08
+ $X=0.189 $Y=0.135 $X2=0.189 $Y2=0.1675
r6 6 7 6.6497 $w=2.04211e-08 $l=1.9e-08 $layer=Gate_1 $thickness=5.6e-08
+ $X=0.189 $Y=0.116 $X2=0.189 $Y2=0.135
r7 5 6 16.4967 $w=2.1e-08 $l=4.85e-08 $layer=Gate_1 $thickness=5.6e-08 $X=0.189
+ $Y=0.0675 $X2=0.189 $Y2=0.116
r8 5 3 14.6259 $w=2.1e-08 $l=4.3e-08 $layer=Gate_1 $thickness=5.6e-08 $X=0.189
+ $Y=0.0675 $X2=0.189 $Y2=0.0245
.ends

.subckt PM_AOI31xp33_ASAP7_75t_R%Y vss 31 16 19 38 1 7 9 13 10 14
c1 1 vss 0.00637545f $X=0.216 $Y=0.054
c2 2 vss 0.00697288f $X=0.27 $Y=0.216
c3 7 vss 0.00260895f $X=0.2015 $Y=0.0725
c4 8 vss 0.000123988f $X=0.2015 $Y=0.0455
c5 9 vss 0.000260944f $X=0.2015 $Y=0.0945
c6 10 vss 0.0263455f $X=0.2555 $Y=0.216
c7 11 vss 0.0032042f $X=0.297 $Y=0.198
c8 12 vss 0.0027819f $X=0.297 $Y=0.036
c9 13 vss 0.00792824f $X=0.204 $Y=0.036
c10 14 vss 0.00475917f $X=0.297 $Y=0.0575
r1 10 2 0.231482 $w=5.4e-08 $l=1.25e-08 $layer=P_src_drn $thickness=1e-09
+ $X=0.2555 $Y=0.216 $X2=0.27 $Y2=0.216
r2 38 10 0.0462963 $w=5.4e-08 $l=2.5e-09 $layer=P_src_drn $thickness=1e-09
+ $X=0.2526 $Y=0.216 $X2=0.2555 $Y2=0.216
r3 2 35 19.3796 $a=3.24e-16 $layer=V0LISD $X=0.27 $Y=0.216 $X2=0.27 $Y2=0.198
r4 35 36 3.14806 $w=1.3e-08 $l=1.35e-08 $layer=M1 $thickness=3.6e-08 $X=0.27
+ $Y=0.198 $X2=0.2835 $Y2=0.198
r5 11 33 3.83327 $w=1.5093e-08 $l=2.15e-08 $layer=M1 $thickness=3.6e-08
+ $X=0.297 $Y=0.198 $X2=0.297 $Y2=0.1765
r6 11 36 1.96775 $w=1.63333e-08 $l=1.35e-08 $layer=M1 $thickness=3.6e-08
+ $X=0.297 $Y=0.198 $X2=0.2835 $Y2=0.198
r7 32 33 9.0361 $w=1.3e-08 $l=3.88e-08 $layer=M1 $thickness=3.6e-08 $X=0.297
+ $Y=0.1377 $X2=0.297 $Y2=0.1765
r8 31 32 6.23783 $w=1.3e-08 $l=2.67e-08 $layer=M1 $thickness=3.6e-08 $X=0.299
+ $Y=0.111 $X2=0.297 $Y2=0.1377
r9 31 30 4.83869 $w=1.3e-08 $l=2.08e-08 $layer=M1 $thickness=3.6e-08 $X=0.299
+ $Y=0.111 $X2=0.297 $Y2=0.0902
r10 14 30 7.63696 $w=1.3e-08 $l=3.27e-08 $layer=M1 $thickness=3.6e-08 $X=0.297
+ $Y=0.0575 $X2=0.297 $Y2=0.0902
r11 12 29 4.18063 $w=1.48e-08 $l=2.5e-08 $layer=M1 $thickness=3.6e-08 $X=0.297
+ $Y=0.036 $X2=0.272 $Y2=0.036
r12 12 14 3.36447 $w=1.71023e-08 $l=2.15e-08 $layer=M1 $thickness=3.6e-08
+ $X=0.297 $Y=0.036 $X2=0.297 $Y2=0.0575
r13 28 29 4.19742 $w=1.3e-08 $l=1.8e-08 $layer=M1 $thickness=3.6e-08 $X=0.254
+ $Y=0.036 $X2=0.272 $Y2=0.036
r14 27 28 2.56509 $w=1.3e-08 $l=1.1e-08 $layer=M1 $thickness=3.6e-08 $X=0.243
+ $Y=0.036 $X2=0.254 $Y2=0.036
r15 26 27 2.56509 $w=1.3e-08 $l=1.1e-08 $layer=M1 $thickness=3.6e-08 $X=0.232
+ $Y=0.036 $X2=0.243 $Y2=0.036
r16 25 26 1.04935 $w=1.3e-08 $l=4.5e-09 $layer=M1 $thickness=3.6e-08 $X=0.2275
+ $Y=0.036 $X2=0.232 $Y2=0.036
r17 24 25 2.68168 $w=1.3e-08 $l=1.15e-08 $layer=M1 $thickness=3.6e-08 $X=0.216
+ $Y=0.036 $X2=0.2275 $Y2=0.036
r18 13 24 2.79828 $w=1.3e-08 $l=1.2e-08 $layer=M1 $thickness=3.6e-08 $X=0.204
+ $Y=0.036 $X2=0.216 $Y2=0.036
r19 1 24 19.3796 $a=3.24e-16 $layer=V0LISD $X=0.216 $Y=0.054 $X2=0.216 $Y2=0.036
r20 9 1 0.462963 $w=2.7e-08 $l=1.25e-08 $layer=N_src_drn $thickness=1e-09
+ $X=0.2015 $Y=0.0945 $X2=0.216 $Y2=0.054
r21 8 1 0.245304 $w=3.7e-08 $l=1.45e-08 $layer=N_src_drn $thickness=1e-09
+ $X=0.2015 $Y=0.0455 $X2=0.216 $Y2=0.054
r22 19 18 0.147059 $w=1.7e-08 $l=2.5e-09 $layer=N_src_drn $thickness=1e-09
+ $X=0.2333 $Y=0.054 $X2=0.2305 $Y2=0.0725
r23 17 18 0.264706 $w=1.7e-08 $l=4.5e-09 $layer=N_src_drn $thickness=1e-09
+ $X=0.226 $Y=0.0725 $X2=0.2305 $Y2=0.0725
r24 1 17 0.705882 $w=1.7e-08 $l=1.2e-08 $layer=N_src_drn $thickness=1e-09
+ $X=0.216 $Y=0.054 $X2=0.226 $Y2=0.0725
r25 7 1 0.735294 $w=1.7e-08 $l=1.25e-08 $layer=N_src_drn $thickness=1e-09
+ $X=0.2015 $Y=0.0725 $X2=0.216 $Y2=0.054
r26 16 7 0.147059 $w=1.7e-08 $l=2.5e-09 $layer=N_src_drn $thickness=1e-09
+ $X=0.1986 $Y=0.0675 $X2=0.2015 $Y2=0.0725
.ends

* End of included file AOI31xp33_ASAP7_75t_R.pex.sp.pex

*
.subckt AOI31xp33_ASAP7_75t_CUSTOM_4_25_0_7 VSS VDD A3 A2 A1 B Y
*
* VSS VSS
* VDD VDD
* A3 A3
* A2 A2
* A1 A1
* B B
* Y Y
*
*

M0 noxref_9 N_M0_g VSS VSS nmos_rvt L=2e-08 W=8.1e-08 nfin=3 $X=0.071 $Y=0.027
M1 noxref_10 N_M1_g noxref_9 VSS nmos_rvt L=2e-08 W=8.1e-08 nfin=3 $X=0.125
+ $Y=0.027
M2 N_M2_d N_M2_g noxref_10 VSS nmos_rvt L=2e-08 W=8.1e-08 nfin=3 $X=0.179
+ $Y=0.027
M3 VSS N_M3_g N_M3_s VSS nmos_rvt L=2e-08 W=5.4e-08 nfin=2 $X=0.233 $Y=0.027
M4 noxref_7 N_M4_g VDD VDD pmos_rvt L=2e-08 W=5.4e-08 nfin=2 $X=0.071 $Y=0.189
M5 VDD N_M5_g noxref_7 VDD pmos_rvt L=2e-08 W=5.4e-08 nfin=2 $X=0.125 $Y=0.189
M6 noxref_7 N_M6_g VDD VDD pmos_rvt L=2e-08 W=5.4e-08 nfin=2 $X=0.179 $Y=0.189
M7 N_M7_d N_M7_g noxref_7 VDD pmos_rvt L=2e-08 W=5.4e-08 nfin=2 $X=0.233
+ $Y=0.189

* .include "AOI31xp33_ASAP7_75t_R.pex.sp.pxi"

* Start of included file AOI31xp33_ASAP7_75t_R.pex.sp.pxi
x_PM_AOI31xp33_ASAP7_75t_R%A3 vss A3 N_M0_g N_M4_g N_A3_3 N_A3_4
+ PM_AOI31xp33_ASAP7_75t_R%A3
x_PM_AOI31xp33_ASAP7_75t_R%A2 vss A2 N_M1_g N_M5_g N_A2_1 N_A2_4 N_A2_3
+ PM_AOI31xp33_ASAP7_75t_R%A2
cc_1 N_A2_1 N_A3_3 0.00165344f $X=0.135 $Y=0.135
cc_2 N_A2_4 N_A3_4 0.00637256f $X=0.135 $Y=0.0975
cc_3 N_A2_3 N_A3_3 0.00801959f $X=0.135 $Y=0.0245
x_PM_AOI31xp33_ASAP7_75t_R%B vss B N_M3_g N_M7_g N_B_4 N_B_3 N_B_1
+ PM_AOI31xp33_ASAP7_75t_R%B
cc_4 N_B_4 N_A1_4 0.00373941f $X=0.243 $Y=0.0975
cc_5 N_B_3 N_A1_3 0.00706469f $X=0.243 $Y=0.0245
x_PM_AOI31xp33_ASAP7_75t_R%A1 vss A1 N_M2_g N_M6_g N_A1_3 N_A1_4
+ PM_AOI31xp33_ASAP7_75t_R%A1
cc_6 N_A1_3 N_A2_1 0.00161783f $X=0.189 $Y=0.0245
cc_7 N_A1_4 N_A2_4 0.00532291f $X=0.189 $Y=0.0975
cc_8 N_A1_3 N_A2_3 0.00786004f $X=0.189 $Y=0.0245
x_PM_AOI31xp33_ASAP7_75t_R%Y vss Y N_M2_d N_M3_s N_M7_d N_Y_1 N_Y_7 N_Y_9
+ N_Y_13 N_Y_10 N_Y_14 PM_AOI31xp33_ASAP7_75t_R%Y
cc_9 N_Y_1 N_A2_4 0.00155914f $X=0.216 $Y=0.054
cc_10 N_Y_1 N_A1_3 0.00137795f $X=0.216 $Y=0.054
cc_11 N_Y_1 N_A1_4 0.00141144f $X=0.216 $Y=0.054
cc_12 N_Y_7 N_A1_3 0.00915319f $X=0.2015 $Y=0.0725
cc_13 N_Y_9 N_A1_3 0.0309605f $X=0.2015 $Y=0.0945
cc_14 N_Y_13 N_B_3 0.000890066f $X=0.204 $Y=0.036
cc_15 N_Y_1 N_B_3 0.00121316f $X=0.216 $Y=0.054
cc_16 N_Y_7 N_B_1 0.00129569f $X=0.2015 $Y=0.0725
cc_17 N_Y_10 N_B_3 0.0100374f $X=0.2555 $Y=0.216
cc_18 N_Y_9 N_B_3 0.00477365f $X=0.2015 $Y=0.0945
cc_19 N_Y_14 N_B_4 0.00571001f $X=0.297 $Y=0.0575
cc_20 N_Y_7 N_B_3 0.0486341f $X=0.2015 $Y=0.0725

* End of included file AOI31xp33_ASAP7_75t_R.pex.sp.pxi
.ends

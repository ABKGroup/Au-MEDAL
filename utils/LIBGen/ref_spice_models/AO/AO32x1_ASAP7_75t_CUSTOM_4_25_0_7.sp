.subckt PM_AO32x1_ASAP7_75t_R%A3 vss 13 5 9 4 3
c1 1 vss 0.005792f $X=0.135 $Y=0.135
c2 3 vss 0.145659f $X=0.135 $Y=0.0245
c3 4 vss 0.00653234f $X=0.135 $Y=0.135
r1 13 12 3.73104 $w=1.3e-08 $l=1.6e-08 $layer=M1 $thickness=3.6e-08 $X=0.137
+ $Y=0.1755 $X2=0.135 $Y2=0.1595
r2 4 12 5.71315 $w=1.3e-08 $l=2.45e-08 $layer=M1 $thickness=3.6e-08 $X=0.135
+ $Y=0.135 $X2=0.135 $Y2=0.1595
r3 1 7 10.4265 $w=1.765e-08 $layer=LIG $thickness=5.2e-08 $X=0.135 $Y=0.135
+ $X2=0.135 $Y2=0.135
r4 1 4 19.3796 $a=3.24e-16 $layer=V0LIG $X=0.135 $Y=0.135 $X2=0.135 $Y2=0.135
r5 9 8 16.4967 $w=2.1e-08 $l=4.85e-08 $layer=Gate_1 $thickness=5.6e-08 $X=0.135
+ $Y=0.216 $X2=0.135 $Y2=0.1675
r6 7 8 11.2416 $w=2.06615e-08 $l=3.25e-08 $layer=Gate_1 $thickness=5.6e-08
+ $X=0.135 $Y=0.135 $X2=0.135 $Y2=0.1675
r7 6 7 6.6497 $w=2.04211e-08 $l=1.9e-08 $layer=Gate_1 $thickness=5.6e-08
+ $X=0.135 $Y=0.116 $X2=0.135 $Y2=0.135
r8 5 6 16.4967 $w=2.1e-08 $l=4.85e-08 $layer=Gate_1 $thickness=5.6e-08 $X=0.135
+ $Y=0.0675 $X2=0.135 $Y2=0.116
r9 5 3 14.6259 $w=2.1e-08 $l=4.3e-08 $layer=Gate_1 $thickness=5.6e-08 $X=0.135
+ $Y=0.0675 $X2=0.135 $Y2=0.0245
.ends

.subckt PM_AO32x1_ASAP7_75t_R%B1 vss 11 5 9 3 4 1
c1 1 vss 0.00241314f $X=0.297 $Y=0.135
c2 3 vss 0.0517615f $X=0.297 $Y=0.0245
c3 4 vss 0.00748543f $X=0.297 $Y=0.0945
r1 12 13 2.79828 $w=1.3e-08 $l=1.2e-08 $layer=M1 $thickness=3.6e-08 $X=0.297
+ $Y=0.123 $X2=0.297 $Y2=0.135
r2 11 12 0.816164 $w=1.3e-08 $l=3.5e-09 $layer=M1 $thickness=3.6e-08 $X=0.297
+ $Y=0.1195 $X2=0.297 $Y2=0.123
r3 11 4 5.82974 $w=1.3e-08 $l=2.5e-08 $layer=M1 $thickness=3.6e-08 $X=0.297
+ $Y=0.1195 $X2=0.297 $Y2=0.0945
r4 1 7 10.4265 $w=1.765e-08 $layer=LIG $thickness=5.2e-08 $X=0.297 $Y=0.135
+ $X2=0.297 $Y2=0.135
r5 1 13 19.3796 $a=3.24e-16 $layer=V0LIG $X=0.297 $Y=0.135 $X2=0.297 $Y2=0.135
r6 9 8 16.4967 $w=2.1e-08 $l=4.85e-08 $layer=Gate_1 $thickness=5.6e-08 $X=0.297
+ $Y=0.216 $X2=0.297 $Y2=0.1675
r7 7 8 11.2416 $w=2.06615e-08 $l=3.25e-08 $layer=Gate_1 $thickness=5.6e-08
+ $X=0.297 $Y=0.135 $X2=0.297 $Y2=0.1675
r8 6 7 11.2416 $w=2.06615e-08 $l=3.25e-08 $layer=Gate_1 $thickness=5.6e-08
+ $X=0.297 $Y=0.1025 $X2=0.297 $Y2=0.135
r9 5 6 16.4967 $w=2.1e-08 $l=4.85e-08 $layer=Gate_1 $thickness=5.6e-08 $X=0.297
+ $Y=0.054 $X2=0.297 $Y2=0.1025
r10 5 3 10.0341 $w=2.1e-08 $l=2.95e-08 $layer=Gate_1 $thickness=5.6e-08
+ $X=0.297 $Y=0.054 $X2=0.297 $Y2=0.0245
.ends

.subckt PM_AO32x1_ASAP7_75t_R%A2 vss 11 5 9 4 3
c1 1 vss 0.00243265f $X=0.189 $Y=0.135
c2 3 vss 0.103118f $X=0.189 $Y=0.0245
c3 4 vss 0.00637771f $X=0.189 $Y=0.098
r1 11 4 8.62802 $w=1.3e-08 $l=3.7e-08 $layer=M1 $thickness=3.6e-08 $X=0.189
+ $Y=0.1295 $X2=0.189 $Y2=0.098
r2 1 7 10.4265 $w=1.765e-08 $layer=LIG $thickness=5.2e-08 $X=0.189 $Y=0.135
+ $X2=0.189 $Y2=0.135
r3 11 1 19.3796 $a=3.24e-16 $layer=V0LIG $X=0.189 $Y=0.1295 $X2=0.189 $Y2=0.135
r4 9 8 16.4967 $w=2.1e-08 $l=4.85e-08 $layer=Gate_1 $thickness=5.6e-08 $X=0.189
+ $Y=0.216 $X2=0.189 $Y2=0.1675
r5 7 8 11.2416 $w=2.06615e-08 $l=3.25e-08 $layer=Gate_1 $thickness=5.6e-08
+ $X=0.189 $Y=0.135 $X2=0.189 $Y2=0.1675
r6 6 7 6.6497 $w=2.04211e-08 $l=1.9e-08 $layer=Gate_1 $thickness=5.6e-08
+ $X=0.189 $Y=0.116 $X2=0.189 $Y2=0.135
r7 5 6 16.4967 $w=2.1e-08 $l=4.85e-08 $layer=Gate_1 $thickness=5.6e-08 $X=0.189
+ $Y=0.0675 $X2=0.189 $Y2=0.116
r8 5 3 14.6259 $w=2.1e-08 $l=4.3e-08 $layer=Gate_1 $thickness=5.6e-08 $X=0.189
+ $Y=0.0675 $X2=0.189 $Y2=0.0245
.ends

.subckt PM_AO32x1_ASAP7_75t_R%Y vss 21 14 29 8 11 12 7
c1 7 vss 0.0495305f $X=0.056 $Y=0.0675
c2 8 vss 0.0510216f $X=0.056 $Y=0.2025
c3 9 vss 0.00213878f $X=0.0405 $Y=0.072
c4 10 vss 0.00764384f $X=0.027 $Y=0.234
c5 11 vss 0.00411463f $X=0.054 $Y=0.037
c6 12 vss 0.00864094f $X=0.027 $Y=0.1035
r1 29 28 0.0308642 $w=8.1e-08 $l=2.5e-09 $layer=P_src_drn $thickness=1e-09
+ $X=0.0713 $Y=0.2025 $X2=0.0685 $Y2=0.2025
r2 8 28 0.154321 $w=8.1e-08 $l=1.25e-08 $layer=P_src_drn $thickness=1e-09
+ $X=0.056 $Y=0.2025 $X2=0.0685 $Y2=0.2025
r3 8 25 19.3796 $a=3.24e-16 $layer=V0LISD $X=0.056 $Y=0.2025 $X2=0.0535
+ $Y2=0.234
r4 24 25 3.03147 $w=1.3e-08 $l=1.3e-08 $layer=M1 $thickness=3.6e-08 $X=0.0405
+ $Y=0.234 $X2=0.0535 $Y2=0.234
r5 10 23 3.83327 $w=1.5093e-08 $l=2.15e-08 $layer=M1 $thickness=3.6e-08
+ $X=0.027 $Y=0.234 $X2=0.027 $Y2=0.2125
r6 10 24 1.96775 $w=1.63333e-08 $l=1.35e-08 $layer=M1 $thickness=3.6e-08
+ $X=0.027 $Y=0.234 $X2=0.0405 $Y2=0.234
r7 22 23 5.71315 $w=1.3e-08 $l=2.45e-08 $layer=M1 $thickness=3.6e-08 $X=0.027
+ $Y=0.188 $X2=0.027 $Y2=0.2125
r8 21 22 2.91487 $w=1.3e-08 $l=1.25e-08 $layer=M1 $thickness=3.6e-08 $X=0.026
+ $Y=0.1755 $X2=0.027 $Y2=0.188
r9 21 20 3.73104 $w=1.3e-08 $l=1.6e-08 $layer=M1 $thickness=3.6e-08 $X=0.026
+ $Y=0.1755 $X2=0.027 $Y2=0.1595
r10 19 20 5.71315 $w=1.3e-08 $l=2.45e-08 $layer=M1 $thickness=3.6e-08 $X=0.027
+ $Y=0.135 $X2=0.027 $Y2=0.1595
r11 12 18 6.16517 $w=1.44286e-08 $l=3.15e-08 $layer=M1 $thickness=3.6e-08
+ $X=0.027 $Y=0.1035 $X2=0.027 $Y2=0.072
r12 12 19 7.34548 $w=1.3e-08 $l=3.15e-08 $layer=M1 $thickness=3.6e-08 $X=0.027
+ $Y=0.1035 $X2=0.027 $Y2=0.135
r13 9 17 1.96775 $w=1.63333e-08 $l=1.35e-08 $layer=M1 $thickness=3.6e-08
+ $X=0.0405 $Y=0.072 $X2=0.054 $Y2=0.072
r14 9 18 1.96775 $w=1.63333e-08 $l=1.35e-08 $layer=M1 $thickness=3.6e-08
+ $X=0.0405 $Y=0.072 $X2=0.027 $Y2=0.072
r15 16 17 1.50137 $w=1.6913e-08 $l=1.15e-08 $layer=M1 $thickness=3.6e-08
+ $X=0.054 $Y=0.0605 $X2=0.054 $Y2=0.072
r16 15 16 2.68168 $w=1.3e-08 $l=1.15e-08 $layer=M1 $thickness=3.6e-08 $X=0.054
+ $Y=0.049 $X2=0.054 $Y2=0.0605
r17 11 15 2.79828 $w=1.3e-08 $l=1.2e-08 $layer=M1 $thickness=3.6e-08 $X=0.054
+ $Y=0.037 $X2=0.054 $Y2=0.049
r18 7 15 19.3796 $a=3.24e-16 $layer=V0LISD $X=0.056 $Y=0.0675 $X2=0.054
+ $Y2=0.049
r19 14 13 0.0308642 $w=8.1e-08 $l=2.5e-09 $layer=N_src_drn $thickness=1e-09
+ $X=0.0713 $Y=0.0675 $X2=0.0685 $Y2=0.0675
r20 7 13 0.154321 $w=8.1e-08 $l=1.25e-08 $layer=N_src_drn $thickness=1e-09
+ $X=0.056 $Y=0.0675 $X2=0.0685 $Y2=0.0675
.ends

.subckt PM_AO32x1_ASAP7_75t_R%3 vss 22 28 58 61 74 75 19 1 18 9 14 3 10 12 13 4
+ 20 21 15
c1 1 vss 0.00376619f $X=0.078 $Y=0.135
c2 3 vss 0.00484504f $X=0.27 $Y=0.054
c3 4 vss 0.00788024f $X=0.324 $Y=0.216
c4 9 vss 0.117519f $X=0.081 $Y=0.0245
c5 10 vss 0.00199376f $X=0.2555 $Y=0.0725
c6 11 vss 0.000127697f $X=0.2555 $Y=0.0455
c7 12 vss 0.000261701f $X=0.2555 $Y=0.0945
c8 13 vss 0.00365172f $X=0.3095 $Y=0.216
c9 14 vss 0.000732047f $X=0.065 $Y=0.135
c10 15 vss 0.00275907f $X=0.099 $Y=0.0395
c11 16 vss 0.00302253f $X=0.405 $Y=0.036
c12 17 vss 0.00222297f $X=0.405 $Y=0.198
c13 18 vss 0.00203936f $X=0.099 $Y=0.1035
c14 19 vss 0.0241396f $X=0.117 $Y=0.036
c15 20 vss 0.00749717f $X=0.394 $Y=0.198
c16 21 vss 0.00543607f $X=0.405 $Y=0.0575
r1 75 73 0.0462963 $w=5.4e-08 $l=2.5e-09 $layer=P_src_drn $thickness=1e-09
+ $X=0.3413 $Y=0.216 $X2=0.3385 $Y2=0.216
r2 4 73 0.268519 $w=5.4e-08 $l=1.45e-08 $layer=P_src_drn $thickness=1e-09
+ $X=0.324 $Y=0.216 $X2=0.3385 $Y2=0.216
r3 13 4 0.268519 $w=5.4e-08 $l=1.45e-08 $layer=P_src_drn $thickness=1e-09
+ $X=0.3095 $Y=0.216 $X2=0.324 $Y2=0.216
r4 74 13 0.0462963 $w=5.4e-08 $l=2.5e-09 $layer=P_src_drn $thickness=1e-09
+ $X=0.3066 $Y=0.216 $X2=0.3095 $Y2=0.216
r5 4 70 19.3796 $a=3.24e-16 $layer=V0LISD $X=0.324 $Y=0.216 $X2=0.324 $Y2=0.198
r6 70 71 3.14806 $w=1.3e-08 $l=1.35e-08 $layer=M1 $thickness=3.6e-08 $X=0.324
+ $Y=0.198 $X2=0.3375 $Y2=0.198
r7 68 71 3.14806 $w=1.3e-08 $l=1.35e-08 $layer=M1 $thickness=3.6e-08 $X=0.351
+ $Y=0.198 $X2=0.3375 $Y2=0.198
r8 67 68 5.82974 $w=1.3e-08 $l=2.5e-08 $layer=M1 $thickness=3.6e-08 $X=0.376
+ $Y=0.198 $X2=0.351 $Y2=0.198
r9 20 67 4.19742 $w=1.3e-08 $l=1.8e-08 $layer=M1 $thickness=3.6e-08 $X=0.394
+ $Y=0.198 $X2=0.376 $Y2=0.198
r10 17 66 3.36447 $w=1.71023e-08 $l=2.15e-08 $layer=M1 $thickness=3.6e-08
+ $X=0.405 $Y=0.198 $X2=0.405 $Y2=0.1765
r11 17 20 0.915974 $w=1.70909e-08 $l=1.1e-08 $layer=M1 $thickness=3.6e-08
+ $X=0.405 $Y=0.198 $X2=0.394 $Y2=0.198
r12 65 66 13.8748 $w=1.3e-08 $l=5.95e-08 $layer=M1 $thickness=3.6e-08 $X=0.405
+ $Y=0.117 $X2=0.405 $Y2=0.1765
r13 21 65 13.8748 $w=1.3e-08 $l=5.95e-08 $layer=M1 $thickness=3.6e-08 $X=0.405
+ $Y=0.0575 $X2=0.405 $Y2=0.117
r14 12 3 0.462963 $w=2.7e-08 $l=1.25e-08 $layer=N_src_drn $thickness=1e-09
+ $X=0.2555 $Y=0.0945 $X2=0.27 $Y2=0.054
r15 11 3 0.391892 $w=3.7e-08 $l=1.45e-08 $layer=N_src_drn $thickness=1e-09
+ $X=0.2555 $Y=0.0455 $X2=0.27 $Y2=0.054
r16 61 60 0.147059 $w=1.7e-08 $l=2.5e-09 $layer=N_src_drn $thickness=1e-09
+ $X=0.2873 $Y=0.054 $X2=0.2845 $Y2=0.0725
r17 59 60 0.264706 $w=1.7e-08 $l=4.5e-09 $layer=N_src_drn $thickness=1e-09
+ $X=0.28 $Y=0.0725 $X2=0.2845 $Y2=0.0725
r18 3 59 0.705882 $w=1.7e-08 $l=1.2e-08 $layer=N_src_drn $thickness=1e-09
+ $X=0.27 $Y=0.054 $X2=0.28 $Y2=0.0725
r19 10 3 0.735294 $w=1.7e-08 $l=1.25e-08 $layer=N_src_drn $thickness=1e-09
+ $X=0.2555 $Y=0.0725 $X2=0.27 $Y2=0.054
r20 58 10 0.147059 $w=1.7e-08 $l=2.5e-09 $layer=N_src_drn $thickness=1e-09
+ $X=0.2526 $Y=0.0675 $X2=0.2555 $Y2=0.0725
r21 16 55 4.64701 $w=1.46667e-08 $l=2.7e-08 $layer=M1 $thickness=3.6e-08
+ $X=0.405 $Y=0.036 $X2=0.378 $Y2=0.036
r22 16 21 3.36447 $w=1.71023e-08 $l=2.15e-08 $layer=M1 $thickness=3.6e-08
+ $X=0.405 $Y=0.036 $X2=0.405 $Y2=0.0575
r23 3 49 19.3796 $a=3.24e-16 $layer=V0LISD $X=0.27 $Y=0.054 $X2=0.27 $Y2=0.036
r24 54 55 6.29612 $w=1.3e-08 $l=2.7e-08 $layer=M1 $thickness=3.6e-08 $X=0.351
+ $Y=0.036 $X2=0.378 $Y2=0.036
r25 53 54 5.82974 $w=1.3e-08 $l=2.5e-08 $layer=M1 $thickness=3.6e-08 $X=0.326
+ $Y=0.036 $X2=0.351 $Y2=0.036
r26 52 53 4.19742 $w=1.3e-08 $l=1.8e-08 $layer=M1 $thickness=3.6e-08 $X=0.308
+ $Y=0.036 $X2=0.326 $Y2=0.036
r27 51 52 2.56509 $w=1.3e-08 $l=1.1e-08 $layer=M1 $thickness=3.6e-08 $X=0.297
+ $Y=0.036 $X2=0.308 $Y2=0.036
r28 50 51 3.14806 $w=1.3e-08 $l=1.35e-08 $layer=M1 $thickness=3.6e-08 $X=0.2835
+ $Y=0.036 $X2=0.297 $Y2=0.036
r29 49 50 3.14806 $w=1.3e-08 $l=1.35e-08 $layer=M1 $thickness=3.6e-08 $X=0.27
+ $Y=0.036 $X2=0.2835 $Y2=0.036
r30 48 49 3.14806 $w=1.3e-08 $l=1.35e-08 $layer=M1 $thickness=3.6e-08 $X=0.2565
+ $Y=0.036 $X2=0.27 $Y2=0.036
r31 47 48 3.14806 $w=1.3e-08 $l=1.35e-08 $layer=M1 $thickness=3.6e-08 $X=0.243
+ $Y=0.036 $X2=0.2565 $Y2=0.036
r32 46 47 6.29612 $w=1.3e-08 $l=2.7e-08 $layer=M1 $thickness=3.6e-08 $X=0.216
+ $Y=0.036 $X2=0.243 $Y2=0.036
r33 45 46 6.29612 $w=1.3e-08 $l=2.7e-08 $layer=M1 $thickness=3.6e-08 $X=0.189
+ $Y=0.036 $X2=0.216 $Y2=0.036
r34 44 45 5.82974 $w=1.3e-08 $l=2.5e-08 $layer=M1 $thickness=3.6e-08 $X=0.164
+ $Y=0.036 $X2=0.189 $Y2=0.036
r35 43 44 4.19742 $w=1.3e-08 $l=1.8e-08 $layer=M1 $thickness=3.6e-08 $X=0.146
+ $Y=0.036 $X2=0.164 $Y2=0.036
r36 42 43 2.56509 $w=1.3e-08 $l=1.1e-08 $layer=M1 $thickness=3.6e-08 $X=0.135
+ $Y=0.036 $X2=0.146 $Y2=0.036
r37 19 42 4.19742 $w=1.3e-08 $l=1.8e-08 $layer=M1 $thickness=3.6e-08 $X=0.117
+ $Y=0.036 $X2=0.135 $Y2=0.036
r38 15 40 3.47612 $w=1.45278e-08 $l=1.8e-08 $layer=M1 $thickness=3.6e-08
+ $X=0.099 $Y=0.0395 $X2=0.099 $Y2=0.0575
r39 15 19 2.65995 $w=1.48966e-08 $l=1.83371e-08 $layer=M1 $thickness=3.6e-08
+ $X=0.099 $Y=0.0395 $X2=0.117 $Y2=0.036
r40 39 40 4.19742 $w=1.3e-08 $l=1.8e-08 $layer=M1 $thickness=3.6e-08 $X=0.099
+ $Y=0.0755 $X2=0.099 $Y2=0.0575
r41 18 38 6.16517 $w=1.44286e-08 $l=3.15e-08 $layer=M1 $thickness=3.6e-08
+ $X=0.099 $Y=0.1035 $X2=0.099 $Y2=0.135
r42 18 39 6.52931 $w=1.3e-08 $l=2.8e-08 $layer=M1 $thickness=3.6e-08 $X=0.099
+ $Y=0.1035 $X2=0.099 $Y2=0.0755
r43 37 38 1.50137 $w=1.6913e-08 $l=1.15e-08 $layer=M1 $thickness=3.6e-08
+ $X=0.0875 $Y=0.135 $X2=0.099 $Y2=0.135
r44 36 37 2.56509 $w=1.3e-08 $l=1.1e-08 $layer=M1 $thickness=3.6e-08 $X=0.0765
+ $Y=0.135 $X2=0.0875 $Y2=0.135
r45 34 36 2.09871 $w=1.3e-08 $l=9e-09 $layer=M1 $thickness=3.6e-08 $X=0.0675
+ $Y=0.135 $X2=0.0765 $Y2=0.135
r46 14 34 0.582974 $w=1.3e-08 $l=2.5e-09 $layer=M1 $thickness=3.6e-08 $X=0.065
+ $Y=0.135 $X2=0.0675 $Y2=0.135
r47 1 30 2.6116 $w=2.2e-08 $l=1e-08 $layer=LIG $thickness=4.8e-08 $X=0.078
+ $Y=0.135 $X2=0.088 $Y2=0.135
r48 1 25 5.75672 $w=2.07778e-08 $l=3e-09 $layer=Gate_1 $thickness=5.28889e-08
+ $X=0.078 $Y=0.135 $X2=0.081 $Y2=0.135
r49 1 36 19.3796 $a=3.24e-16 $layer=V0LIG $X=0.078 $Y=0.135 $X2=0.0765 $Y2=0.135
r50 28 27 14.6259 $w=2.1e-08 $l=4.3e-08 $layer=Gate_1 $thickness=5.6e-08
+ $X=0.081 $Y=0.2025 $X2=0.081 $Y2=0.1595
r51 26 27 2.7211 $w=2.1e-08 $l=8e-09 $layer=Gate_1 $thickness=5.6e-08 $X=0.081
+ $Y=0.1515 $X2=0.081 $Y2=0.1595
r52 25 26 5.79936 $w=2.03333e-08 $l=1.65e-08 $layer=Gate_1 $thickness=5.6e-08
+ $X=0.081 $Y=0.135 $X2=0.081 $Y2=0.1515
r53 25 30 4.71208 $w=2.04286e-08 $l=7e-09 $layer=Gate_1 $thickness=5.42857e-08
+ $X=0.081 $Y=0.135 $X2=0.088 $Y2=0.135
r54 24 25 5.79936 $w=2.03333e-08 $l=1.65e-08 $layer=Gate_1 $thickness=5.6e-08
+ $X=0.081 $Y=0.1185 $X2=0.081 $Y2=0.135
r55 23 24 2.7211 $w=2.1e-08 $l=8e-09 $layer=Gate_1 $thickness=5.6e-08 $X=0.081
+ $Y=0.1105 $X2=0.081 $Y2=0.1185
r56 22 23 14.6259 $w=2.1e-08 $l=4.3e-08 $layer=Gate_1 $thickness=5.6e-08
+ $X=0.081 $Y=0.0675 $X2=0.081 $Y2=0.1105
r57 22 9 14.6259 $w=2.1e-08 $l=4.3e-08 $layer=Gate_1 $thickness=5.6e-08
+ $X=0.081 $Y=0.0675 $X2=0.081 $Y2=0.0245
.ends

.subckt PM_AO32x1_ASAP7_75t_R%A1 vss 14 5 9 3 4
c1 1 vss 0.0101722f $X=0.243 $Y=0.135
c2 3 vss 0.0868454f $X=0.243 $Y=0.0245
c3 4 vss 0.00891676f $X=0.243 $Y=0.098
r1 14 13 1.51573 $w=1.3e-08 $l=6.5e-09 $layer=M1 $thickness=3.6e-08 $X=0.248
+ $Y=0.1765 $X2=0.243 $Y2=0.17
r2 12 13 3.73104 $w=1.3e-08 $l=1.6e-08 $layer=M1 $thickness=3.6e-08 $X=0.243
+ $Y=0.154 $X2=0.243 $Y2=0.17
r3 11 12 4.4306 $w=1.3e-08 $l=1.9e-08 $layer=M1 $thickness=3.6e-08 $X=0.243
+ $Y=0.135 $X2=0.243 $Y2=0.154
r4 4 11 8.62802 $w=1.3e-08 $l=3.7e-08 $layer=M1 $thickness=3.6e-08 $X=0.243
+ $Y=0.098 $X2=0.243 $Y2=0.135
r5 1 7 10.4265 $w=1.765e-08 $layer=LIG $thickness=5.2e-08 $X=0.243 $Y=0.135
+ $X2=0.243 $Y2=0.135
r6 1 11 19.3796 $a=3.24e-16 $layer=V0LIG $X=0.243 $Y=0.135 $X2=0.243 $Y2=0.135
r7 9 8 16.4967 $w=2.1e-08 $l=4.85e-08 $layer=Gate_1 $thickness=5.6e-08 $X=0.243
+ $Y=0.216 $X2=0.243 $Y2=0.1675
r8 7 8 11.2416 $w=2.06615e-08 $l=3.25e-08 $layer=Gate_1 $thickness=5.6e-08
+ $X=0.243 $Y=0.135 $X2=0.243 $Y2=0.1675
r9 6 7 6.6497 $w=2.04211e-08 $l=1.9e-08 $layer=Gate_1 $thickness=5.6e-08
+ $X=0.243 $Y=0.116 $X2=0.243 $Y2=0.135
r10 5 6 16.4967 $w=2.1e-08 $l=4.85e-08 $layer=Gate_1 $thickness=5.6e-08
+ $X=0.243 $Y=0.0675 $X2=0.243 $Y2=0.116
r11 5 3 14.6259 $w=2.1e-08 $l=4.3e-08 $layer=Gate_1 $thickness=5.6e-08 $X=0.243
+ $Y=0.0675 $X2=0.243 $Y2=0.0245
.ends

.subckt PM_AO32x1_ASAP7_75t_R%B2 vss 13 5 11 3 4
c1 1 vss 0.00291348f $X=0.351 $Y=0.135
c2 3 vss 0.0846664f $X=0.351 $Y=0.0245
c3 4 vss 0.00640374f $X=0.351 $Y=0.098
r1 13 4 8.62802 $w=1.3e-08 $l=3.7e-08 $layer=M1 $thickness=3.6e-08 $X=0.354
+ $Y=0.1345 $X2=0.351 $Y2=0.098
r2 1 8 10.4265 $w=1.765e-08 $layer=LIG $thickness=5.2e-08 $X=0.351 $Y=0.135
+ $X2=0.351 $Y2=0.135
r3 13 1 19.3796 $a=3.24e-16 $layer=V0LIG $X=0.354 $Y=0.1345 $X2=0.351 $Y2=0.135
r4 11 10 14.6259 $w=2.1e-08 $l=4.3e-08 $layer=Gate_1 $thickness=5.6e-08
+ $X=0.351 $Y=0.216 $X2=0.351 $Y2=0.173
r5 9 10 7.31297 $w=2.1e-08 $l=2.15e-08 $layer=Gate_1 $thickness=5.6e-08
+ $X=0.351 $Y=0.1515 $X2=0.351 $Y2=0.173
r6 8 9 5.79936 $w=2.03333e-08 $l=1.65e-08 $layer=Gate_1 $thickness=5.6e-08
+ $X=0.351 $Y=0.135 $X2=0.351 $Y2=0.1515
r7 7 8 5.79936 $w=2.03333e-08 $l=1.65e-08 $layer=Gate_1 $thickness=5.6e-08
+ $X=0.351 $Y=0.1185 $X2=0.351 $Y2=0.135
r8 6 7 7.31297 $w=2.1e-08 $l=2.15e-08 $layer=Gate_1 $thickness=5.6e-08 $X=0.351
+ $Y=0.097 $X2=0.351 $Y2=0.1185
r9 5 6 14.6259 $w=2.1e-08 $l=4.3e-08 $layer=Gate_1 $thickness=5.6e-08 $X=0.351
+ $Y=0.054 $X2=0.351 $Y2=0.097
r10 5 3 10.0341 $w=2.1e-08 $l=2.95e-08 $layer=Gate_1 $thickness=5.6e-08
+ $X=0.351 $Y=0.054 $X2=0.351 $Y2=0.0245
.ends

* End of included file AO32x1_ASAP7_75t_R.pex.sp.pex

*
.subckt AO32x1_ASAP7_75t_CUSTOM_4_25_0_7 VSS VDD A3 A2 A1 B1 B2 Y
*
* VSS VSS
* VDD VDD
* A3 A3
* A2 A2
* A1 A1
* B1 B1
* B2 B2
* Y Y
*
*

M0 VSS N_M0_g N_M0_s VSS nmos_rvt L=2e-08 W=8.1e-08 nfin=3 $X=0.071 $Y=0.027
M1 noxref_11 N_M1_g VSS VSS nmos_rvt L=2e-08 W=8.1e-08 nfin=3 $X=0.125 $Y=0.027
M2 noxref_12 N_M2_g noxref_11 VSS nmos_rvt L=2e-08 W=8.1e-08 nfin=3 $X=0.179
+ $Y=0.027
M3 N_M3_d N_M3_g noxref_12 VSS nmos_rvt L=2e-08 W=8.1e-08 nfin=3 $X=0.233
+ $Y=0.027
M4 noxref_13 N_M4_g N_M4_s VSS nmos_rvt L=2e-08 W=5.4e-08 nfin=2 $X=0.287
+ $Y=0.027
M5 VSS N_M5_g noxref_13 VSS nmos_rvt L=2e-08 W=5.4e-08 nfin=2 $X=0.341 $Y=0.027
M6 VDD N_M6_g N_M6_s VDD pmos_rvt L=2e-08 W=8.1e-08 nfin=3 $X=0.071 $Y=0.162
M7 noxref_10 N_M7_g VDD VDD pmos_rvt L=2e-08 W=5.4e-08 nfin=2 $X=0.125 $Y=0.189
M8 VDD N_M8_g noxref_10 VDD pmos_rvt L=2e-08 W=5.4e-08 nfin=2 $X=0.179 $Y=0.189
M9 noxref_10 N_M9_g VDD VDD pmos_rvt L=2e-08 W=5.4e-08 nfin=2 $X=0.233 $Y=0.189
M10 N_M10_d N_M10_g noxref_10 VDD pmos_rvt L=2e-08 W=5.4e-08 nfin=2 $X=0.287
+ $Y=0.189
M11 noxref_10 N_M11_g N_M11_s VDD pmos_rvt L=2e-08 W=5.4e-08 nfin=2 $X=0.341
+ $Y=0.189

* .include "AO32x1_ASAP7_75t_R.pex.sp.pxi"

* Start of included file AO32x1_ASAP7_75t_R.pex.sp.pxi
x_PM_AO32x1_ASAP7_75t_R%A3 vss A3 N_M1_g N_M7_g N_A3_4 N_A3_3
+ PM_AO32x1_ASAP7_75t_R%A3
cc_1 N_A3_4 N_3_19 0.000972255f $X=0.135 $Y=0.135
cc_2 N_A3_4 N_3_1 0.00107339f $X=0.135 $Y=0.135
cc_3 N_A3_4 N_3_18 0.00211164f $X=0.135 $Y=0.135
cc_4 N_A3_3 N_3_9 0.00320251f $X=0.135 $Y=0.0245
cc_5 N_A3_4 N_3_14 0.00616585f $X=0.135 $Y=0.135
x_PM_AO32x1_ASAP7_75t_R%B1 vss B1 N_M4_g N_M10_g N_B1_3 N_B1_4 N_B1_1
+ PM_AO32x1_ASAP7_75t_R%B1
cc_6 N_B1_3 N_3_13 0.0105996f $X=0.297 $Y=0.0245
cc_7 N_B1_3 N_3_4 0.000826127f $X=0.297 $Y=0.0245
cc_8 N_B1_3 N_3_3 0.00179621f $X=0.297 $Y=0.0245
cc_9 N_B1_4 N_3_20 0.000537975f $X=0.297 $Y=0.0945
cc_10 N_B1_1 N_3_10 0.00101542f $X=0.297 $Y=0.135
cc_11 N_B1_4 N_3_19 0.00118813f $X=0.297 $Y=0.0945
cc_12 N_B1_4 N_3_3 0.00247671f $X=0.297 $Y=0.0945
cc_13 N_B1_3 N_3_12 0.00498744f $X=0.297 $Y=0.0245
cc_14 N_B1_3 N_3_10 0.0436866f $X=0.297 $Y=0.0245
cc_15 N_B1_4 N_A1_4 0.00366958f $X=0.297 $Y=0.0945
cc_16 N_B1_3 N_A1_3 0.00692878f $X=0.297 $Y=0.0245
x_PM_AO32x1_ASAP7_75t_R%A2 vss A2 N_M2_g N_M8_g N_A2_4 N_A2_3
+ PM_AO32x1_ASAP7_75t_R%A2
cc_17 N_A2_4 N_3_19 0.00139888f $X=0.189 $Y=0.098
cc_18 N_A2_4 N_3_14 0.00235734f $X=0.189 $Y=0.098
cc_19 N_A2_4 N_A3_4 0.00475171f $X=0.189 $Y=0.098
cc_20 N_A2_3 N_A3_3 0.00937948f $X=0.189 $Y=0.0245
x_PM_AO32x1_ASAP7_75t_R%Y vss Y N_M0_s N_M6_s N_Y_8 N_Y_11 N_Y_12 N_Y_7
+ PM_AO32x1_ASAP7_75t_R%Y
cc_21 N_Y_8 N_3_15 0.000540135f $X=0.056 $Y=0.2025
cc_22 N_Y_8 N_3_1 0.00319739f $X=0.056 $Y=0.2025
cc_23 N_Y_11 N_3_18 0.0030543f $X=0.054 $Y=0.037
cc_24 N_Y_12 N_3_14 0.00320802f $X=0.027 $Y=0.1035
cc_25 N_Y_7 N_3_9 0.0145267f $X=0.056 $Y=0.0675
cc_26 N_Y_8 N_3_9 0.0443856f $X=0.056 $Y=0.2025
x_PM_AO32x1_ASAP7_75t_R%3 vss N_M0_g N_M6_g N_M3_d N_M4_s N_M10_d N_M11_s
+ N_3_19 N_3_1 N_3_18 N_3_9 N_3_14 N_3_3 N_3_10 N_3_12 N_3_13 N_3_4 N_3_20
+ N_3_21 N_3_15 PM_AO32x1_ASAP7_75t_R%3
x_PM_AO32x1_ASAP7_75t_R%A1 vss A1 N_M3_g N_M9_g N_A1_3 N_A1_4
+ PM_AO32x1_ASAP7_75t_R%A1
cc_27 N_A1_3 N_3_3 0.00164053f $X=0.243 $Y=0.0245
cc_28 N_A1_3 N_3_10 0.0103841f $X=0.243 $Y=0.0245
cc_29 N_A1_4 N_3_19 0.00121482f $X=0.243 $Y=0.098
cc_30 N_A1_4 N_3_3 0.0020058f $X=0.243 $Y=0.098
cc_31 N_A1_3 N_3_12 0.0325565f $X=0.243 $Y=0.0245
cc_32 N_A1_4 N_A2_4 0.00480664f $X=0.243 $Y=0.098
cc_33 N_A1_3 N_A2_3 0.00934112f $X=0.243 $Y=0.0245
x_PM_AO32x1_ASAP7_75t_R%B2 vss B2 N_M5_g N_M11_g N_B2_3 N_B2_4
+ PM_AO32x1_ASAP7_75t_R%B2
cc_34 N_B2_3 N_3_4 0.000790171f $X=0.351 $Y=0.0245
cc_35 N_B2_3 N_3_21 0.00067422f $X=0.351 $Y=0.0245
cc_36 N_B2_4 N_3_20 0.00102696f $X=0.351 $Y=0.098
cc_37 N_B2_4 N_3_19 0.00116242f $X=0.351 $Y=0.098
cc_38 N_B2_4 N_3_21 0.00616421f $X=0.351 $Y=0.098
cc_39 N_B2_3 N_3_13 0.0256293f $X=0.351 $Y=0.0245
cc_40 N_B2_4 N_B1_4 0.00336954f $X=0.351 $Y=0.098
cc_41 N_B2_3 N_B1_3 0.0107878f $X=0.351 $Y=0.0245

* End of included file AO32x1_ASAP7_75t_R.pex.sp.pxi
.ends

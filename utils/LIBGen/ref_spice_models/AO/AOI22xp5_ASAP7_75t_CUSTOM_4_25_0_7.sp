.subckt PM_AOI22xp5_ASAP7_75t_R%A1 vss 22 10 16 3
c1 1 vss 0.00689492f $X=0.081 $Y=0.135
c2 3 vss 0.142748f $X=0.081 $Y=0.0245
c3 4 vss 0.00715049f $X=0.027 $Y=0.036
c4 5 vss 0.00110319f $X=0.027 $Y=0.135
c5 6 vss 0.00635042f $X=0.027 $Y=0.198
c6 7 vss 0.00620652f $X=0.027 $Y=0.098
c7 8 vss 0.00328057f $X=0.027 $Y=0.1472
c8 9 vss 0.00300509f $X=0.0635 $Y=0.135
r1 6 23 5.29071 $w=1.46216e-08 $l=2.78e-08 $layer=M1 $thickness=3.6e-08
+ $X=0.027 $Y=0.198 $X2=0.027 $Y2=0.1702
r2 4 21 3.83327 $w=1.5093e-08 $l=2.15e-08 $layer=M1 $thickness=3.6e-08 $X=0.027
+ $Y=0.036 $X2=0.027 $Y2=0.0575
r3 22 23 4.4889 $w=1.3e-08 $l=1.92e-08 $layer=M1 $thickness=3.6e-08 $X=0.018
+ $Y=0.151 $X2=0.027 $Y2=0.1702
r4 22 8 0.874462 $w=1.3e-08 $l=3.8e-09 $layer=M1 $thickness=3.6e-08 $X=0.018
+ $Y=0.151 $X2=0.027 $Y2=0.1472
r5 7 21 9.44419 $w=1.3e-08 $l=4.05e-08 $layer=M1 $thickness=3.6e-08 $X=0.027
+ $Y=0.098 $X2=0.027 $Y2=0.0575
r6 5 20 3.1337 $w=1.54324e-08 $l=1.85e-08 $layer=M1 $thickness=3.6e-08 $X=0.027
+ $Y=0.135 $X2=0.0455 $Y2=0.135
r7 5 7 7.44771 $w=1.42162e-08 $l=3.7e-08 $layer=M1 $thickness=3.6e-08 $X=0.027
+ $Y=0.135 $X2=0.027 $Y2=0.098
r8 5 8 1.67627 $w=1.66735e-08 $l=1.22e-08 $layer=M1 $thickness=3.6e-08 $X=0.027
+ $Y=0.135 $X2=0.027 $Y2=0.1472
r9 9 18 4.08082 $w=1.3e-08 $l=1.75e-08 $layer=M1 $thickness=3.6e-08 $X=0.0635
+ $Y=0.135 $X2=0.081 $Y2=0.135
r10 9 20 4.19742 $w=1.3e-08 $l=1.8e-08 $layer=M1 $thickness=3.6e-08 $X=0.0635
+ $Y=0.135 $X2=0.0455 $Y2=0.135
r11 1 13 10.4265 $w=1.765e-08 $layer=LIG $thickness=5.2e-08 $X=0.081 $Y=0.135
+ $X2=0.081 $Y2=0.135
r12 1 18 19.3796 $a=3.24e-16 $layer=V0LIG $X=0.081 $Y=0.135 $X2=0.081 $Y2=0.135
r13 16 15 14.6259 $w=2.1e-08 $l=4.3e-08 $layer=Gate_1 $thickness=5.6e-08
+ $X=0.081 $Y=0.2025 $X2=0.081 $Y2=0.1595
r14 14 15 2.7211 $w=2.1e-08 $l=8e-09 $layer=Gate_1 $thickness=5.6e-08 $X=0.081
+ $Y=0.1515 $X2=0.081 $Y2=0.1595
r15 13 14 5.79936 $w=2.03333e-08 $l=1.65e-08 $layer=Gate_1 $thickness=5.6e-08
+ $X=0.081 $Y=0.135 $X2=0.081 $Y2=0.1515
r16 12 13 5.79936 $w=2.03333e-08 $l=1.65e-08 $layer=Gate_1 $thickness=5.6e-08
+ $X=0.081 $Y=0.1185 $X2=0.081 $Y2=0.135
r17 11 12 2.7211 $w=2.1e-08 $l=8e-09 $layer=Gate_1 $thickness=5.6e-08 $X=0.081
+ $Y=0.1105 $X2=0.081 $Y2=0.1185
r18 10 11 14.6259 $w=2.1e-08 $l=4.3e-08 $layer=Gate_1 $thickness=5.6e-08
+ $X=0.081 $Y=0.0675 $X2=0.081 $Y2=0.1105
r19 10 3 14.6259 $w=2.1e-08 $l=4.3e-08 $layer=Gate_1 $thickness=5.6e-08
+ $X=0.081 $Y=0.0675 $X2=0.081 $Y2=0.0245
.ends

.subckt PM_AOI22xp5_ASAP7_75t_R%B1 vss 13 5 11 4 3
c1 1 vss 0.0047715f $X=0.243 $Y=0.135
c2 3 vss 0.107571f $X=0.243 $Y=0.0245
c3 4 vss 0.0050294f $X=0.243 $Y=0.0752
r1 14 15 7.28718 $w=1.3e-08 $l=3.13e-08 $layer=M1 $thickness=3.6e-08 $X=0.243
+ $Y=0.1037 $X2=0.243 $Y2=0.135
r2 13 14 5.30507 $w=1.3e-08 $l=2.27e-08 $layer=M1 $thickness=3.6e-08 $X=0.245
+ $Y=0.081 $X2=0.243 $Y2=0.1037
r3 13 4 1.34084 $w=1.3e-08 $l=5.8e-09 $layer=M1 $thickness=3.6e-08 $X=0.245
+ $Y=0.081 $X2=0.243 $Y2=0.0752
r4 1 8 10.4265 $w=1.765e-08 $layer=LIG $thickness=5.2e-08 $X=0.243 $Y=0.135
+ $X2=0.243 $Y2=0.135
r5 1 15 19.3796 $a=3.24e-16 $layer=V0LIG $X=0.243 $Y=0.135 $X2=0.243 $Y2=0.135
r6 11 10 14.6259 $w=2.1e-08 $l=4.3e-08 $layer=Gate_1 $thickness=5.6e-08
+ $X=0.243 $Y=0.2025 $X2=0.243 $Y2=0.1595
r7 9 10 2.7211 $w=2.1e-08 $l=8e-09 $layer=Gate_1 $thickness=5.6e-08 $X=0.243
+ $Y=0.1515 $X2=0.243 $Y2=0.1595
r8 8 9 5.79936 $w=2.03333e-08 $l=1.65e-08 $layer=Gate_1 $thickness=5.6e-08
+ $X=0.243 $Y=0.135 $X2=0.243 $Y2=0.1515
r9 7 8 5.79936 $w=2.03333e-08 $l=1.65e-08 $layer=Gate_1 $thickness=5.6e-08
+ $X=0.243 $Y=0.1185 $X2=0.243 $Y2=0.135
r10 6 7 2.7211 $w=2.1e-08 $l=8e-09 $layer=Gate_1 $thickness=5.6e-08 $X=0.243
+ $Y=0.1105 $X2=0.243 $Y2=0.1185
r11 5 6 14.6259 $w=2.1e-08 $l=4.3e-08 $layer=Gate_1 $thickness=5.6e-08 $X=0.243
+ $Y=0.0675 $X2=0.243 $Y2=0.1105
r12 5 3 14.6259 $w=2.1e-08 $l=4.3e-08 $layer=Gate_1 $thickness=5.6e-08 $X=0.243
+ $Y=0.0675 $X2=0.243 $Y2=0.0245
.ends

.subckt PM_AOI22xp5_ASAP7_75t_R%Y vss 26 16 17 36 37 1 7 11 8 12 13
c1 1 vss 0.00615298f $X=0.162 $Y=0.0675
c2 2 vss 0.00950333f $X=0.216 $Y=0.2025
c3 7 vss 0.00259439f $X=0.1475 $Y=0.0675
c4 8 vss 0.00451461f $X=0.2015 $Y=0.2025
c5 9 vss 0.00292978f $X=0.297 $Y=0.036
c6 10 vss 0.00231889f $X=0.297 $Y=0.198
c7 11 vss 0.0133601f $X=0.1505 $Y=0.036
c8 12 vss 0.00762357f $X=0.286 $Y=0.198
c9 13 vss 0.00618895f $X=0.297 $Y=0.0575
r1 37 35 0.0308642 $w=8.1e-08 $l=2.5e-09 $layer=P_src_drn $thickness=1e-09
+ $X=0.2333 $Y=0.2025 $X2=0.2305 $Y2=0.2025
r2 2 35 0.179012 $w=8.1e-08 $l=1.45e-08 $layer=P_src_drn $thickness=1e-09
+ $X=0.216 $Y=0.2025 $X2=0.2305 $Y2=0.2025
r3 8 2 0.179012 $w=8.1e-08 $l=1.45e-08 $layer=P_src_drn $thickness=1e-09
+ $X=0.2015 $Y=0.2025 $X2=0.216 $Y2=0.2025
r4 36 8 0.0308642 $w=8.1e-08 $l=2.5e-09 $layer=P_src_drn $thickness=1e-09
+ $X=0.1986 $Y=0.2025 $X2=0.2015 $Y2=0.2025
r5 2 32 19.3796 $a=3.24e-16 $layer=V0LISD $X=0.216 $Y=0.2025 $X2=0.216 $Y2=0.198
r6 32 33 3.14806 $w=1.3e-08 $l=1.35e-08 $layer=M1 $thickness=3.6e-08 $X=0.216
+ $Y=0.198 $X2=0.2295 $Y2=0.198
r7 30 33 3.14806 $w=1.3e-08 $l=1.35e-08 $layer=M1 $thickness=3.6e-08 $X=0.243
+ $Y=0.198 $X2=0.2295 $Y2=0.198
r8 29 30 5.82974 $w=1.3e-08 $l=2.5e-08 $layer=M1 $thickness=3.6e-08 $X=0.268
+ $Y=0.198 $X2=0.243 $Y2=0.198
r9 12 29 4.19742 $w=1.3e-08 $l=1.8e-08 $layer=M1 $thickness=3.6e-08 $X=0.286
+ $Y=0.198 $X2=0.268 $Y2=0.198
r10 10 28 3.36447 $w=1.71023e-08 $l=2.15e-08 $layer=M1 $thickness=3.6e-08
+ $X=0.297 $Y=0.198 $X2=0.297 $Y2=0.1765
r11 10 12 0.915974 $w=1.70909e-08 $l=1.1e-08 $layer=M1 $thickness=3.6e-08
+ $X=0.297 $Y=0.198 $X2=0.286 $Y2=0.198
r12 27 28 8.68632 $w=1.3e-08 $l=3.73e-08 $layer=M1 $thickness=3.6e-08 $X=0.297
+ $Y=0.1392 $X2=0.297 $Y2=0.1765
r13 26 27 5.88804 $w=1.3e-08 $l=2.52e-08 $layer=M1 $thickness=3.6e-08 $X=0.297
+ $Y=0.114 $X2=0.297 $Y2=0.1392
r14 26 25 5.18847 $w=1.3e-08 $l=2.23e-08 $layer=M1 $thickness=3.6e-08 $X=0.297
+ $Y=0.114 $X2=0.297 $Y2=0.0917
r15 13 25 7.98675 $w=1.3e-08 $l=3.42e-08 $layer=M1 $thickness=3.6e-08 $X=0.297
+ $Y=0.0575 $X2=0.297 $Y2=0.0917
r16 9 24 4.64701 $w=1.46667e-08 $l=2.7e-08 $layer=M1 $thickness=3.6e-08
+ $X=0.297 $Y=0.036 $X2=0.27 $Y2=0.036
r17 9 13 3.36447 $w=1.71023e-08 $l=2.15e-08 $layer=M1 $thickness=3.6e-08
+ $X=0.297 $Y=0.036 $X2=0.297 $Y2=0.0575
r18 23 24 6.29612 $w=1.3e-08 $l=2.7e-08 $layer=M1 $thickness=3.6e-08 $X=0.243
+ $Y=0.036 $X2=0.27 $Y2=0.036
r19 22 23 5.82974 $w=1.3e-08 $l=2.5e-08 $layer=M1 $thickness=3.6e-08 $X=0.218
+ $Y=0.036 $X2=0.243 $Y2=0.036
r20 21 22 4.19742 $w=1.3e-08 $l=1.8e-08 $layer=M1 $thickness=3.6e-08 $X=0.2
+ $Y=0.036 $X2=0.218 $Y2=0.036
r21 20 21 2.56509 $w=1.3e-08 $l=1.1e-08 $layer=M1 $thickness=3.6e-08 $X=0.189
+ $Y=0.036 $X2=0.2 $Y2=0.036
r22 19 20 3.14806 $w=1.3e-08 $l=1.35e-08 $layer=M1 $thickness=3.6e-08 $X=0.1755
+ $Y=0.036 $X2=0.189 $Y2=0.036
r23 18 19 3.14806 $w=1.3e-08 $l=1.35e-08 $layer=M1 $thickness=3.6e-08 $X=0.162
+ $Y=0.036 $X2=0.1755 $Y2=0.036
r24 11 18 2.68168 $w=1.3e-08 $l=1.15e-08 $layer=M1 $thickness=3.6e-08 $X=0.1505
+ $Y=0.036 $X2=0.162 $Y2=0.036
r25 1 18 19.3796 $a=3.24e-16 $layer=V0LISD $X=0.162 $Y=0.0675 $X2=0.162
+ $Y2=0.036
r26 17 15 0.0308642 $w=8.1e-08 $l=2.5e-09 $layer=N_src_drn $thickness=1e-09
+ $X=0.1793 $Y=0.0675 $X2=0.1765 $Y2=0.0675
r27 1 15 0.179012 $w=8.1e-08 $l=1.45e-08 $layer=N_src_drn $thickness=1e-09
+ $X=0.162 $Y=0.0675 $X2=0.1765 $Y2=0.0675
r28 7 1 0.179012 $w=8.1e-08 $l=1.45e-08 $layer=N_src_drn $thickness=1e-09
+ $X=0.1475 $Y=0.0675 $X2=0.162 $Y2=0.0675
r29 16 7 0.0308642 $w=8.1e-08 $l=2.5e-09 $layer=N_src_drn $thickness=1e-09
+ $X=0.1446 $Y=0.0675 $X2=0.1475 $Y2=0.0675
.ends

.subckt PM_AOI22xp5_ASAP7_75t_R%A2 vss 15 6 10 1 5 3
c1 1 vss 0.00665622f $X=0.135 $Y=0.135
c2 3 vss 0.102007f $X=0.135 $Y=0.0245
c3 4 vss 0.00757242f $X=0.135 $Y=0.198
c4 5 vss 0.00525692f $X=0.135 $Y=0.135
r1 4 16 1.20989 $w=1.73902e-08 $l=1.03e-08 $layer=M1 $thickness=3.6e-08
+ $X=0.135 $Y=0.198 $X2=0.135 $Y2=0.1877
r2 15 16 0.408082 $w=1.3e-08 $l=1.7e-09 $layer=M1 $thickness=3.6e-08 $X=0.135
+ $Y=0.186 $X2=0.135 $Y2=0.1877
r3 15 14 2.62338 $w=1.3e-08 $l=1.13e-08 $layer=M1 $thickness=3.6e-08 $X=0.135
+ $Y=0.186 $X2=0.135 $Y2=0.1747
r4 13 14 4.83869 $w=1.3e-08 $l=2.07e-08 $layer=M1 $thickness=3.6e-08 $X=0.135
+ $Y=0.154 $X2=0.135 $Y2=0.1747
r5 5 13 4.43061 $w=1.3e-08 $l=1.9e-08 $layer=M1 $thickness=3.6e-08 $X=0.135
+ $Y=0.135 $X2=0.135 $Y2=0.154
r6 1 8 10.4265 $w=1.765e-08 $layer=LIG $thickness=5.2e-08 $X=0.135 $Y=0.135
+ $X2=0.135 $Y2=0.135
r7 1 5 19.3796 $a=3.24e-16 $layer=V0LIG $X=0.135 $Y=0.135 $X2=0.135 $Y2=0.135
r8 10 9 16.4967 $w=2.1e-08 $l=4.85e-08 $layer=Gate_1 $thickness=5.6e-08
+ $X=0.135 $Y=0.2025 $X2=0.135 $Y2=0.154
r9 8 9 6.6497 $w=2.04211e-08 $l=1.9e-08 $layer=Gate_1 $thickness=5.6e-08
+ $X=0.135 $Y=0.135 $X2=0.135 $Y2=0.154
r10 7 8 6.6497 $w=2.04211e-08 $l=1.9e-08 $layer=Gate_1 $thickness=5.6e-08
+ $X=0.135 $Y=0.116 $X2=0.135 $Y2=0.135
r11 6 7 16.4967 $w=2.1e-08 $l=4.85e-08 $layer=Gate_1 $thickness=5.6e-08
+ $X=0.135 $Y=0.0675 $X2=0.135 $Y2=0.116
r12 6 3 14.6259 $w=2.1e-08 $l=4.3e-08 $layer=Gate_1 $thickness=5.6e-08 $X=0.135
+ $Y=0.0675 $X2=0.135 $Y2=0.0245
.ends

.subckt PM_AOI22xp5_ASAP7_75t_R%B2 vss 11 5 9 3 4 1
c1 1 vss 0.00776881f $X=0.189 $Y=0.135
c2 3 vss 0.065394f $X=0.189 $Y=0.0245
c3 4 vss 0.00483017f $X=0.189 $Y=0.0922
r1 12 13 3.32295 $w=1.3e-08 $l=1.43e-08 $layer=M1 $thickness=3.6e-08 $X=0.189
+ $Y=0.1207 $X2=0.189 $Y2=0.135
r2 11 12 1.34084 $w=1.3e-08 $l=5.7e-09 $layer=M1 $thickness=3.6e-08 $X=0.188
+ $Y=0.115 $X2=0.189 $Y2=0.1207
r3 11 4 5.30507 $w=1.3e-08 $l=2.28e-08 $layer=M1 $thickness=3.6e-08 $X=0.188
+ $Y=0.115 $X2=0.189 $Y2=0.0922
r4 1 7 10.4265 $w=1.765e-08 $layer=LIG $thickness=5.2e-08 $X=0.189 $Y=0.135
+ $X2=0.189 $Y2=0.135
r5 1 13 19.3796 $a=3.24e-16 $layer=V0LIG $X=0.189 $Y=0.135 $X2=0.189 $Y2=0.135
r6 9 8 16.4967 $w=2.1e-08 $l=4.85e-08 $layer=Gate_1 $thickness=5.6e-08 $X=0.189
+ $Y=0.2025 $X2=0.189 $Y2=0.154
r7 7 8 6.6497 $w=2.04211e-08 $l=1.9e-08 $layer=Gate_1 $thickness=5.6e-08
+ $X=0.189 $Y=0.135 $X2=0.189 $Y2=0.154
r8 6 7 6.6497 $w=2.04211e-08 $l=1.9e-08 $layer=Gate_1 $thickness=5.6e-08
+ $X=0.189 $Y=0.116 $X2=0.189 $Y2=0.135
r9 5 6 16.4967 $w=2.1e-08 $l=4.85e-08 $layer=Gate_1 $thickness=5.6e-08 $X=0.189
+ $Y=0.0675 $X2=0.189 $Y2=0.116
r10 5 3 14.6259 $w=2.1e-08 $l=4.3e-08 $layer=Gate_1 $thickness=5.6e-08 $X=0.189
+ $Y=0.0675 $X2=0.189 $Y2=0.0245
.ends

* End of included file AOI22xp5_ASAP7_75t_R.pex.sp.pex

*
.subckt AOI22xp5_ASAP7_75t_CUSTOM_4_25_0_7 VSS VDD A1 A2 B2 B1 Y
*
* VSS VSS
* VDD VDD
* A1 A1
* A2 A2
* B2 B2
* B1 B1
* Y Y
*
*

M0 noxref_9 N_M0_g VSS VSS nmos_rvt L=2e-08 W=8.1e-08 nfin=3 $X=0.071 $Y=0.027
M1 N_M1_d N_M1_g noxref_9 VSS nmos_rvt L=2e-08 W=8.1e-08 nfin=3 $X=0.125
+ $Y=0.027
M2 noxref_10 N_M2_g N_M2_s VSS nmos_rvt L=2e-08 W=8.1e-08 nfin=3 $X=0.179
+ $Y=0.027
M3 VSS N_M3_g noxref_10 VSS nmos_rvt L=2e-08 W=8.1e-08 nfin=3 $X=0.233 $Y=0.027
M4 VDD N_M4_g noxref_7 VDD pmos_rvt L=2e-08 W=8.1e-08 nfin=3 $X=0.071 $Y=0.162
M5 noxref_7 N_M5_g VDD VDD pmos_rvt L=2e-08 W=8.1e-08 nfin=3 $X=0.125 $Y=0.162
M6 N_M6_d N_M6_g noxref_7 VDD pmos_rvt L=2e-08 W=8.1e-08 nfin=3 $X=0.179
+ $Y=0.162
M7 noxref_7 N_M7_g N_M7_s VDD pmos_rvt L=2e-08 W=8.1e-08 nfin=3 $X=0.233
+ $Y=0.162

* .include "AOI22xp5_ASAP7_75t_R.pex.sp.pxi"

* Start of included file AOI22xp5_ASAP7_75t_R.pex.sp.pxi
x_PM_AOI22xp5_ASAP7_75t_R%A1 vss A1 N_M0_g N_M4_g N_A1_3
+ PM_AOI22xp5_ASAP7_75t_R%A1
x_PM_AOI22xp5_ASAP7_75t_R%B1 vss B1 N_M3_g N_M7_g N_B1_4 N_B1_3
+ PM_AOI22xp5_ASAP7_75t_R%B1
cc_1 N_B1_4 N_B2_4 0.00328482f $X=0.243 $Y=0.0752
cc_2 N_B1_3 N_B2_3 0.00693651f $X=0.243 $Y=0.0245
x_PM_AOI22xp5_ASAP7_75t_R%Y vss Y N_M1_d N_M2_s N_M6_d N_M7_s N_Y_1 N_Y_7
+ N_Y_11 N_Y_8 N_Y_12 N_Y_13 PM_AOI22xp5_ASAP7_75t_R%Y
cc_3 N_Y_1 N_A2_5 0.00145189f $X=0.162 $Y=0.0675
cc_4 N_Y_1 N_A2_3 0.00145452f $X=0.162 $Y=0.0675
cc_5 N_Y_7 N_A2_3 0.0362499f $X=0.1475 $Y=0.0675
cc_6 N_Y_11 N_B2_4 0.00111285f $X=0.1505 $Y=0.036
cc_7 N_Y_1 N_B2_3 0.00133986f $X=0.162 $Y=0.0675
cc_8 N_Y_7 N_B2_1 0.00142269f $X=0.1475 $Y=0.0675
cc_9 N_Y_1 N_B2_4 0.0024395f $X=0.162 $Y=0.0675
cc_10 N_Y_8 N_B2_3 0.0144107f $X=0.2015 $Y=0.2025
cc_11 N_Y_7 N_B2_3 0.0551176f $X=0.1475 $Y=0.0675
cc_12 N_Y_12 N_B1_4 0.000981214f $X=0.286 $Y=0.198
cc_13 N_Y_11 N_B1_4 0.00113979f $X=0.1505 $Y=0.036
cc_14 N_Y_13 N_B1_4 0.00593614f $X=0.297 $Y=0.0575
cc_15 N_Y_8 N_B1_3 0.0367434f $X=0.2015 $Y=0.2025
x_PM_AOI22xp5_ASAP7_75t_R%A2 vss A2 N_M1_g N_M5_g N_A2_1 N_A2_5 N_A2_3
+ PM_AOI22xp5_ASAP7_75t_R%A2
cc_16 N_A2_1 N_A1_3 0.00126557f $X=0.135 $Y=0.135
cc_17 N_A2_5 N_A1_3 0.00271282f $X=0.135 $Y=0.135
cc_18 N_A2_3 N_A1_3 0.00705284f $X=0.135 $Y=0.0245
x_PM_AOI22xp5_ASAP7_75t_R%B2 vss B2 N_M2_g N_M6_g N_B2_3 N_B2_4 N_B2_1
+ PM_AOI22xp5_ASAP7_75t_R%B2
cc_19 N_B2_3 N_A2_3 0.00317957f $X=0.189 $Y=0.0245
cc_20 N_B2_4 N_A2_5 0.00566446f $X=0.189 $Y=0.0922

* End of included file AOI22xp5_ASAP7_75t_R.pex.sp.pxi
.ends

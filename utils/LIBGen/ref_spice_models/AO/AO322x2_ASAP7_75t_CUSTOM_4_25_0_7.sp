.subckt PM_AO322x2_ASAP7_75t_R%A3 vss 11 5 9 4 3
c1 1 vss 0.00620288f $X=0.189 $Y=0.135
c2 3 vss 0.14303f $X=0.189 $Y=0.0245
c3 4 vss 0.00729446f $X=0.189 $Y=0.0855
r1 12 13 6.17953 $w=1.3e-08 $l=2.65e-08 $layer=M1 $thickness=3.6e-08 $X=0.189
+ $Y=0.1085 $X2=0.189 $Y2=0.135
r2 11 12 4.19742 $w=1.3e-08 $l=1.8e-08 $layer=M1 $thickness=3.6e-08 $X=0.1885
+ $Y=0.0905 $X2=0.189 $Y2=0.1085
r3 11 4 1.16595 $w=1.3e-08 $l=5e-09 $layer=M1 $thickness=3.6e-08 $X=0.1885
+ $Y=0.0905 $X2=0.189 $Y2=0.0855
r4 1 7 10.4265 $w=1.765e-08 $layer=LIG $thickness=5.2e-08 $X=0.189 $Y=0.135
+ $X2=0.189 $Y2=0.135
r5 1 13 19.3796 $a=3.24e-16 $layer=V0LIG $X=0.189 $Y=0.135 $X2=0.189 $Y2=0.135
r6 9 8 16.4967 $w=2.1e-08 $l=4.85e-08 $layer=Gate_1 $thickness=5.6e-08 $X=0.189
+ $Y=0.2025 $X2=0.189 $Y2=0.154
r7 7 8 6.6497 $w=2.04211e-08 $l=1.9e-08 $layer=Gate_1 $thickness=5.6e-08
+ $X=0.189 $Y=0.135 $X2=0.189 $Y2=0.154
r8 6 7 6.6497 $w=2.04211e-08 $l=1.9e-08 $layer=Gate_1 $thickness=5.6e-08
+ $X=0.189 $Y=0.116 $X2=0.189 $Y2=0.135
r9 5 6 16.4967 $w=2.1e-08 $l=4.85e-08 $layer=Gate_1 $thickness=5.6e-08 $X=0.189
+ $Y=0.0675 $X2=0.189 $Y2=0.116
r10 5 3 14.6259 $w=2.1e-08 $l=4.3e-08 $layer=Gate_1 $thickness=5.6e-08 $X=0.189
+ $Y=0.0675 $X2=0.189 $Y2=0.0245
.ends

.subckt PM_AO322x2_ASAP7_75t_R%B1 vss 15 7 13 6 3 4
c1 1 vss 0.00521635f $X=0.297 $Y=0.135
c2 3 vss 0.106646f $X=0.297 $Y=0.0245
c3 4 vss 0.00180418f $X=0.297 $Y=0.072
c4 5 vss 0.00625482f $X=0.297 $Y=0.162
c5 6 vss 0.0027446f $X=0.297 $Y=0.0835
r1 5 18 1.96775 $w=1.63333e-08 $l=1.35e-08 $layer=M1 $thickness=3.6e-08
+ $X=0.297 $Y=0.162 $X2=0.297 $Y2=0.1485
r2 4 6 1.50137 $w=1.6913e-08 $l=1.15e-08 $layer=M1 $thickness=3.6e-08 $X=0.297
+ $Y=0.072 $X2=0.297 $Y2=0.0835
r3 17 18 3.14806 $w=1.3e-08 $l=1.35e-08 $layer=M1 $thickness=3.6e-08 $X=0.297
+ $Y=0.135 $X2=0.297 $Y2=0.1485
r4 16 17 6.64591 $w=1.3e-08 $l=2.85e-08 $layer=M1 $thickness=3.6e-08 $X=0.297
+ $Y=0.1065 $X2=0.297 $Y2=0.135
r5 15 16 4.6638 $w=1.3e-08 $l=2e-08 $layer=M1 $thickness=3.6e-08 $X=0.2995
+ $Y=0.0865 $X2=0.297 $Y2=0.1065
r6 15 6 0.699569 $w=1.3e-08 $l=3e-09 $layer=M1 $thickness=3.6e-08 $X=0.2995
+ $Y=0.0865 $X2=0.297 $Y2=0.0835
r7 1 10 10.4265 $w=1.765e-08 $layer=LIG $thickness=5.2e-08 $X=0.297 $Y=0.135
+ $X2=0.297 $Y2=0.135
r8 1 17 19.3796 $a=3.24e-16 $layer=V0LIG $X=0.297 $Y=0.135 $X2=0.297 $Y2=0.135
r9 13 12 14.6259 $w=2.1e-08 $l=4.3e-08 $layer=Gate_1 $thickness=5.6e-08
+ $X=0.297 $Y=0.2025 $X2=0.297 $Y2=0.1595
r10 11 12 2.7211 $w=2.1e-08 $l=8e-09 $layer=Gate_1 $thickness=5.6e-08 $X=0.297
+ $Y=0.1515 $X2=0.297 $Y2=0.1595
r11 10 11 5.79936 $w=2.03333e-08 $l=1.65e-08 $layer=Gate_1 $thickness=5.6e-08
+ $X=0.297 $Y=0.135 $X2=0.297 $Y2=0.1515
r12 9 10 5.79936 $w=2.03333e-08 $l=1.65e-08 $layer=Gate_1 $thickness=5.6e-08
+ $X=0.297 $Y=0.1185 $X2=0.297 $Y2=0.135
r13 8 9 7.31297 $w=2.1e-08 $l=2.15e-08 $layer=Gate_1 $thickness=5.6e-08
+ $X=0.297 $Y=0.097 $X2=0.297 $Y2=0.1185
r14 7 8 14.6259 $w=2.1e-08 $l=4.3e-08 $layer=Gate_1 $thickness=5.6e-08 $X=0.297
+ $Y=0.054 $X2=0.297 $Y2=0.097
r15 7 3 10.0341 $w=2.1e-08 $l=2.95e-08 $layer=Gate_1 $thickness=5.6e-08
+ $X=0.297 $Y=0.054 $X2=0.297 $Y2=0.0245
.ends

.subckt PM_AO322x2_ASAP7_75t_R%C1 vss 13 5 11 4 3 1
c1 1 vss 0.00313027f $X=0.459 $Y=0.135
c2 3 vss 0.0705147f $X=0.459 $Y=0.0245
c3 4 vss 0.00505897f $X=0.459 $Y=0.0815
r1 14 15 7.11229 $w=1.3e-08 $l=3.05e-08 $layer=M1 $thickness=3.6e-08 $X=0.459
+ $Y=0.1045 $X2=0.459 $Y2=0.135
r2 13 14 5.13018 $w=1.3e-08 $l=2.2e-08 $layer=M1 $thickness=3.6e-08 $X=0.4585
+ $Y=0.0825 $X2=0.459 $Y2=0.1045
r3 13 4 0.23319 $w=1.3e-08 $l=1e-09 $layer=M1 $thickness=3.6e-08 $X=0.4585
+ $Y=0.0825 $X2=0.459 $Y2=0.0815
r4 1 8 10.4265 $w=1.765e-08 $layer=LIG $thickness=5.2e-08 $X=0.459 $Y=0.135
+ $X2=0.459 $Y2=0.135
r5 1 15 19.3796 $a=3.24e-16 $layer=V0LIG $X=0.459 $Y=0.135 $X2=0.459 $Y2=0.135
r6 11 10 14.6259 $w=2.1e-08 $l=4.3e-08 $layer=Gate_1 $thickness=5.6e-08
+ $X=0.459 $Y=0.2025 $X2=0.459 $Y2=0.1595
r7 9 10 2.7211 $w=2.1e-08 $l=8e-09 $layer=Gate_1 $thickness=5.6e-08 $X=0.459
+ $Y=0.1515 $X2=0.459 $Y2=0.1595
r8 8 9 5.79936 $w=2.03333e-08 $l=1.65e-08 $layer=Gate_1 $thickness=5.6e-08
+ $X=0.459 $Y=0.135 $X2=0.459 $Y2=0.1515
r9 7 8 5.79936 $w=2.03333e-08 $l=1.65e-08 $layer=Gate_1 $thickness=5.6e-08
+ $X=0.459 $Y=0.1185 $X2=0.459 $Y2=0.135
r10 6 7 7.31297 $w=2.1e-08 $l=2.15e-08 $layer=Gate_1 $thickness=5.6e-08
+ $X=0.459 $Y=0.097 $X2=0.459 $Y2=0.1185
r11 5 6 14.6259 $w=2.1e-08 $l=4.3e-08 $layer=Gate_1 $thickness=5.6e-08 $X=0.459
+ $Y=0.054 $X2=0.459 $Y2=0.097
r12 5 3 10.0341 $w=2.1e-08 $l=2.95e-08 $layer=Gate_1 $thickness=5.6e-08
+ $X=0.459 $Y=0.054 $X2=0.459 $Y2=0.0245
.ends

.subckt PM_AO322x2_ASAP7_75t_R%C2 vss 16 6 12 5 3 1
c1 1 vss 0.00342672f $X=0.513 $Y=0.135
c2 3 vss 0.0964401f $X=0.513 $Y=0.0245
c3 4 vss 0.00520263f $X=0.513 $Y=0.072
c4 5 vss 0.00363599f $X=0.513 $Y=0.1035
r1 4 5 6.16517 $w=1.44286e-08 $l=3.15e-08 $layer=M1 $thickness=3.6e-08 $X=0.513
+ $Y=0.072 $X2=0.513 $Y2=0.1035
r2 16 15 0.932759 $w=1.3e-08 $l=4e-09 $layer=M1 $thickness=3.6e-08 $X=0.5145
+ $Y=0.1515 $X2=0.513 $Y2=0.1475
r3 14 15 2.91487 $w=1.3e-08 $l=1.25e-08 $layer=M1 $thickness=3.6e-08 $X=0.513
+ $Y=0.135 $X2=0.513 $Y2=0.1475
r4 5 14 7.34548 $w=1.3e-08 $l=3.15e-08 $layer=M1 $thickness=3.6e-08 $X=0.513
+ $Y=0.1035 $X2=0.513 $Y2=0.135
r5 1 9 10.4265 $w=1.765e-08 $layer=LIG $thickness=5.2e-08 $X=0.513 $Y=0.135
+ $X2=0.513 $Y2=0.135
r6 1 14 19.3796 $a=3.24e-16 $layer=V0LIG $X=0.513 $Y=0.135 $X2=0.513 $Y2=0.135
r7 12 11 14.6259 $w=2.1e-08 $l=4.3e-08 $layer=Gate_1 $thickness=5.6e-08
+ $X=0.513 $Y=0.2025 $X2=0.513 $Y2=0.1595
r8 10 11 2.7211 $w=2.1e-08 $l=8e-09 $layer=Gate_1 $thickness=5.6e-08 $X=0.513
+ $Y=0.1515 $X2=0.513 $Y2=0.1595
r9 9 10 5.79936 $w=2.03333e-08 $l=1.65e-08 $layer=Gate_1 $thickness=5.6e-08
+ $X=0.513 $Y=0.135 $X2=0.513 $Y2=0.1515
r10 8 9 5.79936 $w=2.03333e-08 $l=1.65e-08 $layer=Gate_1 $thickness=5.6e-08
+ $X=0.513 $Y=0.1185 $X2=0.513 $Y2=0.135
r11 7 8 7.31297 $w=2.1e-08 $l=2.15e-08 $layer=Gate_1 $thickness=5.6e-08
+ $X=0.513 $Y=0.097 $X2=0.513 $Y2=0.1185
r12 6 7 14.6259 $w=2.1e-08 $l=4.3e-08 $layer=Gate_1 $thickness=5.6e-08 $X=0.513
+ $Y=0.054 $X2=0.513 $Y2=0.097
r13 6 3 10.0341 $w=2.1e-08 $l=2.95e-08 $layer=Gate_1 $thickness=5.6e-08
+ $X=0.513 $Y=0.054 $X2=0.513 $Y2=0.0245
.ends

.subckt PM_AO322x2_ASAP7_75t_R%A1 vss 21 10 16 3 9 4
c1 1 vss 0.00466215f $X=0.081 $Y=0.135
c2 3 vss 0.1047f $X=0.081 $Y=0.0245
c3 4 vss 0.00273847f $X=0.027 $Y=0.072
c4 5 vss 0.00104837f $X=0.027 $Y=0.135
c5 6 vss 0.00769535f $X=0.027 $Y=0.234
c6 7 vss 0.00270633f $X=0.027 $Y=0.1035
c7 8 vss 0.00687409f $X=0.027 $Y=0.1665
c8 9 vss 0.00241766f $X=0.0635 $Y=0.135
r1 6 25 3.01711 $w=1.55e-08 $l=1.8e-08 $layer=M1 $thickness=3.6e-08 $X=0.027
+ $Y=0.234 $X2=0.027 $Y2=0.216
r2 4 7 6.16517 $w=1.44286e-08 $l=3.15e-08 $layer=M1 $thickness=3.6e-08 $X=0.027
+ $Y=0.072 $X2=0.027 $Y2=0.1035
r3 24 25 4.19742 $w=1.3e-08 $l=1.8e-08 $layer=M1 $thickness=3.6e-08 $X=0.027
+ $Y=0.198 $X2=0.027 $Y2=0.216
r4 8 24 7.34548 $w=1.3e-08 $l=3.15e-08 $layer=M1 $thickness=3.6e-08 $X=0.027
+ $Y=0.1665 $X2=0.027 $Y2=0.198
r5 5 20 2.55073 $w=1.58125e-08 $l=1.6e-08 $layer=M1 $thickness=3.6e-08 $X=0.027
+ $Y=0.135 $X2=0.043 $Y2=0.135
r6 5 7 6.16517 $w=1.44286e-08 $l=3.15e-08 $layer=M1 $thickness=3.6e-08 $X=0.027
+ $Y=0.135 $X2=0.027 $Y2=0.1035
r7 5 8 6.16517 $w=1.44286e-08 $l=3.15e-08 $layer=M1 $thickness=3.6e-08 $X=0.027
+ $Y=0.135 $X2=0.027 $Y2=0.1665
r8 21 22 0.582974 $w=1.3e-08 $l=2.5e-09 $layer=M1 $thickness=3.6e-08 $X=0.0505
+ $Y=0.1385 $X2=0.053 $Y2=0.135
r9 21 20 1.74892 $w=1.3e-08 $l=7.5e-09 $layer=M1 $thickness=3.6e-08 $X=0.0505
+ $Y=0.1385 $X2=0.043 $Y2=0.135
r10 9 18 4.08082 $w=1.3e-08 $l=1.75e-08 $layer=M1 $thickness=3.6e-08 $X=0.0635
+ $Y=0.135 $X2=0.081 $Y2=0.135
r11 9 22 2.44849 $w=1.3e-08 $l=1.05e-08 $layer=M1 $thickness=3.6e-08 $X=0.0635
+ $Y=0.135 $X2=0.053 $Y2=0.135
r12 1 13 10.4265 $w=1.765e-08 $layer=LIG $thickness=5.2e-08 $X=0.081 $Y=0.135
+ $X2=0.081 $Y2=0.135
r13 1 18 19.3796 $a=3.24e-16 $layer=V0LIG $X=0.081 $Y=0.135 $X2=0.081 $Y2=0.135
r14 16 15 14.6259 $w=2.1e-08 $l=4.3e-08 $layer=Gate_1 $thickness=5.6e-08
+ $X=0.081 $Y=0.2025 $X2=0.081 $Y2=0.1595
r15 14 15 2.7211 $w=2.1e-08 $l=8e-09 $layer=Gate_1 $thickness=5.6e-08 $X=0.081
+ $Y=0.1515 $X2=0.081 $Y2=0.1595
r16 13 14 5.79936 $w=2.03333e-08 $l=1.65e-08 $layer=Gate_1 $thickness=5.6e-08
+ $X=0.081 $Y=0.135 $X2=0.081 $Y2=0.1515
r17 12 13 5.79936 $w=2.03333e-08 $l=1.65e-08 $layer=Gate_1 $thickness=5.6e-08
+ $X=0.081 $Y=0.1185 $X2=0.081 $Y2=0.135
r18 11 12 2.7211 $w=2.1e-08 $l=8e-09 $layer=Gate_1 $thickness=5.6e-08 $X=0.081
+ $Y=0.1105 $X2=0.081 $Y2=0.1185
r19 10 11 14.6259 $w=2.1e-08 $l=4.3e-08 $layer=Gate_1 $thickness=5.6e-08
+ $X=0.081 $Y=0.0675 $X2=0.081 $Y2=0.1105
r20 10 3 14.6259 $w=2.1e-08 $l=4.3e-08 $layer=Gate_1 $thickness=5.6e-08
+ $X=0.081 $Y=0.0675 $X2=0.081 $Y2=0.0245
.ends

.subckt PM_AO322x2_ASAP7_75t_R%Y vss 32 23 38 45 47 16 1 2 21 14 13 15
c1 1 vss 0.00994271f $X=0.648 $Y=0.054
c2 2 vss 0.00871388f $X=0.648 $Y=0.2025
c3 3 vss 0.00820871f $X=0.756 $Y=0.0675
c4 4 vss 0.00820871f $X=0.756 $Y=0.2025
c5 13 vss 0.0381028f $X=0.65 $Y=0.0675
c6 14 vss 0.0379543f $X=0.7415 $Y=0.0675
c7 15 vss 0.0379328f $X=0.65 $Y=0.2025
c8 16 vss 0.0379744f $X=0.7415 $Y=0.2025
c9 17 vss 0.00271233f $X=0.783 $Y=0.036
c10 18 vss 0.00270603f $X=0.783 $Y=0.234
c11 19 vss 0.0134824f $X=0.6365 $Y=0.036
c12 20 vss 0.0128791f $X=0.745 $Y=0.234
c13 21 vss 0.00454827f $X=0.783 $Y=0.054
r1 47 46 0.0308642 $w=8.1e-08 $l=2.5e-09 $layer=P_src_drn $thickness=1e-09
+ $X=0.6653 $Y=0.2025 $X2=0.6625 $Y2=0.2025
r2 15 46 0.154321 $w=8.1e-08 $l=1.25e-08 $layer=P_src_drn $thickness=1e-09
+ $X=0.65 $Y=0.2025 $X2=0.6625 $Y2=0.2025
r3 16 4 0.154321 $w=8.1e-08 $l=1.25e-08 $layer=P_src_drn $thickness=1e-09
+ $X=0.7415 $Y=0.2025 $X2=0.756 $Y2=0.2025
r4 45 16 0.0308642 $w=8.1e-08 $l=2.5e-09 $layer=P_src_drn $thickness=1e-09
+ $X=0.7386 $Y=0.2025 $X2=0.7415 $Y2=0.2025
r5 2 42 19.3796 $a=3.24e-16 $layer=V0LISD $X=0.648 $Y=0.2025 $X2=0.648 $Y2=0.234
r6 4 39 19.3796 $a=3.24e-16 $layer=V0LISD $X=0.756 $Y=0.2025 $X2=0.756 $Y2=0.234
r7 42 43 12.1259 $w=1.3e-08 $l=5.2e-08 $layer=M1 $thickness=3.6e-08 $X=0.648
+ $Y=0.234 $X2=0.7 $Y2=0.234
r8 39 40 3.14806 $w=1.3e-08 $l=1.35e-08 $layer=M1 $thickness=3.6e-08 $X=0.756
+ $Y=0.234 $X2=0.7695 $Y2=0.234
r9 20 39 2.56509 $w=1.3e-08 $l=1.1e-08 $layer=M1 $thickness=3.6e-08 $X=0.745
+ $Y=0.234 $X2=0.756 $Y2=0.234
r10 20 43 10.4935 $w=1.3e-08 $l=4.5e-08 $layer=M1 $thickness=3.6e-08 $X=0.745
+ $Y=0.234 $X2=0.7 $Y2=0.234
r11 18 36 2.5483 $w=1.79e-08 $l=1.8e-08 $layer=M1 $thickness=3.6e-08 $X=0.783
+ $Y=0.234 $X2=0.783 $Y2=0.216
r12 18 40 1.49895 $w=1.63333e-08 $l=1.35e-08 $layer=M1 $thickness=3.6e-08
+ $X=0.783 $Y=0.234 $X2=0.7695 $Y2=0.234
r13 14 3 0.154321 $w=8.1e-08 $l=1.25e-08 $layer=N_src_drn $thickness=1e-09
+ $X=0.7415 $Y=0.0675 $X2=0.756 $Y2=0.0675
r14 38 14 0.0308642 $w=8.1e-08 $l=2.5e-09 $layer=N_src_drn $thickness=1e-09
+ $X=0.7386 $Y=0.0675 $X2=0.7415 $Y2=0.0675
r15 35 36 9.44419 $w=1.3e-08 $l=4.05e-08 $layer=M1 $thickness=3.6e-08 $X=0.783
+ $Y=0.1755 $X2=0.783 $Y2=0.216
r16 34 35 9.44419 $w=1.3e-08 $l=4.05e-08 $layer=M1 $thickness=3.6e-08 $X=0.783
+ $Y=0.135 $X2=0.783 $Y2=0.1755
r17 33 34 3.38125 $w=1.3e-08 $l=1.45e-08 $layer=M1 $thickness=3.6e-08 $X=0.783
+ $Y=0.1205 $X2=0.783 $Y2=0.135
r18 32 33 1.39914 $w=1.3e-08 $l=6e-09 $layer=M1 $thickness=3.6e-08 $X=0.7835
+ $Y=0.1145 $X2=0.783 $Y2=0.1205
r19 32 31 3.96423 $w=1.3e-08 $l=1.7e-08 $layer=M1 $thickness=3.6e-08 $X=0.7835
+ $Y=0.1145 $X2=0.783 $Y2=0.0975
r20 30 31 5.94634 $w=1.3e-08 $l=2.55e-08 $layer=M1 $thickness=3.6e-08 $X=0.783
+ $Y=0.072 $X2=0.783 $Y2=0.0975
r21 21 30 4.19742 $w=1.3e-08 $l=1.8e-08 $layer=M1 $thickness=3.6e-08 $X=0.783
+ $Y=0.054 $X2=0.783 $Y2=0.072
r22 3 28 19.3796 $a=3.24e-16 $layer=V0LISD $X=0.756 $Y=0.0675 $X2=0.756
+ $Y2=0.036
r23 17 29 1.49895 $w=1.63333e-08 $l=1.35e-08 $layer=M1 $thickness=3.6e-08
+ $X=0.783 $Y=0.036 $X2=0.7695 $Y2=0.036
r24 17 21 2.5483 $w=1.79e-08 $l=1.8e-08 $layer=M1 $thickness=3.6e-08 $X=0.783
+ $Y=0.036 $X2=0.783 $Y2=0.054
r25 28 29 3.14806 $w=1.3e-08 $l=1.35e-08 $layer=M1 $thickness=3.6e-08 $X=0.756
+ $Y=0.036 $X2=0.7695 $Y2=0.036
r26 27 28 2.56509 $w=1.3e-08 $l=1.1e-08 $layer=M1 $thickness=3.6e-08 $X=0.745
+ $Y=0.036 $X2=0.756 $Y2=0.036
r27 26 27 10.4935 $w=1.3e-08 $l=4.5e-08 $layer=M1 $thickness=3.6e-08 $X=0.7
+ $Y=0.036 $X2=0.745 $Y2=0.036
r28 25 26 12.1259 $w=1.3e-08 $l=5.2e-08 $layer=M1 $thickness=3.6e-08 $X=0.648
+ $Y=0.036 $X2=0.7 $Y2=0.036
r29 19 25 2.68168 $w=1.3e-08 $l=1.15e-08 $layer=M1 $thickness=3.6e-08 $X=0.6365
+ $Y=0.036 $X2=0.648 $Y2=0.036
r30 1 25 19.3796 $a=3.24e-16 $layer=V0LISD $X=0.648 $Y=0.054 $X2=0.648 $Y2=0.036
r31 23 22 0.0308642 $w=8.1e-08 $l=2.5e-09 $layer=N_src_drn $thickness=1e-09
+ $X=0.6653 $Y=0.0675 $X2=0.6625 $Y2=0.0675
r32 13 22 0.154321 $w=8.1e-08 $l=1.25e-08 $layer=N_src_drn $thickness=1e-09
+ $X=0.65 $Y=0.0675 $X2=0.6625 $Y2=0.0675
r33 2 15 1e-05 $l=2e-09 $X=0.648 $Y=0.2025 $X2=0.65 $Y2=0.2025
r34 1 13 1e-05 $l=1.36473e-08 $X=0.648 $Y=0.054 $X2=0.65 $Y2=0.0675
.ends

.subckt PM_AO322x2_ASAP7_75t_R%10 vss 35 41 58 62 77 85 105 107 109 4 30 21 5
+ 31 22 6 7 23 26 32 24 8 34 33 28 25 19 29 1 20
c1 1 vss 0.0103219f $X=0.6655 $Y=0.135
c2 4 vss 0.00720366f $X=0.054 $Y=0.0675
c3 5 vss 0.00606475f $X=0.324 $Y=0.054
c4 6 vss 0.00619013f $X=0.432 $Y=0.054
c5 7 vss 0.00959869f $X=0.432 $Y=0.2025
c6 8 vss 0.00778995f $X=0.54 $Y=0.2025
c7 19 vss 0.0820888f $X=0.675 $Y=0.0245
c8 20 vss 0.0821113f $X=0.729 $Y=0.135
c9 21 vss 0.03944f $X=0.056 $Y=0.0675
c10 22 vss 0.0291598f $X=0.3095 $Y=0.054
c11 23 vss 0.0287995f $X=0.434 $Y=0.054
c12 24 vss 0.0397072f $X=0.434 $Y=0.2025
c13 25 vss 0.0397928f $X=0.5255 $Y=0.2025
c14 26 vss 0.00558146f $X=0.405 $Y=0.036
c15 27 vss 0.00314318f $X=0.405 $Y=0.198
c16 28 vss 0.000811627f $X=0.567 $Y=0.135
c17 29 vss 0.00146889f $X=0.567 $Y=0.198
c18 30 vss 0.0332462f $X=0.367 $Y=0.036
c19 31 vss 0.00463925f $X=0.405 $Y=0.18
c20 32 vss 0.0103794f $X=0.545 $Y=0.198
c21 33 vss 0.00110908f $X=0.567 $Y=0.154
c22 34 vss 0.00482583f $X=0.605 $Y=0.135
r1 109 108 0.0308642 $w=8.1e-08 $l=2.5e-09 $layer=N_src_drn $thickness=1e-09
+ $X=0.0713 $Y=0.0675 $X2=0.0685 $Y2=0.0675
r2 21 108 0.154321 $w=8.1e-08 $l=1.25e-08 $layer=N_src_drn $thickness=1e-09
+ $X=0.056 $Y=0.0675 $X2=0.0685 $Y2=0.0675
r3 22 5 0.231482 $w=5.4e-08 $l=1.25e-08 $layer=N_src_drn $thickness=1e-09
+ $X=0.3095 $Y=0.054 $X2=0.324 $Y2=0.054
r4 107 22 0.0462963 $w=5.4e-08 $l=2.5e-09 $layer=N_src_drn $thickness=1e-09
+ $X=0.3066 $Y=0.054 $X2=0.3095 $Y2=0.054
r5 105 104 0.0462963 $w=5.4e-08 $l=2.5e-09 $layer=N_src_drn $thickness=1e-09
+ $X=0.4493 $Y=0.054 $X2=0.4465 $Y2=0.054
r6 23 104 0.231482 $w=5.4e-08 $l=1.25e-08 $layer=N_src_drn $thickness=1e-09
+ $X=0.434 $Y=0.054 $X2=0.4465 $Y2=0.054
r7 4 103 19.3796 $a=3.24e-16 $layer=V0LISD $X=0.054 $Y=0.0675 $X2=0.05 $Y2=0.036
r8 5 92 19.3796 $a=3.24e-16 $layer=V0LISD $X=0.324 $Y=0.054 $X2=0.32 $Y2=0.036
r9 6 87 19.3796 $a=3.24e-16 $layer=V0LISD $X=0.432 $Y=0.054 $X2=0.432 $Y2=0.036
r10 100 101 4.6638 $w=1.3e-08 $l=2e-08 $layer=M1 $thickness=3.6e-08 $X=0.059
+ $Y=0.036 $X2=0.079 $Y2=0.036
r11 100 103 2.09871 $w=1.3e-08 $l=9e-09 $layer=M1 $thickness=3.6e-08 $X=0.059
+ $Y=0.036 $X2=0.05 $Y2=0.036
r12 99 101 5.13017 $w=1.3e-08 $l=2.2e-08 $layer=M1 $thickness=3.6e-08 $X=0.101
+ $Y=0.036 $X2=0.079 $Y2=0.036
r13 98 99 5.71315 $w=1.3e-08 $l=2.45e-08 $layer=M1 $thickness=3.6e-08 $X=0.1255
+ $Y=0.036 $X2=0.101 $Y2=0.036
r14 97 98 8.51143 $w=1.3e-08 $l=3.65e-08 $layer=M1 $thickness=3.6e-08 $X=0.162
+ $Y=0.036 $X2=0.1255 $Y2=0.036
r15 96 97 6.29612 $w=1.3e-08 $l=2.7e-08 $layer=M1 $thickness=3.6e-08 $X=0.189
+ $Y=0.036 $X2=0.162 $Y2=0.036
r16 95 96 6.29612 $w=1.3e-08 $l=2.7e-08 $layer=M1 $thickness=3.6e-08 $X=0.216
+ $Y=0.036 $X2=0.189 $Y2=0.036
r17 94 95 6.29612 $w=1.3e-08 $l=2.7e-08 $layer=M1 $thickness=3.6e-08 $X=0.243
+ $Y=0.036 $X2=0.216 $Y2=0.036
r18 93 94 6.29612 $w=1.3e-08 $l=2.7e-08 $layer=M1 $thickness=3.6e-08 $X=0.27
+ $Y=0.036 $X2=0.243 $Y2=0.036
r19 91 92 4.31401 $w=1.3e-08 $l=1.85e-08 $layer=M1 $thickness=3.6e-08 $X=0.3015
+ $Y=0.036 $X2=0.32 $Y2=0.036
r20 91 93 7.34548 $w=1.3e-08 $l=3.15e-08 $layer=M1 $thickness=3.6e-08 $X=0.3015
+ $Y=0.036 $X2=0.27 $Y2=0.036
r21 89 90 1.51573 $w=1.3e-08 $l=6.5e-09 $layer=M1 $thickness=3.6e-08 $X=0.329
+ $Y=0.036 $X2=0.3355 $Y2=0.036
r22 89 92 2.09871 $w=1.3e-08 $l=9e-09 $layer=M1 $thickness=3.6e-08 $X=0.329
+ $Y=0.036 $X2=0.32 $Y2=0.036
r23 30 90 7.34548 $w=1.3e-08 $l=3.15e-08 $layer=M1 $thickness=3.6e-08 $X=0.367
+ $Y=0.036 $X2=0.3355 $Y2=0.036
r24 86 87 3.14806 $w=1.3e-08 $l=1.35e-08 $layer=M1 $thickness=3.6e-08 $X=0.4185
+ $Y=0.036 $X2=0.432 $Y2=0.036
r25 26 83 3.01711 $w=1.55e-08 $l=1.8e-08 $layer=M1 $thickness=3.6e-08 $X=0.405
+ $Y=0.036 $X2=0.405 $Y2=0.054
r26 26 86 1.96775 $w=1.63333e-08 $l=1.35e-08 $layer=M1 $thickness=3.6e-08
+ $X=0.405 $Y=0.036 $X2=0.4185 $Y2=0.036
r27 26 30 7.6809 $w=1.41842e-08 $l=3.8e-08 $layer=M1 $thickness=3.6e-08
+ $X=0.405 $Y=0.036 $X2=0.367 $Y2=0.036
r28 85 84 0.0308642 $w=8.1e-08 $l=2.5e-09 $layer=P_src_drn $thickness=1e-09
+ $X=0.4493 $Y=0.2025 $X2=0.4465 $Y2=0.2025
r29 24 84 0.154321 $w=8.1e-08 $l=1.25e-08 $layer=P_src_drn $thickness=1e-09
+ $X=0.434 $Y=0.2025 $X2=0.4465 $Y2=0.2025
r30 82 83 2.91487 $w=1.3e-08 $l=1.25e-08 $layer=M1 $thickness=3.6e-08 $X=0.405
+ $Y=0.0665 $X2=0.405 $Y2=0.054
r31 81 82 2.09871 $w=1.3e-08 $l=9e-09 $layer=M1 $thickness=3.6e-08 $X=0.405
+ $Y=0.0755 $X2=0.405 $Y2=0.0665
r32 80 81 9.67738 $w=1.3e-08 $l=4.15e-08 $layer=M1 $thickness=3.6e-08 $X=0.405
+ $Y=0.117 $X2=0.405 $Y2=0.0755
r33 79 80 9.67738 $w=1.3e-08 $l=4.15e-08 $layer=M1 $thickness=3.6e-08 $X=0.405
+ $Y=0.1585 $X2=0.405 $Y2=0.117
r34 78 79 2.09871 $w=1.3e-08 $l=9e-09 $layer=M1 $thickness=3.6e-08 $X=0.405
+ $Y=0.1675 $X2=0.405 $Y2=0.1585
r35 31 78 2.91487 $w=1.3e-08 $l=1.25e-08 $layer=M1 $thickness=3.6e-08 $X=0.405
+ $Y=0.18 $X2=0.405 $Y2=0.1675
r36 25 8 0.154321 $w=8.1e-08 $l=1.25e-08 $layer=P_src_drn $thickness=1e-09
+ $X=0.5255 $Y=0.2025 $X2=0.54 $Y2=0.2025
r37 77 25 0.0308642 $w=8.1e-08 $l=2.5e-09 $layer=P_src_drn $thickness=1e-09
+ $X=0.5226 $Y=0.2025 $X2=0.5255 $Y2=0.2025
r38 7 74 19.3796 $a=3.24e-16 $layer=V0LISD $X=0.432 $Y=0.2025 $X2=0.433
+ $Y2=0.198
r39 27 73 1.61554 $w=1.62143e-08 $l=1.4e-08 $layer=M1 $thickness=3.6e-08
+ $X=0.405 $Y=0.198 $X2=0.419 $Y2=0.198
r40 27 31 2.5483 $w=1.79e-08 $l=1.8e-08 $layer=M1 $thickness=3.6e-08 $X=0.405
+ $Y=0.198 $X2=0.405 $Y2=0.18
r41 8 67 19.3796 $a=3.24e-16 $layer=V0LISD $X=0.54 $Y=0.2025 $X2=0.536 $Y2=0.198
r42 74 75 2.56509 $w=1.3e-08 $l=1.1e-08 $layer=M1 $thickness=3.6e-08 $X=0.433
+ $Y=0.198 $X2=0.444 $Y2=0.198
r43 73 74 3.26466 $w=1.3e-08 $l=1.4e-08 $layer=M1 $thickness=3.6e-08 $X=0.419
+ $Y=0.198 $X2=0.433 $Y2=0.198
r44 72 75 0.932759 $w=1.3e-08 $l=4e-09 $layer=M1 $thickness=3.6e-08 $X=0.448
+ $Y=0.198 $X2=0.444 $Y2=0.198
r45 71 72 2.56509 $w=1.3e-08 $l=1.1e-08 $layer=M1 $thickness=3.6e-08 $X=0.459
+ $Y=0.198 $X2=0.448 $Y2=0.198
r46 70 71 5.82974 $w=1.3e-08 $l=2.5e-08 $layer=M1 $thickness=3.6e-08 $X=0.484
+ $Y=0.198 $X2=0.459 $Y2=0.198
r47 69 70 4.19742 $w=1.3e-08 $l=1.8e-08 $layer=M1 $thickness=3.6e-08 $X=0.502
+ $Y=0.198 $X2=0.484 $Y2=0.198
r48 68 69 2.56509 $w=1.3e-08 $l=1.1e-08 $layer=M1 $thickness=3.6e-08 $X=0.513
+ $Y=0.198 $X2=0.502 $Y2=0.198
r49 66 67 2.2153 $w=1.3e-08 $l=9.5e-09 $layer=M1 $thickness=3.6e-08 $X=0.5265
+ $Y=0.198 $X2=0.536 $Y2=0.198
r50 66 68 3.14806 $w=1.3e-08 $l=1.35e-08 $layer=M1 $thickness=3.6e-08 $X=0.5265
+ $Y=0.198 $X2=0.513 $Y2=0.198
r51 32 65 1.98211 $w=1.3e-08 $l=8.5e-09 $layer=M1 $thickness=3.6e-08 $X=0.545
+ $Y=0.198 $X2=0.5535 $Y2=0.198
r52 32 67 2.09871 $w=1.3e-08 $l=9e-09 $layer=M1 $thickness=3.6e-08 $X=0.545
+ $Y=0.198 $X2=0.536 $Y2=0.198
r53 29 64 3.36447 $w=1.71023e-08 $l=2.15e-08 $layer=M1 $thickness=3.6e-08
+ $X=0.567 $Y=0.198 $X2=0.567 $Y2=0.1765
r54 29 65 1.49895 $w=1.63333e-08 $l=1.35e-08 $layer=M1 $thickness=3.6e-08
+ $X=0.567 $Y=0.198 $X2=0.5535 $Y2=0.198
r55 33 64 5.24677 $w=1.3e-08 $l=2.25e-08 $layer=M1 $thickness=3.6e-08 $X=0.567
+ $Y=0.154 $X2=0.567 $Y2=0.1765
r56 28 34 7.2121 $w=1.41842e-08 $l=3.8e-08 $layer=M1 $thickness=3.6e-08
+ $X=0.567 $Y=0.135 $X2=0.605 $Y2=0.135
r57 28 33 2.78149 $w=1.76421e-08 $l=1.9e-08 $layer=M1 $thickness=3.6e-08
+ $X=0.567 $Y=0.135 $X2=0.567 $Y2=0.154
r58 62 61 14.6259 $w=2.1e-08 $l=4.3e-08 $layer=Gate_1 $thickness=5.6e-08
+ $X=0.729 $Y=0.2025 $X2=0.729 $Y2=0.1595
r59 60 61 2.7211 $w=2.1e-08 $l=8e-09 $layer=Gate_1 $thickness=5.6e-08 $X=0.729
+ $Y=0.1515 $X2=0.729 $Y2=0.1595
r60 58 59 14.6259 $w=2.1e-08 $l=4.3e-08 $layer=Gate_1 $thickness=5.6e-08
+ $X=0.729 $Y=0.0675 $X2=0.729 $Y2=0.1105
r61 56 59 2.7211 $w=2.1e-08 $l=8e-09 $layer=Gate_1 $thickness=5.6e-08 $X=0.729
+ $Y=0.1185 $X2=0.729 $Y2=0.1105
r62 20 48 6.27904 $w=2.09e-08 $layer=Gate_1 $thickness=5.24e-08 $X=0.729
+ $Y=0.135 $X2=0.729 $Y2=0.135
r63 20 56 5.79936 $w=2.03333e-08 $l=1.65e-08 $layer=Gate_1 $thickness=5.6e-08
+ $X=0.729 $Y=0.135 $X2=0.729 $Y2=0.1185
r64 20 60 5.79936 $w=2.03333e-08 $l=1.65e-08 $layer=Gate_1 $thickness=5.6e-08
+ $X=0.729 $Y=0.135 $X2=0.729 $Y2=0.1515
r65 53 54 6.29612 $w=1.3e-08 $l=2.7e-08 $layer=M1 $thickness=3.6e-08 $X=0.702
+ $Y=0.135 $X2=0.729 $Y2=0.135
r66 52 53 6.29612 $w=1.3e-08 $l=2.7e-08 $layer=M1 $thickness=3.6e-08 $X=0.675
+ $Y=0.135 $X2=0.702 $Y2=0.135
r67 51 52 5.82974 $w=1.3e-08 $l=2.5e-08 $layer=M1 $thickness=3.6e-08 $X=0.65
+ $Y=0.135 $X2=0.675 $Y2=0.135
r68 34 51 10.4935 $w=1.3e-08 $l=4.5e-08 $layer=M1 $thickness=3.6e-08 $X=0.605
+ $Y=0.135 $X2=0.65 $Y2=0.135
r69 48 54 19.3796 $a=3.24e-16 $layer=V0LIG $X=0.729 $Y=0.135 $X2=0.729 $Y2=0.135
r70 47 48 2.48102 $w=2.2e-08 $l=9.5e-09 $layer=LIG $thickness=4.8e-08 $X=0.7195
+ $Y=0.135 $X2=0.729 $Y2=0.135
r71 46 47 10.1729 $w=1.54914e-08 $l=1.75e-08 $layer=LIG $thickness=4.8e-08
+ $X=0.702 $Y=0.135 $X2=0.7195 $Y2=0.135
r72 44 46 10.1729 $w=1.54914e-08 $l=1.75e-08 $layer=LIG $thickness=4.8e-08
+ $X=0.6845 $Y=0.135 $X2=0.702 $Y2=0.135
r73 43 44 2.48102 $w=2.2e-08 $l=9.5e-09 $layer=LIG $thickness=4.8e-08 $X=0.675
+ $Y=0.135 $X2=0.6845 $Y2=0.135
r74 43 52 19.3796 $a=3.24e-16 $layer=V0LIG $X=0.675 $Y=0.135 $X2=0.675 $Y2=0.135
r75 1 43 2.48102 $w=2.2e-08 $l=9.5e-09 $layer=LIG $thickness=4.8e-08 $X=0.6655
+ $Y=0.135 $X2=0.675 $Y2=0.135
r76 41 40 14.6259 $w=2.1e-08 $l=4.3e-08 $layer=Gate_1 $thickness=5.6e-08
+ $X=0.675 $Y=0.2025 $X2=0.675 $Y2=0.1595
r77 39 40 2.7211 $w=2.1e-08 $l=8e-09 $layer=Gate_1 $thickness=5.6e-08 $X=0.675
+ $Y=0.1515 $X2=0.675 $Y2=0.1595
r78 38 39 5.79936 $w=2.03333e-08 $l=1.65e-08 $layer=Gate_1 $thickness=5.6e-08
+ $X=0.675 $Y=0.135 $X2=0.675 $Y2=0.1515
r79 38 44 4.05918 $w=2.0087e-08 $l=9.5e-09 $layer=Gate_1 $thickness=5.56522e-08
+ $X=0.675 $Y=0.135 $X2=0.6845 $Y2=0.135
r80 38 43 6.27904 $w=2.09e-08 $layer=Gate_1 $thickness=5.24e-08 $X=0.675
+ $Y=0.135 $X2=0.675 $Y2=0.135
r81 37 38 5.79936 $w=2.03333e-08 $l=1.65e-08 $layer=Gate_1 $thickness=5.6e-08
+ $X=0.675 $Y=0.1185 $X2=0.675 $Y2=0.135
r82 36 37 2.7211 $w=2.1e-08 $l=8e-09 $layer=Gate_1 $thickness=5.6e-08 $X=0.675
+ $Y=0.1105 $X2=0.675 $Y2=0.1185
r83 35 36 14.6259 $w=2.1e-08 $l=4.3e-08 $layer=Gate_1 $thickness=5.6e-08
+ $X=0.675 $Y=0.0675 $X2=0.675 $Y2=0.1105
r84 35 19 14.6259 $w=2.1e-08 $l=4.3e-08 $layer=Gate_1 $thickness=5.6e-08
+ $X=0.675 $Y=0.0675 $X2=0.675 $Y2=0.0245
r85 4 21 1e-05 $l=2e-09 $X=0.054 $Y=0.0675 $X2=0.056 $Y2=0.0675
r86 6 23 1e-05 $l=2e-09 $X=0.432 $Y=0.054 $X2=0.434 $Y2=0.054
r87 7 24 1e-05 $l=2e-09 $X=0.432 $Y=0.2025 $X2=0.434 $Y2=0.2025
.ends

.subckt PM_AO322x2_ASAP7_75t_R%A2 vss 18 7 11 5 1 6 3 4
c1 1 vss 0.0041384f $X=0.135 $Y=0.135
c2 3 vss 0.118868f $X=0.135 $Y=0.0245
c3 4 vss 0.00116806f $X=0.135 $Y=0.072
c4 5 vss 0.00653408f $X=0.1305 $Y=0.198
c5 6 vss 0.00333836f $X=0.135 $Y=0.135
r1 18 5 0.510222 $w=1.8e-08 $l=5e-09 $layer=M1 $thickness=3.6e-08 $X=0.1355
+ $Y=0.1905 $X2=0.1305 $Y2=0.198
r2 4 13 6.16517 $w=1.44286e-08 $l=3.15e-08 $layer=M1 $thickness=3.6e-08
+ $X=0.135 $Y=0.072 $X2=0.135 $Y2=0.1035
r3 18 16 2.14973 $w=1.32632e-08 $l=1.80069e-08 $layer=M1 $thickness=3.6e-08
+ $X=0.1355 $Y=0.1905 $X2=0.135 $Y2=0.18
r4 15 16 2.91487 $w=1.3e-08 $l=1.25e-08 $layer=M1 $thickness=3.6e-08 $X=0.135
+ $Y=0.1675 $X2=0.135 $Y2=0.18
r5 14 15 3.14806 $w=1.3e-08 $l=1.35e-08 $layer=M1 $thickness=3.6e-08 $X=0.135
+ $Y=0.154 $X2=0.135 $Y2=0.1675
r6 6 13 7.34548 $w=1.3e-08 $l=3.15e-08 $layer=M1 $thickness=3.6e-08 $X=0.135
+ $Y=0.135 $X2=0.135 $Y2=0.1035
r7 6 14 4.43061 $w=1.3e-08 $l=1.9e-08 $layer=M1 $thickness=3.6e-08 $X=0.135
+ $Y=0.135 $X2=0.135 $Y2=0.154
r8 1 9 10.4265 $w=1.765e-08 $layer=LIG $thickness=5.2e-08 $X=0.135 $Y=0.135
+ $X2=0.135 $Y2=0.135
r9 1 6 19.3796 $a=3.24e-16 $layer=V0LIG $X=0.135 $Y=0.135 $X2=0.135 $Y2=0.135
r10 11 10 16.4967 $w=2.1e-08 $l=4.85e-08 $layer=Gate_1 $thickness=5.6e-08
+ $X=0.135 $Y=0.2025 $X2=0.135 $Y2=0.154
r11 9 10 6.6497 $w=2.04211e-08 $l=1.9e-08 $layer=Gate_1 $thickness=5.6e-08
+ $X=0.135 $Y=0.135 $X2=0.135 $Y2=0.154
r12 8 9 6.6497 $w=2.04211e-08 $l=1.9e-08 $layer=Gate_1 $thickness=5.6e-08
+ $X=0.135 $Y=0.116 $X2=0.135 $Y2=0.135
r13 7 8 16.4967 $w=2.1e-08 $l=4.85e-08 $layer=Gate_1 $thickness=5.6e-08
+ $X=0.135 $Y=0.0675 $X2=0.135 $Y2=0.116
r14 7 3 14.6259 $w=2.1e-08 $l=4.3e-08 $layer=Gate_1 $thickness=5.6e-08 $X=0.135
+ $Y=0.0675 $X2=0.135 $Y2=0.0245
.ends

.subckt PM_AO322x2_ASAP7_75t_R%B2 vss 13 5 9 3 4
c1 1 vss 0.00595636f $X=0.243 $Y=0.135
c2 3 vss 0.153422f $X=0.243 $Y=0.0245
c3 4 vss 0.00561198f $X=0.243 $Y=0.1035
r1 13 12 0.816164 $w=1.3e-08 $l=3.5e-09 $layer=M1 $thickness=3.6e-08 $X=0.2445
+ $Y=0.1505 $X2=0.243 $Y2=0.147
r2 11 12 2.79828 $w=1.3e-08 $l=1.2e-08 $layer=M1 $thickness=3.6e-08 $X=0.243
+ $Y=0.135 $X2=0.243 $Y2=0.147
r3 4 11 7.34548 $w=1.3e-08 $l=3.15e-08 $layer=M1 $thickness=3.6e-08 $X=0.243
+ $Y=0.1035 $X2=0.243 $Y2=0.135
r4 1 7 10.4265 $w=1.765e-08 $layer=LIG $thickness=5.2e-08 $X=0.243 $Y=0.135
+ $X2=0.243 $Y2=0.135
r5 1 11 19.3796 $a=3.24e-16 $layer=V0LIG $X=0.243 $Y=0.135 $X2=0.243 $Y2=0.135
r6 9 8 16.4967 $w=2.1e-08 $l=4.85e-08 $layer=Gate_1 $thickness=5.6e-08 $X=0.243
+ $Y=0.2025 $X2=0.243 $Y2=0.154
r7 7 8 6.6497 $w=2.04211e-08 $l=1.9e-08 $layer=Gate_1 $thickness=5.6e-08
+ $X=0.243 $Y=0.135 $X2=0.243 $Y2=0.154
r8 6 7 11.2416 $w=2.06615e-08 $l=3.25e-08 $layer=Gate_1 $thickness=5.6e-08
+ $X=0.243 $Y=0.1025 $X2=0.243 $Y2=0.135
r9 5 6 16.4967 $w=2.1e-08 $l=4.85e-08 $layer=Gate_1 $thickness=5.6e-08 $X=0.243
+ $Y=0.054 $X2=0.243 $Y2=0.1025
r10 5 3 10.0341 $w=2.1e-08 $l=2.95e-08 $layer=Gate_1 $thickness=5.6e-08
+ $X=0.243 $Y=0.054 $X2=0.243 $Y2=0.0245
.ends

* End of included file AO322x2_ASAP7_75t_R.pex.sp.pex

*
.subckt AO322x2_ASAP7_75t_CUSTOM_4_25_0_7 VSS VDD A1 A2 A3 B2 B1 C1 C2 Y
*
* VSS VSS
* VDD VDD
* A1 A1
* A2 A2
* A3 A3
* B2 B2
* B1 B1
* C1 C1
* C2 C2
* Y Y
*
*

M0 noxref_14 N_M0_g N_M0_s VSS nmos_rvt L=2e-08 W=8.1e-08 nfin=3 $X=0.071
+ $Y=0.027
M1 noxref_15 N_M1_g noxref_14 VSS nmos_rvt L=2e-08 W=8.1e-08 nfin=3 $X=0.125
+ $Y=0.027
M2 VSS N_M2_g noxref_15 VSS nmos_rvt L=2e-08 W=8.1e-08 nfin=3 $X=0.179 $Y=0.027
M3 noxref_16 N_M3_g VSS VSS nmos_rvt L=2e-08 W=5.4e-08 nfin=2 $X=0.233 $Y=0.027
M4 N_M4_d N_M4_g noxref_16 VSS nmos_rvt L=2e-08 W=5.4e-08 nfin=2 $X=0.287
+ $Y=0.027
M5 noxref_17 N_M5_g N_M5_s VSS nmos_rvt L=2e-08 W=5.4e-08 nfin=2 $X=0.449
+ $Y=0.027
M6 VSS N_M6_g noxref_17 VSS nmos_rvt L=2e-08 W=5.4e-08 nfin=2 $X=0.503 $Y=0.027
M7 VSS N_M7_g N_M7_s VSS nmos_rvt L=2e-08 W=8.1e-08 nfin=3 $X=0.665 $Y=0.027
M8 VSS N_M8_g N_M8_s VSS nmos_rvt L=2e-08 W=8.1e-08 nfin=3 $X=0.719 $Y=0.027
M9 noxref_11 N_M9_g VDD VDD pmos_rvt L=2e-08 W=8.1e-08 nfin=3 $X=0.071 $Y=0.162
M10 VDD N_M10_g noxref_11 VDD pmos_rvt L=2e-08 W=8.1e-08 nfin=3 $X=0.125
+ $Y=0.162
M11 noxref_11 N_M11_g VDD VDD pmos_rvt L=2e-08 W=8.1e-08 nfin=3 $X=0.179
+ $Y=0.162
M12 noxref_12 N_M12_g noxref_11 VDD pmos_rvt L=2e-08 W=8.1e-08 nfin=3 $X=0.233
+ $Y=0.162
M13 noxref_11 N_M13_g noxref_12 VDD pmos_rvt L=2e-08 W=8.1e-08 nfin=3 $X=0.287
+ $Y=0.162
M14 noxref_12 N_M14_g N_M14_s VDD pmos_rvt L=2e-08 W=8.1e-08 nfin=3 $X=0.449
+ $Y=0.162
M15 N_M15_d N_M15_g noxref_12 VDD pmos_rvt L=2e-08 W=8.1e-08 nfin=3 $X=0.503
+ $Y=0.162
M16 VDD N_M16_g N_M16_s VDD pmos_rvt L=2e-08 W=8.1e-08 nfin=3 $X=0.665 $Y=0.162
M17 VDD N_M17_g N_M17_s VDD pmos_rvt L=2e-08 W=8.1e-08 nfin=3 $X=0.719 $Y=0.162

* .include "AO322x2_ASAP7_75t_R.pex.sp.pxi"

* Start of included file AO322x2_ASAP7_75t_R.pex.sp.pxi
x_PM_AO322x2_ASAP7_75t_R%A3 vss A3 N_M2_g N_M11_g N_A3_4 N_A3_3
+ PM_AO322x2_ASAP7_75t_R%A3
cc_1 N_A3_4 N_A2_6 0.00352075f $X=0.189 $Y=0.0855
cc_2 N_A3_3 N_A2_3 0.0116367f $X=0.189 $Y=0.0245
x_PM_AO322x2_ASAP7_75t_R%B1 vss B1 N_M4_g N_M13_g N_B1_6 N_B1_3 N_B1_4
+ PM_AO322x2_ASAP7_75t_R%B1
cc_3 N_B1_6 N_B2_4 0.00300489f $X=0.297 $Y=0.0835
cc_4 N_B1_3 N_B2_3 0.00912968f $X=0.297 $Y=0.0245
x_PM_AO322x2_ASAP7_75t_R%C1 vss C1 N_M5_g N_M14_g N_C1_4 N_C1_3 N_C1_1
+ PM_AO322x2_ASAP7_75t_R%C1
x_PM_AO322x2_ASAP7_75t_R%C2 vss C2 N_M6_g N_M15_g N_C2_5 N_C2_3 N_C2_1
+ PM_AO322x2_ASAP7_75t_R%C2
cc_5 N_C2_5 N_C1_4 0.00324199f $X=0.513 $Y=0.1035
cc_6 N_C2_3 N_C1_3 0.00909116f $X=0.513 $Y=0.0245
x_PM_AO322x2_ASAP7_75t_R%A1 vss A1 N_M0_g N_M9_g N_A1_3 N_A1_9 N_A1_4
+ PM_AO322x2_ASAP7_75t_R%A1
x_PM_AO322x2_ASAP7_75t_R%Y vss Y N_M7_s N_M8_s N_M17_s N_M16_s N_Y_16 N_Y_1
+ N_Y_2 N_Y_21 N_Y_14 N_Y_13 N_Y_15 PM_AO322x2_ASAP7_75t_R%Y
cc_7 N_Y_16 N_10_28 0.000136243f $X=0.7415 $Y=0.2025
cc_8 N_Y_16 N_10_19 0.0011523f $X=0.7415 $Y=0.2025
cc_9 N_Y_16 N_10_32 0.000165946f $X=0.7415 $Y=0.2025
cc_10 N_Y_16 N_10_8 0.00021607f $X=0.7415 $Y=0.2025
cc_11 N_Y_16 N_10_29 0.000273937f $X=0.7415 $Y=0.2025
cc_12 N_Y_16 N_10_33 0.000274695f $X=0.7415 $Y=0.2025
cc_13 N_Y_16 N_10_34 0.00198158f $X=0.7415 $Y=0.2025
cc_14 N_Y_16 N_10_1 0.00202172f $X=0.7415 $Y=0.2025
cc_15 N_Y_1 N_10_19 0.00148839f $X=0.648 $Y=0.054
cc_16 N_Y_2 N_10_19 0.00170199f $X=0.648 $Y=0.2025
cc_17 N_Y_21 N_10_34 0.0017446f $X=0.783 $Y=0.054
cc_18 N_Y_14 N_10_1 0.00374273f $X=0.7415 $Y=0.0675
cc_19 N_Y_1 N_10_34 0.00417681f $X=0.648 $Y=0.054
cc_20 N_Y_14 N_10_20 0.0148929f $X=0.7415 $Y=0.0675
cc_21 N_Y_13 N_10_19 0.0150254f $X=0.65 $Y=0.0675
cc_22 N_Y_15 N_10_19 0.0534073f $X=0.65 $Y=0.2025
cc_23 N_Y_16 N_10_20 0.0565669f $X=0.7415 $Y=0.2025
x_PM_AO322x2_ASAP7_75t_R%10 vss N_M7_g N_M16_g N_M8_g N_M17_g N_M15_d N_M14_s
+ N_M5_s N_M4_d N_M0_s N_10_4 N_10_30 N_10_21 N_10_5 N_10_31 N_10_22 N_10_6
+ N_10_7 N_10_23 N_10_26 N_10_32 N_10_24 N_10_8 N_10_34 N_10_33 N_10_28 N_10_25
+ N_10_19 N_10_29 N_10_1 N_10_20 PM_AO322x2_ASAP7_75t_R%10
cc_24 N_10_4 N_A1_3 0.00378791f $X=0.054 $Y=0.0675
cc_25 N_10_30 N_A1_3 0.00148667f $X=0.367 $Y=0.036
cc_26 N_10_30 N_A1_4 0.0018801f $X=0.367 $Y=0.036
cc_27 N_10_21 N_A1_3 0.0362833f $X=0.056 $Y=0.0675
cc_28 N_10_4 N_A2_4 0.000441461f $X=0.054 $Y=0.0675
cc_29 N_10_30 N_A2_4 0.00552613f $X=0.367 $Y=0.036
cc_30 N_10_30 N_A3_4 0.00274613f $X=0.367 $Y=0.036
cc_31 N_10_30 N_B2_4 0.00296289f $X=0.367 $Y=0.036
cc_32 N_10_5 N_B1_3 0.00254328f $X=0.324 $Y=0.054
cc_33 N_10_31 N_B1_3 0.00104188f $X=0.405 $Y=0.18
cc_34 N_10_30 N_B1_4 0.00506427f $X=0.367 $Y=0.036
cc_35 N_10_22 N_B1_3 0.0265203f $X=0.3095 $Y=0.054
cc_36 N_10_6 N_C1_3 0.00117719f $X=0.432 $Y=0.054
cc_37 N_10_7 N_C1_3 0.00203571f $X=0.432 $Y=0.2025
cc_38 N_10_23 N_C1_3 0.0111472f $X=0.434 $Y=0.054
cc_39 N_10_26 N_C1_3 0.000469574f $X=0.405 $Y=0.036
cc_40 N_10_32 N_C1_4 0.0010556f $X=0.545 $Y=0.198
cc_41 N_10_24 N_C1_1 0.00133369f $X=0.434 $Y=0.2025
cc_42 N_10_31 N_C1_4 0.00605308f $X=0.405 $Y=0.18
cc_43 N_10_24 N_C1_3 0.0500786f $X=0.434 $Y=0.2025
cc_44 N_10_6 N_C2_3 0.000238893f $X=0.432 $Y=0.054
cc_45 N_10_8 N_C2_3 0.00187647f $X=0.54 $Y=0.2025
cc_46 N_10_34 N_C2_3 0.000337418f $X=0.605 $Y=0.135
cc_47 N_10_33 N_C2_3 0.000512273f $X=0.567 $Y=0.154
cc_48 N_10_28 N_C2_3 0.000630282f $X=0.567 $Y=0.135
cc_49 N_10_25 N_C2_1 0.00102991f $X=0.5255 $Y=0.2025
cc_50 N_10_32 N_C2_5 0.00108101f $X=0.545 $Y=0.198
cc_51 N_10_28 N_C2_5 0.00316044f $X=0.567 $Y=0.135
cc_52 N_10_25 N_C2_3 0.0359193f $X=0.5255 $Y=0.2025
x_PM_AO322x2_ASAP7_75t_R%A2 vss A2 N_M1_g N_M10_g N_A2_5 N_A2_1 N_A2_6 N_A2_3
+ N_A2_4 PM_AO322x2_ASAP7_75t_R%A2
cc_53 N_A2_5 N_A1_3 0.000579449f $X=0.1305 $Y=0.198
cc_54 N_A2_1 N_A1_3 0.00126503f $X=0.135 $Y=0.135
cc_55 N_A2_6 N_A1_9 0.00240955f $X=0.135 $Y=0.135
cc_56 N_A2_3 N_A1_3 0.00735363f $X=0.135 $Y=0.0245
x_PM_AO322x2_ASAP7_75t_R%B2 vss B2 N_M3_g N_M12_g N_B2_3 N_B2_4
+ PM_AO322x2_ASAP7_75t_R%B2
cc_57 N_B2_3 N_A3_3 0.00302049f $X=0.243 $Y=0.0245
cc_58 N_B2_4 N_A3_4 0.00499165f $X=0.243 $Y=0.1035

* End of included file AO322x2_ASAP7_75t_R.pex.sp.pxi
.ends

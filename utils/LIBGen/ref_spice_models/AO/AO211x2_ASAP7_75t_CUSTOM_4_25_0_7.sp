.subckt PM_AO211x2_ASAP7_75t_R%B vss 23 11 15 30 3 9 7 4 5
c1 1 vss 0.0136503f $X=0.2875 $Y=0.135
c2 3 vss 0.111364f $X=0.297 $Y=0.0245
c3 4 vss 0.0928746f $X=0.351 $Y=0.135
c4 5 vss 0.00282805f $X=0.243 $Y=0.072
c5 6 vss 0.00766246f $X=0.243 $Y=0.198
c6 7 vss 0.00111825f $X=0.243 $Y=0.135
c7 8 vss 0.00250862f $X=0.243 $Y=0.1035
c8 9 vss 0.00329967f $X=0.243 $Y=0.1485
c9 10 vss 0.00347082f $X=0.27 $Y=0.135
r1 6 33 3.01711 $w=1.55e-08 $l=1.8e-08 $layer=M1 $thickness=3.6e-08 $X=0.243
+ $Y=0.198 $X2=0.243 $Y2=0.18
r2 5 8 6.16517 $w=1.44286e-08 $l=3.15e-08 $layer=M1 $thickness=3.6e-08 $X=0.243
+ $Y=0.072 $X2=0.243 $Y2=0.1035
r3 32 33 4.19742 $w=1.3e-08 $l=1.8e-08 $layer=M1 $thickness=3.6e-08 $X=0.243
+ $Y=0.162 $X2=0.243 $Y2=0.18
r4 9 32 3.14806 $w=1.3e-08 $l=1.35e-08 $layer=M1 $thickness=3.6e-08 $X=0.243
+ $Y=0.1485 $X2=0.243 $Y2=0.162
r5 7 10 5.11582 $w=1.46667e-08 $l=2.7e-08 $layer=M1 $thickness=3.6e-08 $X=0.243
+ $Y=0.135 $X2=0.27 $Y2=0.135
r6 7 8 6.16517 $w=1.44286e-08 $l=3.15e-08 $layer=M1 $thickness=3.6e-08 $X=0.243
+ $Y=0.135 $X2=0.243 $Y2=0.1035
r7 7 9 1.96775 $w=1.63333e-08 $l=1.35e-08 $layer=M1 $thickness=3.6e-08 $X=0.243
+ $Y=0.135 $X2=0.243 $Y2=0.1485
r8 30 29 14.6259 $w=2.1e-08 $l=4.3e-08 $layer=Gate_1 $thickness=5.6e-08
+ $X=0.351 $Y=0.2025 $X2=0.351 $Y2=0.1595
r9 28 29 2.7211 $w=2.1e-08 $l=8e-09 $layer=Gate_1 $thickness=5.6e-08 $X=0.351
+ $Y=0.1515 $X2=0.351 $Y2=0.1595
r10 4 21 6.54019 $w=2.09524e-08 $layer=Gate_1 $thickness=5.21905e-08 $X=0.351
+ $Y=0.135 $X2=0.351 $Y2=0.135
r11 4 28 5.79936 $w=2.03333e-08 $l=1.65e-08 $layer=Gate_1 $thickness=5.6e-08
+ $X=0.351 $Y=0.135 $X2=0.351 $Y2=0.1515
r12 23 10 6.29612 $w=1.3e-08 $l=2.7e-08 $layer=M1 $thickness=3.6e-08 $X=0.298
+ $Y=0.1345 $X2=0.27 $Y2=0.135
r13 20 21 12.6539 $w=1.77815e-08 $l=2.7e-08 $layer=LIG $thickness=4.8e-08
+ $X=0.324 $Y=0.135 $X2=0.351 $Y2=0.135
r14 18 20 10.1729 $w=1.54914e-08 $l=1.75e-08 $layer=LIG $thickness=4.8e-08
+ $X=0.3065 $Y=0.135 $X2=0.324 $Y2=0.135
r15 17 18 2.48102 $w=2.2e-08 $l=9.5e-09 $layer=LIG $thickness=4.8e-08 $X=0.297
+ $Y=0.135 $X2=0.3065 $Y2=0.135
r16 23 17 19.3796 $a=3.24e-16 $layer=V0LIG $X=0.298 $Y=0.1345 $X2=0.297
+ $Y2=0.135
r17 1 17 2.48102 $w=2.2e-08 $l=9.5e-09 $layer=LIG $thickness=4.8e-08 $X=0.2875
+ $Y=0.135 $X2=0.297 $Y2=0.135
r18 15 14 16.4967 $w=2.1e-08 $l=4.85e-08 $layer=Gate_1 $thickness=5.6e-08
+ $X=0.297 $Y=0.2025 $X2=0.297 $Y2=0.154
r19 13 14 6.6497 $w=2.04211e-08 $l=1.9e-08 $layer=Gate_1 $thickness=5.6e-08
+ $X=0.297 $Y=0.135 $X2=0.297 $Y2=0.154
r20 13 18 4.05918 $w=2.0087e-08 $l=9.5e-09 $layer=Gate_1 $thickness=5.56522e-08
+ $X=0.297 $Y=0.135 $X2=0.3065 $Y2=0.135
r21 13 17 6.27904 $w=2.09e-08 $layer=Gate_1 $thickness=5.24e-08 $X=0.297
+ $Y=0.135 $X2=0.297 $Y2=0.135
r22 12 13 11.2416 $w=2.06615e-08 $l=3.25e-08 $layer=Gate_1 $thickness=5.6e-08
+ $X=0.297 $Y=0.1025 $X2=0.297 $Y2=0.135
r23 11 12 16.4967 $w=2.1e-08 $l=4.85e-08 $layer=Gate_1 $thickness=5.6e-08
+ $X=0.297 $Y=0.054 $X2=0.297 $Y2=0.1025
r24 11 3 10.0341 $w=2.1e-08 $l=2.95e-08 $layer=Gate_1 $thickness=5.6e-08
+ $X=0.297 $Y=0.054 $X2=0.297 $Y2=0.0245
.ends

.subckt PM_AO211x2_ASAP7_75t_R%A2 vss 29 11 15 27 5 9 8 7 3 1 10 4
c1 1 vss 0.0151273f $X=0.1795 $Y=0.135
c2 3 vss 0.142336f $X=0.189 $Y=0.0245
c3 4 vss 0.150782f $X=0.243 $Y=0.135
c4 5 vss 0.00141028f $X=0.135 $Y=0.072
c5 6 vss 0.00649515f $X=0.135 $Y=0.198
c6 7 vss 0.000253633f $X=0.135 $Y=0.1295
c7 8 vss 0.00111343f $X=0.135 $Y=0.1035
c8 9 vss 0.00240401f $X=0.135 $Y=0.1665
c9 10 vss 0.00205389f $X=0.162 $Y=0.135
r1 6 9 6.16517 $w=1.44286e-08 $l=3.15e-08 $layer=M1 $thickness=3.6e-08 $X=0.135
+ $Y=0.198 $X2=0.135 $Y2=0.1665
r2 5 8 6.16517 $w=1.44286e-08 $l=3.15e-08 $layer=M1 $thickness=3.6e-08 $X=0.135
+ $Y=0.072 $X2=0.135 $Y2=0.1035
r3 9 30 5.75699 $w=1.39091e-08 $l=2.75e-08 $layer=M1 $thickness=3.6e-08
+ $X=0.135 $Y=0.1665 $X2=0.135 $Y2=0.139
r4 29 30 0.561244 $w=1.8e-08 $l=5.5e-09 $layer=M1 $thickness=3.6e-08 $X=0.137
+ $Y=0.1335 $X2=0.135 $Y2=0.139
r5 29 7 0.408178 $w=1.8e-08 $l=4e-09 $layer=M1 $thickness=3.6e-08 $X=0.137
+ $Y=0.1335 $X2=0.135 $Y2=0.1295
r6 7 8 5.60393 $w=1.36731e-08 $l=2.6e-08 $layer=M1 $thickness=3.6e-08 $X=0.135
+ $Y=0.1295 $X2=0.135 $Y2=0.1035
r7 27 26 16.4967 $w=2.1e-08 $l=4.85e-08 $layer=Gate_1 $thickness=5.6e-08
+ $X=0.243 $Y=0.2025 $X2=0.243 $Y2=0.154
r8 4 21 6.54019 $w=2.09524e-08 $layer=Gate_1 $thickness=5.21905e-08 $X=0.243
+ $Y=0.135 $X2=0.243 $Y2=0.135
r9 4 26 6.6497 $w=2.04211e-08 $l=1.9e-08 $layer=Gate_1 $thickness=5.6e-08
+ $X=0.243 $Y=0.135 $X2=0.243 $Y2=0.154
r10 10 23 6.29612 $w=1.3e-08 $l=2.7e-08 $layer=M1 $thickness=3.6e-08 $X=0.162
+ $Y=0.135 $X2=0.189 $Y2=0.135
r11 29 10 4.24844 $w=9e-09 $l=2.70416e-08 $layer=M1 $thickness=3.6e-08 $X=0.137
+ $Y=0.1335 $X2=0.162 $Y2=0.135
r12 20 21 12.6539 $w=1.77815e-08 $l=2.7e-08 $layer=LIG $thickness=4.8e-08
+ $X=0.216 $Y=0.135 $X2=0.243 $Y2=0.135
r13 18 20 10.1729 $w=1.54914e-08 $l=1.75e-08 $layer=LIG $thickness=4.8e-08
+ $X=0.1985 $Y=0.135 $X2=0.216 $Y2=0.135
r14 17 18 2.48102 $w=2.2e-08 $l=9.5e-09 $layer=LIG $thickness=4.8e-08 $X=0.189
+ $Y=0.135 $X2=0.1985 $Y2=0.135
r15 17 23 19.3796 $a=3.24e-16 $layer=V0LIG $X=0.189 $Y=0.135 $X2=0.189 $Y2=0.135
r16 1 17 2.48102 $w=2.2e-08 $l=9.5e-09 $layer=LIG $thickness=4.8e-08 $X=0.1795
+ $Y=0.135 $X2=0.189 $Y2=0.135
r17 15 14 16.4967 $w=2.1e-08 $l=4.85e-08 $layer=Gate_1 $thickness=5.6e-08
+ $X=0.189 $Y=0.2025 $X2=0.189 $Y2=0.154
r18 13 14 6.6497 $w=2.04211e-08 $l=1.9e-08 $layer=Gate_1 $thickness=5.6e-08
+ $X=0.189 $Y=0.135 $X2=0.189 $Y2=0.154
r19 13 18 4.05918 $w=2.0087e-08 $l=9.5e-09 $layer=Gate_1 $thickness=5.56522e-08
+ $X=0.189 $Y=0.135 $X2=0.1985 $Y2=0.135
r20 13 17 6.27904 $w=2.09e-08 $layer=Gate_1 $thickness=5.24e-08 $X=0.189
+ $Y=0.135 $X2=0.189 $Y2=0.135
r21 12 13 6.6497 $w=2.04211e-08 $l=1.9e-08 $layer=Gate_1 $thickness=5.6e-08
+ $X=0.189 $Y=0.116 $X2=0.189 $Y2=0.135
r22 11 12 16.4967 $w=2.1e-08 $l=4.85e-08 $layer=Gate_1 $thickness=5.6e-08
+ $X=0.189 $Y=0.0675 $X2=0.189 $Y2=0.116
r23 11 3 14.6259 $w=2.1e-08 $l=4.3e-08 $layer=Gate_1 $thickness=5.6e-08
+ $X=0.189 $Y=0.0675 $X2=0.189 $Y2=0.0245
.ends

.subckt PM_AO211x2_ASAP7_75t_R%Y vss 21 16 17 28 29 7 1 8
c1 1 vss 0.00908523f $X=0.756 $Y=0.0675
c2 2 vss 0.00910805f $X=0.756 $Y=0.2025
c3 7 vss 0.00442511f $X=0.7415 $Y=0.0675
c4 8 vss 0.0045757f $X=0.7415 $Y=0.2025
c5 9 vss 0.00294322f $X=0.837 $Y=0.036
c6 10 vss 0.00294541f $X=0.837 $Y=0.234
c7 11 vss 0.00871702f $X=0.7425 $Y=0.036
c8 12 vss 0.00871884f $X=0.745 $Y=0.234
c9 13 vss 0.00849861f $X=0.837 $Y=0.085
r1 29 27 0.0308642 $w=8.1e-08 $l=2.5e-09 $layer=P_src_drn $thickness=1e-09
+ $X=0.7733 $Y=0.2025 $X2=0.7705 $Y2=0.2025
r2 2 27 0.179012 $w=8.1e-08 $l=1.45e-08 $layer=P_src_drn $thickness=1e-09
+ $X=0.756 $Y=0.2025 $X2=0.7705 $Y2=0.2025
r3 8 2 0.179012 $w=8.1e-08 $l=1.45e-08 $layer=P_src_drn $thickness=1e-09
+ $X=0.7415 $Y=0.2025 $X2=0.756 $Y2=0.2025
r4 28 8 0.0308642 $w=8.1e-08 $l=2.5e-09 $layer=P_src_drn $thickness=1e-09
+ $X=0.7386 $Y=0.2025 $X2=0.7415 $Y2=0.2025
r5 2 23 19.3796 $a=3.24e-16 $layer=V0LISD $X=0.756 $Y=0.2025 $X2=0.756 $Y2=0.234
r6 23 24 9.44419 $w=1.3e-08 $l=4.05e-08 $layer=M1 $thickness=3.6e-08 $X=0.756
+ $Y=0.234 $X2=0.7965 $Y2=0.234
r7 12 23 2.56509 $w=1.3e-08 $l=1.1e-08 $layer=M1 $thickness=3.6e-08 $X=0.745
+ $Y=0.234 $X2=0.756 $Y2=0.234
r8 10 22 10.0104 $w=1.4764e-08 $l=5e-08 $layer=M1 $thickness=3.6e-08 $X=0.837
+ $Y=0.234 $X2=0.837 $Y2=0.184
r9 10 24 7.79507 $w=1.41111e-08 $l=4.05e-08 $layer=M1 $thickness=3.6e-08
+ $X=0.837 $Y=0.234 $X2=0.7965 $Y2=0.234
r10 21 22 11.6595 $w=1.3e-08 $l=5e-08 $layer=M1 $thickness=3.6e-08 $X=0.8375
+ $Y=0.1355 $X2=0.837 $Y2=0.184
r11 21 13 11.4263 $w=1.3e-08 $l=4.9e-08 $layer=M1 $thickness=3.6e-08 $X=0.8375
+ $Y=0.1355 $X2=0.837 $Y2=0.085
r12 9 20 7.79507 $w=1.41111e-08 $l=4.05e-08 $layer=M1 $thickness=3.6e-08
+ $X=0.837 $Y=0.036 $X2=0.7965 $Y2=0.036
r13 9 13 9.77719 $w=1.48e-08 $l=4.9e-08 $layer=M1 $thickness=3.6e-08 $X=0.837
+ $Y=0.036 $X2=0.837 $Y2=0.085
r14 19 20 9.44419 $w=1.3e-08 $l=4.05e-08 $layer=M1 $thickness=3.6e-08 $X=0.756
+ $Y=0.036 $X2=0.7965 $Y2=0.036
r15 18 19 2.56509 $w=1.3e-08 $l=1.1e-08 $layer=M1 $thickness=3.6e-08 $X=0.745
+ $Y=0.036 $X2=0.756 $Y2=0.036
r16 11 18 0.582974 $w=1.3e-08 $l=2.5e-09 $layer=M1 $thickness=3.6e-08 $X=0.7425
+ $Y=0.036 $X2=0.745 $Y2=0.036
r17 1 19 19.3796 $a=3.24e-16 $layer=V0LISD $X=0.756 $Y=0.0675 $X2=0.756
+ $Y2=0.036
r18 17 15 0.0308642 $w=8.1e-08 $l=2.5e-09 $layer=N_src_drn $thickness=1e-09
+ $X=0.7733 $Y=0.0675 $X2=0.7705 $Y2=0.0675
r19 1 15 0.179012 $w=8.1e-08 $l=1.45e-08 $layer=N_src_drn $thickness=1e-09
+ $X=0.756 $Y=0.0675 $X2=0.7705 $Y2=0.0675
r20 7 1 0.179012 $w=8.1e-08 $l=1.45e-08 $layer=N_src_drn $thickness=1e-09
+ $X=0.7415 $Y=0.0675 $X2=0.756 $Y2=0.0675
r21 16 7 0.0308642 $w=8.1e-08 $l=2.5e-09 $layer=N_src_drn $thickness=1e-09
+ $X=0.7386 $Y=0.0675 $X2=0.7415 $Y2=0.0675
.ends

.subckt PM_AO211x2_ASAP7_75t_R%7 vss 29 35 48 52 81 83 85 88 89 3 24 17 4 18 6
+ 19 5 20 16 26 27 1 28 15
c1 1 vss 0.00822291f $X=0.7195 $Y=0.134
c2 3 vss 0.00579481f $X=0.108 $Y=0.0675
c3 4 vss 0.00687179f $X=0.324 $Y=0.054
c4 5 vss 0.00776163f $X=0.486 $Y=0.054
c5 6 vss 0.0117564f $X=0.54 $Y=0.2025
c6 15 vss 0.0830797f $X=0.729 $Y=0.0245
c7 16 vss 0.0829665f $X=0.783 $Y=0.134
c8 17 vss 0.00447676f $X=0.108 $Y=0.0675
c9 18 vss 0.00435586f $X=0.3095 $Y=0.054
c10 19 vss 0.0296956f $X=0.488 $Y=0.054
c11 20 vss 0.00593054f $X=0.5255 $Y=0.2025
c12 21 vss 0.00331751f $X=0.675 $Y=0.036
c13 22 vss 0.000804883f $X=0.675 $Y=0.134
c14 23 vss 0.0033876f $X=0.675 $Y=0.234
c15 24 vss 0.0586283f $X=0.637 $Y=0.036
c16 25 vss 0.0212655f $X=0.637 $Y=0.234
c17 26 vss 0.00466344f $X=0.675 $Y=0.103
c18 27 vss 0.00509369f $X=0.675 $Y=0.148
c19 28 vss 0.00225841f $X=0.702 $Y=0.134
r1 89 87 0.0308642 $w=8.1e-08 $l=2.5e-09 $layer=P_src_drn $thickness=1e-09
+ $X=0.5573 $Y=0.2025 $X2=0.5545 $Y2=0.2025
r2 6 87 0.179012 $w=8.1e-08 $l=1.45e-08 $layer=P_src_drn $thickness=1e-09
+ $X=0.54 $Y=0.2025 $X2=0.5545 $Y2=0.2025
r3 20 6 0.179012 $w=8.1e-08 $l=1.45e-08 $layer=P_src_drn $thickness=1e-09
+ $X=0.5255 $Y=0.2025 $X2=0.54 $Y2=0.2025
r4 88 20 0.0308642 $w=8.1e-08 $l=2.5e-09 $layer=P_src_drn $thickness=1e-09
+ $X=0.5226 $Y=0.2025 $X2=0.5255 $Y2=0.2025
r5 85 84 0.0308642 $w=8.1e-08 $l=2.5e-09 $layer=N_src_drn $thickness=1e-09
+ $X=0.1253 $Y=0.0675 $X2=0.1225 $Y2=0.0675
r6 17 84 0.179012 $w=8.1e-08 $l=1.45e-08 $layer=N_src_drn $thickness=1e-09
+ $X=0.108 $Y=0.0675 $X2=0.1225 $Y2=0.0675
r7 18 4 0.231482 $w=5.4e-08 $l=1.25e-08 $layer=N_src_drn $thickness=1e-09
+ $X=0.3095 $Y=0.054 $X2=0.324 $Y2=0.054
r8 83 18 0.0462963 $w=5.4e-08 $l=2.5e-09 $layer=N_src_drn $thickness=1e-09
+ $X=0.3066 $Y=0.054 $X2=0.3095 $Y2=0.054
r9 81 80 0.0462963 $w=5.4e-08 $l=2.5e-09 $layer=N_src_drn $thickness=1e-09
+ $X=0.5033 $Y=0.054 $X2=0.5005 $Y2=0.054
r10 19 80 0.231482 $w=5.4e-08 $l=1.25e-08 $layer=N_src_drn $thickness=1e-09
+ $X=0.488 $Y=0.054 $X2=0.5005 $Y2=0.054
r11 6 78 19.3796 $a=3.24e-16 $layer=V0LISD $X=0.54 $Y=0.2025 $X2=0.54 $Y2=0.234
r12 3 72 19.3796 $a=3.24e-16 $layer=V0LISD $X=0.108 $Y=0.0675 $X2=0.112
+ $Y2=0.036
r13 4 65 19.3796 $a=3.24e-16 $layer=V0LISD $X=0.324 $Y=0.054 $X2=0.324 $Y2=0.036
r14 5 62 19.3796 $a=3.24e-16 $layer=V0LISD $X=0.486 $Y=0.054 $X2=0.49 $Y2=0.036
r15 78 79 8.97781 $w=1.3e-08 $l=3.85e-08 $layer=M1 $thickness=3.6e-08 $X=0.54
+ $Y=0.234 $X2=0.5785 $Y2=0.234
r16 25 79 13.6416 $w=1.3e-08 $l=5.85e-08 $layer=M1 $thickness=3.6e-08 $X=0.637
+ $Y=0.234 $X2=0.5785 $Y2=0.234
r17 72 73 4.31401 $w=1.3e-08 $l=1.85e-08 $layer=M1 $thickness=3.6e-08 $X=0.112
+ $Y=0.036 $X2=0.1305 $Y2=0.036
r18 71 73 10.0272 $w=1.3e-08 $l=4.3e-08 $layer=M1 $thickness=3.6e-08 $X=0.1735
+ $Y=0.036 $X2=0.1305 $Y2=0.036
r19 70 71 8.27824 $w=1.3e-08 $l=3.55e-08 $layer=M1 $thickness=3.6e-08 $X=0.209
+ $Y=0.036 $X2=0.1735 $Y2=0.036
r20 69 70 5.71315 $w=1.3e-08 $l=2.45e-08 $layer=M1 $thickness=3.6e-08 $X=0.2335
+ $Y=0.036 $X2=0.209 $Y2=0.036
r21 68 69 11.1931 $w=1.3e-08 $l=4.8e-08 $layer=M1 $thickness=3.6e-08 $X=0.2815
+ $Y=0.036 $X2=0.2335 $Y2=0.036
r22 66 67 17.7224 $w=1.3e-08 $l=7.6e-08 $layer=M1 $thickness=3.6e-08 $X=0.405
+ $Y=0.036 $X2=0.481 $Y2=0.036
r23 65 66 18.8884 $w=1.3e-08 $l=8.1e-08 $layer=M1 $thickness=3.6e-08 $X=0.324
+ $Y=0.036 $X2=0.405 $Y2=0.036
r24 64 65 2.56509 $w=1.3e-08 $l=1.1e-08 $layer=M1 $thickness=3.6e-08 $X=0.313
+ $Y=0.036 $X2=0.324 $Y2=0.036
r25 64 68 7.34548 $w=1.3e-08 $l=3.15e-08 $layer=M1 $thickness=3.6e-08 $X=0.313
+ $Y=0.036 $X2=0.2815 $Y2=0.036
r26 62 63 4.31401 $w=1.3e-08 $l=1.85e-08 $layer=M1 $thickness=3.6e-08 $X=0.49
+ $Y=0.036 $X2=0.5085 $Y2=0.036
r27 62 67 2.09871 $w=1.3e-08 $l=9e-09 $layer=M1 $thickness=3.6e-08 $X=0.49
+ $Y=0.036 $X2=0.481 $Y2=0.036
r28 61 63 5.36336 $w=1.3e-08 $l=2.3e-08 $layer=M1 $thickness=3.6e-08 $X=0.5315
+ $Y=0.036 $X2=0.5085 $Y2=0.036
r29 60 61 10.0272 $w=1.3e-08 $l=4.3e-08 $layer=M1 $thickness=3.6e-08 $X=0.5745
+ $Y=0.036 $X2=0.5315 $Y2=0.036
r30 24 60 14.5744 $w=1.3e-08 $l=6.25e-08 $layer=M1 $thickness=3.6e-08 $X=0.637
+ $Y=0.036 $X2=0.5745 $Y2=0.036
r31 23 59 2.5483 $w=1.79e-08 $l=1.8e-08 $layer=M1 $thickness=3.6e-08 $X=0.675
+ $Y=0.234 $X2=0.675 $Y2=0.216
r32 23 25 7.2121 $w=1.41842e-08 $l=3.8e-08 $layer=M1 $thickness=3.6e-08
+ $X=0.675 $Y=0.234 $X2=0.637 $Y2=0.234
r33 21 55 2.5483 $w=1.79e-08 $l=1.8e-08 $layer=M1 $thickness=3.6e-08 $X=0.675
+ $Y=0.036 $X2=0.675 $Y2=0.054
r34 21 24 7.2121 $w=1.41842e-08 $l=3.8e-08 $layer=M1 $thickness=3.6e-08
+ $X=0.675 $Y=0.036 $X2=0.637 $Y2=0.036
r35 58 59 4.19742 $w=1.3e-08 $l=1.8e-08 $layer=M1 $thickness=3.6e-08 $X=0.675
+ $Y=0.198 $X2=0.675 $Y2=0.216
r36 57 58 4.19742 $w=1.3e-08 $l=1.8e-08 $layer=M1 $thickness=3.6e-08 $X=0.675
+ $Y=0.18 $X2=0.675 $Y2=0.198
r37 56 57 4.19742 $w=1.3e-08 $l=1.8e-08 $layer=M1 $thickness=3.6e-08 $X=0.675
+ $Y=0.162 $X2=0.675 $Y2=0.18
r38 27 56 3.26466 $w=1.3e-08 $l=1.4e-08 $layer=M1 $thickness=3.6e-08 $X=0.675
+ $Y=0.148 $X2=0.675 $Y2=0.162
r39 54 55 4.19742 $w=1.3e-08 $l=1.8e-08 $layer=M1 $thickness=3.6e-08 $X=0.675
+ $Y=0.072 $X2=0.675 $Y2=0.054
r40 26 54 7.22888 $w=1.3e-08 $l=3.1e-08 $layer=M1 $thickness=3.6e-08 $X=0.675
+ $Y=0.103 $X2=0.675 $Y2=0.072
r41 22 28 5.11582 $w=1.46667e-08 $l=2.7e-08 $layer=M1 $thickness=3.6e-08
+ $X=0.675 $Y=0.134 $X2=0.702 $Y2=0.134
r42 22 26 6.04857 $w=1.44516e-08 $l=3.1e-08 $layer=M1 $thickness=3.6e-08
+ $X=0.675 $Y=0.134 $X2=0.675 $Y2=0.103
r43 22 27 2.08435 $w=1.62143e-08 $l=1.4e-08 $layer=M1 $thickness=3.6e-08
+ $X=0.675 $Y=0.134 $X2=0.675 $Y2=0.148
r44 52 51 14.6259 $w=2.1e-08 $l=4.3e-08 $layer=Gate_1 $thickness=5.6e-08
+ $X=0.783 $Y=0.2025 $X2=0.783 $Y2=0.1595
r45 50 51 3.06124 $w=2.1e-08 $l=9e-09 $layer=Gate_1 $thickness=5.6e-08 $X=0.783
+ $Y=0.1505 $X2=0.783 $Y2=0.1595
r46 48 49 14.6259 $w=2.1e-08 $l=4.3e-08 $layer=Gate_1 $thickness=5.6e-08
+ $X=0.783 $Y=0.0675 $X2=0.783 $Y2=0.1105
r47 46 49 2.7211 $w=2.1e-08 $l=8e-09 $layer=Gate_1 $thickness=5.6e-08 $X=0.783
+ $Y=0.1185 $X2=0.783 $Y2=0.1105
r48 16 41 6.74717 $w=2e-08 $layer=Gate_1 $thickness=5.2e-08 $X=0.783 $Y=0.134
+ $X2=0.783 $Y2=0.134
r49 16 46 5.44221 $w=2.03548e-08 $l=1.55e-08 $layer=Gate_1 $thickness=5.6e-08
+ $X=0.783 $Y=0.134 $X2=0.783 $Y2=0.1185
r50 16 50 5.78235 $w=2.03939e-08 $l=1.65e-08 $layer=Gate_1 $thickness=5.6e-08
+ $X=0.783 $Y=0.134 $X2=0.783 $Y2=0.1505
r51 28 43 6.29612 $w=1.3e-08 $l=2.7e-08 $layer=M1 $thickness=3.6e-08 $X=0.702
+ $Y=0.134 $X2=0.729 $Y2=0.134
r52 40 41 20.114 $w=1.57815e-08 $l=2.7e-08 $layer=LIG $thickness=4.8e-08
+ $X=0.756 $Y=0.134 $X2=0.783 $Y2=0.134
r53 38 40 17.097 $w=1.34914e-08 $l=1.75e-08 $layer=LIG $thickness=4.8e-08
+ $X=0.7385 $Y=0.134 $X2=0.756 $Y2=0.134
r54 37 38 3.01694 $w=2e-08 $l=9.5e-09 $layer=LIG $thickness=4.8e-08 $X=0.729
+ $Y=0.134 $X2=0.7385 $Y2=0.134
r55 37 43 19.3796 $a=3.24e-16 $layer=V0LIG $X=0.729 $Y=0.134 $X2=0.729 $Y2=0.134
r56 1 37 3.01694 $w=2e-08 $l=9.5e-09 $layer=LIG $thickness=4.8e-08 $X=0.7195
+ $Y=0.134 $X2=0.729 $Y2=0.134
r57 35 34 14.6259 $w=2.1e-08 $l=4.3e-08 $layer=Gate_1 $thickness=5.6e-08
+ $X=0.729 $Y=0.2025 $X2=0.729 $Y2=0.1595
r58 33 34 3.06124 $w=2.1e-08 $l=9e-09 $layer=Gate_1 $thickness=5.6e-08 $X=0.729
+ $Y=0.1505 $X2=0.729 $Y2=0.1595
r59 32 33 5.78235 $w=2.03939e-08 $l=1.65e-08 $layer=Gate_1 $thickness=5.6e-08
+ $X=0.729 $Y=0.134 $X2=0.729 $Y2=0.1505
r60 32 38 3.73024 $w=2e-08 $l=9.5e-09 $layer=Gate_1 $thickness=5.5619e-08
+ $X=0.729 $Y=0.134 $X2=0.7385 $Y2=0.134
r61 32 37 6.4296 $w=2e-08 $layer=Gate_1 $thickness=5.22105e-08 $X=0.729
+ $Y=0.134 $X2=0.729 $Y2=0.134
r62 31 32 5.44221 $w=2.03548e-08 $l=1.55e-08 $layer=Gate_1 $thickness=5.6e-08
+ $X=0.729 $Y=0.1185 $X2=0.729 $Y2=0.134
r63 30 31 2.7211 $w=2.1e-08 $l=8e-09 $layer=Gate_1 $thickness=5.6e-08 $X=0.729
+ $Y=0.1105 $X2=0.729 $Y2=0.1185
r64 29 30 14.6259 $w=2.1e-08 $l=4.3e-08 $layer=Gate_1 $thickness=5.6e-08
+ $X=0.729 $Y=0.0675 $X2=0.729 $Y2=0.1105
r65 29 15 14.6259 $w=2.1e-08 $l=4.3e-08 $layer=Gate_1 $thickness=5.6e-08
+ $X=0.729 $Y=0.0675 $X2=0.729 $Y2=0.0245
r66 3 17 1e-05 $X=0.108 $Y=0.0675 $X2=0.108 $Y2=0.0675
r67 5 19 1e-05 $l=2e-09 $X=0.486 $Y=0.054 $X2=0.488 $Y2=0.054
.ends

.subckt PM_AO211x2_ASAP7_75t_R%A1 vss 6 11 15 27 4 10 1 3
c1 1 vss 0.0101312f $X=0.135 $Y=0.135
c2 3 vss 0.093478f $X=0.081 $Y=0.135
c3 4 vss 0.100435f $X=0.135 $Y=0.0245
c4 5 vss 0.00727809f $X=0.027 $Y=0.036
c5 6 vss 0.00149239f $X=0.0265 $Y=0.135
c6 7 vss 0.00741825f $X=0.027 $Y=0.198
c7 8 vss 0.00725396f $X=0.027 $Y=0.1035
c8 9 vss 0.0045046f $X=0.027 $Y=0.1665
c9 10 vss 0.00267862f $X=0.0635 $Y=0.135
r1 7 9 6.16517 $w=1.44286e-08 $l=3.15e-08 $layer=M1 $thickness=3.6e-08 $X=0.027
+ $Y=0.198 $X2=0.027 $Y2=0.1665
r2 5 34 3.01711 $w=1.55e-08 $l=1.8e-08 $layer=M1 $thickness=3.6e-08 $X=0.027
+ $Y=0.036 $X2=0.027 $Y2=0.054
r3 33 34 4.19742 $w=1.3e-08 $l=1.8e-08 $layer=M1 $thickness=3.6e-08 $X=0.027
+ $Y=0.072 $X2=0.027 $Y2=0.054
r4 8 33 7.34548 $w=1.3e-08 $l=3.15e-08 $layer=M1 $thickness=3.6e-08 $X=0.027
+ $Y=0.1035 $X2=0.027 $Y2=0.072
r5 6 31 3.1337 $w=1.54324e-08 $l=1.85e-08 $layer=M1 $thickness=3.6e-08
+ $X=0.0265 $Y=0.135 $X2=0.0455 $Y2=0.135
r6 6 8 6.16517 $w=1.44286e-08 $l=3.15e-08 $layer=M1 $thickness=3.6e-08
+ $X=0.0265 $Y=0.135 $X2=0.027 $Y2=0.1035
r7 6 9 6.16517 $w=1.44286e-08 $l=3.15e-08 $layer=M1 $thickness=3.6e-08
+ $X=0.0265 $Y=0.135 $X2=0.027 $Y2=0.1665
r8 10 29 4.08082 $w=1.3e-08 $l=1.75e-08 $layer=M1 $thickness=3.6e-08 $X=0.0635
+ $Y=0.135 $X2=0.081 $Y2=0.135
r9 10 31 4.19742 $w=1.3e-08 $l=1.8e-08 $layer=M1 $thickness=3.6e-08 $X=0.0635
+ $Y=0.135 $X2=0.0455 $Y2=0.135
r10 27 26 14.6259 $w=2.1e-08 $l=4.3e-08 $layer=Gate_1 $thickness=5.6e-08
+ $X=0.081 $Y=0.2025 $X2=0.081 $Y2=0.1595
r11 25 26 2.7211 $w=2.1e-08 $l=8e-09 $layer=Gate_1 $thickness=5.6e-08 $X=0.081
+ $Y=0.1515 $X2=0.081 $Y2=0.1595
r12 3 19 6.27904 $w=2.09e-08 $layer=Gate_1 $thickness=5.24e-08 $X=0.081
+ $Y=0.135 $X2=0.081 $Y2=0.135
r13 3 25 5.79936 $w=2.03333e-08 $l=1.65e-08 $layer=Gate_1 $thickness=5.6e-08
+ $X=0.081 $Y=0.135 $X2=0.081 $Y2=0.1515
r14 19 20 2.48102 $w=2.2e-08 $l=9.5e-09 $layer=LIG $thickness=4.8e-08 $X=0.081
+ $Y=0.135 $X2=0.0905 $Y2=0.135
r15 19 29 19.3796 $a=3.24e-16 $layer=V0LIG $X=0.081 $Y=0.135 $X2=0.081 $Y2=0.135
r16 17 20 10.1729 $w=1.54914e-08 $l=1.75e-08 $layer=LIG $thickness=4.8e-08
+ $X=0.108 $Y=0.135 $X2=0.0905 $Y2=0.135
r17 1 13 6.54019 $w=2.09524e-08 $layer=Gate_1 $thickness=5.21905e-08 $X=0.135
+ $Y=0.135 $X2=0.135 $Y2=0.135
r18 1 17 12.6539 $w=1.77815e-08 $l=2.7e-08 $layer=LIG $thickness=4.8e-08
+ $X=0.135 $Y=0.135 $X2=0.108 $Y2=0.135
r19 15 14 16.4967 $w=2.1e-08 $l=4.85e-08 $layer=Gate_1 $thickness=5.6e-08
+ $X=0.135 $Y=0.2025 $X2=0.135 $Y2=0.154
r20 13 14 6.6497 $w=2.04211e-08 $l=1.9e-08 $layer=Gate_1 $thickness=5.6e-08
+ $X=0.135 $Y=0.135 $X2=0.135 $Y2=0.154
r21 12 13 6.6497 $w=2.04211e-08 $l=1.9e-08 $layer=Gate_1 $thickness=5.6e-08
+ $X=0.135 $Y=0.116 $X2=0.135 $Y2=0.135
r22 11 12 16.4967 $w=2.1e-08 $l=4.85e-08 $layer=Gate_1 $thickness=5.6e-08
+ $X=0.135 $Y=0.0675 $X2=0.135 $Y2=0.116
r23 11 4 14.6259 $w=2.1e-08 $l=4.3e-08 $layer=Gate_1 $thickness=5.6e-08
+ $X=0.135 $Y=0.0675 $X2=0.135 $Y2=0.0245
.ends

.subckt PM_AO211x2_ASAP7_75t_R%C vss 7 8 14 28 3 1 5 4
c1 1 vss 0.0099723f $X=0.5035 $Y=0.135
c2 3 vss 0.0817043f $X=0.513 $Y=0.0245
c3 4 vss 0.0851301f $X=0.567 $Y=0.135
c4 5 vss 0.00329569f $X=0.513 $Y=0.072
c5 6 vss 0.00674967f $X=0.513 $Y=0.162
c6 7 vss 0.0049807f $X=0.514 $Y=0.137
r1 6 23 1.96775 $w=1.63333e-08 $l=1.35e-08 $layer=M1 $thickness=3.6e-08
+ $X=0.513 $Y=0.162 $X2=0.513 $Y2=0.1485
r2 5 22 6.16517 $w=1.44286e-08 $l=3.15e-08 $layer=M1 $thickness=3.6e-08
+ $X=0.513 $Y=0.072 $X2=0.513 $Y2=0.1035
r3 28 27 14.6259 $w=2.1e-08 $l=4.3e-08 $layer=Gate_1 $thickness=5.6e-08
+ $X=0.567 $Y=0.2025 $X2=0.567 $Y2=0.1595
r4 26 27 2.7211 $w=2.1e-08 $l=8e-09 $layer=Gate_1 $thickness=5.6e-08 $X=0.567
+ $Y=0.1515 $X2=0.567 $Y2=0.1595
r5 4 20 6.54019 $w=2.09524e-08 $layer=Gate_1 $thickness=5.21905e-08 $X=0.567
+ $Y=0.135 $X2=0.567 $Y2=0.135
r6 4 26 5.79936 $w=2.03333e-08 $l=1.65e-08 $layer=Gate_1 $thickness=5.6e-08
+ $X=0.567 $Y=0.135 $X2=0.567 $Y2=0.1515
r7 7 16 19.3796 $a=3.24e-16 $layer=V0LIG $X=0.514 $Y=0.137 $X2=0.513 $Y2=0.135
r8 7 22 7.34548 $w=1.3e-08 $l=3.15e-08 $layer=M1 $thickness=3.6e-08 $X=0.514
+ $Y=0.137 $X2=0.513 $Y2=0.1035
r9 7 23 3.14806 $w=1.3e-08 $l=1.35e-08 $layer=M1 $thickness=3.6e-08 $X=0.514
+ $Y=0.137 $X2=0.513 $Y2=0.1485
r10 19 20 12.6539 $w=1.77815e-08 $l=2.7e-08 $layer=LIG $thickness=4.8e-08
+ $X=0.54 $Y=0.135 $X2=0.567 $Y2=0.135
r11 17 19 10.1729 $w=1.54914e-08 $l=1.75e-08 $layer=LIG $thickness=4.8e-08
+ $X=0.5225 $Y=0.135 $X2=0.54 $Y2=0.135
r12 16 17 2.48102 $w=2.2e-08 $l=9.5e-09 $layer=LIG $thickness=4.8e-08 $X=0.513
+ $Y=0.135 $X2=0.5225 $Y2=0.135
r13 1 16 2.48102 $w=2.2e-08 $l=9.5e-09 $layer=LIG $thickness=4.8e-08 $X=0.5035
+ $Y=0.135 $X2=0.513 $Y2=0.135
r14 14 13 14.6259 $w=2.1e-08 $l=4.3e-08 $layer=Gate_1 $thickness=5.6e-08
+ $X=0.513 $Y=0.2025 $X2=0.513 $Y2=0.1595
r15 12 13 2.7211 $w=2.1e-08 $l=8e-09 $layer=Gate_1 $thickness=5.6e-08 $X=0.513
+ $Y=0.1515 $X2=0.513 $Y2=0.1595
r16 11 12 5.79936 $w=2.03333e-08 $l=1.65e-08 $layer=Gate_1 $thickness=5.6e-08
+ $X=0.513 $Y=0.135 $X2=0.513 $Y2=0.1515
r17 11 17 4.05918 $w=2.0087e-08 $l=9.5e-09 $layer=Gate_1 $thickness=5.56522e-08
+ $X=0.513 $Y=0.135 $X2=0.5225 $Y2=0.135
r18 11 16 6.27904 $w=2.09e-08 $layer=Gate_1 $thickness=5.24e-08 $X=0.513
+ $Y=0.135 $X2=0.513 $Y2=0.135
r19 10 11 5.79936 $w=2.03333e-08 $l=1.65e-08 $layer=Gate_1 $thickness=5.6e-08
+ $X=0.513 $Y=0.1185 $X2=0.513 $Y2=0.135
r20 9 10 7.31297 $w=2.1e-08 $l=2.15e-08 $layer=Gate_1 $thickness=5.6e-08
+ $X=0.513 $Y=0.097 $X2=0.513 $Y2=0.1185
r21 8 9 14.6259 $w=2.1e-08 $l=4.3e-08 $layer=Gate_1 $thickness=5.6e-08 $X=0.513
+ $Y=0.054 $X2=0.513 $Y2=0.097
r22 8 3 10.0341 $w=2.1e-08 $l=2.95e-08 $layer=Gate_1 $thickness=5.6e-08
+ $X=0.513 $Y=0.054 $X2=0.513 $Y2=0.0245
.ends

* End of included file AO211x2_ASAP7_75t_R.pex.sp.pex

*
.subckt AO211x2_ASAP7_75t_CUSTOM_4_25_0_7 VSS VDD A1 A2 B C Y
*
* VSS VSS
* VDD VDD
* A1 A1
* A2 A2
* B B
* C C
* Y Y
*
*

M0 noxref_11 N_M0_g N_M0_s VSS nmos_rvt L=2e-08 W=8.1e-08 nfin=3 $X=0.125
+ $Y=0.027
M1 VSS N_M1_g noxref_11 VSS nmos_rvt L=2e-08 W=8.1e-08 nfin=3 $X=0.179 $Y=0.027
M2 N_M2_d N_M2_g VSS VSS nmos_rvt L=2e-08 W=5.4e-08 nfin=2 $X=0.287 $Y=0.027
M3 VSS N_M3_g N_M3_s VSS nmos_rvt L=2e-08 W=5.4e-08 nfin=2 $X=0.503 $Y=0.027
M4 N_M4_d N_M4_g VSS VSS nmos_rvt L=2e-08 W=8.1e-08 nfin=3 $X=0.719 $Y=0.027
M5 N_M5_d N_M5_g VSS VSS nmos_rvt L=2e-08 W=8.1e-08 nfin=3 $X=0.773 $Y=0.027
M6 VDD N_M6_g noxref_8 VDD pmos_rvt L=2e-08 W=8.1e-08 nfin=3 $X=0.071 $Y=0.162
M7 VDD N_M7_g noxref_8 VDD pmos_rvt L=2e-08 W=8.1e-08 nfin=3 $X=0.125 $Y=0.162
M8 VDD N_M8_g noxref_8 VDD pmos_rvt L=2e-08 W=8.1e-08 nfin=3 $X=0.179 $Y=0.162
M9 VDD N_M9_g noxref_8 VDD pmos_rvt L=2e-08 W=8.1e-08 nfin=3 $X=0.233 $Y=0.162
M10 noxref_9 N_M10_g noxref_8 VDD pmos_rvt L=2e-08 W=8.1e-08 nfin=3 $X=0.287
+ $Y=0.162
M11 noxref_9 N_M11_g noxref_8 VDD pmos_rvt L=2e-08 W=8.1e-08 nfin=3 $X=0.341
+ $Y=0.162
M12 N_M12_d N_M12_g noxref_9 VDD pmos_rvt L=2e-08 W=8.1e-08 nfin=3 $X=0.503
+ $Y=0.162
M13 N_M13_d N_M13_g noxref_9 VDD pmos_rvt L=2e-08 W=8.1e-08 nfin=3 $X=0.557
+ $Y=0.162
M14 N_M14_d N_M14_g VDD VDD pmos_rvt L=2e-08 W=8.1e-08 nfin=3 $X=0.719 $Y=0.162
M15 N_M15_d N_M15_g VDD VDD pmos_rvt L=2e-08 W=8.1e-08 nfin=3 $X=0.773 $Y=0.162

* .include "AO211x2_ASAP7_75t_R.pex.sp.pxi"

* Start of included file AO211x2_ASAP7_75t_R.pex.sp.pxi
x_PM_AO211x2_ASAP7_75t_R%B vss B N_M2_g N_M10_g N_M11_g N_B_3 N_B_9 N_B_7 N_B_4
+ N_B_5 PM_AO211x2_ASAP7_75t_R%B
cc_1 N_B_3 N_A2_1 0.000561973f $X=0.297 $Y=0.0245
cc_2 N_B_3 N_A2_10 0.000633532f $X=0.297 $Y=0.0245
cc_3 N_B_9 N_A2_10 0.000649653f $X=0.243 $Y=0.1485
cc_4 N_B_7 N_A2_1 0.00134744f $X=0.243 $Y=0.135
cc_5 N_B_7 N_A2_10 0.00177265f $X=0.243 $Y=0.135
cc_6 N_B_3 N_A2_4 0.00777902f $X=0.297 $Y=0.0245
x_PM_AO211x2_ASAP7_75t_R%A2 vss A2 N_M1_g N_M8_g N_M9_g N_A2_5 N_A2_9 N_A2_8
+ N_A2_7 N_A2_3 N_A2_1 N_A2_10 N_A2_4 PM_AO211x2_ASAP7_75t_R%A2
cc_7 N_A2_5 N_A1_4 0.000678402f $X=0.135 $Y=0.072
cc_8 N_A2_9 N_A1_4 0.000701853f $X=0.135 $Y=0.1665
cc_9 N_A2_8 N_A1_10 0.000727028f $X=0.135 $Y=0.1035
cc_10 N_A2_7 N_A1_10 0.00178229f $X=0.135 $Y=0.1295
cc_11 N_A2_7 N_A1_1 0.00179398f $X=0.135 $Y=0.1295
cc_12 N_A2_3 N_A1_4 0.00760954f $X=0.189 $Y=0.0245
x_PM_AO211x2_ASAP7_75t_R%Y vss Y N_M4_d N_M5_d N_M14_d N_M15_d N_Y_7 N_Y_1
+ N_Y_8 PM_AO211x2_ASAP7_75t_R%Y
cc_13 N_Y_7 N_7_16 0.0402665f $X=0.7415 $Y=0.0675
cc_14 N_Y_7 N_7_26 0.000417306f $X=0.7415 $Y=0.0675
cc_15 N_Y_7 N_7_27 0.000503849f $X=0.7415 $Y=0.0675
cc_16 N_Y_7 N_7_1 0.00660229f $X=0.7415 $Y=0.0675
cc_17 N_Y_7 N_7_28 0.000975092f $X=0.7415 $Y=0.0675
cc_18 N_Y_1 N_7_15 0.00189377f $X=0.756 $Y=0.0675
cc_19 N_Y_8 N_7_16 0.0103267f $X=0.7415 $Y=0.2025
cc_20 N_Y_8 N_7_15 0.018366f $X=0.7415 $Y=0.2025
cc_21 N_Y_7 N_7_15 0.0678321f $X=0.7415 $Y=0.0675
x_PM_AO211x2_ASAP7_75t_R%7 vss N_M4_g N_M14_g N_M5_g N_M15_g N_M3_s N_M2_d
+ N_M0_s N_M12_d N_M13_d N_7_3 N_7_24 N_7_17 N_7_4 N_7_18 N_7_6 N_7_19 N_7_5
+ N_7_20 N_7_16 N_7_26 N_7_27 N_7_1 N_7_28 N_7_15 PM_AO211x2_ASAP7_75t_R%7
cc_22 N_7_3 N_A1_4 0.000288283f $X=0.108 $Y=0.0675
cc_23 N_7_24 N_A1_4 0.0013899f $X=0.637 $Y=0.036
cc_24 N_7_17 N_A1_1 0.00253233f $X=0.108 $Y=0.0675
cc_25 N_7_3 N_A1_3 0.00255465f $X=0.108 $Y=0.0675
cc_26 N_7_17 N_A1_3 0.0195915f $X=0.108 $Y=0.0675
cc_27 N_7_17 N_A1_4 0.0517395f $X=0.108 $Y=0.0675
cc_28 N_7_17 N_A2_5 0.000326695f $X=0.108 $Y=0.0675
cc_29 N_7_3 N_A2_5 0.00197279f $X=0.108 $Y=0.0675
cc_30 N_7_24 N_A2_10 0.0023182f $X=0.637 $Y=0.036
cc_31 N_7_24 N_A2_5 0.00299912f $X=0.637 $Y=0.036
cc_32 N_7_24 N_B_3 0.000728655f $X=0.637 $Y=0.036
cc_33 N_7_4 N_B_3 0.000489638f $X=0.324 $Y=0.054
cc_34 N_7_4 N_B_4 0.00124573f $X=0.324 $Y=0.054
cc_35 N_7_24 N_B_5 0.00518446f $X=0.637 $Y=0.036
cc_36 N_7_18 N_B_4 0.0146447f $X=0.3095 $Y=0.054
cc_37 N_7_18 N_B_3 0.0393745f $X=0.3095 $Y=0.054
cc_38 N_7_6 N_C_3 0.00260693f $X=0.54 $Y=0.2025
cc_39 N_7_19 N_C_3 0.0111471f $X=0.488 $Y=0.054
cc_40 N_7_5 N_C_3 0.00228637f $X=0.486 $Y=0.054
cc_41 N_7_20 N_C_1 0.0028731f $X=0.5255 $Y=0.2025
cc_42 N_7_24 N_C_5 0.00561403f $X=0.637 $Y=0.036
cc_43 N_7_20 N_C_4 0.0486977f $X=0.5255 $Y=0.2025
cc_44 N_7_20 N_C_3 0.0345794f $X=0.5255 $Y=0.2025
x_PM_AO211x2_ASAP7_75t_R%A1 vss A1 N_M0_g N_M7_g N_M6_g N_A1_4 N_A1_10 N_A1_1
+ N_A1_3 PM_AO211x2_ASAP7_75t_R%A1
x_PM_AO211x2_ASAP7_75t_R%C vss C N_M3_g N_M12_g N_M13_g N_C_3 N_C_1 N_C_5 N_C_4
+ PM_AO211x2_ASAP7_75t_R%C

* End of included file AO211x2_ASAP7_75t_R.pex.sp.pxi
.ends

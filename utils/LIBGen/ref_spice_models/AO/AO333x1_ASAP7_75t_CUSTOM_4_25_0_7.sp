.subckt PM_AO333x1_ASAP7_75t_R%A1 vss 11 5 9 3 4
c1 1 vss 0.0043141f $X=0.243 $Y=0.135
c2 3 vss 0.102413f $X=0.243 $Y=0.0245
c3 4 vss 0.00962894f $X=0.243 $Y=0.098
r1 11 4 8.62802 $w=1.3e-08 $l=3.7e-08 $layer=M1 $thickness=3.6e-08 $X=0.2435
+ $Y=0.1345 $X2=0.243 $Y2=0.098
r2 1 7 10.4265 $w=1.765e-08 $layer=LIG $thickness=5.2e-08 $X=0.243 $Y=0.135
+ $X2=0.243 $Y2=0.135
r3 11 1 19.3796 $a=3.24e-16 $layer=V0LIG $X=0.2435 $Y=0.1345 $X2=0.243 $Y2=0.135
r4 9 8 16.4967 $w=2.1e-08 $l=4.85e-08 $layer=Gate_1 $thickness=5.6e-08 $X=0.243
+ $Y=0.2025 $X2=0.243 $Y2=0.154
r5 7 8 6.6497 $w=2.04211e-08 $l=1.9e-08 $layer=Gate_1 $thickness=5.6e-08
+ $X=0.243 $Y=0.135 $X2=0.243 $Y2=0.154
r6 6 7 6.6497 $w=2.04211e-08 $l=1.9e-08 $layer=Gate_1 $thickness=5.6e-08
+ $X=0.243 $Y=0.116 $X2=0.243 $Y2=0.135
r7 5 6 16.4967 $w=2.1e-08 $l=4.85e-08 $layer=Gate_1 $thickness=5.6e-08 $X=0.243
+ $Y=0.0675 $X2=0.243 $Y2=0.116
r8 5 3 14.6259 $w=2.1e-08 $l=4.3e-08 $layer=Gate_1 $thickness=5.6e-08 $X=0.243
+ $Y=0.0675 $X2=0.243 $Y2=0.0245
.ends

.subckt PM_AO333x1_ASAP7_75t_R%B3 vss 13 5 9 4 3
c1 1 vss 0.00701036f $X=0.297 $Y=0.135
c2 3 vss 0.101666f $X=0.297 $Y=0.0245
c3 4 vss 0.00470404f $X=0.297 $Y=0.098
r1 13 12 1.28254 $w=1.3e-08 $l=5.5e-09 $layer=M1 $thickness=3.6e-08 $X=0.2975
+ $Y=0.1545 $X2=0.297 $Y2=0.149
r2 11 12 3.26466 $w=1.3e-08 $l=1.4e-08 $layer=M1 $thickness=3.6e-08 $X=0.297
+ $Y=0.135 $X2=0.297 $Y2=0.149
r3 4 11 8.62802 $w=1.3e-08 $l=3.7e-08 $layer=M1 $thickness=3.6e-08 $X=0.297
+ $Y=0.098 $X2=0.297 $Y2=0.135
r4 1 7 10.4265 $w=1.765e-08 $layer=LIG $thickness=5.2e-08 $X=0.297 $Y=0.135
+ $X2=0.297 $Y2=0.135
r5 1 11 19.3796 $a=3.24e-16 $layer=V0LIG $X=0.297 $Y=0.135 $X2=0.297 $Y2=0.135
r6 9 8 16.4967 $w=2.1e-08 $l=4.85e-08 $layer=Gate_1 $thickness=5.6e-08 $X=0.297
+ $Y=0.2025 $X2=0.297 $Y2=0.154
r7 7 8 6.6497 $w=2.04211e-08 $l=1.9e-08 $layer=Gate_1 $thickness=5.6e-08
+ $X=0.297 $Y=0.135 $X2=0.297 $Y2=0.154
r8 6 7 6.6497 $w=2.04211e-08 $l=1.9e-08 $layer=Gate_1 $thickness=5.6e-08
+ $X=0.297 $Y=0.116 $X2=0.297 $Y2=0.135
r9 5 6 16.4967 $w=2.1e-08 $l=4.85e-08 $layer=Gate_1 $thickness=5.6e-08 $X=0.297
+ $Y=0.0675 $X2=0.297 $Y2=0.116
r10 5 3 14.6259 $w=2.1e-08 $l=4.3e-08 $layer=Gate_1 $thickness=5.6e-08 $X=0.297
+ $Y=0.0675 $X2=0.297 $Y2=0.0245
.ends

.subckt PM_AO333x1_ASAP7_75t_R%A2 vss 15 5 9 4 3
c1 1 vss 0.00438814f $X=0.189 $Y=0.135
c2 3 vss 0.121254f $X=0.189 $Y=0.0245
c3 4 vss 0.00694196f $X=0.189 $Y=0.0935
r1 15 14 5.01358 $w=1.3e-08 $l=2.15e-08 $layer=M1 $thickness=3.6e-08 $X=0.1875
+ $Y=0.1865 $X2=0.189 $Y2=0.165
r2 13 14 6.99569 $w=1.3e-08 $l=3e-08 $layer=M1 $thickness=3.6e-08 $X=0.189
+ $Y=0.135 $X2=0.189 $Y2=0.165
r3 12 13 4.4306 $w=1.3e-08 $l=1.9e-08 $layer=M1 $thickness=3.6e-08 $X=0.189
+ $Y=0.116 $X2=0.189 $Y2=0.135
r4 4 12 5.24677 $w=1.3e-08 $l=2.25e-08 $layer=M1 $thickness=3.6e-08 $X=0.189
+ $Y=0.0935 $X2=0.189 $Y2=0.116
r5 1 7 10.4265 $w=1.765e-08 $layer=LIG $thickness=5.2e-08 $X=0.189 $Y=0.135
+ $X2=0.189 $Y2=0.135
r6 1 13 19.3796 $a=3.24e-16 $layer=V0LIG $X=0.189 $Y=0.135 $X2=0.189 $Y2=0.135
r7 9 8 16.4967 $w=2.1e-08 $l=4.85e-08 $layer=Gate_1 $thickness=5.6e-08 $X=0.189
+ $Y=0.2025 $X2=0.189 $Y2=0.154
r8 7 8 6.6497 $w=2.04211e-08 $l=1.9e-08 $layer=Gate_1 $thickness=5.6e-08
+ $X=0.189 $Y=0.135 $X2=0.189 $Y2=0.154
r9 6 7 6.6497 $w=2.04211e-08 $l=1.9e-08 $layer=Gate_1 $thickness=5.6e-08
+ $X=0.189 $Y=0.116 $X2=0.189 $Y2=0.135
r10 5 6 16.4967 $w=2.1e-08 $l=4.85e-08 $layer=Gate_1 $thickness=5.6e-08
+ $X=0.189 $Y=0.0675 $X2=0.189 $Y2=0.116
r11 5 3 14.6259 $w=2.1e-08 $l=4.3e-08 $layer=Gate_1 $thickness=5.6e-08 $X=0.189
+ $Y=0.0675 $X2=0.189 $Y2=0.0245
.ends

.subckt PM_AO333x1_ASAP7_75t_R%B1 vss 15 5 9 4 3
c1 1 vss 0.00619768f $X=0.405 $Y=0.135
c2 3 vss 0.139845f $X=0.405 $Y=0.0245
c3 4 vss 0.00590532f $X=0.405 $Y=0.098
r1 15 14 1.39914 $w=1.3e-08 $l=6e-09 $layer=M1 $thickness=3.6e-08 $X=0.4085
+ $Y=0.1555 $X2=0.405 $Y2=0.1495
r2 13 14 3.38125 $w=1.3e-08 $l=1.45e-08 $layer=M1 $thickness=3.6e-08 $X=0.405
+ $Y=0.135 $X2=0.405 $Y2=0.1495
r3 4 13 8.62802 $w=1.3e-08 $l=3.7e-08 $layer=M1 $thickness=3.6e-08 $X=0.405
+ $Y=0.098 $X2=0.405 $Y2=0.135
r4 1 7 6.54019 $w=2.09524e-08 $layer=Gate_1 $thickness=5.21905e-08 $X=0.405
+ $Y=0.135 $X2=0.405 $Y2=0.135
r5 1 13 19.3796 $a=3.24e-16 $layer=V0LIG $X=0.405 $Y=0.135 $X2=0.405 $Y2=0.135
r6 9 8 16.4967 $w=2.1e-08 $l=4.85e-08 $layer=Gate_1 $thickness=5.6e-08 $X=0.405
+ $Y=0.2025 $X2=0.405 $Y2=0.154
r7 7 8 6.6497 $w=2.04211e-08 $l=1.9e-08 $layer=Gate_1 $thickness=5.6e-08
+ $X=0.405 $Y=0.135 $X2=0.405 $Y2=0.154
r8 6 7 6.6497 $w=2.04211e-08 $l=1.9e-08 $layer=Gate_1 $thickness=5.6e-08
+ $X=0.405 $Y=0.116 $X2=0.405 $Y2=0.135
r9 5 6 16.4967 $w=2.1e-08 $l=4.85e-08 $layer=Gate_1 $thickness=5.6e-08 $X=0.405
+ $Y=0.0675 $X2=0.405 $Y2=0.116
r10 5 3 14.6259 $w=2.1e-08 $l=4.3e-08 $layer=Gate_1 $thickness=5.6e-08 $X=0.405
+ $Y=0.0675 $X2=0.405 $Y2=0.0245
.ends

.subckt PM_AO333x1_ASAP7_75t_R%C3 vss 13 5 9 3 4
c1 1 vss 0.00464933f $X=0.459 $Y=0.135
c2 3 vss 0.103378f $X=0.459 $Y=0.0245
c3 4 vss 0.00783715f $X=0.459 $Y=0.0765
r1 14 15 6.99569 $w=1.3e-08 $l=3e-08 $layer=M1 $thickness=3.6e-08 $X=0.459
+ $Y=0.105 $X2=0.459 $Y2=0.135
r2 13 14 5.01358 $w=1.3e-08 $l=2.15e-08 $layer=M1 $thickness=3.6e-08 $X=0.4565
+ $Y=0.0835 $X2=0.459 $Y2=0.105
r3 13 4 1.63233 $w=1.3e-08 $l=7e-09 $layer=M1 $thickness=3.6e-08 $X=0.4565
+ $Y=0.0835 $X2=0.459 $Y2=0.0765
r4 1 7 6.54019 $w=2.09524e-08 $layer=Gate_1 $thickness=5.21905e-08 $X=0.459
+ $Y=0.135 $X2=0.459 $Y2=0.135
r5 1 15 19.3796 $a=3.24e-16 $layer=V0LIG $X=0.459 $Y=0.135 $X2=0.459 $Y2=0.135
r6 9 8 16.4967 $w=2.1e-08 $l=4.85e-08 $layer=Gate_1 $thickness=5.6e-08 $X=0.459
+ $Y=0.2025 $X2=0.459 $Y2=0.154
r7 7 8 6.6497 $w=2.04211e-08 $l=1.9e-08 $layer=Gate_1 $thickness=5.6e-08
+ $X=0.459 $Y=0.135 $X2=0.459 $Y2=0.154
r8 6 7 6.6497 $w=2.04211e-08 $l=1.9e-08 $layer=Gate_1 $thickness=5.6e-08
+ $X=0.459 $Y=0.116 $X2=0.459 $Y2=0.135
r9 5 6 16.4967 $w=2.1e-08 $l=4.85e-08 $layer=Gate_1 $thickness=5.6e-08 $X=0.459
+ $Y=0.0675 $X2=0.459 $Y2=0.116
r10 5 3 14.6259 $w=2.1e-08 $l=4.3e-08 $layer=Gate_1 $thickness=5.6e-08 $X=0.459
+ $Y=0.0675 $X2=0.459 $Y2=0.0245
.ends

.subckt PM_AO333x1_ASAP7_75t_R%C2 vss 15 5 9 3 4
c1 1 vss 0.00334851f $X=0.513 $Y=0.135
c2 3 vss 0.0833999f $X=0.513 $Y=0.0245
c3 4 vss 0.00728347f $X=0.513 $Y=0.098
r1 15 14 1.16595 $w=1.3e-08 $l=5e-09 $layer=M1 $thickness=3.6e-08 $X=0.5125
+ $Y=0.1535 $X2=0.513 $Y2=0.1485
r2 13 14 3.14806 $w=1.3e-08 $l=1.35e-08 $layer=M1 $thickness=3.6e-08 $X=0.513
+ $Y=0.135 $X2=0.513 $Y2=0.1485
r3 4 13 8.62802 $w=1.3e-08 $l=3.7e-08 $layer=M1 $thickness=3.6e-08 $X=0.513
+ $Y=0.098 $X2=0.513 $Y2=0.135
r4 1 7 6.54019 $w=2.09524e-08 $layer=Gate_1 $thickness=5.21905e-08 $X=0.513
+ $Y=0.135 $X2=0.513 $Y2=0.135
r5 1 13 19.3796 $a=3.24e-16 $layer=V0LIG $X=0.513 $Y=0.135 $X2=0.513 $Y2=0.135
r6 9 8 16.4967 $w=2.1e-08 $l=4.85e-08 $layer=Gate_1 $thickness=5.6e-08 $X=0.513
+ $Y=0.2025 $X2=0.513 $Y2=0.154
r7 7 8 6.6497 $w=2.04211e-08 $l=1.9e-08 $layer=Gate_1 $thickness=5.6e-08
+ $X=0.513 $Y=0.135 $X2=0.513 $Y2=0.154
r8 6 7 6.6497 $w=2.04211e-08 $l=1.9e-08 $layer=Gate_1 $thickness=5.6e-08
+ $X=0.513 $Y=0.116 $X2=0.513 $Y2=0.135
r9 5 6 16.4967 $w=2.1e-08 $l=4.85e-08 $layer=Gate_1 $thickness=5.6e-08 $X=0.513
+ $Y=0.0675 $X2=0.513 $Y2=0.116
r10 5 3 14.6259 $w=2.1e-08 $l=4.3e-08 $layer=Gate_1 $thickness=5.6e-08 $X=0.513
+ $Y=0.0675 $X2=0.513 $Y2=0.0245
.ends

.subckt PM_AO333x1_ASAP7_75t_R%C1 vss 15 5 11 3 1 4
c1 1 vss 0.002871f $X=0.567 $Y=0.135
c2 3 vss 0.0708596f $X=0.567 $Y=0.0245
c3 4 vss 0.00590281f $X=0.567 $Y=0.0755
r1 16 17 7.22888 $w=1.3e-08 $l=3.1e-08 $layer=M1 $thickness=3.6e-08 $X=0.567
+ $Y=0.104 $X2=0.567 $Y2=0.135
r2 15 16 5.24677 $w=1.3e-08 $l=2.25e-08 $layer=M1 $thickness=3.6e-08 $X=0.5715
+ $Y=0.0815 $X2=0.567 $Y2=0.104
r3 15 4 1.39914 $w=1.3e-08 $l=6e-09 $layer=M1 $thickness=3.6e-08 $X=0.5715
+ $Y=0.0815 $X2=0.567 $Y2=0.0755
r4 1 8 6.54019 $w=2.09524e-08 $layer=Gate_1 $thickness=5.21905e-08 $X=0.567
+ $Y=0.135 $X2=0.567 $Y2=0.135
r5 1 17 19.3796 $a=3.24e-16 $layer=V0LIG $X=0.567 $Y=0.135 $X2=0.567 $Y2=0.135
r6 11 10 14.6259 $w=2.1e-08 $l=4.3e-08 $layer=Gate_1 $thickness=5.6e-08
+ $X=0.567 $Y=0.2025 $X2=0.567 $Y2=0.1595
r7 9 10 2.7211 $w=2.1e-08 $l=8e-09 $layer=Gate_1 $thickness=5.6e-08 $X=0.567
+ $Y=0.1515 $X2=0.567 $Y2=0.1595
r8 8 9 5.79936 $w=2.03333e-08 $l=1.65e-08 $layer=Gate_1 $thickness=5.6e-08
+ $X=0.567 $Y=0.135 $X2=0.567 $Y2=0.1515
r9 7 8 5.79936 $w=2.03333e-08 $l=1.65e-08 $layer=Gate_1 $thickness=5.6e-08
+ $X=0.567 $Y=0.1185 $X2=0.567 $Y2=0.135
r10 6 7 2.7211 $w=2.1e-08 $l=8e-09 $layer=Gate_1 $thickness=5.6e-08 $X=0.567
+ $Y=0.1105 $X2=0.567 $Y2=0.1185
r11 5 6 14.6259 $w=2.1e-08 $l=4.3e-08 $layer=Gate_1 $thickness=5.6e-08 $X=0.567
+ $Y=0.0675 $X2=0.567 $Y2=0.1105
r12 5 3 14.6259 $w=2.1e-08 $l=4.3e-08 $layer=Gate_1 $thickness=5.6e-08 $X=0.567
+ $Y=0.0675 $X2=0.567 $Y2=0.0245
.ends

.subckt PM_AO333x1_ASAP7_75t_R%Y vss 20 14 28 7 12 11 8
c1 7 vss 0.0468249f $X=0.056 $Y=0.0675
c2 8 vss 0.0481039f $X=0.056 $Y=0.2025
c3 9 vss 0.00280359f $X=0.027 $Y=0.036
c4 10 vss 0.00661896f $X=0.027 $Y=0.234
c5 11 vss 0.00573454f $X=0.027 $Y=0.054
c6 12 vss 0.00432815f $X=0.0405 $Y=0.036
r1 28 27 0.0308642 $w=8.1e-08 $l=2.5e-09 $layer=P_src_drn $thickness=1e-09
+ $X=0.0713 $Y=0.2025 $X2=0.0685 $Y2=0.2025
r2 8 27 0.154321 $w=8.1e-08 $l=1.25e-08 $layer=P_src_drn $thickness=1e-09
+ $X=0.056 $Y=0.2025 $X2=0.0685 $Y2=0.2025
r3 8 25 19.3796 $a=3.24e-16 $layer=V0LISD $X=0.056 $Y=0.2025 $X2=0.054 $Y2=0.234
r4 24 25 3.14806 $w=1.3e-08 $l=1.35e-08 $layer=M1 $thickness=3.6e-08 $X=0.0405
+ $Y=0.234 $X2=0.054 $Y2=0.234
r5 10 23 3.83327 $w=1.5093e-08 $l=2.15e-08 $layer=M1 $thickness=3.6e-08
+ $X=0.027 $Y=0.234 $X2=0.027 $Y2=0.2125
r6 10 24 1.96775 $w=1.63333e-08 $l=1.35e-08 $layer=M1 $thickness=3.6e-08
+ $X=0.027 $Y=0.234 $X2=0.0405 $Y2=0.234
r7 22 23 8.51143 $w=1.3e-08 $l=3.65e-08 $layer=M1 $thickness=3.6e-08 $X=0.027
+ $Y=0.176 $X2=0.027 $Y2=0.2125
r8 21 22 6.99569 $w=1.3e-08 $l=3e-08 $layer=M1 $thickness=3.6e-08 $X=0.027
+ $Y=0.146 $X2=0.027 $Y2=0.176
r9 20 21 1.51573 $w=1.3e-08 $l=6.5e-09 $layer=M1 $thickness=3.6e-08 $X=0.0245
+ $Y=0.1395 $X2=0.027 $Y2=0.146
r10 20 19 8.97781 $w=1.3e-08 $l=3.85e-08 $layer=M1 $thickness=3.6e-08 $X=0.0245
+ $Y=0.1395 $X2=0.027 $Y2=0.101
r11 11 19 10.9599 $w=1.3e-08 $l=4.7e-08 $layer=M1 $thickness=3.6e-08 $X=0.027
+ $Y=0.054 $X2=0.027 $Y2=0.101
r12 9 12 1.49895 $w=1.63333e-08 $l=1.35e-08 $layer=M1 $thickness=3.6e-08
+ $X=0.027 $Y=0.036 $X2=0.0405 $Y2=0.036
r13 9 11 2.5483 $w=1.79e-08 $l=1.8e-08 $layer=M1 $thickness=3.6e-08 $X=0.027
+ $Y=0.036 $X2=0.027 $Y2=0.054
r14 12 15 3.14806 $w=1.3e-08 $l=1.35e-08 $layer=M1 $thickness=3.6e-08 $X=0.0405
+ $Y=0.036 $X2=0.054 $Y2=0.036
r15 7 15 19.3796 $a=3.24e-16 $layer=V0LISD $X=0.056 $Y=0.0675 $X2=0.054
+ $Y2=0.036
r16 14 13 0.0308642 $w=8.1e-08 $l=2.5e-09 $layer=N_src_drn $thickness=1e-09
+ $X=0.0713 $Y=0.0675 $X2=0.0685 $Y2=0.0675
r17 7 13 0.154321 $w=8.1e-08 $l=1.25e-08 $layer=N_src_drn $thickness=1e-09
+ $X=0.056 $Y=0.0675 $X2=0.0685 $Y2=0.0675
.ends

.subckt PM_AO333x1_ASAP7_75t_R%3 vss 31 37 67 68 74 81 84 85 26 22 1 25 15 16 3
+ 28 4 18 17 5 6 30 19 27 20 21
c1 1 vss 0.00371252f $X=0.081 $Y=0.135
c2 3 vss 0.00502027f $X=0.27 $Y=0.0675
c3 4 vss 0.0118816f $X=0.486 $Y=0.2025
c4 5 vss 0.00641596f $X=0.594 $Y=0.0675
c5 6 vss 0.00932616f $X=0.594 $Y=0.2025
c6 15 vss 0.0811836f $X=0.081 $Y=0.0245
c7 16 vss 0.00335314f $X=0.2555 $Y=0.0675
c8 17 vss 0.0376967f $X=0.5795 $Y=0.0675
c9 18 vss 0.00527425f $X=0.4715 $Y=0.2025
c10 19 vss 0.0385364f $X=0.5795 $Y=0.2025
c11 20 vss 0.000836192f $X=0.081 $Y=0.072
c12 21 vss 0.00284981f $X=0.135 $Y=0.036
c13 22 vss 0.00065797f $X=0.135 $Y=0.0665
c14 23 vss 0.00286159f $X=0.621 $Y=0.036
c15 24 vss 0.00294623f $X=0.621 $Y=0.234
c16 25 vss 0.00154385f $X=0.081 $Y=0.116
c17 26 vss 0.0014536f $X=0.108 $Y=0.072
c18 27 vss 0.000609456f $X=0.135 $Y=0.054
c19 28 vss 0.0404657f $X=0.146 $Y=0.036
c20 29 vss 0.0202837f $X=0.5805 $Y=0.234
c21 30 vss 0.00666306f $X=0.621 $Y=0.0575
r1 85 83 0.0308642 $w=8.1e-08 $l=2.5e-09 $layer=P_src_drn $thickness=1e-09
+ $X=0.5033 $Y=0.2025 $X2=0.5005 $Y2=0.2025
r2 4 83 0.179012 $w=8.1e-08 $l=1.45e-08 $layer=P_src_drn $thickness=1e-09
+ $X=0.486 $Y=0.2025 $X2=0.5005 $Y2=0.2025
r3 18 4 0.179012 $w=8.1e-08 $l=1.45e-08 $layer=P_src_drn $thickness=1e-09
+ $X=0.4715 $Y=0.2025 $X2=0.486 $Y2=0.2025
r4 84 18 0.0308642 $w=8.1e-08 $l=2.5e-09 $layer=P_src_drn $thickness=1e-09
+ $X=0.4686 $Y=0.2025 $X2=0.4715 $Y2=0.2025
r5 19 6 0.154321 $w=8.1e-08 $l=1.25e-08 $layer=P_src_drn $thickness=1e-09
+ $X=0.5795 $Y=0.2025 $X2=0.594 $Y2=0.2025
r6 81 19 0.0308642 $w=8.1e-08 $l=2.5e-09 $layer=P_src_drn $thickness=1e-09
+ $X=0.5766 $Y=0.2025 $X2=0.5795 $Y2=0.2025
r7 4 78 19.3796 $a=3.24e-16 $layer=V0LISD $X=0.486 $Y=0.2025 $X2=0.486 $Y2=0.234
r8 6 75 19.3796 $a=3.24e-16 $layer=V0LISD $X=0.594 $Y=0.2025 $X2=0.594 $Y2=0.234
r9 78 79 11.5429 $w=1.3e-08 $l=4.95e-08 $layer=M1 $thickness=3.6e-08 $X=0.486
+ $Y=0.234 $X2=0.5355 $Y2=0.234
r10 75 76 3.14806 $w=1.3e-08 $l=1.35e-08 $layer=M1 $thickness=3.6e-08 $X=0.594
+ $Y=0.234 $X2=0.6075 $Y2=0.234
r11 29 75 3.14806 $w=1.3e-08 $l=1.35e-08 $layer=M1 $thickness=3.6e-08 $X=0.5805
+ $Y=0.234 $X2=0.594 $Y2=0.234
r12 29 79 10.4935 $w=1.3e-08 $l=4.5e-08 $layer=M1 $thickness=3.6e-08 $X=0.5805
+ $Y=0.234 $X2=0.5355 $Y2=0.234
r13 24 72 2.5483 $w=1.79e-08 $l=1.8e-08 $layer=M1 $thickness=3.6e-08 $X=0.621
+ $Y=0.234 $X2=0.621 $Y2=0.216
r14 24 76 1.49895 $w=1.63333e-08 $l=1.35e-08 $layer=M1 $thickness=3.6e-08
+ $X=0.621 $Y=0.234 $X2=0.6075 $Y2=0.234
r15 17 5 0.154321 $w=8.1e-08 $l=1.25e-08 $layer=N_src_drn $thickness=1e-09
+ $X=0.5795 $Y=0.0675 $X2=0.594 $Y2=0.0675
r16 74 17 0.0308642 $w=8.1e-08 $l=2.5e-09 $layer=N_src_drn $thickness=1e-09
+ $X=0.5766 $Y=0.0675 $X2=0.5795 $Y2=0.0675
r17 71 72 4.19742 $w=1.3e-08 $l=1.8e-08 $layer=M1 $thickness=3.6e-08 $X=0.621
+ $Y=0.198 $X2=0.621 $Y2=0.216
r18 70 71 5.01358 $w=1.3e-08 $l=2.15e-08 $layer=M1 $thickness=3.6e-08 $X=0.621
+ $Y=0.1765 $X2=0.621 $Y2=0.198
r19 69 70 13.8748 $w=1.3e-08 $l=5.95e-08 $layer=M1 $thickness=3.6e-08 $X=0.621
+ $Y=0.117 $X2=0.621 $Y2=0.1765
r20 30 69 13.8748 $w=1.3e-08 $l=5.95e-08 $layer=M1 $thickness=3.6e-08 $X=0.621
+ $Y=0.0575 $X2=0.621 $Y2=0.117
r21 68 66 0.0308642 $w=8.1e-08 $l=2.5e-09 $layer=N_src_drn $thickness=1e-09
+ $X=0.2873 $Y=0.0675 $X2=0.2845 $Y2=0.0675
r22 3 66 0.179012 $w=8.1e-08 $l=1.45e-08 $layer=N_src_drn $thickness=1e-09
+ $X=0.27 $Y=0.0675 $X2=0.2845 $Y2=0.0675
r23 16 3 0.179012 $w=8.1e-08 $l=1.45e-08 $layer=N_src_drn $thickness=1e-09
+ $X=0.2555 $Y=0.0675 $X2=0.27 $Y2=0.0675
r24 67 16 0.0308642 $w=8.1e-08 $l=2.5e-09 $layer=N_src_drn $thickness=1e-09
+ $X=0.2526 $Y=0.0675 $X2=0.2555 $Y2=0.0675
r25 5 63 19.3796 $a=3.24e-16 $layer=V0LISD $X=0.594 $Y=0.0675 $X2=0.594
+ $Y2=0.036
r26 23 64 1.49895 $w=1.63333e-08 $l=1.35e-08 $layer=M1 $thickness=3.6e-08
+ $X=0.621 $Y=0.036 $X2=0.6075 $Y2=0.036
r27 23 30 3.36447 $w=1.71023e-08 $l=2.15e-08 $layer=M1 $thickness=3.6e-08
+ $X=0.621 $Y=0.036 $X2=0.621 $Y2=0.0575
r28 3 48 19.3796 $a=3.24e-16 $layer=V0LISD $X=0.27 $Y=0.0675 $X2=0.27 $Y2=0.036
r29 63 64 3.14806 $w=1.3e-08 $l=1.35e-08 $layer=M1 $thickness=3.6e-08 $X=0.594
+ $Y=0.036 $X2=0.6075 $Y2=0.036
r30 62 63 3.14806 $w=1.3e-08 $l=1.35e-08 $layer=M1 $thickness=3.6e-08 $X=0.5805
+ $Y=0.036 $X2=0.594 $Y2=0.036
r31 61 62 3.14806 $w=1.3e-08 $l=1.35e-08 $layer=M1 $thickness=3.6e-08 $X=0.567
+ $Y=0.036 $X2=0.5805 $Y2=0.036
r32 60 61 6.29612 $w=1.3e-08 $l=2.7e-08 $layer=M1 $thickness=3.6e-08 $X=0.54
+ $Y=0.036 $X2=0.567 $Y2=0.036
r33 59 60 6.29612 $w=1.3e-08 $l=2.7e-08 $layer=M1 $thickness=3.6e-08 $X=0.513
+ $Y=0.036 $X2=0.54 $Y2=0.036
r34 58 59 6.29612 $w=1.3e-08 $l=2.7e-08 $layer=M1 $thickness=3.6e-08 $X=0.486
+ $Y=0.036 $X2=0.513 $Y2=0.036
r35 57 58 6.29612 $w=1.3e-08 $l=2.7e-08 $layer=M1 $thickness=3.6e-08 $X=0.459
+ $Y=0.036 $X2=0.486 $Y2=0.036
r36 56 57 6.29612 $w=1.3e-08 $l=2.7e-08 $layer=M1 $thickness=3.6e-08 $X=0.432
+ $Y=0.036 $X2=0.459 $Y2=0.036
r37 55 56 6.29612 $w=1.3e-08 $l=2.7e-08 $layer=M1 $thickness=3.6e-08 $X=0.405
+ $Y=0.036 $X2=0.432 $Y2=0.036
r38 54 55 6.29612 $w=1.3e-08 $l=2.7e-08 $layer=M1 $thickness=3.6e-08 $X=0.378
+ $Y=0.036 $X2=0.405 $Y2=0.036
r39 53 54 6.29612 $w=1.3e-08 $l=2.7e-08 $layer=M1 $thickness=3.6e-08 $X=0.351
+ $Y=0.036 $X2=0.378 $Y2=0.036
r40 52 53 5.82974 $w=1.3e-08 $l=2.5e-08 $layer=M1 $thickness=3.6e-08 $X=0.326
+ $Y=0.036 $X2=0.351 $Y2=0.036
r41 51 52 4.19742 $w=1.3e-08 $l=1.8e-08 $layer=M1 $thickness=3.6e-08 $X=0.308
+ $Y=0.036 $X2=0.326 $Y2=0.036
r42 50 51 2.56509 $w=1.3e-08 $l=1.1e-08 $layer=M1 $thickness=3.6e-08 $X=0.297
+ $Y=0.036 $X2=0.308 $Y2=0.036
r43 49 50 3.14806 $w=1.3e-08 $l=1.35e-08 $layer=M1 $thickness=3.6e-08 $X=0.2835
+ $Y=0.036 $X2=0.297 $Y2=0.036
r44 48 49 3.14806 $w=1.3e-08 $l=1.35e-08 $layer=M1 $thickness=3.6e-08 $X=0.27
+ $Y=0.036 $X2=0.2835 $Y2=0.036
r45 47 48 3.14806 $w=1.3e-08 $l=1.35e-08 $layer=M1 $thickness=3.6e-08 $X=0.2565
+ $Y=0.036 $X2=0.27 $Y2=0.036
r46 46 47 3.14806 $w=1.3e-08 $l=1.35e-08 $layer=M1 $thickness=3.6e-08 $X=0.243
+ $Y=0.036 $X2=0.2565 $Y2=0.036
r47 45 46 6.29612 $w=1.3e-08 $l=2.7e-08 $layer=M1 $thickness=3.6e-08 $X=0.216
+ $Y=0.036 $X2=0.243 $Y2=0.036
r48 44 45 6.29612 $w=1.3e-08 $l=2.7e-08 $layer=M1 $thickness=3.6e-08 $X=0.189
+ $Y=0.036 $X2=0.216 $Y2=0.036
r49 43 44 5.82974 $w=1.3e-08 $l=2.5e-08 $layer=M1 $thickness=3.6e-08 $X=0.164
+ $Y=0.036 $X2=0.189 $Y2=0.036
r50 28 43 4.19742 $w=1.3e-08 $l=1.8e-08 $layer=M1 $thickness=3.6e-08 $X=0.146
+ $Y=0.036 $X2=0.164 $Y2=0.036
r51 21 27 2.5483 $w=1.79e-08 $l=1.8e-08 $layer=M1 $thickness=3.6e-08 $X=0.135
+ $Y=0.036 $X2=0.135 $Y2=0.054
r52 21 28 0.915974 $w=1.70909e-08 $l=1.1e-08 $layer=M1 $thickness=3.6e-08
+ $X=0.135 $Y=0.036 $X2=0.146 $Y2=0.036
r53 22 26 4.55457 $w=1.3814e-08 $l=2.75545e-08 $layer=M1 $thickness=3.6e-08
+ $X=0.135 $Y=0.0665 $X2=0.108 $Y2=0.072
r54 22 27 2.45586 $w=1.44e-08 $l=1.25e-08 $layer=M1 $thickness=3.6e-08 $X=0.135
+ $Y=0.0665 $X2=0.135 $Y2=0.054
r55 20 41 3.36447 $w=1.71023e-08 $l=2.15e-08 $layer=M1 $thickness=3.6e-08
+ $X=0.081 $Y=0.072 $X2=0.081 $Y2=0.0935
r56 20 26 4.64701 $w=1.46667e-08 $l=2.7e-08 $layer=M1 $thickness=3.6e-08
+ $X=0.081 $Y=0.072 $X2=0.108 $Y2=0.072
r57 25 39 4.43061 $w=1.3e-08 $l=1.9e-08 $layer=M1 $thickness=3.6e-08 $X=0.081
+ $Y=0.116 $X2=0.081 $Y2=0.135
r58 25 41 5.24677 $w=1.3e-08 $l=2.25e-08 $layer=M1 $thickness=3.6e-08 $X=0.081
+ $Y=0.116 $X2=0.081 $Y2=0.0935
r59 1 34 10.4265 $w=1.765e-08 $layer=LIG $thickness=5.2e-08 $X=0.081 $Y=0.135
+ $X2=0.081 $Y2=0.135
r60 1 39 19.3796 $a=3.24e-16 $layer=V0LIG $X=0.081 $Y=0.135 $X2=0.081 $Y2=0.135
r61 37 36 14.6259 $w=2.1e-08 $l=4.3e-08 $layer=Gate_1 $thickness=5.6e-08
+ $X=0.081 $Y=0.2025 $X2=0.081 $Y2=0.1595
r62 35 36 2.7211 $w=2.1e-08 $l=8e-09 $layer=Gate_1 $thickness=5.6e-08 $X=0.081
+ $Y=0.1515 $X2=0.081 $Y2=0.1595
r63 34 35 5.79936 $w=2.03333e-08 $l=1.65e-08 $layer=Gate_1 $thickness=5.6e-08
+ $X=0.081 $Y=0.135 $X2=0.081 $Y2=0.1515
r64 33 34 5.79936 $w=2.03333e-08 $l=1.65e-08 $layer=Gate_1 $thickness=5.6e-08
+ $X=0.081 $Y=0.1185 $X2=0.081 $Y2=0.135
r65 32 33 2.7211 $w=2.1e-08 $l=8e-09 $layer=Gate_1 $thickness=5.6e-08 $X=0.081
+ $Y=0.1105 $X2=0.081 $Y2=0.1185
r66 31 32 14.6259 $w=2.1e-08 $l=4.3e-08 $layer=Gate_1 $thickness=5.6e-08
+ $X=0.081 $Y=0.0675 $X2=0.081 $Y2=0.1105
r67 31 15 14.6259 $w=2.1e-08 $l=4.3e-08 $layer=Gate_1 $thickness=5.6e-08
+ $X=0.081 $Y=0.0675 $X2=0.081 $Y2=0.0245
.ends

.subckt PM_AO333x1_ASAP7_75t_R%A3 vss 13 5 9 3 4
c1 1 vss 0.00585835f $X=0.135 $Y=0.135
c2 3 vss 0.139937f $X=0.135 $Y=0.0245
c3 4 vss 0.00671867f $X=0.135 $Y=0.116
r1 13 12 0.582974 $w=1.3e-08 $l=2.5e-09 $layer=M1 $thickness=3.6e-08 $X=0.1365
+ $Y=0.1485 $X2=0.135 $Y2=0.146
r2 11 12 2.56509 $w=1.3e-08 $l=1.1e-08 $layer=M1 $thickness=3.6e-08 $X=0.135
+ $Y=0.135 $X2=0.135 $Y2=0.146
r3 4 11 4.43061 $w=1.3e-08 $l=1.9e-08 $layer=M1 $thickness=3.6e-08 $X=0.135
+ $Y=0.116 $X2=0.135 $Y2=0.135
r4 1 7 10.4265 $w=1.765e-08 $layer=LIG $thickness=5.2e-08 $X=0.135 $Y=0.135
+ $X2=0.135 $Y2=0.135
r5 1 11 19.3796 $a=3.24e-16 $layer=V0LIG $X=0.135 $Y=0.135 $X2=0.135 $Y2=0.135
r6 9 8 16.4967 $w=2.1e-08 $l=4.85e-08 $layer=Gate_1 $thickness=5.6e-08 $X=0.135
+ $Y=0.2025 $X2=0.135 $Y2=0.154
r7 7 8 6.6497 $w=2.04211e-08 $l=1.9e-08 $layer=Gate_1 $thickness=5.6e-08
+ $X=0.135 $Y=0.135 $X2=0.135 $Y2=0.154
r8 6 7 6.6497 $w=2.04211e-08 $l=1.9e-08 $layer=Gate_1 $thickness=5.6e-08
+ $X=0.135 $Y=0.116 $X2=0.135 $Y2=0.135
r9 5 6 16.4967 $w=2.1e-08 $l=4.85e-08 $layer=Gate_1 $thickness=5.6e-08 $X=0.135
+ $Y=0.0675 $X2=0.135 $Y2=0.116
r10 5 3 14.6259 $w=2.1e-08 $l=4.3e-08 $layer=Gate_1 $thickness=5.6e-08 $X=0.135
+ $Y=0.0675 $X2=0.135 $Y2=0.0245
.ends

.subckt PM_AO333x1_ASAP7_75t_R%B2 vss 13 5 9 4 3
c1 1 vss 0.00478948f $X=0.351 $Y=0.135
c2 3 vss 0.120862f $X=0.351 $Y=0.0245
c3 4 vss 0.00523927f $X=0.351 $Y=0.077
r1 14 15 6.8791 $w=1.3e-08 $l=2.95e-08 $layer=M1 $thickness=3.6e-08 $X=0.351
+ $Y=0.1055 $X2=0.351 $Y2=0.135
r2 13 14 4.89699 $w=1.3e-08 $l=2.1e-08 $layer=M1 $thickness=3.6e-08 $X=0.3505
+ $Y=0.0845 $X2=0.351 $Y2=0.1055
r3 13 4 1.74892 $w=1.3e-08 $l=7.5e-09 $layer=M1 $thickness=3.6e-08 $X=0.3505
+ $Y=0.0845 $X2=0.351 $Y2=0.077
r4 1 7 6.54019 $w=2.09524e-08 $layer=Gate_1 $thickness=5.21905e-08 $X=0.351
+ $Y=0.135 $X2=0.351 $Y2=0.135
r5 1 15 19.3796 $a=3.24e-16 $layer=V0LIG $X=0.351 $Y=0.135 $X2=0.351 $Y2=0.135
r6 9 8 16.4967 $w=2.1e-08 $l=4.85e-08 $layer=Gate_1 $thickness=5.6e-08 $X=0.351
+ $Y=0.2025 $X2=0.351 $Y2=0.154
r7 7 8 6.6497 $w=2.04211e-08 $l=1.9e-08 $layer=Gate_1 $thickness=5.6e-08
+ $X=0.351 $Y=0.135 $X2=0.351 $Y2=0.154
r8 6 7 6.6497 $w=2.04211e-08 $l=1.9e-08 $layer=Gate_1 $thickness=5.6e-08
+ $X=0.351 $Y=0.116 $X2=0.351 $Y2=0.135
r9 5 6 16.4967 $w=2.1e-08 $l=4.85e-08 $layer=Gate_1 $thickness=5.6e-08 $X=0.351
+ $Y=0.0675 $X2=0.351 $Y2=0.116
r10 5 3 14.6259 $w=2.1e-08 $l=4.3e-08 $layer=Gate_1 $thickness=5.6e-08 $X=0.351
+ $Y=0.0675 $X2=0.351 $Y2=0.0245
.ends

* End of included file AO333x1_ASAP7_75t_R.pex.sp.pex

*
.subckt AO333x1_ASAP7_75t_CUSTOM_4_25_0_7 VSS VDD A3 A2 A1 B3 B2 B1 C3 C2 C1 Y
*
* VSS VSS
* VDD VDD
* A3 A3
* A2 A2
* A1 A1
* B3 B3
* B2 B2
* B1 B1
* C3 C3
* C2 C2
* C1 C1
* Y Y
*
*

M0 VSS N_M0_g N_M0_s VSS nmos_rvt L=2e-08 W=8.1e-08 nfin=3 $X=0.071 $Y=0.027
M1 noxref_16 N_M1_g VSS VSS nmos_rvt L=2e-08 W=8.1e-08 nfin=3 $X=0.125 $Y=0.027
M2 noxref_17 N_M2_g noxref_16 VSS nmos_rvt L=2e-08 W=8.1e-08 nfin=3 $X=0.179
+ $Y=0.027
M3 N_M3_d N_M3_g noxref_17 VSS nmos_rvt L=2e-08 W=8.1e-08 nfin=3 $X=0.233
+ $Y=0.027
M4 noxref_18 N_M4_g N_M4_s VSS nmos_rvt L=2e-08 W=8.1e-08 nfin=3 $X=0.287
+ $Y=0.027
M5 noxref_19 N_M5_g noxref_18 VSS nmos_rvt L=2e-08 W=8.1e-08 nfin=3 $X=0.341
+ $Y=0.027
M6 VSS N_M6_g noxref_19 VSS nmos_rvt L=2e-08 W=8.1e-08 nfin=3 $X=0.395 $Y=0.027
M7 noxref_20 N_M7_g VSS VSS nmos_rvt L=2e-08 W=8.1e-08 nfin=3 $X=0.449 $Y=0.027
M8 noxref_21 N_M8_g noxref_20 VSS nmos_rvt L=2e-08 W=8.1e-08 nfin=3 $X=0.503
+ $Y=0.027
M9 N_M9_d N_M9_g noxref_21 VSS nmos_rvt L=2e-08 W=8.1e-08 nfin=3 $X=0.557
+ $Y=0.027
M10 VDD N_M10_g N_M10_s VDD pmos_rvt L=2e-08 W=8.1e-08 nfin=3 $X=0.071 $Y=0.162
M11 noxref_14 N_M11_g VDD VDD pmos_rvt L=2e-08 W=8.1e-08 nfin=3 $X=0.125
+ $Y=0.162
M12 VDD N_M12_g noxref_14 VDD pmos_rvt L=2e-08 W=8.1e-08 nfin=3 $X=0.179
+ $Y=0.162
M13 noxref_14 N_M13_g VDD VDD pmos_rvt L=2e-08 W=8.1e-08 nfin=3 $X=0.233
+ $Y=0.162
M14 noxref_15 N_M14_g noxref_14 VDD pmos_rvt L=2e-08 W=8.1e-08 nfin=3 $X=0.287
+ $Y=0.162
M15 noxref_14 N_M15_g noxref_15 VDD pmos_rvt L=2e-08 W=8.1e-08 nfin=3 $X=0.341
+ $Y=0.162
M16 noxref_15 N_M16_g noxref_14 VDD pmos_rvt L=2e-08 W=8.1e-08 nfin=3 $X=0.395
+ $Y=0.162
M17 N_M17_d N_M17_g noxref_15 VDD pmos_rvt L=2e-08 W=8.1e-08 nfin=3 $X=0.449
+ $Y=0.162
M18 noxref_15 N_M18_g N_M18_s VDD pmos_rvt L=2e-08 W=8.1e-08 nfin=3 $X=0.503
+ $Y=0.162
M19 N_M19_d N_M19_g noxref_15 VDD pmos_rvt L=2e-08 W=8.1e-08 nfin=3 $X=0.557
+ $Y=0.162

* .include "AO333x1_ASAP7_75t_R.pex.sp.pxi"

* Start of included file AO333x1_ASAP7_75t_R.pex.sp.pxi
x_PM_AO333x1_ASAP7_75t_R%A1 vss A1 N_M3_g N_M13_g N_A1_3 N_A1_4
+ PM_AO333x1_ASAP7_75t_R%A1
cc_1 N_A1_3 N_3_3 0.00179061f $X=0.243 $Y=0.0245
cc_2 N_A1_4 N_3_28 0.00125812f $X=0.243 $Y=0.098
cc_3 N_A1_4 N_3_3 0.00187156f $X=0.243 $Y=0.098
cc_4 N_A1_3 N_3_16 0.0360878f $X=0.243 $Y=0.0245
cc_5 N_A1_4 N_A2_4 0.00461625f $X=0.243 $Y=0.098
cc_6 N_A1_3 N_A2_3 0.00712953f $X=0.243 $Y=0.0245
x_PM_AO333x1_ASAP7_75t_R%B3 vss B3 N_M4_g N_M14_g N_B3_4 N_B3_3
+ PM_AO333x1_ASAP7_75t_R%B3
cc_7 N_B3_4 N_3_28 0.00124086f $X=0.297 $Y=0.098
cc_8 N_B3_3 N_3_3 0.00151195f $X=0.297 $Y=0.0245
cc_9 N_B3_4 N_3_3 0.00171224f $X=0.297 $Y=0.098
cc_10 N_B3_3 N_3_16 0.036082f $X=0.297 $Y=0.0245
cc_11 N_B3_3 N_A1_3 0.00315945f $X=0.297 $Y=0.0245
cc_12 N_B3_4 N_A1_4 0.00532445f $X=0.297 $Y=0.098
x_PM_AO333x1_ASAP7_75t_R%A2 vss A2 N_M2_g N_M12_g N_A2_4 N_A2_3
+ PM_AO333x1_ASAP7_75t_R%A2
cc_13 N_A2_4 N_3_16 0.00019699f $X=0.189 $Y=0.0935
cc_14 N_A2_4 N_3_3 0.000336601f $X=0.189 $Y=0.0935
cc_15 N_A2_4 N_3_28 0.00133514f $X=0.189 $Y=0.0935
cc_16 N_A2_4 N_3_22 0.00286257f $X=0.189 $Y=0.0935
cc_17 N_A2_4 N_A3_4 0.0036397f $X=0.189 $Y=0.0935
cc_18 N_A2_3 N_A3_3 0.00695251f $X=0.189 $Y=0.0245
x_PM_AO333x1_ASAP7_75t_R%B1 vss B1 N_M6_g N_M16_g N_B1_4 N_B1_3
+ PM_AO333x1_ASAP7_75t_R%B1
cc_19 N_B1_4 N_3_28 0.00273186f $X=0.405 $Y=0.098
cc_20 N_B1_4 N_B2_4 0.00332214f $X=0.405 $Y=0.098
cc_21 N_B1_3 N_B2_3 0.00697108f $X=0.405 $Y=0.0245
x_PM_AO333x1_ASAP7_75t_R%C3 vss C3 N_M7_g N_M17_g N_C3_3 N_C3_4
+ PM_AO333x1_ASAP7_75t_R%C3
cc_22 N_C3_3 N_3_4 0.000793191f $X=0.459 $Y=0.0245
cc_23 N_C3_4 N_3_28 0.00133163f $X=0.459 $Y=0.0765
cc_24 N_C3_4 N_3_4 0.00155185f $X=0.459 $Y=0.0765
cc_25 N_C3_3 N_3_18 0.0354357f $X=0.459 $Y=0.0245
cc_26 N_C3_3 N_B1_3 0.00314388f $X=0.459 $Y=0.0245
cc_27 N_C3_4 N_B1_4 0.00500423f $X=0.459 $Y=0.0765
x_PM_AO333x1_ASAP7_75t_R%C2 vss C2 N_M8_g N_M18_g N_C2_3 N_C2_4
+ PM_AO333x1_ASAP7_75t_R%C2
cc_28 N_C2_3 N_3_4 0.00119296f $X=0.513 $Y=0.0245
cc_29 N_C2_4 N_3_28 0.00145001f $X=0.513 $Y=0.098
cc_30 N_C2_4 N_3_4 0.00180586f $X=0.513 $Y=0.098
cc_31 N_C2_3 N_3_18 0.0358106f $X=0.513 $Y=0.0245
cc_32 N_C2_4 N_C3_4 0.00334719f $X=0.513 $Y=0.098
cc_33 N_C2_3 N_C3_3 0.00695406f $X=0.513 $Y=0.0245
x_PM_AO333x1_ASAP7_75t_R%C1 vss C1 N_M9_g N_M19_g N_C1_3 N_C1_1 N_C1_4
+ PM_AO333x1_ASAP7_75t_R%C1
cc_34 N_C1_3 N_3_17 0.0154494f $X=0.567 $Y=0.0245
cc_35 N_C1_3 N_3_5 0.00239379f $X=0.567 $Y=0.0245
cc_36 N_C1_3 N_3_6 0.000943971f $X=0.567 $Y=0.0245
cc_37 N_C1_3 N_3_28 0.00114128f $X=0.567 $Y=0.0245
cc_38 N_C1_1 N_3_17 0.00178534f $X=0.567 $Y=0.135
cc_39 N_C1_4 N_3_30 0.005846f $X=0.567 $Y=0.0755
cc_40 N_C1_3 N_3_19 0.0542716f $X=0.567 $Y=0.0245
cc_41 N_C1_4 N_C2_4 0.00338294f $X=0.567 $Y=0.0755
cc_42 N_C1_3 N_C2_3 0.0071191f $X=0.567 $Y=0.0245
x_PM_AO333x1_ASAP7_75t_R%Y vss Y N_M0_s N_M10_s N_Y_7 N_Y_12 N_Y_11 N_Y_8
+ PM_AO333x1_ASAP7_75t_R%Y
cc_43 N_Y_7 N_3_27 0.000246097f $X=0.056 $Y=0.0675
cc_44 N_Y_7 N_3_20 0.000249559f $X=0.056 $Y=0.0675
cc_45 N_Y_7 N_3_21 0.000362474f $X=0.056 $Y=0.0675
cc_46 N_Y_7 N_3_26 0.000433584f $X=0.056 $Y=0.0675
cc_47 N_Y_7 N_3_1 0.00248914f $X=0.056 $Y=0.0675
cc_48 N_Y_12 N_3_20 0.00250791f $X=0.0405 $Y=0.036
cc_49 N_Y_11 N_3_25 0.00439686f $X=0.027 $Y=0.054
cc_50 N_Y_8 N_3_15 0.0148693f $X=0.056 $Y=0.2025
cc_51 N_Y_7 N_3_15 0.0566506f $X=0.056 $Y=0.0675
x_PM_AO333x1_ASAP7_75t_R%3 vss N_M0_g N_M10_g N_M3_d N_M4_s N_M9_d N_M19_d
+ N_M17_d N_M18_s N_3_26 N_3_22 N_3_1 N_3_25 N_3_15 N_3_16 N_3_3 N_3_28 N_3_4
+ N_3_18 N_3_17 N_3_5 N_3_6 N_3_30 N_3_19 N_3_27 N_3_20 N_3_21
+ PM_AO333x1_ASAP7_75t_R%3
x_PM_AO333x1_ASAP7_75t_R%A3 vss A3 N_M1_g N_M11_g N_A3_3 N_A3_4
+ PM_AO333x1_ASAP7_75t_R%A3
cc_52 N_A3_3 N_3_26 0.000393083f $X=0.135 $Y=0.0245
cc_53 N_A3_3 N_3_22 0.00055054f $X=0.135 $Y=0.0245
cc_54 N_A3_3 N_3_1 0.0020548f $X=0.135 $Y=0.0245
cc_55 N_A3_4 N_3_25 0.0032325f $X=0.135 $Y=0.116
cc_56 N_A3_3 N_3_15 0.00353191f $X=0.135 $Y=0.0245
x_PM_AO333x1_ASAP7_75t_R%B2 vss B2 N_M5_g N_M15_g N_B2_4 N_B2_3
+ PM_AO333x1_ASAP7_75t_R%B2
cc_57 N_B2_4 N_3_3 0.000335829f $X=0.351 $Y=0.077
cc_58 N_B2_4 N_3_28 0.00313929f $X=0.351 $Y=0.077
cc_59 N_B2_4 N_B3_4 0.0033601f $X=0.351 $Y=0.077
cc_60 N_B2_3 N_B3_3 0.00704069f $X=0.351 $Y=0.0245

* End of included file AO333x1_ASAP7_75t_R.pex.sp.pxi
.ends

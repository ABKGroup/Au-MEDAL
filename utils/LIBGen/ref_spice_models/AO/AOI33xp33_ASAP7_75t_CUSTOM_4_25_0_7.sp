.subckt PM_AOI33xp33_ASAP7_75t_R%A1 vss 15 5 11 4 3
c1 1 vss 0.00535363f $X=0.081 $Y=0.135
c2 3 vss 0.12613f $X=0.081 $Y=0.0245
c3 4 vss 0.0146173f $X=0.081 $Y=0.0657
r1 16 17 5.30507 $w=1.3e-08 $l=2.28e-08 $layer=M1 $thickness=3.6e-08 $X=0.081
+ $Y=0.1122 $X2=0.081 $Y2=0.135
r2 15 16 3.32295 $w=1.3e-08 $l=1.42e-08 $layer=M1 $thickness=3.6e-08 $X=0.082
+ $Y=0.098 $X2=0.081 $Y2=0.1122
r3 15 4 7.52037 $w=1.3e-08 $l=3.23e-08 $layer=M1 $thickness=3.6e-08 $X=0.082
+ $Y=0.098 $X2=0.081 $Y2=0.0657
r4 1 8 6.74717 $w=2e-08 $layer=Gate_1 $thickness=5.2e-08 $X=0.081 $Y=0.135
+ $X2=0.081 $Y2=0.135
r5 1 17 19.3796 $a=3.24e-16 $layer=V0LIG $X=0.081 $Y=0.135 $X2=0.081 $Y2=0.135
r6 11 10 14.6259 $w=2.1e-08 $l=4.3e-08 $layer=Gate_1 $thickness=5.6e-08
+ $X=0.081 $Y=0.216 $X2=0.081 $Y2=0.173
r7 9 10 7.48304 $w=2.1e-08 $l=2.2e-08 $layer=Gate_1 $thickness=5.6e-08 $X=0.081
+ $Y=0.151 $X2=0.081 $Y2=0.173
r8 8 9 5.61228 $w=2.0375e-08 $l=1.6e-08 $layer=Gate_1 $thickness=5.6e-08
+ $X=0.081 $Y=0.135 $X2=0.081 $Y2=0.151
r9 7 8 5.61228 $w=2.0375e-08 $l=1.6e-08 $layer=Gate_1 $thickness=5.6e-08
+ $X=0.081 $Y=0.119 $X2=0.081 $Y2=0.135
r10 6 7 2.89117 $w=2.1e-08 $l=8.5e-09 $layer=Gate_1 $thickness=5.6e-08 $X=0.081
+ $Y=0.1105 $X2=0.081 $Y2=0.119
r11 5 6 14.6259 $w=2.1e-08 $l=4.3e-08 $layer=Gate_1 $thickness=5.6e-08 $X=0.081
+ $Y=0.0675 $X2=0.081 $Y2=0.1105
r12 5 3 14.6259 $w=2.1e-08 $l=4.3e-08 $layer=Gate_1 $thickness=5.6e-08 $X=0.081
+ $Y=0.0675 $X2=0.081 $Y2=0.0245
.ends

.subckt PM_AOI33xp33_ASAP7_75t_R%B1 vss 13 5 9 4 3 1
c1 1 vss 0.00611051f $X=0.243 $Y=0.135
c2 3 vss 0.0567093f $X=0.243 $Y=0.0245
c3 4 vss 0.00437951f $X=0.243 $Y=0.0922
r1 14 15 3.32295 $w=1.3e-08 $l=1.43e-08 $layer=M1 $thickness=3.6e-08 $X=0.243
+ $Y=0.1207 $X2=0.243 $Y2=0.135
r2 13 14 1.34084 $w=1.3e-08 $l=5.7e-09 $layer=M1 $thickness=3.6e-08 $X=0.238
+ $Y=0.115 $X2=0.243 $Y2=0.1207
r3 13 4 5.30507 $w=1.3e-08 $l=2.28e-08 $layer=M1 $thickness=3.6e-08 $X=0.238
+ $Y=0.115 $X2=0.243 $Y2=0.0922
r4 1 7 6.74717 $w=2e-08 $layer=Gate_1 $thickness=5.2e-08 $X=0.243 $Y=0.135
+ $X2=0.243 $Y2=0.135
r5 1 15 19.3796 $a=3.24e-16 $layer=V0LIG $X=0.243 $Y=0.135 $X2=0.243 $Y2=0.135
r6 9 8 16.6668 $w=2.1e-08 $l=4.9e-08 $layer=Gate_1 $thickness=5.6e-08 $X=0.243
+ $Y=0.216 $X2=0.243 $Y2=0.167
r7 7 8 11.0545 $w=2.06875e-08 $l=3.2e-08 $layer=Gate_1 $thickness=5.6e-08
+ $X=0.243 $Y=0.135 $X2=0.243 $Y2=0.167
r8 6 7 6.46262 $w=2.04595e-08 $l=1.85e-08 $layer=Gate_1 $thickness=5.6e-08
+ $X=0.243 $Y=0.1165 $X2=0.243 $Y2=0.135
r9 5 6 16.6668 $w=2.1e-08 $l=4.9e-08 $layer=Gate_1 $thickness=5.6e-08 $X=0.243
+ $Y=0.0675 $X2=0.243 $Y2=0.1165
r10 5 3 14.6259 $w=2.1e-08 $l=4.3e-08 $layer=Gate_1 $thickness=5.6e-08 $X=0.243
+ $Y=0.0675 $X2=0.243 $Y2=0.0245
.ends

.subckt PM_AOI33xp33_ASAP7_75t_R%B2 vss 13 5 9 4 3 1
c1 1 vss 0.00185311f $X=0.297 $Y=0.135
c2 3 vss 0.0756419f $X=0.297 $Y=0.0245
c3 4 vss 0.00465666f $X=0.297 $Y=0.0957
r1 14 15 2.50679 $w=1.3e-08 $l=1.08e-08 $layer=M1 $thickness=3.6e-08 $X=0.297
+ $Y=0.1242 $X2=0.297 $Y2=0.135
r2 13 14 0.524677 $w=1.3e-08 $l=2.2e-09 $layer=M1 $thickness=3.6e-08 $X=0.303
+ $Y=0.122 $X2=0.297 $Y2=0.1242
r3 13 4 6.12123 $w=1.3e-08 $l=2.63e-08 $layer=M1 $thickness=3.6e-08 $X=0.303
+ $Y=0.122 $X2=0.297 $Y2=0.0957
r4 1 7 6.74717 $w=2e-08 $layer=Gate_1 $thickness=5.2e-08 $X=0.297 $Y=0.135
+ $X2=0.297 $Y2=0.135
r5 1 15 19.3796 $a=3.24e-16 $layer=V0LIG $X=0.297 $Y=0.135 $X2=0.297 $Y2=0.135
r6 9 8 16.6668 $w=2.1e-08 $l=4.9e-08 $layer=Gate_1 $thickness=5.6e-08 $X=0.297
+ $Y=0.216 $X2=0.297 $Y2=0.167
r7 7 8 11.0545 $w=2.06875e-08 $l=3.2e-08 $layer=Gate_1 $thickness=5.6e-08
+ $X=0.297 $Y=0.135 $X2=0.297 $Y2=0.167
r8 6 7 6.46262 $w=2.04595e-08 $l=1.85e-08 $layer=Gate_1 $thickness=5.6e-08
+ $X=0.297 $Y=0.1165 $X2=0.297 $Y2=0.135
r9 5 6 16.6668 $w=2.1e-08 $l=4.9e-08 $layer=Gate_1 $thickness=5.6e-08 $X=0.297
+ $Y=0.0675 $X2=0.297 $Y2=0.1165
r10 5 3 14.6259 $w=2.1e-08 $l=4.3e-08 $layer=Gate_1 $thickness=5.6e-08 $X=0.297
+ $Y=0.0675 $X2=0.297 $Y2=0.0245
.ends

.subckt PM_AOI33xp33_ASAP7_75t_R%B3 vss 15 5 11 4 3
c1 1 vss 0.00624198f $X=0.351 $Y=0.135
c2 3 vss 0.0987211f $X=0.351 $Y=0.0245
c3 4 vss 0.00358142f $X=0.351 $Y=0.0957
r1 16 17 2.50679 $w=1.3e-08 $l=1.08e-08 $layer=M1 $thickness=3.6e-08 $X=0.351
+ $Y=0.1242 $X2=0.351 $Y2=0.135
r2 15 16 0.524677 $w=1.3e-08 $l=2.2e-09 $layer=M1 $thickness=3.6e-08 $X=0.353
+ $Y=0.122 $X2=0.351 $Y2=0.1242
r3 15 4 6.12123 $w=1.3e-08 $l=2.63e-08 $layer=M1 $thickness=3.6e-08 $X=0.353
+ $Y=0.122 $X2=0.351 $Y2=0.0957
r4 1 8 6.74717 $w=2e-08 $layer=Gate_1 $thickness=5.2e-08 $X=0.351 $Y=0.135
+ $X2=0.351 $Y2=0.135
r5 1 17 19.3796 $a=3.24e-16 $layer=V0LIG $X=0.351 $Y=0.135 $X2=0.351 $Y2=0.135
r6 11 10 14.6259 $w=2.1e-08 $l=4.3e-08 $layer=Gate_1 $thickness=5.6e-08
+ $X=0.351 $Y=0.216 $X2=0.351 $Y2=0.173
r7 9 10 7.48304 $w=2.1e-08 $l=2.2e-08 $layer=Gate_1 $thickness=5.6e-08 $X=0.351
+ $Y=0.151 $X2=0.351 $Y2=0.173
r8 8 9 5.61228 $w=2.0375e-08 $l=1.6e-08 $layer=Gate_1 $thickness=5.6e-08
+ $X=0.351 $Y=0.135 $X2=0.351 $Y2=0.151
r9 7 8 5.61228 $w=2.0375e-08 $l=1.6e-08 $layer=Gate_1 $thickness=5.6e-08
+ $X=0.351 $Y=0.119 $X2=0.351 $Y2=0.135
r10 6 7 2.89117 $w=2.1e-08 $l=8.5e-09 $layer=Gate_1 $thickness=5.6e-08 $X=0.351
+ $Y=0.1105 $X2=0.351 $Y2=0.119
r11 5 6 14.6259 $w=2.1e-08 $l=4.3e-08 $layer=Gate_1 $thickness=5.6e-08 $X=0.351
+ $Y=0.0675 $X2=0.351 $Y2=0.1105
r12 5 3 14.6259 $w=2.1e-08 $l=4.3e-08 $layer=Gate_1 $thickness=5.6e-08 $X=0.351
+ $Y=0.0675 $X2=0.351 $Y2=0.0245
.ends

.subckt PM_AOI33xp33_ASAP7_75t_R%Y vss 31 20 21 45 48 49 10 1 15 11 16 17 12
c1 1 vss 0.00633544f $X=0.216 $Y=0.0675
c2 2 vss 0.00791847f $X=0.27 $Y=0.216
c3 3 vss 0.00684695f $X=0.378 $Y=0.216
c4 10 vss 0.00254199f $X=0.2015 $Y=0.0675
c5 11 vss 0.00367519f $X=0.2555 $Y=0.216
c6 12 vss 0.0279148f $X=0.3635 $Y=0.216
c7 13 vss 0.0029539f $X=0.405 $Y=0.0297
c8 14 vss 0.00149162f $X=0.405 $Y=0.198
c9 15 vss 0.0176003f $X=0.204 $Y=0.036
c10 16 vss 0.00992903f $X=0.3645 $Y=0.198
c11 17 vss 0.00538261f $X=0.405 $Y=0.0575
r1 48 47 0.0462963 $w=5.4e-08 $l=2.5e-09 $layer=P_src_drn $thickness=1e-09
+ $X=0.2873 $Y=0.216 $X2=0.2845 $Y2=0.216
r2 2 47 0.268519 $w=5.4e-08 $l=1.45e-08 $layer=P_src_drn $thickness=1e-09
+ $X=0.27 $Y=0.216 $X2=0.2845 $Y2=0.216
r3 11 2 0.268519 $w=5.4e-08 $l=1.45e-08 $layer=P_src_drn $thickness=1e-09
+ $X=0.2555 $Y=0.216 $X2=0.27 $Y2=0.216
r4 49 11 0.0462963 $w=5.4e-08 $l=2.5e-09 $layer=P_src_drn $thickness=1e-09
+ $X=0.2526 $Y=0.216 $X2=0.2555 $Y2=0.216
r5 12 3 0.231482 $w=5.4e-08 $l=1.25e-08 $layer=P_src_drn $thickness=1e-09
+ $X=0.3635 $Y=0.216 $X2=0.378 $Y2=0.216
r6 45 12 0.0462963 $w=5.4e-08 $l=2.5e-09 $layer=P_src_drn $thickness=1e-09
+ $X=0.3606 $Y=0.216 $X2=0.3635 $Y2=0.216
r7 2 42 19.3796 $a=3.24e-16 $layer=V0LISD $X=0.27 $Y=0.216 $X2=0.27 $Y2=0.198
r8 3 35 19.3796 $a=3.24e-16 $layer=V0LISD $X=0.378 $Y=0.216 $X2=0.378 $Y2=0.198
r9 42 43 3.14806 $w=1.3e-08 $l=1.35e-08 $layer=M1 $thickness=3.6e-08 $X=0.27
+ $Y=0.198 $X2=0.2835 $Y2=0.198
r10 40 43 3.14806 $w=1.3e-08 $l=1.35e-08 $layer=M1 $thickness=3.6e-08 $X=0.297
+ $Y=0.198 $X2=0.2835 $Y2=0.198
r11 39 40 5.82974 $w=1.3e-08 $l=2.5e-08 $layer=M1 $thickness=3.6e-08 $X=0.322
+ $Y=0.198 $X2=0.297 $Y2=0.198
r12 38 39 4.19742 $w=1.3e-08 $l=1.8e-08 $layer=M1 $thickness=3.6e-08 $X=0.34
+ $Y=0.198 $X2=0.322 $Y2=0.198
r13 37 38 2.56509 $w=1.3e-08 $l=1.1e-08 $layer=M1 $thickness=3.6e-08 $X=0.351
+ $Y=0.198 $X2=0.34 $Y2=0.198
r14 35 36 3.14806 $w=1.3e-08 $l=1.35e-08 $layer=M1 $thickness=3.6e-08 $X=0.378
+ $Y=0.198 $X2=0.3915 $Y2=0.198
r15 16 35 3.14806 $w=1.3e-08 $l=1.35e-08 $layer=M1 $thickness=3.6e-08 $X=0.3645
+ $Y=0.198 $X2=0.378 $Y2=0.198
r16 16 37 3.14806 $w=1.3e-08 $l=1.35e-08 $layer=M1 $thickness=3.6e-08 $X=0.3645
+ $Y=0.198 $X2=0.351 $Y2=0.198
r17 14 34 3.36447 $w=1.71023e-08 $l=2.15e-08 $layer=M1 $thickness=3.6e-08
+ $X=0.405 $Y=0.198 $X2=0.405 $Y2=0.1765
r18 14 36 1.49895 $w=1.63333e-08 $l=1.35e-08 $layer=M1 $thickness=3.6e-08
+ $X=0.405 $Y=0.198 $X2=0.3915 $Y2=0.198
r19 33 34 13.8748 $w=1.3e-08 $l=5.95e-08 $layer=M1 $thickness=3.6e-08 $X=0.405
+ $Y=0.117 $X2=0.405 $Y2=0.1765
r20 17 32 3.50163 $w=1.45753e-08 $l=1.83e-08 $layer=M1 $thickness=3.6e-08
+ $X=0.405 $Y=0.0575 $X2=0.405 $Y2=0.0392
r21 17 33 13.8748 $w=1.3e-08 $l=5.95e-08 $layer=M1 $thickness=3.6e-08 $X=0.405
+ $Y=0.0575 $X2=0.405 $Y2=0.117
r22 31 32 0.637778 $w=1.8e-08 $l=6.2e-09 $layer=M1 $thickness=3.6e-08 $X=0.406
+ $Y=0.033 $X2=0.405 $Y2=0.0392
r23 31 13 0.331644 $w=1.8e-08 $l=3.3e-09 $layer=M1 $thickness=3.6e-08 $X=0.406
+ $Y=0.033 $X2=0.405 $Y2=0.0297
r24 31 30 4.24844 $w=9e-09 $l=2.71662e-08 $layer=M1 $thickness=3.6e-08 $X=0.406
+ $Y=0.033 $X2=0.378 $Y2=0.036
r25 29 30 6.29612 $w=1.3e-08 $l=2.7e-08 $layer=M1 $thickness=3.6e-08 $X=0.351
+ $Y=0.036 $X2=0.378 $Y2=0.036
r26 28 29 6.29612 $w=1.3e-08 $l=2.7e-08 $layer=M1 $thickness=3.6e-08 $X=0.324
+ $Y=0.036 $X2=0.351 $Y2=0.036
r27 27 28 6.29612 $w=1.3e-08 $l=2.7e-08 $layer=M1 $thickness=3.6e-08 $X=0.297
+ $Y=0.036 $X2=0.324 $Y2=0.036
r28 26 27 5.82974 $w=1.3e-08 $l=2.5e-08 $layer=M1 $thickness=3.6e-08 $X=0.272
+ $Y=0.036 $X2=0.297 $Y2=0.036
r29 25 26 4.19742 $w=1.3e-08 $l=1.8e-08 $layer=M1 $thickness=3.6e-08 $X=0.254
+ $Y=0.036 $X2=0.272 $Y2=0.036
r30 24 25 2.56509 $w=1.3e-08 $l=1.1e-08 $layer=M1 $thickness=3.6e-08 $X=0.243
+ $Y=0.036 $X2=0.254 $Y2=0.036
r31 23 24 3.14806 $w=1.3e-08 $l=1.35e-08 $layer=M1 $thickness=3.6e-08 $X=0.2295
+ $Y=0.036 $X2=0.243 $Y2=0.036
r32 22 23 3.14806 $w=1.3e-08 $l=1.35e-08 $layer=M1 $thickness=3.6e-08 $X=0.216
+ $Y=0.036 $X2=0.2295 $Y2=0.036
r33 15 22 2.79828 $w=1.3e-08 $l=1.2e-08 $layer=M1 $thickness=3.6e-08 $X=0.204
+ $Y=0.036 $X2=0.216 $Y2=0.036
r34 1 22 19.3796 $a=3.24e-16 $layer=V0LISD $X=0.216 $Y=0.0675 $X2=0.216
+ $Y2=0.036
r35 21 19 0.0308642 $w=8.1e-08 $l=2.5e-09 $layer=N_src_drn $thickness=1e-09
+ $X=0.2333 $Y=0.0675 $X2=0.2305 $Y2=0.0675
r36 1 19 0.179012 $w=8.1e-08 $l=1.45e-08 $layer=N_src_drn $thickness=1e-09
+ $X=0.216 $Y=0.0675 $X2=0.2305 $Y2=0.0675
r37 10 1 0.179012 $w=8.1e-08 $l=1.45e-08 $layer=N_src_drn $thickness=1e-09
+ $X=0.2015 $Y=0.0675 $X2=0.216 $Y2=0.0675
r38 20 10 0.0308642 $w=8.1e-08 $l=2.5e-09 $layer=N_src_drn $thickness=1e-09
+ $X=0.1986 $Y=0.0675 $X2=0.2015 $Y2=0.0675
.ends

.subckt PM_AOI33xp33_ASAP7_75t_R%A2 vss 13 5 9 4 3
c1 1 vss 0.00261797f $X=0.135 $Y=0.135
c2 3 vss 0.10347f $X=0.135 $Y=0.0245
c3 4 vss 0.0108399f $X=0.135 $Y=0.0862
r1 14 15 4.72209 $w=1.3e-08 $l=2.03e-08 $layer=M1 $thickness=3.6e-08 $X=0.135
+ $Y=0.1147 $X2=0.135 $Y2=0.135
r2 13 14 2.73998 $w=1.3e-08 $l=1.17e-08 $layer=M1 $thickness=3.6e-08 $X=0.133
+ $Y=0.103 $X2=0.135 $Y2=0.1147
r3 13 4 3.90593 $w=1.3e-08 $l=1.68e-08 $layer=M1 $thickness=3.6e-08 $X=0.133
+ $Y=0.103 $X2=0.135 $Y2=0.0862
r4 1 7 6.74717 $w=2e-08 $layer=Gate_1 $thickness=5.2e-08 $X=0.135 $Y=0.135
+ $X2=0.135 $Y2=0.135
r5 1 15 19.3796 $a=3.24e-16 $layer=V0LIG $X=0.135 $Y=0.135 $X2=0.135 $Y2=0.135
r6 9 8 16.6668 $w=2.1e-08 $l=4.9e-08 $layer=Gate_1 $thickness=5.6e-08 $X=0.135
+ $Y=0.216 $X2=0.135 $Y2=0.167
r7 7 8 11.0545 $w=2.06875e-08 $l=3.2e-08 $layer=Gate_1 $thickness=5.6e-08
+ $X=0.135 $Y=0.135 $X2=0.135 $Y2=0.167
r8 6 7 6.46262 $w=2.04595e-08 $l=1.85e-08 $layer=Gate_1 $thickness=5.6e-08
+ $X=0.135 $Y=0.1165 $X2=0.135 $Y2=0.135
r9 5 6 16.6668 $w=2.1e-08 $l=4.9e-08 $layer=Gate_1 $thickness=5.6e-08 $X=0.135
+ $Y=0.0675 $X2=0.135 $Y2=0.1165
r10 5 3 14.6259 $w=2.1e-08 $l=4.3e-08 $layer=Gate_1 $thickness=5.6e-08 $X=0.135
+ $Y=0.0675 $X2=0.135 $Y2=0.0245
.ends

.subckt PM_AOI33xp33_ASAP7_75t_R%A3 vss 16 5 9 4 3 1
c1 1 vss 0.00499728f $X=0.189 $Y=0.135
c2 3 vss 0.0827151f $X=0.189 $Y=0.0245
c3 4 vss 0.00738627f $X=0.189 $Y=0.098
r1 16 15 0.991056 $w=1.3e-08 $l=4.3e-09 $layer=M1 $thickness=3.6e-08 $X=0.186
+ $Y=0.172 $X2=0.189 $Y2=0.1677
r2 14 15 3.20636 $w=1.3e-08 $l=1.37e-08 $layer=M1 $thickness=3.6e-08 $X=0.189
+ $Y=0.154 $X2=0.189 $Y2=0.1677
r3 13 14 4.4306 $w=1.3e-08 $l=1.9e-08 $layer=M1 $thickness=3.6e-08 $X=0.189
+ $Y=0.135 $X2=0.189 $Y2=0.154
r4 4 13 8.62802 $w=1.3e-08 $l=3.7e-08 $layer=M1 $thickness=3.6e-08 $X=0.189
+ $Y=0.098 $X2=0.189 $Y2=0.135
r5 1 7 6.74717 $w=2e-08 $layer=Gate_1 $thickness=5.2e-08 $X=0.189 $Y=0.135
+ $X2=0.189 $Y2=0.135
r6 1 13 19.3796 $a=3.24e-16 $layer=V0LIG $X=0.189 $Y=0.135 $X2=0.189 $Y2=0.135
r7 9 8 16.6668 $w=2.1e-08 $l=4.9e-08 $layer=Gate_1 $thickness=5.6e-08 $X=0.189
+ $Y=0.216 $X2=0.189 $Y2=0.167
r8 7 8 11.0545 $w=2.06875e-08 $l=3.2e-08 $layer=Gate_1 $thickness=5.6e-08
+ $X=0.189 $Y=0.135 $X2=0.189 $Y2=0.167
r9 6 7 6.46262 $w=2.04595e-08 $l=1.85e-08 $layer=Gate_1 $thickness=5.6e-08
+ $X=0.189 $Y=0.1165 $X2=0.189 $Y2=0.135
r10 5 6 16.6668 $w=2.1e-08 $l=4.9e-08 $layer=Gate_1 $thickness=5.6e-08 $X=0.189
+ $Y=0.0675 $X2=0.189 $Y2=0.1165
r11 5 3 14.6259 $w=2.1e-08 $l=4.3e-08 $layer=Gate_1 $thickness=5.6e-08 $X=0.189
+ $Y=0.0675 $X2=0.189 $Y2=0.0245
.ends

* End of included file AOI33xp33_ASAP7_75t_R.pex.sp.pex

*
.subckt AOI33xp33_ASAP7_75t_CUSTOM_4_25_0_7 VSS VDD A1 A2 A3 B1 B2 B3 Y
*
* VSS VSS
* VDD VDD
* A1 A1
* A2 A2
* A3 A3
* B1 B1
* B2 B2
* B3 B3
* Y Y
*
*

M0 noxref_11 N_M0_g VSS VSS nmos_rvt L=2e-08 W=8.1e-08 nfin=3 $X=0.071 $Y=0.027
M1 noxref_12 N_M1_g noxref_11 VSS nmos_rvt L=2e-08 W=8.1e-08 nfin=3 $X=0.125
+ $Y=0.027
M2 N_M2_d N_M2_g noxref_12 VSS nmos_rvt L=2e-08 W=8.1e-08 nfin=3 $X=0.179
+ $Y=0.027
M3 noxref_13 N_M3_g N_M3_s VSS nmos_rvt L=2e-08 W=8.1e-08 nfin=3 $X=0.233
+ $Y=0.027
M4 noxref_14 N_M4_g noxref_13 VSS nmos_rvt L=2e-08 W=8.1e-08 nfin=3 $X=0.287
+ $Y=0.027
M5 VSS N_M5_g noxref_14 VSS nmos_rvt L=2e-08 W=8.1e-08 nfin=3 $X=0.341 $Y=0.027
M6 noxref_9 N_M6_g VDD VDD pmos_rvt L=2e-08 W=5.4e-08 nfin=2 $X=0.071 $Y=0.189
M7 VDD N_M7_g noxref_9 VDD pmos_rvt L=2e-08 W=5.4e-08 nfin=2 $X=0.125 $Y=0.189
M8 noxref_9 N_M8_g VDD VDD pmos_rvt L=2e-08 W=5.4e-08 nfin=2 $X=0.179 $Y=0.189
M9 N_M9_d N_M9_g noxref_9 VDD pmos_rvt L=2e-08 W=5.4e-08 nfin=2 $X=0.233
+ $Y=0.189
M10 noxref_9 N_M10_g N_M10_s VDD pmos_rvt L=2e-08 W=5.4e-08 nfin=2 $X=0.287
+ $Y=0.189
M11 N_M11_d N_M11_g noxref_9 VDD pmos_rvt L=2e-08 W=5.4e-08 nfin=2 $X=0.341
+ $Y=0.189

* .include "AOI33xp33_ASAP7_75t_R.pex.sp.pxi"

* Start of included file AOI33xp33_ASAP7_75t_R.pex.sp.pxi
x_PM_AOI33xp33_ASAP7_75t_R%A1 vss A1 N_M0_g N_M6_g N_A1_4 N_A1_3
+ PM_AOI33xp33_ASAP7_75t_R%A1
x_PM_AOI33xp33_ASAP7_75t_R%B1 vss B1 N_M3_g N_M9_g N_B1_4 N_B1_3 N_B1_1
+ PM_AOI33xp33_ASAP7_75t_R%B1
cc_1 N_B1_4 N_A3_4 0.00364168f $X=0.243 $Y=0.0922
cc_2 N_B1_3 N_A3_3 0.007117f $X=0.243 $Y=0.0245
x_PM_AOI33xp33_ASAP7_75t_R%B2 vss B2 N_M4_g N_M10_g N_B2_4 N_B2_3 N_B2_1
+ PM_AOI33xp33_ASAP7_75t_R%B2
cc_3 N_B2_4 N_B1_4 0.00336243f $X=0.297 $Y=0.0957
cc_4 N_B2_3 N_B1_3 0.00918991f $X=0.297 $Y=0.0245
x_PM_AOI33xp33_ASAP7_75t_R%B3 vss B3 N_M5_g N_M11_g N_B3_4 N_B3_3
+ PM_AOI33xp33_ASAP7_75t_R%B3
cc_5 N_B3_4 N_B2_4 0.00343175f $X=0.351 $Y=0.0957
cc_6 N_B3_3 N_B2_3 0.00921003f $X=0.351 $Y=0.0245
x_PM_AOI33xp33_ASAP7_75t_R%Y vss Y N_M2_d N_M3_s N_M11_d N_M10_s N_M9_d N_Y_10
+ N_Y_1 N_Y_15 N_Y_11 N_Y_16 N_Y_17 N_Y_12 PM_AOI33xp33_ASAP7_75t_R%Y
cc_7 N_Y_10 N_A3_1 0.000966561f $X=0.2015 $Y=0.0675
cc_8 N_Y_1 N_A3_4 0.00139368f $X=0.216 $Y=0.0675
cc_9 N_Y_1 N_A3_3 0.00140667f $X=0.216 $Y=0.0675
cc_10 N_Y_10 N_A3_3 0.0361245f $X=0.2015 $Y=0.0675
cc_11 N_Y_10 N_B1_4 0.000580282f $X=0.2015 $Y=0.0675
cc_12 N_Y_10 N_B1_1 0.000966561f $X=0.2015 $Y=0.0675
cc_13 N_Y_15 N_B1_4 0.00115701f $X=0.204 $Y=0.036
cc_14 N_Y_1 N_B1_3 0.00133569f $X=0.216 $Y=0.0675
cc_15 N_Y_1 N_B1_4 0.00239759f $X=0.216 $Y=0.0675
cc_16 N_Y_11 N_B1_3 0.0105624f $X=0.2555 $Y=0.216
cc_17 N_Y_10 N_B1_3 0.0505081f $X=0.2015 $Y=0.0675
cc_18 N_Y_11 N_B2_1 0.000472369f $X=0.2555 $Y=0.216
cc_19 N_Y_15 N_B2_4 0.00144033f $X=0.204 $Y=0.036
cc_20 N_Y_16 N_B2_4 0.00371228f $X=0.3645 $Y=0.198
cc_21 N_Y_11 N_B2_3 0.0266502f $X=0.2555 $Y=0.216
cc_22 N_Y_16 N_B3_3 0.00109649f $X=0.3645 $Y=0.198
cc_23 N_Y_15 N_B3_4 0.00118925f $X=0.204 $Y=0.036
cc_24 N_Y_17 N_B3_4 0.00609121f $X=0.405 $Y=0.0575
cc_25 N_Y_12 N_B3_3 0.0271215f $X=0.3635 $Y=0.216
x_PM_AOI33xp33_ASAP7_75t_R%A2 vss A2 N_M1_g N_M7_g N_A2_4 N_A2_3
+ PM_AOI33xp33_ASAP7_75t_R%A2
cc_26 N_A2_4 N_A1_4 0.00638934f $X=0.135 $Y=0.0862
cc_27 N_A2_3 N_A1_3 0.0094856f $X=0.135 $Y=0.0245
x_PM_AOI33xp33_ASAP7_75t_R%A3 vss A3 N_M2_g N_M8_g N_A3_4 N_A3_3 N_A3_1
+ PM_AOI33xp33_ASAP7_75t_R%A3
cc_28 N_A3_4 N_A2_4 0.00521617f $X=0.189 $Y=0.098
cc_29 N_A3_3 N_A2_3 0.00925767f $X=0.189 $Y=0.0245

* End of included file AOI33xp33_ASAP7_75t_R.pex.sp.pxi
.ends

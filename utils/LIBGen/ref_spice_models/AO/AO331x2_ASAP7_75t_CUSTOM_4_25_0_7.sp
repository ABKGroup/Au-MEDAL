.subckt PM_AO331x2_ASAP7_75t_R%A3 vss 11 5 9 3 4
c1 1 vss 0.00582344f $X=0.189 $Y=0.135
c2 3 vss 0.139806f $X=0.189 $Y=0.0245
c3 4 vss 0.00668514f $X=0.189 $Y=0.1102
r1 12 13 3.32295 $w=1.3e-08 $l=1.43e-08 $layer=M1 $thickness=3.6e-08 $X=0.189
+ $Y=0.1207 $X2=0.189 $Y2=0.135
r2 11 12 1.34084 $w=1.3e-08 $l=5.7e-09 $layer=M1 $thickness=3.6e-08 $X=0.189
+ $Y=0.115 $X2=0.189 $Y2=0.1207
r3 11 4 1.10765 $w=1.3e-08 $l=4.8e-09 $layer=M1 $thickness=3.6e-08 $X=0.189
+ $Y=0.115 $X2=0.189 $Y2=0.1102
r4 1 7 10.4265 $w=1.765e-08 $layer=LIG $thickness=5.2e-08 $X=0.189 $Y=0.135
+ $X2=0.189 $Y2=0.135
r5 1 13 19.3796 $a=3.24e-16 $layer=V0LIG $X=0.189 $Y=0.135 $X2=0.189 $Y2=0.135
r6 9 8 16.4967 $w=2.1e-08 $l=4.85e-08 $layer=Gate_1 $thickness=5.6e-08 $X=0.189
+ $Y=0.2025 $X2=0.189 $Y2=0.154
r7 7 8 6.6497 $w=2.04211e-08 $l=1.9e-08 $layer=Gate_1 $thickness=5.6e-08
+ $X=0.189 $Y=0.135 $X2=0.189 $Y2=0.154
r8 6 7 6.6497 $w=2.04211e-08 $l=1.9e-08 $layer=Gate_1 $thickness=5.6e-08
+ $X=0.189 $Y=0.116 $X2=0.189 $Y2=0.135
r9 5 6 16.4967 $w=2.1e-08 $l=4.85e-08 $layer=Gate_1 $thickness=5.6e-08 $X=0.189
+ $Y=0.0675 $X2=0.189 $Y2=0.116
r10 5 3 14.6259 $w=2.1e-08 $l=4.3e-08 $layer=Gate_1 $thickness=5.6e-08 $X=0.189
+ $Y=0.0675 $X2=0.189 $Y2=0.0245
.ends

.subckt PM_AO331x2_ASAP7_75t_R%B2 vss 11 5 9 4 3
c1 1 vss 0.00485708f $X=0.405 $Y=0.135
c2 3 vss 0.121016f $X=0.405 $Y=0.0245
c3 4 vss 0.005175f $X=0.405 $Y=0.0922
r1 12 13 3.32295 $w=1.3e-08 $l=1.43e-08 $layer=M1 $thickness=3.6e-08 $X=0.405
+ $Y=0.1207 $X2=0.405 $Y2=0.135
r2 11 12 1.34084 $w=1.3e-08 $l=5.7e-09 $layer=M1 $thickness=3.6e-08 $X=0.404
+ $Y=0.115 $X2=0.405 $Y2=0.1207
r3 11 4 5.30507 $w=1.3e-08 $l=2.28e-08 $layer=M1 $thickness=3.6e-08 $X=0.404
+ $Y=0.115 $X2=0.405 $Y2=0.0922
r4 1 7 10.4265 $w=1.765e-08 $layer=LIG $thickness=5.2e-08 $X=0.405 $Y=0.135
+ $X2=0.405 $Y2=0.135
r5 1 13 19.3796 $a=3.24e-16 $layer=V0LIG $X=0.405 $Y=0.135 $X2=0.405 $Y2=0.135
r6 9 8 16.4967 $w=2.1e-08 $l=4.85e-08 $layer=Gate_1 $thickness=5.6e-08 $X=0.405
+ $Y=0.2025 $X2=0.405 $Y2=0.154
r7 7 8 6.6497 $w=2.04211e-08 $l=1.9e-08 $layer=Gate_1 $thickness=5.6e-08
+ $X=0.405 $Y=0.135 $X2=0.405 $Y2=0.154
r8 6 7 6.6497 $w=2.04211e-08 $l=1.9e-08 $layer=Gate_1 $thickness=5.6e-08
+ $X=0.405 $Y=0.116 $X2=0.405 $Y2=0.135
r9 5 6 16.4967 $w=2.1e-08 $l=4.85e-08 $layer=Gate_1 $thickness=5.6e-08 $X=0.405
+ $Y=0.0675 $X2=0.405 $Y2=0.116
r10 5 3 14.6259 $w=2.1e-08 $l=4.3e-08 $layer=Gate_1 $thickness=5.6e-08 $X=0.405
+ $Y=0.0675 $X2=0.405 $Y2=0.0245
.ends

.subckt PM_AO331x2_ASAP7_75t_R%B1 vss 11 5 9 4 3
c1 1 vss 0.00700955f $X=0.351 $Y=0.135
c2 3 vss 0.101647f $X=0.351 $Y=0.0245
c3 4 vss 0.00464314f $X=0.351 $Y=0.0927
r1 12 13 3.20636 $w=1.3e-08 $l=1.38e-08 $layer=M1 $thickness=3.6e-08 $X=0.351
+ $Y=0.1212 $X2=0.351 $Y2=0.135
r2 11 12 1.22425 $w=1.3e-08 $l=5.2e-09 $layer=M1 $thickness=3.6e-08 $X=0.351
+ $Y=0.116 $X2=0.351 $Y2=0.1212
r3 11 4 5.42166 $w=1.3e-08 $l=2.33e-08 $layer=M1 $thickness=3.6e-08 $X=0.351
+ $Y=0.116 $X2=0.351 $Y2=0.0927
r4 1 7 10.4265 $w=1.765e-08 $layer=LIG $thickness=5.2e-08 $X=0.351 $Y=0.135
+ $X2=0.351 $Y2=0.135
r5 1 13 19.3796 $a=3.24e-16 $layer=V0LIG $X=0.351 $Y=0.135 $X2=0.351 $Y2=0.135
r6 9 8 16.4967 $w=2.1e-08 $l=4.85e-08 $layer=Gate_1 $thickness=5.6e-08 $X=0.351
+ $Y=0.2025 $X2=0.351 $Y2=0.154
r7 7 8 6.6497 $w=2.04211e-08 $l=1.9e-08 $layer=Gate_1 $thickness=5.6e-08
+ $X=0.351 $Y=0.135 $X2=0.351 $Y2=0.154
r8 6 7 6.6497 $w=2.04211e-08 $l=1.9e-08 $layer=Gate_1 $thickness=5.6e-08
+ $X=0.351 $Y=0.116 $X2=0.351 $Y2=0.135
r9 5 6 16.4967 $w=2.1e-08 $l=4.85e-08 $layer=Gate_1 $thickness=5.6e-08 $X=0.351
+ $Y=0.0675 $X2=0.351 $Y2=0.116
r10 5 3 14.6259 $w=2.1e-08 $l=4.3e-08 $layer=Gate_1 $thickness=5.6e-08 $X=0.351
+ $Y=0.0675 $X2=0.351 $Y2=0.0245
.ends

.subckt PM_AO331x2_ASAP7_75t_R%C vss 13 5 11 3 1 4
c1 1 vss 0.00402483f $X=0.513 $Y=0.135
c2 3 vss 0.0889154f $X=0.513 $Y=0.0245
c3 4 vss 0.00653353f $X=0.513 $Y=0.0922
r1 14 15 3.32295 $w=1.3e-08 $l=1.43e-08 $layer=M1 $thickness=3.6e-08 $X=0.513
+ $Y=0.1207 $X2=0.513 $Y2=0.135
r2 13 14 1.34084 $w=1.3e-08 $l=5.7e-09 $layer=M1 $thickness=3.6e-08 $X=0.511
+ $Y=0.115 $X2=0.513 $Y2=0.1207
r3 13 4 5.30507 $w=1.3e-08 $l=2.28e-08 $layer=M1 $thickness=3.6e-08 $X=0.511
+ $Y=0.115 $X2=0.513 $Y2=0.0922
r4 1 8 10.4265 $w=1.765e-08 $layer=LIG $thickness=5.2e-08 $X=0.513 $Y=0.135
+ $X2=0.513 $Y2=0.135
r5 1 15 19.3796 $a=3.24e-16 $layer=V0LIG $X=0.513 $Y=0.135 $X2=0.513 $Y2=0.135
r6 11 10 14.6259 $w=2.1e-08 $l=4.3e-08 $layer=Gate_1 $thickness=5.6e-08
+ $X=0.513 $Y=0.2025 $X2=0.513 $Y2=0.1595
r7 9 10 2.7211 $w=2.1e-08 $l=8e-09 $layer=Gate_1 $thickness=5.6e-08 $X=0.513
+ $Y=0.1515 $X2=0.513 $Y2=0.1595
r8 8 9 5.79936 $w=2.03333e-08 $l=1.65e-08 $layer=Gate_1 $thickness=5.6e-08
+ $X=0.513 $Y=0.135 $X2=0.513 $Y2=0.1515
r9 7 8 5.79936 $w=2.03333e-08 $l=1.65e-08 $layer=Gate_1 $thickness=5.6e-08
+ $X=0.513 $Y=0.1185 $X2=0.513 $Y2=0.135
r10 6 7 2.7211 $w=2.1e-08 $l=8e-09 $layer=Gate_1 $thickness=5.6e-08 $X=0.513
+ $Y=0.1105 $X2=0.513 $Y2=0.1185
r11 5 6 14.6259 $w=2.1e-08 $l=4.3e-08 $layer=Gate_1 $thickness=5.6e-08 $X=0.513
+ $Y=0.0675 $X2=0.513 $Y2=0.1105
r12 5 3 14.6259 $w=2.1e-08 $l=4.3e-08 $layer=Gate_1 $thickness=5.6e-08 $X=0.513
+ $Y=0.0675 $X2=0.513 $Y2=0.0245
.ends

.subckt PM_AO331x2_ASAP7_75t_R%B3 vss 11 5 9 4 3
c1 1 vss 0.00576238f $X=0.459 $Y=0.135
c2 3 vss 0.140022f $X=0.459 $Y=0.0245
c3 4 vss 0.00576581f $X=0.459 $Y=0.0922
r1 12 13 3.32295 $w=1.3e-08 $l=1.43e-08 $layer=M1 $thickness=3.6e-08 $X=0.459
+ $Y=0.1207 $X2=0.459 $Y2=0.135
r2 11 12 1.34084 $w=1.3e-08 $l=5.7e-09 $layer=M1 $thickness=3.6e-08 $X=0.457
+ $Y=0.115 $X2=0.459 $Y2=0.1207
r3 11 4 5.30507 $w=1.3e-08 $l=2.28e-08 $layer=M1 $thickness=3.6e-08 $X=0.457
+ $Y=0.115 $X2=0.459 $Y2=0.0922
r4 1 7 10.4265 $w=1.765e-08 $layer=LIG $thickness=5.2e-08 $X=0.459 $Y=0.135
+ $X2=0.459 $Y2=0.135
r5 1 13 19.3796 $a=3.24e-16 $layer=V0LIG $X=0.459 $Y=0.135 $X2=0.459 $Y2=0.135
r6 9 8 16.4967 $w=2.1e-08 $l=4.85e-08 $layer=Gate_1 $thickness=5.6e-08 $X=0.459
+ $Y=0.2025 $X2=0.459 $Y2=0.154
r7 7 8 6.6497 $w=2.04211e-08 $l=1.9e-08 $layer=Gate_1 $thickness=5.6e-08
+ $X=0.459 $Y=0.135 $X2=0.459 $Y2=0.154
r8 6 7 6.6497 $w=2.04211e-08 $l=1.9e-08 $layer=Gate_1 $thickness=5.6e-08
+ $X=0.459 $Y=0.116 $X2=0.459 $Y2=0.135
r9 5 6 16.4967 $w=2.1e-08 $l=4.85e-08 $layer=Gate_1 $thickness=5.6e-08 $X=0.459
+ $Y=0.0675 $X2=0.459 $Y2=0.116
r10 5 3 14.6259 $w=2.1e-08 $l=4.3e-08 $layer=Gate_1 $thickness=5.6e-08 $X=0.459
+ $Y=0.0675 $X2=0.459 $Y2=0.0245
.ends

.subckt PM_AO331x2_ASAP7_75t_R%Y vss 22 15 16 31 32 7 12 11 8
c1 1 vss 0.00834272f $X=0.108 $Y=0.0675
c2 2 vss 0.00982575f $X=0.108 $Y=0.2025
c3 7 vss 0.00425315f $X=0.0935 $Y=0.0675
c4 8 vss 0.00430015f $X=0.0935 $Y=0.2025
c5 9 vss 0.00298923f $X=0.081 $Y=0.036
c6 10 vss 0.00643325f $X=0.081 $Y=0.234
c7 11 vss 0.00792353f $X=0.081 $Y=0.054
c8 12 vss 0.00413465f $X=0.0945 $Y=0.036
r1 31 30 0.0308642 $w=8.1e-08 $l=2.5e-09 $layer=P_src_drn $thickness=1e-09
+ $X=0.1253 $Y=0.2025 $X2=0.1225 $Y2=0.2025
r2 2 30 0.179012 $w=8.1e-08 $l=1.45e-08 $layer=P_src_drn $thickness=1e-09
+ $X=0.108 $Y=0.2025 $X2=0.1225 $Y2=0.2025
r3 8 2 0.179012 $w=8.1e-08 $l=1.45e-08 $layer=P_src_drn $thickness=1e-09
+ $X=0.0935 $Y=0.2025 $X2=0.108 $Y2=0.2025
r4 32 8 0.0308642 $w=8.1e-08 $l=2.5e-09 $layer=P_src_drn $thickness=1e-09
+ $X=0.0906 $Y=0.2025 $X2=0.0935 $Y2=0.2025
r5 2 27 19.3796 $a=3.24e-16 $layer=V0LISD $X=0.108 $Y=0.2025 $X2=0.108 $Y2=0.234
r6 26 27 3.14806 $w=1.3e-08 $l=1.35e-08 $layer=M1 $thickness=3.6e-08 $X=0.0945
+ $Y=0.234 $X2=0.108 $Y2=0.234
r7 10 25 3.83327 $w=1.5093e-08 $l=2.15e-08 $layer=M1 $thickness=3.6e-08
+ $X=0.081 $Y=0.234 $X2=0.081 $Y2=0.2125
r8 10 26 1.96775 $w=1.63333e-08 $l=1.35e-08 $layer=M1 $thickness=3.6e-08
+ $X=0.081 $Y=0.234 $X2=0.0945 $Y2=0.234
r9 24 25 8.51143 $w=1.3e-08 $l=3.65e-08 $layer=M1 $thickness=3.6e-08 $X=0.081
+ $Y=0.176 $X2=0.081 $Y2=0.2125
r10 23 24 6.06293 $w=1.3e-08 $l=2.6e-08 $layer=M1 $thickness=3.6e-08 $X=0.081
+ $Y=0.15 $X2=0.081 $Y2=0.176
r11 22 23 0.582974 $w=1.3e-08 $l=2.5e-09 $layer=M1 $thickness=3.6e-08 $X=0.079
+ $Y=0.1475 $X2=0.081 $Y2=0.15
r12 22 21 9.91056 $w=1.3e-08 $l=4.25e-08 $layer=M1 $thickness=3.6e-08 $X=0.079
+ $Y=0.1475 $X2=0.081 $Y2=0.105
r13 11 21 11.8927 $w=1.3e-08 $l=5.1e-08 $layer=M1 $thickness=3.6e-08 $X=0.081
+ $Y=0.054 $X2=0.081 $Y2=0.105
r14 9 12 1.49895 $w=1.63333e-08 $l=1.35e-08 $layer=M1 $thickness=3.6e-08
+ $X=0.081 $Y=0.036 $X2=0.0945 $Y2=0.036
r15 9 11 2.5483 $w=1.79e-08 $l=1.8e-08 $layer=M1 $thickness=3.6e-08 $X=0.081
+ $Y=0.036 $X2=0.081 $Y2=0.054
r16 12 17 3.14806 $w=1.3e-08 $l=1.35e-08 $layer=M1 $thickness=3.6e-08 $X=0.0945
+ $Y=0.036 $X2=0.108 $Y2=0.036
r17 1 17 19.3796 $a=3.24e-16 $layer=V0LISD $X=0.108 $Y=0.0675 $X2=0.108
+ $Y2=0.036
r18 16 14 0.0308642 $w=8.1e-08 $l=2.5e-09 $layer=N_src_drn $thickness=1e-09
+ $X=0.1253 $Y=0.0675 $X2=0.1225 $Y2=0.0675
r19 1 14 0.179012 $w=8.1e-08 $l=1.45e-08 $layer=N_src_drn $thickness=1e-09
+ $X=0.108 $Y=0.0675 $X2=0.1225 $Y2=0.0675
r20 7 1 0.179012 $w=8.1e-08 $l=1.45e-08 $layer=N_src_drn $thickness=1e-09
+ $X=0.0935 $Y=0.0675 $X2=0.108 $Y2=0.0675
r21 15 7 0.0308642 $w=8.1e-08 $l=2.5e-09 $layer=N_src_drn $thickness=1e-09
+ $X=0.0906 $Y=0.0675 $X2=0.0935 $Y2=0.0675
.ends

.subckt PM_AO331x2_ASAP7_75t_R%3 vss 27 33 42 45 73 74 80 85 19 1 22 13 14 3 25
+ 16 5 4 26 15 24 17 18 23 12
c1 1 vss 0.00807086f $X=0.081 $Y=0.135
c2 3 vss 0.00510746f $X=0.324 $Y=0.0675
c3 4 vss 0.00863035f $X=0.54 $Y=0.0675
c4 5 vss 0.00967538f $X=0.54 $Y=0.2025
c5 12 vss 0.0846776f $X=0.081 $Y=0.0245
c6 13 vss 0.0810686f $X=0.135 $Y=0.135
c7 14 vss 0.00601882f $X=0.3095 $Y=0.0675
c8 15 vss 0.0409262f $X=0.5255 $Y=0.0675
c9 16 vss 0.0410001f $X=0.5255 $Y=0.2025
c10 17 vss 0.0008846f $X=0.135 $Y=0.072
c11 18 vss 0.00290822f $X=0.189 $Y=0.036
c12 19 vss 0.000680442f $X=0.189 $Y=0.0665
c13 20 vss 0.00805628f $X=0.567 $Y=0.234
c14 21 vss 0.00333831f $X=0.567 $Y=0.036
c15 22 vss 0.00233646f $X=0.135 $Y=0.116
c16 23 vss 0.00168503f $X=0.162 $Y=0.072
c17 24 vss 0.000620464f $X=0.189 $Y=0.054
c18 25 vss 0.0345076f $X=0.199 $Y=0.036
c19 26 vss 0.0105695f $X=0.567 $Y=0.0575
r1 16 5 0.154321 $w=8.1e-08 $l=1.25e-08 $layer=P_src_drn $thickness=1e-09
+ $X=0.5255 $Y=0.2025 $X2=0.54 $Y2=0.2025
r2 85 16 0.0308642 $w=8.1e-08 $l=2.5e-09 $layer=P_src_drn $thickness=1e-09
+ $X=0.5226 $Y=0.2025 $X2=0.5255 $Y2=0.2025
r3 5 82 19.3796 $a=3.24e-16 $layer=V0LISD $X=0.54 $Y=0.2025 $X2=0.54 $Y2=0.234
r4 82 83 3.14806 $w=1.3e-08 $l=1.35e-08 $layer=M1 $thickness=3.6e-08 $X=0.54
+ $Y=0.234 $X2=0.5535 $Y2=0.234
r5 20 78 3.01711 $w=1.55e-08 $l=1.8e-08 $layer=M1 $thickness=3.6e-08 $X=0.567
+ $Y=0.234 $X2=0.567 $Y2=0.216
r6 20 83 1.96775 $w=1.63333e-08 $l=1.35e-08 $layer=M1 $thickness=3.6e-08
+ $X=0.567 $Y=0.234 $X2=0.5535 $Y2=0.234
r7 15 4 0.154321 $w=8.1e-08 $l=1.25e-08 $layer=N_src_drn $thickness=1e-09
+ $X=0.5255 $Y=0.0675 $X2=0.54 $Y2=0.0675
r8 80 15 0.0308642 $w=8.1e-08 $l=2.5e-09 $layer=N_src_drn $thickness=1e-09
+ $X=0.5226 $Y=0.0675 $X2=0.5255 $Y2=0.0675
r9 77 78 4.19742 $w=1.3e-08 $l=1.8e-08 $layer=M1 $thickness=3.6e-08 $X=0.567
+ $Y=0.198 $X2=0.567 $Y2=0.216
r10 76 77 5.01358 $w=1.3e-08 $l=2.15e-08 $layer=M1 $thickness=3.6e-08 $X=0.567
+ $Y=0.1765 $X2=0.567 $Y2=0.198
r11 75 76 13.8748 $w=1.3e-08 $l=5.95e-08 $layer=M1 $thickness=3.6e-08 $X=0.567
+ $Y=0.117 $X2=0.567 $Y2=0.1765
r12 26 75 13.8748 $w=1.3e-08 $l=5.95e-08 $layer=M1 $thickness=3.6e-08 $X=0.567
+ $Y=0.0575 $X2=0.567 $Y2=0.117
r13 74 72 0.0308642 $w=8.1e-08 $l=2.5e-09 $layer=N_src_drn $thickness=1e-09
+ $X=0.3413 $Y=0.0675 $X2=0.3385 $Y2=0.0675
r14 3 72 0.179012 $w=8.1e-08 $l=1.45e-08 $layer=N_src_drn $thickness=1e-09
+ $X=0.324 $Y=0.0675 $X2=0.3385 $Y2=0.0675
r15 14 3 0.179012 $w=8.1e-08 $l=1.45e-08 $layer=N_src_drn $thickness=1e-09
+ $X=0.3095 $Y=0.0675 $X2=0.324 $Y2=0.0675
r16 73 14 0.0308642 $w=8.1e-08 $l=2.5e-09 $layer=N_src_drn $thickness=1e-09
+ $X=0.3066 $Y=0.0675 $X2=0.3095 $Y2=0.0675
r17 4 69 19.3796 $a=3.24e-16 $layer=V0LISD $X=0.54 $Y=0.0675 $X2=0.54 $Y2=0.036
r18 21 70 1.49895 $w=1.63333e-08 $l=1.35e-08 $layer=M1 $thickness=3.6e-08
+ $X=0.567 $Y=0.036 $X2=0.5535 $Y2=0.036
r19 21 26 3.36447 $w=1.71023e-08 $l=2.15e-08 $layer=M1 $thickness=3.6e-08
+ $X=0.567 $Y=0.036 $X2=0.567 $Y2=0.0575
r20 3 56 19.3796 $a=3.24e-16 $layer=V0LISD $X=0.324 $Y=0.0675 $X2=0.324
+ $Y2=0.036
r21 69 70 3.14806 $w=1.3e-08 $l=1.35e-08 $layer=M1 $thickness=3.6e-08 $X=0.54
+ $Y=0.036 $X2=0.5535 $Y2=0.036
r22 68 69 2.79828 $w=1.3e-08 $l=1.2e-08 $layer=M1 $thickness=3.6e-08 $X=0.528
+ $Y=0.036 $X2=0.54 $Y2=0.036
r23 67 68 1.04935 $w=1.3e-08 $l=4.5e-09 $layer=M1 $thickness=3.6e-08 $X=0.5235
+ $Y=0.036 $X2=0.528 $Y2=0.036
r24 66 67 2.44849 $w=1.3e-08 $l=1.05e-08 $layer=M1 $thickness=3.6e-08 $X=0.513
+ $Y=0.036 $X2=0.5235 $Y2=0.036
r25 65 66 2.44849 $w=1.3e-08 $l=1.05e-08 $layer=M1 $thickness=3.6e-08 $X=0.5025
+ $Y=0.036 $X2=0.513 $Y2=0.036
r26 64 65 4.19742 $w=1.3e-08 $l=1.8e-08 $layer=M1 $thickness=3.6e-08 $X=0.4845
+ $Y=0.036 $X2=0.5025 $Y2=0.036
r27 63 64 5.94634 $w=1.3e-08 $l=2.55e-08 $layer=M1 $thickness=3.6e-08 $X=0.459
+ $Y=0.036 $X2=0.4845 $Y2=0.036
r28 62 63 6.29612 $w=1.3e-08 $l=2.7e-08 $layer=M1 $thickness=3.6e-08 $X=0.432
+ $Y=0.036 $X2=0.459 $Y2=0.036
r29 61 62 6.29612 $w=1.3e-08 $l=2.7e-08 $layer=M1 $thickness=3.6e-08 $X=0.405
+ $Y=0.036 $X2=0.432 $Y2=0.036
r30 60 61 6.06293 $w=1.3e-08 $l=2.6e-08 $layer=M1 $thickness=3.6e-08 $X=0.379
+ $Y=0.036 $X2=0.405 $Y2=0.036
r31 59 60 4.19742 $w=1.3e-08 $l=1.8e-08 $layer=M1 $thickness=3.6e-08 $X=0.361
+ $Y=0.036 $X2=0.379 $Y2=0.036
r32 58 59 2.3319 $w=1.3e-08 $l=1e-08 $layer=M1 $thickness=3.6e-08 $X=0.351
+ $Y=0.036 $X2=0.361 $Y2=0.036
r33 57 58 3.14806 $w=1.3e-08 $l=1.35e-08 $layer=M1 $thickness=3.6e-08 $X=0.3375
+ $Y=0.036 $X2=0.351 $Y2=0.036
r34 56 57 3.14806 $w=1.3e-08 $l=1.35e-08 $layer=M1 $thickness=3.6e-08 $X=0.324
+ $Y=0.036 $X2=0.3375 $Y2=0.036
r35 55 56 3.14806 $w=1.3e-08 $l=1.35e-08 $layer=M1 $thickness=3.6e-08 $X=0.3105
+ $Y=0.036 $X2=0.324 $Y2=0.036
r36 54 55 3.14806 $w=1.3e-08 $l=1.35e-08 $layer=M1 $thickness=3.6e-08 $X=0.297
+ $Y=0.036 $X2=0.3105 $Y2=0.036
r37 53 54 6.29612 $w=1.3e-08 $l=2.7e-08 $layer=M1 $thickness=3.6e-08 $X=0.27
+ $Y=0.036 $X2=0.297 $Y2=0.036
r38 52 53 6.29612 $w=1.3e-08 $l=2.7e-08 $layer=M1 $thickness=3.6e-08 $X=0.243
+ $Y=0.036 $X2=0.27 $Y2=0.036
r39 51 52 6.06293 $w=1.3e-08 $l=2.6e-08 $layer=M1 $thickness=3.6e-08 $X=0.217
+ $Y=0.036 $X2=0.243 $Y2=0.036
r40 25 51 4.19742 $w=1.3e-08 $l=1.8e-08 $layer=M1 $thickness=3.6e-08 $X=0.199
+ $Y=0.036 $X2=0.217 $Y2=0.036
r41 18 24 2.5483 $w=1.79e-08 $l=1.8e-08 $layer=M1 $thickness=3.6e-08 $X=0.189
+ $Y=0.036 $X2=0.189 $Y2=0.054
r42 18 25 0.682785 $w=1.75e-08 $l=1e-08 $layer=M1 $thickness=3.6e-08 $X=0.189
+ $Y=0.036 $X2=0.199 $Y2=0.036
r43 19 23 4.55457 $w=1.3814e-08 $l=2.75545e-08 $layer=M1 $thickness=3.6e-08
+ $X=0.189 $Y=0.0665 $X2=0.162 $Y2=0.072
r44 19 24 2.45586 $w=1.44e-08 $l=1.25e-08 $layer=M1 $thickness=3.6e-08 $X=0.189
+ $Y=0.0665 $X2=0.189 $Y2=0.054
r45 17 49 3.36447 $w=1.71023e-08 $l=2.15e-08 $layer=M1 $thickness=3.6e-08
+ $X=0.135 $Y=0.072 $X2=0.135 $Y2=0.0935
r46 17 23 4.64701 $w=1.46667e-08 $l=2.7e-08 $layer=M1 $thickness=3.6e-08
+ $X=0.135 $Y=0.072 $X2=0.162 $Y2=0.072
r47 22 47 4.43061 $w=1.3e-08 $l=1.9e-08 $layer=M1 $thickness=3.6e-08 $X=0.135
+ $Y=0.116 $X2=0.135 $Y2=0.135
r48 22 49 5.24677 $w=1.3e-08 $l=2.25e-08 $layer=M1 $thickness=3.6e-08 $X=0.135
+ $Y=0.116 $X2=0.135 $Y2=0.0935
r49 45 44 16.4967 $w=2.1e-08 $l=4.85e-08 $layer=Gate_1 $thickness=5.6e-08
+ $X=0.135 $Y=0.2025 $X2=0.135 $Y2=0.154
r50 42 43 16.4967 $w=2.1e-08 $l=4.85e-08 $layer=Gate_1 $thickness=5.6e-08
+ $X=0.135 $Y=0.0675 $X2=0.135 $Y2=0.116
r51 13 38 6.27904 $w=2.09e-08 $layer=Gate_1 $thickness=5.24e-08 $X=0.135
+ $Y=0.135 $X2=0.135 $Y2=0.135
r52 13 43 6.6497 $w=2.04211e-08 $l=1.9e-08 $layer=Gate_1 $thickness=5.6e-08
+ $X=0.135 $Y=0.135 $X2=0.135 $Y2=0.116
r53 13 44 6.6497 $w=2.04211e-08 $l=1.9e-08 $layer=Gate_1 $thickness=5.6e-08
+ $X=0.135 $Y=0.135 $X2=0.135 $Y2=0.154
r54 38 47 19.3796 $a=3.24e-16 $layer=V0LIG $X=0.135 $Y=0.135 $X2=0.135 $Y2=0.135
r55 37 38 2.48102 $w=2.2e-08 $l=9.5e-09 $layer=LIG $thickness=4.8e-08 $X=0.1255
+ $Y=0.135 $X2=0.135 $Y2=0.135
r56 36 37 10.1729 $w=1.54914e-08 $l=1.75e-08 $layer=LIG $thickness=4.8e-08
+ $X=0.108 $Y=0.135 $X2=0.1255 $Y2=0.135
r57 1 30 6.54019 $w=2.09524e-08 $layer=Gate_1 $thickness=5.21905e-08 $X=0.081
+ $Y=0.135 $X2=0.081 $Y2=0.135
r58 1 36 12.6539 $w=1.77815e-08 $l=2.7e-08 $layer=LIG $thickness=4.8e-08
+ $X=0.081 $Y=0.135 $X2=0.108 $Y2=0.135
r59 33 32 14.6259 $w=2.1e-08 $l=4.3e-08 $layer=Gate_1 $thickness=5.6e-08
+ $X=0.081 $Y=0.2025 $X2=0.081 $Y2=0.1595
r60 31 32 2.7211 $w=2.1e-08 $l=8e-09 $layer=Gate_1 $thickness=5.6e-08 $X=0.081
+ $Y=0.1515 $X2=0.081 $Y2=0.1595
r61 30 31 5.79936 $w=2.03333e-08 $l=1.65e-08 $layer=Gate_1 $thickness=5.6e-08
+ $X=0.081 $Y=0.135 $X2=0.081 $Y2=0.1515
r62 29 30 5.79936 $w=2.03333e-08 $l=1.65e-08 $layer=Gate_1 $thickness=5.6e-08
+ $X=0.081 $Y=0.1185 $X2=0.081 $Y2=0.135
r63 28 29 2.7211 $w=2.1e-08 $l=8e-09 $layer=Gate_1 $thickness=5.6e-08 $X=0.081
+ $Y=0.1105 $X2=0.081 $Y2=0.1185
r64 27 28 14.6259 $w=2.1e-08 $l=4.3e-08 $layer=Gate_1 $thickness=5.6e-08
+ $X=0.081 $Y=0.0675 $X2=0.081 $Y2=0.1105
r65 27 12 14.6259 $w=2.1e-08 $l=4.3e-08 $layer=Gate_1 $thickness=5.6e-08
+ $X=0.081 $Y=0.0675 $X2=0.081 $Y2=0.0245
.ends

.subckt PM_AO331x2_ASAP7_75t_R%A2 vss 13 5 9 4 3
c1 1 vss 0.00462576f $X=0.243 $Y=0.135
c2 3 vss 0.121314f $X=0.243 $Y=0.0245
c3 4 vss 0.0069211f $X=0.243 $Y=0.0935
r1 14 15 3.32295 $w=1.3e-08 $l=1.43e-08 $layer=M1 $thickness=3.6e-08 $X=0.243
+ $Y=0.1207 $X2=0.243 $Y2=0.135
r2 13 14 1.34084 $w=1.3e-08 $l=5.7e-09 $layer=M1 $thickness=3.6e-08 $X=0.243
+ $Y=0.115 $X2=0.243 $Y2=0.1207
r3 13 12 1.10765 $w=1.3e-08 $l=4.8e-09 $layer=M1 $thickness=3.6e-08 $X=0.243
+ $Y=0.115 $X2=0.243 $Y2=0.1102
r4 4 12 3.90593 $w=1.3e-08 $l=1.67e-08 $layer=M1 $thickness=3.6e-08 $X=0.243
+ $Y=0.0935 $X2=0.243 $Y2=0.1102
r5 1 7 10.4265 $w=1.765e-08 $layer=LIG $thickness=5.2e-08 $X=0.243 $Y=0.135
+ $X2=0.243 $Y2=0.135
r6 1 15 19.3796 $a=3.24e-16 $layer=V0LIG $X=0.243 $Y=0.135 $X2=0.243 $Y2=0.135
r7 9 8 16.4967 $w=2.1e-08 $l=4.85e-08 $layer=Gate_1 $thickness=5.6e-08 $X=0.243
+ $Y=0.2025 $X2=0.243 $Y2=0.154
r8 7 8 6.6497 $w=2.04211e-08 $l=1.9e-08 $layer=Gate_1 $thickness=5.6e-08
+ $X=0.243 $Y=0.135 $X2=0.243 $Y2=0.154
r9 6 7 6.6497 $w=2.04211e-08 $l=1.9e-08 $layer=Gate_1 $thickness=5.6e-08
+ $X=0.243 $Y=0.116 $X2=0.243 $Y2=0.135
r10 5 6 16.4967 $w=2.1e-08 $l=4.85e-08 $layer=Gate_1 $thickness=5.6e-08
+ $X=0.243 $Y=0.0675 $X2=0.243 $Y2=0.116
r11 5 3 14.6259 $w=2.1e-08 $l=4.3e-08 $layer=Gate_1 $thickness=5.6e-08 $X=0.243
+ $Y=0.0675 $X2=0.243 $Y2=0.0245
.ends

.subckt PM_AO331x2_ASAP7_75t_R%A1 vss 11 5 9 3 4
c1 1 vss 0.00457623f $X=0.297 $Y=0.135
c2 3 vss 0.102382f $X=0.297 $Y=0.0245
c3 4 vss 0.00965049f $X=0.297 $Y=0.0922
r1 12 13 3.32295 $w=1.3e-08 $l=1.43e-08 $layer=M1 $thickness=3.6e-08 $X=0.297
+ $Y=0.1207 $X2=0.297 $Y2=0.135
r2 11 12 1.34084 $w=1.3e-08 $l=5.7e-09 $layer=M1 $thickness=3.6e-08 $X=0.297
+ $Y=0.115 $X2=0.297 $Y2=0.1207
r3 11 4 5.30507 $w=1.3e-08 $l=2.28e-08 $layer=M1 $thickness=3.6e-08 $X=0.297
+ $Y=0.115 $X2=0.297 $Y2=0.0922
r4 1 7 10.4265 $w=1.765e-08 $layer=LIG $thickness=5.2e-08 $X=0.297 $Y=0.135
+ $X2=0.297 $Y2=0.135
r5 1 13 19.3796 $a=3.24e-16 $layer=V0LIG $X=0.297 $Y=0.135 $X2=0.297 $Y2=0.135
r6 9 8 16.4967 $w=2.1e-08 $l=4.85e-08 $layer=Gate_1 $thickness=5.6e-08 $X=0.297
+ $Y=0.2025 $X2=0.297 $Y2=0.154
r7 7 8 6.6497 $w=2.04211e-08 $l=1.9e-08 $layer=Gate_1 $thickness=5.6e-08
+ $X=0.297 $Y=0.135 $X2=0.297 $Y2=0.154
r8 6 7 6.6497 $w=2.04211e-08 $l=1.9e-08 $layer=Gate_1 $thickness=5.6e-08
+ $X=0.297 $Y=0.116 $X2=0.297 $Y2=0.135
r9 5 6 16.4967 $w=2.1e-08 $l=4.85e-08 $layer=Gate_1 $thickness=5.6e-08 $X=0.297
+ $Y=0.0675 $X2=0.297 $Y2=0.116
r10 5 3 14.6259 $w=2.1e-08 $l=4.3e-08 $layer=Gate_1 $thickness=5.6e-08 $X=0.297
+ $Y=0.0675 $X2=0.297 $Y2=0.0245
.ends

* End of included file AO331x2_ASAP7_75t_R.pex.sp.pex

*
.subckt AO331x2_ASAP7_75t_CUSTOM_4_25_0_7 VSS VDD A3 A2 A1 B1 B2 B3 C Y
*
* VSS VSS
* VDD VDD
* A3 A3
* A2 A2
* A1 A1
* B1 B1
* B2 B2
* B3 B3
* C C
* Y Y
*
*

M0 N_M0_d N_M0_g VSS VSS nmos_rvt L=2e-08 W=8.1e-08 nfin=3 $X=0.071 $Y=0.027
M1 N_M1_d N_M1_g VSS VSS nmos_rvt L=2e-08 W=8.1e-08 nfin=3 $X=0.125 $Y=0.027
M2 noxref_14 N_M2_g VSS VSS nmos_rvt L=2e-08 W=8.1e-08 nfin=3 $X=0.179 $Y=0.027
M3 noxref_15 N_M3_g noxref_14 VSS nmos_rvt L=2e-08 W=8.1e-08 nfin=3 $X=0.233
+ $Y=0.027
M4 N_M4_d N_M4_g noxref_15 VSS nmos_rvt L=2e-08 W=8.1e-08 nfin=3 $X=0.287
+ $Y=0.027
M5 noxref_16 N_M5_g N_M5_s VSS nmos_rvt L=2e-08 W=8.1e-08 nfin=3 $X=0.341
+ $Y=0.027
M6 noxref_17 N_M6_g noxref_16 VSS nmos_rvt L=2e-08 W=8.1e-08 nfin=3 $X=0.395
+ $Y=0.027
M7 VSS N_M7_g noxref_17 VSS nmos_rvt L=2e-08 W=8.1e-08 nfin=3 $X=0.449 $Y=0.027
M8 N_M8_d N_M8_g VSS VSS nmos_rvt L=2e-08 W=8.1e-08 nfin=3 $X=0.503 $Y=0.027
M9 N_M9_d N_M9_g VDD VDD pmos_rvt L=2e-08 W=8.1e-08 nfin=3 $X=0.071 $Y=0.162
M10 N_M10_d N_M10_g VDD VDD pmos_rvt L=2e-08 W=8.1e-08 nfin=3 $X=0.125 $Y=0.162
M11 noxref_12 N_M11_g VDD VDD pmos_rvt L=2e-08 W=8.1e-08 nfin=3 $X=0.179
+ $Y=0.162
M12 VDD N_M12_g noxref_12 VDD pmos_rvt L=2e-08 W=8.1e-08 nfin=3 $X=0.233
+ $Y=0.162
M13 noxref_12 N_M13_g VDD VDD pmos_rvt L=2e-08 W=8.1e-08 nfin=3 $X=0.287
+ $Y=0.162
M14 noxref_13 N_M14_g noxref_12 VDD pmos_rvt L=2e-08 W=8.1e-08 nfin=3 $X=0.341
+ $Y=0.162
M15 noxref_12 N_M15_g noxref_13 VDD pmos_rvt L=2e-08 W=8.1e-08 nfin=3 $X=0.395
+ $Y=0.162
M16 noxref_13 N_M16_g noxref_12 VDD pmos_rvt L=2e-08 W=8.1e-08 nfin=3 $X=0.449
+ $Y=0.162
M17 N_M17_d N_M17_g noxref_13 VDD pmos_rvt L=2e-08 W=8.1e-08 nfin=3 $X=0.503
+ $Y=0.162

* .include "AO331x2_ASAP7_75t_R.pex.sp.pxi"

* Start of included file AO331x2_ASAP7_75t_R.pex.sp.pxi
x_PM_AO331x2_ASAP7_75t_R%A3 vss A3 N_M2_g N_M11_g N_A3_3 N_A3_4
+ PM_AO331x2_ASAP7_75t_R%A3
cc_1 N_A3_3 N_3_19 0.000550534f $X=0.189 $Y=0.0245
cc_2 N_A3_3 N_3_1 0.00208626f $X=0.189 $Y=0.0245
cc_3 N_A3_4 N_3_22 0.00319605f $X=0.189 $Y=0.1102
cc_4 N_A3_3 N_3_13 0.0039925f $X=0.189 $Y=0.0245
x_PM_AO331x2_ASAP7_75t_R%B2 vss B2 N_M6_g N_M15_g N_B2_4 N_B2_3
+ PM_AO331x2_ASAP7_75t_R%B2
cc_5 N_B2_4 N_3_3 0.000336454f $X=0.405 $Y=0.0922
cc_6 N_B2_4 N_3_25 0.00321659f $X=0.405 $Y=0.0922
cc_7 N_B2_4 N_B1_4 0.00337037f $X=0.405 $Y=0.0922
cc_8 N_B2_3 N_B1_3 0.00703114f $X=0.405 $Y=0.0245
x_PM_AO331x2_ASAP7_75t_R%B1 vss B1 N_M5_g N_M14_g N_B1_4 N_B1_3
+ PM_AO331x2_ASAP7_75t_R%B1
cc_9 N_B1_4 N_3_25 0.00127215f $X=0.351 $Y=0.0927
cc_10 N_B1_3 N_3_3 0.00151244f $X=0.351 $Y=0.0245
cc_11 N_B1_4 N_3_3 0.00172449f $X=0.351 $Y=0.0927
cc_12 N_B1_3 N_3_14 0.0361145f $X=0.351 $Y=0.0245
cc_13 N_B1_3 N_A1_3 0.00315943f $X=0.351 $Y=0.0245
cc_14 N_B1_4 N_A1_4 0.00528607f $X=0.351 $Y=0.0927
x_PM_AO331x2_ASAP7_75t_R%C vss C N_M8_g N_M17_g N_C_3 N_C_1 N_C_4
+ PM_AO331x2_ASAP7_75t_R%C
cc_15 N_C_3 N_3_16 0.0152527f $X=0.513 $Y=0.0245
cc_16 N_C_3 N_3_5 0.00176766f $X=0.513 $Y=0.0245
cc_17 N_C_3 N_3_25 0.00106917f $X=0.513 $Y=0.0245
cc_18 N_C_3 N_3_4 0.00120614f $X=0.513 $Y=0.0245
cc_19 N_C_1 N_3_16 0.0016609f $X=0.513 $Y=0.135
cc_20 N_C_4 N_3_26 0.0059912f $X=0.513 $Y=0.0922
cc_21 N_C_3 N_3_15 0.0538132f $X=0.513 $Y=0.0245
cc_22 N_C_4 N_B3_4 0.00323189f $X=0.513 $Y=0.0922
cc_23 N_C_3 N_B3_3 0.00510612f $X=0.513 $Y=0.0245
x_PM_AO331x2_ASAP7_75t_R%B3 vss B3 N_M7_g N_M16_g N_B3_4 N_B3_3
+ PM_AO331x2_ASAP7_75t_R%B3
cc_24 N_B3_4 N_3_25 0.00312883f $X=0.459 $Y=0.0922
cc_25 N_B3_4 N_B2_4 0.00333473f $X=0.459 $Y=0.0922
cc_26 N_B3_3 N_B2_3 0.00699379f $X=0.459 $Y=0.0245
x_PM_AO331x2_ASAP7_75t_R%Y vss Y N_M0_d N_M1_d N_M10_d N_M9_d N_Y_7 N_Y_12
+ N_Y_11 N_Y_8 PM_AO331x2_ASAP7_75t_R%Y
cc_27 N_Y_7 N_3_24 0.000233941f $X=0.0935 $Y=0.0675
cc_28 N_Y_7 N_3_17 0.000256228f $X=0.0935 $Y=0.0675
cc_29 N_Y_7 N_3_18 0.00035689f $X=0.0935 $Y=0.0675
cc_30 N_Y_7 N_3_23 0.000416627f $X=0.0935 $Y=0.0675
cc_31 N_Y_7 N_3_1 0.000735312f $X=0.0935 $Y=0.0675
cc_32 N_Y_7 N_3_13 0.036765f $X=0.0935 $Y=0.0675
cc_33 N_Y_12 N_3_17 0.0023914f $X=0.0945 $Y=0.036
cc_34 N_Y_11 N_3_22 0.00455218f $X=0.081 $Y=0.054
cc_35 N_Y_8 N_3_1 0.00492473f $X=0.0935 $Y=0.2025
cc_36 N_Y_8 N_3_13 0.028308f $X=0.0935 $Y=0.2025
cc_37 N_Y_7 N_3_12 0.0693181f $X=0.0935 $Y=0.0675
x_PM_AO331x2_ASAP7_75t_R%3 vss N_M0_g N_M9_g N_M1_g N_M10_g N_M4_d N_M5_s
+ N_M8_d N_M17_d N_3_19 N_3_1 N_3_22 N_3_13 N_3_14 N_3_3 N_3_25 N_3_16 N_3_5
+ N_3_4 N_3_26 N_3_15 N_3_24 N_3_17 N_3_18 N_3_23 N_3_12
+ PM_AO331x2_ASAP7_75t_R%3
x_PM_AO331x2_ASAP7_75t_R%A2 vss A2 N_M3_g N_M12_g N_A2_4 N_A2_3
+ PM_AO331x2_ASAP7_75t_R%A2
cc_38 N_A2_4 N_3_14 0.000196921f $X=0.243 $Y=0.0935
cc_39 N_A2_4 N_3_3 0.000335951f $X=0.243 $Y=0.0935
cc_40 N_A2_4 N_3_25 0.00134747f $X=0.243 $Y=0.0935
cc_41 N_A2_4 N_3_19 0.00285317f $X=0.243 $Y=0.0935
cc_42 N_A2_4 N_A3_4 0.00363357f $X=0.243 $Y=0.0935
cc_43 N_A2_3 N_A3_3 0.00699177f $X=0.243 $Y=0.0245
x_PM_AO331x2_ASAP7_75t_R%A1 vss A1 N_M4_g N_M13_g N_A1_3 N_A1_4
+ PM_AO331x2_ASAP7_75t_R%A1
cc_44 N_A1_3 N_3_3 0.00179105f $X=0.297 $Y=0.0245
cc_45 N_A1_4 N_3_25 0.00126406f $X=0.297 $Y=0.0922
cc_46 N_A1_4 N_3_3 0.00186404f $X=0.297 $Y=0.0922
cc_47 N_A1_3 N_3_14 0.0361422f $X=0.297 $Y=0.0245
cc_48 N_A1_4 N_A2_4 0.00464513f $X=0.297 $Y=0.0922
cc_49 N_A1_3 N_A2_3 0.00694257f $X=0.297 $Y=0.0245

* End of included file AO331x2_ASAP7_75t_R.pex.sp.pxi
.ends

.subckt PM_AO332x2_ASAP7_75t_R%A3 vss 11 5 9 3 4
c1 1 vss 0.00581656f $X=0.189 $Y=0.135
c2 3 vss 0.139755f $X=0.189 $Y=0.0245
c3 4 vss 0.00674135f $X=0.189 $Y=0.1102
r1 12 13 3.32295 $w=1.3e-08 $l=1.43e-08 $layer=M1 $thickness=3.6e-08 $X=0.189
+ $Y=0.1207 $X2=0.189 $Y2=0.135
r2 11 12 1.34084 $w=1.3e-08 $l=5.7e-09 $layer=M1 $thickness=3.6e-08 $X=0.189
+ $Y=0.115 $X2=0.189 $Y2=0.1207
r3 11 4 1.10765 $w=1.3e-08 $l=4.8e-09 $layer=M1 $thickness=3.6e-08 $X=0.189
+ $Y=0.115 $X2=0.189 $Y2=0.1102
r4 1 7 10.4265 $w=1.765e-08 $layer=LIG $thickness=5.2e-08 $X=0.189 $Y=0.135
+ $X2=0.189 $Y2=0.135
r5 1 13 19.3796 $a=3.24e-16 $layer=V0LIG $X=0.189 $Y=0.135 $X2=0.189 $Y2=0.135
r6 9 8 16.4967 $w=2.1e-08 $l=4.85e-08 $layer=Gate_1 $thickness=5.6e-08 $X=0.189
+ $Y=0.2025 $X2=0.189 $Y2=0.154
r7 7 8 6.6497 $w=2.04211e-08 $l=1.9e-08 $layer=Gate_1 $thickness=5.6e-08
+ $X=0.189 $Y=0.135 $X2=0.189 $Y2=0.154
r8 6 7 6.6497 $w=2.04211e-08 $l=1.9e-08 $layer=Gate_1 $thickness=5.6e-08
+ $X=0.189 $Y=0.116 $X2=0.189 $Y2=0.135
r9 5 6 16.4967 $w=2.1e-08 $l=4.85e-08 $layer=Gate_1 $thickness=5.6e-08 $X=0.189
+ $Y=0.0675 $X2=0.189 $Y2=0.116
r10 5 3 14.6259 $w=2.1e-08 $l=4.3e-08 $layer=Gate_1 $thickness=5.6e-08 $X=0.189
+ $Y=0.0675 $X2=0.189 $Y2=0.0245
.ends

.subckt PM_AO332x2_ASAP7_75t_R%B2 vss 11 5 9 4 3
c1 1 vss 0.00485839f $X=0.405 $Y=0.135
c2 3 vss 0.121201f $X=0.405 $Y=0.0245
c3 4 vss 0.00515985f $X=0.405 $Y=0.0922
r1 12 13 3.32295 $w=1.3e-08 $l=1.43e-08 $layer=M1 $thickness=3.6e-08 $X=0.405
+ $Y=0.1207 $X2=0.405 $Y2=0.135
r2 11 12 1.34084 $w=1.3e-08 $l=5.7e-09 $layer=M1 $thickness=3.6e-08 $X=0.404
+ $Y=0.115 $X2=0.405 $Y2=0.1207
r3 11 4 5.30507 $w=1.3e-08 $l=2.28e-08 $layer=M1 $thickness=3.6e-08 $X=0.404
+ $Y=0.115 $X2=0.405 $Y2=0.0922
r4 1 7 10.4265 $w=1.765e-08 $layer=LIG $thickness=5.2e-08 $X=0.405 $Y=0.135
+ $X2=0.405 $Y2=0.135
r5 1 13 19.3796 $a=3.24e-16 $layer=V0LIG $X=0.405 $Y=0.135 $X2=0.405 $Y2=0.135
r6 9 8 16.4967 $w=2.1e-08 $l=4.85e-08 $layer=Gate_1 $thickness=5.6e-08 $X=0.405
+ $Y=0.2025 $X2=0.405 $Y2=0.154
r7 7 8 6.6497 $w=2.04211e-08 $l=1.9e-08 $layer=Gate_1 $thickness=5.6e-08
+ $X=0.405 $Y=0.135 $X2=0.405 $Y2=0.154
r8 6 7 6.6497 $w=2.04211e-08 $l=1.9e-08 $layer=Gate_1 $thickness=5.6e-08
+ $X=0.405 $Y=0.116 $X2=0.405 $Y2=0.135
r9 5 6 16.4967 $w=2.1e-08 $l=4.85e-08 $layer=Gate_1 $thickness=5.6e-08 $X=0.405
+ $Y=0.0675 $X2=0.405 $Y2=0.116
r10 5 3 14.6259 $w=2.1e-08 $l=4.3e-08 $layer=Gate_1 $thickness=5.6e-08 $X=0.405
+ $Y=0.0675 $X2=0.405 $Y2=0.0245
.ends

.subckt PM_AO332x2_ASAP7_75t_R%B3 vss 11 5 9 4 3
c1 1 vss 0.00602838f $X=0.459 $Y=0.135
c2 3 vss 0.140101f $X=0.459 $Y=0.0245
c3 4 vss 0.00540912f $X=0.459 $Y=0.0922
r1 12 13 3.32295 $w=1.3e-08 $l=1.43e-08 $layer=M1 $thickness=3.6e-08 $X=0.459
+ $Y=0.1207 $X2=0.459 $Y2=0.135
r2 11 12 1.34084 $w=1.3e-08 $l=5.7e-09 $layer=M1 $thickness=3.6e-08 $X=0.457
+ $Y=0.115 $X2=0.459 $Y2=0.1207
r3 11 4 5.30507 $w=1.3e-08 $l=2.28e-08 $layer=M1 $thickness=3.6e-08 $X=0.457
+ $Y=0.115 $X2=0.459 $Y2=0.0922
r4 1 7 10.4265 $w=1.765e-08 $layer=LIG $thickness=5.2e-08 $X=0.459 $Y=0.135
+ $X2=0.459 $Y2=0.135
r5 1 13 19.3796 $a=3.24e-16 $layer=V0LIG $X=0.459 $Y=0.135 $X2=0.459 $Y2=0.135
r6 9 8 16.4967 $w=2.1e-08 $l=4.85e-08 $layer=Gate_1 $thickness=5.6e-08 $X=0.459
+ $Y=0.2025 $X2=0.459 $Y2=0.154
r7 7 8 6.6497 $w=2.04211e-08 $l=1.9e-08 $layer=Gate_1 $thickness=5.6e-08
+ $X=0.459 $Y=0.135 $X2=0.459 $Y2=0.154
r8 6 7 6.6497 $w=2.04211e-08 $l=1.9e-08 $layer=Gate_1 $thickness=5.6e-08
+ $X=0.459 $Y=0.116 $X2=0.459 $Y2=0.135
r9 5 6 16.4967 $w=2.1e-08 $l=4.85e-08 $layer=Gate_1 $thickness=5.6e-08 $X=0.459
+ $Y=0.0675 $X2=0.459 $Y2=0.116
r10 5 3 14.6259 $w=2.1e-08 $l=4.3e-08 $layer=Gate_1 $thickness=5.6e-08 $X=0.459
+ $Y=0.0675 $X2=0.459 $Y2=0.0245
.ends

.subckt PM_AO332x2_ASAP7_75t_R%C2 vss 11 5 9 3 4
c1 1 vss 0.00663386f $X=0.513 $Y=0.135
c2 3 vss 0.102318f $X=0.513 $Y=0.0245
c3 4 vss 0.00435631f $X=0.513 $Y=0.0917
r1 12 13 3.43955 $w=1.3e-08 $l=1.48e-08 $layer=M1 $thickness=3.6e-08 $X=0.513
+ $Y=0.1202 $X2=0.513 $Y2=0.135
r2 11 12 1.45744 $w=1.3e-08 $l=6.2e-09 $layer=M1 $thickness=3.6e-08 $X=0.514
+ $Y=0.114 $X2=0.513 $Y2=0.1202
r3 11 4 5.18847 $w=1.3e-08 $l=2.23e-08 $layer=M1 $thickness=3.6e-08 $X=0.514
+ $Y=0.114 $X2=0.513 $Y2=0.0917
r4 1 7 10.4265 $w=1.765e-08 $layer=LIG $thickness=5.2e-08 $X=0.513 $Y=0.135
+ $X2=0.513 $Y2=0.135
r5 1 13 19.3796 $a=3.24e-16 $layer=V0LIG $X=0.513 $Y=0.135 $X2=0.513 $Y2=0.135
r6 9 8 16.4967 $w=2.1e-08 $l=4.85e-08 $layer=Gate_1 $thickness=5.6e-08 $X=0.513
+ $Y=0.2025 $X2=0.513 $Y2=0.154
r7 7 8 6.6497 $w=2.04211e-08 $l=1.9e-08 $layer=Gate_1 $thickness=5.6e-08
+ $X=0.513 $Y=0.135 $X2=0.513 $Y2=0.154
r8 6 7 6.6497 $w=2.04211e-08 $l=1.9e-08 $layer=Gate_1 $thickness=5.6e-08
+ $X=0.513 $Y=0.116 $X2=0.513 $Y2=0.135
r9 5 6 16.4967 $w=2.1e-08 $l=4.85e-08 $layer=Gate_1 $thickness=5.6e-08 $X=0.513
+ $Y=0.0675 $X2=0.513 $Y2=0.116
r10 5 3 14.6259 $w=2.1e-08 $l=4.3e-08 $layer=Gate_1 $thickness=5.6e-08 $X=0.513
+ $Y=0.0675 $X2=0.513 $Y2=0.0245
.ends

.subckt PM_AO332x2_ASAP7_75t_R%A1 vss 11 5 9 3 4
c1 1 vss 0.00474385f $X=0.297 $Y=0.135
c2 3 vss 0.102418f $X=0.297 $Y=0.0245
c3 4 vss 0.00649434f $X=0.297 $Y=0.0922
r1 12 13 3.32295 $w=1.3e-08 $l=1.43e-08 $layer=M1 $thickness=3.6e-08 $X=0.297
+ $Y=0.1207 $X2=0.297 $Y2=0.135
r2 11 12 1.34084 $w=1.3e-08 $l=5.7e-09 $layer=M1 $thickness=3.6e-08 $X=0.297
+ $Y=0.115 $X2=0.297 $Y2=0.1207
r3 11 4 5.30507 $w=1.3e-08 $l=2.28e-08 $layer=M1 $thickness=3.6e-08 $X=0.297
+ $Y=0.115 $X2=0.297 $Y2=0.0922
r4 1 7 10.4265 $w=1.765e-08 $layer=LIG $thickness=5.2e-08 $X=0.297 $Y=0.135
+ $X2=0.297 $Y2=0.135
r5 1 13 19.3796 $a=3.24e-16 $layer=V0LIG $X=0.297 $Y=0.135 $X2=0.297 $Y2=0.135
r6 9 8 16.4967 $w=2.1e-08 $l=4.85e-08 $layer=Gate_1 $thickness=5.6e-08 $X=0.297
+ $Y=0.2025 $X2=0.297 $Y2=0.154
r7 7 8 6.6497 $w=2.04211e-08 $l=1.9e-08 $layer=Gate_1 $thickness=5.6e-08
+ $X=0.297 $Y=0.135 $X2=0.297 $Y2=0.154
r8 6 7 6.6497 $w=2.04211e-08 $l=1.9e-08 $layer=Gate_1 $thickness=5.6e-08
+ $X=0.297 $Y=0.116 $X2=0.297 $Y2=0.135
r9 5 6 16.4967 $w=2.1e-08 $l=4.85e-08 $layer=Gate_1 $thickness=5.6e-08 $X=0.297
+ $Y=0.0675 $X2=0.297 $Y2=0.116
r10 5 3 14.6259 $w=2.1e-08 $l=4.3e-08 $layer=Gate_1 $thickness=5.6e-08 $X=0.297
+ $Y=0.0675 $X2=0.297 $Y2=0.0245
.ends

.subckt PM_AO332x2_ASAP7_75t_R%C1 vss 13 5 11 3 4 1
c1 1 vss 0.0029228f $X=0.567 $Y=0.135
c2 3 vss 0.0707089f $X=0.567 $Y=0.0245
c3 4 vss 0.00493396f $X=0.567 $Y=0.0922
r1 14 15 3.32295 $w=1.3e-08 $l=1.43e-08 $layer=M1 $thickness=3.6e-08 $X=0.567
+ $Y=0.1207 $X2=0.567 $Y2=0.135
r2 13 14 1.34084 $w=1.3e-08 $l=5.7e-09 $layer=M1 $thickness=3.6e-08 $X=0.567
+ $Y=0.115 $X2=0.567 $Y2=0.1207
r3 13 4 5.30507 $w=1.3e-08 $l=2.28e-08 $layer=M1 $thickness=3.6e-08 $X=0.567
+ $Y=0.115 $X2=0.567 $Y2=0.0922
r4 1 8 10.4265 $w=1.765e-08 $layer=LIG $thickness=5.2e-08 $X=0.567 $Y=0.135
+ $X2=0.567 $Y2=0.135
r5 1 15 19.3796 $a=3.24e-16 $layer=V0LIG $X=0.567 $Y=0.135 $X2=0.567 $Y2=0.135
r6 11 10 14.6259 $w=2.1e-08 $l=4.3e-08 $layer=Gate_1 $thickness=5.6e-08
+ $X=0.567 $Y=0.2025 $X2=0.567 $Y2=0.1595
r7 9 10 2.7211 $w=2.1e-08 $l=8e-09 $layer=Gate_1 $thickness=5.6e-08 $X=0.567
+ $Y=0.1515 $X2=0.567 $Y2=0.1595
r8 8 9 5.79936 $w=2.03333e-08 $l=1.65e-08 $layer=Gate_1 $thickness=5.6e-08
+ $X=0.567 $Y=0.135 $X2=0.567 $Y2=0.1515
r9 7 8 5.79936 $w=2.03333e-08 $l=1.65e-08 $layer=Gate_1 $thickness=5.6e-08
+ $X=0.567 $Y=0.1185 $X2=0.567 $Y2=0.135
r10 6 7 2.7211 $w=2.1e-08 $l=8e-09 $layer=Gate_1 $thickness=5.6e-08 $X=0.567
+ $Y=0.1105 $X2=0.567 $Y2=0.1185
r11 5 6 14.6259 $w=2.1e-08 $l=4.3e-08 $layer=Gate_1 $thickness=5.6e-08 $X=0.567
+ $Y=0.0675 $X2=0.567 $Y2=0.1105
r12 5 3 14.6259 $w=2.1e-08 $l=4.3e-08 $layer=Gate_1 $thickness=5.6e-08 $X=0.567
+ $Y=0.0675 $X2=0.567 $Y2=0.0245
.ends

.subckt PM_AO332x2_ASAP7_75t_R%Y vss 23 16 17 31 32 8 12 7
c1 1 vss 0.00854241f $X=0.108 $Y=0.0675
c2 2 vss 0.010011f $X=0.108 $Y=0.2025
c3 7 vss 0.00438268f $X=0.0935 $Y=0.0675
c4 8 vss 0.00441437f $X=0.0935 $Y=0.2025
c5 9 vss 0.0029151f $X=0.027 $Y=0.036
c6 10 vss 0.00291978f $X=0.027 $Y=0.234
c7 11 vss 0.00882792f $X=0.027 $Y=0.054
c8 12 vss 0.0103414f $X=0.0675 $Y=0.036
c9 13 vss 0.00886735f $X=0.0675 $Y=0.234
r1 32 30 0.0308642 $w=8.1e-08 $l=2.5e-09 $layer=P_src_drn $thickness=1e-09
+ $X=0.1253 $Y=0.2025 $X2=0.1225 $Y2=0.2025
r2 2 30 0.179012 $w=8.1e-08 $l=1.45e-08 $layer=P_src_drn $thickness=1e-09
+ $X=0.108 $Y=0.2025 $X2=0.1225 $Y2=0.2025
r3 8 2 0.179012 $w=8.1e-08 $l=1.45e-08 $layer=P_src_drn $thickness=1e-09
+ $X=0.0935 $Y=0.2025 $X2=0.108 $Y2=0.2025
r4 31 8 0.0308642 $w=8.1e-08 $l=2.5e-09 $layer=P_src_drn $thickness=1e-09
+ $X=0.0906 $Y=0.2025 $X2=0.0935 $Y2=0.2025
r5 2 27 19.3796 $a=3.24e-16 $layer=V0LISD $X=0.108 $Y=0.2025 $X2=0.108 $Y2=0.234
r6 13 27 9.44419 $w=1.3e-08 $l=4.05e-08 $layer=M1 $thickness=3.6e-08 $X=0.0675
+ $Y=0.234 $X2=0.108 $Y2=0.234
r7 10 26 3.36447 $w=1.71023e-08 $l=2.15e-08 $layer=M1 $thickness=3.6e-08
+ $X=0.027 $Y=0.234 $X2=0.027 $Y2=0.2125
r8 10 13 7.79507 $w=1.41111e-08 $l=4.05e-08 $layer=M1 $thickness=3.6e-08
+ $X=0.027 $Y=0.234 $X2=0.0675 $Y2=0.234
r9 25 26 8.62802 $w=1.3e-08 $l=3.7e-08 $layer=M1 $thickness=3.6e-08 $X=0.027
+ $Y=0.1755 $X2=0.027 $Y2=0.2125
r10 24 25 6.99569 $w=1.3e-08 $l=3e-08 $layer=M1 $thickness=3.6e-08 $X=0.027
+ $Y=0.1455 $X2=0.027 $Y2=0.1755
r11 23 24 1.39914 $w=1.3e-08 $l=6e-09 $layer=M1 $thickness=3.6e-08 $X=0.0285
+ $Y=0.1395 $X2=0.027 $Y2=0.1455
r12 23 22 8.97781 $w=1.3e-08 $l=3.85e-08 $layer=M1 $thickness=3.6e-08 $X=0.0285
+ $Y=0.1395 $X2=0.027 $Y2=0.101
r13 11 22 10.9599 $w=1.3e-08 $l=4.7e-08 $layer=M1 $thickness=3.6e-08 $X=0.027
+ $Y=0.054 $X2=0.027 $Y2=0.101
r14 9 12 7.79507 $w=1.41111e-08 $l=4.05e-08 $layer=M1 $thickness=3.6e-08
+ $X=0.027 $Y=0.036 $X2=0.0675 $Y2=0.036
r15 9 11 2.5483 $w=1.79e-08 $l=1.8e-08 $layer=M1 $thickness=3.6e-08 $X=0.027
+ $Y=0.036 $X2=0.027 $Y2=0.054
r16 12 18 9.44419 $w=1.3e-08 $l=4.05e-08 $layer=M1 $thickness=3.6e-08 $X=0.0675
+ $Y=0.036 $X2=0.108 $Y2=0.036
r17 1 18 19.3796 $a=3.24e-16 $layer=V0LISD $X=0.108 $Y=0.0675 $X2=0.108
+ $Y2=0.036
r18 17 15 0.0308642 $w=8.1e-08 $l=2.5e-09 $layer=N_src_drn $thickness=1e-09
+ $X=0.1253 $Y=0.0675 $X2=0.1225 $Y2=0.0675
r19 1 15 0.179012 $w=8.1e-08 $l=1.45e-08 $layer=N_src_drn $thickness=1e-09
+ $X=0.108 $Y=0.0675 $X2=0.1225 $Y2=0.0675
r20 7 1 0.179012 $w=8.1e-08 $l=1.45e-08 $layer=N_src_drn $thickness=1e-09
+ $X=0.0935 $Y=0.0675 $X2=0.108 $Y2=0.0675
r21 16 7 0.0308642 $w=8.1e-08 $l=2.5e-09 $layer=N_src_drn $thickness=1e-09
+ $X=0.0906 $Y=0.0675 $X2=0.0935 $Y2=0.0675
.ends

.subckt PM_AO332x2_ASAP7_75t_R%3 vss 28 34 43 46 76 77 81 89 90 23 19 1 22 13
+ 14 3 25 4 26 16 15 5 27 17 18 12
c1 1 vss 0.00742348f $X=0.081 $Y=0.135
c2 3 vss 0.00505507f $X=0.324 $Y=0.0675
c3 4 vss 0.0100003f $X=0.54 $Y=0.2025
c4 5 vss 0.0070391f $X=0.594 $Y=0.0675
c5 12 vss 0.0837917f $X=0.081 $Y=0.0245
c6 13 vss 0.0808975f $X=0.135 $Y=0.135
c7 14 vss 0.00512704f $X=0.3095 $Y=0.0675
c8 15 vss 0.0399706f $X=0.5795 $Y=0.0675
c9 16 vss 0.00650244f $X=0.5255 $Y=0.2025
c10 17 vss 0.000780465f $X=0.135 $Y=0.072
c11 18 vss 0.00289297f $X=0.189 $Y=0.036
c12 19 vss 0.000706282f $X=0.189 $Y=0.0665
c13 20 vss 0.0032066f $X=0.621 $Y=0.036
c14 21 vss 0.00298873f $X=0.621 $Y=0.198
c15 22 vss 0.00250397f $X=0.135 $Y=0.116
c16 23 vss 0.00149905f $X=0.146 $Y=0.072
c17 24 vss 0.000650822f $X=0.189 $Y=0.054
c18 25 vss 0.0385658f $X=0.199 $Y=0.036
c19 26 vss 0.00905029f $X=0.611 $Y=0.198
c20 27 vss 0.00777039f $X=0.621 $Y=0.0575
r1 90 88 0.0308642 $w=8.1e-08 $l=2.5e-09 $layer=P_src_drn $thickness=1e-09
+ $X=0.5573 $Y=0.2025 $X2=0.5545 $Y2=0.2025
r2 4 88 0.179012 $w=8.1e-08 $l=1.45e-08 $layer=P_src_drn $thickness=1e-09
+ $X=0.54 $Y=0.2025 $X2=0.5545 $Y2=0.2025
r3 16 4 0.179012 $w=8.1e-08 $l=1.45e-08 $layer=P_src_drn $thickness=1e-09
+ $X=0.5255 $Y=0.2025 $X2=0.54 $Y2=0.2025
r4 89 16 0.0308642 $w=8.1e-08 $l=2.5e-09 $layer=P_src_drn $thickness=1e-09
+ $X=0.5226 $Y=0.2025 $X2=0.5255 $Y2=0.2025
r5 4 85 19.3796 $a=3.24e-16 $layer=V0LISD $X=0.54 $Y=0.2025 $X2=0.54 $Y2=0.198
r6 85 86 3.14806 $w=1.3e-08 $l=1.35e-08 $layer=M1 $thickness=3.6e-08 $X=0.54
+ $Y=0.198 $X2=0.5535 $Y2=0.198
r7 83 86 3.14806 $w=1.3e-08 $l=1.35e-08 $layer=M1 $thickness=3.6e-08 $X=0.567
+ $Y=0.198 $X2=0.5535 $Y2=0.198
r8 82 83 6.06293 $w=1.3e-08 $l=2.6e-08 $layer=M1 $thickness=3.6e-08 $X=0.593
+ $Y=0.198 $X2=0.567 $Y2=0.198
r9 26 82 4.19742 $w=1.3e-08 $l=1.8e-08 $layer=M1 $thickness=3.6e-08 $X=0.611
+ $Y=0.198 $X2=0.593 $Y2=0.198
r10 21 79 3.36447 $w=1.71023e-08 $l=2.15e-08 $layer=M1 $thickness=3.6e-08
+ $X=0.621 $Y=0.198 $X2=0.621 $Y2=0.1765
r11 21 26 0.682785 $w=1.75e-08 $l=1e-08 $layer=M1 $thickness=3.6e-08 $X=0.621
+ $Y=0.198 $X2=0.611 $Y2=0.198
r12 15 5 0.154321 $w=8.1e-08 $l=1.25e-08 $layer=N_src_drn $thickness=1e-09
+ $X=0.5795 $Y=0.0675 $X2=0.594 $Y2=0.0675
r13 81 15 0.0308642 $w=8.1e-08 $l=2.5e-09 $layer=N_src_drn $thickness=1e-09
+ $X=0.5766 $Y=0.0675 $X2=0.5795 $Y2=0.0675
r14 78 79 13.8748 $w=1.3e-08 $l=5.95e-08 $layer=M1 $thickness=3.6e-08 $X=0.621
+ $Y=0.117 $X2=0.621 $Y2=0.1765
r15 27 78 13.8748 $w=1.3e-08 $l=5.95e-08 $layer=M1 $thickness=3.6e-08 $X=0.621
+ $Y=0.0575 $X2=0.621 $Y2=0.117
r16 77 75 0.0308642 $w=8.1e-08 $l=2.5e-09 $layer=N_src_drn $thickness=1e-09
+ $X=0.3413 $Y=0.0675 $X2=0.3385 $Y2=0.0675
r17 3 75 0.179012 $w=8.1e-08 $l=1.45e-08 $layer=N_src_drn $thickness=1e-09
+ $X=0.324 $Y=0.0675 $X2=0.3385 $Y2=0.0675
r18 14 3 0.179012 $w=8.1e-08 $l=1.45e-08 $layer=N_src_drn $thickness=1e-09
+ $X=0.3095 $Y=0.0675 $X2=0.324 $Y2=0.0675
r19 76 14 0.0308642 $w=8.1e-08 $l=2.5e-09 $layer=N_src_drn $thickness=1e-09
+ $X=0.3066 $Y=0.0675 $X2=0.3095 $Y2=0.0675
r20 5 72 19.3796 $a=3.24e-16 $layer=V0LISD $X=0.594 $Y=0.0675 $X2=0.594
+ $Y2=0.036
r21 20 73 1.49895 $w=1.63333e-08 $l=1.35e-08 $layer=M1 $thickness=3.6e-08
+ $X=0.621 $Y=0.036 $X2=0.6075 $Y2=0.036
r22 20 27 3.36447 $w=1.71023e-08 $l=2.15e-08 $layer=M1 $thickness=3.6e-08
+ $X=0.621 $Y=0.036 $X2=0.621 $Y2=0.0575
r23 3 58 19.3796 $a=3.24e-16 $layer=V0LISD $X=0.324 $Y=0.0675 $X2=0.324
+ $Y2=0.036
r24 72 73 3.14806 $w=1.3e-08 $l=1.35e-08 $layer=M1 $thickness=3.6e-08 $X=0.594
+ $Y=0.036 $X2=0.6075 $Y2=0.036
r25 71 72 3.14806 $w=1.3e-08 $l=1.35e-08 $layer=M1 $thickness=3.6e-08 $X=0.5805
+ $Y=0.036 $X2=0.594 $Y2=0.036
r26 70 71 3.14806 $w=1.3e-08 $l=1.35e-08 $layer=M1 $thickness=3.6e-08 $X=0.567
+ $Y=0.036 $X2=0.5805 $Y2=0.036
r27 69 70 5.94634 $w=1.3e-08 $l=2.55e-08 $layer=M1 $thickness=3.6e-08 $X=0.5415
+ $Y=0.036 $X2=0.567 $Y2=0.036
r28 68 69 4.19742 $w=1.3e-08 $l=1.8e-08 $layer=M1 $thickness=3.6e-08 $X=0.5235
+ $Y=0.036 $X2=0.5415 $Y2=0.036
r29 67 68 2.44849 $w=1.3e-08 $l=1.05e-08 $layer=M1 $thickness=3.6e-08 $X=0.513
+ $Y=0.036 $X2=0.5235 $Y2=0.036
r30 66 67 6.29612 $w=1.3e-08 $l=2.7e-08 $layer=M1 $thickness=3.6e-08 $X=0.486
+ $Y=0.036 $X2=0.513 $Y2=0.036
r31 65 66 6.29612 $w=1.3e-08 $l=2.7e-08 $layer=M1 $thickness=3.6e-08 $X=0.459
+ $Y=0.036 $X2=0.486 $Y2=0.036
r32 64 65 2.44849 $w=1.3e-08 $l=1.05e-08 $layer=M1 $thickness=3.6e-08 $X=0.4485
+ $Y=0.036 $X2=0.459 $Y2=0.036
r33 63 64 4.19742 $w=1.3e-08 $l=1.8e-08 $layer=M1 $thickness=3.6e-08 $X=0.4305
+ $Y=0.036 $X2=0.4485 $Y2=0.036
r34 62 63 5.94634 $w=1.3e-08 $l=2.55e-08 $layer=M1 $thickness=3.6e-08 $X=0.405
+ $Y=0.036 $X2=0.4305 $Y2=0.036
r35 61 62 6.29612 $w=1.3e-08 $l=2.7e-08 $layer=M1 $thickness=3.6e-08 $X=0.378
+ $Y=0.036 $X2=0.405 $Y2=0.036
r36 60 61 6.29612 $w=1.3e-08 $l=2.7e-08 $layer=M1 $thickness=3.6e-08 $X=0.351
+ $Y=0.036 $X2=0.378 $Y2=0.036
r37 59 60 3.14806 $w=1.3e-08 $l=1.35e-08 $layer=M1 $thickness=3.6e-08 $X=0.3375
+ $Y=0.036 $X2=0.351 $Y2=0.036
r38 58 59 3.14806 $w=1.3e-08 $l=1.35e-08 $layer=M1 $thickness=3.6e-08 $X=0.324
+ $Y=0.036 $X2=0.3375 $Y2=0.036
r39 57 58 3.14806 $w=1.3e-08 $l=1.35e-08 $layer=M1 $thickness=3.6e-08 $X=0.3105
+ $Y=0.036 $X2=0.324 $Y2=0.036
r40 56 57 3.14806 $w=1.3e-08 $l=1.35e-08 $layer=M1 $thickness=3.6e-08 $X=0.297
+ $Y=0.036 $X2=0.3105 $Y2=0.036
r41 55 56 6.29612 $w=1.3e-08 $l=2.7e-08 $layer=M1 $thickness=3.6e-08 $X=0.27
+ $Y=0.036 $X2=0.297 $Y2=0.036
r42 54 55 6.29612 $w=1.3e-08 $l=2.7e-08 $layer=M1 $thickness=3.6e-08 $X=0.243
+ $Y=0.036 $X2=0.27 $Y2=0.036
r43 53 54 6.06293 $w=1.3e-08 $l=2.6e-08 $layer=M1 $thickness=3.6e-08 $X=0.217
+ $Y=0.036 $X2=0.243 $Y2=0.036
r44 25 53 4.19742 $w=1.3e-08 $l=1.8e-08 $layer=M1 $thickness=3.6e-08 $X=0.199
+ $Y=0.036 $X2=0.217 $Y2=0.036
r45 18 24 2.5483 $w=1.79e-08 $l=1.8e-08 $layer=M1 $thickness=3.6e-08 $X=0.189
+ $Y=0.036 $X2=0.189 $Y2=0.054
r46 18 25 0.682785 $w=1.75e-08 $l=1e-08 $layer=M1 $thickness=3.6e-08 $X=0.189
+ $Y=0.036 $X2=0.199 $Y2=0.036
r47 19 51 4.08819 $w=1.38974e-08 $l=2.55979e-08 $layer=M1 $thickness=3.6e-08
+ $X=0.189 $Y=0.0665 $X2=0.164 $Y2=0.072
r48 19 24 2.45586 $w=1.44e-08 $l=1.25e-08 $layer=M1 $thickness=3.6e-08 $X=0.189
+ $Y=0.0665 $X2=0.189 $Y2=0.054
r49 23 51 4.19742 $w=1.3e-08 $l=1.8e-08 $layer=M1 $thickness=3.6e-08 $X=0.146
+ $Y=0.072 $X2=0.164 $Y2=0.072
r50 17 50 3.36447 $w=1.71023e-08 $l=2.15e-08 $layer=M1 $thickness=3.6e-08
+ $X=0.135 $Y=0.072 $X2=0.135 $Y2=0.0935
r51 17 23 0.915974 $w=1.70909e-08 $l=1.1e-08 $layer=M1 $thickness=3.6e-08
+ $X=0.135 $Y=0.072 $X2=0.146 $Y2=0.072
r52 22 48 4.43061 $w=1.3e-08 $l=1.9e-08 $layer=M1 $thickness=3.6e-08 $X=0.135
+ $Y=0.116 $X2=0.135 $Y2=0.135
r53 22 50 5.24677 $w=1.3e-08 $l=2.25e-08 $layer=M1 $thickness=3.6e-08 $X=0.135
+ $Y=0.116 $X2=0.135 $Y2=0.0935
r54 46 45 16.4967 $w=2.1e-08 $l=4.85e-08 $layer=Gate_1 $thickness=5.6e-08
+ $X=0.135 $Y=0.2025 $X2=0.135 $Y2=0.154
r55 43 44 16.4967 $w=2.1e-08 $l=4.85e-08 $layer=Gate_1 $thickness=5.6e-08
+ $X=0.135 $Y=0.0675 $X2=0.135 $Y2=0.116
r56 13 39 6.27904 $w=2.09e-08 $layer=Gate_1 $thickness=5.24e-08 $X=0.135
+ $Y=0.135 $X2=0.135 $Y2=0.135
r57 13 44 6.6497 $w=2.04211e-08 $l=1.9e-08 $layer=Gate_1 $thickness=5.6e-08
+ $X=0.135 $Y=0.135 $X2=0.135 $Y2=0.116
r58 13 45 6.6497 $w=2.04211e-08 $l=1.9e-08 $layer=Gate_1 $thickness=5.6e-08
+ $X=0.135 $Y=0.135 $X2=0.135 $Y2=0.154
r59 39 48 19.3796 $a=3.24e-16 $layer=V0LIG $X=0.135 $Y=0.135 $X2=0.135 $Y2=0.135
r60 38 39 2.48102 $w=2.2e-08 $l=9.5e-09 $layer=LIG $thickness=4.8e-08 $X=0.1255
+ $Y=0.135 $X2=0.135 $Y2=0.135
r61 37 38 10.1729 $w=1.54914e-08 $l=1.75e-08 $layer=LIG $thickness=4.8e-08
+ $X=0.108 $Y=0.135 $X2=0.1255 $Y2=0.135
r62 1 31 6.54019 $w=2.09524e-08 $layer=Gate_1 $thickness=5.21905e-08 $X=0.081
+ $Y=0.135 $X2=0.081 $Y2=0.135
r63 1 37 12.6539 $w=1.77815e-08 $l=2.7e-08 $layer=LIG $thickness=4.8e-08
+ $X=0.081 $Y=0.135 $X2=0.108 $Y2=0.135
r64 34 33 14.6259 $w=2.1e-08 $l=4.3e-08 $layer=Gate_1 $thickness=5.6e-08
+ $X=0.081 $Y=0.2025 $X2=0.081 $Y2=0.1595
r65 32 33 2.7211 $w=2.1e-08 $l=8e-09 $layer=Gate_1 $thickness=5.6e-08 $X=0.081
+ $Y=0.1515 $X2=0.081 $Y2=0.1595
r66 31 32 5.79936 $w=2.03333e-08 $l=1.65e-08 $layer=Gate_1 $thickness=5.6e-08
+ $X=0.081 $Y=0.135 $X2=0.081 $Y2=0.1515
r67 30 31 5.79936 $w=2.03333e-08 $l=1.65e-08 $layer=Gate_1 $thickness=5.6e-08
+ $X=0.081 $Y=0.1185 $X2=0.081 $Y2=0.135
r68 29 30 2.7211 $w=2.1e-08 $l=8e-09 $layer=Gate_1 $thickness=5.6e-08 $X=0.081
+ $Y=0.1105 $X2=0.081 $Y2=0.1185
r69 28 29 14.6259 $w=2.1e-08 $l=4.3e-08 $layer=Gate_1 $thickness=5.6e-08
+ $X=0.081 $Y=0.0675 $X2=0.081 $Y2=0.1105
r70 28 12 14.6259 $w=2.1e-08 $l=4.3e-08 $layer=Gate_1 $thickness=5.6e-08
+ $X=0.081 $Y=0.0675 $X2=0.081 $Y2=0.0245
.ends

.subckt PM_AO332x2_ASAP7_75t_R%A2 vss 11 5 9 4 3
c1 1 vss 0.00446269f $X=0.243 $Y=0.135
c2 3 vss 0.121367f $X=0.243 $Y=0.0245
c3 4 vss 0.00757038f $X=0.243 $Y=0.1102
r1 12 13 3.32295 $w=1.3e-08 $l=1.43e-08 $layer=M1 $thickness=3.6e-08 $X=0.243
+ $Y=0.1207 $X2=0.243 $Y2=0.135
r2 11 12 1.34084 $w=1.3e-08 $l=5.7e-09 $layer=M1 $thickness=3.6e-08 $X=0.243
+ $Y=0.115 $X2=0.243 $Y2=0.1207
r3 11 4 1.10765 $w=1.3e-08 $l=4.8e-09 $layer=M1 $thickness=3.6e-08 $X=0.243
+ $Y=0.115 $X2=0.243 $Y2=0.1102
r4 1 7 10.4265 $w=1.765e-08 $layer=LIG $thickness=5.2e-08 $X=0.243 $Y=0.135
+ $X2=0.243 $Y2=0.135
r5 1 13 19.3796 $a=3.24e-16 $layer=V0LIG $X=0.243 $Y=0.135 $X2=0.243 $Y2=0.135
r6 9 8 16.4967 $w=2.1e-08 $l=4.85e-08 $layer=Gate_1 $thickness=5.6e-08 $X=0.243
+ $Y=0.2025 $X2=0.243 $Y2=0.154
r7 7 8 6.6497 $w=2.04211e-08 $l=1.9e-08 $layer=Gate_1 $thickness=5.6e-08
+ $X=0.243 $Y=0.135 $X2=0.243 $Y2=0.154
r8 6 7 6.6497 $w=2.04211e-08 $l=1.9e-08 $layer=Gate_1 $thickness=5.6e-08
+ $X=0.243 $Y=0.116 $X2=0.243 $Y2=0.135
r9 5 6 16.4967 $w=2.1e-08 $l=4.85e-08 $layer=Gate_1 $thickness=5.6e-08 $X=0.243
+ $Y=0.0675 $X2=0.243 $Y2=0.116
r10 5 3 14.6259 $w=2.1e-08 $l=4.3e-08 $layer=Gate_1 $thickness=5.6e-08 $X=0.243
+ $Y=0.0675 $X2=0.243 $Y2=0.0245
.ends

.subckt PM_AO332x2_ASAP7_75t_R%B1 vss 11 5 9 4 3
c1 1 vss 0.00723448f $X=0.351 $Y=0.135
c2 3 vss 0.10166f $X=0.351 $Y=0.0245
c3 4 vss 0.00542907f $X=0.351 $Y=0.0927
r1 12 13 3.20636 $w=1.3e-08 $l=1.38e-08 $layer=M1 $thickness=3.6e-08 $X=0.351
+ $Y=0.1212 $X2=0.351 $Y2=0.135
r2 11 12 1.22425 $w=1.3e-08 $l=5.2e-09 $layer=M1 $thickness=3.6e-08 $X=0.351
+ $Y=0.116 $X2=0.351 $Y2=0.1212
r3 11 4 5.42166 $w=1.3e-08 $l=2.33e-08 $layer=M1 $thickness=3.6e-08 $X=0.351
+ $Y=0.116 $X2=0.351 $Y2=0.0927
r4 1 7 10.4265 $w=1.765e-08 $layer=LIG $thickness=5.2e-08 $X=0.351 $Y=0.135
+ $X2=0.351 $Y2=0.135
r5 1 13 19.3796 $a=3.24e-16 $layer=V0LIG $X=0.351 $Y=0.135 $X2=0.351 $Y2=0.135
r6 9 8 16.4967 $w=2.1e-08 $l=4.85e-08 $layer=Gate_1 $thickness=5.6e-08 $X=0.351
+ $Y=0.2025 $X2=0.351 $Y2=0.154
r7 7 8 6.6497 $w=2.04211e-08 $l=1.9e-08 $layer=Gate_1 $thickness=5.6e-08
+ $X=0.351 $Y=0.135 $X2=0.351 $Y2=0.154
r8 6 7 6.6497 $w=2.04211e-08 $l=1.9e-08 $layer=Gate_1 $thickness=5.6e-08
+ $X=0.351 $Y=0.116 $X2=0.351 $Y2=0.135
r9 5 6 16.4967 $w=2.1e-08 $l=4.85e-08 $layer=Gate_1 $thickness=5.6e-08 $X=0.351
+ $Y=0.0675 $X2=0.351 $Y2=0.116
r10 5 3 14.6259 $w=2.1e-08 $l=4.3e-08 $layer=Gate_1 $thickness=5.6e-08 $X=0.351
+ $Y=0.0675 $X2=0.351 $Y2=0.0245
.ends

* End of included file AO332x2_ASAP7_75t_R.pex.sp.pex

*
.subckt AO332x2_ASAP7_75t_CUSTOM_4_25_0_7 VSS VDD A3 A2 A1 B1 B2 B3 C2 C1 Y
*
* VSS VSS
* VDD VDD
* A3 A3
* A2 A2
* A1 A1
* B1 B1
* B2 B2
* B3 B3
* C2 C2
* C1 C1
* Y Y
*
*

M0 N_M0_d N_M0_g VSS VSS nmos_rvt L=2e-08 W=8.1e-08 nfin=3 $X=0.071 $Y=0.027
M1 N_M1_d N_M1_g VSS VSS nmos_rvt L=2e-08 W=8.1e-08 nfin=3 $X=0.125 $Y=0.027
M2 noxref_15 N_M2_g VSS VSS nmos_rvt L=2e-08 W=8.1e-08 nfin=3 $X=0.179 $Y=0.027
M3 noxref_16 N_M3_g noxref_15 VSS nmos_rvt L=2e-08 W=8.1e-08 nfin=3 $X=0.233
+ $Y=0.027
M4 N_M4_d N_M4_g noxref_16 VSS nmos_rvt L=2e-08 W=8.1e-08 nfin=3 $X=0.287
+ $Y=0.027
M5 noxref_17 N_M5_g N_M5_s VSS nmos_rvt L=2e-08 W=8.1e-08 nfin=3 $X=0.341
+ $Y=0.027
M6 noxref_18 N_M6_g noxref_17 VSS nmos_rvt L=2e-08 W=8.1e-08 nfin=3 $X=0.395
+ $Y=0.027
M7 VSS N_M7_g noxref_18 VSS nmos_rvt L=2e-08 W=8.1e-08 nfin=3 $X=0.449 $Y=0.027
M8 noxref_19 N_M8_g VSS VSS nmos_rvt L=2e-08 W=8.1e-08 nfin=3 $X=0.503 $Y=0.027
M9 N_M9_d N_M9_g noxref_19 VSS nmos_rvt L=2e-08 W=8.1e-08 nfin=3 $X=0.557
+ $Y=0.027
M10 N_M10_d N_M10_g VDD VDD pmos_rvt L=2e-08 W=8.1e-08 nfin=3 $X=0.071 $Y=0.162
M11 N_M11_d N_M11_g VDD VDD pmos_rvt L=2e-08 W=8.1e-08 nfin=3 $X=0.125 $Y=0.162
M12 noxref_13 N_M12_g VDD VDD pmos_rvt L=2e-08 W=8.1e-08 nfin=3 $X=0.179
+ $Y=0.162
M13 VDD N_M13_g noxref_13 VDD pmos_rvt L=2e-08 W=8.1e-08 nfin=3 $X=0.233
+ $Y=0.162
M14 noxref_13 N_M14_g VDD VDD pmos_rvt L=2e-08 W=8.1e-08 nfin=3 $X=0.287
+ $Y=0.162
M15 noxref_14 N_M15_g noxref_13 VDD pmos_rvt L=2e-08 W=8.1e-08 nfin=3 $X=0.341
+ $Y=0.162
M16 noxref_13 N_M16_g noxref_14 VDD pmos_rvt L=2e-08 W=8.1e-08 nfin=3 $X=0.395
+ $Y=0.162
M17 noxref_14 N_M17_g noxref_13 VDD pmos_rvt L=2e-08 W=8.1e-08 nfin=3 $X=0.449
+ $Y=0.162
M18 N_M18_d N_M18_g noxref_14 VDD pmos_rvt L=2e-08 W=8.1e-08 nfin=3 $X=0.503
+ $Y=0.162
M19 noxref_14 N_M19_g N_M19_s VDD pmos_rvt L=2e-08 W=8.1e-08 nfin=3 $X=0.557
+ $Y=0.162

* .include "AO332x2_ASAP7_75t_R.pex.sp.pxi"

* Start of included file AO332x2_ASAP7_75t_R.pex.sp.pxi
x_PM_AO332x2_ASAP7_75t_R%A3 vss A3 N_M2_g N_M12_g N_A3_3 N_A3_4
+ PM_AO332x2_ASAP7_75t_R%A3
cc_1 N_A3_3 N_3_23 0.00039738f $X=0.189 $Y=0.0245
cc_2 N_A3_3 N_3_19 0.000552092f $X=0.189 $Y=0.0245
cc_3 N_A3_3 N_3_1 0.00230004f $X=0.189 $Y=0.0245
cc_4 N_A3_4 N_3_22 0.0032451f $X=0.189 $Y=0.1102
cc_5 N_A3_3 N_3_13 0.00361642f $X=0.189 $Y=0.0245
x_PM_AO332x2_ASAP7_75t_R%B2 vss B2 N_M6_g N_M16_g N_B2_4 N_B2_3
+ PM_AO332x2_ASAP7_75t_R%B2
cc_6 N_B2_4 N_3_3 0.000336205f $X=0.405 $Y=0.0922
cc_7 N_B2_4 N_3_25 0.00317191f $X=0.405 $Y=0.0922
cc_8 N_B2_4 N_B1_4 0.00331561f $X=0.405 $Y=0.0922
cc_9 N_B2_3 N_B1_3 0.00697136f $X=0.405 $Y=0.0245
x_PM_AO332x2_ASAP7_75t_R%B3 vss B3 N_M7_g N_M17_g N_B3_4 N_B3_3
+ PM_AO332x2_ASAP7_75t_R%B3
cc_10 N_B3_4 N_3_25 0.0030677f $X=0.459 $Y=0.0922
cc_11 N_B3_4 N_B2_4 0.00333492f $X=0.459 $Y=0.0922
cc_12 N_B3_3 N_B2_3 0.00690701f $X=0.459 $Y=0.0245
x_PM_AO332x2_ASAP7_75t_R%C2 vss C2 N_M8_g N_M18_g N_C2_3 N_C2_4
+ PM_AO332x2_ASAP7_75t_R%C2
cc_13 N_C2_3 N_3_4 0.00149201f $X=0.513 $Y=0.0245
cc_14 N_C2_3 N_3_26 0.000544566f $X=0.513 $Y=0.0245
cc_15 N_C2_4 N_3_25 0.0013014f $X=0.513 $Y=0.0917
cc_16 N_C2_4 N_3_4 0.00219077f $X=0.513 $Y=0.0917
cc_17 N_C2_3 N_3_16 0.0357002f $X=0.513 $Y=0.0245
cc_18 N_C2_3 N_B3_3 0.00317792f $X=0.513 $Y=0.0245
cc_19 N_C2_4 N_B3_4 0.00519454f $X=0.513 $Y=0.0917
x_PM_AO332x2_ASAP7_75t_R%A1 vss A1 N_M4_g N_M14_g N_A1_3 N_A1_4
+ PM_AO332x2_ASAP7_75t_R%A1
cc_20 N_A1_3 N_3_3 0.00178843f $X=0.297 $Y=0.0245
cc_21 N_A1_4 N_3_25 0.0012498f $X=0.297 $Y=0.0922
cc_22 N_A1_4 N_3_3 0.00183949f $X=0.297 $Y=0.0922
cc_23 N_A1_3 N_3_14 0.0361067f $X=0.297 $Y=0.0245
cc_24 N_A1_4 N_A2_4 0.00372134f $X=0.297 $Y=0.0922
cc_25 N_A1_3 N_A2_3 0.0069307f $X=0.297 $Y=0.0245
x_PM_AO332x2_ASAP7_75t_R%C1 vss C1 N_M9_g N_M19_g N_C1_3 N_C1_4 N_C1_1
+ PM_AO332x2_ASAP7_75t_R%C1
cc_26 N_C1_3 N_3_4 0.0010638f $X=0.567 $Y=0.0245
cc_27 N_C1_3 N_3_15 0.0155504f $X=0.567 $Y=0.0245
cc_28 N_C1_3 N_3_5 0.00244238f $X=0.567 $Y=0.0245
cc_29 N_C1_3 N_3_26 0.000993697f $X=0.567 $Y=0.0245
cc_30 N_C1_4 N_3_25 0.00115438f $X=0.567 $Y=0.0922
cc_31 N_C1_1 N_3_15 0.00173064f $X=0.567 $Y=0.135
cc_32 N_C1_4 N_3_27 0.00657701f $X=0.567 $Y=0.0922
cc_33 N_C1_3 N_3_16 0.0540887f $X=0.567 $Y=0.0245
cc_34 N_C1_4 N_C2_4 0.00328605f $X=0.567 $Y=0.0922
cc_35 N_C1_3 N_C2_3 0.0069465f $X=0.567 $Y=0.0245
x_PM_AO332x2_ASAP7_75t_R%Y vss Y N_M0_d N_M1_d N_M10_d N_M11_d N_Y_8 N_Y_12
+ N_Y_7 PM_AO332x2_ASAP7_75t_R%Y
cc_36 N_Y_8 N_3_17 0.000267588f $X=0.0935 $Y=0.2025
cc_37 N_Y_8 N_3_22 0.00161894f $X=0.0935 $Y=0.2025
cc_38 N_Y_8 N_3_18 0.00029663f $X=0.0935 $Y=0.2025
cc_39 N_Y_8 N_3_1 0.00135989f $X=0.0935 $Y=0.2025
cc_40 N_Y_8 N_3_23 0.000614825f $X=0.0935 $Y=0.2025
cc_41 N_Y_8 N_3_13 0.00254905f $X=0.0935 $Y=0.2025
cc_42 N_Y_12 N_3_17 0.00327801f $X=0.0675 $Y=0.036
cc_43 N_Y_7 N_3_1 0.0049512f $X=0.0935 $Y=0.0675
cc_44 N_Y_7 N_3_12 0.0104423f $X=0.0935 $Y=0.0675
cc_45 N_Y_7 N_3_13 0.0551436f $X=0.0935 $Y=0.0675
cc_46 N_Y_8 N_3_12 0.0691467f $X=0.0935 $Y=0.2025
x_PM_AO332x2_ASAP7_75t_R%3 vss N_M0_g N_M10_g N_M1_g N_M11_g N_M4_d N_M5_s
+ N_M9_d N_M18_d N_M19_s N_3_23 N_3_19 N_3_1 N_3_22 N_3_13 N_3_14 N_3_3 N_3_25
+ N_3_4 N_3_26 N_3_16 N_3_15 N_3_5 N_3_27 N_3_17 N_3_18 N_3_12
+ PM_AO332x2_ASAP7_75t_R%3
x_PM_AO332x2_ASAP7_75t_R%A2 vss A2 N_M3_g N_M13_g N_A2_4 N_A2_3
+ PM_AO332x2_ASAP7_75t_R%A2
cc_47 N_A2_4 N_3_14 0.000195133f $X=0.243 $Y=0.1102
cc_48 N_A2_4 N_3_3 0.00033594f $X=0.243 $Y=0.1102
cc_49 N_A2_4 N_3_25 0.00135815f $X=0.243 $Y=0.1102
cc_50 N_A2_4 N_3_19 0.00289962f $X=0.243 $Y=0.1102
cc_51 N_A2_4 N_A3_4 0.00370888f $X=0.243 $Y=0.1102
cc_52 N_A2_3 N_A3_3 0.00698541f $X=0.243 $Y=0.0245
x_PM_AO332x2_ASAP7_75t_R%B1 vss B1 N_M5_g N_M15_g N_B1_4 N_B1_3
+ PM_AO332x2_ASAP7_75t_R%B1
cc_53 N_B1_4 N_3_25 0.00125751f $X=0.351 $Y=0.0927
cc_54 N_B1_3 N_3_3 0.00151237f $X=0.351 $Y=0.0245
cc_55 N_B1_4 N_3_3 0.00179628f $X=0.351 $Y=0.0927
cc_56 N_B1_3 N_3_14 0.036107f $X=0.351 $Y=0.0245
cc_57 N_B1_3 N_A1_3 0.00317569f $X=0.351 $Y=0.0245
cc_58 N_B1_4 N_A1_4 0.00497697f $X=0.351 $Y=0.0927

* End of included file AO332x2_ASAP7_75t_R.pex.sp.pxi
.ends

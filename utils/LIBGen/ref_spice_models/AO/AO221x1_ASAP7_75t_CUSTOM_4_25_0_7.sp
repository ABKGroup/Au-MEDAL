.subckt PM_AO221x1_ASAP7_75t_R%C vss 11 5 9 4 3
c1 1 vss 0.00685431f $X=0.189 $Y=0.135
c2 3 vss 0.112783f $X=0.189 $Y=0.0245
c3 4 vss 0.0047829f $X=0.189 $Y=0.0962
r1 12 13 2.39019 $w=1.3e-08 $l=1.03e-08 $layer=M1 $thickness=3.6e-08 $X=0.189
+ $Y=0.1247 $X2=0.189 $Y2=0.135
r2 11 12 0.408082 $w=1.3e-08 $l=1.7e-09 $layer=M1 $thickness=3.6e-08 $X=0.188
+ $Y=0.123 $X2=0.189 $Y2=0.1247
r3 11 4 6.23783 $w=1.3e-08 $l=2.68e-08 $layer=M1 $thickness=3.6e-08 $X=0.188
+ $Y=0.123 $X2=0.189 $Y2=0.0962
r4 1 7 10.4265 $w=1.765e-08 $layer=LIG $thickness=5.2e-08 $X=0.189 $Y=0.135
+ $X2=0.189 $Y2=0.135
r5 1 13 19.3796 $a=3.24e-16 $layer=V0LIG $X=0.189 $Y=0.135 $X2=0.189 $Y2=0.135
r6 9 8 16.4967 $w=2.1e-08 $l=4.85e-08 $layer=Gate_1 $thickness=5.6e-08 $X=0.189
+ $Y=0.2025 $X2=0.189 $Y2=0.154
r7 7 8 6.6497 $w=2.04211e-08 $l=1.9e-08 $layer=Gate_1 $thickness=5.6e-08
+ $X=0.189 $Y=0.135 $X2=0.189 $Y2=0.154
r8 6 7 11.2416 $w=2.06615e-08 $l=3.25e-08 $layer=Gate_1 $thickness=5.6e-08
+ $X=0.189 $Y=0.1025 $X2=0.189 $Y2=0.135
r9 5 6 16.4967 $w=2.1e-08 $l=4.85e-08 $layer=Gate_1 $thickness=5.6e-08 $X=0.189
+ $Y=0.054 $X2=0.189 $Y2=0.1025
r10 5 3 10.0341 $w=2.1e-08 $l=2.95e-08 $layer=Gate_1 $thickness=5.6e-08
+ $X=0.189 $Y=0.054 $X2=0.189 $Y2=0.0245
.ends

.subckt PM_AO221x1_ASAP7_75t_R%A2 vss 13 5 11 4 3
c1 1 vss 0.00614063f $X=0.297 $Y=0.135
c2 3 vss 0.13371f $X=0.297 $Y=0.0245
c3 4 vss 0.00660546f $X=0.297 $Y=0.0962
r1 14 15 2.39019 $w=1.3e-08 $l=1.03e-08 $layer=M1 $thickness=3.6e-08 $X=0.297
+ $Y=0.1247 $X2=0.297 $Y2=0.135
r2 13 14 0.408082 $w=1.3e-08 $l=1.7e-09 $layer=M1 $thickness=3.6e-08 $X=0.295
+ $Y=0.123 $X2=0.297 $Y2=0.1247
r3 13 4 6.23783 $w=1.3e-08 $l=2.68e-08 $layer=M1 $thickness=3.6e-08 $X=0.295
+ $Y=0.123 $X2=0.297 $Y2=0.0962
r4 1 8 10.4265 $w=1.765e-08 $layer=LIG $thickness=5.2e-08 $X=0.297 $Y=0.135
+ $X2=0.297 $Y2=0.135
r5 1 15 19.3796 $a=3.24e-16 $layer=V0LIG $X=0.297 $Y=0.135 $X2=0.297 $Y2=0.135
r6 11 10 14.6259 $w=2.1e-08 $l=4.3e-08 $layer=Gate_1 $thickness=5.6e-08
+ $X=0.297 $Y=0.2025 $X2=0.297 $Y2=0.1595
r7 9 10 2.7211 $w=2.1e-08 $l=8e-09 $layer=Gate_1 $thickness=5.6e-08 $X=0.297
+ $Y=0.1515 $X2=0.297 $Y2=0.1595
r8 8 9 5.79936 $w=2.03333e-08 $l=1.65e-08 $layer=Gate_1 $thickness=5.6e-08
+ $X=0.297 $Y=0.135 $X2=0.297 $Y2=0.1515
r9 7 8 5.79936 $w=2.03333e-08 $l=1.65e-08 $layer=Gate_1 $thickness=5.6e-08
+ $X=0.297 $Y=0.1185 $X2=0.297 $Y2=0.135
r10 6 7 7.31297 $w=2.1e-08 $l=2.15e-08 $layer=Gate_1 $thickness=5.6e-08
+ $X=0.297 $Y=0.097 $X2=0.297 $Y2=0.1185
r11 5 6 14.6259 $w=2.1e-08 $l=4.3e-08 $layer=Gate_1 $thickness=5.6e-08 $X=0.297
+ $Y=0.054 $X2=0.297 $Y2=0.097
r12 5 3 10.0341 $w=2.1e-08 $l=2.95e-08 $layer=Gate_1 $thickness=5.6e-08
+ $X=0.297 $Y=0.054 $X2=0.297 $Y2=0.0245
.ends

.subckt PM_AO221x1_ASAP7_75t_R%B2 vss 11 5 9 4 3 1
c1 1 vss 0.00594683f $X=0.135 $Y=0.135
c2 3 vss 0.0902499f $X=0.135 $Y=0.0245
c3 4 vss 0.00413517f $X=0.135 $Y=0.0892
r1 12 13 4.02252 $w=1.3e-08 $l=1.73e-08 $layer=M1 $thickness=3.6e-08 $X=0.135
+ $Y=0.1177 $X2=0.135 $Y2=0.135
r2 11 12 2.04041 $w=1.3e-08 $l=8.7e-09 $layer=M1 $thickness=3.6e-08 $X=0.133
+ $Y=0.109 $X2=0.135 $Y2=0.1177
r3 11 4 4.6055 $w=1.3e-08 $l=1.98e-08 $layer=M1 $thickness=3.6e-08 $X=0.133
+ $Y=0.109 $X2=0.135 $Y2=0.0892
r4 1 7 10.4265 $w=1.765e-08 $layer=LIG $thickness=5.2e-08 $X=0.135 $Y=0.135
+ $X2=0.135 $Y2=0.135
r5 1 13 19.3796 $a=3.24e-16 $layer=V0LIG $X=0.135 $Y=0.135 $X2=0.135 $Y2=0.135
r6 9 8 16.4967 $w=2.1e-08 $l=4.85e-08 $layer=Gate_1 $thickness=5.6e-08 $X=0.135
+ $Y=0.2025 $X2=0.135 $Y2=0.154
r7 7 8 6.6497 $w=2.04211e-08 $l=1.9e-08 $layer=Gate_1 $thickness=5.6e-08
+ $X=0.135 $Y=0.135 $X2=0.135 $Y2=0.154
r8 6 7 11.2416 $w=2.06615e-08 $l=3.25e-08 $layer=Gate_1 $thickness=5.6e-08
+ $X=0.135 $Y=0.1025 $X2=0.135 $Y2=0.135
r9 5 6 16.4967 $w=2.1e-08 $l=4.85e-08 $layer=Gate_1 $thickness=5.6e-08 $X=0.135
+ $Y=0.054 $X2=0.135 $Y2=0.1025
r10 5 3 10.0341 $w=2.1e-08 $l=2.95e-08 $layer=Gate_1 $thickness=5.6e-08
+ $X=0.135 $Y=0.054 $X2=0.135 $Y2=0.0245
.ends

.subckt PM_AO221x1_ASAP7_75t_R%Y vss 20 14 30 7 12 8
c1 1 vss 0.00870739f $X=0.486 $Y=0.0675
c2 2 vss 0.0090049f $X=0.486 $Y=0.2025
c3 7 vss 0.0385615f $X=0.4715 $Y=0.0675
c4 8 vss 0.0385587f $X=0.4715 $Y=0.2025
c5 9 vss 0.00648882f $X=0.513 $Y=0.234
c6 10 vss 0.00282032f $X=0.513 $Y=0.036
c7 11 vss 0.00475847f $X=0.4665 $Y=0.036
c8 12 vss 0.00620608f $X=0.513 $Y=0.0855
r1 8 2 0.154321 $w=8.1e-08 $l=1.25e-08 $layer=P_src_drn $thickness=1e-09
+ $X=0.4715 $Y=0.2025 $X2=0.486 $Y2=0.2025
r2 30 8 0.0308642 $w=8.1e-08 $l=2.5e-09 $layer=P_src_drn $thickness=1e-09
+ $X=0.4686 $Y=0.2025 $X2=0.4715 $Y2=0.2025
r3 2 26 19.3796 $a=3.24e-16 $layer=V0LISD $X=0.486 $Y=0.2025 $X2=0.486 $Y2=0.234
r4 26 27 3.14806 $w=1.3e-08 $l=1.35e-08 $layer=M1 $thickness=3.6e-08 $X=0.486
+ $Y=0.234 $X2=0.4995 $Y2=0.234
r5 9 24 3.01711 $w=1.55e-08 $l=1.8e-08 $layer=M1 $thickness=3.6e-08 $X=0.513
+ $Y=0.234 $X2=0.513 $Y2=0.216
r6 9 27 1.96775 $w=1.63333e-08 $l=1.35e-08 $layer=M1 $thickness=3.6e-08
+ $X=0.513 $Y=0.234 $X2=0.4995 $Y2=0.234
r7 23 24 4.19742 $w=1.3e-08 $l=1.8e-08 $layer=M1 $thickness=3.6e-08 $X=0.513
+ $Y=0.198 $X2=0.513 $Y2=0.216
r8 22 23 5.01358 $w=1.3e-08 $l=2.15e-08 $layer=M1 $thickness=3.6e-08 $X=0.513
+ $Y=0.1765 $X2=0.513 $Y2=0.198
r9 21 22 4.78039 $w=1.3e-08 $l=2.05e-08 $layer=M1 $thickness=3.6e-08 $X=0.513
+ $Y=0.156 $X2=0.513 $Y2=0.1765
r10 20 21 1.98211 $w=1.3e-08 $l=8.5e-09 $layer=M1 $thickness=3.6e-08 $X=0.509
+ $Y=0.1475 $X2=0.513 $Y2=0.156
r11 20 19 0.46638 $w=1.3e-08 $l=2e-09 $layer=M1 $thickness=3.6e-08 $X=0.509
+ $Y=0.1475 $X2=0.513 $Y2=0.1455
r12 18 19 2.44849 $w=1.3e-08 $l=1.05e-08 $layer=M1 $thickness=3.6e-08 $X=0.513
+ $Y=0.135 $X2=0.513 $Y2=0.1455
r13 12 18 11.5429 $w=1.3e-08 $l=4.95e-08 $layer=M1 $thickness=3.6e-08 $X=0.513
+ $Y=0.0855 $X2=0.513 $Y2=0.135
r14 10 17 1.49895 $w=1.63333e-08 $l=1.35e-08 $layer=M1 $thickness=3.6e-08
+ $X=0.513 $Y=0.036 $X2=0.4995 $Y2=0.036
r15 10 12 9.89378 $w=1.47818e-08 $l=4.95e-08 $layer=M1 $thickness=3.6e-08
+ $X=0.513 $Y=0.036 $X2=0.513 $Y2=0.0855
r16 16 17 3.14806 $w=1.3e-08 $l=1.35e-08 $layer=M1 $thickness=3.6e-08 $X=0.486
+ $Y=0.036 $X2=0.4995 $Y2=0.036
r17 15 16 2.44849 $w=1.3e-08 $l=1.05e-08 $layer=M1 $thickness=3.6e-08 $X=0.4755
+ $Y=0.036 $X2=0.486 $Y2=0.036
r18 11 15 2.09871 $w=1.3e-08 $l=9e-09 $layer=M1 $thickness=3.6e-08 $X=0.4665
+ $Y=0.036 $X2=0.4755 $Y2=0.036
r19 1 16 19.3796 $a=3.24e-16 $layer=V0LISD $X=0.486 $Y=0.0675 $X2=0.486
+ $Y2=0.036
r20 7 1 0.154321 $w=8.1e-08 $l=1.25e-08 $layer=N_src_drn $thickness=1e-09
+ $X=0.4715 $Y=0.0675 $X2=0.486 $Y2=0.0675
r21 14 7 0.0308642 $w=8.1e-08 $l=2.5e-09 $layer=N_src_drn $thickness=1e-09
+ $X=0.4686 $Y=0.0675 $X2=0.4715 $Y2=0.0675
.ends

.subckt PM_AO221x1_ASAP7_75t_R%8 vss 25 31 57 58 62 70 71 4 3 22 21 15 13 20 5
+ 14 23 1 18 24 12
c1 1 vss 0.00462065f $X=0.459 $Y=0.135
c2 3 vss 0.00629075f $X=0.054 $Y=0.054
c3 4 vss 0.00987843f $X=0.108 $Y=0.2025
c4 5 vss 0.00612637f $X=0.216 $Y=0.054
c5 12 vss 0.0833789f $X=0.459 $Y=0.0245
c6 13 vss 0.0286724f $X=0.056 $Y=0.054
c7 14 vss 0.00382147f $X=0.2015 $Y=0.054
c8 15 vss 0.005531f $X=0.0935 $Y=0.2025
c9 16 vss 0.00294018f $X=0.027 $Y=0.036
c10 17 vss 0.00267119f $X=0.027 $Y=0.198
c11 18 vss 0.00290374f $X=0.405 $Y=0.036
c12 19 vss 0.00169825f $X=0.405 $Y=0.135
c13 20 vss 0.00631648f $X=0.027 $Y=0.0575
c14 21 vss 0.033195f $X=0.3675 $Y=0.036
c15 22 vss 0.00903643f $X=0.0375 $Y=0.198
c16 23 vss 0.00441751f $X=0.405 $Y=0.098
c17 24 vss 0.00252473f $X=0.432 $Y=0.135
r1 71 69 0.0308642 $w=8.1e-08 $l=2.5e-09 $layer=P_src_drn $thickness=1e-09
+ $X=0.1253 $Y=0.2025 $X2=0.1225 $Y2=0.2025
r2 4 69 0.179012 $w=8.1e-08 $l=1.45e-08 $layer=P_src_drn $thickness=1e-09
+ $X=0.108 $Y=0.2025 $X2=0.1225 $Y2=0.2025
r3 15 4 0.179012 $w=8.1e-08 $l=1.45e-08 $layer=P_src_drn $thickness=1e-09
+ $X=0.0935 $Y=0.2025 $X2=0.108 $Y2=0.2025
r4 70 15 0.0308642 $w=8.1e-08 $l=2.5e-09 $layer=P_src_drn $thickness=1e-09
+ $X=0.0906 $Y=0.2025 $X2=0.0935 $Y2=0.2025
r5 4 66 19.3796 $a=3.24e-16 $layer=V0LISD $X=0.108 $Y=0.2025 $X2=0.108 $Y2=0.198
r6 65 66 3.14806 $w=1.3e-08 $l=1.35e-08 $layer=M1 $thickness=3.6e-08 $X=0.0945
+ $Y=0.198 $X2=0.108 $Y2=0.198
r7 64 65 3.14806 $w=1.3e-08 $l=1.35e-08 $layer=M1 $thickness=3.6e-08 $X=0.081
+ $Y=0.198 $X2=0.0945 $Y2=0.198
r8 63 64 5.94634 $w=1.3e-08 $l=2.55e-08 $layer=M1 $thickness=3.6e-08 $X=0.0555
+ $Y=0.198 $X2=0.081 $Y2=0.198
r9 22 63 4.19742 $w=1.3e-08 $l=1.8e-08 $layer=M1 $thickness=3.6e-08 $X=0.0375
+ $Y=0.198 $X2=0.0555 $Y2=0.198
r10 17 60 3.36447 $w=1.71023e-08 $l=2.15e-08 $layer=M1 $thickness=3.6e-08
+ $X=0.027 $Y=0.198 $X2=0.027 $Y2=0.1765
r11 17 22 0.79938 $w=1.72857e-08 $l=1.05e-08 $layer=M1 $thickness=3.6e-08
+ $X=0.027 $Y=0.198 $X2=0.0375 $Y2=0.198
r12 62 61 0.0462963 $w=5.4e-08 $l=2.5e-09 $layer=N_src_drn $thickness=1e-09
+ $X=0.0713 $Y=0.054 $X2=0.0685 $Y2=0.054
r13 13 61 0.231482 $w=5.4e-08 $l=1.25e-08 $layer=N_src_drn $thickness=1e-09
+ $X=0.056 $Y=0.054 $X2=0.0685 $Y2=0.054
r14 59 60 13.8748 $w=1.3e-08 $l=5.95e-08 $layer=M1 $thickness=3.6e-08 $X=0.027
+ $Y=0.117 $X2=0.027 $Y2=0.1765
r15 20 59 13.8748 $w=1.3e-08 $l=5.95e-08 $layer=M1 $thickness=3.6e-08 $X=0.027
+ $Y=0.0575 $X2=0.027 $Y2=0.117
r16 58 56 0.0462963 $w=5.4e-08 $l=2.5e-09 $layer=N_src_drn $thickness=1e-09
+ $X=0.2333 $Y=0.054 $X2=0.2305 $Y2=0.054
r17 5 56 0.268519 $w=5.4e-08 $l=1.45e-08 $layer=N_src_drn $thickness=1e-09
+ $X=0.216 $Y=0.054 $X2=0.2305 $Y2=0.054
r18 14 5 0.268519 $w=5.4e-08 $l=1.45e-08 $layer=N_src_drn $thickness=1e-09
+ $X=0.2015 $Y=0.054 $X2=0.216 $Y2=0.054
r19 57 14 0.0462963 $w=5.4e-08 $l=2.5e-09 $layer=N_src_drn $thickness=1e-09
+ $X=0.1986 $Y=0.054 $X2=0.2015 $Y2=0.054
r20 3 53 19.3796 $a=3.24e-16 $layer=V0LISD $X=0.054 $Y=0.054 $X2=0.054 $Y2=0.036
r21 16 52 1.49895 $w=1.63333e-08 $l=1.35e-08 $layer=M1 $thickness=3.6e-08
+ $X=0.027 $Y=0.036 $X2=0.0405 $Y2=0.036
r22 16 20 3.36447 $w=1.71023e-08 $l=2.15e-08 $layer=M1 $thickness=3.6e-08
+ $X=0.027 $Y=0.036 $X2=0.027 $Y2=0.0575
r23 5 43 19.3796 $a=3.24e-16 $layer=V0LISD $X=0.216 $Y=0.054 $X2=0.216 $Y2=0.036
r24 53 54 3.14806 $w=1.3e-08 $l=1.35e-08 $layer=M1 $thickness=3.6e-08 $X=0.054
+ $Y=0.036 $X2=0.0675 $Y2=0.036
r25 52 53 3.14806 $w=1.3e-08 $l=1.35e-08 $layer=M1 $thickness=3.6e-08 $X=0.0405
+ $Y=0.036 $X2=0.054 $Y2=0.036
r26 51 54 3.14806 $w=1.3e-08 $l=1.35e-08 $layer=M1 $thickness=3.6e-08 $X=0.081
+ $Y=0.036 $X2=0.0675 $Y2=0.036
r27 50 51 6.29612 $w=1.3e-08 $l=2.7e-08 $layer=M1 $thickness=3.6e-08 $X=0.108
+ $Y=0.036 $X2=0.081 $Y2=0.036
r28 49 50 6.29612 $w=1.3e-08 $l=2.7e-08 $layer=M1 $thickness=3.6e-08 $X=0.135
+ $Y=0.036 $X2=0.108 $Y2=0.036
r29 48 49 5.82974 $w=1.3e-08 $l=2.5e-08 $layer=M1 $thickness=3.6e-08 $X=0.16
+ $Y=0.036 $X2=0.135 $Y2=0.036
r30 47 48 4.19742 $w=1.3e-08 $l=1.8e-08 $layer=M1 $thickness=3.6e-08 $X=0.178
+ $Y=0.036 $X2=0.16 $Y2=0.036
r31 46 47 2.56509 $w=1.3e-08 $l=1.1e-08 $layer=M1 $thickness=3.6e-08 $X=0.189
+ $Y=0.036 $X2=0.178 $Y2=0.036
r32 45 46 2.3319 $w=1.3e-08 $l=1e-08 $layer=M1 $thickness=3.6e-08 $X=0.199
+ $Y=0.036 $X2=0.189 $Y2=0.036
r33 43 44 3.14806 $w=1.3e-08 $l=1.35e-08 $layer=M1 $thickness=3.6e-08 $X=0.216
+ $Y=0.036 $X2=0.2295 $Y2=0.036
r34 42 43 2.91487 $w=1.3e-08 $l=1.25e-08 $layer=M1 $thickness=3.6e-08 $X=0.2035
+ $Y=0.036 $X2=0.216 $Y2=0.036
r35 42 45 1.04935 $w=1.3e-08 $l=4.5e-09 $layer=M1 $thickness=3.6e-08 $X=0.2035
+ $Y=0.036 $X2=0.199 $Y2=0.036
r36 41 44 3.14806 $w=1.3e-08 $l=1.35e-08 $layer=M1 $thickness=3.6e-08 $X=0.243
+ $Y=0.036 $X2=0.2295 $Y2=0.036
r37 40 41 6.29612 $w=1.3e-08 $l=2.7e-08 $layer=M1 $thickness=3.6e-08 $X=0.27
+ $Y=0.036 $X2=0.243 $Y2=0.036
r38 39 40 6.29612 $w=1.3e-08 $l=2.7e-08 $layer=M1 $thickness=3.6e-08 $X=0.297
+ $Y=0.036 $X2=0.27 $Y2=0.036
r39 38 39 5.94634 $w=1.3e-08 $l=2.55e-08 $layer=M1 $thickness=3.6e-08 $X=0.3225
+ $Y=0.036 $X2=0.297 $Y2=0.036
r40 21 38 10.4935 $w=1.3e-08 $l=4.5e-08 $layer=M1 $thickness=3.6e-08 $X=0.3675
+ $Y=0.036 $X2=0.3225 $Y2=0.036
r41 18 37 3.36447 $w=1.71023e-08 $l=2.15e-08 $layer=M1 $thickness=3.6e-08
+ $X=0.405 $Y=0.036 $X2=0.405 $Y2=0.0575
r42 18 21 7.0955 $w=1.42e-08 $l=3.75e-08 $layer=M1 $thickness=3.6e-08 $X=0.405
+ $Y=0.036 $X2=0.3675 $Y2=0.036
r43 23 37 9.44419 $w=1.3e-08 $l=4.05e-08 $layer=M1 $thickness=3.6e-08 $X=0.405
+ $Y=0.098 $X2=0.405 $Y2=0.0575
r44 19 24 4.64701 $w=1.46667e-08 $l=2.7e-08 $layer=M1 $thickness=3.6e-08
+ $X=0.405 $Y=0.135 $X2=0.432 $Y2=0.135
r45 19 23 6.97891 $w=1.53838e-08 $l=3.7e-08 $layer=M1 $thickness=3.6e-08
+ $X=0.405 $Y=0.135 $X2=0.405 $Y2=0.098
r46 24 33 5.24677 $w=1.3e-08 $l=2.25e-08 $layer=M1 $thickness=3.6e-08 $X=0.432
+ $Y=0.135 $X2=0.4545 $Y2=0.135
r47 1 28 10.4265 $w=1.765e-08 $layer=LIG $thickness=5.2e-08 $X=0.459 $Y=0.135
+ $X2=0.459 $Y2=0.135
r48 1 33 19.3796 $a=3.24e-16 $layer=V0LIG $X=0.459 $Y=0.135 $X2=0.4545 $Y2=0.135
r49 31 30 14.6259 $w=2.1e-08 $l=4.3e-08 $layer=Gate_1 $thickness=5.6e-08
+ $X=0.459 $Y=0.2025 $X2=0.459 $Y2=0.1595
r50 29 30 2.7211 $w=2.1e-08 $l=8e-09 $layer=Gate_1 $thickness=5.6e-08 $X=0.459
+ $Y=0.1515 $X2=0.459 $Y2=0.1595
r51 28 29 5.79936 $w=2.03333e-08 $l=1.65e-08 $layer=Gate_1 $thickness=5.6e-08
+ $X=0.459 $Y=0.135 $X2=0.459 $Y2=0.1515
r52 27 28 5.79936 $w=2.03333e-08 $l=1.65e-08 $layer=Gate_1 $thickness=5.6e-08
+ $X=0.459 $Y=0.1185 $X2=0.459 $Y2=0.135
r53 26 27 2.7211 $w=2.1e-08 $l=8e-09 $layer=Gate_1 $thickness=5.6e-08 $X=0.459
+ $Y=0.1105 $X2=0.459 $Y2=0.1185
r54 25 26 14.6259 $w=2.1e-08 $l=4.3e-08 $layer=Gate_1 $thickness=5.6e-08
+ $X=0.459 $Y=0.0675 $X2=0.459 $Y2=0.1105
r55 25 12 14.6259 $w=2.1e-08 $l=4.3e-08 $layer=Gate_1 $thickness=5.6e-08
+ $X=0.459 $Y=0.0675 $X2=0.459 $Y2=0.0245
r56 3 13 1e-05 $l=2e-09 $X=0.054 $Y=0.054 $X2=0.056 $Y2=0.054
.ends

.subckt PM_AO221x1_ASAP7_75t_R%B1 vss 15 5 11 4 3 1
c1 1 vss 0.00333805f $X=0.081 $Y=0.135
c2 3 vss 0.0692213f $X=0.081 $Y=0.0245
c3 4 vss 0.00570803f $X=0.081 $Y=0.098
r1 15 14 0.524677 $w=1.3e-08 $l=2.3e-09 $layer=M1 $thickness=3.6e-08 $X=0.076
+ $Y=0.148 $X2=0.081 $Y2=0.1457
r2 13 14 2.50679 $w=1.3e-08 $l=1.07e-08 $layer=M1 $thickness=3.6e-08 $X=0.081
+ $Y=0.135 $X2=0.081 $Y2=0.1457
r3 4 13 8.62802 $w=1.3e-08 $l=3.7e-08 $layer=M1 $thickness=3.6e-08 $X=0.081
+ $Y=0.098 $X2=0.081 $Y2=0.135
r4 1 8 10.4265 $w=1.765e-08 $layer=LIG $thickness=5.2e-08 $X=0.081 $Y=0.135
+ $X2=0.081 $Y2=0.135
r5 1 13 19.3796 $a=3.24e-16 $layer=V0LIG $X=0.081 $Y=0.135 $X2=0.081 $Y2=0.135
r6 11 10 14.6259 $w=2.1e-08 $l=4.3e-08 $layer=Gate_1 $thickness=5.6e-08
+ $X=0.081 $Y=0.2025 $X2=0.081 $Y2=0.1595
r7 9 10 2.7211 $w=2.1e-08 $l=8e-09 $layer=Gate_1 $thickness=5.6e-08 $X=0.081
+ $Y=0.1515 $X2=0.081 $Y2=0.1595
r8 8 9 5.79936 $w=2.03333e-08 $l=1.65e-08 $layer=Gate_1 $thickness=5.6e-08
+ $X=0.081 $Y=0.135 $X2=0.081 $Y2=0.1515
r9 7 8 5.79936 $w=2.03333e-08 $l=1.65e-08 $layer=Gate_1 $thickness=5.6e-08
+ $X=0.081 $Y=0.1185 $X2=0.081 $Y2=0.135
r10 6 7 7.31297 $w=2.1e-08 $l=2.15e-08 $layer=Gate_1 $thickness=5.6e-08
+ $X=0.081 $Y=0.097 $X2=0.081 $Y2=0.1185
r11 5 6 14.6259 $w=2.1e-08 $l=4.3e-08 $layer=Gate_1 $thickness=5.6e-08 $X=0.081
+ $Y=0.054 $X2=0.081 $Y2=0.097
r12 5 3 10.0341 $w=2.1e-08 $l=2.95e-08 $layer=Gate_1 $thickness=5.6e-08
+ $X=0.081 $Y=0.054 $X2=0.081 $Y2=0.0245
.ends

.subckt PM_AO221x1_ASAP7_75t_R%A1 vss 13 5 9 4 3
c1 1 vss 0.00661425f $X=0.243 $Y=0.135
c2 3 vss 0.10092f $X=0.243 $Y=0.0245
c3 4 vss 0.00520438f $X=0.243 $Y=0.098
r1 13 12 0.874462 $w=1.3e-08 $l=3.8e-09 $layer=M1 $thickness=3.6e-08 $X=0.244
+ $Y=0.151 $X2=0.243 $Y2=0.1472
r2 11 12 2.85657 $w=1.3e-08 $l=1.22e-08 $layer=M1 $thickness=3.6e-08 $X=0.243
+ $Y=0.135 $X2=0.243 $Y2=0.1472
r3 4 11 8.62802 $w=1.3e-08 $l=3.7e-08 $layer=M1 $thickness=3.6e-08 $X=0.243
+ $Y=0.098 $X2=0.243 $Y2=0.135
r4 1 7 10.4265 $w=1.765e-08 $layer=LIG $thickness=5.2e-08 $X=0.243 $Y=0.135
+ $X2=0.243 $Y2=0.135
r5 1 11 19.3796 $a=3.24e-16 $layer=V0LIG $X=0.243 $Y=0.135 $X2=0.243 $Y2=0.135
r6 9 8 16.4967 $w=2.1e-08 $l=4.85e-08 $layer=Gate_1 $thickness=5.6e-08 $X=0.243
+ $Y=0.2025 $X2=0.243 $Y2=0.154
r7 7 8 6.6497 $w=2.04211e-08 $l=1.9e-08 $layer=Gate_1 $thickness=5.6e-08
+ $X=0.243 $Y=0.135 $X2=0.243 $Y2=0.154
r8 6 7 11.2416 $w=2.06615e-08 $l=3.25e-08 $layer=Gate_1 $thickness=5.6e-08
+ $X=0.243 $Y=0.1025 $X2=0.243 $Y2=0.135
r9 5 6 16.4967 $w=2.1e-08 $l=4.85e-08 $layer=Gate_1 $thickness=5.6e-08 $X=0.243
+ $Y=0.054 $X2=0.243 $Y2=0.1025
r10 5 3 10.0341 $w=2.1e-08 $l=2.95e-08 $layer=Gate_1 $thickness=5.6e-08
+ $X=0.243 $Y=0.054 $X2=0.243 $Y2=0.0245
.ends

* End of included file AO221x1_ASAP7_75t_R.pex.sp.pex

*
.subckt AO221x1_ASAP7_75t_CUSTOM_4_25_0_7 VSS VDD B1 B2 C A1 A2 Y
*
* VSS VSS
* VDD VDD
* B1 B1
* B2 B2
* C C
* A1 A1
* A2 A2
* Y Y
*
*

M0 noxref_12 N_M0_g N_M0_s VSS nmos_rvt L=2e-08 W=5.4e-08 nfin=2 $X=0.071
+ $Y=0.027
M1 VSS N_M1_g noxref_12 VSS nmos_rvt L=2e-08 W=5.4e-08 nfin=2 $X=0.125 $Y=0.027
M2 N_M2_d N_M2_g VSS VSS nmos_rvt L=2e-08 W=5.4e-08 nfin=2 $X=0.179 $Y=0.027
M3 noxref_13 N_M3_g N_M3_s VSS nmos_rvt L=2e-08 W=5.4e-08 nfin=2 $X=0.233
+ $Y=0.027
M4 VSS N_M4_g noxref_13 VSS nmos_rvt L=2e-08 W=5.4e-08 nfin=2 $X=0.287 $Y=0.027
M5 N_M5_d N_M5_g VSS VSS nmos_rvt L=2e-08 W=8.1e-08 nfin=3 $X=0.449 $Y=0.027
M6 N_M6_d N_M6_g noxref_9 VDD pmos_rvt L=2e-08 W=8.1e-08 nfin=3 $X=0.071
+ $Y=0.162
M7 noxref_9 N_M7_g N_M7_s VDD pmos_rvt L=2e-08 W=8.1e-08 nfin=3 $X=0.125
+ $Y=0.162
M8 noxref_10 N_M8_g noxref_9 VDD pmos_rvt L=2e-08 W=8.1e-08 nfin=3 $X=0.179
+ $Y=0.162
M9 VDD N_M9_g noxref_10 VDD pmos_rvt L=2e-08 W=8.1e-08 nfin=3 $X=0.233 $Y=0.162
M10 noxref_10 N_M10_g VDD VDD pmos_rvt L=2e-08 W=8.1e-08 nfin=3 $X=0.287
+ $Y=0.162
M11 N_M11_d N_M11_g VDD VDD pmos_rvt L=2e-08 W=8.1e-08 nfin=3 $X=0.449 $Y=0.162

* .include "AO221x1_ASAP7_75t_R.pex.sp.pxi"

* Start of included file AO221x1_ASAP7_75t_R.pex.sp.pxi
x_PM_AO221x1_ASAP7_75t_R%C vss C N_M2_g N_M8_g N_C_4 N_C_3
+ PM_AO221x1_ASAP7_75t_R%C
cc_1 N_C_4 N_B2_4 0.00337278f $X=0.189 $Y=0.0962
cc_2 N_C_3 N_B2_3 0.00715272f $X=0.189 $Y=0.0245
x_PM_AO221x1_ASAP7_75t_R%A2 vss A2 N_M4_g N_M10_g N_A2_4 N_A2_3
+ PM_AO221x1_ASAP7_75t_R%A2
cc_3 N_A2_4 N_A1_4 0.00332975f $X=0.297 $Y=0.0962
cc_4 N_A2_3 N_A1_3 0.00863056f $X=0.297 $Y=0.0245
x_PM_AO221x1_ASAP7_75t_R%B2 vss B2 N_M1_g N_M7_g N_B2_4 N_B2_3 N_B2_1
+ PM_AO221x1_ASAP7_75t_R%B2
cc_5 N_B2_4 N_B1_4 0.00331384f $X=0.135 $Y=0.0892
cc_6 N_B2_3 N_B1_3 0.0085892f $X=0.135 $Y=0.0245
x_PM_AO221x1_ASAP7_75t_R%Y vss Y N_M5_d N_M11_d N_Y_7 N_Y_12 N_Y_8
+ PM_AO221x1_ASAP7_75t_R%Y
cc_7 N_Y_7 N_8_23 0.00061725f $X=0.4715 $Y=0.0675
cc_8 N_Y_7 N_8_1 0.0026208f $X=0.4715 $Y=0.0675
cc_9 N_Y_7 N_8_18 0.00106313f $X=0.4715 $Y=0.0675
cc_10 N_Y_12 N_8_24 0.00352044f $X=0.513 $Y=0.0855
cc_11 N_Y_8 N_8_12 0.0148696f $X=0.4715 $Y=0.2025
cc_12 N_Y_7 N_8_12 0.0565971f $X=0.4715 $Y=0.0675
x_PM_AO221x1_ASAP7_75t_R%8 vss N_M5_g N_M11_g N_M2_d N_M3_s N_M0_s N_M6_d
+ N_M7_s N_8_4 N_8_3 N_8_22 N_8_21 N_8_15 N_8_13 N_8_20 N_8_5 N_8_14 N_8_23
+ N_8_1 N_8_18 N_8_24 N_8_12 PM_AO221x1_ASAP7_75t_R%8
cc_13 N_8_4 N_B1_3 0.00159013f $X=0.108 $Y=0.2025
cc_14 N_8_3 N_B1_3 0.000914512f $X=0.054 $Y=0.054
cc_15 N_8_22 N_B1_4 0.000979267f $X=0.0375 $Y=0.198
cc_16 N_8_21 N_B1_4 0.00111226f $X=0.3675 $Y=0.036
cc_17 N_8_15 N_B1_1 0.00126646f $X=0.0935 $Y=0.2025
cc_18 N_8_13 N_B1_3 0.0108968f $X=0.056 $Y=0.054
cc_19 N_8_20 N_B1_4 0.00657348f $X=0.027 $Y=0.0575
cc_20 N_8_15 N_B1_3 0.0505764f $X=0.0935 $Y=0.2025
cc_21 N_8_4 N_B2_3 0.00122513f $X=0.108 $Y=0.2025
cc_22 N_8_22 N_B2_3 0.000586919f $X=0.0375 $Y=0.198
cc_23 N_8_15 N_B2_1 0.000856813f $X=0.0935 $Y=0.2025
cc_24 N_8_21 N_B2_4 0.0012899f $X=0.3675 $Y=0.036
cc_25 N_8_4 N_B2_4 0.00224985f $X=0.108 $Y=0.2025
cc_26 N_8_15 N_B2_3 0.036081f $X=0.0935 $Y=0.2025
cc_27 N_8_5 N_C_3 0.000626125f $X=0.216 $Y=0.054
cc_28 N_8_21 N_C_3 0.00114262f $X=0.3675 $Y=0.036
cc_29 N_8_5 N_C_4 0.00170841f $X=0.216 $Y=0.054
cc_30 N_8_14 N_C_3 0.0260375f $X=0.2015 $Y=0.054
cc_31 N_8_5 N_A1_3 0.000873047f $X=0.216 $Y=0.054
cc_32 N_8_21 N_A1_4 0.00123246f $X=0.3675 $Y=0.036
cc_33 N_8_5 N_A1_4 0.00173442f $X=0.216 $Y=0.054
cc_34 N_8_14 N_A1_3 0.0266132f $X=0.2015 $Y=0.054
cc_35 N_8_5 N_A2_4 0.00025375f $X=0.216 $Y=0.054
cc_36 N_8_23 N_A2_4 0.000272011f $X=0.405 $Y=0.098
cc_37 N_8_21 N_A2_4 0.00417358f $X=0.3675 $Y=0.036
x_PM_AO221x1_ASAP7_75t_R%B1 vss B1 N_M0_g N_M6_g N_B1_4 N_B1_3 N_B1_1
+ PM_AO221x1_ASAP7_75t_R%B1
x_PM_AO221x1_ASAP7_75t_R%A1 vss A1 N_M3_g N_M9_g N_A1_4 N_A1_3
+ PM_AO221x1_ASAP7_75t_R%A1
cc_38 N_A1_4 N_C_4 0.00330509f $X=0.243 $Y=0.098
cc_39 N_A1_3 N_C_3 0.00713846f $X=0.243 $Y=0.0245

* End of included file AO221x1_ASAP7_75t_R.pex.sp.pxi
.ends

.subckt PM_AOI32xp33_ASAP7_75t_R%A3 vss 16 6 10 1 5 3
c1 1 vss 0.00379586f $X=0.189 $Y=0.135
c2 3 vss 0.135076f $X=0.189 $Y=0.0245
c3 4 vss 0.00634048f $X=0.1832 $Y=0.198
c4 5 vss 0.00429194f $X=0.189 $Y=0.1035
r1 16 4 0.382667 $w=1.8e-08 $l=3.8e-09 $layer=M1 $thickness=3.6e-08 $X=0.187
+ $Y=0.1945 $X2=0.1832 $Y2=0.198
r2 16 15 2.96589 $w=1.31923e-08 $l=2.15928e-08 $layer=M1 $thickness=3.6e-08
+ $X=0.187 $Y=0.1945 $X2=0.189 $Y2=0.1765
r3 13 15 5.24677 $w=1.3e-08 $l=2.25e-08 $layer=M1 $thickness=3.6e-08 $X=0.189
+ $Y=0.154 $X2=0.189 $Y2=0.1765
r4 12 13 4.43061 $w=1.3e-08 $l=1.9e-08 $layer=M1 $thickness=3.6e-08 $X=0.189
+ $Y=0.135 $X2=0.189 $Y2=0.154
r5 5 12 7.34548 $w=1.3e-08 $l=3.15e-08 $layer=M1 $thickness=3.6e-08 $X=0.189
+ $Y=0.1035 $X2=0.189 $Y2=0.135
r6 1 8 10.4265 $w=1.765e-08 $layer=LIG $thickness=5.2e-08 $X=0.189 $Y=0.135
+ $X2=0.189 $Y2=0.135
r7 1 12 19.3796 $a=3.24e-16 $layer=V0LIG $X=0.189 $Y=0.135 $X2=0.189 $Y2=0.135
r8 10 9 16.4967 $w=2.1e-08 $l=4.85e-08 $layer=Gate_1 $thickness=5.6e-08
+ $X=0.189 $Y=0.216 $X2=0.189 $Y2=0.1675
r9 8 9 11.2416 $w=2.06615e-08 $l=3.25e-08 $layer=Gate_1 $thickness=5.6e-08
+ $X=0.189 $Y=0.135 $X2=0.189 $Y2=0.1675
r10 7 8 6.6497 $w=2.04211e-08 $l=1.9e-08 $layer=Gate_1 $thickness=5.6e-08
+ $X=0.189 $Y=0.116 $X2=0.189 $Y2=0.135
r11 6 7 16.4967 $w=2.1e-08 $l=4.85e-08 $layer=Gate_1 $thickness=5.6e-08
+ $X=0.189 $Y=0.0675 $X2=0.189 $Y2=0.116
r12 6 3 14.6259 $w=2.1e-08 $l=4.3e-08 $layer=Gate_1 $thickness=5.6e-08 $X=0.189
+ $Y=0.0675 $X2=0.189 $Y2=0.0245
.ends

.subckt PM_AOI32xp33_ASAP7_75t_R%B1 vss 11 5 9 4 3
c1 1 vss 0.00493615f $X=0.243 $Y=0.135
c2 3 vss 0.0891408f $X=0.243 $Y=0.0245
c3 4 vss 0.00355893f $X=0.243 $Y=0.0945
r1 12 13 2.79828 $w=1.3e-08 $l=1.2e-08 $layer=M1 $thickness=3.6e-08 $X=0.243
+ $Y=0.123 $X2=0.243 $Y2=0.135
r2 11 12 0.816164 $w=1.3e-08 $l=3.5e-09 $layer=M1 $thickness=3.6e-08 $X=0.243
+ $Y=0.1195 $X2=0.243 $Y2=0.123
r3 11 4 5.82974 $w=1.3e-08 $l=2.5e-08 $layer=M1 $thickness=3.6e-08 $X=0.243
+ $Y=0.1195 $X2=0.243 $Y2=0.0945
r4 1 7 10.4265 $w=1.765e-08 $layer=LIG $thickness=5.2e-08 $X=0.243 $Y=0.135
+ $X2=0.243 $Y2=0.135
r5 1 13 19.3796 $a=3.24e-16 $layer=V0LIG $X=0.243 $Y=0.135 $X2=0.243 $Y2=0.135
r6 9 8 16.4967 $w=2.1e-08 $l=4.85e-08 $layer=Gate_1 $thickness=5.6e-08 $X=0.243
+ $Y=0.216 $X2=0.243 $Y2=0.1675
r7 7 8 11.2416 $w=2.06615e-08 $l=3.25e-08 $layer=Gate_1 $thickness=5.6e-08
+ $X=0.243 $Y=0.135 $X2=0.243 $Y2=0.1675
r8 6 7 11.2416 $w=2.06615e-08 $l=3.25e-08 $layer=Gate_1 $thickness=5.6e-08
+ $X=0.243 $Y=0.1025 $X2=0.243 $Y2=0.135
r9 5 6 16.4967 $w=2.1e-08 $l=4.85e-08 $layer=Gate_1 $thickness=5.6e-08 $X=0.243
+ $Y=0.054 $X2=0.243 $Y2=0.1025
r10 5 3 10.0341 $w=2.1e-08 $l=2.95e-08 $layer=Gate_1 $thickness=5.6e-08
+ $X=0.243 $Y=0.054 $X2=0.243 $Y2=0.0245
.ends

.subckt PM_AOI32xp33_ASAP7_75t_R%B2 vss 13 5 11 4 3
c1 1 vss 0.00607459f $X=0.297 $Y=0.135
c2 3 vss 0.0574879f $X=0.297 $Y=0.0245
c3 4 vss 0.0034427f $X=0.297 $Y=0.098
r1 13 4 8.62802 $w=1.3e-08 $l=3.7e-08 $layer=M1 $thickness=3.6e-08 $X=0.297
+ $Y=0.1335 $X2=0.297 $Y2=0.098
r2 1 8 10.4265 $w=1.765e-08 $layer=LIG $thickness=5.2e-08 $X=0.297 $Y=0.135
+ $X2=0.297 $Y2=0.135
r3 13 1 19.3796 $a=3.24e-16 $layer=V0LIG $X=0.297 $Y=0.1335 $X2=0.297 $Y2=0.135
r4 11 10 14.6259 $w=2.1e-08 $l=4.3e-08 $layer=Gate_1 $thickness=5.6e-08
+ $X=0.297 $Y=0.216 $X2=0.297 $Y2=0.173
r5 9 10 7.31297 $w=2.1e-08 $l=2.15e-08 $layer=Gate_1 $thickness=5.6e-08
+ $X=0.297 $Y=0.1515 $X2=0.297 $Y2=0.173
r6 8 9 5.79936 $w=2.03333e-08 $l=1.65e-08 $layer=Gate_1 $thickness=5.6e-08
+ $X=0.297 $Y=0.135 $X2=0.297 $Y2=0.1515
r7 7 8 5.79936 $w=2.03333e-08 $l=1.65e-08 $layer=Gate_1 $thickness=5.6e-08
+ $X=0.297 $Y=0.1185 $X2=0.297 $Y2=0.135
r8 6 7 7.31297 $w=2.1e-08 $l=2.15e-08 $layer=Gate_1 $thickness=5.6e-08 $X=0.297
+ $Y=0.097 $X2=0.297 $Y2=0.1185
r9 5 6 14.6259 $w=2.1e-08 $l=4.3e-08 $layer=Gate_1 $thickness=5.6e-08 $X=0.297
+ $Y=0.054 $X2=0.297 $Y2=0.097
r10 5 3 10.0341 $w=2.1e-08 $l=2.95e-08 $layer=Gate_1 $thickness=5.6e-08
+ $X=0.297 $Y=0.054 $X2=0.297 $Y2=0.0245
.ends

.subckt PM_AOI32xp33_ASAP7_75t_R%Y vss 37 19 43 51 52 1 15 10 16 12 17 11 3
c1 1 vss 0.00648763f $X=0.054 $Y=0.0675
c2 2 vss 0.00798884f $X=0.27 $Y=0.216
c3 3 vss 0.00618989f $X=0.324 $Y=0.054
c4 10 vss 0.0374517f $X=0.056 $Y=0.0675
c5 11 vss 0.0276982f $X=0.3095 $Y=0.054
c6 12 vss 0.00386937f $X=0.2555 $Y=0.216
c7 13 vss 0.00273513f $X=0.351 $Y=0.0302
c8 14 vss 0.0023435f $X=0.351 $Y=0.198
c9 15 vss 0.0263385f $X=0.0425 $Y=0.036
c10 16 vss 0.00742941f $X=0.34 $Y=0.198
c11 17 vss 0.00470696f $X=0.351 $Y=0.054
r1 52 50 0.0462963 $w=5.4e-08 $l=2.5e-09 $layer=P_src_drn $thickness=1e-09
+ $X=0.2873 $Y=0.216 $X2=0.2845 $Y2=0.216
r2 2 50 0.268519 $w=5.4e-08 $l=1.45e-08 $layer=P_src_drn $thickness=1e-09
+ $X=0.27 $Y=0.216 $X2=0.2845 $Y2=0.216
r3 12 2 0.268519 $w=5.4e-08 $l=1.45e-08 $layer=P_src_drn $thickness=1e-09
+ $X=0.2555 $Y=0.216 $X2=0.27 $Y2=0.216
r4 51 12 0.0462963 $w=5.4e-08 $l=2.5e-09 $layer=P_src_drn $thickness=1e-09
+ $X=0.2526 $Y=0.216 $X2=0.2555 $Y2=0.216
r5 2 47 19.3796 $a=3.24e-16 $layer=V0LISD $X=0.27 $Y=0.216 $X2=0.27 $Y2=0.198
r6 47 48 3.14806 $w=1.3e-08 $l=1.35e-08 $layer=M1 $thickness=3.6e-08 $X=0.27
+ $Y=0.198 $X2=0.2835 $Y2=0.198
r7 45 48 3.14806 $w=1.3e-08 $l=1.35e-08 $layer=M1 $thickness=3.6e-08 $X=0.297
+ $Y=0.198 $X2=0.2835 $Y2=0.198
r8 44 45 5.82974 $w=1.3e-08 $l=2.5e-08 $layer=M1 $thickness=3.6e-08 $X=0.322
+ $Y=0.198 $X2=0.297 $Y2=0.198
r9 16 44 4.19742 $w=1.3e-08 $l=1.8e-08 $layer=M1 $thickness=3.6e-08 $X=0.34
+ $Y=0.198 $X2=0.322 $Y2=0.198
r10 14 41 3.36447 $w=1.71023e-08 $l=2.15e-08 $layer=M1 $thickness=3.6e-08
+ $X=0.351 $Y=0.198 $X2=0.351 $Y2=0.1765
r11 14 16 0.915974 $w=1.70909e-08 $l=1.1e-08 $layer=M1 $thickness=3.6e-08
+ $X=0.351 $Y=0.198 $X2=0.34 $Y2=0.198
r12 11 3 0.231482 $w=5.4e-08 $l=1.25e-08 $layer=N_src_drn $thickness=1e-09
+ $X=0.3095 $Y=0.054 $X2=0.324 $Y2=0.054
r13 43 11 0.0462963 $w=5.4e-08 $l=2.5e-09 $layer=N_src_drn $thickness=1e-09
+ $X=0.3066 $Y=0.054 $X2=0.3095 $Y2=0.054
r14 40 41 13.8748 $w=1.3e-08 $l=5.95e-08 $layer=M1 $thickness=3.6e-08 $X=0.351
+ $Y=0.117 $X2=0.351 $Y2=0.1765
r15 39 40 11.7761 $w=1.3e-08 $l=5.05e-08 $layer=M1 $thickness=3.6e-08 $X=0.351
+ $Y=0.0665 $X2=0.351 $Y2=0.117
r16 17 38 2.63444 $w=1.48421e-08 $l=1.43e-08 $layer=M1 $thickness=3.6e-08
+ $X=0.351 $Y=0.054 $X2=0.351 $Y2=0.0397
r17 17 39 2.91487 $w=1.3e-08 $l=1.25e-08 $layer=M1 $thickness=3.6e-08 $X=0.351
+ $Y=0.054 $X2=0.351 $Y2=0.0665
r18 3 35 19.3796 $a=3.24e-16 $layer=V0LISD $X=0.324 $Y=0.054 $X2=0.324 $Y2=0.036
r19 37 38 0.586756 $w=1.8e-08 $l=5.7e-09 $layer=M1 $thickness=3.6e-08 $X=0.355
+ $Y=0.034 $X2=0.351 $Y2=0.0397
r20 37 13 0.382667 $w=1.8e-08 $l=3.8e-09 $layer=M1 $thickness=3.6e-08 $X=0.355
+ $Y=0.034 $X2=0.351 $Y2=0.0302
r21 37 36 1.10038 $w=5e-09 $l=1.36473e-08 $layer=M1 $thickness=3.6e-08 $X=0.355
+ $Y=0.034 $X2=0.3375 $Y2=0.036
r22 35 36 3.14806 $w=1.3e-08 $l=1.35e-08 $layer=M1 $thickness=3.6e-08 $X=0.324
+ $Y=0.036 $X2=0.3375 $Y2=0.036
r23 34 35 3.14806 $w=1.3e-08 $l=1.35e-08 $layer=M1 $thickness=3.6e-08 $X=0.3105
+ $Y=0.036 $X2=0.324 $Y2=0.036
r24 33 34 3.14806 $w=1.3e-08 $l=1.35e-08 $layer=M1 $thickness=3.6e-08 $X=0.297
+ $Y=0.036 $X2=0.3105 $Y2=0.036
r25 32 33 5.82974 $w=1.3e-08 $l=2.5e-08 $layer=M1 $thickness=3.6e-08 $X=0.272
+ $Y=0.036 $X2=0.297 $Y2=0.036
r26 31 32 4.19742 $w=1.3e-08 $l=1.8e-08 $layer=M1 $thickness=3.6e-08 $X=0.254
+ $Y=0.036 $X2=0.272 $Y2=0.036
r27 30 31 2.56509 $w=1.3e-08 $l=1.1e-08 $layer=M1 $thickness=3.6e-08 $X=0.243
+ $Y=0.036 $X2=0.254 $Y2=0.036
r28 29 30 3.49785 $w=1.3e-08 $l=1.5e-08 $layer=M1 $thickness=3.6e-08 $X=0.228
+ $Y=0.036 $X2=0.243 $Y2=0.036
r29 28 29 4.19742 $w=1.3e-08 $l=1.8e-08 $layer=M1 $thickness=3.6e-08 $X=0.21
+ $Y=0.036 $X2=0.228 $Y2=0.036
r30 27 28 4.89699 $w=1.3e-08 $l=2.1e-08 $layer=M1 $thickness=3.6e-08 $X=0.189
+ $Y=0.036 $X2=0.21 $Y2=0.036
r31 26 27 6.29612 $w=1.3e-08 $l=2.7e-08 $layer=M1 $thickness=3.6e-08 $X=0.162
+ $Y=0.036 $X2=0.189 $Y2=0.036
r32 25 26 8.86121 $w=1.3e-08 $l=3.8e-08 $layer=M1 $thickness=3.6e-08 $X=0.124
+ $Y=0.036 $X2=0.162 $Y2=0.036
r33 24 25 5.82974 $w=1.3e-08 $l=2.5e-08 $layer=M1 $thickness=3.6e-08 $X=0.099
+ $Y=0.036 $X2=0.124 $Y2=0.036
r34 23 24 3.03147 $w=1.3e-08 $l=1.3e-08 $layer=M1 $thickness=3.6e-08 $X=0.086
+ $Y=0.036 $X2=0.099 $Y2=0.036
r35 22 23 3.61444 $w=1.3e-08 $l=1.55e-08 $layer=M1 $thickness=3.6e-08 $X=0.0705
+ $Y=0.036 $X2=0.086 $Y2=0.036
r36 21 22 2.3319 $w=1.3e-08 $l=1e-08 $layer=M1 $thickness=3.6e-08 $X=0.0605
+ $Y=0.036 $X2=0.0705 $Y2=0.036
r37 20 21 2.09871 $w=1.3e-08 $l=9e-09 $layer=M1 $thickness=3.6e-08 $X=0.0515
+ $Y=0.036 $X2=0.0605 $Y2=0.036
r38 15 20 2.09871 $w=1.3e-08 $l=9e-09 $layer=M1 $thickness=3.6e-08 $X=0.0425
+ $Y=0.036 $X2=0.0515 $Y2=0.036
r39 1 20 19.3796 $a=3.24e-16 $layer=V0LISD $X=0.054 $Y=0.0675 $X2=0.0515
+ $Y2=0.036
r40 19 18 0.0308642 $w=8.1e-08 $l=2.5e-09 $layer=N_src_drn $thickness=1e-09
+ $X=0.0713 $Y=0.0675 $X2=0.0685 $Y2=0.0675
r41 10 18 0.154321 $w=8.1e-08 $l=1.25e-08 $layer=N_src_drn $thickness=1e-09
+ $X=0.056 $Y=0.0675 $X2=0.0685 $Y2=0.0675
r42 1 10 1e-05 $l=2e-09 $X=0.054 $Y=0.0675 $X2=0.056 $Y2=0.0675
.ends

.subckt PM_AOI32xp33_ASAP7_75t_R%A2 vss 15 7 11 4 6 1 3
c1 1 vss 0.00235617f $X=0.135 $Y=0.135
c2 3 vss 0.103348f $X=0.135 $Y=0.0245
c3 4 vss 0.00140629f $X=0.1302 $Y=0.072
c4 5 vss 0.00620167f $X=0.135 $Y=0.198
c5 6 vss 0.00325251f $X=0.135 $Y=0.135
r1 5 14 6.16517 $w=1.44286e-08 $l=3.15e-08 $layer=M1 $thickness=3.6e-08
+ $X=0.135 $Y=0.198 $X2=0.135 $Y2=0.1665
r2 15 4 0.484711 $w=1.8e-08 $l=4.8e-09 $layer=M1 $thickness=3.6e-08 $X=0.135
+ $Y=0.0785 $X2=0.1302 $Y2=0.072
r3 15 13 5.29779 $w=1.31087e-08 $l=3.15e-08 $layer=M1 $thickness=3.6e-08
+ $X=0.135 $Y=0.0785 $X2=0.135 $Y2=0.1035
r4 6 13 7.34548 $w=1.3e-08 $l=3.15e-08 $layer=M1 $thickness=3.6e-08 $X=0.135
+ $Y=0.135 $X2=0.135 $Y2=0.1035
r5 6 14 7.34548 $w=1.3e-08 $l=3.15e-08 $layer=M1 $thickness=3.6e-08 $X=0.135
+ $Y=0.135 $X2=0.135 $Y2=0.1665
r6 1 9 10.4265 $w=1.765e-08 $layer=LIG $thickness=5.2e-08 $X=0.135 $Y=0.135
+ $X2=0.135 $Y2=0.135
r7 1 6 19.3796 $a=3.24e-16 $layer=V0LIG $X=0.135 $Y=0.135 $X2=0.135 $Y2=0.135
r8 11 10 16.4967 $w=2.1e-08 $l=4.85e-08 $layer=Gate_1 $thickness=5.6e-08
+ $X=0.135 $Y=0.216 $X2=0.135 $Y2=0.1675
r9 9 10 11.2416 $w=2.06615e-08 $l=3.25e-08 $layer=Gate_1 $thickness=5.6e-08
+ $X=0.135 $Y=0.135 $X2=0.135 $Y2=0.1675
r10 8 9 6.6497 $w=2.04211e-08 $l=1.9e-08 $layer=Gate_1 $thickness=5.6e-08
+ $X=0.135 $Y=0.116 $X2=0.135 $Y2=0.135
r11 7 8 16.4967 $w=2.1e-08 $l=4.85e-08 $layer=Gate_1 $thickness=5.6e-08
+ $X=0.135 $Y=0.0675 $X2=0.135 $Y2=0.116
r12 7 3 14.6259 $w=2.1e-08 $l=4.3e-08 $layer=Gate_1 $thickness=5.6e-08 $X=0.135
+ $Y=0.0675 $X2=0.135 $Y2=0.0245
.ends

.subckt PM_AOI32xp33_ASAP7_75t_R%A1 vss 29 10 16 3 9 1 4
c1 1 vss 0.00487848f $X=0.072 $Y=0.135
c2 3 vss 0.0866336f $X=0.081 $Y=0.0245
c3 4 vss 0.00290279f $X=0.027 $Y=0.072
c4 5 vss 0.00106069f $X=0.027 $Y=0.135
c5 6 vss 0.0079587f $X=0.0267 $Y=0.234
c6 7 vss 0.00278974f $X=0.027 $Y=0.1035
c7 8 vss 0.00675907f $X=0.027 $Y=0.1665
c8 9 vss 0.00192871f $X=0.0455 $Y=0.135
r1 29 6 0.9184 $w=1.8e-08 $l=9e-09 $layer=M1 $thickness=3.6e-08 $X=0.036
+ $Y=0.2345 $X2=0.0267 $Y2=0.234
r2 4 7 6.16517 $w=1.44286e-08 $l=3.15e-08 $layer=M1 $thickness=3.6e-08 $X=0.027
+ $Y=0.072 $X2=0.027 $Y2=0.1035
r3 29 26 2.12422 $w=1.31351e-08 $l=1.99922e-08 $layer=M1 $thickness=3.6e-08
+ $X=0.036 $Y=0.2345 $X2=0.027 $Y2=0.216
r4 25 26 4.19742 $w=1.3e-08 $l=1.8e-08 $layer=M1 $thickness=3.6e-08 $X=0.027
+ $Y=0.198 $X2=0.027 $Y2=0.216
r5 8 25 7.34548 $w=1.3e-08 $l=3.15e-08 $layer=M1 $thickness=3.6e-08 $X=0.027
+ $Y=0.1665 $X2=0.027 $Y2=0.198
r6 5 9 3.1337 $w=1.54324e-08 $l=1.85e-08 $layer=M1 $thickness=3.6e-08 $X=0.027
+ $Y=0.135 $X2=0.0455 $Y2=0.135
r7 5 7 6.16517 $w=1.44286e-08 $l=3.15e-08 $layer=M1 $thickness=3.6e-08 $X=0.027
+ $Y=0.135 $X2=0.027 $Y2=0.1035
r8 5 8 6.16517 $w=1.44286e-08 $l=3.15e-08 $layer=M1 $thickness=3.6e-08 $X=0.027
+ $Y=0.135 $X2=0.027 $Y2=0.1665
r9 22 23 2.09871 $w=1.3e-08 $l=9e-09 $layer=M1 $thickness=3.6e-08 $X=0.0565
+ $Y=0.135 $X2=0.0655 $Y2=0.135
r10 9 22 2.56509 $w=1.3e-08 $l=1.1e-08 $layer=M1 $thickness=3.6e-08 $X=0.0455
+ $Y=0.135 $X2=0.0565 $Y2=0.135
r11 20 23 19.3796 $a=3.24e-16 $layer=V0LIG $X=0.063 $Y=0.135 $X2=0.0655
+ $Y2=0.135
r12 1 18 2.6116 $w=2.2e-08 $l=1e-08 $layer=LIG $thickness=4.8e-08 $X=0.072
+ $Y=0.135 $X2=0.082 $Y2=0.135
r13 1 20 4.98695 $w=1.60444e-08 $l=9e-09 $layer=LIG $thickness=4.8e-08 $X=0.072
+ $Y=0.135 $X2=0.063 $Y2=0.135
r14 16 15 14.6259 $w=2.1e-08 $l=4.3e-08 $layer=Gate_1 $thickness=5.6e-08
+ $X=0.081 $Y=0.216 $X2=0.081 $Y2=0.173
r15 14 15 7.31297 $w=2.1e-08 $l=2.15e-08 $layer=Gate_1 $thickness=5.6e-08
+ $X=0.081 $Y=0.1515 $X2=0.081 $Y2=0.173
r16 13 14 5.79936 $w=2.03333e-08 $l=1.65e-08 $layer=Gate_1 $thickness=5.6e-08
+ $X=0.081 $Y=0.135 $X2=0.081 $Y2=0.1515
r17 13 18 6.27904 $w=2.09e-08 $l=1e-09 $layer=Gate_1 $thickness=5.24e-08
+ $X=0.081 $Y=0.135 $X2=0.082 $Y2=0.135
r18 12 13 5.79936 $w=2.03333e-08 $l=1.65e-08 $layer=Gate_1 $thickness=5.6e-08
+ $X=0.081 $Y=0.1185 $X2=0.081 $Y2=0.135
r19 11 12 2.7211 $w=2.1e-08 $l=8e-09 $layer=Gate_1 $thickness=5.6e-08 $X=0.081
+ $Y=0.1105 $X2=0.081 $Y2=0.1185
r20 10 11 14.6259 $w=2.1e-08 $l=4.3e-08 $layer=Gate_1 $thickness=5.6e-08
+ $X=0.081 $Y=0.0675 $X2=0.081 $Y2=0.1105
r21 10 3 14.6259 $w=2.1e-08 $l=4.3e-08 $layer=Gate_1 $thickness=5.6e-08
+ $X=0.081 $Y=0.0675 $X2=0.081 $Y2=0.0245
.ends

* End of included file AOI32xp33_ASAP7_75t_R.pex.sp.pex

*
.subckt AOI32xp33_ASAP7_75t_CUSTOM_4_25_0_7 VSS VDD A1 A2 A3 B1 B2 Y
*
* VSS VSS
* VDD VDD
* A1 A1
* A2 A2
* A3 A3
* B1 B1
* B2 B2
* Y Y
*
*

M0 noxref_10 N_M0_g N_M0_s VSS nmos_rvt L=2e-08 W=8.1e-08 nfin=3 $X=0.071
+ $Y=0.027
M1 noxref_11 N_M1_g noxref_10 VSS nmos_rvt L=2e-08 W=8.1e-08 nfin=3 $X=0.125
+ $Y=0.027
M2 VSS N_M2_g noxref_11 VSS nmos_rvt L=2e-08 W=8.1e-08 nfin=3 $X=0.179 $Y=0.027
M3 noxref_12 N_M3_g VSS VSS nmos_rvt L=2e-08 W=5.4e-08 nfin=2 $X=0.233 $Y=0.027
M4 N_M4_d N_M4_g noxref_12 VSS nmos_rvt L=2e-08 W=5.4e-08 nfin=2 $X=0.287
+ $Y=0.027
M5 noxref_8 N_M5_g VDD VDD pmos_rvt L=2e-08 W=5.4e-08 nfin=2 $X=0.071 $Y=0.189
M6 VDD N_M6_g noxref_8 VDD pmos_rvt L=2e-08 W=5.4e-08 nfin=2 $X=0.125 $Y=0.189
M7 noxref_8 N_M7_g VDD VDD pmos_rvt L=2e-08 W=5.4e-08 nfin=2 $X=0.179 $Y=0.189
M8 N_M8_d N_M8_g noxref_8 VDD pmos_rvt L=2e-08 W=5.4e-08 nfin=2 $X=0.233
+ $Y=0.189
M9 noxref_8 N_M9_g N_M9_s VDD pmos_rvt L=2e-08 W=5.4e-08 nfin=2 $X=0.287
+ $Y=0.189

* .include "AOI32xp33_ASAP7_75t_R.pex.sp.pxi"

* Start of included file AOI32xp33_ASAP7_75t_R.pex.sp.pxi
x_PM_AOI32xp33_ASAP7_75t_R%A3 vss A3 N_M2_g N_M7_g N_A3_1 N_A3_5 N_A3_3
+ PM_AOI32xp33_ASAP7_75t_R%A3
cc_1 N_A3_1 N_A2_1 0.00153944f $X=0.189 $Y=0.135
cc_2 N_A3_5 N_A2_6 0.00423214f $X=0.189 $Y=0.1035
cc_3 N_A3_3 N_A2_3 0.00903686f $X=0.189 $Y=0.0245
x_PM_AOI32xp33_ASAP7_75t_R%B1 vss B1 N_M3_g N_M8_g N_B1_4 N_B1_3
+ PM_AOI32xp33_ASAP7_75t_R%B1
cc_4 N_B1_4 N_A3_5 0.00380816f $X=0.243 $Y=0.0945
cc_5 N_B1_3 N_A3_3 0.00738251f $X=0.243 $Y=0.0245
x_PM_AOI32xp33_ASAP7_75t_R%B2 vss B2 N_M4_g N_M9_g N_B2_4 N_B2_3
+ PM_AOI32xp33_ASAP7_75t_R%B2
cc_6 N_B2_4 N_B1_4 0.00336032f $X=0.297 $Y=0.098
cc_7 N_B2_3 N_B1_3 0.0108513f $X=0.297 $Y=0.0245
x_PM_AOI32xp33_ASAP7_75t_R%Y vss Y N_M0_s N_M4_d N_M8_d N_M9_s N_Y_1 N_Y_15
+ N_Y_10 N_Y_16 N_Y_12 N_Y_17 N_Y_11 N_Y_3 PM_AOI32xp33_ASAP7_75t_R%Y
cc_8 N_Y_1 N_A1_3 0.00291581f $X=0.054 $Y=0.0675
cc_9 N_Y_15 N_A1_4 0.00353542f $X=0.0425 $Y=0.036
cc_10 N_Y_10 N_A1_3 0.0385573f $X=0.056 $Y=0.0675
cc_11 N_Y_15 N_A2_4 0.00625384f $X=0.0425 $Y=0.036
cc_12 N_Y_15 N_A3_5 0.00409392f $X=0.0425 $Y=0.036
cc_13 N_Y_16 N_B1_4 0.000525359f $X=0.34 $Y=0.198
cc_14 N_Y_15 N_B1_4 0.00326579f $X=0.0425 $Y=0.036
cc_15 N_Y_12 N_B1_3 0.026788f $X=0.2555 $Y=0.216
cc_16 N_Y_17 N_B2_3 0.000739302f $X=0.351 $Y=0.054
cc_17 N_Y_11 N_B2_3 0.011726f $X=0.3095 $Y=0.054
cc_18 N_Y_3 N_B2_3 0.000913499f $X=0.324 $Y=0.054
cc_19 N_Y_16 N_B2_4 0.00103292f $X=0.34 $Y=0.198
cc_20 N_Y_15 N_B2_4 0.00111097f $X=0.0425 $Y=0.036
cc_21 N_Y_17 N_B2_4 0.00663394f $X=0.351 $Y=0.054
cc_22 N_Y_12 N_B2_3 0.0411862f $X=0.2555 $Y=0.216
x_PM_AOI32xp33_ASAP7_75t_R%A2 vss A2 N_M1_g N_M6_g N_A2_4 N_A2_6 N_A2_1 N_A2_3
+ PM_AOI32xp33_ASAP7_75t_R%A2
cc_23 N_A2_4 N_A1_3 0.000811187f $X=0.1302 $Y=0.072
cc_24 N_A2_6 N_A1_9 0.00166137f $X=0.135 $Y=0.135
cc_25 N_A2_1 N_A1_1 0.00172009f $X=0.135 $Y=0.135
cc_26 N_A2_3 N_A1_3 0.0090589f $X=0.135 $Y=0.0245
x_PM_AOI32xp33_ASAP7_75t_R%A1 vss A1 N_M0_g N_M5_g N_A1_3 N_A1_9 N_A1_1 N_A1_4
+ PM_AOI32xp33_ASAP7_75t_R%A1

* End of included file AOI32xp33_ASAP7_75t_R.pex.sp.pxi
.ends

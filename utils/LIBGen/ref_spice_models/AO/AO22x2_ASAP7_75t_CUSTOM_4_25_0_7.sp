.subckt PM_AO22x2_ASAP7_75t_R%A1 vss 23 10 16 3
c1 1 vss 0.00685803f $X=0.081 $Y=0.135
c2 3 vss 0.142567f $X=0.081 $Y=0.0245
c3 4 vss 0.00698438f $X=0.027 $Y=0.036
c4 5 vss 0.00108801f $X=0.027 $Y=0.135
c5 6 vss 0.00638322f $X=0.027 $Y=0.198
c6 7 vss 0.00613219f $X=0.027 $Y=0.1035
c7 8 vss 0.00331356f $X=0.027 $Y=0.1472
c8 9 vss 0.0031557f $X=0.0635 $Y=0.135
r1 6 24 5.29071 $w=1.46216e-08 $l=2.78e-08 $layer=M1 $thickness=3.6e-08
+ $X=0.027 $Y=0.198 $X2=0.027 $Y2=0.1702
r2 4 22 3.01711 $w=1.55e-08 $l=1.8e-08 $layer=M1 $thickness=3.6e-08 $X=0.027
+ $Y=0.036 $X2=0.027 $Y2=0.054
r3 23 24 4.4889 $w=1.3e-08 $l=1.92e-08 $layer=M1 $thickness=3.6e-08 $X=0.028
+ $Y=0.151 $X2=0.027 $Y2=0.1702
r4 23 8 0.874462 $w=1.3e-08 $l=3.8e-09 $layer=M1 $thickness=3.6e-08 $X=0.028
+ $Y=0.151 $X2=0.027 $Y2=0.1472
r5 21 22 4.19742 $w=1.3e-08 $l=1.8e-08 $layer=M1 $thickness=3.6e-08 $X=0.027
+ $Y=0.072 $X2=0.027 $Y2=0.054
r6 7 21 7.34548 $w=1.3e-08 $l=3.15e-08 $layer=M1 $thickness=3.6e-08 $X=0.027
+ $Y=0.1035 $X2=0.027 $Y2=0.072
r7 5 20 3.1337 $w=1.54324e-08 $l=1.85e-08 $layer=M1 $thickness=3.6e-08 $X=0.027
+ $Y=0.135 $X2=0.0455 $Y2=0.135
r8 5 7 6.16517 $w=1.44286e-08 $l=3.15e-08 $layer=M1 $thickness=3.6e-08 $X=0.027
+ $Y=0.135 $X2=0.027 $Y2=0.1035
r9 5 8 1.67627 $w=1.66735e-08 $l=1.22e-08 $layer=M1 $thickness=3.6e-08 $X=0.027
+ $Y=0.135 $X2=0.027 $Y2=0.1472
r10 9 18 4.08082 $w=1.3e-08 $l=1.75e-08 $layer=M1 $thickness=3.6e-08 $X=0.0635
+ $Y=0.135 $X2=0.081 $Y2=0.135
r11 9 20 4.19742 $w=1.3e-08 $l=1.8e-08 $layer=M1 $thickness=3.6e-08 $X=0.0635
+ $Y=0.135 $X2=0.0455 $Y2=0.135
r12 1 13 10.4265 $w=1.765e-08 $layer=LIG $thickness=5.2e-08 $X=0.081 $Y=0.135
+ $X2=0.081 $Y2=0.135
r13 1 18 19.3796 $a=3.24e-16 $layer=V0LIG $X=0.081 $Y=0.135 $X2=0.081 $Y2=0.135
r14 16 15 14.6259 $w=2.1e-08 $l=4.3e-08 $layer=Gate_1 $thickness=5.6e-08
+ $X=0.081 $Y=0.2025 $X2=0.081 $Y2=0.1595
r15 14 15 2.7211 $w=2.1e-08 $l=8e-09 $layer=Gate_1 $thickness=5.6e-08 $X=0.081
+ $Y=0.1515 $X2=0.081 $Y2=0.1595
r16 13 14 5.79936 $w=2.03333e-08 $l=1.65e-08 $layer=Gate_1 $thickness=5.6e-08
+ $X=0.081 $Y=0.135 $X2=0.081 $Y2=0.1515
r17 12 13 5.79936 $w=2.03333e-08 $l=1.65e-08 $layer=Gate_1 $thickness=5.6e-08
+ $X=0.081 $Y=0.1185 $X2=0.081 $Y2=0.135
r18 11 12 2.7211 $w=2.1e-08 $l=8e-09 $layer=Gate_1 $thickness=5.6e-08 $X=0.081
+ $Y=0.1105 $X2=0.081 $Y2=0.1185
r19 10 11 14.6259 $w=2.1e-08 $l=4.3e-08 $layer=Gate_1 $thickness=5.6e-08
+ $X=0.081 $Y=0.0675 $X2=0.081 $Y2=0.1105
r20 10 3 14.6259 $w=2.1e-08 $l=4.3e-08 $layer=Gate_1 $thickness=5.6e-08
+ $X=0.081 $Y=0.0675 $X2=0.081 $Y2=0.0245
.ends

.subckt PM_AO22x2_ASAP7_75t_R%B2 vss 11 5 9 3 4 1
c1 1 vss 0.00671558f $X=0.189 $Y=0.135
c2 3 vss 0.0648436f $X=0.189 $Y=0.0245
c3 4 vss 0.00427113f $X=0.189 $Y=0.0977
r1 12 13 3.32295 $w=1.3e-08 $l=1.43e-08 $layer=M1 $thickness=3.6e-08 $X=0.189
+ $Y=0.1207 $X2=0.189 $Y2=0.135
r2 11 12 1.34084 $w=1.3e-08 $l=5.7e-09 $layer=M1 $thickness=3.6e-08 $X=0.188
+ $Y=0.115 $X2=0.189 $Y2=0.1207
r3 11 4 4.02252 $w=1.3e-08 $l=1.73e-08 $layer=M1 $thickness=3.6e-08 $X=0.188
+ $Y=0.115 $X2=0.189 $Y2=0.0977
r4 1 7 10.4265 $w=1.765e-08 $layer=LIG $thickness=5.2e-08 $X=0.189 $Y=0.135
+ $X2=0.189 $Y2=0.135
r5 1 13 19.3796 $a=3.24e-16 $layer=V0LIG $X=0.189 $Y=0.135 $X2=0.189 $Y2=0.135
r6 9 8 16.4967 $w=2.1e-08 $l=4.85e-08 $layer=Gate_1 $thickness=5.6e-08 $X=0.189
+ $Y=0.2025 $X2=0.189 $Y2=0.154
r7 7 8 6.6497 $w=2.04211e-08 $l=1.9e-08 $layer=Gate_1 $thickness=5.6e-08
+ $X=0.189 $Y=0.135 $X2=0.189 $Y2=0.154
r8 6 7 6.6497 $w=2.04211e-08 $l=1.9e-08 $layer=Gate_1 $thickness=5.6e-08
+ $X=0.189 $Y=0.116 $X2=0.189 $Y2=0.135
r9 5 6 16.4967 $w=2.1e-08 $l=4.85e-08 $layer=Gate_1 $thickness=5.6e-08 $X=0.189
+ $Y=0.0675 $X2=0.189 $Y2=0.116
r10 5 3 14.6259 $w=2.1e-08 $l=4.3e-08 $layer=Gate_1 $thickness=5.6e-08 $X=0.189
+ $Y=0.0675 $X2=0.189 $Y2=0.0245
.ends

.subckt PM_AO22x2_ASAP7_75t_R%Y vss 22 16 17 31 32 7 2 8
c1 1 vss 0.00914475f $X=0.432 $Y=0.0675
c2 2 vss 0.00914475f $X=0.432 $Y=0.2025
c3 7 vss 0.00444061f $X=0.4175 $Y=0.0675
c4 8 vss 0.00444045f $X=0.4175 $Y=0.2025
c5 9 vss 0.00290106f $X=0.513 $Y=0.036
c6 10 vss 0.00289527f $X=0.513 $Y=0.234
c7 11 vss 0.00862078f $X=0.4185 $Y=0.036
c8 12 vss 0.00873725f $X=0.421 $Y=0.234
c9 13 vss 0.0084652f $X=0.513 $Y=0.0855
r1 32 30 0.0308642 $w=8.1e-08 $l=2.5e-09 $layer=P_src_drn $thickness=1e-09
+ $X=0.4493 $Y=0.2025 $X2=0.4465 $Y2=0.2025
r2 2 30 0.179012 $w=8.1e-08 $l=1.45e-08 $layer=P_src_drn $thickness=1e-09
+ $X=0.432 $Y=0.2025 $X2=0.4465 $Y2=0.2025
r3 8 2 0.179012 $w=8.1e-08 $l=1.45e-08 $layer=P_src_drn $thickness=1e-09
+ $X=0.4175 $Y=0.2025 $X2=0.432 $Y2=0.2025
r4 31 8 0.0308642 $w=8.1e-08 $l=2.5e-09 $layer=P_src_drn $thickness=1e-09
+ $X=0.4146 $Y=0.2025 $X2=0.4175 $Y2=0.2025
r5 2 26 19.3796 $a=3.24e-16 $layer=V0LISD $X=0.432 $Y=0.2025 $X2=0.432 $Y2=0.234
r6 26 27 9.44419 $w=1.3e-08 $l=4.05e-08 $layer=M1 $thickness=3.6e-08 $X=0.432
+ $Y=0.234 $X2=0.4725 $Y2=0.234
r7 12 26 2.56509 $w=1.3e-08 $l=1.1e-08 $layer=M1 $thickness=3.6e-08 $X=0.421
+ $Y=0.234 $X2=0.432 $Y2=0.234
r8 10 25 2.5483 $w=1.79e-08 $l=1.8e-08 $layer=M1 $thickness=3.6e-08 $X=0.513
+ $Y=0.234 $X2=0.513 $Y2=0.216
r9 10 27 7.79507 $w=1.41111e-08 $l=4.05e-08 $layer=M1 $thickness=3.6e-08
+ $X=0.513 $Y=0.234 $X2=0.4725 $Y2=0.234
r10 24 25 9.44419 $w=1.3e-08 $l=4.05e-08 $layer=M1 $thickness=3.6e-08 $X=0.513
+ $Y=0.1755 $X2=0.513 $Y2=0.216
r11 23 24 7.98675 $w=1.3e-08 $l=3.43e-08 $layer=M1 $thickness=3.6e-08 $X=0.513
+ $Y=0.1412 $X2=0.513 $Y2=0.1755
r12 22 23 0.757867 $w=1.3e-08 $l=3.2e-09 $layer=M1 $thickness=3.6e-08 $X=0.513
+ $Y=0.138 $X2=0.513 $Y2=0.1412
r13 22 21 1.45744 $w=1.3e-08 $l=6.3e-09 $layer=M1 $thickness=3.6e-08 $X=0.513
+ $Y=0.138 $X2=0.513 $Y2=0.1317
r14 13 21 10.785 $w=1.3e-08 $l=4.62e-08 $layer=M1 $thickness=3.6e-08 $X=0.513
+ $Y=0.0855 $X2=0.513 $Y2=0.1317
r15 9 20 7.79507 $w=1.41111e-08 $l=4.05e-08 $layer=M1 $thickness=3.6e-08
+ $X=0.513 $Y=0.036 $X2=0.4725 $Y2=0.036
r16 9 13 9.89378 $w=1.47818e-08 $l=4.95e-08 $layer=M1 $thickness=3.6e-08
+ $X=0.513 $Y=0.036 $X2=0.513 $Y2=0.0855
r17 19 20 9.44419 $w=1.3e-08 $l=4.05e-08 $layer=M1 $thickness=3.6e-08 $X=0.432
+ $Y=0.036 $X2=0.4725 $Y2=0.036
r18 18 19 2.56509 $w=1.3e-08 $l=1.1e-08 $layer=M1 $thickness=3.6e-08 $X=0.421
+ $Y=0.036 $X2=0.432 $Y2=0.036
r19 11 18 0.582974 $w=1.3e-08 $l=2.5e-09 $layer=M1 $thickness=3.6e-08 $X=0.4185
+ $Y=0.036 $X2=0.421 $Y2=0.036
r20 1 19 19.3796 $a=3.24e-16 $layer=V0LISD $X=0.432 $Y=0.0675 $X2=0.432
+ $Y2=0.036
r21 17 15 0.0308642 $w=8.1e-08 $l=2.5e-09 $layer=N_src_drn $thickness=1e-09
+ $X=0.4493 $Y=0.0675 $X2=0.4465 $Y2=0.0675
r22 1 15 0.179012 $w=8.1e-08 $l=1.45e-08 $layer=N_src_drn $thickness=1e-09
+ $X=0.432 $Y=0.0675 $X2=0.4465 $Y2=0.0675
r23 7 1 0.179012 $w=8.1e-08 $l=1.45e-08 $layer=N_src_drn $thickness=1e-09
+ $X=0.4175 $Y=0.0675 $X2=0.432 $Y2=0.0675
r24 16 7 0.0308642 $w=8.1e-08 $l=2.5e-09 $layer=N_src_drn $thickness=1e-09
+ $X=0.4146 $Y=0.0675 $X2=0.4175 $Y2=0.0675
.ends

.subckt PM_AO22x2_ASAP7_75t_R%7 vss 21 27 40 44 65 66 69 70 3 16 11 17 4 12 18
+ 1 9 20 10
c1 1 vss 0.00834356f $X=0.3955 $Y=0.135
c2 3 vss 0.00597367f $X=0.162 $Y=0.0675
c3 4 vss 0.00982168f $X=0.216 $Y=0.2025
c4 9 vss 0.0843911f $X=0.405 $Y=0.0245
c5 10 vss 0.0842854f $X=0.459 $Y=0.135
c6 11 vss 0.00557003f $X=0.1475 $Y=0.0675
c7 12 vss 0.00690295f $X=0.2015 $Y=0.2025
c8 13 vss 0.00330379f $X=0.351 $Y=0.036
c9 14 vss 0.000496659f $X=0.351 $Y=0.135
c10 15 vss 0.00224683f $X=0.351 $Y=0.198
c11 16 vss 0.0251515f $X=0.3145 $Y=0.036
c12 17 vss 0.0131748f $X=0.3145 $Y=0.198
c13 18 vss 0.00466792f $X=0.351 $Y=0.1035
c14 19 vss 0.00232919f $X=0.351 $Y=0.154
c15 20 vss 0.00261f $X=0.378 $Y=0.135
r1 70 68 0.0308642 $w=8.1e-08 $l=2.5e-09 $layer=P_src_drn $thickness=1e-09
+ $X=0.2333 $Y=0.2025 $X2=0.2305 $Y2=0.2025
r2 4 68 0.179012 $w=8.1e-08 $l=1.45e-08 $layer=P_src_drn $thickness=1e-09
+ $X=0.216 $Y=0.2025 $X2=0.2305 $Y2=0.2025
r3 12 4 0.179012 $w=8.1e-08 $l=1.45e-08 $layer=P_src_drn $thickness=1e-09
+ $X=0.2015 $Y=0.2025 $X2=0.216 $Y2=0.2025
r4 69 12 0.0308642 $w=8.1e-08 $l=2.5e-09 $layer=P_src_drn $thickness=1e-09
+ $X=0.1986 $Y=0.2025 $X2=0.2015 $Y2=0.2025
r5 66 64 0.0308642 $w=8.1e-08 $l=2.5e-09 $layer=N_src_drn $thickness=1e-09
+ $X=0.1793 $Y=0.0675 $X2=0.1765 $Y2=0.0675
r6 3 64 0.179012 $w=8.1e-08 $l=1.45e-08 $layer=N_src_drn $thickness=1e-09
+ $X=0.162 $Y=0.0675 $X2=0.1765 $Y2=0.0675
r7 11 3 0.179012 $w=8.1e-08 $l=1.45e-08 $layer=N_src_drn $thickness=1e-09
+ $X=0.1475 $Y=0.0675 $X2=0.162 $Y2=0.0675
r8 65 11 0.0308642 $w=8.1e-08 $l=2.5e-09 $layer=N_src_drn $thickness=1e-09
+ $X=0.1446 $Y=0.0675 $X2=0.1475 $Y2=0.0675
r9 4 61 19.3796 $a=3.24e-16 $layer=V0LISD $X=0.216 $Y=0.2025 $X2=0.216 $Y2=0.198
r10 3 54 19.3796 $a=3.24e-16 $layer=V0LISD $X=0.162 $Y=0.0675 $X2=0.162
+ $Y2=0.036
r11 61 62 3.14806 $w=1.3e-08 $l=1.35e-08 $layer=M1 $thickness=3.6e-08 $X=0.216
+ $Y=0.198 $X2=0.2295 $Y2=0.198
r12 59 62 3.14806 $w=1.3e-08 $l=1.35e-08 $layer=M1 $thickness=3.6e-08 $X=0.243
+ $Y=0.198 $X2=0.2295 $Y2=0.198
r13 58 59 5.82974 $w=1.3e-08 $l=2.5e-08 $layer=M1 $thickness=3.6e-08 $X=0.268
+ $Y=0.198 $X2=0.243 $Y2=0.198
r14 57 58 4.08082 $w=1.3e-08 $l=1.75e-08 $layer=M1 $thickness=3.6e-08 $X=0.2855
+ $Y=0.198 $X2=0.268 $Y2=0.198
r15 17 57 6.7625 $w=1.3e-08 $l=2.9e-08 $layer=M1 $thickness=3.6e-08 $X=0.3145
+ $Y=0.198 $X2=0.2855 $Y2=0.198
r16 54 55 3.14806 $w=1.3e-08 $l=1.35e-08 $layer=M1 $thickness=3.6e-08 $X=0.162
+ $Y=0.036 $X2=0.1755 $Y2=0.036
r17 52 55 3.14806 $w=1.3e-08 $l=1.35e-08 $layer=M1 $thickness=3.6e-08 $X=0.189
+ $Y=0.036 $X2=0.1755 $Y2=0.036
r18 51 52 2.56509 $w=1.3e-08 $l=1.1e-08 $layer=M1 $thickness=3.6e-08 $X=0.2
+ $Y=0.036 $X2=0.189 $Y2=0.036
r19 50 51 4.19742 $w=1.3e-08 $l=1.8e-08 $layer=M1 $thickness=3.6e-08 $X=0.218
+ $Y=0.036 $X2=0.2 $Y2=0.036
r20 49 50 9.91056 $w=1.3e-08 $l=4.25e-08 $layer=M1 $thickness=3.6e-08 $X=0.2605
+ $Y=0.036 $X2=0.218 $Y2=0.036
r21 16 49 12.5922 $w=1.3e-08 $l=5.4e-08 $layer=M1 $thickness=3.6e-08 $X=0.3145
+ $Y=0.036 $X2=0.2605 $Y2=0.036
r22 15 48 3.36447 $w=1.71023e-08 $l=2.15e-08 $layer=M1 $thickness=3.6e-08
+ $X=0.351 $Y=0.198 $X2=0.351 $Y2=0.1765
r23 15 17 6.86231 $w=1.42329e-08 $l=3.65e-08 $layer=M1 $thickness=3.6e-08
+ $X=0.351 $Y=0.198 $X2=0.3145 $Y2=0.198
r24 13 47 2.5483 $w=1.79e-08 $l=1.8e-08 $layer=M1 $thickness=3.6e-08 $X=0.351
+ $Y=0.036 $X2=0.351 $Y2=0.054
r25 13 16 6.86231 $w=1.42329e-08 $l=3.65e-08 $layer=M1 $thickness=3.6e-08
+ $X=0.351 $Y=0.036 $X2=0.3145 $Y2=0.036
r26 19 48 5.24677 $w=1.3e-08 $l=2.25e-08 $layer=M1 $thickness=3.6e-08 $X=0.351
+ $Y=0.154 $X2=0.351 $Y2=0.1765
r27 46 47 4.19742 $w=1.3e-08 $l=1.8e-08 $layer=M1 $thickness=3.6e-08 $X=0.351
+ $Y=0.072 $X2=0.351 $Y2=0.054
r28 18 46 7.34548 $w=1.3e-08 $l=3.15e-08 $layer=M1 $thickness=3.6e-08 $X=0.351
+ $Y=0.1035 $X2=0.351 $Y2=0.072
r29 14 20 5.11582 $w=1.46667e-08 $l=2.7e-08 $layer=M1 $thickness=3.6e-08
+ $X=0.351 $Y=0.135 $X2=0.378 $Y2=0.135
r30 14 18 6.16517 $w=1.44286e-08 $l=3.15e-08 $layer=M1 $thickness=3.6e-08
+ $X=0.351 $Y=0.135 $X2=0.351 $Y2=0.1035
r31 14 19 3.2503 $w=1.53684e-08 $l=1.9e-08 $layer=M1 $thickness=3.6e-08
+ $X=0.351 $Y=0.135 $X2=0.351 $Y2=0.154
r32 44 43 14.6259 $w=2.1e-08 $l=4.3e-08 $layer=Gate_1 $thickness=5.6e-08
+ $X=0.459 $Y=0.2025 $X2=0.459 $Y2=0.1595
r33 42 43 2.7211 $w=2.1e-08 $l=8e-09 $layer=Gate_1 $thickness=5.6e-08 $X=0.459
+ $Y=0.1515 $X2=0.459 $Y2=0.1595
r34 40 41 14.6259 $w=2.1e-08 $l=4.3e-08 $layer=Gate_1 $thickness=5.6e-08
+ $X=0.459 $Y=0.0675 $X2=0.459 $Y2=0.1105
r35 38 41 2.7211 $w=2.1e-08 $l=8e-09 $layer=Gate_1 $thickness=5.6e-08 $X=0.459
+ $Y=0.1185 $X2=0.459 $Y2=0.1105
r36 10 33 6.54019 $w=2.09524e-08 $layer=Gate_1 $thickness=5.21905e-08 $X=0.459
+ $Y=0.135 $X2=0.459 $Y2=0.135
r37 10 38 5.79936 $w=2.03333e-08 $l=1.65e-08 $layer=Gate_1 $thickness=5.6e-08
+ $X=0.459 $Y=0.135 $X2=0.459 $Y2=0.1185
r38 10 42 5.79936 $w=2.03333e-08 $l=1.65e-08 $layer=Gate_1 $thickness=5.6e-08
+ $X=0.459 $Y=0.135 $X2=0.459 $Y2=0.1515
r39 20 35 6.29612 $w=1.3e-08 $l=2.7e-08 $layer=M1 $thickness=3.6e-08 $X=0.378
+ $Y=0.135 $X2=0.405 $Y2=0.135
r40 32 33 12.6539 $w=1.77815e-08 $l=2.7e-08 $layer=LIG $thickness=4.8e-08
+ $X=0.432 $Y=0.135 $X2=0.459 $Y2=0.135
r41 30 32 10.1729 $w=1.54914e-08 $l=1.75e-08 $layer=LIG $thickness=4.8e-08
+ $X=0.4145 $Y=0.135 $X2=0.432 $Y2=0.135
r42 29 30 2.48102 $w=2.2e-08 $l=9.5e-09 $layer=LIG $thickness=4.8e-08 $X=0.405
+ $Y=0.135 $X2=0.4145 $Y2=0.135
r43 29 35 19.3796 $a=3.24e-16 $layer=V0LIG $X=0.405 $Y=0.135 $X2=0.405 $Y2=0.135
r44 1 29 2.48102 $w=2.2e-08 $l=9.5e-09 $layer=LIG $thickness=4.8e-08 $X=0.3955
+ $Y=0.135 $X2=0.405 $Y2=0.135
r45 27 26 14.6259 $w=2.1e-08 $l=4.3e-08 $layer=Gate_1 $thickness=5.6e-08
+ $X=0.405 $Y=0.2025 $X2=0.405 $Y2=0.1595
r46 25 26 2.7211 $w=2.1e-08 $l=8e-09 $layer=Gate_1 $thickness=5.6e-08 $X=0.405
+ $Y=0.1515 $X2=0.405 $Y2=0.1595
r47 24 25 5.79936 $w=2.03333e-08 $l=1.65e-08 $layer=Gate_1 $thickness=5.6e-08
+ $X=0.405 $Y=0.135 $X2=0.405 $Y2=0.1515
r48 24 30 4.05918 $w=2.0087e-08 $l=9.5e-09 $layer=Gate_1 $thickness=5.56522e-08
+ $X=0.405 $Y=0.135 $X2=0.4145 $Y2=0.135
r49 24 29 6.27904 $w=2.09e-08 $layer=Gate_1 $thickness=5.24e-08 $X=0.405
+ $Y=0.135 $X2=0.405 $Y2=0.135
r50 23 24 5.79936 $w=2.03333e-08 $l=1.65e-08 $layer=Gate_1 $thickness=5.6e-08
+ $X=0.405 $Y=0.1185 $X2=0.405 $Y2=0.135
r51 22 23 2.7211 $w=2.1e-08 $l=8e-09 $layer=Gate_1 $thickness=5.6e-08 $X=0.405
+ $Y=0.1105 $X2=0.405 $Y2=0.1185
r52 21 22 14.6259 $w=2.1e-08 $l=4.3e-08 $layer=Gate_1 $thickness=5.6e-08
+ $X=0.405 $Y=0.0675 $X2=0.405 $Y2=0.1105
r53 21 9 14.6259 $w=2.1e-08 $l=4.3e-08 $layer=Gate_1 $thickness=5.6e-08
+ $X=0.405 $Y=0.0675 $X2=0.405 $Y2=0.0245
.ends

.subckt PM_AO22x2_ASAP7_75t_R%A2 vss 16 7 11 1 6 3 4
c1 1 vss 0.00593756f $X=0.135 $Y=0.135
c2 3 vss 0.101639f $X=0.135 $Y=0.0245
c3 4 vss 0.00255622f $X=0.135 $Y=0.072
c4 5 vss 0.00737768f $X=0.135 $Y=0.198
c5 6 vss 0.00388605f $X=0.135 $Y=0.135
r1 5 17 1.20989 $w=1.73902e-08 $l=1.03e-08 $layer=M1 $thickness=3.6e-08
+ $X=0.135 $Y=0.198 $X2=0.135 $Y2=0.1877
r2 4 13 6.16517 $w=1.44286e-08 $l=3.15e-08 $layer=M1 $thickness=3.6e-08
+ $X=0.135 $Y=0.072 $X2=0.135 $Y2=0.1035
r3 16 17 0.408082 $w=1.3e-08 $l=1.7e-09 $layer=M1 $thickness=3.6e-08 $X=0.134
+ $Y=0.186 $X2=0.135 $Y2=0.1877
r4 16 15 2.62338 $w=1.3e-08 $l=1.13e-08 $layer=M1 $thickness=3.6e-08 $X=0.134
+ $Y=0.186 $X2=0.135 $Y2=0.1747
r5 14 15 4.83869 $w=1.3e-08 $l=2.07e-08 $layer=M1 $thickness=3.6e-08 $X=0.135
+ $Y=0.154 $X2=0.135 $Y2=0.1747
r6 6 13 7.34548 $w=1.3e-08 $l=3.15e-08 $layer=M1 $thickness=3.6e-08 $X=0.135
+ $Y=0.135 $X2=0.135 $Y2=0.1035
r7 6 14 4.43061 $w=1.3e-08 $l=1.9e-08 $layer=M1 $thickness=3.6e-08 $X=0.135
+ $Y=0.135 $X2=0.135 $Y2=0.154
r8 1 9 10.4265 $w=1.765e-08 $layer=LIG $thickness=5.2e-08 $X=0.135 $Y=0.135
+ $X2=0.135 $Y2=0.135
r9 1 6 19.3796 $a=3.24e-16 $layer=V0LIG $X=0.135 $Y=0.135 $X2=0.135 $Y2=0.135
r10 11 10 16.4967 $w=2.1e-08 $l=4.85e-08 $layer=Gate_1 $thickness=5.6e-08
+ $X=0.135 $Y=0.2025 $X2=0.135 $Y2=0.154
r11 9 10 6.6497 $w=2.04211e-08 $l=1.9e-08 $layer=Gate_1 $thickness=5.6e-08
+ $X=0.135 $Y=0.135 $X2=0.135 $Y2=0.154
r12 8 9 6.6497 $w=2.04211e-08 $l=1.9e-08 $layer=Gate_1 $thickness=5.6e-08
+ $X=0.135 $Y=0.116 $X2=0.135 $Y2=0.135
r13 7 8 16.4967 $w=2.1e-08 $l=4.85e-08 $layer=Gate_1 $thickness=5.6e-08
+ $X=0.135 $Y=0.0675 $X2=0.135 $Y2=0.116
r14 7 3 14.6259 $w=2.1e-08 $l=4.3e-08 $layer=Gate_1 $thickness=5.6e-08 $X=0.135
+ $Y=0.0675 $X2=0.135 $Y2=0.0245
.ends

.subckt PM_AO22x2_ASAP7_75t_R%B1 vss 5 6 12 3 4
c1 1 vss 0.00503244f $X=0.243 $Y=0.135
c2 3 vss 0.106714f $X=0.243 $Y=0.0245
c3 4 vss 0.00341262f $X=0.2605 $Y=0.0752
c4 5 vss 0.00372594f $X=0.243 $Y=0.081
r1 4 17 0.126622 $w=4.8e-08 $l=5.5e-09 $layer=M1 $thickness=3.6e-08 $X=0.2605
+ $Y=0.0752 $X2=0.2605 $Y2=0.0807
r2 14 15 7.28718 $w=1.3e-08 $l=3.13e-08 $layer=M1 $thickness=3.6e-08 $X=0.243
+ $Y=0.1037 $X2=0.243 $Y2=0.135
r3 5 14 5.24677 $w=1.3e-08 $l=2.25e-08 $layer=M1 $thickness=3.6e-08 $X=0.243
+ $Y=0.081 $X2=0.243 $Y2=0.1037
r4 5 17 0.064053 $w=3.05e-08 $l=1.75071e-08 $layer=M1 $thickness=3.6e-08
+ $X=0.243 $Y=0.081 $X2=0.2605 $Y2=0.0807
r5 1 9 10.4265 $w=1.765e-08 $layer=LIG $thickness=5.2e-08 $X=0.243 $Y=0.135
+ $X2=0.243 $Y2=0.135
r6 1 15 19.3796 $a=3.24e-16 $layer=V0LIG $X=0.243 $Y=0.135 $X2=0.243 $Y2=0.135
r7 12 11 14.6259 $w=2.1e-08 $l=4.3e-08 $layer=Gate_1 $thickness=5.6e-08
+ $X=0.243 $Y=0.2025 $X2=0.243 $Y2=0.1595
r8 10 11 2.7211 $w=2.1e-08 $l=8e-09 $layer=Gate_1 $thickness=5.6e-08 $X=0.243
+ $Y=0.1515 $X2=0.243 $Y2=0.1595
r9 9 10 5.79936 $w=2.03333e-08 $l=1.65e-08 $layer=Gate_1 $thickness=5.6e-08
+ $X=0.243 $Y=0.135 $X2=0.243 $Y2=0.1515
r10 8 9 5.79936 $w=2.03333e-08 $l=1.65e-08 $layer=Gate_1 $thickness=5.6e-08
+ $X=0.243 $Y=0.1185 $X2=0.243 $Y2=0.135
r11 7 8 2.7211 $w=2.1e-08 $l=8e-09 $layer=Gate_1 $thickness=5.6e-08 $X=0.243
+ $Y=0.1105 $X2=0.243 $Y2=0.1185
r12 6 7 14.6259 $w=2.1e-08 $l=4.3e-08 $layer=Gate_1 $thickness=5.6e-08 $X=0.243
+ $Y=0.0675 $X2=0.243 $Y2=0.1105
r13 6 3 14.6259 $w=2.1e-08 $l=4.3e-08 $layer=Gate_1 $thickness=5.6e-08 $X=0.243
+ $Y=0.0675 $X2=0.243 $Y2=0.0245
.ends

* End of included file AO22x2_ASAP7_75t_R.pex.sp.pex

*
.subckt AO22x2_ASAP7_75t_CUSTOM_4_25_0_7 VSS VDD A1 A2 B2 B1 Y
*
* VSS VSS
* VDD VDD
* A1 A1
* A2 A2
* B2 B2
* B1 B1
* Y Y
*
*

M0 noxref_10 N_M0_g VSS VSS nmos_rvt L=2e-08 W=8.1e-08 nfin=3 $X=0.071 $Y=0.027
M1 N_M1_d N_M1_g noxref_10 VSS nmos_rvt L=2e-08 W=8.1e-08 nfin=3 $X=0.125
+ $Y=0.027
M2 noxref_11 N_M2_g N_M2_s VSS nmos_rvt L=2e-08 W=8.1e-08 nfin=3 $X=0.179
+ $Y=0.027
M3 VSS N_M3_g noxref_11 VSS nmos_rvt L=2e-08 W=8.1e-08 nfin=3 $X=0.233 $Y=0.027
M4 N_M4_d N_M4_g VSS VSS nmos_rvt L=2e-08 W=8.1e-08 nfin=3 $X=0.395 $Y=0.027
M5 N_M5_d N_M5_g VSS VSS nmos_rvt L=2e-08 W=8.1e-08 nfin=3 $X=0.449 $Y=0.027
M6 VDD N_M6_g noxref_8 VDD pmos_rvt L=2e-08 W=8.1e-08 nfin=3 $X=0.071 $Y=0.162
M7 noxref_8 N_M7_g VDD VDD pmos_rvt L=2e-08 W=8.1e-08 nfin=3 $X=0.125 $Y=0.162
M8 N_M8_d N_M8_g noxref_8 VDD pmos_rvt L=2e-08 W=8.1e-08 nfin=3 $X=0.179
+ $Y=0.162
M9 noxref_8 N_M9_g N_M9_s VDD pmos_rvt L=2e-08 W=8.1e-08 nfin=3 $X=0.233
+ $Y=0.162
M10 N_M10_d N_M10_g VDD VDD pmos_rvt L=2e-08 W=8.1e-08 nfin=3 $X=0.395 $Y=0.162
M11 N_M11_d N_M11_g VDD VDD pmos_rvt L=2e-08 W=8.1e-08 nfin=3 $X=0.449 $Y=0.162

* .include "AO22x2_ASAP7_75t_R.pex.sp.pxi"

* Start of included file AO22x2_ASAP7_75t_R.pex.sp.pxi
x_PM_AO22x2_ASAP7_75t_R%A1 vss A1 N_M0_g N_M6_g N_A1_3 PM_AO22x2_ASAP7_75t_R%A1
x_PM_AO22x2_ASAP7_75t_R%B2 vss B2 N_M2_g N_M8_g N_B2_3 N_B2_4 N_B2_1
+ PM_AO22x2_ASAP7_75t_R%B2
cc_1 N_B2_3 N_A2_3 0.00317071f $X=0.189 $Y=0.0245
cc_2 N_B2_4 N_A2_6 0.00576733f $X=0.189 $Y=0.0977
x_PM_AO22x2_ASAP7_75t_R%Y vss Y N_M4_d N_M5_d N_M10_d N_M11_d N_Y_7 N_Y_2 N_Y_8
+ PM_AO22x2_ASAP7_75t_R%Y
cc_3 N_Y_7 N_7_17 0.000337762f $X=0.4175 $Y=0.0675
cc_4 N_Y_7 N_7_18 0.000447978f $X=0.4175 $Y=0.0675
cc_5 N_Y_7 N_7_1 0.00168175f $X=0.4175 $Y=0.0675
cc_6 N_Y_7 N_7_9 0.030421f $X=0.4175 $Y=0.0675
cc_7 N_Y_7 N_7_20 0.000983154f $X=0.4175 $Y=0.0675
cc_8 N_Y_2 N_7_10 0.00188666f $X=0.432 $Y=0.2025
cc_9 N_Y_8 N_7_1 0.0050534f $X=0.4175 $Y=0.2025
cc_10 N_Y_8 N_7_10 0.0103169f $X=0.4175 $Y=0.2025
cc_11 N_Y_8 N_7_9 0.0550801f $X=0.4175 $Y=0.2025
cc_12 N_Y_7 N_7_10 0.0409947f $X=0.4175 $Y=0.0675
x_PM_AO22x2_ASAP7_75t_R%7 vss N_M4_g N_M10_g N_M5_g N_M11_g N_M1_d N_M2_s
+ N_M8_d N_M9_s N_7_3 N_7_16 N_7_11 N_7_17 N_7_4 N_7_12 N_7_18 N_7_1 N_7_9
+ N_7_20 N_7_10 PM_AO22x2_ASAP7_75t_R%7
cc_13 N_7_3 N_A2_6 0.000821092f $X=0.162 $Y=0.0675
cc_14 N_7_3 N_A2_3 0.00151216f $X=0.162 $Y=0.0675
cc_15 N_7_16 N_A2_4 0.00387259f $X=0.3145 $Y=0.036
cc_16 N_7_11 N_A2_3 0.0366084f $X=0.1475 $Y=0.0675
cc_17 N_7_11 N_B2_3 0.0152422f $X=0.1475 $Y=0.0675
cc_18 N_7_3 N_B2_3 0.00194388f $X=0.162 $Y=0.0675
cc_19 N_7_17 N_B2_3 0.000534845f $X=0.3145 $Y=0.198
cc_20 N_7_4 N_B2_3 0.000804448f $X=0.216 $Y=0.2025
cc_21 N_7_16 N_B2_4 0.00112356f $X=0.3145 $Y=0.036
cc_22 N_7_12 N_B2_1 0.00146026f $X=0.2015 $Y=0.2025
cc_23 N_7_3 N_B2_4 0.00253133f $X=0.162 $Y=0.0675
cc_24 N_7_12 N_B2_3 0.0543261f $X=0.2015 $Y=0.2025
cc_25 N_7_4 N_B1_3 0.00137743f $X=0.216 $Y=0.2025
cc_26 N_7_17 B1 0.0033838f $X=0.3145 $Y=0.198
cc_27 N_7_16 N_B1_4 0.00607551f $X=0.3145 $Y=0.036
cc_28 N_7_12 N_B1_3 0.0366616f $X=0.2015 $Y=0.2025
x_PM_AO22x2_ASAP7_75t_R%A2 vss A2 N_M1_g N_M7_g N_A2_1 N_A2_6 N_A2_3 N_A2_4
+ PM_AO22x2_ASAP7_75t_R%A2
cc_29 N_A2_1 N_A1_3 0.00127984f $X=0.135 $Y=0.135
cc_30 N_A2_6 N_A1_3 0.00236436f $X=0.135 $Y=0.135
cc_31 N_A2_3 N_A1_3 0.00780903f $X=0.135 $Y=0.0245
x_PM_AO22x2_ASAP7_75t_R%B1 vss B1 N_M3_g N_M9_g N_B1_3 N_B1_4
+ PM_AO22x2_ASAP7_75t_R%B1
cc_32 B1 N_B2_4 0.00311166f $X=0.243 $Y=0.081
cc_33 N_B1_3 N_B2_3 0.00727588f $X=0.243 $Y=0.0245

* End of included file AO22x2_ASAP7_75t_R.pex.sp.pxi
.ends

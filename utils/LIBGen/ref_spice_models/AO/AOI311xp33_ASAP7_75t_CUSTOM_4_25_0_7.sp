.subckt PM_AOI311xp33_ASAP7_75t_R%A2 vss 4 5 9 3
c1 1 vss 0.0045129f $X=0.135 $Y=0.135
c2 3 vss 0.119281f $X=0.135 $Y=0.0245
c3 4 vss 0.0112712f $X=0.134 $Y=0.136
r1 1 7 10.4265 $w=1.765e-08 $layer=LIG $thickness=5.2e-08 $X=0.135 $Y=0.135
+ $X2=0.135 $Y2=0.135
r2 4 1 19.3796 $a=3.24e-16 $layer=V0LIG $X=0.134 $Y=0.136 $X2=0.135 $Y2=0.135
r3 9 8 16.4967 $w=2.1e-08 $l=4.85e-08 $layer=Gate_1 $thickness=5.6e-08 $X=0.135
+ $Y=0.2025 $X2=0.135 $Y2=0.154
r4 7 8 6.6497 $w=2.04211e-08 $l=1.9e-08 $layer=Gate_1 $thickness=5.6e-08
+ $X=0.135 $Y=0.135 $X2=0.135 $Y2=0.154
r5 6 7 6.6497 $w=2.04211e-08 $l=1.9e-08 $layer=Gate_1 $thickness=5.6e-08
+ $X=0.135 $Y=0.116 $X2=0.135 $Y2=0.135
r6 5 6 16.4967 $w=2.1e-08 $l=4.85e-08 $layer=Gate_1 $thickness=5.6e-08 $X=0.135
+ $Y=0.0675 $X2=0.135 $Y2=0.116
r7 5 3 14.6259 $w=2.1e-08 $l=4.3e-08 $layer=Gate_1 $thickness=5.6e-08 $X=0.135
+ $Y=0.0675 $X2=0.135 $Y2=0.0245
.ends

.subckt PM_AOI311xp33_ASAP7_75t_R%A1 vss 11 5 9 4 3
c1 1 vss 0.00540337f $X=0.189 $Y=0.135
c2 3 vss 0.0828071f $X=0.189 $Y=0.0245
c3 4 vss 0.0181516f $X=0.189 $Y=0.098
r1 11 4 8.62802 $w=1.3e-08 $l=3.7e-08 $layer=M1 $thickness=3.6e-08 $X=0.196
+ $Y=0.136 $X2=0.189 $Y2=0.098
r2 1 7 10.4265 $w=1.765e-08 $layer=LIG $thickness=5.2e-08 $X=0.189 $Y=0.135
+ $X2=0.189 $Y2=0.135
r3 11 1 19.3796 $a=3.24e-16 $layer=V0LIG $X=0.196 $Y=0.136 $X2=0.189 $Y2=0.135
r4 9 8 16.4967 $w=2.1e-08 $l=4.85e-08 $layer=Gate_1 $thickness=5.6e-08 $X=0.189
+ $Y=0.2025 $X2=0.189 $Y2=0.154
r5 7 8 6.6497 $w=2.04211e-08 $l=1.9e-08 $layer=Gate_1 $thickness=5.6e-08
+ $X=0.189 $Y=0.135 $X2=0.189 $Y2=0.154
r6 6 7 6.6497 $w=2.04211e-08 $l=1.9e-08 $layer=Gate_1 $thickness=5.6e-08
+ $X=0.189 $Y=0.116 $X2=0.189 $Y2=0.135
r7 5 6 16.4967 $w=2.1e-08 $l=4.85e-08 $layer=Gate_1 $thickness=5.6e-08 $X=0.189
+ $Y=0.0675 $X2=0.189 $Y2=0.116
r8 5 3 14.6259 $w=2.1e-08 $l=4.3e-08 $layer=Gate_1 $thickness=5.6e-08 $X=0.189
+ $Y=0.0675 $X2=0.189 $Y2=0.0245
.ends

.subckt PM_AOI311xp33_ASAP7_75t_R%B vss 11 5 9 3 4
c1 1 vss 0.00641845f $X=0.243 $Y=0.135
c2 3 vss 0.0943882f $X=0.243 $Y=0.0245
c3 4 vss 0.00660403f $X=0.243 $Y=0.098
r1 11 4 8.62802 $w=1.3e-08 $l=3.7e-08 $layer=M1 $thickness=3.6e-08 $X=0.247
+ $Y=0.134 $X2=0.243 $Y2=0.098
r2 1 7 10.4265 $w=1.765e-08 $layer=LIG $thickness=5.2e-08 $X=0.243 $Y=0.135
+ $X2=0.243 $Y2=0.135
r3 11 1 19.3796 $a=3.24e-16 $layer=V0LIG $X=0.247 $Y=0.134 $X2=0.243 $Y2=0.135
r4 9 8 16.4967 $w=2.1e-08 $l=4.85e-08 $layer=Gate_1 $thickness=5.6e-08 $X=0.243
+ $Y=0.2025 $X2=0.243 $Y2=0.154
r5 7 8 6.6497 $w=2.04211e-08 $l=1.9e-08 $layer=Gate_1 $thickness=5.6e-08
+ $X=0.243 $Y=0.135 $X2=0.243 $Y2=0.154
r6 6 7 11.2416 $w=2.06615e-08 $l=3.25e-08 $layer=Gate_1 $thickness=5.6e-08
+ $X=0.243 $Y=0.1025 $X2=0.243 $Y2=0.135
r7 5 6 16.4967 $w=2.1e-08 $l=4.85e-08 $layer=Gate_1 $thickness=5.6e-08 $X=0.243
+ $Y=0.054 $X2=0.243 $Y2=0.1025
r8 5 3 10.0341 $w=2.1e-08 $l=2.95e-08 $layer=Gate_1 $thickness=5.6e-08 $X=0.243
+ $Y=0.054 $X2=0.243 $Y2=0.0245
.ends

.subckt PM_AOI311xp33_ASAP7_75t_R%Y vss 31 20 23 42 47 12 1 10 17 14 3 13 18
c1 1 vss 0.00746246f $X=0.216 $Y=0.054
c2 2 vss 0.00682641f $X=0.324 $Y=0.054
c3 3 vss 0.00659661f $X=0.324 $Y=0.2025
c4 10 vss 0.00286935f $X=0.2015 $Y=0.0725
c5 11 vss 0.000113403f $X=0.2015 $Y=0.0455
c6 12 vss 0.000270604f $X=0.2015 $Y=0.0945
c7 13 vss 0.0268642f $X=0.3095 $Y=0.054
c8 14 vss 0.0353698f $X=0.3095 $Y=0.2025
c9 15 vss 0.00559165f $X=0.351 $Y=0.234
c10 16 vss 0.00257165f $X=0.351 $Y=0.036
c11 17 vss 0.0125499f $X=0.2025 $Y=0.036
c12 18 vss 0.00414096f $X=0.351 $Y=0.0575
r1 14 3 0.154321 $w=8.1e-08 $l=1.25e-08 $layer=P_src_drn $thickness=1e-09
+ $X=0.3095 $Y=0.2025 $X2=0.324 $Y2=0.2025
r2 47 14 0.0308642 $w=8.1e-08 $l=2.5e-09 $layer=P_src_drn $thickness=1e-09
+ $X=0.3066 $Y=0.2025 $X2=0.3095 $Y2=0.2025
r3 3 44 19.3796 $a=3.24e-16 $layer=V0LISD $X=0.324 $Y=0.2025 $X2=0.324 $Y2=0.234
r4 44 45 3.14806 $w=1.3e-08 $l=1.35e-08 $layer=M1 $thickness=3.6e-08 $X=0.324
+ $Y=0.234 $X2=0.3375 $Y2=0.234
r5 15 40 3.83327 $w=1.5093e-08 $l=2.15e-08 $layer=M1 $thickness=3.6e-08
+ $X=0.351 $Y=0.234 $X2=0.351 $Y2=0.2125
r6 15 45 1.96775 $w=1.63333e-08 $l=1.35e-08 $layer=M1 $thickness=3.6e-08
+ $X=0.351 $Y=0.234 $X2=0.3375 $Y2=0.234
r7 13 2 0.231482 $w=5.4e-08 $l=1.25e-08 $layer=N_src_drn $thickness=1e-09
+ $X=0.3095 $Y=0.054 $X2=0.324 $Y2=0.054
r8 42 13 0.0462963 $w=5.4e-08 $l=2.5e-09 $layer=N_src_drn $thickness=1e-09
+ $X=0.3066 $Y=0.054 $X2=0.3095 $Y2=0.054
r9 39 40 18.0722 $w=1.3e-08 $l=7.75e-08 $layer=M1 $thickness=3.6e-08 $X=0.351
+ $Y=0.135 $X2=0.351 $Y2=0.2125
r10 18 39 18.0722 $w=1.3e-08 $l=7.75e-08 $layer=M1 $thickness=3.6e-08 $X=0.351
+ $Y=0.0575 $X2=0.351 $Y2=0.135
r11 2 37 19.3796 $a=3.24e-16 $layer=V0LISD $X=0.324 $Y=0.054 $X2=0.324 $Y2=0.036
r12 16 38 1.49895 $w=1.63333e-08 $l=1.35e-08 $layer=M1 $thickness=3.6e-08
+ $X=0.351 $Y=0.036 $X2=0.3375 $Y2=0.036
r13 16 18 3.36447 $w=1.71023e-08 $l=2.15e-08 $layer=M1 $thickness=3.6e-08
+ $X=0.351 $Y=0.036 $X2=0.351 $Y2=0.0575
r14 37 38 3.14806 $w=1.3e-08 $l=1.35e-08 $layer=M1 $thickness=3.6e-08 $X=0.324
+ $Y=0.036 $X2=0.3375 $Y2=0.036
r15 36 37 2.68168 $w=1.3e-08 $l=1.15e-08 $layer=M1 $thickness=3.6e-08 $X=0.3125
+ $Y=0.036 $X2=0.324 $Y2=0.036
r16 35 36 1.04935 $w=1.3e-08 $l=4.5e-09 $layer=M1 $thickness=3.6e-08 $X=0.308
+ $Y=0.036 $X2=0.3125 $Y2=0.036
r17 34 35 2.56509 $w=1.3e-08 $l=1.1e-08 $layer=M1 $thickness=3.6e-08 $X=0.297
+ $Y=0.036 $X2=0.308 $Y2=0.036
r18 33 34 6.29612 $w=1.3e-08 $l=2.7e-08 $layer=M1 $thickness=3.6e-08 $X=0.27
+ $Y=0.036 $X2=0.297 $Y2=0.036
r19 32 33 4.6055 $w=1.3e-08 $l=1.98e-08 $layer=M1 $thickness=3.6e-08 $X=0.2502
+ $Y=0.036 $X2=0.27 $Y2=0.036
r20 31 32 0.524677 $w=1.3e-08 $l=2.2e-09 $layer=M1 $thickness=3.6e-08 $X=0.248
+ $Y=0.035 $X2=0.2502 $Y2=0.036
r21 31 30 1.69063 $w=1.3e-08 $l=7.3e-09 $layer=M1 $thickness=3.6e-08 $X=0.248
+ $Y=0.035 $X2=0.2407 $Y2=0.036
r22 29 30 2.62338 $w=1.3e-08 $l=1.12e-08 $layer=M1 $thickness=3.6e-08 $X=0.2295
+ $Y=0.036 $X2=0.2407 $Y2=0.036
r23 28 29 3.14806 $w=1.3e-08 $l=1.35e-08 $layer=M1 $thickness=3.6e-08 $X=0.216
+ $Y=0.036 $X2=0.2295 $Y2=0.036
r24 17 28 3.14806 $w=1.3e-08 $l=1.35e-08 $layer=M1 $thickness=3.6e-08 $X=0.2025
+ $Y=0.036 $X2=0.216 $Y2=0.036
r25 1 28 19.3796 $a=3.24e-16 $layer=V0LISD $X=0.216 $Y=0.054 $X2=0.216 $Y2=0.036
r26 12 1 0.462963 $w=2.7e-08 $l=1.25e-08 $layer=N_src_drn $thickness=1e-09
+ $X=0.2015 $Y=0.0945 $X2=0.216 $Y2=0.054
r27 11 1 0.245304 $w=3.7e-08 $l=1.45e-08 $layer=N_src_drn $thickness=1e-09
+ $X=0.2015 $Y=0.0455 $X2=0.216 $Y2=0.054
r28 23 22 0.147059 $w=1.7e-08 $l=2.5e-09 $layer=N_src_drn $thickness=1e-09
+ $X=0.2333 $Y=0.054 $X2=0.2305 $Y2=0.0725
r29 21 22 0.264706 $w=1.7e-08 $l=4.5e-09 $layer=N_src_drn $thickness=1e-09
+ $X=0.226 $Y=0.0725 $X2=0.2305 $Y2=0.0725
r30 1 21 0.705882 $w=1.7e-08 $l=1.2e-08 $layer=N_src_drn $thickness=1e-09
+ $X=0.216 $Y=0.054 $X2=0.226 $Y2=0.0725
r31 10 1 0.735294 $w=1.7e-08 $l=1.25e-08 $layer=N_src_drn $thickness=1e-09
+ $X=0.2015 $Y=0.0725 $X2=0.216 $Y2=0.054
r32 20 10 0.147059 $w=1.7e-08 $l=2.5e-09 $layer=N_src_drn $thickness=1e-09
+ $X=0.1986 $Y=0.0675 $X2=0.2015 $Y2=0.0725
.ends

.subckt PM_AOI311xp33_ASAP7_75t_R%A3 vss 16 8 14 3
c1 1 vss 0.00692861f $X=0.081 $Y=0.135
c2 3 vss 0.142352f $X=0.081 $Y=0.0245
c3 4 vss 0.00112942f $X=0.027 $Y=0.135
c4 5 vss 0.00975778f $X=0.027 $Y=0.08
c5 6 vss 0.0101374f $X=0.027 $Y=0.172
c6 7 vss 0.00301993f $X=0.054 $Y=0.135
r1 4 7 5.11582 $w=1.46667e-08 $l=2.7e-08 $layer=M1 $thickness=3.6e-08 $X=0.027
+ $Y=0.135 $X2=0.054 $Y2=0.135
r2 4 5 11.6451 $w=1.38182e-08 $l=5.5e-08 $layer=M1 $thickness=3.6e-08 $X=0.027
+ $Y=0.135 $X2=0.027 $Y2=0.08
r3 4 6 7.44771 $w=1.42162e-08 $l=3.7e-08 $layer=M1 $thickness=3.6e-08 $X=0.027
+ $Y=0.135 $X2=0.027 $Y2=0.172
r4 16 7 6.29612 $w=1.3e-08 $l=2.7e-08 $layer=M1 $thickness=3.6e-08 $X=0.08
+ $Y=0.136 $X2=0.054 $Y2=0.135
r5 1 11 10.4265 $w=1.765e-08 $layer=LIG $thickness=5.2e-08 $X=0.081 $Y=0.135
+ $X2=0.081 $Y2=0.135
r6 16 1 19.3796 $a=3.24e-16 $layer=V0LIG $X=0.08 $Y=0.136 $X2=0.081 $Y2=0.135
r7 14 13 14.6259 $w=2.1e-08 $l=4.3e-08 $layer=Gate_1 $thickness=5.6e-08
+ $X=0.081 $Y=0.2025 $X2=0.081 $Y2=0.1595
r8 12 13 2.7211 $w=2.1e-08 $l=8e-09 $layer=Gate_1 $thickness=5.6e-08 $X=0.081
+ $Y=0.1515 $X2=0.081 $Y2=0.1595
r9 11 12 5.79936 $w=2.03333e-08 $l=1.65e-08 $layer=Gate_1 $thickness=5.6e-08
+ $X=0.081 $Y=0.135 $X2=0.081 $Y2=0.1515
r10 10 11 5.79936 $w=2.03333e-08 $l=1.65e-08 $layer=Gate_1 $thickness=5.6e-08
+ $X=0.081 $Y=0.1185 $X2=0.081 $Y2=0.135
r11 9 10 2.7211 $w=2.1e-08 $l=8e-09 $layer=Gate_1 $thickness=5.6e-08 $X=0.081
+ $Y=0.1105 $X2=0.081 $Y2=0.1185
r12 8 9 14.6259 $w=2.1e-08 $l=4.3e-08 $layer=Gate_1 $thickness=5.6e-08 $X=0.081
+ $Y=0.0675 $X2=0.081 $Y2=0.1105
r13 8 3 14.6259 $w=2.1e-08 $l=4.3e-08 $layer=Gate_1 $thickness=5.6e-08 $X=0.081
+ $Y=0.0675 $X2=0.081 $Y2=0.0245
.ends

.subckt PM_AOI311xp33_ASAP7_75t_R%C vss 13 5 11 4 3 1
c1 1 vss 0.00209675f $X=0.297 $Y=0.135
c2 3 vss 0.0612643f $X=0.297 $Y=0.0245
c3 4 vss 0.0115296f $X=0.297 $Y=0.098
r1 13 4 8.62802 $w=1.3e-08 $l=3.7e-08 $layer=M1 $thickness=3.6e-08 $X=0.297
+ $Y=0.134 $X2=0.297 $Y2=0.098
r2 1 8 10.4265 $w=1.765e-08 $layer=LIG $thickness=5.2e-08 $X=0.297 $Y=0.135
+ $X2=0.297 $Y2=0.135
r3 13 1 19.3796 $a=3.24e-16 $layer=V0LIG $X=0.297 $Y=0.134 $X2=0.297 $Y2=0.135
r4 11 10 14.6259 $w=2.1e-08 $l=4.3e-08 $layer=Gate_1 $thickness=5.6e-08
+ $X=0.297 $Y=0.2025 $X2=0.297 $Y2=0.1595
r5 9 10 2.7211 $w=2.1e-08 $l=8e-09 $layer=Gate_1 $thickness=5.6e-08 $X=0.297
+ $Y=0.1515 $X2=0.297 $Y2=0.1595
r6 8 9 5.79936 $w=2.03333e-08 $l=1.65e-08 $layer=Gate_1 $thickness=5.6e-08
+ $X=0.297 $Y=0.135 $X2=0.297 $Y2=0.1515
r7 7 8 5.79936 $w=2.03333e-08 $l=1.65e-08 $layer=Gate_1 $thickness=5.6e-08
+ $X=0.297 $Y=0.1185 $X2=0.297 $Y2=0.135
r8 6 7 7.31297 $w=2.1e-08 $l=2.15e-08 $layer=Gate_1 $thickness=5.6e-08 $X=0.297
+ $Y=0.097 $X2=0.297 $Y2=0.1185
r9 5 6 14.6259 $w=2.1e-08 $l=4.3e-08 $layer=Gate_1 $thickness=5.6e-08 $X=0.297
+ $Y=0.054 $X2=0.297 $Y2=0.097
r10 5 3 10.0341 $w=2.1e-08 $l=2.95e-08 $layer=Gate_1 $thickness=5.6e-08
+ $X=0.297 $Y=0.054 $X2=0.297 $Y2=0.0245
.ends

* End of included file AOI311xp33_ASAP7_75t_R.pex.sp.pex

*
.subckt AOI311xp33_ASAP7_75t_CUSTOM_4_25_0_7 VSS VDD A3 A2 A1 B C Y
*
* VSS VSS
* VDD VDD
* A3 A3
* A2 A2
* A1 A1
* B B
* C C
* Y Y
*
*

M0 noxref_10 N_M0_g VSS VSS nmos_rvt L=2e-08 W=8.1e-08 nfin=3 $X=0.071 $Y=0.027
M1 noxref_11 N_M1_g noxref_10 VSS nmos_rvt L=2e-08 W=8.1e-08 nfin=3 $X=0.125
+ $Y=0.027
M2 N_M2_d N_M2_g noxref_11 VSS nmos_rvt L=2e-08 W=8.1e-08 nfin=3 $X=0.179
+ $Y=0.027
M3 VSS N_M3_g N_M3_s VSS nmos_rvt L=2e-08 W=5.4e-08 nfin=2 $X=0.233 $Y=0.027
M4 N_M4_d N_M4_g VSS VSS nmos_rvt L=2e-08 W=5.4e-08 nfin=2 $X=0.287 $Y=0.027
M5 noxref_8 N_M5_g VDD VDD pmos_rvt L=2e-08 W=8.1e-08 nfin=3 $X=0.071 $Y=0.162
M6 VDD N_M6_g noxref_8 VDD pmos_rvt L=2e-08 W=8.1e-08 nfin=3 $X=0.125 $Y=0.162
M7 noxref_8 N_M7_g VDD VDD pmos_rvt L=2e-08 W=8.1e-08 nfin=3 $X=0.179 $Y=0.162
M8 noxref_12 N_M8_g noxref_8 VDD pmos_rvt L=2e-08 W=8.1e-08 nfin=3 $X=0.233
+ $Y=0.162
M9 N_M9_d N_M9_g noxref_12 VDD pmos_rvt L=2e-08 W=8.1e-08 nfin=3 $X=0.287
+ $Y=0.162

* .include "AOI311xp33_ASAP7_75t_R.pex.sp.pxi"

* Start of included file AOI311xp33_ASAP7_75t_R.pex.sp.pxi
x_PM_AOI311xp33_ASAP7_75t_R%A2 vss A2 N_M1_g N_M6_g N_A2_3
+ PM_AOI311xp33_ASAP7_75t_R%A2
cc_1 A2 N_A3_3 0.00300311f $X=0.134 $Y=0.136
cc_2 N_A2_3 N_A3_3 0.00779635f $X=0.135 $Y=0.0245
x_PM_AOI311xp33_ASAP7_75t_R%A1 vss A1 N_M2_g N_M7_g N_A1_4 N_A1_3
+ PM_AOI311xp33_ASAP7_75t_R%A1
cc_3 N_A1_4 A2 0.00507809f $X=0.189 $Y=0.098
cc_4 N_A1_3 N_A2_3 0.0113164f $X=0.189 $Y=0.0245
x_PM_AOI311xp33_ASAP7_75t_R%B vss B N_M3_g N_M8_g N_B_3 N_B_4
+ PM_AOI311xp33_ASAP7_75t_R%B
cc_5 N_B_3 N_A1_3 0.00304622f $X=0.243 $Y=0.0245
cc_6 N_B_4 N_A1_4 0.00615758f $X=0.243 $Y=0.098
x_PM_AOI311xp33_ASAP7_75t_R%Y vss Y N_M2_d N_M3_s N_M4_d N_M9_d N_Y_12 N_Y_1
+ N_Y_10 N_Y_17 N_Y_14 N_Y_3 N_Y_13 N_Y_18 PM_AOI311xp33_ASAP7_75t_R%Y
cc_7 N_Y_12 N_A1_4 0.00129153f $X=0.2015 $Y=0.0945
cc_8 N_Y_1 N_A1_3 0.001394f $X=0.216 $Y=0.054
cc_9 N_Y_10 N_A1_3 0.00939476f $X=0.2015 $Y=0.0725
cc_10 N_Y_12 N_A1_3 0.0347079f $X=0.2015 $Y=0.0945
cc_11 N_Y_10 N_B_4 0.000999057f $X=0.2015 $Y=0.0725
cc_12 N_Y_1 N_B_3 0.00121385f $X=0.216 $Y=0.054
cc_13 N_Y_1 N_B_4 0.00200008f $X=0.216 $Y=0.054
cc_14 N_Y_12 N_B_3 0.00484979f $X=0.2015 $Y=0.0945
cc_15 N_Y_10 N_B_3 0.031083f $X=0.2015 $Y=0.0725
cc_16 N_Y_17 N_C_3 0.000969236f $X=0.2025 $Y=0.036
cc_17 N_Y_14 N_C_1 0.00139208f $X=0.3095 $Y=0.2025
cc_18 N_Y_3 N_C_3 0.00151427f $X=0.324 $Y=0.2025
cc_19 N_Y_13 N_C_3 0.0102094f $X=0.3095 $Y=0.054
cc_20 N_Y_18 N_C_4 0.0074293f $X=0.351 $Y=0.0575
cc_21 N_Y_14 N_C_3 0.0500843f $X=0.3095 $Y=0.2025
x_PM_AOI311xp33_ASAP7_75t_R%A3 vss A3 N_M0_g N_M5_g N_A3_3
+ PM_AOI311xp33_ASAP7_75t_R%A3
x_PM_AOI311xp33_ASAP7_75t_R%C vss C N_M4_g N_M9_g N_C_4 N_C_3 N_C_1
+ PM_AOI311xp33_ASAP7_75t_R%C
cc_22 N_C_4 N_B_4 0.00475627f $X=0.297 $Y=0.098
cc_23 N_C_3 N_B_3 0.00915738f $X=0.297 $Y=0.0245

* End of included file AOI311xp33_ASAP7_75t_R.pex.sp.pxi
.ends

.subckt PM_A2O1A1Ixp33_ASAP7_75t_R%A1 vss 16 5 11 4 3
c1 1 vss 0.0052662f $X=0.081 $Y=0.1245
c2 3 vss 0.106597f $X=0.081 $Y=0.0245
c3 4 vss 0.0113645f $X=0.081 $Y=0.098
r1 16 15 1.92382 $w=1.3e-08 $l=8.3e-09 $layer=M1 $thickness=3.6e-08 $X=0.08
+ $Y=0.16 $X2=0.081 $Y2=0.1517
r2 14 15 3.90593 $w=1.3e-08 $l=1.67e-08 $layer=M1 $thickness=3.6e-08 $X=0.081
+ $Y=0.135 $X2=0.081 $Y2=0.1517
r3 4 14 8.62802 $w=1.3e-08 $l=3.7e-08 $layer=M1 $thickness=3.6e-08 $X=0.081
+ $Y=0.098 $X2=0.081 $Y2=0.135
r4 13 14 19.3796 $a=3.24e-16 $layer=V0LIG $X=0.081 $Y=0.1355 $X2=0.081 $Y2=0.135
r5 1 8 4.22396 $w=1.97957e-08 $l=1.05e-08 $layer=Gate_1 $thickness=5.56522e-08
+ $X=0.081 $Y=0.1245 $X2=0.081 $Y2=0.135
r6 1 13 6.49795 $w=1.53e-08 $l=1.1e-08 $layer=LIG $thickness=4.8e-08 $X=0.081
+ $Y=0.1245 $X2=0.081 $Y2=0.1355
r7 11 10 14.6259 $w=2.1e-08 $l=4.3e-08 $layer=Gate_1 $thickness=5.6e-08
+ $X=0.081 $Y=0.2025 $X2=0.081 $Y2=0.1595
r8 9 10 2.7211 $w=2.1e-08 $l=8e-09 $layer=Gate_1 $thickness=5.6e-08 $X=0.081
+ $Y=0.1515 $X2=0.081 $Y2=0.1595
r9 8 9 5.79936 $w=2.03333e-08 $l=1.65e-08 $layer=Gate_1 $thickness=5.6e-08
+ $X=0.081 $Y=0.135 $X2=0.081 $Y2=0.1515
r10 7 8 5.79936 $w=2.03333e-08 $l=1.65e-08 $layer=Gate_1 $thickness=5.6e-08
+ $X=0.081 $Y=0.1185 $X2=0.081 $Y2=0.135
r11 6 7 2.7211 $w=2.1e-08 $l=8e-09 $layer=Gate_1 $thickness=5.6e-08 $X=0.081
+ $Y=0.1105 $X2=0.081 $Y2=0.1185
r12 5 6 14.6259 $w=2.1e-08 $l=4.3e-08 $layer=Gate_1 $thickness=5.6e-08 $X=0.081
+ $Y=0.0675 $X2=0.081 $Y2=0.1105
r13 5 3 14.6259 $w=2.1e-08 $l=4.3e-08 $layer=Gate_1 $thickness=5.6e-08 $X=0.081
+ $Y=0.0675 $X2=0.081 $Y2=0.0245
.ends

.subckt PM_A2O1A1Ixp33_ASAP7_75t_R%B vss 11 5 9 3 4
c1 1 vss 0.00941254f $X=0.189 $Y=0.136
c2 3 vss 0.0862482f $X=0.189 $Y=0.0245
c3 4 vss 0.00832611f $X=0.189 $Y=0.0992
r1 12 13 3.08976 $w=1.3e-08 $l=1.33e-08 $layer=M1 $thickness=3.6e-08 $X=0.189
+ $Y=0.1227 $X2=0.189 $Y2=0.136
r2 11 12 1.10765 $w=1.3e-08 $l=4.7e-09 $layer=M1 $thickness=3.6e-08 $X=0.19
+ $Y=0.118 $X2=0.189 $Y2=0.1227
r3 11 4 4.37231 $w=1.3e-08 $l=1.88e-08 $layer=M1 $thickness=3.6e-08 $X=0.19
+ $Y=0.118 $X2=0.189 $Y2=0.0992
r4 1 7 10.4265 $w=1.765e-08 $layer=LIG $thickness=5.2e-08 $X=0.189 $Y=0.136
+ $X2=0.189 $Y2=0.136
r5 1 13 19.3796 $a=3.24e-16 $layer=V0LIG $X=0.189 $Y=0.136 $X2=0.189 $Y2=0.136
r6 9 8 16.3266 $w=2.1e-08 $l=4.8e-08 $layer=Gate_1 $thickness=5.6e-08 $X=0.189
+ $Y=0.2025 $X2=0.189 $Y2=0.1545
r7 7 8 6.47963 $w=2.04054e-08 $l=1.85e-08 $layer=Gate_1 $thickness=5.6e-08
+ $X=0.189 $Y=0.136 $X2=0.189 $Y2=0.1545
r8 6 7 6.81977 $w=2.04359e-08 $l=1.95e-08 $layer=Gate_1 $thickness=5.6e-08
+ $X=0.189 $Y=0.1165 $X2=0.189 $Y2=0.136
r9 5 6 16.6668 $w=2.1e-08 $l=4.9e-08 $layer=Gate_1 $thickness=5.6e-08 $X=0.189
+ $Y=0.0675 $X2=0.189 $Y2=0.1165
r10 5 3 14.6259 $w=2.1e-08 $l=4.3e-08 $layer=Gate_1 $thickness=5.6e-08 $X=0.189
+ $Y=0.0675 $X2=0.189 $Y2=0.0245
.ends

.subckt PM_A2O1A1Ixp33_ASAP7_75t_R%8 vss 11 22 23 9 1 7 2 8
c1 1 vss 0.0091934f $X=0.054 $Y=0.2025
c2 2 vss 0.00622736f $X=0.162 $Y=0.2025
c3 7 vss 0.0370023f $X=0.056 $Y=0.2025
c4 8 vss 0.00316068f $X=0.1475 $Y=0.2025
c5 9 vss 0.0132607f $X=0.0425 $Y=0.234
r1 23 21 0.0308642 $w=8.1e-08 $l=2.5e-09 $layer=P_src_drn $thickness=1e-09
+ $X=0.1793 $Y=0.2025 $X2=0.1765 $Y2=0.2025
r2 2 21 0.179012 $w=8.1e-08 $l=1.45e-08 $layer=P_src_drn $thickness=1e-09
+ $X=0.162 $Y=0.2025 $X2=0.1765 $Y2=0.2025
r3 8 2 0.179012 $w=8.1e-08 $l=1.45e-08 $layer=P_src_drn $thickness=1e-09
+ $X=0.1475 $Y=0.2025 $X2=0.162 $Y2=0.2025
r4 22 8 0.0308642 $w=8.1e-08 $l=2.5e-09 $layer=P_src_drn $thickness=1e-09
+ $X=0.1446 $Y=0.2025 $X2=0.1475 $Y2=0.2025
r5 2 18 19.3796 $a=3.24e-16 $layer=V0LISD $X=0.162 $Y=0.2025 $X2=0.162 $Y2=0.234
r6 17 18 3.14806 $w=1.3e-08 $l=1.35e-08 $layer=M1 $thickness=3.6e-08 $X=0.1485
+ $Y=0.234 $X2=0.162 $Y2=0.234
r7 16 17 3.14806 $w=1.3e-08 $l=1.35e-08 $layer=M1 $thickness=3.6e-08 $X=0.135
+ $Y=0.234 $X2=0.1485 $Y2=0.234
r8 15 16 6.29612 $w=1.3e-08 $l=2.7e-08 $layer=M1 $thickness=3.6e-08 $X=0.108
+ $Y=0.234 $X2=0.135 $Y2=0.234
r9 14 15 6.29612 $w=1.3e-08 $l=2.7e-08 $layer=M1 $thickness=3.6e-08 $X=0.081
+ $Y=0.234 $X2=0.108 $Y2=0.234
r10 13 14 3.14806 $w=1.3e-08 $l=1.35e-08 $layer=M1 $thickness=3.6e-08 $X=0.0675
+ $Y=0.234 $X2=0.081 $Y2=0.234
r11 12 13 3.14806 $w=1.3e-08 $l=1.35e-08 $layer=M1 $thickness=3.6e-08 $X=0.054
+ $Y=0.234 $X2=0.0675 $Y2=0.234
r12 9 12 2.68168 $w=1.3e-08 $l=1.15e-08 $layer=M1 $thickness=3.6e-08 $X=0.0425
+ $Y=0.234 $X2=0.054 $Y2=0.234
r13 1 12 19.3796 $a=3.24e-16 $layer=V0LISD $X=0.054 $Y=0.2025 $X2=0.054
+ $Y2=0.234
r14 11 10 0.0308642 $w=8.1e-08 $l=2.5e-09 $layer=P_src_drn $thickness=1e-09
+ $X=0.0713 $Y=0.2025 $X2=0.0685 $Y2=0.2025
r15 7 10 0.154321 $w=8.1e-08 $l=1.25e-08 $layer=P_src_drn $thickness=1e-09
+ $X=0.056 $Y=0.2025 $X2=0.0685 $Y2=0.2025
r16 1 7 1e-05 $l=2e-09 $X=0.054 $Y=0.2025 $X2=0.056 $Y2=0.2025
.ends

.subckt PM_A2O1A1Ixp33_ASAP7_75t_R%Y vss 22 16 34 37 1 8 10 2 14 7
c1 1 vss 0.00869557f $X=0.222 $Y=0.216
c2 2 vss 0.0100733f $X=0.273 $Y=0.0675
c3 7 vss 0.0368153f $X=0.2555 $Y=0.0675
c4 8 vss 0.00195832f $X=0.2015 $Y=0.1975
c5 9 vss 3.40073e-20 $X=0.2015 $Y=0.1755
c6 10 vss 0.000332836f $X=0.2015 $Y=0.2245
c7 11 vss 0.00446051f $X=0.2645 $Y=0.046
c8 12 vss 0.00239027f $X=0.297 $Y=0.224
c9 13 vss 0.0054032f $X=0.275 $Y=0.224
c10 14 vss 0.00492909f $X=0.297 $Y=0.0625
r1 10 1 0.391892 $w=3.7e-08 $l=1.45e-08 $layer=P_src_drn $thickness=1e-09
+ $X=0.2015 $Y=0.2245 $X2=0.222 $Y2=0.216
r2 9 1 0.462963 $w=2.7e-08 $l=1.25e-08 $layer=P_src_drn $thickness=1e-09
+ $X=0.2015 $Y=0.1755 $X2=0.222 $Y2=0.216
r3 37 36 0.147059 $w=1.7e-08 $l=2.5e-09 $layer=P_src_drn $thickness=1e-09
+ $X=0.2333 $Y=0.216 $X2=0.2305 $Y2=0.1975
r4 35 36 0.264706 $w=1.7e-08 $l=4.5e-09 $layer=P_src_drn $thickness=1e-09
+ $X=0.226 $Y=0.1975 $X2=0.2305 $Y2=0.1975
r5 1 35 0.705882 $w=1.7e-08 $l=1.2e-08 $layer=P_src_drn $thickness=1e-09
+ $X=0.222 $Y=0.216 $X2=0.226 $Y2=0.1975
r6 8 1 0.735294 $w=1.7e-08 $l=1.25e-08 $layer=P_src_drn $thickness=1e-09
+ $X=0.2015 $Y=0.1975 $X2=0.222 $Y2=0.216
r7 34 8 0.147059 $w=1.7e-08 $l=2.5e-09 $layer=P_src_drn $thickness=1e-09
+ $X=0.1986 $Y=0.2025 $X2=0.2015 $Y2=0.1975
r8 1 31 19.3796 $a=3.24e-16 $layer=V0LISD $X=0.222 $Y=0.216 $X2=0.2245 $Y2=0.224
r9 29 31 1.74892 $w=1.3e-08 $l=7.5e-09 $layer=M1 $thickness=3.6e-08 $X=0.232
+ $Y=0.224 $X2=0.2245 $Y2=0.224
r10 27 28 2.09871 $w=1.3e-08 $l=9e-09 $layer=M1 $thickness=3.6e-08 $X=0.2355
+ $Y=0.224 $X2=0.2445 $Y2=0.224
r11 27 29 0.816164 $w=1.3e-08 $l=3.5e-09 $layer=M1 $thickness=3.6e-08 $X=0.2355
+ $Y=0.224 $X2=0.232 $Y2=0.224
r12 26 28 2.91487 $w=1.3e-08 $l=1.25e-08 $layer=M1 $thickness=3.6e-08 $X=0.257
+ $Y=0.224 $X2=0.2445 $Y2=0.224
r13 13 26 4.19742 $w=1.3e-08 $l=1.8e-08 $layer=M1 $thickness=3.6e-08 $X=0.275
+ $Y=0.224 $X2=0.257 $Y2=0.224
r14 12 25 2.19852 $w=1.83455e-08 $l=1.65e-08 $layer=M1 $thickness=3.6e-08
+ $X=0.297 $Y=0.224 $X2=0.297 $Y2=0.2075
r15 12 13 3.48106 $w=1.50455e-08 $l=2.2e-08 $layer=M1 $thickness=3.6e-08
+ $X=0.297 $Y=0.224 $X2=0.275 $Y2=0.224
r16 24 25 2.91487 $w=1.3e-08 $l=1.25e-08 $layer=M1 $thickness=3.6e-08 $X=0.297
+ $Y=0.195 $X2=0.297 $Y2=0.2075
r17 23 24 2.62338 $w=1.3e-08 $l=1.13e-08 $layer=M1 $thickness=3.6e-08 $X=0.297
+ $Y=0.1837 $X2=0.297 $Y2=0.195
r18 22 23 1.57403 $w=1.3e-08 $l=6.7e-09 $layer=M1 $thickness=3.6e-08 $X=0.298
+ $Y=0.177 $X2=0.297 $Y2=0.1837
r19 22 21 11.2514 $w=1.3e-08 $l=4.83e-08 $layer=M1 $thickness=3.6e-08 $X=0.298
+ $Y=0.177 $X2=0.297 $Y2=0.1287
r20 20 21 12.4174 $w=1.3e-08 $l=5.32e-08 $layer=M1 $thickness=3.6e-08 $X=0.297
+ $Y=0.0755 $X2=0.297 $Y2=0.1287
r21 14 19 2.66732 $w=1.57273e-08 $l=1.65e-08 $layer=M1 $thickness=3.6e-08
+ $X=0.297 $Y=0.0625 $X2=0.297 $Y2=0.046
r22 14 20 3.03147 $w=1.3e-08 $l=1.3e-08 $layer=M1 $thickness=3.6e-08 $X=0.297
+ $Y=0.0625 $X2=0.297 $Y2=0.0755
r23 18 19 1.26818 $w=1.72857e-08 $l=1.05e-08 $layer=M1 $thickness=3.6e-08
+ $X=0.2865 $Y=0.046 $X2=0.297 $Y2=0.046
r24 17 18 2.44849 $w=1.3e-08 $l=1.05e-08 $layer=M1 $thickness=3.6e-08 $X=0.276
+ $Y=0.046 $X2=0.2865 $Y2=0.046
r25 11 17 2.68168 $w=1.3e-08 $l=1.15e-08 $layer=M1 $thickness=3.6e-08 $X=0.2645
+ $Y=0.046 $X2=0.276 $Y2=0.046
r26 2 17 19.3796 $a=3.24e-16 $layer=V0LISD $X=0.273 $Y=0.0675 $X2=0.276
+ $Y2=0.046
r27 7 2 0.154321 $w=8.1e-08 $l=1.25e-08 $layer=N_src_drn $thickness=1e-09
+ $X=0.2555 $Y=0.0675 $X2=0.273 $Y2=0.0675
r28 16 7 0.0308642 $w=8.1e-08 $l=2.5e-09 $layer=N_src_drn $thickness=1e-09
+ $X=0.2526 $Y=0.0675 $X2=0.2555 $Y2=0.0675
.ends

.subckt PM_A2O1A1Ixp33_ASAP7_75t_R%C vss 13 5 11 3 4 1
c1 1 vss 0.00318508f $X=0.243 $Y=0.136
c2 3 vss 0.083888f $X=0.243 $Y=0.0245
c3 4 vss 0.00814279f $X=0.243 $Y=0.0817
r1 14 15 7.17059 $w=1.3e-08 $l=3.08e-08 $layer=M1 $thickness=3.6e-08 $X=0.243
+ $Y=0.1052 $X2=0.243 $Y2=0.136
r2 13 14 5.18847 $w=1.3e-08 $l=2.22e-08 $layer=M1 $thickness=3.6e-08 $X=0.245
+ $Y=0.083 $X2=0.243 $Y2=0.1052
r3 13 4 0.291487 $w=1.3e-08 $l=1.3e-09 $layer=M1 $thickness=3.6e-08 $X=0.245
+ $Y=0.083 $X2=0.243 $Y2=0.0817
r4 1 8 10.4265 $w=1.765e-08 $layer=LIG $thickness=5.2e-08 $X=0.243 $Y=0.136
+ $X2=0.243 $Y2=0.136
r5 1 15 19.3796 $a=3.24e-16 $layer=V0LIG $X=0.243 $Y=0.136 $X2=0.243 $Y2=0.136
r6 11 10 14.6259 $w=2.1e-08 $l=4.3e-08 $layer=Gate_1 $thickness=5.6e-08
+ $X=0.243 $Y=0.216 $X2=0.243 $Y2=0.173
r7 9 10 7.1429 $w=2.1e-08 $l=2.1e-08 $layer=Gate_1 $thickness=5.6e-08 $X=0.243
+ $Y=0.152 $X2=0.243 $Y2=0.173
r8 8 9 5.62929 $w=2.03125e-08 $l=1.6e-08 $layer=Gate_1 $thickness=5.6e-08
+ $X=0.243 $Y=0.136 $X2=0.243 $Y2=0.152
r9 7 8 5.96942 $w=2.03529e-08 $l=1.7e-08 $layer=Gate_1 $thickness=5.6e-08
+ $X=0.243 $Y=0.119 $X2=0.243 $Y2=0.136
r10 6 7 2.89117 $w=2.1e-08 $l=8.5e-09 $layer=Gate_1 $thickness=5.6e-08 $X=0.243
+ $Y=0.1105 $X2=0.243 $Y2=0.119
r11 5 6 14.6259 $w=2.1e-08 $l=4.3e-08 $layer=Gate_1 $thickness=5.6e-08 $X=0.243
+ $Y=0.0675 $X2=0.243 $Y2=0.1105
r12 5 3 14.6259 $w=2.1e-08 $l=4.3e-08 $layer=Gate_1 $thickness=5.6e-08 $X=0.243
+ $Y=0.0675 $X2=0.243 $Y2=0.0245
.ends

.subckt PM_A2O1A1Ixp33_ASAP7_75t_R%A2 vss 14 5 9 4 3
c1 1 vss 0.0042368f $X=0.135 $Y=0.1355
c2 3 vss 0.104057f $X=0.135 $Y=0.0245
c3 4 vss 0.00981459f $X=0.135 $Y=0.0985
r1 14 13 0.874462 $w=1.3e-08 $l=3.8e-09 $layer=M1 $thickness=3.6e-08 $X=0.132
+ $Y=0.152 $X2=0.135 $Y2=0.1482
r2 12 13 2.85657 $w=1.3e-08 $l=1.22e-08 $layer=M1 $thickness=3.6e-08 $X=0.135
+ $Y=0.136 $X2=0.135 $Y2=0.1482
r3 4 12 8.74462 $w=1.3e-08 $l=3.75e-08 $layer=M1 $thickness=3.6e-08 $X=0.135
+ $Y=0.0985 $X2=0.135 $Y2=0.136
r4 1 7 10.1312 $w=1.77047e-08 $l=5e-10 $layer=LIG $thickness=5.2093e-08
+ $X=0.135 $Y=0.1355 $X2=0.135 $Y2=0.136
r5 1 12 19.3796 $a=3.24e-16 $layer=V0LIG $X=0.135 $Y=0.1355 $X2=0.135 $Y2=0.136
r6 9 8 16.3266 $w=2.1e-08 $l=4.8e-08 $layer=Gate_1 $thickness=5.6e-08 $X=0.135
+ $Y=0.2025 $X2=0.135 $Y2=0.1545
r7 7 8 6.47963 $w=2.04054e-08 $l=1.85e-08 $layer=Gate_1 $thickness=5.6e-08
+ $X=0.135 $Y=0.136 $X2=0.135 $Y2=0.1545
r8 6 7 6.81977 $w=2.04359e-08 $l=1.95e-08 $layer=Gate_1 $thickness=5.6e-08
+ $X=0.135 $Y=0.1165 $X2=0.135 $Y2=0.136
r9 5 6 16.6668 $w=2.1e-08 $l=4.9e-08 $layer=Gate_1 $thickness=5.6e-08 $X=0.135
+ $Y=0.0675 $X2=0.135 $Y2=0.1165
r10 5 3 14.6259 $w=2.1e-08 $l=4.3e-08 $layer=Gate_1 $thickness=5.6e-08 $X=0.135
+ $Y=0.0675 $X2=0.135 $Y2=0.0245
.ends

* End of included file A2O1A1Ixp33_ASAP7_75t_R.pex.sp.pex

*
.subckt A2O1A1Ixp33_ASAP7_75t_CUSTOM_4_25_0_7 VSS VDD A1 A2 B C Y
*
* VSS VSS
* VDD VDD
* A1 A1
* A2 A2
* B B
* C C
* Y Y
*
*

M0 noxref_10 N_M0_g noxref_7 VSS nmos_rvt L=2e-08 W=8.1e-08 nfin=3 $X=0.071
+ $Y=0.027
M1 VSS N_M1_g noxref_10 VSS nmos_rvt L=2e-08 W=8.1e-08 nfin=3 $X=0.125 $Y=0.027
M2 noxref_7 N_M2_g VSS VSS nmos_rvt L=2e-08 W=8.1e-08 nfin=3 $X=0.179 $Y=0.027
M3 N_M3_d N_M3_g noxref_7 VSS nmos_rvt L=2e-08 W=8.1e-08 nfin=3 $X=0.233
+ $Y=0.027
M4 VDD N_M4_g N_M4_s VDD pmos_rvt L=2e-08 W=8.1e-08 nfin=3 $X=0.071 $Y=0.162
M5 N_M5_d N_M5_g VDD VDD pmos_rvt L=2e-08 W=8.1e-08 nfin=3 $X=0.125 $Y=0.162
M6 N_M6_d N_M6_g N_M6_s VDD pmos_rvt L=2e-08 W=8.1e-08 nfin=3 $X=0.179 $Y=0.162
M7 VDD N_M7_g N_M7_s VDD pmos_rvt L=2e-08 W=5.4e-08 nfin=2 $X=0.233 $Y=0.189

* .include "A2O1A1Ixp33_ASAP7_75t_R.pex.sp.pxi"

* Start of included file A2O1A1Ixp33_ASAP7_75t_R.pex.sp.pxi
x_PM_A2O1A1Ixp33_ASAP7_75t_R%A1 vss A1 N_M0_g N_M4_g N_A1_4 N_A1_3
+ PM_A2O1A1Ixp33_ASAP7_75t_R%A1
x_PM_A2O1A1Ixp33_ASAP7_75t_R%B vss B N_M2_g N_M6_g N_B_3 N_B_4
+ PM_A2O1A1Ixp33_ASAP7_75t_R%B
cc_1 N_B_3 N_A2_3 0.00319368f $X=0.189 $Y=0.0245
cc_2 N_B_4 N_A2_4 0.00624392f $X=0.189 $Y=0.0992
x_PM_A2O1A1Ixp33_ASAP7_75t_R%8 vss N_M4_s N_M5_d N_M6_s N_8_9 N_8_1 N_8_7 N_8_2
+ N_8_8 PM_A2O1A1Ixp33_ASAP7_75t_R%8
cc_3 N_8_9 N_A1_3 0.00118734f $X=0.0425 $Y=0.234
cc_4 N_8_1 N_A1_3 0.00141974f $X=0.054 $Y=0.2025
cc_5 N_8_1 N_A1_4 0.0019158f $X=0.054 $Y=0.2025
cc_6 N_8_7 N_A1_3 0.0348509f $X=0.056 $Y=0.2025
cc_7 N_8_9 N_A2_3 0.0010615f $X=0.0425 $Y=0.234
cc_8 N_8_2 N_A2_3 0.00115903f $X=0.162 $Y=0.2025
cc_9 N_8_2 N_A2_4 0.00157901f $X=0.162 $Y=0.2025
cc_10 N_8_8 N_A2_3 0.0344671f $X=0.1475 $Y=0.2025
cc_11 N_8_2 N_B_4 0.000991331f $X=0.162 $Y=0.2025
cc_12 N_8_2 N_B_3 0.00117561f $X=0.162 $Y=0.2025
cc_13 N_8_8 N_B_3 0.0350085f $X=0.1475 $Y=0.2025
x_PM_A2O1A1Ixp33_ASAP7_75t_R%Y vss Y N_M3_d N_M6_d N_M7_s N_Y_1 N_Y_8 N_Y_10
+ N_Y_2 N_Y_14 N_Y_7 PM_A2O1A1Ixp33_ASAP7_75t_R%Y
cc_14 N_Y_1 N_B_3 0.00120244f $X=0.222 $Y=0.216
cc_15 N_Y_1 N_B_4 0.00121337f $X=0.222 $Y=0.216
cc_16 N_Y_8 N_B_3 0.00950268f $X=0.2015 $Y=0.1975
cc_17 N_Y_10 N_B_3 0.0259297f $X=0.2015 $Y=0.2245
cc_18 N_Y_2 N_C_3 0.00118696f $X=0.273 $Y=0.0675
cc_19 N_Y_1 N_C_1 0.00191109f $X=0.222 $Y=0.216
cc_20 N_Y_1 N_C_3 0.00206966f $X=0.222 $Y=0.216
cc_21 N_Y_10 N_C_3 0.0049872f $X=0.2015 $Y=0.2245
cc_22 N_Y_14 N_C_4 0.00650237f $X=0.297 $Y=0.0625
cc_23 N_Y_8 N_C_3 0.00966954f $X=0.2015 $Y=0.1975
cc_24 N_Y_7 N_C_3 0.0576933f $X=0.2555 $Y=0.0675
cc_25 N_Y_1 N_8_9 0.000692598f $X=0.222 $Y=0.216
cc_26 N_Y_1 N_8_2 0.00106926f $X=0.222 $Y=0.216
cc_27 N_Y_1 N_8_8 0.00294525f $X=0.222 $Y=0.216
x_PM_A2O1A1Ixp33_ASAP7_75t_R%C vss C N_M3_g N_M7_g N_C_3 N_C_4 N_C_1
+ PM_A2O1A1Ixp33_ASAP7_75t_R%C
cc_28 N_C_3 N_B_3 0.0031267f $X=0.243 $Y=0.0245
cc_29 N_C_4 N_B_4 0.00563164f $X=0.243 $Y=0.0817
x_PM_A2O1A1Ixp33_ASAP7_75t_R%A2 vss A2 N_M1_g N_M5_g N_A2_4 N_A2_3
+ PM_A2O1A1Ixp33_ASAP7_75t_R%A2
cc_30 N_A2_4 N_A1_4 0.00463867f $X=0.135 $Y=0.0985
cc_31 N_A2_3 N_A1_3 0.00714645f $X=0.135 $Y=0.0245

* End of included file A2O1A1Ixp33_ASAP7_75t_R.pex.sp.pxi
.ends

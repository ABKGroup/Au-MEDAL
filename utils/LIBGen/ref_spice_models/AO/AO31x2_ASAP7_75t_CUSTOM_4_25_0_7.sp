.subckt PM_AO31x2_ASAP7_75t_R%A3 vss 25 11 17 30 33 4 10
c1 1 vss 0.0170498f $X=0.0715 $Y=0.135
c2 3 vss 0.159594f $X=0.081 $Y=0.0245
c3 4 vss 0.160234f $X=0.135 $Y=0.135
c4 5 vss 0.00785647f $X=0.027 $Y=0.036
c5 6 vss 0.00109705f $X=0.027 $Y=0.135
c6 7 vss 0.00671104f $X=0.027 $Y=0.198
c7 8 vss 0.00627467f $X=0.027 $Y=0.1035
c8 9 vss 0.00322975f $X=0.027 $Y=0.1665
c9 10 vss 0.00252867f $X=0.0655 $Y=0.135
r1 7 9 6.16517 $w=1.44286e-08 $l=3.15e-08 $layer=M1 $thickness=3.6e-08 $X=0.027
+ $Y=0.198 $X2=0.027 $Y2=0.1665
r2 5 36 3.01711 $w=1.55e-08 $l=1.8e-08 $layer=M1 $thickness=3.6e-08 $X=0.027
+ $Y=0.036 $X2=0.027 $Y2=0.054
r3 35 36 4.19742 $w=1.3e-08 $l=1.8e-08 $layer=M1 $thickness=3.6e-08 $X=0.027
+ $Y=0.072 $X2=0.027 $Y2=0.054
r4 8 35 7.34548 $w=1.3e-08 $l=3.15e-08 $layer=M1 $thickness=3.6e-08 $X=0.027
+ $Y=0.1035 $X2=0.027 $Y2=0.072
r5 6 27 3.60008 $w=1.51951e-08 $l=2.05e-08 $layer=M1 $thickness=3.6e-08
+ $X=0.027 $Y=0.135 $X2=0.0475 $Y2=0.135
r6 6 8 6.16517 $w=1.44286e-08 $l=3.15e-08 $layer=M1 $thickness=3.6e-08 $X=0.027
+ $Y=0.135 $X2=0.027 $Y2=0.1035
r7 6 9 6.16517 $w=1.44286e-08 $l=3.15e-08 $layer=M1 $thickness=3.6e-08 $X=0.027
+ $Y=0.135 $X2=0.027 $Y2=0.1665
r8 33 32 16.4967 $w=2.1e-08 $l=4.85e-08 $layer=Gate_1 $thickness=5.6e-08
+ $X=0.135 $Y=0.2025 $X2=0.135 $Y2=0.154
r9 30 31 16.4967 $w=2.1e-08 $l=4.85e-08 $layer=Gate_1 $thickness=5.6e-08
+ $X=0.135 $Y=0.0675 $X2=0.135 $Y2=0.116
r10 4 23 6.54019 $w=2.09524e-08 $layer=Gate_1 $thickness=5.21905e-08 $X=0.135
+ $Y=0.135 $X2=0.135 $Y2=0.135
r11 4 31 6.6497 $w=2.04211e-08 $l=1.9e-08 $layer=Gate_1 $thickness=5.6e-08
+ $X=0.135 $Y=0.135 $X2=0.135 $Y2=0.116
r12 4 32 6.6497 $w=2.04211e-08 $l=1.9e-08 $layer=Gate_1 $thickness=5.6e-08
+ $X=0.135 $Y=0.135 $X2=0.135 $Y2=0.154
r13 25 10 3.61444 $w=1.3e-08 $l=1.55e-08 $layer=M1 $thickness=3.6e-08 $X=0.08
+ $Y=0.136 $X2=0.0655 $Y2=0.135
r14 10 27 4.19742 $w=1.3e-08 $l=1.8e-08 $layer=M1 $thickness=3.6e-08 $X=0.0655
+ $Y=0.135 $X2=0.0475 $Y2=0.135
r15 22 23 12.6539 $w=1.77815e-08 $l=2.7e-08 $layer=LIG $thickness=4.8e-08
+ $X=0.108 $Y=0.135 $X2=0.135 $Y2=0.135
r16 20 22 10.1729 $w=1.54914e-08 $l=1.75e-08 $layer=LIG $thickness=4.8e-08
+ $X=0.0905 $Y=0.135 $X2=0.108 $Y2=0.135
r17 19 20 2.48102 $w=2.2e-08 $l=9.5e-09 $layer=LIG $thickness=4.8e-08 $X=0.081
+ $Y=0.135 $X2=0.0905 $Y2=0.135
r18 25 19 19.3796 $a=3.24e-16 $layer=V0LIG $X=0.08 $Y=0.136 $X2=0.081 $Y2=0.135
r19 1 19 2.48102 $w=2.2e-08 $l=9.5e-09 $layer=LIG $thickness=4.8e-08 $X=0.0715
+ $Y=0.135 $X2=0.081 $Y2=0.135
r20 17 16 14.6259 $w=2.1e-08 $l=4.3e-08 $layer=Gate_1 $thickness=5.6e-08
+ $X=0.081 $Y=0.2025 $X2=0.081 $Y2=0.1595
r21 15 16 2.7211 $w=2.1e-08 $l=8e-09 $layer=Gate_1 $thickness=5.6e-08 $X=0.081
+ $Y=0.1515 $X2=0.081 $Y2=0.1595
r22 14 15 5.79936 $w=2.03333e-08 $l=1.65e-08 $layer=Gate_1 $thickness=5.6e-08
+ $X=0.081 $Y=0.135 $X2=0.081 $Y2=0.1515
r23 14 20 4.05918 $w=2.0087e-08 $l=9.5e-09 $layer=Gate_1 $thickness=5.56522e-08
+ $X=0.081 $Y=0.135 $X2=0.0905 $Y2=0.135
r24 14 19 6.27904 $w=2.09e-08 $layer=Gate_1 $thickness=5.24e-08 $X=0.081
+ $Y=0.135 $X2=0.081 $Y2=0.135
r25 13 14 5.79936 $w=2.03333e-08 $l=1.65e-08 $layer=Gate_1 $thickness=5.6e-08
+ $X=0.081 $Y=0.1185 $X2=0.081 $Y2=0.135
r26 12 13 2.7211 $w=2.1e-08 $l=8e-09 $layer=Gate_1 $thickness=5.6e-08 $X=0.081
+ $Y=0.1105 $X2=0.081 $Y2=0.1185
r27 11 12 14.6259 $w=2.1e-08 $l=4.3e-08 $layer=Gate_1 $thickness=5.6e-08
+ $X=0.081 $Y=0.0675 $X2=0.081 $Y2=0.1105
r28 11 3 14.6259 $w=2.1e-08 $l=4.3e-08 $layer=Gate_1 $thickness=5.6e-08
+ $X=0.081 $Y=0.0675 $X2=0.081 $Y2=0.0245
.ends

.subckt PM_AO31x2_ASAP7_75t_R%A2 vss 24 10 16 28 31 4 7 6 8
c1 1 vss 0.0172342f $X=0.3955 $Y=0.135
c2 3 vss 0.159297f $X=0.405 $Y=0.0245
c3 4 vss 0.156215f $X=0.459 $Y=0.135
c4 5 vss 0.00448998f $X=0.297 $Y=0.108
c5 6 vss 0.00199696f $X=0.297 $Y=0.162
c6 7 vss 0.00455241f $X=0.405 $Y=0.1215
c7 8 vss 0.00172227f $X=0.297 $Y=0.133
c8 9 vss 0.00744001f $X=0.38 $Y=0.108
r1 6 37 1.38478 $w=1.70909e-08 $l=1.1e-08 $layer=M1 $thickness=3.6e-08 $X=0.297
+ $Y=0.162 $X2=0.297 $Y2=0.151
r2 8 37 4.19742 $w=1.3e-08 $l=1.8e-08 $layer=M1 $thickness=3.6e-08 $X=0.297
+ $Y=0.133 $X2=0.297 $Y2=0.151
r3 5 34 3.1337 $w=1.54324e-08 $l=1.85e-08 $layer=M1 $thickness=3.6e-08 $X=0.297
+ $Y=0.108 $X2=0.3155 $Y2=0.108
r4 5 8 4.64944 $w=1.48e-08 $l=2.5e-08 $layer=M1 $thickness=3.6e-08 $X=0.297
+ $Y=0.108 $X2=0.297 $Y2=0.133
r5 33 34 6.7625 $w=1.3e-08 $l=2.9e-08 $layer=M1 $thickness=3.6e-08 $X=0.3445
+ $Y=0.108 $X2=0.3155 $Y2=0.108
r6 9 26 4.64944 $w=1.48e-08 $l=2.5e-08 $layer=M1 $thickness=3.6e-08 $X=0.38
+ $Y=0.108 $X2=0.405 $Y2=0.108
r7 9 33 8.27824 $w=1.3e-08 $l=3.55e-08 $layer=M1 $thickness=3.6e-08 $X=0.38
+ $Y=0.108 $X2=0.3445 $Y2=0.108
r8 31 30 16.4967 $w=2.1e-08 $l=4.85e-08 $layer=Gate_1 $thickness=5.6e-08
+ $X=0.459 $Y=0.2025 $X2=0.459 $Y2=0.154
r9 28 29 16.4967 $w=2.1e-08 $l=4.85e-08 $layer=Gate_1 $thickness=5.6e-08
+ $X=0.459 $Y=0.0675 $X2=0.459 $Y2=0.116
r10 4 22 6.54019 $w=2.09524e-08 $layer=Gate_1 $thickness=5.21905e-08 $X=0.459
+ $Y=0.135 $X2=0.459 $Y2=0.135
r11 4 29 6.6497 $w=2.04211e-08 $l=1.9e-08 $layer=Gate_1 $thickness=5.6e-08
+ $X=0.459 $Y=0.135 $X2=0.459 $Y2=0.116
r12 4 30 6.6497 $w=2.04211e-08 $l=1.9e-08 $layer=Gate_1 $thickness=5.6e-08
+ $X=0.459 $Y=0.135 $X2=0.459 $Y2=0.154
r13 24 7 3.14806 $w=1.3e-08 $l=1.35e-08 $layer=M1 $thickness=3.6e-08 $X=0.403
+ $Y=0.137 $X2=0.405 $Y2=0.1215
r14 7 26 1.96775 $w=1.63333e-08 $l=1.35e-08 $layer=M1 $thickness=3.6e-08
+ $X=0.405 $Y=0.1215 $X2=0.405 $Y2=0.108
r15 21 22 12.6539 $w=1.77815e-08 $l=2.7e-08 $layer=LIG $thickness=4.8e-08
+ $X=0.432 $Y=0.135 $X2=0.459 $Y2=0.135
r16 19 21 10.1729 $w=1.54914e-08 $l=1.75e-08 $layer=LIG $thickness=4.8e-08
+ $X=0.4145 $Y=0.135 $X2=0.432 $Y2=0.135
r17 18 19 2.48102 $w=2.2e-08 $l=9.5e-09 $layer=LIG $thickness=4.8e-08 $X=0.405
+ $Y=0.135 $X2=0.4145 $Y2=0.135
r18 24 18 19.3796 $a=3.24e-16 $layer=V0LIG $X=0.403 $Y=0.137 $X2=0.405 $Y2=0.135
r19 1 18 2.48102 $w=2.2e-08 $l=9.5e-09 $layer=LIG $thickness=4.8e-08 $X=0.3955
+ $Y=0.135 $X2=0.405 $Y2=0.135
r20 16 15 14.6259 $w=2.1e-08 $l=4.3e-08 $layer=Gate_1 $thickness=5.6e-08
+ $X=0.405 $Y=0.2025 $X2=0.405 $Y2=0.1595
r21 14 15 2.7211 $w=2.1e-08 $l=8e-09 $layer=Gate_1 $thickness=5.6e-08 $X=0.405
+ $Y=0.1515 $X2=0.405 $Y2=0.1595
r22 13 14 5.79936 $w=2.03333e-08 $l=1.65e-08 $layer=Gate_1 $thickness=5.6e-08
+ $X=0.405 $Y=0.135 $X2=0.405 $Y2=0.1515
r23 13 19 4.05918 $w=2.0087e-08 $l=9.5e-09 $layer=Gate_1 $thickness=5.56522e-08
+ $X=0.405 $Y=0.135 $X2=0.4145 $Y2=0.135
r24 13 18 6.27904 $w=2.09e-08 $layer=Gate_1 $thickness=5.24e-08 $X=0.405
+ $Y=0.135 $X2=0.405 $Y2=0.135
r25 12 13 5.79936 $w=2.03333e-08 $l=1.65e-08 $layer=Gate_1 $thickness=5.6e-08
+ $X=0.405 $Y=0.1185 $X2=0.405 $Y2=0.135
r26 11 12 2.7211 $w=2.1e-08 $l=8e-09 $layer=Gate_1 $thickness=5.6e-08 $X=0.405
+ $Y=0.1105 $X2=0.405 $Y2=0.1185
r27 10 11 14.6259 $w=2.1e-08 $l=4.3e-08 $layer=Gate_1 $thickness=5.6e-08
+ $X=0.405 $Y=0.0675 $X2=0.405 $Y2=0.1105
r28 10 3 14.6259 $w=2.1e-08 $l=4.3e-08 $layer=Gate_1 $thickness=5.6e-08
+ $X=0.405 $Y=0.0675 $X2=0.405 $Y2=0.0245
.ends

.subckt PM_AO31x2_ASAP7_75t_R%Y vss 22 16 17 30 31 7 2 1 8
c1 1 vss 0.0089292f $X=0.756 $Y=0.0675
c2 2 vss 0.0089292f $X=0.756 $Y=0.2025
c3 7 vss 0.00438611f $X=0.7415 $Y=0.0675
c4 8 vss 0.00439234f $X=0.7415 $Y=0.2025
c5 9 vss 0.00294104f $X=0.837 $Y=0.036
c6 10 vss 0.00294365f $X=0.837 $Y=0.234
c7 11 vss 0.00879256f $X=0.8125 $Y=0.234
c8 12 vss 0.00869855f $X=0.7445 $Y=0.036
c9 13 vss 0.00797551f $X=0.837 $Y=0.0855
r1 31 29 0.0308642 $w=8.1e-08 $l=2.5e-09 $layer=P_src_drn $thickness=1e-09
+ $X=0.7733 $Y=0.2025 $X2=0.7705 $Y2=0.2025
r2 2 29 0.179012 $w=8.1e-08 $l=1.45e-08 $layer=P_src_drn $thickness=1e-09
+ $X=0.756 $Y=0.2025 $X2=0.7705 $Y2=0.2025
r3 8 2 0.179012 $w=8.1e-08 $l=1.45e-08 $layer=P_src_drn $thickness=1e-09
+ $X=0.7415 $Y=0.2025 $X2=0.756 $Y2=0.2025
r4 30 8 0.0308642 $w=8.1e-08 $l=2.5e-09 $layer=P_src_drn $thickness=1e-09
+ $X=0.7386 $Y=0.2025 $X2=0.7415 $Y2=0.2025
r5 2 26 19.3796 $a=3.24e-16 $layer=V0LISD $X=0.756 $Y=0.2025 $X2=0.756 $Y2=0.234
r6 26 27 5.82974 $w=1.3e-08 $l=2.5e-08 $layer=M1 $thickness=3.6e-08 $X=0.756
+ $Y=0.234 $X2=0.781 $Y2=0.234
r7 11 27 7.34548 $w=1.3e-08 $l=3.15e-08 $layer=M1 $thickness=3.6e-08 $X=0.8125
+ $Y=0.234 $X2=0.781 $Y2=0.234
r8 10 24 9.89378 $w=1.47818e-08 $l=4.95e-08 $layer=M1 $thickness=3.6e-08
+ $X=0.837 $Y=0.234 $X2=0.837 $Y2=0.1845
r9 10 11 4.06404 $w=1.48367e-08 $l=2.45e-08 $layer=M1 $thickness=3.6e-08
+ $X=0.837 $Y=0.234 $X2=0.8125 $Y2=0.234
r10 23 24 10.9016 $w=1.3e-08 $l=4.68e-08 $layer=M1 $thickness=3.6e-08 $X=0.837
+ $Y=0.1377 $X2=0.837 $Y2=0.1845
r11 22 23 1.57403 $w=1.3e-08 $l=6.7e-09 $layer=M1 $thickness=3.6e-08 $X=0.839
+ $Y=0.131 $X2=0.837 $Y2=0.1377
r12 22 21 0.641272 $w=1.3e-08 $l=2.8e-09 $layer=M1 $thickness=3.6e-08 $X=0.839
+ $Y=0.131 $X2=0.837 $Y2=0.1282
r13 13 21 9.96886 $w=1.3e-08 $l=4.27e-08 $layer=M1 $thickness=3.6e-08 $X=0.837
+ $Y=0.0855 $X2=0.837 $Y2=0.1282
r14 9 20 4.06404 $w=1.48367e-08 $l=2.45e-08 $layer=M1 $thickness=3.6e-08
+ $X=0.837 $Y=0.036 $X2=0.8125 $Y2=0.036
r15 9 13 9.89378 $w=1.47818e-08 $l=4.95e-08 $layer=M1 $thickness=3.6e-08
+ $X=0.837 $Y=0.036 $X2=0.837 $Y2=0.0855
r16 19 20 7.34548 $w=1.3e-08 $l=3.15e-08 $layer=M1 $thickness=3.6e-08 $X=0.781
+ $Y=0.036 $X2=0.8125 $Y2=0.036
r17 18 19 5.82974 $w=1.3e-08 $l=2.5e-08 $layer=M1 $thickness=3.6e-08 $X=0.756
+ $Y=0.036 $X2=0.781 $Y2=0.036
r18 12 18 2.68168 $w=1.3e-08 $l=1.15e-08 $layer=M1 $thickness=3.6e-08 $X=0.7445
+ $Y=0.036 $X2=0.756 $Y2=0.036
r19 1 18 19.3796 $a=3.24e-16 $layer=V0LISD $X=0.756 $Y=0.0675 $X2=0.756
+ $Y2=0.036
r20 17 15 0.0308642 $w=8.1e-08 $l=2.5e-09 $layer=N_src_drn $thickness=1e-09
+ $X=0.7733 $Y=0.0675 $X2=0.7705 $Y2=0.0675
r21 1 15 0.179012 $w=8.1e-08 $l=1.45e-08 $layer=N_src_drn $thickness=1e-09
+ $X=0.756 $Y=0.0675 $X2=0.7705 $Y2=0.0675
r22 7 1 0.179012 $w=8.1e-08 $l=1.45e-08 $layer=N_src_drn $thickness=1e-09
+ $X=0.7415 $Y=0.0675 $X2=0.756 $Y2=0.0675
r23 16 7 0.0308642 $w=8.1e-08 $l=2.5e-09 $layer=N_src_drn $thickness=1e-09
+ $X=0.7386 $Y=0.0675 $X2=0.7415 $Y2=0.0675
.ends

.subckt PM_AO31x2_ASAP7_75t_R%7 vss 33 39 57 61 76 77 102 103 105 5 4 19 15 17
+ 25 18 26 30 6 16 14 31 1 32 13
c1 1 vss 0.0095909f $X=0.7195 $Y=0.135
c2 4 vss 0.0076768f $X=0.216 $Y=0.054
c3 5 vss 0.0098132f $X=0.216 $Y=0.2025
c4 6 vss 0.0117984f $X=0.54 $Y=0.0675
c5 13 vss 0.0835795f $X=0.729 $Y=0.0245
c6 14 vss 0.0834198f $X=0.783 $Y=0.135
c7 15 vss 0.00459968f $X=0.2015 $Y=0.054
c8 16 vss 0.00643895f $X=0.5255 $Y=0.0675
c9 17 vss 0.00608257f $X=0.2015 $Y=0.2025
c10 18 vss 0.00595586f $X=0.243 $Y=0.198
c11 19 vss 0.00633177f $X=0.243 $Y=0.072
c12 20 vss 0.00135869f $X=0.621 $Y=0.198
c13 21 vss 0.00331875f $X=0.621 $Y=0.234
c14 22 vss 0.00338478f $X=0.675 $Y=0.036
c15 23 vss 0.000550046f $X=0.675 $Y=0.135
c16 24 vss 0.00333371f $X=0.675 $Y=0.234
c17 25 vss 0.00296101f $X=0.243 $Y=0.18
c18 26 vss 0.0368467f $X=0.61 $Y=0.198
c19 27 vss 0.0214826f $X=0.648 $Y=0.036
c20 28 vss 0.000985365f $X=0.621 $Y=0.216
c21 29 vss 0.00388804f $X=0.648 $Y=0.234
c22 30 vss 0.00503024f $X=0.675 $Y=0.1125
c23 31 vss 0.00422029f $X=0.675 $Y=0.1465
c24 32 vss 0.00349345f $X=0.702 $Y=0.135
r1 15 4 0.231482 $w=5.4e-08 $l=1.25e-08 $layer=N_src_drn $thickness=1e-09
+ $X=0.2015 $Y=0.054 $X2=0.216 $Y2=0.054
r2 105 15 0.0462963 $w=5.4e-08 $l=2.5e-09 $layer=N_src_drn $thickness=1e-09
+ $X=0.1986 $Y=0.054 $X2=0.2015 $Y2=0.054
r3 4 97 19.3796 $a=3.24e-16 $layer=V0LISD $X=0.216 $Y=0.054 $X2=0.216 $Y2=0.072
r4 103 101 0.0308642 $w=8.1e-08 $l=2.5e-09 $layer=P_src_drn $thickness=1e-09
+ $X=0.2333 $Y=0.2025 $X2=0.2305 $Y2=0.2025
r5 5 101 0.179012 $w=8.1e-08 $l=1.45e-08 $layer=P_src_drn $thickness=1e-09
+ $X=0.216 $Y=0.2025 $X2=0.2305 $Y2=0.2025
r6 17 5 0.179012 $w=8.1e-08 $l=1.45e-08 $layer=P_src_drn $thickness=1e-09
+ $X=0.2015 $Y=0.2025 $X2=0.216 $Y2=0.2025
r7 102 17 0.0308642 $w=8.1e-08 $l=2.5e-09 $layer=P_src_drn $thickness=1e-09
+ $X=0.1986 $Y=0.2025 $X2=0.2015 $Y2=0.2025
r8 97 98 3.14806 $w=1.3e-08 $l=1.35e-08 $layer=M1 $thickness=3.6e-08 $X=0.216
+ $Y=0.072 $X2=0.2295 $Y2=0.072
r9 19 95 6.16517 $w=1.44286e-08 $l=3.15e-08 $layer=M1 $thickness=3.6e-08
+ $X=0.243 $Y=0.072 $X2=0.243 $Y2=0.1035
r10 19 98 1.96775 $w=1.63333e-08 $l=1.35e-08 $layer=M1 $thickness=3.6e-08
+ $X=0.243 $Y=0.072 $X2=0.2295 $Y2=0.072
r11 5 89 19.3796 $a=3.24e-16 $layer=V0LISD $X=0.216 $Y=0.2025 $X2=0.216
+ $Y2=0.198
r12 94 95 7.34548 $w=1.3e-08 $l=3.15e-08 $layer=M1 $thickness=3.6e-08 $X=0.243
+ $Y=0.135 $X2=0.243 $Y2=0.1035
r13 93 94 3.14806 $w=1.3e-08 $l=1.35e-08 $layer=M1 $thickness=3.6e-08 $X=0.243
+ $Y=0.1485 $X2=0.243 $Y2=0.135
r14 92 93 3.14806 $w=1.3e-08 $l=1.35e-08 $layer=M1 $thickness=3.6e-08 $X=0.243
+ $Y=0.162 $X2=0.243 $Y2=0.1485
r15 25 92 4.19742 $w=1.3e-08 $l=1.8e-08 $layer=M1 $thickness=3.6e-08 $X=0.243
+ $Y=0.18 $X2=0.243 $Y2=0.162
r16 89 90 3.14806 $w=1.3e-08 $l=1.35e-08 $layer=M1 $thickness=3.6e-08 $X=0.216
+ $Y=0.198 $X2=0.2295 $Y2=0.198
r17 18 87 5.11582 $w=1.46667e-08 $l=2.7e-08 $layer=M1 $thickness=3.6e-08
+ $X=0.243 $Y=0.198 $X2=0.27 $Y2=0.198
r18 18 90 1.96775 $w=1.63333e-08 $l=1.35e-08 $layer=M1 $thickness=3.6e-08
+ $X=0.243 $Y=0.198 $X2=0.2295 $Y2=0.198
r19 18 25 3.01711 $w=1.55e-08 $l=1.8e-08 $layer=M1 $thickness=3.6e-08 $X=0.243
+ $Y=0.198 $X2=0.243 $Y2=0.18
r20 86 87 8.51143 $w=1.3e-08 $l=3.65e-08 $layer=M1 $thickness=3.6e-08 $X=0.3065
+ $Y=0.198 $X2=0.27 $Y2=0.198
r21 85 86 12.5922 $w=1.3e-08 $l=5.4e-08 $layer=M1 $thickness=3.6e-08 $X=0.3605
+ $Y=0.198 $X2=0.3065 $Y2=0.198
r22 84 85 10.3769 $w=1.3e-08 $l=4.45e-08 $layer=M1 $thickness=3.6e-08 $X=0.405
+ $Y=0.198 $X2=0.3605 $Y2=0.198
r23 83 84 10.3769 $w=1.3e-08 $l=4.45e-08 $layer=M1 $thickness=3.6e-08 $X=0.4495
+ $Y=0.198 $X2=0.405 $Y2=0.198
r24 82 83 12.5922 $w=1.3e-08 $l=5.4e-08 $layer=M1 $thickness=3.6e-08 $X=0.5035
+ $Y=0.198 $X2=0.4495 $Y2=0.198
r25 81 82 8.04505 $w=1.3e-08 $l=3.45e-08 $layer=M1 $thickness=3.6e-08 $X=0.538
+ $Y=0.198 $X2=0.5035 $Y2=0.198
r26 80 81 4.19742 $w=1.3e-08 $l=1.8e-08 $layer=M1 $thickness=3.6e-08 $X=0.556
+ $Y=0.198 $X2=0.538 $Y2=0.198
r27 79 80 2.56509 $w=1.3e-08 $l=1.1e-08 $layer=M1 $thickness=3.6e-08 $X=0.567
+ $Y=0.198 $X2=0.556 $Y2=0.198
r28 78 79 5.82974 $w=1.3e-08 $l=2.5e-08 $layer=M1 $thickness=3.6e-08 $X=0.592
+ $Y=0.198 $X2=0.567 $Y2=0.198
r29 26 78 4.19742 $w=1.3e-08 $l=1.8e-08 $layer=M1 $thickness=3.6e-08 $X=0.61
+ $Y=0.198 $X2=0.592 $Y2=0.198
r30 20 28 2.5483 $w=1.79e-08 $l=1.8e-08 $layer=M1 $thickness=3.6e-08 $X=0.621
+ $Y=0.198 $X2=0.621 $Y2=0.216
r31 20 26 0.915974 $w=1.70909e-08 $l=1.1e-08 $layer=M1 $thickness=3.6e-08
+ $X=0.621 $Y=0.198 $X2=0.61 $Y2=0.198
r32 77 75 0.0308642 $w=8.1e-08 $l=2.5e-09 $layer=N_src_drn $thickness=1e-09
+ $X=0.5573 $Y=0.0675 $X2=0.5545 $Y2=0.0675
r33 6 75 0.179012 $w=8.1e-08 $l=1.45e-08 $layer=N_src_drn $thickness=1e-09
+ $X=0.54 $Y=0.0675 $X2=0.5545 $Y2=0.0675
r34 16 6 0.179012 $w=8.1e-08 $l=1.45e-08 $layer=N_src_drn $thickness=1e-09
+ $X=0.5255 $Y=0.0675 $X2=0.54 $Y2=0.0675
r35 76 16 0.0308642 $w=8.1e-08 $l=2.5e-09 $layer=N_src_drn $thickness=1e-09
+ $X=0.5226 $Y=0.0675 $X2=0.5255 $Y2=0.0675
r36 21 29 4.64701 $w=1.46667e-08 $l=2.7e-08 $layer=M1 $thickness=3.6e-08
+ $X=0.621 $Y=0.234 $X2=0.648 $Y2=0.234
r37 21 28 2.5483 $w=1.79e-08 $l=1.8e-08 $layer=M1 $thickness=3.6e-08 $X=0.621
+ $Y=0.234 $X2=0.621 $Y2=0.216
r38 6 72 19.3796 $a=3.24e-16 $layer=V0LISD $X=0.54 $Y=0.0675 $X2=0.54 $Y2=0.036
r39 72 73 8.97781 $w=1.3e-08 $l=3.85e-08 $layer=M1 $thickness=3.6e-08 $X=0.54
+ $Y=0.036 $X2=0.5785 $Y2=0.036
r40 70 73 9.44419 $w=1.3e-08 $l=4.05e-08 $layer=M1 $thickness=3.6e-08 $X=0.619
+ $Y=0.036 $X2=0.5785 $Y2=0.036
r41 27 70 6.7625 $w=1.3e-08 $l=2.9e-08 $layer=M1 $thickness=3.6e-08 $X=0.648
+ $Y=0.036 $X2=0.619 $Y2=0.036
r42 24 69 4.64701 $w=1.62667e-08 $l=2.7e-08 $layer=M1 $thickness=3.6e-08
+ $X=0.675 $Y=0.234 $X2=0.675 $Y2=0.207
r43 24 29 4.64701 $w=1.46667e-08 $l=2.7e-08 $layer=M1 $thickness=3.6e-08
+ $X=0.675 $Y=0.234 $X2=0.648 $Y2=0.234
r44 22 65 2.5483 $w=1.79e-08 $l=1.8e-08 $layer=M1 $thickness=3.6e-08 $X=0.675
+ $Y=0.036 $X2=0.675 $Y2=0.054
r45 22 27 4.64701 $w=1.46667e-08 $l=2.7e-08 $layer=M1 $thickness=3.6e-08
+ $X=0.675 $Y=0.036 $X2=0.648 $Y2=0.036
r46 68 69 6.29612 $w=1.3e-08 $l=2.7e-08 $layer=M1 $thickness=3.6e-08 $X=0.675
+ $Y=0.18 $X2=0.675 $Y2=0.207
r47 67 68 4.19742 $w=1.3e-08 $l=1.8e-08 $layer=M1 $thickness=3.6e-08 $X=0.675
+ $Y=0.162 $X2=0.675 $Y2=0.18
r48 66 67 2.56509 $w=1.3e-08 $l=1.1e-08 $layer=M1 $thickness=3.6e-08 $X=0.675
+ $Y=0.151 $X2=0.675 $Y2=0.162
r49 31 66 1.04935 $w=1.3e-08 $l=4.5e-09 $layer=M1 $thickness=3.6e-08 $X=0.675
+ $Y=0.1465 $X2=0.675 $Y2=0.151
r50 64 65 4.19742 $w=1.3e-08 $l=1.8e-08 $layer=M1 $thickness=3.6e-08 $X=0.675
+ $Y=0.072 $X2=0.675 $Y2=0.054
r51 63 64 4.19742 $w=1.3e-08 $l=1.8e-08 $layer=M1 $thickness=3.6e-08 $X=0.675
+ $Y=0.09 $X2=0.675 $Y2=0.072
r52 30 63 5.24677 $w=1.3e-08 $l=2.25e-08 $layer=M1 $thickness=3.6e-08 $X=0.675
+ $Y=0.1125 $X2=0.675 $Y2=0.09
r53 23 32 5.11582 $w=1.46667e-08 $l=2.7e-08 $layer=M1 $thickness=3.6e-08
+ $X=0.675 $Y=0.135 $X2=0.702 $Y2=0.135
r54 23 30 4.06646 $w=1.5e-08 $l=2.25e-08 $layer=M1 $thickness=3.6e-08 $X=0.675
+ $Y=0.135 $X2=0.675 $Y2=0.1125
r55 23 31 1.50137 $w=1.6913e-08 $l=1.15e-08 $layer=M1 $thickness=3.6e-08
+ $X=0.675 $Y=0.135 $X2=0.675 $Y2=0.1465
r56 61 60 14.6259 $w=2.1e-08 $l=4.3e-08 $layer=Gate_1 $thickness=5.6e-08
+ $X=0.783 $Y=0.2025 $X2=0.783 $Y2=0.1595
r57 59 60 2.7211 $w=2.1e-08 $l=8e-09 $layer=Gate_1 $thickness=5.6e-08 $X=0.783
+ $Y=0.1515 $X2=0.783 $Y2=0.1595
r58 57 58 14.6259 $w=2.1e-08 $l=4.3e-08 $layer=Gate_1 $thickness=5.6e-08
+ $X=0.783 $Y=0.0675 $X2=0.783 $Y2=0.1105
r59 55 58 2.7211 $w=2.1e-08 $l=8e-09 $layer=Gate_1 $thickness=5.6e-08 $X=0.783
+ $Y=0.1185 $X2=0.783 $Y2=0.1105
r60 14 46 6.27904 $w=2.09e-08 $layer=Gate_1 $thickness=5.24e-08 $X=0.783
+ $Y=0.135 $X2=0.783 $Y2=0.135
r61 14 55 5.79936 $w=2.03333e-08 $l=1.65e-08 $layer=Gate_1 $thickness=5.6e-08
+ $X=0.783 $Y=0.135 $X2=0.783 $Y2=0.1185
r62 14 59 5.79936 $w=2.03333e-08 $l=1.65e-08 $layer=Gate_1 $thickness=5.6e-08
+ $X=0.783 $Y=0.135 $X2=0.783 $Y2=0.1515
r63 52 53 5.82974 $w=1.3e-08 $l=2.5e-08 $layer=M1 $thickness=3.6e-08 $X=0.758
+ $Y=0.135 $X2=0.783 $Y2=0.135
r64 51 52 3.84763 $w=1.3e-08 $l=1.65e-08 $layer=M1 $thickness=3.6e-08 $X=0.7415
+ $Y=0.135 $X2=0.758 $Y2=0.135
r65 50 51 0.46638 $w=1.3e-08 $l=2e-09 $layer=M1 $thickness=3.6e-08 $X=0.7395
+ $Y=0.135 $X2=0.7415 $Y2=0.135
r66 49 50 2.44849 $w=1.3e-08 $l=1.05e-08 $layer=M1 $thickness=3.6e-08 $X=0.729
+ $Y=0.135 $X2=0.7395 $Y2=0.135
r67 32 49 6.29612 $w=1.3e-08 $l=2.7e-08 $layer=M1 $thickness=3.6e-08 $X=0.702
+ $Y=0.135 $X2=0.729 $Y2=0.135
r68 46 53 19.3796 $a=3.24e-16 $layer=V0LIG $X=0.783 $Y=0.135 $X2=0.783 $Y2=0.135
r69 45 46 2.48102 $w=2.2e-08 $l=9.5e-09 $layer=LIG $thickness=4.8e-08 $X=0.7735
+ $Y=0.135 $X2=0.783 $Y2=0.135
r70 44 45 10.1729 $w=1.54914e-08 $l=1.75e-08 $layer=LIG $thickness=4.8e-08
+ $X=0.756 $Y=0.135 $X2=0.7735 $Y2=0.135
r71 42 44 10.1729 $w=1.54914e-08 $l=1.75e-08 $layer=LIG $thickness=4.8e-08
+ $X=0.7385 $Y=0.135 $X2=0.756 $Y2=0.135
r72 41 42 2.48102 $w=2.2e-08 $l=9.5e-09 $layer=LIG $thickness=4.8e-08 $X=0.729
+ $Y=0.135 $X2=0.7385 $Y2=0.135
r73 41 49 19.3796 $a=3.24e-16 $layer=V0LIG $X=0.729 $Y=0.135 $X2=0.729 $Y2=0.135
r74 1 41 2.48102 $w=2.2e-08 $l=9.5e-09 $layer=LIG $thickness=4.8e-08 $X=0.7195
+ $Y=0.135 $X2=0.729 $Y2=0.135
r75 39 38 14.6259 $w=2.1e-08 $l=4.3e-08 $layer=Gate_1 $thickness=5.6e-08
+ $X=0.729 $Y=0.2025 $X2=0.729 $Y2=0.1595
r76 37 38 2.7211 $w=2.1e-08 $l=8e-09 $layer=Gate_1 $thickness=5.6e-08 $X=0.729
+ $Y=0.1515 $X2=0.729 $Y2=0.1595
r77 36 37 5.79936 $w=2.03333e-08 $l=1.65e-08 $layer=Gate_1 $thickness=5.6e-08
+ $X=0.729 $Y=0.135 $X2=0.729 $Y2=0.1515
r78 36 42 4.05918 $w=2.0087e-08 $l=9.5e-09 $layer=Gate_1 $thickness=5.56522e-08
+ $X=0.729 $Y=0.135 $X2=0.7385 $Y2=0.135
r79 36 41 6.27904 $w=2.09e-08 $layer=Gate_1 $thickness=5.24e-08 $X=0.729
+ $Y=0.135 $X2=0.729 $Y2=0.135
r80 35 36 5.79936 $w=2.03333e-08 $l=1.65e-08 $layer=Gate_1 $thickness=5.6e-08
+ $X=0.729 $Y=0.1185 $X2=0.729 $Y2=0.135
r81 34 35 2.7211 $w=2.1e-08 $l=8e-09 $layer=Gate_1 $thickness=5.6e-08 $X=0.729
+ $Y=0.1105 $X2=0.729 $Y2=0.1185
r82 33 34 14.6259 $w=2.1e-08 $l=4.3e-08 $layer=Gate_1 $thickness=5.6e-08
+ $X=0.729 $Y=0.0675 $X2=0.729 $Y2=0.1105
r83 33 13 14.6259 $w=2.1e-08 $l=4.3e-08 $layer=Gate_1 $thickness=5.6e-08
+ $X=0.729 $Y=0.0675 $X2=0.729 $Y2=0.0245
.ends

.subckt PM_AO31x2_ASAP7_75t_R%A1 vss 30 10 14 24 28 3 4 1 5
c1 1 vss 0.013509f $X=0.513 $Y=0.135
c2 3 vss 0.118704f $X=0.513 $Y=0.0245
c3 4 vss 0.126943f $X=0.567 $Y=0.135
c4 5 vss 0.00236161f $X=0.513 $Y=0.162
c5 6 vss 0.00309816f $X=0.513 $Y=0.108
c6 7 vss 0.00479358f $X=0.567 $Y=0.1215
c7 8 vss 0.0019435f $X=0.513 $Y=0.133
c8 9 vss 0.00349088f $X=0.54 $Y=0.108
r1 5 33 1.38478 $w=1.70909e-08 $l=1.1e-08 $layer=M1 $thickness=3.6e-08 $X=0.513
+ $Y=0.162 $X2=0.513 $Y2=0.151
r2 8 33 4.19742 $w=1.3e-08 $l=1.8e-08 $layer=M1 $thickness=3.6e-08 $X=0.513
+ $Y=0.133 $X2=0.513 $Y2=0.151
r3 6 9 4.64701 $w=1.46667e-08 $l=2.7e-08 $layer=M1 $thickness=3.6e-08 $X=0.513
+ $Y=0.108 $X2=0.54 $Y2=0.108
r4 6 8 4.18063 $w=1.6528e-08 $l=2.5e-08 $layer=M1 $thickness=3.6e-08 $X=0.513
+ $Y=0.108 $X2=0.513 $Y2=0.133
r5 9 32 5.11582 $w=1.46667e-08 $l=2.7e-08 $layer=M1 $thickness=3.6e-08 $X=0.54
+ $Y=0.108 $X2=0.567 $Y2=0.108
r6 30 7 3.14806 $w=1.3e-08 $l=1.35e-08 $layer=M1 $thickness=3.6e-08 $X=0.569
+ $Y=0.137 $X2=0.567 $Y2=0.1215
r7 7 32 1.96775 $w=1.63333e-08 $l=1.35e-08 $layer=M1 $thickness=3.6e-08
+ $X=0.567 $Y=0.1215 $X2=0.567 $Y2=0.108
r8 28 27 14.6259 $w=2.1e-08 $l=4.3e-08 $layer=Gate_1 $thickness=5.6e-08
+ $X=0.567 $Y=0.2025 $X2=0.567 $Y2=0.1595
r9 26 27 2.7211 $w=2.1e-08 $l=8e-09 $layer=Gate_1 $thickness=5.6e-08 $X=0.567
+ $Y=0.1515 $X2=0.567 $Y2=0.1595
r10 24 25 14.6259 $w=2.1e-08 $l=4.3e-08 $layer=Gate_1 $thickness=5.6e-08
+ $X=0.567 $Y=0.0675 $X2=0.567 $Y2=0.1105
r11 22 25 2.7211 $w=2.1e-08 $l=8e-09 $layer=Gate_1 $thickness=5.6e-08 $X=0.567
+ $Y=0.1185 $X2=0.567 $Y2=0.1105
r12 4 19 6.27904 $w=2.09e-08 $layer=Gate_1 $thickness=5.24e-08 $X=0.567
+ $Y=0.135 $X2=0.567 $Y2=0.135
r13 4 22 5.79936 $w=2.03333e-08 $l=1.65e-08 $layer=Gate_1 $thickness=5.6e-08
+ $X=0.567 $Y=0.135 $X2=0.567 $Y2=0.1185
r14 4 26 5.79936 $w=2.03333e-08 $l=1.65e-08 $layer=Gate_1 $thickness=5.6e-08
+ $X=0.567 $Y=0.135 $X2=0.567 $Y2=0.1515
r15 30 19 19.3796 $a=3.24e-16 $layer=V0LIG $X=0.569 $Y=0.137 $X2=0.567 $Y2=0.135
r16 18 19 2.48102 $w=2.2e-08 $l=9.5e-09 $layer=LIG $thickness=4.8e-08 $X=0.5575
+ $Y=0.135 $X2=0.567 $Y2=0.135
r17 17 18 10.1729 $w=1.54914e-08 $l=1.75e-08 $layer=LIG $thickness=4.8e-08
+ $X=0.54 $Y=0.135 $X2=0.5575 $Y2=0.135
r18 1 12 6.54019 $w=2.09524e-08 $layer=Gate_1 $thickness=5.21905e-08 $X=0.513
+ $Y=0.135 $X2=0.513 $Y2=0.135
r19 1 17 12.6539 $w=1.77815e-08 $l=2.7e-08 $layer=LIG $thickness=4.8e-08
+ $X=0.513 $Y=0.135 $X2=0.54 $Y2=0.135
r20 14 13 16.4967 $w=2.1e-08 $l=4.85e-08 $layer=Gate_1 $thickness=5.6e-08
+ $X=0.513 $Y=0.2025 $X2=0.513 $Y2=0.154
r21 12 13 6.6497 $w=2.04211e-08 $l=1.9e-08 $layer=Gate_1 $thickness=5.6e-08
+ $X=0.513 $Y=0.135 $X2=0.513 $Y2=0.154
r22 11 12 6.6497 $w=2.04211e-08 $l=1.9e-08 $layer=Gate_1 $thickness=5.6e-08
+ $X=0.513 $Y=0.116 $X2=0.513 $Y2=0.135
r23 10 11 16.4967 $w=2.1e-08 $l=4.85e-08 $layer=Gate_1 $thickness=5.6e-08
+ $X=0.513 $Y=0.0675 $X2=0.513 $Y2=0.116
r24 10 3 14.6259 $w=2.1e-08 $l=4.3e-08 $layer=Gate_1 $thickness=5.6e-08
+ $X=0.513 $Y=0.0675 $X2=0.513 $Y2=0.0245
.ends

.subckt PM_AO31x2_ASAP7_75t_R%B vss 23 11 15 31 8 7 3 4 10 1
c1 1 vss 0.00931546f $X=0.1795 $Y=0.135
c2 3 vss 0.0840278f $X=0.189 $Y=0.0245
c3 4 vss 0.0618219f $X=0.243 $Y=0.135
c4 5 vss 0.0066375f $X=0.135 $Y=0.072
c5 6 vss 0.00674332f $X=0.135 $Y=0.198
c6 7 vss 0.000547258f $X=0.135 $Y=0.135
c7 8 vss 0.00357406f $X=0.135 $Y=0.1035
c8 9 vss 0.00366023f $X=0.135 $Y=0.1665
c9 10 vss 0.0034913f $X=0.162 $Y=0.135
r1 6 9 6.16517 $w=1.44286e-08 $l=3.15e-08 $layer=M1 $thickness=3.6e-08 $X=0.135
+ $Y=0.198 $X2=0.135 $Y2=0.1665
r2 5 8 6.16517 $w=1.44286e-08 $l=3.15e-08 $layer=M1 $thickness=3.6e-08 $X=0.135
+ $Y=0.072 $X2=0.135 $Y2=0.1035
r3 7 10 5.11582 $w=1.46667e-08 $l=2.7e-08 $layer=M1 $thickness=3.6e-08 $X=0.135
+ $Y=0.135 $X2=0.162 $Y2=0.135
r4 7 8 6.16517 $w=1.44286e-08 $l=3.15e-08 $layer=M1 $thickness=3.6e-08 $X=0.135
+ $Y=0.135 $X2=0.135 $Y2=0.1035
r5 7 9 6.16517 $w=1.44286e-08 $l=3.15e-08 $layer=M1 $thickness=3.6e-08 $X=0.135
+ $Y=0.135 $X2=0.135 $Y2=0.1665
r6 31 30 14.6259 $w=2.1e-08 $l=4.3e-08 $layer=Gate_1 $thickness=5.6e-08
+ $X=0.243 $Y=0.2025 $X2=0.243 $Y2=0.1595
r7 29 30 2.7211 $w=2.1e-08 $l=8e-09 $layer=Gate_1 $thickness=5.6e-08 $X=0.243
+ $Y=0.1515 $X2=0.243 $Y2=0.1595
r8 4 21 6.54019 $w=2.09524e-08 $layer=Gate_1 $thickness=5.21905e-08 $X=0.243
+ $Y=0.135 $X2=0.243 $Y2=0.135
r9 4 29 5.79936 $w=2.03333e-08 $l=1.65e-08 $layer=Gate_1 $thickness=5.6e-08
+ $X=0.243 $Y=0.135 $X2=0.243 $Y2=0.1515
r10 23 10 6.29612 $w=1.3e-08 $l=2.7e-08 $layer=M1 $thickness=3.6e-08 $X=0.189
+ $Y=0.134 $X2=0.162 $Y2=0.135
r11 20 21 12.6539 $w=1.77815e-08 $l=2.7e-08 $layer=LIG $thickness=4.8e-08
+ $X=0.216 $Y=0.135 $X2=0.243 $Y2=0.135
r12 18 20 10.1729 $w=1.54914e-08 $l=1.75e-08 $layer=LIG $thickness=4.8e-08
+ $X=0.1985 $Y=0.135 $X2=0.216 $Y2=0.135
r13 17 18 2.48102 $w=2.2e-08 $l=9.5e-09 $layer=LIG $thickness=4.8e-08 $X=0.189
+ $Y=0.135 $X2=0.1985 $Y2=0.135
r14 23 17 19.3796 $a=3.24e-16 $layer=V0LIG $X=0.189 $Y=0.134 $X2=0.189 $Y2=0.135
r15 1 17 2.48102 $w=2.2e-08 $l=9.5e-09 $layer=LIG $thickness=4.8e-08 $X=0.1795
+ $Y=0.135 $X2=0.189 $Y2=0.135
r16 15 14 16.4967 $w=2.1e-08 $l=4.85e-08 $layer=Gate_1 $thickness=5.6e-08
+ $X=0.189 $Y=0.2025 $X2=0.189 $Y2=0.154
r17 13 14 6.6497 $w=2.04211e-08 $l=1.9e-08 $layer=Gate_1 $thickness=5.6e-08
+ $X=0.189 $Y=0.135 $X2=0.189 $Y2=0.154
r18 13 18 4.05918 $w=2.0087e-08 $l=9.5e-09 $layer=Gate_1 $thickness=5.56522e-08
+ $X=0.189 $Y=0.135 $X2=0.1985 $Y2=0.135
r19 13 17 6.27904 $w=2.09e-08 $layer=Gate_1 $thickness=5.24e-08 $X=0.189
+ $Y=0.135 $X2=0.189 $Y2=0.135
r20 12 13 11.2416 $w=2.06615e-08 $l=3.25e-08 $layer=Gate_1 $thickness=5.6e-08
+ $X=0.189 $Y=0.1025 $X2=0.189 $Y2=0.135
r21 11 12 16.4967 $w=2.1e-08 $l=4.85e-08 $layer=Gate_1 $thickness=5.6e-08
+ $X=0.189 $Y=0.054 $X2=0.189 $Y2=0.1025
r22 11 3 10.0341 $w=2.1e-08 $l=2.95e-08 $layer=Gate_1 $thickness=5.6e-08
+ $X=0.189 $Y=0.054 $X2=0.189 $Y2=0.0245
.ends

* End of included file AO31x2_ASAP7_75t_R.pex.sp.pex

*
.subckt AO31x2_ASAP7_75t_CUSTOM_4_25_0_7 VSS VDD A3 B A2 A1 Y
*
* VSS VSS
* VDD VDD
* A3 A3
* B B
* A2 A2
* A1 A1
* Y Y
*
*

M0 noxref_9 N_M0_g VSS VSS nmos_rvt L=2e-08 W=8.1e-08 nfin=3 $X=0.071 $Y=0.027
M1 noxref_9 N_M1_g VSS VSS nmos_rvt L=2e-08 W=8.1e-08 nfin=3 $X=0.125 $Y=0.027
M2 N_M2_d N_M2_g VSS VSS nmos_rvt L=2e-08 W=5.4e-08 nfin=2 $X=0.179 $Y=0.027
M3 noxref_9 N_M3_g noxref_10 VSS nmos_rvt L=2e-08 W=8.1e-08 nfin=3 $X=0.395
+ $Y=0.027
M4 noxref_9 N_M4_g noxref_10 VSS nmos_rvt L=2e-08 W=8.1e-08 nfin=3 $X=0.449
+ $Y=0.027
M5 N_M5_d N_M5_g noxref_10 VSS nmos_rvt L=2e-08 W=8.1e-08 nfin=3 $X=0.503
+ $Y=0.027
M6 N_M6_d N_M6_g noxref_10 VSS nmos_rvt L=2e-08 W=8.1e-08 nfin=3 $X=0.557
+ $Y=0.027
M7 N_M7_d N_M7_g VSS VSS nmos_rvt L=2e-08 W=8.1e-08 nfin=3 $X=0.719 $Y=0.027
M8 N_M8_d N_M8_g VSS VSS nmos_rvt L=2e-08 W=8.1e-08 nfin=3 $X=0.773 $Y=0.027
M9 VDD N_M9_g noxref_8 VDD pmos_rvt L=2e-08 W=8.1e-08 nfin=3 $X=0.071 $Y=0.162
M10 VDD N_M10_g noxref_8 VDD pmos_rvt L=2e-08 W=8.1e-08 nfin=3 $X=0.125 $Y=0.162
M11 N_M11_d N_M11_g noxref_8 VDD pmos_rvt L=2e-08 W=8.1e-08 nfin=3 $X=0.179
+ $Y=0.162
M12 N_M12_d N_M12_g noxref_8 VDD pmos_rvt L=2e-08 W=8.1e-08 nfin=3 $X=0.233
+ $Y=0.162
M13 noxref_8 N_M13_g VDD VDD pmos_rvt L=2e-08 W=8.1e-08 nfin=3 $X=0.395 $Y=0.162
M14 noxref_8 N_M14_g VDD VDD pmos_rvt L=2e-08 W=8.1e-08 nfin=3 $X=0.449 $Y=0.162
M15 noxref_8 N_M15_g VDD VDD pmos_rvt L=2e-08 W=8.1e-08 nfin=3 $X=0.503 $Y=0.162
M16 noxref_8 N_M16_g VDD VDD pmos_rvt L=2e-08 W=8.1e-08 nfin=3 $X=0.557 $Y=0.162
M17 N_M17_d N_M17_g VDD VDD pmos_rvt L=2e-08 W=8.1e-08 nfin=3 $X=0.719 $Y=0.162
M18 N_M18_d N_M18_g VDD VDD pmos_rvt L=2e-08 W=8.1e-08 nfin=3 $X=0.773 $Y=0.162

* .include "AO31x2_ASAP7_75t_R.pex.sp.pxi"

* Start of included file AO31x2_ASAP7_75t_R.pex.sp.pxi
x_PM_AO31x2_ASAP7_75t_R%A3 vss A3 N_M0_g N_M9_g N_M1_g N_M10_g N_A3_4 N_A3_10
+ PM_AO31x2_ASAP7_75t_R%A3
x_PM_AO31x2_ASAP7_75t_R%A2 vss A2 N_M3_g N_M13_g N_M4_g N_M14_g N_A2_4 N_A2_7
+ N_A2_6 N_A2_8 PM_AO31x2_ASAP7_75t_R%A2
x_PM_AO31x2_ASAP7_75t_R%Y vss Y N_M7_d N_M8_d N_M17_d N_M18_d N_Y_7 N_Y_2 N_Y_1
+ N_Y_8 PM_AO31x2_ASAP7_75t_R%Y
cc_1 N_Y_7 N_7_14 0.0390585f $X=0.7415 $Y=0.0675
cc_2 N_Y_7 N_7_31 0.000407382f $X=0.7415 $Y=0.0675
cc_3 N_Y_7 N_7_30 0.000480538f $X=0.7415 $Y=0.0675
cc_4 N_Y_7 N_7_1 0.00577335f $X=0.7415 $Y=0.0675
cc_5 N_Y_7 N_7_32 0.00320003f $X=0.7415 $Y=0.0675
cc_6 N_Y_2 N_7_14 0.00196106f $X=0.756 $Y=0.2025
cc_7 N_Y_1 N_7_32 0.00232683f $X=0.756 $Y=0.0675
cc_8 N_Y_8 N_7_14 0.0103032f $X=0.7415 $Y=0.2025
cc_9 N_Y_8 N_7_13 0.0184344f $X=0.7415 $Y=0.2025
cc_10 N_Y_7 N_7_13 0.0679003f $X=0.7415 $Y=0.0675
x_PM_AO31x2_ASAP7_75t_R%7 vss N_M7_g N_M17_g N_M8_g N_M18_g N_M5_d N_M6_d
+ N_M11_d N_M12_d N_M2_d N_7_5 N_7_4 N_7_19 N_7_15 N_7_17 N_7_25 N_7_18 N_7_26
+ N_7_30 N_7_6 N_7_16 N_7_14 N_7_31 N_7_1 N_7_32 N_7_13 PM_AO31x2_ASAP7_75t_R%7
cc_11 N_7_5 N_B_3 0.00266363f $X=0.216 $Y=0.2025
cc_12 N_7_4 N_B_3 0.00143268f $X=0.216 $Y=0.054
cc_13 N_7_19 N_B_3 0.000688474f $X=0.243 $Y=0.072
cc_14 N_7_15 N_B_3 0.00874226f $X=0.2015 $Y=0.054
cc_15 N_7_17 N_B_4 0.0531121f $X=0.2015 $Y=0.2025
cc_16 N_7_25 N_B_10 0.00181116f $X=0.243 $Y=0.18
cc_17 N_7_18 N_B_10 0.00212667f $X=0.243 $Y=0.198
cc_18 N_7_17 N_B_1 0.00348669f $X=0.2015 $Y=0.2025
cc_19 N_7_15 N_B_4 0.0148557f $X=0.2015 $Y=0.054
cc_20 N_7_17 N_B_3 0.0446272f $X=0.2015 $Y=0.2025
cc_21 N_7_19 N_A2_7 0.000406347f $X=0.243 $Y=0.072
cc_22 N_7_25 N_A2_7 0.0011603f $X=0.243 $Y=0.18
cc_23 N_7_26 N_A2_6 0.00250412f $X=0.61 $Y=0.198
cc_24 N_7_25 N_A2_8 0.00253658f $X=0.243 $Y=0.18
cc_25 N_7_26 N_A2_7 0.00544768f $X=0.61 $Y=0.198
cc_26 N_7_30 N_A1_4 0.000204659f $X=0.675 $Y=0.1125
cc_27 N_7_26 N_A1_4 0.00115473f $X=0.61 $Y=0.198
cc_28 N_7_6 N_A1_4 0.00153829f $X=0.54 $Y=0.0675
cc_29 N_7_6 N_A1_3 0.00189477f $X=0.54 $Y=0.0675
cc_30 N_7_16 N_A1_1 0.00236322f $X=0.5255 $Y=0.0675
cc_31 N_7_26 N_A1_5 0.00536618f $X=0.61 $Y=0.198
cc_32 N_7_16 N_A1_3 0.0188756f $X=0.5255 $Y=0.0675
cc_33 N_7_16 N_A1_4 0.0501083f $X=0.5255 $Y=0.0675
x_PM_AO31x2_ASAP7_75t_R%A1 vss A1 N_M5_g N_M15_g N_M6_g N_M16_g N_A1_3 N_A1_4
+ N_A1_1 N_A1_5 PM_AO31x2_ASAP7_75t_R%A1
cc_34 N_A1_3 N_A2_4 0.00631692f $X=0.513 $Y=0.0245
x_PM_AO31x2_ASAP7_75t_R%B vss B N_M2_g N_M11_g N_M12_g N_B_8 N_B_7 N_B_3 N_B_4
+ N_B_10 N_B_1 PM_AO31x2_ASAP7_75t_R%B
cc_35 N_B_8 N_A3_4 0.000709173f $X=0.135 $Y=0.1035
cc_36 N_B_7 N_A3_4 0.0015167f $X=0.135 $Y=0.135
cc_37 N_B_7 N_A3_10 0.00181315f $X=0.135 $Y=0.135
cc_38 N_B_3 N_A3_4 0.00699858f $X=0.189 $Y=0.0245

* End of included file AO31x2_ASAP7_75t_R.pex.sp.pxi
.ends

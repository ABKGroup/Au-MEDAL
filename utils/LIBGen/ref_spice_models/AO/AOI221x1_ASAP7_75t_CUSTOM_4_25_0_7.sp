.subckt PM_AOI221x1_ASAP7_75t_R%A2 vss 28 10 16 26 4
c1 1 vss 0.0174175f $X=0.081 $Y=0.1345
c2 3 vss 0.161221f $X=0.081 $Y=0.0245
c3 4 vss 0.125869f $X=0.135 $Y=0.1345
c4 5 vss 0.00730026f $X=0.081 $Y=0.036
c5 6 vss 0.00373543f $X=0.0625 $Y=0.162
c6 7 vss 0.00463256f $X=0.081 $Y=0.135
c7 8 vss 0.0055138f $X=0.081 $Y=0.0855
c8 9 vss 0.00347894f $X=0.0965 $Y=0.135
r1 5 8 10.3626 $w=1.39091e-08 $l=4.95e-08 $layer=M1 $thickness=3.6e-08 $X=0.081
+ $Y=0.036 $X2=0.081 $Y2=0.0855
r2 6 33 3.1337 $w=1.54324e-08 $l=1.85e-08 $layer=M1 $thickness=3.6e-08
+ $X=0.0625 $Y=0.162 $X2=0.081 $Y2=0.162
r3 32 33 1.96775 $w=1.63333e-08 $l=1.35e-08 $layer=M1 $thickness=3.6e-08
+ $X=0.081 $Y=0.1485 $X2=0.081 $Y2=0.162
r4 7 9 2.43413 $w=1.59032e-08 $l=1.55e-08 $layer=M1 $thickness=3.6e-08 $X=0.081
+ $Y=0.135 $X2=0.0965 $Y2=0.135
r5 7 32 1.96775 $w=1.63333e-08 $l=1.35e-08 $layer=M1 $thickness=3.6e-08
+ $X=0.081 $Y=0.135 $X2=0.081 $Y2=0.1485
r6 7 8 10.3626 $w=1.39091e-08 $l=4.95e-08 $layer=M1 $thickness=3.6e-08 $X=0.081
+ $Y=0.135 $X2=0.081 $Y2=0.0855
r7 29 30 4.6638 $w=1.3e-08 $l=2e-08 $layer=M1 $thickness=3.6e-08 $X=0.115
+ $Y=0.135 $X2=0.135 $Y2=0.135
r8 28 29 2.68168 $w=1.3e-08 $l=1.15e-08 $layer=M1 $thickness=3.6e-08 $X=0.1035
+ $Y=0.1365 $X2=0.115 $Y2=0.135
r9 28 9 1.63233 $w=1.3e-08 $l=7e-09 $layer=M1 $thickness=3.6e-08 $X=0.1035
+ $Y=0.1365 $X2=0.0965 $Y2=0.135
r10 26 25 16.5817 $w=2.1e-08 $l=4.88e-08 $layer=Gate_1 $thickness=5.6e-08
+ $X=0.135 $Y=0.2025 $X2=0.135 $Y2=0.1537
r11 4 21 6.27904 $w=2.09e-08 $layer=Gate_1 $thickness=5.24e-08 $X=0.135
+ $Y=0.1345 $X2=0.135 $Y2=0.1345
r12 4 25 6.73473 $w=2.04286e-08 $l=1.92e-08 $layer=Gate_1 $thickness=5.6e-08
+ $X=0.135 $Y=0.1345 $X2=0.135 $Y2=0.1537
r13 21 30 19.3796 $a=3.24e-16 $layer=V0LIG $X=0.135 $Y=0.1345 $X2=0.135
+ $Y2=0.135
r14 20 21 2.48102 $w=2.2e-08 $l=9.5e-09 $layer=LIG $thickness=4.8e-08 $X=0.1255
+ $Y=0.1345 $X2=0.135 $Y2=0.1345
r15 19 20 10.1729 $w=1.54914e-08 $l=1.75e-08 $layer=LIG $thickness=4.8e-08
+ $X=0.108 $Y=0.1345 $X2=0.1255 $Y2=0.1345
r16 1 13 6.54019 $w=2.09524e-08 $layer=Gate_1 $thickness=5.21905e-08 $X=0.081
+ $Y=0.1345 $X2=0.081 $Y2=0.1345
r17 1 19 12.6539 $w=1.77815e-08 $l=2.7e-08 $layer=LIG $thickness=4.8e-08
+ $X=0.081 $Y=0.1345 $X2=0.108 $Y2=0.1345
r18 16 15 14.6259 $w=2.1e-08 $l=4.3e-08 $layer=Gate_1 $thickness=5.6e-08
+ $X=0.081 $Y=0.2025 $X2=0.081 $Y2=0.1595
r19 14 15 2.80614 $w=2.1e-08 $l=8.3e-09 $layer=Gate_1 $thickness=5.6e-08
+ $X=0.081 $Y=0.1512 $X2=0.081 $Y2=0.1595
r20 13 14 5.88439 $w=2.03433e-08 $l=1.67e-08 $layer=Gate_1 $thickness=5.6e-08
+ $X=0.081 $Y=0.1345 $X2=0.081 $Y2=0.1512
r21 12 13 5.71432 $w=2.03231e-08 $l=1.63e-08 $layer=Gate_1 $thickness=5.6e-08
+ $X=0.081 $Y=0.1182 $X2=0.081 $Y2=0.1345
r22 11 12 2.63607 $w=2.1e-08 $l=7.7e-09 $layer=Gate_1 $thickness=5.6e-08
+ $X=0.081 $Y=0.1105 $X2=0.081 $Y2=0.1182
r23 10 11 14.6259 $w=2.1e-08 $l=4.3e-08 $layer=Gate_1 $thickness=5.6e-08
+ $X=0.081 $Y=0.0675 $X2=0.081 $Y2=0.1105
r24 10 3 14.6259 $w=2.1e-08 $l=4.3e-08 $layer=Gate_1 $thickness=5.6e-08
+ $X=0.081 $Y=0.0675 $X2=0.081 $Y2=0.0245
.ends

.subckt PM_AOI221x1_ASAP7_75t_R%B2 vss 32 12 25 29 3 5
c1 1 vss 0.0187906f $X=0.3955 $Y=0.1345
c2 3 vss 0.125388f $X=0.405 $Y=0.0727
c3 4 vss 0.164481f $X=0.459 $Y=0.1345
c4 5 vss 0.00266058f $X=0.459 $Y=0.09
c5 6 vss 0.00390036f $X=0.459 $Y=0.135
c6 7 vss 0.00450729f $X=0.4775 $Y=0.162
c7 8 vss 0.00387849f $X=0.3935 $Y=0.135
c8 9 vss 0.00132079f $X=0.459 $Y=0.1125
r1 5 9 4.06646 $w=1.5e-08 $l=2.25e-08 $layer=M1 $thickness=3.6e-08 $X=0.459
+ $Y=0.09 $X2=0.459 $Y2=0.1125
r2 7 33 3.1337 $w=1.54324e-08 $l=1.85e-08 $layer=M1 $thickness=3.6e-08
+ $X=0.4775 $Y=0.162 $X2=0.459 $Y2=0.162
r3 32 33 1.03499 $w=1.77368e-08 $l=9.5e-09 $layer=M1 $thickness=3.6e-08
+ $X=0.458 $Y=0.1525 $X2=0.459 $Y2=0.162
r4 32 31 1.04935 $w=1.3e-08 $l=4.5e-09 $layer=M1 $thickness=3.6e-08 $X=0.458
+ $Y=0.1525 $X2=0.459 $Y2=0.148
r5 6 22 3.1337 $w=1.54324e-08 $l=1.85e-08 $layer=M1 $thickness=3.6e-08 $X=0.459
+ $Y=0.135 $X2=0.4405 $Y2=0.135
r6 6 31 1.85116 $w=1.64615e-08 $l=1.3e-08 $layer=M1 $thickness=3.6e-08 $X=0.459
+ $Y=0.135 $X2=0.459 $Y2=0.148
r7 6 9 4.06646 $w=1.5e-08 $l=2.25e-08 $layer=M1 $thickness=3.6e-08 $X=0.459
+ $Y=0.135 $X2=0.459 $Y2=0.1125
r8 29 28 14.6259 $w=2.1e-08 $l=4.3e-08 $layer=Gate_1 $thickness=5.6e-08
+ $X=0.459 $Y=0.2025 $X2=0.459 $Y2=0.1595
r9 27 28 2.80614 $w=2.1e-08 $l=8.3e-09 $layer=Gate_1 $thickness=5.6e-08
+ $X=0.459 $Y=0.1512 $X2=0.459 $Y2=0.1595
r10 25 26 14.6259 $w=2.1e-08 $l=4.3e-08 $layer=Gate_1 $thickness=5.6e-08
+ $X=0.459 $Y=0.0675 $X2=0.459 $Y2=0.1105
r11 23 26 2.63607 $w=2.1e-08 $l=7.7e-09 $layer=Gate_1 $thickness=5.6e-08
+ $X=0.459 $Y=0.1182 $X2=0.459 $Y2=0.1105
r12 4 18 6.54019 $w=2.09524e-08 $layer=Gate_1 $thickness=5.21905e-08 $X=0.459
+ $Y=0.1345 $X2=0.459 $Y2=0.1345
r13 4 23 5.71432 $w=2.03231e-08 $l=1.63e-08 $layer=Gate_1 $thickness=5.6e-08
+ $X=0.459 $Y=0.1345 $X2=0.459 $Y2=0.1182
r14 4 27 5.88439 $w=2.03433e-08 $l=1.67e-08 $layer=Gate_1 $thickness=5.6e-08
+ $X=0.459 $Y=0.1345 $X2=0.459 $Y2=0.1512
r15 21 22 4.19742 $w=1.3e-08 $l=1.8e-08 $layer=M1 $thickness=3.6e-08 $X=0.4225
+ $Y=0.135 $X2=0.4405 $Y2=0.135
r16 20 21 4.08082 $w=1.3e-08 $l=1.75e-08 $layer=M1 $thickness=3.6e-08 $X=0.405
+ $Y=0.135 $X2=0.4225 $Y2=0.135
r17 8 20 2.68168 $w=1.3e-08 $l=1.15e-08 $layer=M1 $thickness=3.6e-08 $X=0.3935
+ $Y=0.135 $X2=0.405 $Y2=0.135
r18 17 18 12.6539 $w=1.77815e-08 $l=2.7e-08 $layer=LIG $thickness=4.8e-08
+ $X=0.432 $Y=0.1345 $X2=0.459 $Y2=0.1345
r19 15 17 10.1729 $w=1.54914e-08 $l=1.75e-08 $layer=LIG $thickness=4.8e-08
+ $X=0.4145 $Y=0.1345 $X2=0.432 $Y2=0.1345
r20 14 15 2.48102 $w=2.2e-08 $l=9.5e-09 $layer=LIG $thickness=4.8e-08 $X=0.405
+ $Y=0.1345 $X2=0.4145 $Y2=0.1345
r21 14 20 19.3796 $a=3.24e-16 $layer=V0LIG $X=0.405 $Y=0.1345 $X2=0.405
+ $Y2=0.135
r22 1 14 2.48102 $w=2.2e-08 $l=9.5e-09 $layer=LIG $thickness=4.8e-08 $X=0.3955
+ $Y=0.1345 $X2=0.405 $Y2=0.1345
r23 12 11 16.5817 $w=2.1e-08 $l=4.88e-08 $layer=Gate_1 $thickness=5.6e-08
+ $X=0.405 $Y=0.2025 $X2=0.405 $Y2=0.1537
r24 10 11 6.73473 $w=2.04286e-08 $l=1.92e-08 $layer=Gate_1 $thickness=5.6e-08
+ $X=0.405 $Y=0.1345 $X2=0.405 $Y2=0.1537
r25 10 15 4.05918 $w=2.0087e-08 $l=9.5e-09 $layer=Gate_1 $thickness=5.56522e-08
+ $X=0.405 $Y=0.1345 $X2=0.4145 $Y2=0.1345
r26 10 14 6.27904 $w=2.09e-08 $layer=Gate_1 $thickness=5.24e-08 $X=0.405
+ $Y=0.1345 $X2=0.405 $Y2=0.1345
r27 3 10 21.1906 $w=2.08219e-08 $l=6.18e-08 $layer=Gate_1 $thickness=5.6e-08
+ $X=0.405 $Y=0.0727 $X2=0.405 $Y2=0.1345
.ends

.subckt PM_AOI221x1_ASAP7_75t_R%C vss 36 11 17 32 3 10 1 5 4
c1 1 vss 0.00892849f $X=0.6115 $Y=0.1345
c2 3 vss 0.0837216f $X=0.621 $Y=0.0245
c3 4 vss 0.0847803f $X=0.675 $Y=0.1345
c4 5 vss 0.00283363f $X=0.567 $Y=0.09
c5 6 vss 0.00788754f $X=0.5642 $Y=0.198
c6 7 vss 0.00092712f $X=0.567 $Y=0.135
c7 8 vss 0.00164569f $X=0.567 $Y=0.1125
c8 9 vss 0.00375889f $X=0.567 $Y=0.1485
c9 10 vss 0.00450725f $X=0.594 $Y=0.135
r1 38 39 0.280622 $w=1.8e-08 $l=2.7e-09 $layer=M1 $thickness=3.6e-08 $X=0.571
+ $Y=0.198 $X2=0.5737 $Y2=0.198
r2 6 38 0.6888 $w=1.8e-08 $l=6.8e-09 $layer=M1 $thickness=3.6e-08 $X=0.5642
+ $Y=0.198 $X2=0.571 $Y2=0.198
r3 36 6 0.754373 $w=1.76296e-08 $l=9.90404e-09 $layer=M1 $thickness=3.6e-08
+ $X=0.571 $Y=0.1885 $X2=0.5642 $Y2=0.198
r4 5 8 4.06646 $w=1.5e-08 $l=2.25e-08 $layer=M1 $thickness=3.6e-08 $X=0.567
+ $Y=0.09 $X2=0.567 $Y2=0.1125
r5 36 39 0.346195 $w=1.70909e-08 $l=1.1625e-08 $layer=M1 $thickness=3.6e-08
+ $X=0.571 $Y=0.1885 $X2=0.5737 $Y2=0.198
r6 36 35 2.09871 $w=1.3e-08 $l=9e-09 $layer=M1 $thickness=3.6e-08 $X=0.571
+ $Y=0.1885 $X2=0.567 $Y2=0.1795
r7 34 35 4.08082 $w=1.3e-08 $l=1.75e-08 $layer=M1 $thickness=3.6e-08 $X=0.567
+ $Y=0.162 $X2=0.567 $Y2=0.1795
r8 9 34 3.14806 $w=1.3e-08 $l=1.35e-08 $layer=M1 $thickness=3.6e-08 $X=0.567
+ $Y=0.1485 $X2=0.567 $Y2=0.162
r9 7 10 5.11582 $w=1.46667e-08 $l=2.7e-08 $layer=M1 $thickness=3.6e-08 $X=0.567
+ $Y=0.135 $X2=0.594 $Y2=0.135
r10 7 8 4.06646 $w=1.5e-08 $l=2.25e-08 $layer=M1 $thickness=3.6e-08 $X=0.567
+ $Y=0.135 $X2=0.567 $Y2=0.1125
r11 7 9 1.96775 $w=1.63333e-08 $l=1.35e-08 $layer=M1 $thickness=3.6e-08
+ $X=0.567 $Y=0.135 $X2=0.567 $Y2=0.1485
r12 32 31 14.6259 $w=2.1e-08 $l=4.3e-08 $layer=Gate_1 $thickness=5.6e-08
+ $X=0.675 $Y=0.2025 $X2=0.675 $Y2=0.1595
r13 30 31 2.80614 $w=2.1e-08 $l=8.3e-09 $layer=Gate_1 $thickness=5.6e-08
+ $X=0.675 $Y=0.1512 $X2=0.675 $Y2=0.1595
r14 4 23 6.54019 $w=2.09524e-08 $layer=Gate_1 $thickness=5.21905e-08 $X=0.675
+ $Y=0.1345 $X2=0.675 $Y2=0.1345
r15 4 30 5.88439 $w=2.03433e-08 $l=1.67e-08 $layer=Gate_1 $thickness=5.6e-08
+ $X=0.675 $Y=0.1345 $X2=0.675 $Y2=0.1512
r16 10 25 6.29612 $w=1.3e-08 $l=2.7e-08 $layer=M1 $thickness=3.6e-08 $X=0.594
+ $Y=0.135 $X2=0.621 $Y2=0.135
r17 22 23 12.6539 $w=1.77815e-08 $l=2.7e-08 $layer=LIG $thickness=4.8e-08
+ $X=0.648 $Y=0.1345 $X2=0.675 $Y2=0.1345
r18 20 22 10.1729 $w=1.54914e-08 $l=1.75e-08 $layer=LIG $thickness=4.8e-08
+ $X=0.6305 $Y=0.1345 $X2=0.648 $Y2=0.1345
r19 19 20 2.48102 $w=2.2e-08 $l=9.5e-09 $layer=LIG $thickness=4.8e-08 $X=0.621
+ $Y=0.1345 $X2=0.6305 $Y2=0.1345
r20 19 25 19.3796 $a=3.24e-16 $layer=V0LIG $X=0.621 $Y=0.1345 $X2=0.621
+ $Y2=0.135
r21 1 19 2.48102 $w=2.2e-08 $l=9.5e-09 $layer=LIG $thickness=4.8e-08 $X=0.6115
+ $Y=0.1345 $X2=0.621 $Y2=0.1345
r22 17 16 14.6259 $w=2.1e-08 $l=4.3e-08 $layer=Gate_1 $thickness=5.6e-08
+ $X=0.621 $Y=0.2025 $X2=0.621 $Y2=0.1595
r23 15 16 2.80614 $w=2.1e-08 $l=8.3e-09 $layer=Gate_1 $thickness=5.6e-08
+ $X=0.621 $Y=0.1512 $X2=0.621 $Y2=0.1595
r24 14 15 5.88439 $w=2.03433e-08 $l=1.67e-08 $layer=Gate_1 $thickness=5.6e-08
+ $X=0.621 $Y=0.1345 $X2=0.621 $Y2=0.1512
r25 14 20 4.05918 $w=2.0087e-08 $l=9.5e-09 $layer=Gate_1 $thickness=5.56522e-08
+ $X=0.621 $Y=0.1345 $X2=0.6305 $Y2=0.1345
r26 14 19 6.27904 $w=2.09e-08 $layer=Gate_1 $thickness=5.24e-08 $X=0.621
+ $Y=0.1345 $X2=0.621 $Y2=0.1345
r27 13 14 5.71432 $w=2.03231e-08 $l=1.63e-08 $layer=Gate_1 $thickness=5.6e-08
+ $X=0.621 $Y=0.1182 $X2=0.621 $Y2=0.1345
r28 12 13 7.22793 $w=2.1e-08 $l=2.12e-08 $layer=Gate_1 $thickness=5.6e-08
+ $X=0.621 $Y=0.097 $X2=0.621 $Y2=0.1182
r29 11 12 14.6259 $w=2.1e-08 $l=4.3e-08 $layer=Gate_1 $thickness=5.6e-08
+ $X=0.621 $Y=0.054 $X2=0.621 $Y2=0.097
r30 11 3 10.0341 $w=2.1e-08 $l=2.95e-08 $layer=Gate_1 $thickness=5.6e-08
+ $X=0.621 $Y=0.054 $X2=0.621 $Y2=0.0245
.ends

.subckt PM_AOI221x1_ASAP7_75t_R%Y vss 42 20 21 38 51 52 1 10 15 3 2 17 16 12 11
c1 1 vss 0.00896744f $X=0.27 $Y=0.0675
c2 2 vss 0.00655249f $X=0.594 $Y=0.054
c3 3 vss 0.00967338f $X=0.648 $Y=0.2025
c4 10 vss 0.00450194f $X=0.2555 $Y=0.0675
c5 11 vss 0.0273654f $X=0.596 $Y=0.054
c6 12 vss 0.00462507f $X=0.6335 $Y=0.2025
c7 13 vss 0.00210541f $X=0.729 $Y=0.054
c8 14 vss 0.00234411f $X=0.729 $Y=0.198
c9 15 vss 0.0315203f $X=0.2585 $Y=0.054
c10 16 vss 0.00798696f $X=0.718 $Y=0.198
c11 17 vss 0.00518791f $X=0.729 $Y=0.072
r1 52 50 0.0308642 $w=8.1e-08 $l=2.5e-09 $layer=P_src_drn $thickness=1e-09
+ $X=0.6653 $Y=0.2025 $X2=0.6625 $Y2=0.2025
r2 3 50 0.179012 $w=8.1e-08 $l=1.45e-08 $layer=P_src_drn $thickness=1e-09
+ $X=0.648 $Y=0.2025 $X2=0.6625 $Y2=0.2025
r3 12 3 0.179012 $w=8.1e-08 $l=1.45e-08 $layer=P_src_drn $thickness=1e-09
+ $X=0.6335 $Y=0.2025 $X2=0.648 $Y2=0.2025
r4 51 12 0.0308642 $w=8.1e-08 $l=2.5e-09 $layer=P_src_drn $thickness=1e-09
+ $X=0.6306 $Y=0.2025 $X2=0.6335 $Y2=0.2025
r5 3 46 19.3796 $a=3.24e-16 $layer=V0LISD $X=0.648 $Y=0.2025 $X2=0.648 $Y2=0.198
r6 46 47 8.97781 $w=1.3e-08 $l=3.85e-08 $layer=M1 $thickness=3.6e-08 $X=0.648
+ $Y=0.198 $X2=0.6865 $Y2=0.198
r7 16 47 7.34548 $w=1.3e-08 $l=3.15e-08 $layer=M1 $thickness=3.6e-08 $X=0.718
+ $Y=0.198 $X2=0.6865 $Y2=0.198
r8 14 44 5.69636 $w=1.58e-08 $l=3.15e-08 $layer=M1 $thickness=3.6e-08 $X=0.729
+ $Y=0.198 $X2=0.729 $Y2=0.1665
r9 14 16 0.915974 $w=1.70909e-08 $l=1.1e-08 $layer=M1 $thickness=3.6e-08
+ $X=0.729 $Y=0.198 $X2=0.718 $Y2=0.198
r10 43 44 6.41272 $w=1.3e-08 $l=2.75e-08 $layer=M1 $thickness=3.6e-08 $X=0.729
+ $Y=0.139 $X2=0.729 $Y2=0.1665
r11 42 43 1.28254 $w=1.3e-08 $l=5.5e-09 $layer=M1 $thickness=3.6e-08 $X=0.7305
+ $Y=0.1335 $X2=0.729 $Y2=0.139
r12 42 41 0.932759 $w=1.3e-08 $l=4e-09 $layer=M1 $thickness=3.6e-08 $X=0.7305
+ $Y=0.1335 $X2=0.729 $Y2=0.1295
r13 40 41 3.96423 $w=1.3e-08 $l=1.7e-08 $layer=M1 $thickness=3.6e-08 $X=0.729
+ $Y=0.1125 $X2=0.729 $Y2=0.1295
r14 39 40 5.24677 $w=1.3e-08 $l=2.25e-08 $layer=M1 $thickness=3.6e-08 $X=0.729
+ $Y=0.09 $X2=0.729 $Y2=0.1125
r15 17 39 4.19742 $w=1.3e-08 $l=1.8e-08 $layer=M1 $thickness=3.6e-08 $X=0.729
+ $Y=0.072 $X2=0.729 $Y2=0.09
r16 38 37 0.0462963 $w=5.4e-08 $l=2.5e-09 $layer=N_src_drn $thickness=1e-09
+ $X=0.6113 $Y=0.054 $X2=0.6085 $Y2=0.054
r17 11 37 0.231482 $w=5.4e-08 $l=1.25e-08 $layer=N_src_drn $thickness=1e-09
+ $X=0.596 $Y=0.054 $X2=0.6085 $Y2=0.054
r18 13 36 10.2436 $w=1.38824e-08 $l=5.1e-08 $layer=M1 $thickness=3.6e-08
+ $X=0.729 $Y=0.054 $X2=0.678 $Y2=0.054
r19 13 17 2.5483 $w=1.79e-08 $l=1.8e-08 $layer=M1 $thickness=3.6e-08 $X=0.729
+ $Y=0.054 $X2=0.729 $Y2=0.072
r20 2 34 19.3796 $a=3.24e-16 $layer=V0LISD $X=0.594 $Y=0.054 $X2=0.594 $Y2=0.054
r21 35 36 13.6416 $w=1.3e-08 $l=5.85e-08 $layer=M1 $thickness=3.6e-08 $X=0.6195
+ $Y=0.054 $X2=0.678 $Y2=0.054
r22 34 35 5.94634 $w=1.3e-08 $l=2.55e-08 $layer=M1 $thickness=3.6e-08 $X=0.594
+ $Y=0.054 $X2=0.6195 $Y2=0.054
r23 33 34 3.14806 $w=1.3e-08 $l=1.35e-08 $layer=M1 $thickness=3.6e-08 $X=0.5805
+ $Y=0.054 $X2=0.594 $Y2=0.054
r24 32 33 5.36336 $w=1.3e-08 $l=2.3e-08 $layer=M1 $thickness=3.6e-08 $X=0.5575
+ $Y=0.054 $X2=0.5805 $Y2=0.054
r25 31 32 8.86121 $w=1.3e-08 $l=3.8e-08 $layer=M1 $thickness=3.6e-08 $X=0.5195
+ $Y=0.054 $X2=0.5575 $Y2=0.054
r26 30 31 6.06293 $w=1.3e-08 $l=2.6e-08 $layer=M1 $thickness=3.6e-08 $X=0.4935
+ $Y=0.054 $X2=0.5195 $Y2=0.054
r27 29 30 3.73104 $w=1.3e-08 $l=1.6e-08 $layer=M1 $thickness=3.6e-08 $X=0.4775
+ $Y=0.054 $X2=0.4935 $Y2=0.054
r28 28 29 6.52931 $w=1.3e-08 $l=2.8e-08 $layer=M1 $thickness=3.6e-08 $X=0.4495
+ $Y=0.054 $X2=0.4775 $Y2=0.054
r29 27 28 8.97781 $w=1.3e-08 $l=3.85e-08 $layer=M1 $thickness=3.6e-08 $X=0.411
+ $Y=0.054 $X2=0.4495 $Y2=0.054
r30 26 27 12.3591 $w=1.3e-08 $l=5.3e-08 $layer=M1 $thickness=3.6e-08 $X=0.358
+ $Y=0.054 $X2=0.411 $Y2=0.054
r31 25 26 12.0093 $w=1.3e-08 $l=5.15e-08 $layer=M1 $thickness=3.6e-08 $X=0.3065
+ $Y=0.054 $X2=0.358 $Y2=0.054
r32 24 25 5.36336 $w=1.3e-08 $l=2.3e-08 $layer=M1 $thickness=3.6e-08 $X=0.2835
+ $Y=0.054 $X2=0.3065 $Y2=0.054
r33 23 24 2.2153 $w=1.3e-08 $l=9.5e-09 $layer=M1 $thickness=3.6e-08 $X=0.274
+ $Y=0.054 $X2=0.2835 $Y2=0.054
r34 22 23 2.09871 $w=1.3e-08 $l=9e-09 $layer=M1 $thickness=3.6e-08 $X=0.265
+ $Y=0.054 $X2=0.274 $Y2=0.054
r35 15 22 1.51573 $w=1.3e-08 $l=6.5e-09 $layer=M1 $thickness=3.6e-08 $X=0.2585
+ $Y=0.054 $X2=0.265 $Y2=0.054
r36 1 23 19.3796 $a=3.24e-16 $layer=V0LISD $X=0.27 $Y=0.0675 $X2=0.274 $Y2=0.054
r37 21 19 0.0308642 $w=8.1e-08 $l=2.5e-09 $layer=N_src_drn $thickness=1e-09
+ $X=0.2873 $Y=0.0675 $X2=0.2845 $Y2=0.0675
r38 1 19 0.179012 $w=8.1e-08 $l=1.45e-08 $layer=N_src_drn $thickness=1e-09
+ $X=0.27 $Y=0.0675 $X2=0.2845 $Y2=0.0675
r39 10 1 0.179012 $w=8.1e-08 $l=1.45e-08 $layer=N_src_drn $thickness=1e-09
+ $X=0.2555 $Y=0.0675 $X2=0.27 $Y2=0.0675
r40 20 10 0.0308642 $w=8.1e-08 $l=2.5e-09 $layer=N_src_drn $thickness=1e-09
+ $X=0.2526 $Y=0.0675 $X2=0.2555 $Y2=0.0675
r41 2 11 1e-05 $l=2e-09 $X=0.594 $Y=0.054 $X2=0.596 $Y2=0.054
.ends

.subckt PM_AOI221x1_ASAP7_75t_R%A1 vss 27 8 12 22 1 7 3 4
c1 1 vss 0.0162416f $X=0.243 $Y=0.1345
c2 3 vss 0.125982f $X=0.189 $Y=0.1345
c3 4 vss 0.122364f $X=0.243 $Y=0.0245
c4 5 vss 0.00762335f $X=0.189 $Y=0.036
c5 6 vss 0.00677091f $X=0.189 $Y=0.162
c6 7 vss 0.00614341f $X=0.189 $Y=0.1125
r1 6 30 1.96775 $w=1.63333e-08 $l=1.35e-08 $layer=M1 $thickness=3.6e-08
+ $X=0.189 $Y=0.162 $X2=0.189 $Y2=0.1485
r2 5 28 3.01711 $w=1.55e-08 $l=1.8e-08 $layer=M1 $thickness=3.6e-08 $X=0.189
+ $Y=0.036 $X2=0.189 $Y2=0.054
r3 29 30 3.14806 $w=1.3e-08 $l=1.35e-08 $layer=M1 $thickness=3.6e-08 $X=0.189
+ $Y=0.135 $X2=0.189 $Y2=0.1485
r4 27 26 2.09871 $w=1.3e-08 $l=9e-09 $layer=M1 $thickness=3.6e-08 $X=0.187
+ $Y=0.081 $X2=0.189 $Y2=0.0717
r5 26 28 4.13912 $w=1.3e-08 $l=1.77e-08 $layer=M1 $thickness=3.6e-08 $X=0.189
+ $Y=0.0717 $X2=0.189 $Y2=0.054
r6 24 25 2.09871 $w=1.3e-08 $l=9e-09 $layer=M1 $thickness=3.6e-08 $X=0.189
+ $Y=0.0812 $X2=0.189 $Y2=0.0902
r7 27 24 0.116595 $w=1.3e-08 $l=5e-10 $layer=M1 $thickness=3.6e-08 $X=0.187
+ $Y=0.081 $X2=0.189 $Y2=0.0812
r8 7 25 5.18847 $w=1.3e-08 $l=2.23e-08 $layer=M1 $thickness=3.6e-08 $X=0.189
+ $Y=0.1125 $X2=0.189 $Y2=0.0902
r9 7 29 5.24677 $w=1.3e-08 $l=2.25e-08 $layer=M1 $thickness=3.6e-08 $X=0.189
+ $Y=0.1125 $X2=0.189 $Y2=0.135
r10 22 21 16.5817 $w=2.1e-08 $l=4.88e-08 $layer=Gate_1 $thickness=5.6e-08
+ $X=0.189 $Y=0.2025 $X2=0.189 $Y2=0.1537
r11 3 16 6.27904 $w=2.09e-08 $layer=Gate_1 $thickness=5.24e-08 $X=0.189
+ $Y=0.1345 $X2=0.189 $Y2=0.1345
r12 3 21 6.73473 $w=2.04286e-08 $l=1.92e-08 $layer=Gate_1 $thickness=5.6e-08
+ $X=0.189 $Y=0.1345 $X2=0.189 $Y2=0.1537
r13 16 17 2.48102 $w=2.2e-08 $l=9.5e-09 $layer=LIG $thickness=4.8e-08 $X=0.189
+ $Y=0.1345 $X2=0.1985 $Y2=0.1345
r14 16 29 19.3796 $a=3.24e-16 $layer=V0LIG $X=0.189 $Y=0.1345 $X2=0.189
+ $Y2=0.135
r15 14 17 10.1729 $w=1.54914e-08 $l=1.75e-08 $layer=LIG $thickness=4.8e-08
+ $X=0.216 $Y=0.1345 $X2=0.1985 $Y2=0.1345
r16 1 10 6.54019 $w=2.09524e-08 $layer=Gate_1 $thickness=5.21905e-08 $X=0.243
+ $Y=0.1345 $X2=0.243 $Y2=0.1345
r17 1 14 12.6539 $w=1.77815e-08 $l=2.7e-08 $layer=LIG $thickness=4.8e-08
+ $X=0.243 $Y=0.1345 $X2=0.216 $Y2=0.1345
r18 12 11 16.5817 $w=2.1e-08 $l=4.88e-08 $layer=Gate_1 $thickness=5.6e-08
+ $X=0.243 $Y=0.2025 $X2=0.243 $Y2=0.1537
r19 10 11 6.73473 $w=2.04286e-08 $l=1.92e-08 $layer=Gate_1 $thickness=5.6e-08
+ $X=0.243 $Y=0.1345 $X2=0.243 $Y2=0.1537
r20 9 10 6.56467 $w=2.04133e-08 $l=1.88e-08 $layer=Gate_1 $thickness=5.6e-08
+ $X=0.243 $Y=0.1157 $X2=0.243 $Y2=0.1345
r21 8 9 16.4117 $w=2.1e-08 $l=4.82e-08 $layer=Gate_1 $thickness=5.6e-08
+ $X=0.243 $Y=0.0675 $X2=0.243 $Y2=0.1157
r22 8 4 14.6259 $w=2.1e-08 $l=4.3e-08 $layer=Gate_1 $thickness=5.6e-08 $X=0.243
+ $Y=0.0675 $X2=0.243 $Y2=0.0245
.ends

.subckt PM_AOI221x1_ASAP7_75t_R%B1 vss 24 10 19 22 3 4 1 6
c1 1 vss 0.0179275f $X=0.351 $Y=0.1345
c2 3 vss 0.122556f $X=0.297 $Y=0.1345
c3 4 vss 0.125769f $X=0.351 $Y=0.0727
c4 5 vss 0.00711206f $X=0.297 $Y=0.162
c5 6 vss 0.00292657f $X=0.297 $Y=0.09
c6 7 vss 0.0029253f $X=0.297 $Y=0.1075
r1 5 27 1.96775 $w=1.63333e-08 $l=1.35e-08 $layer=M1 $thickness=3.6e-08
+ $X=0.297 $Y=0.162 $X2=0.297 $Y2=0.1485
r2 6 7 2.90051 $w=1.55714e-08 $l=1.75e-08 $layer=M1 $thickness=3.6e-08 $X=0.297
+ $Y=0.09 $X2=0.297 $Y2=0.1075
r3 26 27 3.14806 $w=1.3e-08 $l=1.35e-08 $layer=M1 $thickness=3.6e-08 $X=0.297
+ $Y=0.135 $X2=0.297 $Y2=0.1485
r4 25 26 3.14806 $w=1.3e-08 $l=1.35e-08 $layer=M1 $thickness=3.6e-08 $X=0.297
+ $Y=0.1215 $X2=0.297 $Y2=0.135
r5 24 25 1.16595 $w=1.3e-08 $l=5e-09 $layer=M1 $thickness=3.6e-08 $X=0.2955
+ $Y=0.1165 $X2=0.297 $Y2=0.1215
r6 24 7 2.09871 $w=1.3e-08 $l=9e-09 $layer=M1 $thickness=3.6e-08 $X=0.2955
+ $Y=0.1165 $X2=0.297 $Y2=0.1075
r7 22 21 16.5817 $w=2.1e-08 $l=4.88e-08 $layer=Gate_1 $thickness=5.6e-08
+ $X=0.297 $Y=0.2025 $X2=0.297 $Y2=0.1537
r8 19 20 16.4117 $w=2.1e-08 $l=4.82e-08 $layer=Gate_1 $thickness=5.6e-08
+ $X=0.297 $Y=0.0675 $X2=0.297 $Y2=0.1157
r9 3 14 6.27904 $w=2.09e-08 $layer=Gate_1 $thickness=5.24e-08 $X=0.297
+ $Y=0.1345 $X2=0.297 $Y2=0.1345
r10 3 20 6.56467 $w=2.04133e-08 $l=1.88e-08 $layer=Gate_1 $thickness=5.6e-08
+ $X=0.297 $Y=0.1345 $X2=0.297 $Y2=0.1157
r11 3 21 6.73473 $w=2.04286e-08 $l=1.92e-08 $layer=Gate_1 $thickness=5.6e-08
+ $X=0.297 $Y=0.1345 $X2=0.297 $Y2=0.1537
r12 14 15 2.48102 $w=2.2e-08 $l=9.5e-09 $layer=LIG $thickness=4.8e-08 $X=0.297
+ $Y=0.1345 $X2=0.3065 $Y2=0.1345
r13 14 26 19.3796 $a=3.24e-16 $layer=V0LIG $X=0.297 $Y=0.1345 $X2=0.297
+ $Y2=0.135
r14 12 15 10.1729 $w=1.54914e-08 $l=1.75e-08 $layer=LIG $thickness=4.8e-08
+ $X=0.324 $Y=0.1345 $X2=0.3065 $Y2=0.1345
r15 1 8 6.54019 $w=2.09524e-08 $layer=Gate_1 $thickness=5.21905e-08 $X=0.351
+ $Y=0.1345 $X2=0.351 $Y2=0.1345
r16 1 12 12.6539 $w=1.77815e-08 $l=2.7e-08 $layer=LIG $thickness=4.8e-08
+ $X=0.351 $Y=0.1345 $X2=0.324 $Y2=0.1345
r17 10 9 16.5817 $w=2.1e-08 $l=4.88e-08 $layer=Gate_1 $thickness=5.6e-08
+ $X=0.351 $Y=0.2025 $X2=0.351 $Y2=0.1537
r18 8 9 6.73473 $w=2.04286e-08 $l=1.92e-08 $layer=Gate_1 $thickness=5.6e-08
+ $X=0.351 $Y=0.1345 $X2=0.351 $Y2=0.1537
r19 4 8 21.1906 $w=2.08219e-08 $l=6.18e-08 $layer=Gate_1 $thickness=5.6e-08
+ $X=0.351 $Y=0.0727 $X2=0.351 $Y2=0.1345
.ends

* End of included file AOI221x1_ASAP7_75t_R.pex.sp.pex

*
.subckt AOI221x1_ASAP7_75t_CUSTOM_4_25_0_7 VSS VDD A2 A1 B1 B2 C Y
*
* VSS VSS
* VDD VDD
* A2 A2
* A1 A1
* B1 B1
* B2 B2
* C C
* Y Y
*
*

M0 noxref_11 N_M0_g VSS VSS nmos_rvt L=2e-08 W=8.1e-08 nfin=3 $X=0.071 $Y=0.027
M1 N_M1_d N_M1_g noxref_11 VSS nmos_rvt L=2e-08 W=8.1e-08 nfin=3 $X=0.233
+ $Y=0.027
M2 noxref_12 N_M2_g N_M2_s VSS nmos_rvt L=2e-08 W=8.1e-08 nfin=3 $X=0.287
+ $Y=0.027
M3 VSS N_M3_g noxref_12 VSS nmos_rvt L=2e-08 W=8.1e-08 nfin=3 $X=0.449 $Y=0.027
M4 VSS N_M4_g N_M4_s VSS nmos_rvt L=2e-08 W=5.4e-08 nfin=2 $X=0.611 $Y=0.027
M5 VDD N_M5_g noxref_8 VDD pmos_rvt L=2e-08 W=8.1e-08 nfin=3 $X=0.071 $Y=0.162
M6 VDD N_M6_g noxref_8 VDD pmos_rvt L=2e-08 W=8.1e-08 nfin=3 $X=0.125 $Y=0.162
M7 VDD N_M7_g noxref_8 VDD pmos_rvt L=2e-08 W=8.1e-08 nfin=3 $X=0.179 $Y=0.162
M8 VDD N_M8_g noxref_8 VDD pmos_rvt L=2e-08 W=8.1e-08 nfin=3 $X=0.233 $Y=0.162
M9 noxref_9 N_M9_g noxref_8 VDD pmos_rvt L=2e-08 W=8.1e-08 nfin=3 $X=0.287
+ $Y=0.162
M10 noxref_9 N_M10_g noxref_8 VDD pmos_rvt L=2e-08 W=8.1e-08 nfin=3 $X=0.341
+ $Y=0.162
M11 noxref_9 N_M11_g noxref_8 VDD pmos_rvt L=2e-08 W=8.1e-08 nfin=3 $X=0.395
+ $Y=0.162
M12 noxref_9 N_M12_g noxref_8 VDD pmos_rvt L=2e-08 W=8.1e-08 nfin=3 $X=0.449
+ $Y=0.162
M13 N_M13_d N_M13_g noxref_9 VDD pmos_rvt L=2e-08 W=8.1e-08 nfin=3 $X=0.611
+ $Y=0.162
M14 N_M14_d N_M14_g noxref_9 VDD pmos_rvt L=2e-08 W=8.1e-08 nfin=3 $X=0.665
+ $Y=0.162

* .include "AOI221x1_ASAP7_75t_R.pex.sp.pxi"

* Start of included file AOI221x1_ASAP7_75t_R.pex.sp.pxi
x_PM_AOI221x1_ASAP7_75t_R%A2 vss A2 N_M0_g N_M5_g N_M6_g N_A2_4
+ PM_AOI221x1_ASAP7_75t_R%A2
x_PM_AOI221x1_ASAP7_75t_R%B2 vss B2 N_M11_g N_M3_g N_M12_g N_B2_3 N_B2_5
+ PM_AOI221x1_ASAP7_75t_R%B2
cc_1 N_B2_3 N_B1_4 0.0121639f $X=0.405 $Y=0.0727
x_PM_AOI221x1_ASAP7_75t_R%C vss C N_M4_g N_M13_g N_M14_g N_C_3 N_C_10 N_C_1
+ N_C_5 N_C_4 PM_AOI221x1_ASAP7_75t_R%C
x_PM_AOI221x1_ASAP7_75t_R%Y vss Y N_M1_d N_M2_s N_M4_s N_M13_d N_M14_d N_Y_1
+ N_Y_10 N_Y_15 N_Y_3 N_Y_2 N_Y_17 N_Y_16 N_Y_12 N_Y_11
+ PM_AOI221x1_ASAP7_75t_R%Y
cc_2 N_Y_1 N_A1_4 0.000757484f $X=0.27 $Y=0.0675
cc_3 N_Y_10 N_A1_1 0.000933582f $X=0.2555 $Y=0.0675
cc_4 N_Y_10 N_A1_4 0.035504f $X=0.2555 $Y=0.0675
cc_5 N_Y_1 N_B1_3 0.00109208f $X=0.27 $Y=0.0675
cc_6 N_Y_15 N_B1_1 0.00231101f $X=0.2585 $Y=0.054
cc_7 N_Y_15 N_B1_6 0.00241649f $X=0.2585 $Y=0.054
cc_8 N_Y_10 N_B1_3 0.0362062f $X=0.2555 $Y=0.0675
cc_9 N_Y_15 N_B2_5 0.00628603f $X=0.2585 $Y=0.054
cc_10 N_Y_3 N_C_3 0.00233331f $X=0.648 $Y=0.2025
cc_11 N_Y_2 N_C_3 0.000721293f $X=0.594 $Y=0.054
cc_12 N_Y_17 N_C_3 0.000867763f $X=0.729 $Y=0.072
cc_13 N_Y_16 N_C_10 0.00201055f $X=0.718 $Y=0.198
cc_14 N_Y_12 N_C_1 0.00328264f $X=0.6335 $Y=0.2025
cc_15 N_Y_11 N_C_3 0.0104924f $X=0.596 $Y=0.054
cc_16 N_Y_15 N_C_5 0.00568892f $X=0.2585 $Y=0.054
cc_17 N_Y_12 N_C_4 0.0292498f $X=0.6335 $Y=0.2025
cc_18 N_Y_12 N_C_3 0.0537631f $X=0.6335 $Y=0.2025
x_PM_AOI221x1_ASAP7_75t_R%A1 vss A1 N_M1_g N_M8_g N_M7_g N_A1_1 N_A1_7 N_A1_3
+ N_A1_4 PM_AOI221x1_ASAP7_75t_R%A1
cc_19 N_A1_1 N_A2_4 0.00142366f $X=0.243 $Y=0.1345
cc_20 N_A1_7 N_A2_4 0.00221422f $X=0.189 $Y=0.1125
cc_21 N_A1_3 N_A2_4 0.0124815f $X=0.189 $Y=0.1345
x_PM_AOI221x1_ASAP7_75t_R%B1 vss B1 N_M10_g N_M2_g N_M9_g N_B1_3 N_B1_4 N_B1_1
+ N_B1_6 PM_AOI221x1_ASAP7_75t_R%B1
cc_22 N_B1_3 N_A1_4 0.0062036f $X=0.297 $Y=0.1345

* End of included file AOI221x1_ASAP7_75t_R.pex.sp.pxi
.ends

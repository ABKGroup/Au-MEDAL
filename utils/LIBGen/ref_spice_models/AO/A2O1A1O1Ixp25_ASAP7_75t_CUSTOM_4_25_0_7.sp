.subckt PM_A2O1A1O1Ixp25_ASAP7_75t_R%A1 vss 13 5 9 4 3
c1 1 vss 0.00619449f $X=0.135 $Y=0.135
c2 3 vss 0.140049f $X=0.135 $Y=0.0245
c3 4 vss 0.0103879f $X=0.135 $Y=0.098
r1 13 12 5.18847 $w=1.3e-08 $l=2.23e-08 $layer=M1 $thickness=3.6e-08 $X=0.136
+ $Y=0.188 $X2=0.135 $Y2=0.1657
r2 11 12 7.17059 $w=1.3e-08 $l=3.07e-08 $layer=M1 $thickness=3.6e-08 $X=0.135
+ $Y=0.135 $X2=0.135 $Y2=0.1657
r3 4 11 8.62802 $w=1.3e-08 $l=3.7e-08 $layer=M1 $thickness=3.6e-08 $X=0.135
+ $Y=0.098 $X2=0.135 $Y2=0.135
r4 1 7 10.4265 $w=1.765e-08 $layer=LIG $thickness=5.2e-08 $X=0.135 $Y=0.135
+ $X2=0.135 $Y2=0.135
r5 1 11 19.3796 $a=3.24e-16 $layer=V0LIG $X=0.135 $Y=0.135 $X2=0.135 $Y2=0.135
r6 9 8 16.4967 $w=2.1e-08 $l=4.85e-08 $layer=Gate_1 $thickness=5.6e-08 $X=0.135
+ $Y=0.2025 $X2=0.135 $Y2=0.154
r7 7 8 6.6497 $w=2.04211e-08 $l=1.9e-08 $layer=Gate_1 $thickness=5.6e-08
+ $X=0.135 $Y=0.135 $X2=0.135 $Y2=0.154
r8 6 7 6.6497 $w=2.04211e-08 $l=1.9e-08 $layer=Gate_1 $thickness=5.6e-08
+ $X=0.135 $Y=0.116 $X2=0.135 $Y2=0.135
r9 5 6 16.4967 $w=2.1e-08 $l=4.85e-08 $layer=Gate_1 $thickness=5.6e-08 $X=0.135
+ $Y=0.0675 $X2=0.135 $Y2=0.116
r10 5 3 14.6259 $w=2.1e-08 $l=4.3e-08 $layer=Gate_1 $thickness=5.6e-08 $X=0.135
+ $Y=0.0675 $X2=0.135 $Y2=0.0245
.ends

.subckt PM_A2O1A1O1Ixp25_ASAP7_75t_R%B vss 13 5 9 3 4
c1 1 vss 0.00689415f $X=0.189 $Y=0.135
c2 3 vss 0.157149f $X=0.189 $Y=0.0245
c3 4 vss 0.0103327f $X=0.189 $Y=0.098
r1 13 12 1.22425 $w=1.3e-08 $l=5.3e-09 $layer=M1 $thickness=3.6e-08 $X=0.185
+ $Y=0.154 $X2=0.189 $Y2=0.1487
r2 11 12 3.20636 $w=1.3e-08 $l=1.37e-08 $layer=M1 $thickness=3.6e-08 $X=0.189
+ $Y=0.135 $X2=0.189 $Y2=0.1487
r3 4 11 8.62802 $w=1.3e-08 $l=3.7e-08 $layer=M1 $thickness=3.6e-08 $X=0.189
+ $Y=0.098 $X2=0.189 $Y2=0.135
r4 1 7 10.4265 $w=1.765e-08 $layer=LIG $thickness=5.2e-08 $X=0.189 $Y=0.135
+ $X2=0.189 $Y2=0.135
r5 1 11 19.3796 $a=3.24e-16 $layer=V0LIG $X=0.189 $Y=0.135 $X2=0.189 $Y2=0.135
r6 9 8 16.4967 $w=2.1e-08 $l=4.85e-08 $layer=Gate_1 $thickness=5.6e-08 $X=0.189
+ $Y=0.2025 $X2=0.189 $Y2=0.154
r7 7 8 6.6497 $w=2.04211e-08 $l=1.9e-08 $layer=Gate_1 $thickness=5.6e-08
+ $X=0.189 $Y=0.135 $X2=0.189 $Y2=0.154
r8 6 7 6.6497 $w=2.04211e-08 $l=1.9e-08 $layer=Gate_1 $thickness=5.6e-08
+ $X=0.189 $Y=0.116 $X2=0.189 $Y2=0.135
r9 5 6 16.4967 $w=2.1e-08 $l=4.85e-08 $layer=Gate_1 $thickness=5.6e-08 $X=0.189
+ $Y=0.0675 $X2=0.189 $Y2=0.116
r10 5 3 14.6259 $w=2.1e-08 $l=4.3e-08 $layer=Gate_1 $thickness=5.6e-08 $X=0.189
+ $Y=0.0675 $X2=0.189 $Y2=0.0245
.ends

.subckt PM_A2O1A1O1Ixp25_ASAP7_75t_R%D vss 4 8 14 3 5 1
c1 1 vss 0.00493735f $X=0.405 $Y=0.135
c2 3 vss 0.0923423f $X=0.405 $Y=0.0245
c3 4 vss 0.00151406f $X=0.35 $Y=0.136
c4 5 vss 0.003077f $X=0.351 $Y=0.0985
c5 6 vss 0.00668028f $X=0.351 $Y=0.1725
c6 7 vss 0.00265786f $X=0.3915 $Y=0.136
r1 4 19 4.06646 $w=1.5e-08 $l=2.25e-08 $layer=M1 $thickness=3.6e-08 $X=0.35
+ $Y=0.136 $X2=0.3735 $Y2=0.136
r2 4 5 7.56431 $w=1.42e-08 $l=3.75e-08 $layer=M1 $thickness=3.6e-08 $X=0.35
+ $Y=0.136 $X2=0.351 $Y2=0.0985
r3 4 6 7.33112 $w=1.42329e-08 $l=3.65e-08 $layer=M1 $thickness=3.6e-08 $X=0.35
+ $Y=0.136 $X2=0.351 $Y2=0.1725
r4 7 18 3.14806 $w=1.3e-08 $l=1.35e-08 $layer=M1 $thickness=3.6e-08 $X=0.3915
+ $Y=0.136 $X2=0.405 $Y2=0.136
r5 7 19 4.19742 $w=1.3e-08 $l=1.8e-08 $layer=M1 $thickness=3.6e-08 $X=0.3915
+ $Y=0.136 $X2=0.3735 $Y2=0.136
r6 1 11 6.54019 $w=2.09524e-08 $layer=Gate_1 $thickness=5.21905e-08 $X=0.405
+ $Y=0.135 $X2=0.405 $Y2=0.135
r7 1 18 19.3796 $a=3.24e-16 $layer=V0LIG $X=0.405 $Y=0.135 $X2=0.405 $Y2=0.136
r8 14 13 14.6259 $w=2.1e-08 $l=4.3e-08 $layer=Gate_1 $thickness=5.6e-08
+ $X=0.405 $Y=0.2025 $X2=0.405 $Y2=0.1595
r9 12 13 2.7211 $w=2.1e-08 $l=8e-09 $layer=Gate_1 $thickness=5.6e-08 $X=0.405
+ $Y=0.1515 $X2=0.405 $Y2=0.1595
r10 11 12 5.79936 $w=2.03333e-08 $l=1.65e-08 $layer=Gate_1 $thickness=5.6e-08
+ $X=0.405 $Y=0.135 $X2=0.405 $Y2=0.1515
r11 10 11 5.79936 $w=2.03333e-08 $l=1.65e-08 $layer=Gate_1 $thickness=5.6e-08
+ $X=0.405 $Y=0.1185 $X2=0.405 $Y2=0.135
r12 9 10 2.7211 $w=2.1e-08 $l=8e-09 $layer=Gate_1 $thickness=5.6e-08 $X=0.405
+ $Y=0.1105 $X2=0.405 $Y2=0.1185
r13 8 9 14.6259 $w=2.1e-08 $l=4.3e-08 $layer=Gate_1 $thickness=5.6e-08 $X=0.405
+ $Y=0.0675 $X2=0.405 $Y2=0.1105
r14 8 3 14.6259 $w=2.1e-08 $l=4.3e-08 $layer=Gate_1 $thickness=5.6e-08 $X=0.405
+ $Y=0.0675 $X2=0.405 $Y2=0.0245
.ends

.subckt PM_A2O1A1O1Ixp25_ASAP7_75t_R%Y vss 26 18 28 37 10 16 2 15 12 11
c1 1 vss 0.00940297f $X=0.27 $Y=0.0675
c2 2 vss 0.00827406f $X=0.378 $Y=0.0675
c3 3 vss 0.00959517f $X=0.432 $Y=0.2025
c4 10 vss 0.0385935f $X=0.2555 $Y=0.0675
c5 11 vss 0.0385606f $X=0.38 $Y=0.0675
c6 12 vss 0.0386105f $X=0.4175 $Y=0.2025
c7 13 vss 0.00598457f $X=0.459 $Y=0.234
c8 14 vss 0.00310069f $X=0.459 $Y=0.0357
c9 15 vss 0.0175964f $X=0.27 $Y=0.036
c10 16 vss 0.00808367f $X=0.459 $Y=0.0452
r1 12 3 0.154321 $w=8.1e-08 $l=1.25e-08 $layer=P_src_drn $thickness=1e-09
+ $X=0.4175 $Y=0.2025 $X2=0.432 $Y2=0.2025
r2 37 12 0.0308642 $w=8.1e-08 $l=2.5e-09 $layer=P_src_drn $thickness=1e-09
+ $X=0.4146 $Y=0.2025 $X2=0.4175 $Y2=0.2025
r3 3 34 19.3796 $a=3.24e-16 $layer=V0LISD $X=0.432 $Y=0.2025 $X2=0.432 $Y2=0.234
r4 34 35 3.14806 $w=1.3e-08 $l=1.35e-08 $layer=M1 $thickness=3.6e-08 $X=0.432
+ $Y=0.234 $X2=0.4455 $Y2=0.234
r5 13 33 3.83327 $w=1.5093e-08 $l=2.15e-08 $layer=M1 $thickness=3.6e-08
+ $X=0.459 $Y=0.234 $X2=0.459 $Y2=0.2125
r6 13 35 1.96775 $w=1.63333e-08 $l=1.35e-08 $layer=M1 $thickness=3.6e-08
+ $X=0.459 $Y=0.234 $X2=0.4455 $Y2=0.234
r7 32 33 9.32759 $w=1.3e-08 $l=4e-08 $layer=M1 $thickness=3.6e-08 $X=0.459
+ $Y=0.1725 $X2=0.459 $Y2=0.2125
r8 31 32 8.51143 $w=1.3e-08 $l=3.65e-08 $layer=M1 $thickness=3.6e-08 $X=0.459
+ $Y=0.136 $X2=0.459 $Y2=0.1725
r9 30 31 8.74462 $w=1.3e-08 $l=3.75e-08 $layer=M1 $thickness=3.6e-08 $X=0.459
+ $Y=0.0985 $X2=0.459 $Y2=0.136
r10 29 30 9.50248 $w=1.3e-08 $l=4.08e-08 $layer=M1 $thickness=3.6e-08 $X=0.459
+ $Y=0.0577 $X2=0.459 $Y2=0.0985
r11 16 29 2.91487 $w=1.3e-08 $l=1.25e-08 $layer=M1 $thickness=3.6e-08 $X=0.459
+ $Y=0.0452 $X2=0.459 $Y2=0.0577
r12 26 16 0.0838085 $w=1.55e-08 $l=5e-10 $layer=M1 $thickness=3.6e-08 $X=0.46
+ $Y=0.045 $X2=0.459 $Y2=0.0452
r13 28 27 0.0308642 $w=8.1e-08 $l=2.5e-09 $layer=N_src_drn $thickness=1e-09
+ $X=0.3953 $Y=0.0675 $X2=0.3925 $Y2=0.0675
r14 11 27 0.154321 $w=8.1e-08 $l=1.25e-08 $layer=N_src_drn $thickness=1e-09
+ $X=0.38 $Y=0.0675 $X2=0.3925 $Y2=0.0675
r15 26 14 0.9184 $w=1.8e-08 $l=9e-09 $layer=M1 $thickness=3.6e-08 $X=0.46
+ $Y=0.045 $X2=0.459 $Y2=0.0357
r16 2 22 19.3796 $a=3.24e-16 $layer=V0LISD $X=0.378 $Y=0.0675 $X2=0.378
+ $Y2=0.036
r17 26 25 3.17357 $w=8e-09 $l=2.41234e-08 $layer=M1 $thickness=3.6e-08 $X=0.46
+ $Y=0.045 $X2=0.4365 $Y2=0.036
r18 24 25 4.19742 $w=1.3e-08 $l=1.8e-08 $layer=M1 $thickness=3.6e-08 $X=0.4185
+ $Y=0.036 $X2=0.4365 $Y2=0.036
r19 23 24 4.19742 $w=1.3e-08 $l=1.8e-08 $layer=M1 $thickness=3.6e-08 $X=0.4005
+ $Y=0.036 $X2=0.4185 $Y2=0.036
r20 22 23 5.24677 $w=1.3e-08 $l=2.25e-08 $layer=M1 $thickness=3.6e-08 $X=0.378
+ $Y=0.036 $X2=0.4005 $Y2=0.036
r21 21 22 3.14806 $w=1.3e-08 $l=1.35e-08 $layer=M1 $thickness=3.6e-08 $X=0.3645
+ $Y=0.036 $X2=0.378 $Y2=0.036
r22 20 21 3.14806 $w=1.3e-08 $l=1.35e-08 $layer=M1 $thickness=3.6e-08 $X=0.351
+ $Y=0.036 $X2=0.3645 $Y2=0.036
r23 19 20 9.44419 $w=1.3e-08 $l=4.05e-08 $layer=M1 $thickness=3.6e-08 $X=0.3105
+ $Y=0.036 $X2=0.351 $Y2=0.036
r24 15 19 9.44419 $w=1.3e-08 $l=4.05e-08 $layer=M1 $thickness=3.6e-08 $X=0.27
+ $Y=0.036 $X2=0.3105 $Y2=0.036
r25 1 15 19.3796 $a=3.24e-16 $layer=V0LISD $X=0.27 $Y=0.0675 $X2=0.27 $Y2=0.036
r26 10 1 0.154321 $w=8.1e-08 $l=1.25e-08 $layer=N_src_drn $thickness=1e-09
+ $X=0.2555 $Y=0.0675 $X2=0.27 $Y2=0.0675
r27 18 10 0.0308642 $w=8.1e-08 $l=2.5e-09 $layer=N_src_drn $thickness=1e-09
+ $X=0.2526 $Y=0.0675 $X2=0.2555 $Y2=0.0675
r28 2 11 1e-05 $l=2e-09 $X=0.378 $Y=0.0675 $X2=0.38 $Y2=0.0675
.ends

.subckt PM_A2O1A1O1Ixp25_ASAP7_75t_R%A2 vss 13 5 11 3
c1 1 vss 0.00751168f $X=0.081 $Y=0.135
c2 3 vss 0.142429f $X=0.081 $Y=0.0245
c3 4 vss 0.0133711f $X=0.081 $Y=0.0757
r1 14 15 7.17059 $w=1.3e-08 $l=3.08e-08 $layer=M1 $thickness=3.6e-08 $X=0.081
+ $Y=0.1042 $X2=0.081 $Y2=0.135
r2 13 14 5.18847 $w=1.3e-08 $l=2.22e-08 $layer=M1 $thickness=3.6e-08 $X=0.081
+ $Y=0.082 $X2=0.081 $Y2=0.1042
r3 13 4 1.45744 $w=1.3e-08 $l=6.3e-09 $layer=M1 $thickness=3.6e-08 $X=0.081
+ $Y=0.082 $X2=0.081 $Y2=0.0757
r4 1 8 10.4265 $w=1.765e-08 $layer=LIG $thickness=5.2e-08 $X=0.081 $Y=0.135
+ $X2=0.081 $Y2=0.135
r5 1 15 19.3796 $a=3.24e-16 $layer=V0LIG $X=0.081 $Y=0.135 $X2=0.081 $Y2=0.135
r6 11 10 14.6259 $w=2.1e-08 $l=4.3e-08 $layer=Gate_1 $thickness=5.6e-08
+ $X=0.081 $Y=0.2025 $X2=0.081 $Y2=0.1595
r7 9 10 2.7211 $w=2.1e-08 $l=8e-09 $layer=Gate_1 $thickness=5.6e-08 $X=0.081
+ $Y=0.1515 $X2=0.081 $Y2=0.1595
r8 8 9 5.79936 $w=2.03333e-08 $l=1.65e-08 $layer=Gate_1 $thickness=5.6e-08
+ $X=0.081 $Y=0.135 $X2=0.081 $Y2=0.1515
r9 7 8 5.79936 $w=2.03333e-08 $l=1.65e-08 $layer=Gate_1 $thickness=5.6e-08
+ $X=0.081 $Y=0.1185 $X2=0.081 $Y2=0.135
r10 6 7 2.7211 $w=2.1e-08 $l=8e-09 $layer=Gate_1 $thickness=5.6e-08 $X=0.081
+ $Y=0.1105 $X2=0.081 $Y2=0.1185
r11 5 6 14.6259 $w=2.1e-08 $l=4.3e-08 $layer=Gate_1 $thickness=5.6e-08 $X=0.081
+ $Y=0.0675 $X2=0.081 $Y2=0.1105
r12 5 3 14.6259 $w=2.1e-08 $l=4.3e-08 $layer=Gate_1 $thickness=5.6e-08 $X=0.081
+ $Y=0.0675 $X2=0.081 $Y2=0.0245
.ends

.subckt PM_A2O1A1O1Ixp25_ASAP7_75t_R%C vss 13 5 11 3 4
c1 1 vss 0.00627627f $X=0.243 $Y=0.135
c2 3 vss 0.12373f $X=0.243 $Y=0.0245
c3 4 vss 0.012146f $X=0.243 $Y=0.0942
r1 14 15 2.85657 $w=1.3e-08 $l=1.23e-08 $layer=M1 $thickness=3.6e-08 $X=0.243
+ $Y=0.1227 $X2=0.243 $Y2=0.135
r2 13 14 0.874462 $w=1.3e-08 $l=3.7e-09 $layer=M1 $thickness=3.6e-08 $X=0.242
+ $Y=0.119 $X2=0.243 $Y2=0.1227
r3 13 4 5.77145 $w=1.3e-08 $l=2.48e-08 $layer=M1 $thickness=3.6e-08 $X=0.242
+ $Y=0.119 $X2=0.243 $Y2=0.0942
r4 1 8 10.4265 $w=1.765e-08 $layer=LIG $thickness=5.2e-08 $X=0.243 $Y=0.135
+ $X2=0.243 $Y2=0.135
r5 1 15 19.3796 $a=3.24e-16 $layer=V0LIG $X=0.243 $Y=0.135 $X2=0.243 $Y2=0.135
r6 11 10 14.6259 $w=2.1e-08 $l=4.3e-08 $layer=Gate_1 $thickness=5.6e-08
+ $X=0.243 $Y=0.2025 $X2=0.243 $Y2=0.1595
r7 9 10 2.7211 $w=2.1e-08 $l=8e-09 $layer=Gate_1 $thickness=5.6e-08 $X=0.243
+ $Y=0.1515 $X2=0.243 $Y2=0.1595
r8 8 9 5.79936 $w=2.03333e-08 $l=1.65e-08 $layer=Gate_1 $thickness=5.6e-08
+ $X=0.243 $Y=0.135 $X2=0.243 $Y2=0.1515
r9 7 8 5.79936 $w=2.03333e-08 $l=1.65e-08 $layer=Gate_1 $thickness=5.6e-08
+ $X=0.243 $Y=0.1185 $X2=0.243 $Y2=0.135
r10 6 7 2.7211 $w=2.1e-08 $l=8e-09 $layer=Gate_1 $thickness=5.6e-08 $X=0.243
+ $Y=0.1105 $X2=0.243 $Y2=0.1185
r11 5 6 14.6259 $w=2.1e-08 $l=4.3e-08 $layer=Gate_1 $thickness=5.6e-08 $X=0.243
+ $Y=0.0675 $X2=0.243 $Y2=0.1105
r12 5 3 14.6259 $w=2.1e-08 $l=4.3e-08 $layer=Gate_1 $thickness=5.6e-08 $X=0.243
+ $Y=0.0675 $X2=0.243 $Y2=0.0245
.ends

* End of included file A2O1A1O1Ixp25_ASAP7_75t_R.pex.sp.pex

*
.subckt A2O1A1O1Ixp25_ASAP7_75t_CUSTOM_4_25_0_7 VSS VDD A2 A1 B C D Y
*
* VSS VSS
* VDD VDD
* A2 A2
* A1 A1
* B B
* C C
* D D
* Y Y
*
*

M0 noxref_12 N_M0_g noxref_8 VSS nmos_rvt L=2e-08 W=8.1e-08 nfin=3 $X=0.071
+ $Y=0.027
M1 VSS N_M1_g noxref_12 VSS nmos_rvt L=2e-08 W=8.1e-08 nfin=3 $X=0.125 $Y=0.027
M2 noxref_8 N_M2_g VSS VSS nmos_rvt L=2e-08 W=8.1e-08 nfin=3 $X=0.179 $Y=0.027
M3 N_M3_d N_M3_g noxref_8 VSS nmos_rvt L=2e-08 W=8.1e-08 nfin=3 $X=0.233
+ $Y=0.027
M4 VSS N_M4_g N_M4_s VSS nmos_rvt L=2e-08 W=8.1e-08 nfin=3 $X=0.395 $Y=0.027
M5 VDD N_M5_g noxref_9 VDD pmos_rvt L=2e-08 W=8.1e-08 nfin=3 $X=0.071 $Y=0.162
M6 noxref_9 N_M6_g VDD VDD pmos_rvt L=2e-08 W=8.1e-08 nfin=3 $X=0.125 $Y=0.162
M7 noxref_10 N_M7_g noxref_9 VDD pmos_rvt L=2e-08 W=8.1e-08 nfin=3 $X=0.179
+ $Y=0.162
M8 VDD N_M8_g noxref_10 VDD pmos_rvt L=2e-08 W=8.1e-08 nfin=3 $X=0.233 $Y=0.162
M9 N_M9_d N_M9_g noxref_10 VDD pmos_rvt L=2e-08 W=8.1e-08 nfin=3 $X=0.395
+ $Y=0.162

* .include "A2O1A1O1Ixp25_ASAP7_75t_R.pex.sp.pxi"

* Start of included file A2O1A1O1Ixp25_ASAP7_75t_R.pex.sp.pxi
x_PM_A2O1A1O1Ixp25_ASAP7_75t_R%A1 vss A1 N_M1_g N_M6_g N_A1_4 N_A1_3
+ PM_A2O1A1O1Ixp25_ASAP7_75t_R%A1
cc_1 N_A1_4 N_A2_3 0.00462981f $X=0.135 $Y=0.098
cc_2 N_A1_3 N_A2_3 0.00703399f $X=0.135 $Y=0.0245
x_PM_A2O1A1O1Ixp25_ASAP7_75t_R%B vss B N_M2_g N_M7_g N_B_3 N_B_4
+ PM_A2O1A1O1Ixp25_ASAP7_75t_R%B
cc_3 N_B_3 N_A1_3 0.00316687f $X=0.189 $Y=0.0245
cc_4 N_B_4 N_A1_4 0.0062617f $X=0.189 $Y=0.098
x_PM_A2O1A1O1Ixp25_ASAP7_75t_R%D vss D N_M4_g N_M9_g N_D_3 N_D_5 N_D_1
+ PM_A2O1A1O1Ixp25_ASAP7_75t_R%D
x_PM_A2O1A1O1Ixp25_ASAP7_75t_R%Y vss Y N_M3_d N_M4_s N_M9_d N_Y_10 N_Y_16 N_Y_2
+ N_Y_15 N_Y_12 N_Y_11 PM_A2O1A1O1Ixp25_ASAP7_75t_R%Y
cc_5 N_Y_10 N_C_4 0.00149718f $X=0.2555 $Y=0.0675
cc_6 N_Y_10 N_C_3 0.0380581f $X=0.2555 $Y=0.0675
cc_7 N_Y_16 N_D_3 0.00151745f $X=0.459 $Y=0.0452
cc_8 N_Y_2 N_D_3 0.00163715f $X=0.378 $Y=0.0675
cc_9 N_Y_15 N_D_5 0.00164155f $X=0.27 $Y=0.036
cc_10 N_Y_12 N_D_1 0.00174214f $X=0.4175 $Y=0.2025
cc_11 N_Y_2 N_D_5 0.00244685f $X=0.378 $Y=0.0675
cc_12 N_Y_11 N_D_3 0.0149815f $X=0.38 $Y=0.0675
cc_13 N_Y_12 N_D_3 0.0589661f $X=0.4175 $Y=0.2025
x_PM_A2O1A1O1Ixp25_ASAP7_75t_R%A2 vss A2 N_M0_g N_M5_g N_A2_3
+ PM_A2O1A1O1Ixp25_ASAP7_75t_R%A2
x_PM_A2O1A1O1Ixp25_ASAP7_75t_R%C vss C N_M3_g N_M8_g N_C_3 N_C_4
+ PM_A2O1A1O1Ixp25_ASAP7_75t_R%C
cc_14 N_C_3 N_B_3 0.00333387f $X=0.243 $Y=0.0245
cc_15 N_C_4 N_B_4 0.00634065f $X=0.243 $Y=0.0942

* End of included file A2O1A1O1Ixp25_ASAP7_75t_R.pex.sp.pxi
.ends

.subckt PM_AO33x2_ASAP7_75t_R%A1 vss 11 5 9 3 4
c1 1 vss 0.00712966f $X=0.297 $Y=0.135
c2 3 vss 0.0974787f $X=0.297 $Y=0.0245
c3 4 vss 0.00743067f $X=0.297 $Y=0.0927
r1 12 13 3.20636 $w=1.3e-08 $l=1.38e-08 $layer=M1 $thickness=3.6e-08 $X=0.297
+ $Y=0.1212 $X2=0.297 $Y2=0.135
r2 11 12 1.22425 $w=1.3e-08 $l=5.2e-09 $layer=M1 $thickness=3.6e-08 $X=0.2995
+ $Y=0.116 $X2=0.297 $Y2=0.1212
r3 11 4 5.42166 $w=1.3e-08 $l=2.33e-08 $layer=M1 $thickness=3.6e-08 $X=0.2995
+ $Y=0.116 $X2=0.297 $Y2=0.0927
r4 1 7 10.4265 $w=1.765e-08 $layer=LIG $thickness=5.2e-08 $X=0.297 $Y=0.135
+ $X2=0.297 $Y2=0.135
r5 1 13 19.3796 $a=3.24e-16 $layer=V0LIG $X=0.297 $Y=0.135 $X2=0.297 $Y2=0.135
r6 9 8 16.4967 $w=2.1e-08 $l=4.85e-08 $layer=Gate_1 $thickness=5.6e-08 $X=0.297
+ $Y=0.216 $X2=0.297 $Y2=0.1675
r7 7 8 11.2416 $w=2.06615e-08 $l=3.25e-08 $layer=Gate_1 $thickness=5.6e-08
+ $X=0.297 $Y=0.135 $X2=0.297 $Y2=0.1675
r8 6 7 6.6497 $w=2.04211e-08 $l=1.9e-08 $layer=Gate_1 $thickness=5.6e-08
+ $X=0.297 $Y=0.116 $X2=0.297 $Y2=0.135
r9 5 6 16.4967 $w=2.1e-08 $l=4.85e-08 $layer=Gate_1 $thickness=5.6e-08 $X=0.297
+ $Y=0.0675 $X2=0.297 $Y2=0.116
r10 5 3 14.6259 $w=2.1e-08 $l=4.3e-08 $layer=Gate_1 $thickness=5.6e-08 $X=0.297
+ $Y=0.0675 $X2=0.297 $Y2=0.0245
.ends

.subckt PM_AO33x2_ASAP7_75t_R%B1 vss 11 5 9 3 4 1
c1 1 vss 0.00676811f $X=0.351 $Y=0.135
c2 3 vss 0.0636735f $X=0.351 $Y=0.0245
c3 4 vss 0.00386076f $X=0.351 $Y=0.0745
r1 12 13 7.46207 $w=1.3e-08 $l=3.2e-08 $layer=M1 $thickness=3.6e-08 $X=0.351
+ $Y=0.103 $X2=0.351 $Y2=0.135
r2 11 12 5.47996 $w=1.3e-08 $l=2.35e-08 $layer=M1 $thickness=3.6e-08 $X=0.3505
+ $Y=0.0795 $X2=0.351 $Y2=0.103
r3 11 4 1.16595 $w=1.3e-08 $l=5e-09 $layer=M1 $thickness=3.6e-08 $X=0.3505
+ $Y=0.0795 $X2=0.351 $Y2=0.0745
r4 1 7 10.4265 $w=1.765e-08 $layer=LIG $thickness=5.2e-08 $X=0.351 $Y=0.135
+ $X2=0.351 $Y2=0.135
r5 1 13 19.3796 $a=3.24e-16 $layer=V0LIG $X=0.351 $Y=0.135 $X2=0.351 $Y2=0.135
r6 9 8 16.4967 $w=2.1e-08 $l=4.85e-08 $layer=Gate_1 $thickness=5.6e-08 $X=0.351
+ $Y=0.216 $X2=0.351 $Y2=0.1675
r7 7 8 11.2416 $w=2.06615e-08 $l=3.25e-08 $layer=Gate_1 $thickness=5.6e-08
+ $X=0.351 $Y=0.135 $X2=0.351 $Y2=0.1675
r8 6 7 6.6497 $w=2.04211e-08 $l=1.9e-08 $layer=Gate_1 $thickness=5.6e-08
+ $X=0.351 $Y=0.116 $X2=0.351 $Y2=0.135
r9 5 6 16.4967 $w=2.1e-08 $l=4.85e-08 $layer=Gate_1 $thickness=5.6e-08 $X=0.351
+ $Y=0.0675 $X2=0.351 $Y2=0.116
r10 5 3 14.6259 $w=2.1e-08 $l=4.3e-08 $layer=Gate_1 $thickness=5.6e-08 $X=0.351
+ $Y=0.0675 $X2=0.351 $Y2=0.0245
.ends

.subckt PM_AO33x2_ASAP7_75t_R%B3 vss 15 5 11 3 4
c1 1 vss 0.00456625f $X=0.459 $Y=0.135
c2 3 vss 0.105725f $X=0.459 $Y=0.0245
c3 4 vss 0.00468059f $X=0.459 $Y=0.098
r1 15 14 0.349785 $w=1.3e-08 $l=1.5e-09 $layer=M1 $thickness=3.6e-08 $X=0.459
+ $Y=0.1465 $X2=0.459 $Y2=0.145
r2 13 14 2.3319 $w=1.3e-08 $l=1e-08 $layer=M1 $thickness=3.6e-08 $X=0.459
+ $Y=0.135 $X2=0.459 $Y2=0.145
r3 4 13 8.62802 $w=1.3e-08 $l=3.7e-08 $layer=M1 $thickness=3.6e-08 $X=0.459
+ $Y=0.098 $X2=0.459 $Y2=0.135
r4 1 8 10.4265 $w=1.765e-08 $layer=LIG $thickness=5.2e-08 $X=0.459 $Y=0.135
+ $X2=0.459 $Y2=0.135
r5 1 13 19.3796 $a=3.24e-16 $layer=V0LIG $X=0.459 $Y=0.135 $X2=0.459 $Y2=0.135
r6 11 10 14.6259 $w=2.1e-08 $l=4.3e-08 $layer=Gate_1 $thickness=5.6e-08
+ $X=0.459 $Y=0.216 $X2=0.459 $Y2=0.173
r7 9 10 7.31297 $w=2.1e-08 $l=2.15e-08 $layer=Gate_1 $thickness=5.6e-08
+ $X=0.459 $Y=0.1515 $X2=0.459 $Y2=0.173
r8 8 9 5.79936 $w=2.03333e-08 $l=1.65e-08 $layer=Gate_1 $thickness=5.6e-08
+ $X=0.459 $Y=0.135 $X2=0.459 $Y2=0.1515
r9 7 8 5.79936 $w=2.03333e-08 $l=1.65e-08 $layer=Gate_1 $thickness=5.6e-08
+ $X=0.459 $Y=0.1185 $X2=0.459 $Y2=0.135
r10 6 7 2.7211 $w=2.1e-08 $l=8e-09 $layer=Gate_1 $thickness=5.6e-08 $X=0.459
+ $Y=0.1105 $X2=0.459 $Y2=0.1185
r11 5 6 14.6259 $w=2.1e-08 $l=4.3e-08 $layer=Gate_1 $thickness=5.6e-08 $X=0.459
+ $Y=0.0675 $X2=0.459 $Y2=0.1105
r12 5 3 14.6259 $w=2.1e-08 $l=4.3e-08 $layer=Gate_1 $thickness=5.6e-08 $X=0.459
+ $Y=0.0675 $X2=0.459 $Y2=0.0245
.ends

.subckt PM_AO33x2_ASAP7_75t_R%Y vss 25 17 18 33 34 8 1 11 7
c1 1 vss 0.00796308f $X=0.108 $Y=0.0675
c2 2 vss 0.00929151f $X=0.108 $Y=0.2025
c3 7 vss 0.00442504f $X=0.0935 $Y=0.0675
c4 8 vss 0.0043627f $X=0.0935 $Y=0.2025
c5 9 vss 0.00174911f $X=0.027 $Y=0.077
c6 10 vss 0.00287983f $X=0.027 $Y=0.234
c7 11 vss 0.00340682f $X=0.108 $Y=0.041
c8 12 vss 0.00626903f $X=0.027 $Y=0.106
c9 13 vss 0.00286193f $X=0.083 $Y=0.077
c10 14 vss 0.00917534f $X=0.0515 $Y=0.234
r1 34 32 0.0308642 $w=8.1e-08 $l=2.5e-09 $layer=P_src_drn $thickness=1e-09
+ $X=0.1253 $Y=0.2025 $X2=0.1225 $Y2=0.2025
r2 2 32 0.179012 $w=8.1e-08 $l=1.45e-08 $layer=P_src_drn $thickness=1e-09
+ $X=0.108 $Y=0.2025 $X2=0.1225 $Y2=0.2025
r3 8 2 0.179012 $w=8.1e-08 $l=1.45e-08 $layer=P_src_drn $thickness=1e-09
+ $X=0.0935 $Y=0.2025 $X2=0.108 $Y2=0.2025
r4 33 8 0.0308642 $w=8.1e-08 $l=2.5e-09 $layer=P_src_drn $thickness=1e-09
+ $X=0.0906 $Y=0.2025 $X2=0.0935 $Y2=0.2025
r5 2 29 19.3796 $a=3.24e-16 $layer=V0LISD $X=0.108 $Y=0.2025 $X2=0.108 $Y2=0.234
r6 28 29 5.82974 $w=1.3e-08 $l=2.5e-08 $layer=M1 $thickness=3.6e-08 $X=0.083
+ $Y=0.234 $X2=0.108 $Y2=0.234
r7 14 28 7.34548 $w=1.3e-08 $l=3.15e-08 $layer=M1 $thickness=3.6e-08 $X=0.0515
+ $Y=0.234 $X2=0.083 $Y2=0.234
r8 10 27 3.36447 $w=1.71023e-08 $l=2.15e-08 $layer=M1 $thickness=3.6e-08
+ $X=0.027 $Y=0.234 $X2=0.027 $Y2=0.2125
r9 10 14 4.06404 $w=1.48367e-08 $l=2.45e-08 $layer=M1 $thickness=3.6e-08
+ $X=0.027 $Y=0.234 $X2=0.0515 $Y2=0.234
r10 26 27 9.0944 $w=1.3e-08 $l=3.9e-08 $layer=M1 $thickness=3.6e-08 $X=0.027
+ $Y=0.1735 $X2=0.027 $Y2=0.2125
r11 25 26 6.29612 $w=1.3e-08 $l=2.7e-08 $layer=M1 $thickness=3.6e-08 $X=0.019
+ $Y=0.1465 $X2=0.027 $Y2=0.1735
r12 25 24 0.349785 $w=1.3e-08 $l=1.5e-09 $layer=M1 $thickness=3.6e-08 $X=0.019
+ $Y=0.1465 $X2=0.027 $Y2=0.145
r13 23 24 2.3319 $w=1.3e-08 $l=1e-08 $layer=M1 $thickness=3.6e-08 $X=0.027
+ $Y=0.135 $X2=0.027 $Y2=0.145
r14 12 23 6.7625 $w=1.3e-08 $l=2.9e-08 $layer=M1 $thickness=3.6e-08 $X=0.027
+ $Y=0.106 $X2=0.027 $Y2=0.135
r15 9 22 4.06404 $w=1.48367e-08 $l=2.45e-08 $layer=M1 $thickness=3.6e-08
+ $X=0.027 $Y=0.077 $X2=0.0515 $Y2=0.077
r16 9 12 5.11339 $w=1.60414e-08 $l=2.9e-08 $layer=M1 $thickness=3.6e-08
+ $X=0.027 $Y=0.077 $X2=0.027 $Y2=0.106
r17 13 21 4.64944 $w=1.48e-08 $l=2.5e-08 $layer=M1 $thickness=3.6e-08 $X=0.083
+ $Y=0.077 $X2=0.108 $Y2=0.077
r18 13 22 7.34548 $w=1.3e-08 $l=3.15e-08 $layer=M1 $thickness=3.6e-08 $X=0.083
+ $Y=0.077 $X2=0.0515 $Y2=0.077
r19 20 21 1.50137 $w=1.6913e-08 $l=1.15e-08 $layer=M1 $thickness=3.6e-08
+ $X=0.108 $Y=0.0655 $X2=0.108 $Y2=0.077
r20 19 20 2.68168 $w=1.3e-08 $l=1.15e-08 $layer=M1 $thickness=3.6e-08 $X=0.108
+ $Y=0.054 $X2=0.108 $Y2=0.0655
r21 11 19 3.03147 $w=1.3e-08 $l=1.3e-08 $layer=M1 $thickness=3.6e-08 $X=0.108
+ $Y=0.041 $X2=0.108 $Y2=0.054
r22 1 19 19.3796 $a=3.24e-16 $layer=V0LISD $X=0.108 $Y=0.0675 $X2=0.108
+ $Y2=0.054
r23 18 16 0.0308642 $w=8.1e-08 $l=2.5e-09 $layer=N_src_drn $thickness=1e-09
+ $X=0.1253 $Y=0.0675 $X2=0.1225 $Y2=0.0675
r24 1 16 0.179012 $w=8.1e-08 $l=1.45e-08 $layer=N_src_drn $thickness=1e-09
+ $X=0.108 $Y=0.0675 $X2=0.1225 $Y2=0.0675
r25 7 1 0.179012 $w=8.1e-08 $l=1.45e-08 $layer=N_src_drn $thickness=1e-09
+ $X=0.0935 $Y=0.0675 $X2=0.108 $Y2=0.0675
r26 17 7 0.0308642 $w=8.1e-08 $l=2.5e-09 $layer=N_src_drn $thickness=1e-09
+ $X=0.0906 $Y=0.0675 $X2=0.0935 $Y2=0.0675
.ends

.subckt PM_AO33x2_ASAP7_75t_R%B2 vss 13 5 9 3 1 4
c1 1 vss 0.00292243f $X=0.405 $Y=0.135
c2 3 vss 0.0805153f $X=0.405 $Y=0.0245
c3 4 vss 0.00490382f $X=0.405 $Y=0.098
r1 13 12 0.349785 $w=1.3e-08 $l=1.5e-09 $layer=M1 $thickness=3.6e-08 $X=0.402
+ $Y=0.1465 $X2=0.405 $Y2=0.145
r2 11 12 2.3319 $w=1.3e-08 $l=1e-08 $layer=M1 $thickness=3.6e-08 $X=0.405
+ $Y=0.135 $X2=0.405 $Y2=0.145
r3 4 11 8.62802 $w=1.3e-08 $l=3.7e-08 $layer=M1 $thickness=3.6e-08 $X=0.405
+ $Y=0.098 $X2=0.405 $Y2=0.135
r4 1 7 10.4265 $w=1.765e-08 $layer=LIG $thickness=5.2e-08 $X=0.405 $Y=0.135
+ $X2=0.405 $Y2=0.135
r5 1 11 19.3796 $a=3.24e-16 $layer=V0LIG $X=0.405 $Y=0.135 $X2=0.405 $Y2=0.135
r6 9 8 16.4967 $w=2.1e-08 $l=4.85e-08 $layer=Gate_1 $thickness=5.6e-08 $X=0.405
+ $Y=0.216 $X2=0.405 $Y2=0.1675
r7 7 8 11.2416 $w=2.06615e-08 $l=3.25e-08 $layer=Gate_1 $thickness=5.6e-08
+ $X=0.405 $Y=0.135 $X2=0.405 $Y2=0.1675
r8 6 7 6.6497 $w=2.04211e-08 $l=1.9e-08 $layer=Gate_1 $thickness=5.6e-08
+ $X=0.405 $Y=0.116 $X2=0.405 $Y2=0.135
r9 5 6 16.4967 $w=2.1e-08 $l=4.85e-08 $layer=Gate_1 $thickness=5.6e-08 $X=0.405
+ $Y=0.0675 $X2=0.405 $Y2=0.116
r10 5 3 14.6259 $w=2.1e-08 $l=4.3e-08 $layer=Gate_1 $thickness=5.6e-08 $X=0.405
+ $Y=0.0675 $X2=0.405 $Y2=0.0245
.ends

.subckt PM_AO33x2_ASAP7_75t_R%3 vss 26 32 46 49 72 73 86 89 90 23 1 22 13 18 3
+ 14 15 4 24 5 25 16 21 17 12
c1 1 vss 0.00764771f $X=0.0715 $Y=0.1345
c2 3 vss 0.00509428f $X=0.324 $Y=0.0675
c3 4 vss 0.00976848f $X=0.378 $Y=0.2025
c4 5 vss 0.0086173f $X=0.486 $Y=0.2025
c5 12 vss 0.0841555f $X=0.081 $Y=0.0245
c6 13 vss 0.0837638f $X=0.135 $Y=0.1345
c7 14 vss 0.00546185f $X=0.3095 $Y=0.0675
c8 15 vss 0.00624043f $X=0.3635 $Y=0.216
c9 16 vss 0.0377531f $X=0.4715 $Y=0.216
c10 17 vss 0.00296909f $X=0.153 $Y=0.041
c11 18 vss 0.000440349f $X=0.153 $Y=0.135
c12 19 vss 0.00358671f $X=0.513 $Y=0.036
c13 20 vss 0.00229657f $X=0.513 $Y=0.198
c14 21 vss 0.0022992f $X=0.0695 $Y=0.135
c15 22 vss 0.00278596f $X=0.153 $Y=0.106
c16 23 vss 0.0328788f $X=0.171 $Y=0.036
c17 24 vss 0.0121743f $X=0.4725 $Y=0.198
c18 25 vss 0.00902975f $X=0.513 $Y=0.0575
r1 90 88 0.0462963 $w=5.4e-08 $l=2.5e-09 $layer=P_src_drn $thickness=1e-09
+ $X=0.3953 $Y=0.216 $X2=0.3925 $Y2=0.216
r2 4 88 0.268519 $w=5.4e-08 $l=1.45e-08 $layer=P_src_drn $thickness=1e-09
+ $X=0.378 $Y=0.2025 $X2=0.3925 $Y2=0.216
r3 15 4 0.268519 $w=5.4e-08 $l=1.45e-08 $layer=P_src_drn $thickness=1e-09
+ $X=0.3635 $Y=0.216 $X2=0.378 $Y2=0.2025
r4 89 15 0.0462963 $w=5.4e-08 $l=2.5e-09 $layer=P_src_drn $thickness=1e-09
+ $X=0.3606 $Y=0.216 $X2=0.3635 $Y2=0.216
r5 16 5 0.231482 $w=5.4e-08 $l=1.25e-08 $layer=P_src_drn $thickness=1e-09
+ $X=0.4715 $Y=0.216 $X2=0.486 $Y2=0.2025
r6 86 16 0.0462963 $w=5.4e-08 $l=2.5e-09 $layer=P_src_drn $thickness=1e-09
+ $X=0.4686 $Y=0.216 $X2=0.4715 $Y2=0.216
r7 4 83 19.3796 $a=3.24e-16 $layer=V0LISD $X=0.378 $Y=0.2025 $X2=0.378 $Y2=0.198
r8 5 76 19.3796 $a=3.24e-16 $layer=V0LISD $X=0.486 $Y=0.2025 $X2=0.486 $Y2=0.198
r9 83 84 3.14806 $w=1.3e-08 $l=1.35e-08 $layer=M1 $thickness=3.6e-08 $X=0.378
+ $Y=0.198 $X2=0.3915 $Y2=0.198
r10 81 84 3.14806 $w=1.3e-08 $l=1.35e-08 $layer=M1 $thickness=3.6e-08 $X=0.405
+ $Y=0.198 $X2=0.3915 $Y2=0.198
r11 80 81 6.17953 $w=1.3e-08 $l=2.65e-08 $layer=M1 $thickness=3.6e-08 $X=0.4315
+ $Y=0.198 $X2=0.405 $Y2=0.198
r12 79 80 4.19742 $w=1.3e-08 $l=1.8e-08 $layer=M1 $thickness=3.6e-08 $X=0.4495
+ $Y=0.198 $X2=0.4315 $Y2=0.198
r13 78 79 2.2153 $w=1.3e-08 $l=9.5e-09 $layer=M1 $thickness=3.6e-08 $X=0.459
+ $Y=0.198 $X2=0.4495 $Y2=0.198
r14 76 77 3.14806 $w=1.3e-08 $l=1.35e-08 $layer=M1 $thickness=3.6e-08 $X=0.486
+ $Y=0.198 $X2=0.4995 $Y2=0.198
r15 24 76 3.14806 $w=1.3e-08 $l=1.35e-08 $layer=M1 $thickness=3.6e-08 $X=0.4725
+ $Y=0.198 $X2=0.486 $Y2=0.198
r16 24 78 3.14806 $w=1.3e-08 $l=1.35e-08 $layer=M1 $thickness=3.6e-08 $X=0.4725
+ $Y=0.198 $X2=0.459 $Y2=0.198
r17 20 75 3.36447 $w=1.71023e-08 $l=2.15e-08 $layer=M1 $thickness=3.6e-08
+ $X=0.513 $Y=0.198 $X2=0.513 $Y2=0.1765
r18 20 77 1.49895 $w=1.63333e-08 $l=1.35e-08 $layer=M1 $thickness=3.6e-08
+ $X=0.513 $Y=0.198 $X2=0.4995 $Y2=0.198
r19 74 75 13.8748 $w=1.3e-08 $l=5.95e-08 $layer=M1 $thickness=3.6e-08 $X=0.513
+ $Y=0.117 $X2=0.513 $Y2=0.1765
r20 25 74 13.8748 $w=1.3e-08 $l=5.95e-08 $layer=M1 $thickness=3.6e-08 $X=0.513
+ $Y=0.0575 $X2=0.513 $Y2=0.117
r21 73 71 0.0308642 $w=8.1e-08 $l=2.5e-09 $layer=N_src_drn $thickness=1e-09
+ $X=0.3413 $Y=0.0675 $X2=0.3385 $Y2=0.0675
r22 3 71 0.179012 $w=8.1e-08 $l=1.45e-08 $layer=N_src_drn $thickness=1e-09
+ $X=0.324 $Y=0.0675 $X2=0.3385 $Y2=0.0675
r23 14 3 0.179012 $w=8.1e-08 $l=1.45e-08 $layer=N_src_drn $thickness=1e-09
+ $X=0.3095 $Y=0.0675 $X2=0.324 $Y2=0.0675
r24 72 14 0.0308642 $w=8.1e-08 $l=2.5e-09 $layer=N_src_drn $thickness=1e-09
+ $X=0.3066 $Y=0.0675 $X2=0.3095 $Y2=0.0675
r25 19 69 4.64701 $w=1.46667e-08 $l=2.7e-08 $layer=M1 $thickness=3.6e-08
+ $X=0.513 $Y=0.036 $X2=0.486 $Y2=0.036
r26 19 25 3.36447 $w=1.71023e-08 $l=2.15e-08 $layer=M1 $thickness=3.6e-08
+ $X=0.513 $Y=0.036 $X2=0.513 $Y2=0.0575
r27 3 61 19.3796 $a=3.24e-16 $layer=V0LISD $X=0.324 $Y=0.0675 $X2=0.324
+ $Y2=0.036
r28 68 69 6.29612 $w=1.3e-08 $l=2.7e-08 $layer=M1 $thickness=3.6e-08 $X=0.459
+ $Y=0.036 $X2=0.486 $Y2=0.036
r29 67 68 6.29612 $w=1.3e-08 $l=2.7e-08 $layer=M1 $thickness=3.6e-08 $X=0.432
+ $Y=0.036 $X2=0.459 $Y2=0.036
r30 66 67 6.29612 $w=1.3e-08 $l=2.7e-08 $layer=M1 $thickness=3.6e-08 $X=0.405
+ $Y=0.036 $X2=0.432 $Y2=0.036
r31 65 66 6.17953 $w=1.3e-08 $l=2.65e-08 $layer=M1 $thickness=3.6e-08 $X=0.3785
+ $Y=0.036 $X2=0.405 $Y2=0.036
r32 64 65 4.19742 $w=1.3e-08 $l=1.8e-08 $layer=M1 $thickness=3.6e-08 $X=0.3605
+ $Y=0.036 $X2=0.3785 $Y2=0.036
r33 63 64 2.2153 $w=1.3e-08 $l=9.5e-09 $layer=M1 $thickness=3.6e-08 $X=0.351
+ $Y=0.036 $X2=0.3605 $Y2=0.036
r34 62 63 3.14806 $w=1.3e-08 $l=1.35e-08 $layer=M1 $thickness=3.6e-08 $X=0.3375
+ $Y=0.036 $X2=0.351 $Y2=0.036
r35 61 62 3.14806 $w=1.3e-08 $l=1.35e-08 $layer=M1 $thickness=3.6e-08 $X=0.324
+ $Y=0.036 $X2=0.3375 $Y2=0.036
r36 60 61 3.14806 $w=1.3e-08 $l=1.35e-08 $layer=M1 $thickness=3.6e-08 $X=0.3105
+ $Y=0.036 $X2=0.324 $Y2=0.036
r37 59 60 3.14806 $w=1.3e-08 $l=1.35e-08 $layer=M1 $thickness=3.6e-08 $X=0.297
+ $Y=0.036 $X2=0.3105 $Y2=0.036
r38 58 59 6.29612 $w=1.3e-08 $l=2.7e-08 $layer=M1 $thickness=3.6e-08 $X=0.27
+ $Y=0.036 $X2=0.297 $Y2=0.036
r39 57 58 6.29612 $w=1.3e-08 $l=2.7e-08 $layer=M1 $thickness=3.6e-08 $X=0.243
+ $Y=0.036 $X2=0.27 $Y2=0.036
r40 56 57 6.17953 $w=1.3e-08 $l=2.65e-08 $layer=M1 $thickness=3.6e-08 $X=0.2165
+ $Y=0.036 $X2=0.243 $Y2=0.036
r41 55 56 4.19742 $w=1.3e-08 $l=1.8e-08 $layer=M1 $thickness=3.6e-08 $X=0.1985
+ $Y=0.036 $X2=0.2165 $Y2=0.036
r42 54 55 2.2153 $w=1.3e-08 $l=9.5e-09 $layer=M1 $thickness=3.6e-08 $X=0.189
+ $Y=0.036 $X2=0.1985 $Y2=0.036
r43 23 54 4.19742 $w=1.3e-08 $l=1.8e-08 $layer=M1 $thickness=3.6e-08 $X=0.171
+ $Y=0.036 $X2=0.189 $Y2=0.036
r44 17 52 3.32305 $w=1.42121e-08 $l=1.65e-08 $layer=M1 $thickness=3.6e-08
+ $X=0.153 $Y=0.041 $X2=0.153 $Y2=0.0575
r45 17 23 2.50689 $w=1.45385e-08 $l=1.86815e-08 $layer=M1 $thickness=3.6e-08
+ $X=0.153 $Y=0.041 $X2=0.171 $Y2=0.036
r46 51 52 4.78039 $w=1.3e-08 $l=2.05e-08 $layer=M1 $thickness=3.6e-08 $X=0.153
+ $Y=0.078 $X2=0.153 $Y2=0.0575
r47 22 51 6.52931 $w=1.3e-08 $l=2.8e-08 $layer=M1 $thickness=3.6e-08 $X=0.153
+ $Y=0.106 $X2=0.153 $Y2=0.078
r48 18 44 3.01468 $w=1.525e-08 $l=2e-08 $layer=M1 $thickness=3.6e-08 $X=0.153
+ $Y=0.135 $X2=0.133 $Y2=0.135
r49 18 22 5.11339 $w=1.60414e-08 $l=2.9e-08 $layer=M1 $thickness=3.6e-08
+ $X=0.153 $Y=0.135 $X2=0.153 $Y2=0.106
r50 49 48 16.4967 $w=2.1e-08 $l=4.85e-08 $layer=Gate_1 $thickness=5.6e-08
+ $X=0.135 $Y=0.2025 $X2=0.135 $Y2=0.154
r51 46 47 16.3266 $w=2.1e-08 $l=4.8e-08 $layer=Gate_1 $thickness=5.6e-08
+ $X=0.135 $Y=0.0675 $X2=0.135 $Y2=0.1155
r52 13 38 6.4735 $w=2.13953e-08 $layer=Gate_1 $thickness=5.22791e-08 $X=0.135
+ $Y=0.1345 $X2=0.135 $Y2=0.1345
r53 13 47 6.6582 $w=2.03947e-08 $l=1.9e-08 $layer=Gate_1 $thickness=5.6e-08
+ $X=0.135 $Y=0.1345 $X2=0.135 $Y2=0.1155
r54 13 48 6.82827 $w=2.04103e-08 $l=1.95e-08 $layer=Gate_1 $thickness=5.6e-08
+ $X=0.135 $Y=0.1345 $X2=0.135 $Y2=0.154
r55 43 44 3.14806 $w=1.3e-08 $l=1.35e-08 $layer=M1 $thickness=3.6e-08 $X=0.1195
+ $Y=0.135 $X2=0.133 $Y2=0.135
r56 42 43 2.68168 $w=1.3e-08 $l=1.15e-08 $layer=M1 $thickness=3.6e-08 $X=0.108
+ $Y=0.135 $X2=0.1195 $Y2=0.135
r57 41 42 3.14806 $w=1.3e-08 $l=1.35e-08 $layer=M1 $thickness=3.6e-08 $X=0.0945
+ $Y=0.135 $X2=0.108 $Y2=0.135
r58 40 41 3.14806 $w=1.3e-08 $l=1.35e-08 $layer=M1 $thickness=3.6e-08 $X=0.081
+ $Y=0.135 $X2=0.0945 $Y2=0.135
r59 21 40 2.68168 $w=1.3e-08 $l=1.15e-08 $layer=M1 $thickness=3.6e-08 $X=0.0695
+ $Y=0.135 $X2=0.081 $Y2=0.135
r60 37 38 10.1596 $w=1.87815e-08 $l=2.7e-08 $layer=LIG $thickness=4.8e-08
+ $X=0.108 $Y=0.1345 $X2=0.135 $Y2=0.1345
r61 35 37 7.91162 $w=1.64914e-08 $l=1.75e-08 $layer=LIG $thickness=4.8e-08
+ $X=0.0905 $Y=0.1345 $X2=0.108 $Y2=0.1345
r62 34 35 2.24801 $w=2.3e-08 $l=9.5e-09 $layer=LIG $thickness=4.8e-08 $X=0.081
+ $Y=0.1345 $X2=0.0905 $Y2=0.1345
r63 34 40 19.3796 $a=3.24e-16 $layer=V0LIG $X=0.081 $Y=0.1345 $X2=0.081
+ $Y2=0.135
r64 1 34 2.24801 $w=2.3e-08 $l=9.5e-09 $layer=LIG $thickness=4.8e-08 $X=0.0715
+ $Y=0.1345 $X2=0.081 $Y2=0.1345
r65 32 31 14.6259 $w=2.1e-08 $l=4.3e-08 $layer=Gate_1 $thickness=5.6e-08
+ $X=0.081 $Y=0.2025 $X2=0.081 $Y2=0.1595
r66 30 31 2.7211 $w=2.1e-08 $l=8e-09 $layer=Gate_1 $thickness=5.6e-08 $X=0.081
+ $Y=0.1515 $X2=0.081 $Y2=0.1595
r67 29 30 5.97793 $w=2.03235e-08 $l=1.7e-08 $layer=Gate_1 $thickness=5.6e-08
+ $X=0.081 $Y=0.1345 $X2=0.081 $Y2=0.1515
r68 29 35 4.22548 $w=2.0125e-08 $l=9.5e-09 $layer=Gate_1 $thickness=5.56667e-08
+ $X=0.081 $Y=0.1345 $X2=0.0905 $Y2=0.1345
r69 29 34 6.23686 $w=2.13171e-08 $layer=Gate_1 $thickness=5.24878e-08 $X=0.081
+ $Y=0.1345 $X2=0.081 $Y2=0.1345
r70 28 29 5.80786 $w=2.0303e-08 $l=1.65e-08 $layer=Gate_1 $thickness=5.6e-08
+ $X=0.081 $Y=0.118 $X2=0.081 $Y2=0.1345
r71 27 28 2.55104 $w=2.1e-08 $l=7.5e-09 $layer=Gate_1 $thickness=5.6e-08
+ $X=0.081 $Y=0.1105 $X2=0.081 $Y2=0.118
r72 26 27 14.6259 $w=2.1e-08 $l=4.3e-08 $layer=Gate_1 $thickness=5.6e-08
+ $X=0.081 $Y=0.0675 $X2=0.081 $Y2=0.1105
r73 26 12 14.6259 $w=2.1e-08 $l=4.3e-08 $layer=Gate_1 $thickness=5.6e-08
+ $X=0.081 $Y=0.0675 $X2=0.081 $Y2=0.0245
.ends

.subckt PM_AO33x2_ASAP7_75t_R%A3 vss 13 5 9 4 3
c1 1 vss 0.0059658f $X=0.189 $Y=0.135
c2 3 vss 0.13995f $X=0.189 $Y=0.0245
c3 4 vss 0.00779114f $X=0.189 $Y=0.098
r1 13 12 0.349785 $w=1.3e-08 $l=1.5e-09 $layer=M1 $thickness=3.6e-08 $X=0.186
+ $Y=0.1465 $X2=0.189 $Y2=0.145
r2 11 12 2.3319 $w=1.3e-08 $l=1e-08 $layer=M1 $thickness=3.6e-08 $X=0.189
+ $Y=0.135 $X2=0.189 $Y2=0.145
r3 4 11 8.62802 $w=1.3e-08 $l=3.7e-08 $layer=M1 $thickness=3.6e-08 $X=0.189
+ $Y=0.098 $X2=0.189 $Y2=0.135
r4 1 7 10.4265 $w=1.765e-08 $layer=LIG $thickness=5.2e-08 $X=0.189 $Y=0.135
+ $X2=0.189 $Y2=0.135
r5 1 11 19.3796 $a=3.24e-16 $layer=V0LIG $X=0.189 $Y=0.135 $X2=0.189 $Y2=0.135
r6 9 8 16.4967 $w=2.1e-08 $l=4.85e-08 $layer=Gate_1 $thickness=5.6e-08 $X=0.189
+ $Y=0.216 $X2=0.189 $Y2=0.1675
r7 7 8 11.2416 $w=2.06615e-08 $l=3.25e-08 $layer=Gate_1 $thickness=5.6e-08
+ $X=0.189 $Y=0.135 $X2=0.189 $Y2=0.1675
r8 6 7 6.6497 $w=2.04211e-08 $l=1.9e-08 $layer=Gate_1 $thickness=5.6e-08
+ $X=0.189 $Y=0.116 $X2=0.189 $Y2=0.135
r9 5 6 16.4967 $w=2.1e-08 $l=4.85e-08 $layer=Gate_1 $thickness=5.6e-08 $X=0.189
+ $Y=0.0675 $X2=0.189 $Y2=0.116
r10 5 3 14.6259 $w=2.1e-08 $l=4.3e-08 $layer=Gate_1 $thickness=5.6e-08 $X=0.189
+ $Y=0.0675 $X2=0.189 $Y2=0.0245
.ends

.subckt PM_AO33x2_ASAP7_75t_R%A2 vss 13 5 9 4 3
c1 1 vss 0.00439141f $X=0.243 $Y=0.135
c2 3 vss 0.115946f $X=0.243 $Y=0.0245
c3 4 vss 0.00691885f $X=0.243 $Y=0.098
r1 13 12 5.42166 $w=1.3e-08 $l=2.33e-08 $layer=M1 $thickness=3.6e-08 $X=0.2465
+ $Y=0.19 $X2=0.243 $Y2=0.1667
r2 11 12 7.40378 $w=1.3e-08 $l=3.17e-08 $layer=M1 $thickness=3.6e-08 $X=0.243
+ $Y=0.135 $X2=0.243 $Y2=0.1667
r3 4 11 8.62802 $w=1.3e-08 $l=3.7e-08 $layer=M1 $thickness=3.6e-08 $X=0.243
+ $Y=0.098 $X2=0.243 $Y2=0.135
r4 1 7 10.4265 $w=1.765e-08 $layer=LIG $thickness=5.2e-08 $X=0.243 $Y=0.135
+ $X2=0.243 $Y2=0.135
r5 1 11 19.3796 $a=3.24e-16 $layer=V0LIG $X=0.243 $Y=0.135 $X2=0.243 $Y2=0.135
r6 9 8 16.4967 $w=2.1e-08 $l=4.85e-08 $layer=Gate_1 $thickness=5.6e-08 $X=0.243
+ $Y=0.216 $X2=0.243 $Y2=0.1675
r7 7 8 11.2416 $w=2.06615e-08 $l=3.25e-08 $layer=Gate_1 $thickness=5.6e-08
+ $X=0.243 $Y=0.135 $X2=0.243 $Y2=0.1675
r8 6 7 6.6497 $w=2.04211e-08 $l=1.9e-08 $layer=Gate_1 $thickness=5.6e-08
+ $X=0.243 $Y=0.116 $X2=0.243 $Y2=0.135
r9 5 6 16.4967 $w=2.1e-08 $l=4.85e-08 $layer=Gate_1 $thickness=5.6e-08 $X=0.243
+ $Y=0.0675 $X2=0.243 $Y2=0.116
r10 5 3 14.6259 $w=2.1e-08 $l=4.3e-08 $layer=Gate_1 $thickness=5.6e-08 $X=0.243
+ $Y=0.0675 $X2=0.243 $Y2=0.0245
.ends

* End of included file AO33x2_ASAP7_75t_R.pex.sp.pex

*
.subckt AO33x2_ASAP7_75t_CUSTOM_4_25_0_7 VSS VDD A3 A2 A1 B1 B2 B3 Y
*
* VSS VSS
* VDD VDD
* A3 A3
* A2 A2
* A1 A1
* B1 B1
* B2 B2
* B3 B3
* Y Y
*
*

M0 N_M0_d N_M0_g VSS VSS nmos_rvt L=2e-08 W=8.1e-08 nfin=3 $X=0.071 $Y=0.027
M1 N_M1_d N_M1_g VSS VSS nmos_rvt L=2e-08 W=8.1e-08 nfin=3 $X=0.125 $Y=0.027
M2 noxref_12 N_M2_g VSS VSS nmos_rvt L=2e-08 W=8.1e-08 nfin=3 $X=0.179 $Y=0.027
M3 noxref_13 N_M3_g noxref_12 VSS nmos_rvt L=2e-08 W=8.1e-08 nfin=3 $X=0.233
+ $Y=0.027
M4 N_M4_d N_M4_g noxref_13 VSS nmos_rvt L=2e-08 W=8.1e-08 nfin=3 $X=0.287
+ $Y=0.027
M5 noxref_14 N_M5_g N_M5_s VSS nmos_rvt L=2e-08 W=8.1e-08 nfin=3 $X=0.341
+ $Y=0.027
M6 noxref_15 N_M6_g noxref_14 VSS nmos_rvt L=2e-08 W=8.1e-08 nfin=3 $X=0.395
+ $Y=0.027
M7 VSS N_M7_g noxref_15 VSS nmos_rvt L=2e-08 W=8.1e-08 nfin=3 $X=0.449 $Y=0.027
M8 N_M8_d N_M8_g VDD VDD pmos_rvt L=2e-08 W=8.1e-08 nfin=3 $X=0.071 $Y=0.162
M9 N_M9_d N_M9_g VDD VDD pmos_rvt L=2e-08 W=8.1e-08 nfin=3 $X=0.125 $Y=0.162
M10 noxref_11 N_M10_g VDD VDD pmos_rvt L=2e-08 W=5.4e-08 nfin=2 $X=0.179
+ $Y=0.189
M11 VDD N_M11_g noxref_11 VDD pmos_rvt L=2e-08 W=5.4e-08 nfin=2 $X=0.233
+ $Y=0.189
M12 noxref_11 N_M12_g VDD VDD pmos_rvt L=2e-08 W=5.4e-08 nfin=2 $X=0.287
+ $Y=0.189
M13 N_M13_d N_M13_g noxref_11 VDD pmos_rvt L=2e-08 W=5.4e-08 nfin=2 $X=0.341
+ $Y=0.189
M14 noxref_11 N_M14_g N_M14_s VDD pmos_rvt L=2e-08 W=5.4e-08 nfin=2 $X=0.395
+ $Y=0.189
M15 N_M15_d N_M15_g noxref_11 VDD pmos_rvt L=2e-08 W=5.4e-08 nfin=2 $X=0.449
+ $Y=0.189

* .include "AO33x2_ASAP7_75t_R.pex.sp.pxi"

* Start of included file AO33x2_ASAP7_75t_R.pex.sp.pxi
x_PM_AO33x2_ASAP7_75t_R%A1 vss A1 N_M4_g N_M12_g N_A1_3 N_A1_4
+ PM_AO33x2_ASAP7_75t_R%A1
cc_1 N_A1_3 N_3_3 0.00172835f $X=0.297 $Y=0.0245
cc_2 N_A1_4 N_3_23 0.0012724f $X=0.297 $Y=0.0927
cc_3 N_A1_4 N_3_3 0.00211179f $X=0.297 $Y=0.0927
cc_4 N_A1_3 N_3_14 0.0364895f $X=0.297 $Y=0.0245
cc_5 N_A1_4 N_A2_4 0.00461343f $X=0.297 $Y=0.0927
cc_6 N_A1_3 N_A2_3 0.00786175f $X=0.297 $Y=0.0245
x_PM_AO33x2_ASAP7_75t_R%B1 vss B1 N_M5_g N_M13_g N_B1_3 N_B1_4 N_B1_1
+ PM_AO33x2_ASAP7_75t_R%B1
cc_7 N_B1_3 N_3_15 0.014674f $X=0.351 $Y=0.0245
cc_8 N_B1_3 N_3_4 0.00129815f $X=0.351 $Y=0.0245
cc_9 N_B1_3 N_3_24 0.000576279f $X=0.351 $Y=0.0245
cc_10 N_B1_4 N_3_23 0.00124576f $X=0.351 $Y=0.0745
cc_11 N_B1_1 N_3_14 0.0014633f $X=0.351 $Y=0.135
cc_12 N_B1_3 N_3_3 0.00148886f $X=0.351 $Y=0.0245
cc_13 N_B1_4 N_3_3 0.00248659f $X=0.351 $Y=0.0745
cc_14 N_B1_3 N_3_14 0.0534639f $X=0.351 $Y=0.0245
cc_15 N_B1_4 N_A1_4 0.00350382f $X=0.351 $Y=0.0745
cc_16 N_B1_3 N_A1_3 0.00588353f $X=0.351 $Y=0.0245
x_PM_AO33x2_ASAP7_75t_R%B3 vss B3 N_M7_g N_M15_g N_B3_3 N_B3_4
+ PM_AO33x2_ASAP7_75t_R%B3
cc_17 N_B3_3 N_3_5 0.0016354f $X=0.459 $Y=0.0245
cc_18 N_B3_4 N_3_24 0.00104726f $X=0.459 $Y=0.098
cc_19 N_B3_4 N_3_23 0.00121075f $X=0.459 $Y=0.098
cc_20 N_B3_4 N_3_25 0.00613064f $X=0.459 $Y=0.098
cc_21 N_B3_3 N_3_16 0.0338702f $X=0.459 $Y=0.0245
cc_22 N_B3_4 N_B2_4 0.00337392f $X=0.459 $Y=0.098
cc_23 N_B3_3 N_B2_3 0.00779783f $X=0.459 $Y=0.0245
x_PM_AO33x2_ASAP7_75t_R%Y vss Y N_M0_d N_M1_d N_M8_d N_M9_d N_Y_8 N_Y_1 N_Y_11
+ N_Y_7 PM_AO33x2_ASAP7_75t_R%Y
cc_24 N_Y_8 N_3_21 0.00250741f $X=0.0935 $Y=0.2025
cc_25 N_Y_8 N_3_22 0.000443576f $X=0.0935 $Y=0.2025
cc_26 N_Y_8 N_3_17 0.000496512f $X=0.0935 $Y=0.2025
cc_27 N_Y_8 N_3_13 0.0578988f $X=0.0935 $Y=0.2025
cc_28 N_Y_8 N_3_1 0.000903522f $X=0.0935 $Y=0.2025
cc_29 N_Y_1 N_3_13 0.00197957f $X=0.108 $Y=0.0675
cc_30 N_Y_11 N_3_21 0.00247393f $X=0.108 $Y=0.041
cc_31 N_Y_11 N_3_22 0.00319577f $X=0.108 $Y=0.041
cc_32 N_Y_7 N_3_1 0.00473056f $X=0.0935 $Y=0.0675
cc_33 N_Y_7 N_3_13 0.0102416f $X=0.0935 $Y=0.0675
cc_34 N_Y_7 N_3_12 0.0183641f $X=0.0935 $Y=0.0675
cc_35 N_Y_8 N_3_12 0.0481621f $X=0.0935 $Y=0.2025
x_PM_AO33x2_ASAP7_75t_R%B2 vss B2 N_M6_g N_M14_g N_B2_3 N_B2_1 N_B2_4
+ PM_AO33x2_ASAP7_75t_R%B2
cc_36 N_B2_3 N_3_3 0.000354125f $X=0.405 $Y=0.0245
cc_37 N_B2_3 N_3_4 0.00129883f $X=0.405 $Y=0.0245
cc_38 N_B2_1 N_3_15 0.00081011f $X=0.405 $Y=0.135
cc_39 N_B2_4 N_3_24 0.00107156f $X=0.405 $Y=0.098
cc_40 N_B2_4 N_3_23 0.00146496f $X=0.405 $Y=0.098
cc_41 N_B2_4 N_3_4 0.00274314f $X=0.405 $Y=0.098
cc_42 N_B2_3 N_3_15 0.0330664f $X=0.405 $Y=0.0245
cc_43 N_B2_4 N_B1_4 0.0033729f $X=0.405 $Y=0.098
cc_44 N_B2_3 N_B1_3 0.00780356f $X=0.405 $Y=0.0245
x_PM_AO33x2_ASAP7_75t_R%3 vss N_M0_g N_M8_g N_M1_g N_M9_g N_M4_d N_M5_s N_M15_d
+ N_M13_d N_M14_s N_3_23 N_3_1 N_3_22 N_3_13 N_3_18 N_3_3 N_3_14 N_3_15 N_3_4
+ N_3_24 N_3_5 N_3_25 N_3_16 N_3_21 N_3_17 N_3_12 PM_AO33x2_ASAP7_75t_R%3
x_PM_AO33x2_ASAP7_75t_R%A3 vss A3 N_M2_g N_M10_g N_A3_4 N_A3_3
+ PM_AO33x2_ASAP7_75t_R%A3
cc_45 N_A3_4 N_3_23 0.00100763f $X=0.189 $Y=0.098
cc_46 N_A3_4 N_3_1 0.00141732f $X=0.189 $Y=0.098
cc_47 N_A3_4 N_3_22 0.00216137f $X=0.189 $Y=0.098
cc_48 N_A3_3 N_3_13 0.00337209f $X=0.189 $Y=0.0245
cc_49 N_A3_4 N_3_18 0.0063722f $X=0.189 $Y=0.098
x_PM_AO33x2_ASAP7_75t_R%A2 vss A2 N_M3_g N_M11_g N_A2_4 N_A2_3
+ PM_AO33x2_ASAP7_75t_R%A2
cc_50 N_A2_4 N_3_3 0.000364755f $X=0.243 $Y=0.098
cc_51 N_A2_4 N_3_23 0.0014427f $X=0.243 $Y=0.098
cc_52 N_A2_4 N_3_18 0.00217765f $X=0.243 $Y=0.098
cc_53 N_A2_4 N_A3_4 0.00457499f $X=0.243 $Y=0.098
cc_54 N_A2_3 N_A3_3 0.0077873f $X=0.243 $Y=0.0245

* End of included file AO33x2_ASAP7_75t_R.pex.sp.pxi
.ends

.subckt PM_AO32x2_ASAP7_75t_R%A2 vss 11 5 9 4 3 1
c1 1 vss 0.00243163f $X=0.243 $Y=0.135
c2 3 vss 0.103526f $X=0.243 $Y=0.0245
c3 4 vss 0.00617498f $X=0.243 $Y=0.098
r1 11 4 8.62802 $w=1.3e-08 $l=3.7e-08 $layer=M1 $thickness=3.6e-08 $X=0.243
+ $Y=0.1295 $X2=0.243 $Y2=0.098
r2 1 7 10.4265 $w=1.765e-08 $layer=LIG $thickness=5.2e-08 $X=0.243 $Y=0.135
+ $X2=0.243 $Y2=0.135
r3 11 1 19.3796 $a=3.24e-16 $layer=V0LIG $X=0.243 $Y=0.1295 $X2=0.243 $Y2=0.135
r4 9 8 16.4967 $w=2.1e-08 $l=4.85e-08 $layer=Gate_1 $thickness=5.6e-08 $X=0.243
+ $Y=0.216 $X2=0.243 $Y2=0.1675
r5 7 8 11.2416 $w=2.06615e-08 $l=3.25e-08 $layer=Gate_1 $thickness=5.6e-08
+ $X=0.243 $Y=0.135 $X2=0.243 $Y2=0.1675
r6 6 7 6.6497 $w=2.04211e-08 $l=1.9e-08 $layer=Gate_1 $thickness=5.6e-08
+ $X=0.243 $Y=0.116 $X2=0.243 $Y2=0.135
r7 5 6 16.4967 $w=2.1e-08 $l=4.85e-08 $layer=Gate_1 $thickness=5.6e-08 $X=0.243
+ $Y=0.0675 $X2=0.243 $Y2=0.116
r8 5 3 14.6259 $w=2.1e-08 $l=4.3e-08 $layer=Gate_1 $thickness=5.6e-08 $X=0.243
+ $Y=0.0675 $X2=0.243 $Y2=0.0245
.ends

.subckt PM_AO32x2_ASAP7_75t_R%B1 vss 11 5 9 3 4 1
c1 1 vss 0.00516487f $X=0.351 $Y=0.135
c2 3 vss 0.0507953f $X=0.351 $Y=0.0245
c3 4 vss 0.00352494f $X=0.351 $Y=0.0945
r1 12 13 2.79828 $w=1.3e-08 $l=1.2e-08 $layer=M1 $thickness=3.6e-08 $X=0.351
+ $Y=0.123 $X2=0.351 $Y2=0.135
r2 11 12 0.816164 $w=1.3e-08 $l=3.5e-09 $layer=M1 $thickness=3.6e-08 $X=0.351
+ $Y=0.1195 $X2=0.351 $Y2=0.123
r3 11 4 5.82974 $w=1.3e-08 $l=2.5e-08 $layer=M1 $thickness=3.6e-08 $X=0.351
+ $Y=0.1195 $X2=0.351 $Y2=0.0945
r4 1 7 10.4265 $w=1.765e-08 $layer=LIG $thickness=5.2e-08 $X=0.351 $Y=0.135
+ $X2=0.351 $Y2=0.135
r5 1 13 19.3796 $a=3.24e-16 $layer=V0LIG $X=0.351 $Y=0.135 $X2=0.351 $Y2=0.135
r6 9 8 16.4967 $w=2.1e-08 $l=4.85e-08 $layer=Gate_1 $thickness=5.6e-08 $X=0.351
+ $Y=0.216 $X2=0.351 $Y2=0.1675
r7 7 8 11.2416 $w=2.06615e-08 $l=3.25e-08 $layer=Gate_1 $thickness=5.6e-08
+ $X=0.351 $Y=0.135 $X2=0.351 $Y2=0.1675
r8 6 7 11.2416 $w=2.06615e-08 $l=3.25e-08 $layer=Gate_1 $thickness=5.6e-08
+ $X=0.351 $Y=0.1025 $X2=0.351 $Y2=0.135
r9 5 6 16.4967 $w=2.1e-08 $l=4.85e-08 $layer=Gate_1 $thickness=5.6e-08 $X=0.351
+ $Y=0.054 $X2=0.351 $Y2=0.1025
r10 5 3 10.0341 $w=2.1e-08 $l=2.95e-08 $layer=Gate_1 $thickness=5.6e-08
+ $X=0.351 $Y=0.054 $X2=0.351 $Y2=0.0245
.ends

.subckt PM_AO32x2_ASAP7_75t_R%B2 vss 13 5 11 3 4
c1 1 vss 0.00496882f $X=0.405 $Y=0.135
c2 3 vss 0.0848642f $X=0.405 $Y=0.0245
c3 4 vss 0.00321579f $X=0.405 $Y=0.098
r1 13 4 8.62802 $w=1.3e-08 $l=3.7e-08 $layer=M1 $thickness=3.6e-08 $X=0.408
+ $Y=0.1345 $X2=0.405 $Y2=0.098
r2 1 8 10.4265 $w=1.765e-08 $layer=LIG $thickness=5.2e-08 $X=0.405 $Y=0.135
+ $X2=0.405 $Y2=0.135
r3 13 1 19.3796 $a=3.24e-16 $layer=V0LIG $X=0.408 $Y=0.1345 $X2=0.405 $Y2=0.135
r4 11 10 14.6259 $w=2.1e-08 $l=4.3e-08 $layer=Gate_1 $thickness=5.6e-08
+ $X=0.405 $Y=0.216 $X2=0.405 $Y2=0.173
r5 9 10 7.31297 $w=2.1e-08 $l=2.15e-08 $layer=Gate_1 $thickness=5.6e-08
+ $X=0.405 $Y=0.1515 $X2=0.405 $Y2=0.173
r6 8 9 5.79936 $w=2.03333e-08 $l=1.65e-08 $layer=Gate_1 $thickness=5.6e-08
+ $X=0.405 $Y=0.135 $X2=0.405 $Y2=0.1515
r7 7 8 5.79936 $w=2.03333e-08 $l=1.65e-08 $layer=Gate_1 $thickness=5.6e-08
+ $X=0.405 $Y=0.1185 $X2=0.405 $Y2=0.135
r8 6 7 7.31297 $w=2.1e-08 $l=2.15e-08 $layer=Gate_1 $thickness=5.6e-08 $X=0.405
+ $Y=0.097 $X2=0.405 $Y2=0.1185
r9 5 6 14.6259 $w=2.1e-08 $l=4.3e-08 $layer=Gate_1 $thickness=5.6e-08 $X=0.405
+ $Y=0.054 $X2=0.405 $Y2=0.097
r10 5 3 10.0341 $w=2.1e-08 $l=2.95e-08 $layer=Gate_1 $thickness=5.6e-08
+ $X=0.405 $Y=0.054 $X2=0.405 $Y2=0.0245
.ends

.subckt PM_AO32x2_ASAP7_75t_R%Y vss 25 17 18 34 35 8 1 11 7
c1 1 vss 0.00790192f $X=0.108 $Y=0.0675
c2 2 vss 0.00937449f $X=0.108 $Y=0.2025
c3 7 vss 0.00436512f $X=0.0935 $Y=0.0675
c4 8 vss 0.00435531f $X=0.0935 $Y=0.2025
c5 9 vss 0.00173281f $X=0.027 $Y=0.077
c6 10 vss 0.00288969f $X=0.027 $Y=0.234
c7 11 vss 0.0035918f $X=0.108 $Y=0.041
c8 12 vss 0.00641617f $X=0.027 $Y=0.106
c9 13 vss 0.00304406f $X=0.096 $Y=0.077
c10 14 vss 0.00893692f $X=0.0645 $Y=0.234
r1 35 33 0.0308642 $w=8.1e-08 $l=2.5e-09 $layer=P_src_drn $thickness=1e-09
+ $X=0.1253 $Y=0.2025 $X2=0.1225 $Y2=0.2025
r2 2 33 0.179012 $w=8.1e-08 $l=1.45e-08 $layer=P_src_drn $thickness=1e-09
+ $X=0.108 $Y=0.2025 $X2=0.1225 $Y2=0.2025
r3 8 2 0.179012 $w=8.1e-08 $l=1.45e-08 $layer=P_src_drn $thickness=1e-09
+ $X=0.0935 $Y=0.2025 $X2=0.108 $Y2=0.2025
r4 34 8 0.0308642 $w=8.1e-08 $l=2.5e-09 $layer=P_src_drn $thickness=1e-09
+ $X=0.0906 $Y=0.2025 $X2=0.0935 $Y2=0.2025
r5 2 30 19.3796 $a=3.24e-16 $layer=V0LISD $X=0.108 $Y=0.2025 $X2=0.108 $Y2=0.234
r6 29 30 2.79828 $w=1.3e-08 $l=1.2e-08 $layer=M1 $thickness=3.6e-08 $X=0.096
+ $Y=0.234 $X2=0.108 $Y2=0.234
r7 14 29 7.34548 $w=1.3e-08 $l=3.15e-08 $layer=M1 $thickness=3.6e-08 $X=0.0645
+ $Y=0.234 $X2=0.096 $Y2=0.234
r8 10 28 2.5483 $w=1.79e-08 $l=1.8e-08 $layer=M1 $thickness=3.6e-08 $X=0.027
+ $Y=0.234 $X2=0.027 $Y2=0.216
r9 10 14 7.0955 $w=1.42e-08 $l=3.75e-08 $layer=M1 $thickness=3.6e-08 $X=0.027
+ $Y=0.234 $X2=0.0645 $Y2=0.234
r10 27 28 2.91487 $w=1.3e-08 $l=1.25e-08 $layer=M1 $thickness=3.6e-08 $X=0.027
+ $Y=0.2035 $X2=0.027 $Y2=0.216
r11 26 27 3.61444 $w=1.3e-08 $l=1.55e-08 $layer=M1 $thickness=3.6e-08 $X=0.027
+ $Y=0.188 $X2=0.027 $Y2=0.2035
r12 25 26 2.91487 $w=1.3e-08 $l=1.25e-08 $layer=M1 $thickness=3.6e-08 $X=0.026
+ $Y=0.1755 $X2=0.027 $Y2=0.188
r13 25 24 3.73104 $w=1.3e-08 $l=1.6e-08 $layer=M1 $thickness=3.6e-08 $X=0.026
+ $Y=0.1755 $X2=0.027 $Y2=0.1595
r14 23 24 5.71315 $w=1.3e-08 $l=2.45e-08 $layer=M1 $thickness=3.6e-08 $X=0.027
+ $Y=0.135 $X2=0.027 $Y2=0.1595
r15 12 23 6.7625 $w=1.3e-08 $l=2.9e-08 $layer=M1 $thickness=3.6e-08 $X=0.027
+ $Y=0.106 $X2=0.027 $Y2=0.135
r16 9 22 7.0955 $w=1.42e-08 $l=3.75e-08 $layer=M1 $thickness=3.6e-08 $X=0.027
+ $Y=0.077 $X2=0.0645 $Y2=0.077
r17 9 12 5.11339 $w=1.60414e-08 $l=2.9e-08 $layer=M1 $thickness=3.6e-08
+ $X=0.027 $Y=0.077 $X2=0.027 $Y2=0.106
r18 13 21 1.61797 $w=1.675e-08 $l=1.2e-08 $layer=M1 $thickness=3.6e-08 $X=0.096
+ $Y=0.077 $X2=0.108 $Y2=0.077
r19 13 22 7.34548 $w=1.3e-08 $l=3.15e-08 $layer=M1 $thickness=3.6e-08 $X=0.096
+ $Y=0.077 $X2=0.0645 $Y2=0.077
r20 20 21 1.50137 $w=1.6913e-08 $l=1.15e-08 $layer=M1 $thickness=3.6e-08
+ $X=0.108 $Y=0.0655 $X2=0.108 $Y2=0.077
r21 19 20 2.68168 $w=1.3e-08 $l=1.15e-08 $layer=M1 $thickness=3.6e-08 $X=0.108
+ $Y=0.054 $X2=0.108 $Y2=0.0655
r22 11 19 3.03147 $w=1.3e-08 $l=1.3e-08 $layer=M1 $thickness=3.6e-08 $X=0.108
+ $Y=0.041 $X2=0.108 $Y2=0.054
r23 1 19 19.3796 $a=3.24e-16 $layer=V0LISD $X=0.108 $Y=0.0675 $X2=0.108
+ $Y2=0.054
r24 18 16 0.0308642 $w=8.1e-08 $l=2.5e-09 $layer=N_src_drn $thickness=1e-09
+ $X=0.1253 $Y=0.0675 $X2=0.1225 $Y2=0.0675
r25 1 16 0.179012 $w=8.1e-08 $l=1.45e-08 $layer=N_src_drn $thickness=1e-09
+ $X=0.108 $Y=0.0675 $X2=0.1225 $Y2=0.0675
r26 7 1 0.179012 $w=8.1e-08 $l=1.45e-08 $layer=N_src_drn $thickness=1e-09
+ $X=0.0935 $Y=0.0675 $X2=0.108 $Y2=0.0675
r27 17 7 0.0308642 $w=8.1e-08 $l=2.5e-09 $layer=N_src_drn $thickness=1e-09
+ $X=0.0906 $Y=0.0675 $X2=0.0935 $Y2=0.0675
.ends

.subckt PM_AO32x2_ASAP7_75t_R%3 vss 24 30 40 43 65 68 81 82 21 1 20 10 16 3 22
+ 11 13 14 4 23 19 15 9
c1 1 vss 0.00723657f $X=0.081 $Y=0.135
c2 3 vss 0.00516341f $X=0.324 $Y=0.054
c3 4 vss 0.00802987f $X=0.378 $Y=0.216
c4 9 vss 0.083668f $X=0.081 $Y=0.0245
c5 10 vss 0.114985f $X=0.135 $Y=0.135
c6 11 vss 0.0028875f $X=0.3095 $Y=0.0725
c7 12 vss 0.000758491f $X=0.3095 $Y=0.0455
c8 13 vss 0.00110093f $X=0.3095 $Y=0.0945
c9 14 vss 0.00517856f $X=0.3635 $Y=0.216
c10 15 vss 0.00295743f $X=0.153 $Y=0.041
c11 16 vss 0.000413198f $X=0.153 $Y=0.135
c12 17 vss 0.00348805f $X=0.459 $Y=0.036
c13 18 vss 0.00291023f $X=0.459 $Y=0.198
c14 19 vss 0.0015966f $X=0.108 $Y=0.135
c15 20 vss 0.0026947f $X=0.153 $Y=0.106
c16 21 vss 0.0274117f $X=0.171 $Y=0.036
c17 22 vss 0.00827175f $X=0.448 $Y=0.198
c18 23 vss 0.00884508f $X=0.459 $Y=0.0575
r1 82 80 0.0462963 $w=5.4e-08 $l=2.5e-09 $layer=P_src_drn $thickness=1e-09
+ $X=0.3953 $Y=0.216 $X2=0.3925 $Y2=0.216
r2 4 80 0.268519 $w=5.4e-08 $l=1.45e-08 $layer=P_src_drn $thickness=1e-09
+ $X=0.378 $Y=0.216 $X2=0.3925 $Y2=0.216
r3 14 4 0.268519 $w=5.4e-08 $l=1.45e-08 $layer=P_src_drn $thickness=1e-09
+ $X=0.3635 $Y=0.216 $X2=0.378 $Y2=0.216
r4 81 14 0.0462963 $w=5.4e-08 $l=2.5e-09 $layer=P_src_drn $thickness=1e-09
+ $X=0.3606 $Y=0.216 $X2=0.3635 $Y2=0.216
r5 4 77 19.3796 $a=3.24e-16 $layer=V0LISD $X=0.378 $Y=0.216 $X2=0.378 $Y2=0.198
r6 77 78 3.14806 $w=1.3e-08 $l=1.35e-08 $layer=M1 $thickness=3.6e-08 $X=0.378
+ $Y=0.198 $X2=0.3915 $Y2=0.198
r7 75 78 3.14806 $w=1.3e-08 $l=1.35e-08 $layer=M1 $thickness=3.6e-08 $X=0.405
+ $Y=0.198 $X2=0.3915 $Y2=0.198
r8 74 75 5.82974 $w=1.3e-08 $l=2.5e-08 $layer=M1 $thickness=3.6e-08 $X=0.43
+ $Y=0.198 $X2=0.405 $Y2=0.198
r9 22 74 4.19742 $w=1.3e-08 $l=1.8e-08 $layer=M1 $thickness=3.6e-08 $X=0.448
+ $Y=0.198 $X2=0.43 $Y2=0.198
r10 18 73 3.36447 $w=1.71023e-08 $l=2.15e-08 $layer=M1 $thickness=3.6e-08
+ $X=0.459 $Y=0.198 $X2=0.459 $Y2=0.1765
r11 18 22 0.915974 $w=1.70909e-08 $l=1.1e-08 $layer=M1 $thickness=3.6e-08
+ $X=0.459 $Y=0.198 $X2=0.448 $Y2=0.198
r12 72 73 13.8748 $w=1.3e-08 $l=5.95e-08 $layer=M1 $thickness=3.6e-08 $X=0.459
+ $Y=0.117 $X2=0.459 $Y2=0.1765
r13 23 72 13.8748 $w=1.3e-08 $l=5.95e-08 $layer=M1 $thickness=3.6e-08 $X=0.459
+ $Y=0.0575 $X2=0.459 $Y2=0.117
r14 13 3 0.462963 $w=2.7e-08 $l=1.25e-08 $layer=N_src_drn $thickness=1e-09
+ $X=0.3095 $Y=0.0945 $X2=0.324 $Y2=0.054
r15 12 3 0.391892 $w=3.7e-08 $l=1.45e-08 $layer=N_src_drn $thickness=1e-09
+ $X=0.3095 $Y=0.0455 $X2=0.324 $Y2=0.054
r16 68 67 0.147059 $w=1.7e-08 $l=2.5e-09 $layer=N_src_drn $thickness=1e-09
+ $X=0.3413 $Y=0.054 $X2=0.3385 $Y2=0.0725
r17 66 67 0.264706 $w=1.7e-08 $l=4.5e-09 $layer=N_src_drn $thickness=1e-09
+ $X=0.334 $Y=0.0725 $X2=0.3385 $Y2=0.0725
r18 3 66 0.705882 $w=1.7e-08 $l=1.2e-08 $layer=N_src_drn $thickness=1e-09
+ $X=0.324 $Y=0.054 $X2=0.334 $Y2=0.0725
r19 11 3 0.735294 $w=1.7e-08 $l=1.25e-08 $layer=N_src_drn $thickness=1e-09
+ $X=0.3095 $Y=0.0725 $X2=0.324 $Y2=0.054
r20 65 11 0.147059 $w=1.7e-08 $l=2.5e-09 $layer=N_src_drn $thickness=1e-09
+ $X=0.3066 $Y=0.0675 $X2=0.3095 $Y2=0.0725
r21 17 62 4.64701 $w=1.46667e-08 $l=2.7e-08 $layer=M1 $thickness=3.6e-08
+ $X=0.459 $Y=0.036 $X2=0.432 $Y2=0.036
r22 17 23 3.36447 $w=1.71023e-08 $l=2.15e-08 $layer=M1 $thickness=3.6e-08
+ $X=0.459 $Y=0.036 $X2=0.459 $Y2=0.0575
r23 3 55 19.3796 $a=3.24e-16 $layer=V0LISD $X=0.324 $Y=0.054 $X2=0.3225
+ $Y2=0.036
r24 61 62 6.29612 $w=1.3e-08 $l=2.7e-08 $layer=M1 $thickness=3.6e-08 $X=0.405
+ $Y=0.036 $X2=0.432 $Y2=0.036
r25 60 61 5.82974 $w=1.3e-08 $l=2.5e-08 $layer=M1 $thickness=3.6e-08 $X=0.38
+ $Y=0.036 $X2=0.405 $Y2=0.036
r26 59 60 4.19742 $w=1.3e-08 $l=1.8e-08 $layer=M1 $thickness=3.6e-08 $X=0.362
+ $Y=0.036 $X2=0.38 $Y2=0.036
r27 58 59 2.56509 $w=1.3e-08 $l=1.1e-08 $layer=M1 $thickness=3.6e-08 $X=0.351
+ $Y=0.036 $X2=0.362 $Y2=0.036
r28 57 58 3.14806 $w=1.3e-08 $l=1.35e-08 $layer=M1 $thickness=3.6e-08 $X=0.3375
+ $Y=0.036 $X2=0.351 $Y2=0.036
r29 56 57 1.39914 $w=1.3e-08 $l=6e-09 $layer=M1 $thickness=3.6e-08 $X=0.3315
+ $Y=0.036 $X2=0.3375 $Y2=0.036
r30 55 56 2.09871 $w=1.3e-08 $l=9e-09 $layer=M1 $thickness=3.6e-08 $X=0.3225
+ $Y=0.036 $X2=0.3315 $Y2=0.036
r31 54 55 2.79828 $w=1.3e-08 $l=1.2e-08 $layer=M1 $thickness=3.6e-08 $X=0.3105
+ $Y=0.036 $X2=0.3225 $Y2=0.036
r32 53 54 3.14806 $w=1.3e-08 $l=1.35e-08 $layer=M1 $thickness=3.6e-08 $X=0.297
+ $Y=0.036 $X2=0.3105 $Y2=0.036
r33 52 53 6.29612 $w=1.3e-08 $l=2.7e-08 $layer=M1 $thickness=3.6e-08 $X=0.27
+ $Y=0.036 $X2=0.297 $Y2=0.036
r34 51 52 6.29612 $w=1.3e-08 $l=2.7e-08 $layer=M1 $thickness=3.6e-08 $X=0.243
+ $Y=0.036 $X2=0.27 $Y2=0.036
r35 50 51 5.82974 $w=1.3e-08 $l=2.5e-08 $layer=M1 $thickness=3.6e-08 $X=0.218
+ $Y=0.036 $X2=0.243 $Y2=0.036
r36 49 50 4.19742 $w=1.3e-08 $l=1.8e-08 $layer=M1 $thickness=3.6e-08 $X=0.2
+ $Y=0.036 $X2=0.218 $Y2=0.036
r37 48 49 2.56509 $w=1.3e-08 $l=1.1e-08 $layer=M1 $thickness=3.6e-08 $X=0.189
+ $Y=0.036 $X2=0.2 $Y2=0.036
r38 21 48 4.19742 $w=1.3e-08 $l=1.8e-08 $layer=M1 $thickness=3.6e-08 $X=0.171
+ $Y=0.036 $X2=0.189 $Y2=0.036
r39 15 46 3.32305 $w=1.42121e-08 $l=1.65e-08 $layer=M1 $thickness=3.6e-08
+ $X=0.153 $Y=0.041 $X2=0.153 $Y2=0.0575
r40 15 21 2.50689 $w=1.45385e-08 $l=1.86815e-08 $layer=M1 $thickness=3.6e-08
+ $X=0.153 $Y=0.041 $X2=0.171 $Y2=0.036
r41 45 46 4.78039 $w=1.3e-08 $l=2.05e-08 $layer=M1 $thickness=3.6e-08 $X=0.153
+ $Y=0.078 $X2=0.153 $Y2=0.0575
r42 20 45 6.52931 $w=1.3e-08 $l=2.8e-08 $layer=M1 $thickness=3.6e-08 $X=0.153
+ $Y=0.106 $X2=0.153 $Y2=0.078
r43 16 38 3.01468 $w=1.525e-08 $l=2e-08 $layer=M1 $thickness=3.6e-08 $X=0.153
+ $Y=0.135 $X2=0.133 $Y2=0.135
r44 16 20 5.11339 $w=1.60414e-08 $l=2.9e-08 $layer=M1 $thickness=3.6e-08
+ $X=0.153 $Y=0.135 $X2=0.153 $Y2=0.106
r45 43 42 16.4967 $w=2.1e-08 $l=4.85e-08 $layer=Gate_1 $thickness=5.6e-08
+ $X=0.135 $Y=0.2025 $X2=0.135 $Y2=0.154
r46 40 41 16.4967 $w=2.1e-08 $l=4.85e-08 $layer=Gate_1 $thickness=5.6e-08
+ $X=0.135 $Y=0.0675 $X2=0.135 $Y2=0.116
r47 10 34 6.54019 $w=2.09524e-08 $layer=Gate_1 $thickness=5.21905e-08 $X=0.135
+ $Y=0.135 $X2=0.135 $Y2=0.135
r48 10 41 6.6497 $w=2.04211e-08 $l=1.9e-08 $layer=Gate_1 $thickness=5.6e-08
+ $X=0.135 $Y=0.135 $X2=0.135 $Y2=0.116
r49 10 42 6.6497 $w=2.04211e-08 $l=1.9e-08 $layer=Gate_1 $thickness=5.6e-08
+ $X=0.135 $Y=0.135 $X2=0.135 $Y2=0.154
r50 37 38 3.14806 $w=1.3e-08 $l=1.35e-08 $layer=M1 $thickness=3.6e-08 $X=0.1195
+ $Y=0.135 $X2=0.133 $Y2=0.135
r51 19 33 19.3796 $a=3.24e-16 $layer=V0LIG $X=0.108 $Y=0.135 $X2=0.108 $Y2=0.135
r52 19 37 2.68168 $w=1.3e-08 $l=1.15e-08 $layer=M1 $thickness=3.6e-08 $X=0.108
+ $Y=0.135 $X2=0.1195 $Y2=0.135
r53 33 34 12.6539 $w=1.77815e-08 $l=2.7e-08 $layer=LIG $thickness=4.8e-08
+ $X=0.108 $Y=0.135 $X2=0.135 $Y2=0.135
r54 1 27 6.54019 $w=2.09524e-08 $layer=Gate_1 $thickness=5.21905e-08 $X=0.081
+ $Y=0.135 $X2=0.081 $Y2=0.135
r55 1 33 12.6539 $w=1.77815e-08 $l=2.7e-08 $layer=LIG $thickness=4.8e-08
+ $X=0.081 $Y=0.135 $X2=0.108 $Y2=0.135
r56 30 29 14.6259 $w=2.1e-08 $l=4.3e-08 $layer=Gate_1 $thickness=5.6e-08
+ $X=0.081 $Y=0.2025 $X2=0.081 $Y2=0.1595
r57 28 29 2.7211 $w=2.1e-08 $l=8e-09 $layer=Gate_1 $thickness=5.6e-08 $X=0.081
+ $Y=0.1515 $X2=0.081 $Y2=0.1595
r58 27 28 5.79936 $w=2.03333e-08 $l=1.65e-08 $layer=Gate_1 $thickness=5.6e-08
+ $X=0.081 $Y=0.135 $X2=0.081 $Y2=0.1515
r59 26 27 5.79936 $w=2.03333e-08 $l=1.65e-08 $layer=Gate_1 $thickness=5.6e-08
+ $X=0.081 $Y=0.1185 $X2=0.081 $Y2=0.135
r60 25 26 2.7211 $w=2.1e-08 $l=8e-09 $layer=Gate_1 $thickness=5.6e-08 $X=0.081
+ $Y=0.1105 $X2=0.081 $Y2=0.1185
r61 24 25 14.6259 $w=2.1e-08 $l=4.3e-08 $layer=Gate_1 $thickness=5.6e-08
+ $X=0.081 $Y=0.0675 $X2=0.081 $Y2=0.1105
r62 24 9 14.6259 $w=2.1e-08 $l=4.3e-08 $layer=Gate_1 $thickness=5.6e-08
+ $X=0.081 $Y=0.0675 $X2=0.081 $Y2=0.0245
.ends

.subckt PM_AO32x2_ASAP7_75t_R%A3 vss 13 5 9 4 3
c1 1 vss 0.00475371f $X=0.189 $Y=0.135
c2 3 vss 0.145502f $X=0.189 $Y=0.0245
c3 4 vss 0.0071609f $X=0.189 $Y=0.098
r1 13 12 3.73104 $w=1.3e-08 $l=1.6e-08 $layer=M1 $thickness=3.6e-08 $X=0.191
+ $Y=0.1755 $X2=0.189 $Y2=0.1595
r2 11 12 5.71315 $w=1.3e-08 $l=2.45e-08 $layer=M1 $thickness=3.6e-08 $X=0.189
+ $Y=0.135 $X2=0.189 $Y2=0.1595
r3 4 11 8.62802 $w=1.3e-08 $l=3.7e-08 $layer=M1 $thickness=3.6e-08 $X=0.189
+ $Y=0.098 $X2=0.189 $Y2=0.135
r4 1 7 10.4265 $w=1.765e-08 $layer=LIG $thickness=5.2e-08 $X=0.189 $Y=0.135
+ $X2=0.189 $Y2=0.135
r5 1 11 19.3796 $a=3.24e-16 $layer=V0LIG $X=0.189 $Y=0.135 $X2=0.189 $Y2=0.135
r6 9 8 16.4967 $w=2.1e-08 $l=4.85e-08 $layer=Gate_1 $thickness=5.6e-08 $X=0.189
+ $Y=0.216 $X2=0.189 $Y2=0.1675
r7 7 8 11.2416 $w=2.06615e-08 $l=3.25e-08 $layer=Gate_1 $thickness=5.6e-08
+ $X=0.189 $Y=0.135 $X2=0.189 $Y2=0.1675
r8 6 7 6.6497 $w=2.04211e-08 $l=1.9e-08 $layer=Gate_1 $thickness=5.6e-08
+ $X=0.189 $Y=0.116 $X2=0.189 $Y2=0.135
r9 5 6 16.4967 $w=2.1e-08 $l=4.85e-08 $layer=Gate_1 $thickness=5.6e-08 $X=0.189
+ $Y=0.0675 $X2=0.189 $Y2=0.116
r10 5 3 14.6259 $w=2.1e-08 $l=4.3e-08 $layer=Gate_1 $thickness=5.6e-08 $X=0.189
+ $Y=0.0675 $X2=0.189 $Y2=0.0245
.ends

.subckt PM_AO32x2_ASAP7_75t_R%A1 vss 15 6 10 3 5
c1 1 vss 0.00785738f $X=0.297 $Y=0.135
c2 3 vss 0.0857747f $X=0.297 $Y=0.0245
c3 4 vss 0.00919891f $X=0.297 $Y=0.198
c4 5 vss 0.0052398f $X=0.297 $Y=0.098
r1 4 16 2.31754 $w=1.6e-08 $l=1.5e-08 $layer=M1 $thickness=3.6e-08 $X=0.297
+ $Y=0.198 $X2=0.297 $Y2=0.183
r2 15 16 1.51573 $w=1.3e-08 $l=6.5e-09 $layer=M1 $thickness=3.6e-08 $X=0.302
+ $Y=0.1765 $X2=0.297 $Y2=0.183
r3 15 14 1.51573 $w=1.3e-08 $l=6.5e-09 $layer=M1 $thickness=3.6e-08 $X=0.302
+ $Y=0.1765 $X2=0.297 $Y2=0.17
r4 13 14 3.73104 $w=1.3e-08 $l=1.6e-08 $layer=M1 $thickness=3.6e-08 $X=0.297
+ $Y=0.154 $X2=0.297 $Y2=0.17
r5 12 13 4.4306 $w=1.3e-08 $l=1.9e-08 $layer=M1 $thickness=3.6e-08 $X=0.297
+ $Y=0.135 $X2=0.297 $Y2=0.154
r6 5 12 8.62802 $w=1.3e-08 $l=3.7e-08 $layer=M1 $thickness=3.6e-08 $X=0.297
+ $Y=0.098 $X2=0.297 $Y2=0.135
r7 1 8 10.4265 $w=1.765e-08 $layer=LIG $thickness=5.2e-08 $X=0.297 $Y=0.135
+ $X2=0.297 $Y2=0.135
r8 1 12 19.3796 $a=3.24e-16 $layer=V0LIG $X=0.297 $Y=0.135 $X2=0.297 $Y2=0.135
r9 10 9 16.4967 $w=2.1e-08 $l=4.85e-08 $layer=Gate_1 $thickness=5.6e-08
+ $X=0.297 $Y=0.216 $X2=0.297 $Y2=0.1675
r10 8 9 11.2416 $w=2.06615e-08 $l=3.25e-08 $layer=Gate_1 $thickness=5.6e-08
+ $X=0.297 $Y=0.135 $X2=0.297 $Y2=0.1675
r11 7 8 6.6497 $w=2.04211e-08 $l=1.9e-08 $layer=Gate_1 $thickness=5.6e-08
+ $X=0.297 $Y=0.116 $X2=0.297 $Y2=0.135
r12 6 7 16.4967 $w=2.1e-08 $l=4.85e-08 $layer=Gate_1 $thickness=5.6e-08
+ $X=0.297 $Y=0.0675 $X2=0.297 $Y2=0.116
r13 6 3 14.6259 $w=2.1e-08 $l=4.3e-08 $layer=Gate_1 $thickness=5.6e-08 $X=0.297
+ $Y=0.0675 $X2=0.297 $Y2=0.0245
.ends

* End of included file AO32x2_ASAP7_75t_R.pex.sp.pex

*
.subckt AO32x2_ASAP7_75t_CUSTOM_4_25_0_7 VSS VDD A3 A2 A1 B1 B2 Y
*
* VSS VSS
* VDD VDD
* A3 A3
* A2 A2
* A1 A1
* B1 B1
* B2 B2
* Y Y
*
*

M0 N_M0_d N_M0_g VSS VSS nmos_rvt L=2e-08 W=8.1e-08 nfin=3 $X=0.071 $Y=0.027
M1 N_M1_d N_M1_g VSS VSS nmos_rvt L=2e-08 W=8.1e-08 nfin=3 $X=0.125 $Y=0.027
M2 noxref_11 N_M2_g VSS VSS nmos_rvt L=2e-08 W=8.1e-08 nfin=3 $X=0.179 $Y=0.027
M3 noxref_12 N_M3_g noxref_11 VSS nmos_rvt L=2e-08 W=8.1e-08 nfin=3 $X=0.233
+ $Y=0.027
M4 N_M4_d N_M4_g noxref_12 VSS nmos_rvt L=2e-08 W=8.1e-08 nfin=3 $X=0.287
+ $Y=0.027
M5 noxref_13 N_M5_g N_M5_s VSS nmos_rvt L=2e-08 W=5.4e-08 nfin=2 $X=0.341
+ $Y=0.027
M6 VSS N_M6_g noxref_13 VSS nmos_rvt L=2e-08 W=5.4e-08 nfin=2 $X=0.395 $Y=0.027
M7 N_M7_d N_M7_g VDD VDD pmos_rvt L=2e-08 W=8.1e-08 nfin=3 $X=0.071 $Y=0.162
M8 N_M8_d N_M8_g VDD VDD pmos_rvt L=2e-08 W=8.1e-08 nfin=3 $X=0.125 $Y=0.162
M9 noxref_10 N_M9_g VDD VDD pmos_rvt L=2e-08 W=5.4e-08 nfin=2 $X=0.179 $Y=0.189
M10 VDD N_M10_g noxref_10 VDD pmos_rvt L=2e-08 W=5.4e-08 nfin=2 $X=0.233
+ $Y=0.189
M11 noxref_10 N_M11_g VDD VDD pmos_rvt L=2e-08 W=5.4e-08 nfin=2 $X=0.287
+ $Y=0.189
M12 N_M12_d N_M12_g noxref_10 VDD pmos_rvt L=2e-08 W=5.4e-08 nfin=2 $X=0.341
+ $Y=0.189
M13 noxref_10 N_M13_g N_M13_s VDD pmos_rvt L=2e-08 W=5.4e-08 nfin=2 $X=0.395
+ $Y=0.189

* .include "AO32x2_ASAP7_75t_R.pex.sp.pxi"

* Start of included file AO32x2_ASAP7_75t_R.pex.sp.pxi
x_PM_AO32x2_ASAP7_75t_R%A2 vss A2 N_M3_g N_M10_g N_A2_4 N_A2_3 N_A2_1
+ PM_AO32x2_ASAP7_75t_R%A2
cc_1 N_A2_4 N_3_3 0.000362165f $X=0.243 $Y=0.098
cc_2 N_A2_4 N_3_21 0.00144962f $X=0.243 $Y=0.098
cc_3 N_A2_4 N_3_16 0.0021063f $X=0.243 $Y=0.098
cc_4 N_A2_4 N_A3_4 0.00472878f $X=0.243 $Y=0.098
cc_5 N_A2_3 N_A3_3 0.00938814f $X=0.243 $Y=0.0245
x_PM_AO32x2_ASAP7_75t_R%B1 vss B1 N_M5_g N_M12_g N_B1_3 N_B1_4 N_B1_1
+ PM_AO32x2_ASAP7_75t_R%B1
cc_6 N_B1_3 N_3_13 0.00537126f $X=0.351 $Y=0.0245
cc_7 N_B1_3 N_3_14 0.0107812f $X=0.351 $Y=0.0245
cc_8 N_B1_3 N_3_4 0.000832467f $X=0.351 $Y=0.0245
cc_9 N_B1_3 N_3_3 0.00186681f $X=0.351 $Y=0.0245
cc_10 N_B1_4 N_3_22 0.000525289f $X=0.351 $Y=0.0945
cc_11 N_B1_1 N_3_11 0.00104398f $X=0.351 $Y=0.135
cc_12 N_B1_4 N_3_21 0.00124427f $X=0.351 $Y=0.0945
cc_13 N_B1_4 N_3_3 0.00248076f $X=0.351 $Y=0.0945
cc_14 N_B1_3 N_3_11 0.0446735f $X=0.351 $Y=0.0245
cc_15 N_B1_4 N_A1_5 0.00378329f $X=0.351 $Y=0.0945
cc_16 N_B1_3 N_A1_3 0.00737512f $X=0.351 $Y=0.0245
x_PM_AO32x2_ASAP7_75t_R%B2 vss B2 N_M6_g N_M13_g N_B2_3 N_B2_4
+ PM_AO32x2_ASAP7_75t_R%B2
cc_17 N_B2_3 N_3_3 0.000351156f $X=0.405 $Y=0.0245
cc_18 N_B2_3 N_3_4 0.000811365f $X=0.405 $Y=0.0245
cc_19 N_B2_3 N_3_23 0.000693185f $X=0.405 $Y=0.0245
cc_20 N_B2_4 N_3_22 0.00103177f $X=0.405 $Y=0.098
cc_21 N_B2_4 N_3_21 0.00120444f $X=0.405 $Y=0.098
cc_22 N_B2_4 N_3_23 0.00639243f $X=0.405 $Y=0.098
cc_23 N_B2_3 N_3_14 0.0259185f $X=0.405 $Y=0.0245
cc_24 N_B2_4 N_B1_4 0.00335756f $X=0.405 $Y=0.098
cc_25 N_B2_3 N_B1_3 0.0107707f $X=0.405 $Y=0.0245
x_PM_AO32x2_ASAP7_75t_R%Y vss Y N_M0_d N_M1_d N_M7_d N_M8_d N_Y_8 N_Y_1 N_Y_11
+ N_Y_7 PM_AO32x2_ASAP7_75t_R%Y
cc_26 N_Y_8 N_3_19 0.00319056f $X=0.0935 $Y=0.2025
cc_27 N_Y_8 N_3_20 0.000438213f $X=0.0935 $Y=0.2025
cc_28 N_Y_8 N_3_15 0.000499389f $X=0.0935 $Y=0.2025
cc_29 N_Y_8 N_3_9 0.0129164f $X=0.0935 $Y=0.2025
cc_30 N_Y_8 N_3_1 0.000839904f $X=0.0935 $Y=0.2025
cc_31 N_Y_1 N_3_9 0.00193054f $X=0.108 $Y=0.0675
cc_32 N_Y_11 N_3_20 0.00317295f $X=0.108 $Y=0.041
cc_33 N_Y_7 N_3_1 0.00469072f $X=0.0935 $Y=0.0675
cc_34 N_Y_7 N_3_10 0.0102412f $X=0.0935 $Y=0.0675
cc_35 N_Y_7 N_3_9 0.0549177f $X=0.0935 $Y=0.0675
cc_36 N_Y_8 N_3_10 0.0566643f $X=0.0935 $Y=0.2025
x_PM_AO32x2_ASAP7_75t_R%3 vss N_M0_g N_M7_g N_M1_g N_M8_g N_M4_d N_M5_s N_M12_d
+ N_M13_s N_3_21 N_3_1 N_3_20 N_3_10 N_3_16 N_3_3 N_3_22 N_3_11 N_3_13 N_3_14
+ N_3_4 N_3_23 N_3_19 N_3_15 N_3_9 PM_AO32x2_ASAP7_75t_R%3
x_PM_AO32x2_ASAP7_75t_R%A3 vss A3 N_M2_g N_M9_g N_A3_4 N_A3_3
+ PM_AO32x2_ASAP7_75t_R%A3
cc_37 N_A3_4 N_3_21 0.00101584f $X=0.189 $Y=0.098
cc_38 N_A3_4 N_3_1 0.00132335f $X=0.189 $Y=0.098
cc_39 N_A3_4 N_3_20 0.0021625f $X=0.189 $Y=0.098
cc_40 N_A3_3 N_3_10 0.00330381f $X=0.189 $Y=0.0245
cc_41 N_A3_4 N_3_16 0.00645418f $X=0.189 $Y=0.098
x_PM_AO32x2_ASAP7_75t_R%A1 vss A1 N_M4_g N_M11_g N_A1_3 N_A1_5
+ PM_AO32x2_ASAP7_75t_R%A1
cc_42 N_A1_3 N_3_3 0.00191064f $X=0.297 $Y=0.0245
cc_43 N_A1_3 N_3_22 0.000758722f $X=0.297 $Y=0.0245
cc_44 N_A1_3 N_3_11 0.0106421f $X=0.297 $Y=0.0245
cc_45 N_A1_5 N_3_21 0.00126818f $X=0.297 $Y=0.098
cc_46 N_A1_5 N_3_3 0.00199746f $X=0.297 $Y=0.098
cc_47 N_A1_3 N_3_13 0.0332392f $X=0.297 $Y=0.0245
cc_48 N_A1_3 N_A2_1 0.00157163f $X=0.297 $Y=0.0245
cc_49 N_A1_5 N_A2_4 0.00456778f $X=0.297 $Y=0.098
cc_50 N_A1_3 N_A2_3 0.00814876f $X=0.297 $Y=0.0245

* End of included file AO32x2_ASAP7_75t_R.pex.sp.pxi
.ends

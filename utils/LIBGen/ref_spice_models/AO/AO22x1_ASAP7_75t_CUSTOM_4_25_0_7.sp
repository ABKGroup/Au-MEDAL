.subckt PM_AO22x1_ASAP7_75t_R%A1 vss 23 10 16 3
c1 1 vss 0.00405691f $X=0.081 $Y=0.135
c2 3 vss 0.112599f $X=0.081 $Y=0.0245
c3 4 vss 0.00702453f $X=0.027 $Y=0.036
c4 5 vss 0.00100791f $X=0.027 $Y=0.135
c5 6 vss 0.00610467f $X=0.027 $Y=0.198
c6 7 vss 0.00589555f $X=0.027 $Y=0.1035
c7 8 vss 0.00297583f $X=0.027 $Y=0.1472
c8 9 vss 0.00274183f $X=0.0635 $Y=0.135
r1 6 24 5.29071 $w=1.46216e-08 $l=2.78e-08 $layer=M1 $thickness=3.6e-08
+ $X=0.027 $Y=0.198 $X2=0.027 $Y2=0.1702
r2 4 22 3.01711 $w=1.55e-08 $l=1.8e-08 $layer=M1 $thickness=3.6e-08 $X=0.027
+ $Y=0.036 $X2=0.027 $Y2=0.054
r3 23 24 4.4889 $w=1.3e-08 $l=1.92e-08 $layer=M1 $thickness=3.6e-08 $X=0.026
+ $Y=0.151 $X2=0.027 $Y2=0.1702
r4 23 8 0.874462 $w=1.3e-08 $l=3.8e-09 $layer=M1 $thickness=3.6e-08 $X=0.026
+ $Y=0.151 $X2=0.027 $Y2=0.1472
r5 21 22 4.19742 $w=1.3e-08 $l=1.8e-08 $layer=M1 $thickness=3.6e-08 $X=0.027
+ $Y=0.072 $X2=0.027 $Y2=0.054
r6 7 21 7.34548 $w=1.3e-08 $l=3.15e-08 $layer=M1 $thickness=3.6e-08 $X=0.027
+ $Y=0.1035 $X2=0.027 $Y2=0.072
r7 5 20 3.1337 $w=1.54324e-08 $l=1.85e-08 $layer=M1 $thickness=3.6e-08 $X=0.027
+ $Y=0.135 $X2=0.0455 $Y2=0.135
r8 5 7 6.16517 $w=1.44286e-08 $l=3.15e-08 $layer=M1 $thickness=3.6e-08 $X=0.027
+ $Y=0.135 $X2=0.027 $Y2=0.1035
r9 5 8 1.67627 $w=1.66735e-08 $l=1.22e-08 $layer=M1 $thickness=3.6e-08 $X=0.027
+ $Y=0.135 $X2=0.027 $Y2=0.1472
r10 9 18 4.08082 $w=1.3e-08 $l=1.75e-08 $layer=M1 $thickness=3.6e-08 $X=0.0635
+ $Y=0.135 $X2=0.081 $Y2=0.135
r11 9 20 4.19742 $w=1.3e-08 $l=1.8e-08 $layer=M1 $thickness=3.6e-08 $X=0.0635
+ $Y=0.135 $X2=0.0455 $Y2=0.135
r12 1 13 10.4265 $w=1.765e-08 $layer=LIG $thickness=5.2e-08 $X=0.081 $Y=0.135
+ $X2=0.081 $Y2=0.135
r13 1 18 19.3796 $a=3.24e-16 $layer=V0LIG $X=0.081 $Y=0.135 $X2=0.081 $Y2=0.135
r14 16 15 14.6259 $w=2.1e-08 $l=4.3e-08 $layer=Gate_1 $thickness=5.6e-08
+ $X=0.081 $Y=0.216 $X2=0.081 $Y2=0.173
r15 14 15 7.31297 $w=2.1e-08 $l=2.15e-08 $layer=Gate_1 $thickness=5.6e-08
+ $X=0.081 $Y=0.1515 $X2=0.081 $Y2=0.173
r16 13 14 5.79936 $w=2.03333e-08 $l=1.65e-08 $layer=Gate_1 $thickness=5.6e-08
+ $X=0.081 $Y=0.135 $X2=0.081 $Y2=0.1515
r17 12 13 5.79936 $w=2.03333e-08 $l=1.65e-08 $layer=Gate_1 $thickness=5.6e-08
+ $X=0.081 $Y=0.1185 $X2=0.081 $Y2=0.135
r18 11 12 7.31297 $w=2.1e-08 $l=2.15e-08 $layer=Gate_1 $thickness=5.6e-08
+ $X=0.081 $Y=0.097 $X2=0.081 $Y2=0.1185
r19 10 11 14.6259 $w=2.1e-08 $l=4.3e-08 $layer=Gate_1 $thickness=5.6e-08
+ $X=0.081 $Y=0.054 $X2=0.081 $Y2=0.097
r20 10 3 10.0341 $w=2.1e-08 $l=2.95e-08 $layer=Gate_1 $thickness=5.6e-08
+ $X=0.081 $Y=0.054 $X2=0.081 $Y2=0.0245
.ends

.subckt PM_AO22x1_ASAP7_75t_R%A2 vss 16 7 11 4 1 6 3
c1 1 vss 0.00215374f $X=0.135 $Y=0.135
c2 3 vss 0.0775559f $X=0.135 $Y=0.0245
c3 4 vss 0.00213228f $X=0.135 $Y=0.072
c4 5 vss 0.00658094f $X=0.135 $Y=0.198
c5 6 vss 0.00461724f $X=0.135 $Y=0.135
r1 5 17 1.20989 $w=1.73902e-08 $l=1.03e-08 $layer=M1 $thickness=3.6e-08
+ $X=0.135 $Y=0.198 $X2=0.135 $Y2=0.1877
r2 4 13 6.16517 $w=1.44286e-08 $l=3.15e-08 $layer=M1 $thickness=3.6e-08
+ $X=0.135 $Y=0.072 $X2=0.135 $Y2=0.1035
r3 16 17 0.408082 $w=1.3e-08 $l=1.7e-09 $layer=M1 $thickness=3.6e-08 $X=0.134
+ $Y=0.186 $X2=0.135 $Y2=0.1877
r4 16 15 2.62338 $w=1.3e-08 $l=1.13e-08 $layer=M1 $thickness=3.6e-08 $X=0.134
+ $Y=0.186 $X2=0.135 $Y2=0.1747
r5 14 15 4.83869 $w=1.3e-08 $l=2.07e-08 $layer=M1 $thickness=3.6e-08 $X=0.135
+ $Y=0.154 $X2=0.135 $Y2=0.1747
r6 6 13 7.34548 $w=1.3e-08 $l=3.15e-08 $layer=M1 $thickness=3.6e-08 $X=0.135
+ $Y=0.135 $X2=0.135 $Y2=0.1035
r7 6 14 4.43061 $w=1.3e-08 $l=1.9e-08 $layer=M1 $thickness=3.6e-08 $X=0.135
+ $Y=0.135 $X2=0.135 $Y2=0.154
r8 1 9 10.4265 $w=1.765e-08 $layer=LIG $thickness=5.2e-08 $X=0.135 $Y=0.135
+ $X2=0.135 $Y2=0.135
r9 1 6 19.3796 $a=3.24e-16 $layer=V0LIG $X=0.135 $Y=0.135 $X2=0.135 $Y2=0.135
r10 11 10 16.4967 $w=2.1e-08 $l=4.85e-08 $layer=Gate_1 $thickness=5.6e-08
+ $X=0.135 $Y=0.216 $X2=0.135 $Y2=0.1675
r11 9 10 11.2416 $w=2.06615e-08 $l=3.25e-08 $layer=Gate_1 $thickness=5.6e-08
+ $X=0.135 $Y=0.135 $X2=0.135 $Y2=0.1675
r12 8 9 11.2416 $w=2.06615e-08 $l=3.25e-08 $layer=Gate_1 $thickness=5.6e-08
+ $X=0.135 $Y=0.1025 $X2=0.135 $Y2=0.135
r13 7 8 16.4967 $w=2.1e-08 $l=4.85e-08 $layer=Gate_1 $thickness=5.6e-08
+ $X=0.135 $Y=0.054 $X2=0.135 $Y2=0.1025
r14 7 3 10.0341 $w=2.1e-08 $l=2.95e-08 $layer=Gate_1 $thickness=5.6e-08
+ $X=0.135 $Y=0.054 $X2=0.135 $Y2=0.0245
.ends

.subckt PM_AO22x1_ASAP7_75t_R%Y vss 19 13 28 8 11 7
c1 1 vss 0.00876854f $X=0.432 $Y=0.0675
c2 2 vss 0.00881508f $X=0.432 $Y=0.2025
c3 7 vss 0.0385266f $X=0.4175 $Y=0.0675
c4 8 vss 0.0385358f $X=0.4175 $Y=0.2025
c5 9 vss 0.00627789f $X=0.4185 $Y=0.036
c6 10 vss 0.00618664f $X=0.459 $Y=0.234
c7 11 vss 0.00599523f $X=0.459 $Y=0.0855
r1 8 2 0.154321 $w=8.1e-08 $l=1.25e-08 $layer=P_src_drn $thickness=1e-09
+ $X=0.4175 $Y=0.2025 $X2=0.432 $Y2=0.2025
r2 28 8 0.0308642 $w=8.1e-08 $l=2.5e-09 $layer=P_src_drn $thickness=1e-09
+ $X=0.4146 $Y=0.2025 $X2=0.4175 $Y2=0.2025
r3 2 24 19.3796 $a=3.24e-16 $layer=V0LISD $X=0.432 $Y=0.2025 $X2=0.432 $Y2=0.234
r4 24 25 3.14806 $w=1.3e-08 $l=1.35e-08 $layer=M1 $thickness=3.6e-08 $X=0.432
+ $Y=0.234 $X2=0.4455 $Y2=0.234
r5 10 22 3.01711 $w=1.55e-08 $l=1.8e-08 $layer=M1 $thickness=3.6e-08 $X=0.459
+ $Y=0.234 $X2=0.459 $Y2=0.216
r6 10 25 1.96775 $w=1.63333e-08 $l=1.35e-08 $layer=M1 $thickness=3.6e-08
+ $X=0.459 $Y=0.234 $X2=0.4455 $Y2=0.234
r7 21 22 9.44419 $w=1.3e-08 $l=4.05e-08 $layer=M1 $thickness=3.6e-08 $X=0.459
+ $Y=0.1755 $X2=0.459 $Y2=0.216
r8 20 21 7.98675 $w=1.3e-08 $l=3.43e-08 $layer=M1 $thickness=3.6e-08 $X=0.459
+ $Y=0.1412 $X2=0.459 $Y2=0.1755
r9 19 20 0.757867 $w=1.3e-08 $l=3.2e-09 $layer=M1 $thickness=3.6e-08 $X=0.459
+ $Y=0.138 $X2=0.459 $Y2=0.1412
r10 19 18 1.45744 $w=1.3e-08 $l=6.3e-09 $layer=M1 $thickness=3.6e-08 $X=0.459
+ $Y=0.138 $X2=0.459 $Y2=0.1317
r11 11 17 10.3626 $w=1.39091e-08 $l=4.95e-08 $layer=M1 $thickness=3.6e-08
+ $X=0.459 $Y=0.0855 $X2=0.459 $Y2=0.036
r12 11 18 10.785 $w=1.3e-08 $l=4.62e-08 $layer=M1 $thickness=3.6e-08 $X=0.459
+ $Y=0.0855 $X2=0.459 $Y2=0.1317
r13 16 17 1.96775 $w=1.63333e-08 $l=1.35e-08 $layer=M1 $thickness=3.6e-08
+ $X=0.4455 $Y=0.036 $X2=0.459 $Y2=0.036
r14 15 16 3.14806 $w=1.3e-08 $l=1.35e-08 $layer=M1 $thickness=3.6e-08 $X=0.432
+ $Y=0.036 $X2=0.4455 $Y2=0.036
r15 14 15 2.56509 $w=1.3e-08 $l=1.1e-08 $layer=M1 $thickness=3.6e-08 $X=0.421
+ $Y=0.036 $X2=0.432 $Y2=0.036
r16 9 14 0.582974 $w=1.3e-08 $l=2.5e-09 $layer=M1 $thickness=3.6e-08 $X=0.4185
+ $Y=0.036 $X2=0.421 $Y2=0.036
r17 1 15 19.3796 $a=3.24e-16 $layer=V0LISD $X=0.432 $Y=0.0675 $X2=0.432
+ $Y2=0.036
r18 7 1 0.154321 $w=8.1e-08 $l=1.25e-08 $layer=N_src_drn $thickness=1e-09
+ $X=0.4175 $Y=0.0675 $X2=0.432 $Y2=0.0675
r19 13 7 0.0308642 $w=8.1e-08 $l=2.5e-09 $layer=N_src_drn $thickness=1e-09
+ $X=0.4146 $Y=0.0675 $X2=0.4175 $Y2=0.0675
.ends

.subckt PM_AO22x1_ASAP7_75t_R%7 vss 20 26 50 51 54 55 3 15 10 4 16 11 17 12 14
+ 1 19 9
c1 1 vss 0.00450838f $X=0.405 $Y=0.135
c2 3 vss 0.00531502f $X=0.162 $Y=0.054
c3 4 vss 0.00813671f $X=0.216 $Y=0.216
c4 9 vss 0.0846246f $X=0.405 $Y=0.0245
c5 10 vss 0.00383663f $X=0.1475 $Y=0.054
c6 11 vss 0.0047889f $X=0.2015 $Y=0.216
c7 12 vss 0.00322905f $X=0.351 $Y=0.036
c8 13 vss 0.000403004f $X=0.351 $Y=0.135
c9 14 vss 0.00205431f $X=0.351 $Y=0.198
c10 15 vss 0.0237863f $X=0.3145 $Y=0.036
c11 16 vss 0.0123245f $X=0.3145 $Y=0.198
c12 17 vss 0.00419844f $X=0.351 $Y=0.1035
c13 18 vss 0.00213495f $X=0.351 $Y=0.154
c14 19 vss 0.00194003f $X=0.378 $Y=0.135
r1 55 53 0.0462963 $w=5.4e-08 $l=2.5e-09 $layer=P_src_drn $thickness=1e-09
+ $X=0.2333 $Y=0.216 $X2=0.2305 $Y2=0.216
r2 4 53 0.268519 $w=5.4e-08 $l=1.45e-08 $layer=P_src_drn $thickness=1e-09
+ $X=0.216 $Y=0.216 $X2=0.2305 $Y2=0.216
r3 11 4 0.268519 $w=5.4e-08 $l=1.45e-08 $layer=P_src_drn $thickness=1e-09
+ $X=0.2015 $Y=0.216 $X2=0.216 $Y2=0.216
r4 54 11 0.0462963 $w=5.4e-08 $l=2.5e-09 $layer=P_src_drn $thickness=1e-09
+ $X=0.1986 $Y=0.216 $X2=0.2015 $Y2=0.216
r5 51 49 0.0462963 $w=5.4e-08 $l=2.5e-09 $layer=N_src_drn $thickness=1e-09
+ $X=0.1793 $Y=0.054 $X2=0.1765 $Y2=0.054
r6 3 49 0.268519 $w=5.4e-08 $l=1.45e-08 $layer=N_src_drn $thickness=1e-09
+ $X=0.162 $Y=0.054 $X2=0.1765 $Y2=0.054
r7 10 3 0.268519 $w=5.4e-08 $l=1.45e-08 $layer=N_src_drn $thickness=1e-09
+ $X=0.1475 $Y=0.054 $X2=0.162 $Y2=0.054
r8 50 10 0.0462963 $w=5.4e-08 $l=2.5e-09 $layer=N_src_drn $thickness=1e-09
+ $X=0.1446 $Y=0.054 $X2=0.1475 $Y2=0.054
r9 4 46 19.3796 $a=3.24e-16 $layer=V0LISD $X=0.216 $Y=0.216 $X2=0.216 $Y2=0.198
r10 3 39 19.3796 $a=3.24e-16 $layer=V0LISD $X=0.162 $Y=0.054 $X2=0.162 $Y2=0.036
r11 46 47 3.14806 $w=1.3e-08 $l=1.35e-08 $layer=M1 $thickness=3.6e-08 $X=0.216
+ $Y=0.198 $X2=0.2295 $Y2=0.198
r12 44 47 3.14806 $w=1.3e-08 $l=1.35e-08 $layer=M1 $thickness=3.6e-08 $X=0.243
+ $Y=0.198 $X2=0.2295 $Y2=0.198
r13 43 44 5.82974 $w=1.3e-08 $l=2.5e-08 $layer=M1 $thickness=3.6e-08 $X=0.268
+ $Y=0.198 $X2=0.243 $Y2=0.198
r14 42 43 4.08082 $w=1.3e-08 $l=1.75e-08 $layer=M1 $thickness=3.6e-08 $X=0.2855
+ $Y=0.198 $X2=0.268 $Y2=0.198
r15 16 42 6.7625 $w=1.3e-08 $l=2.9e-08 $layer=M1 $thickness=3.6e-08 $X=0.3145
+ $Y=0.198 $X2=0.2855 $Y2=0.198
r16 39 40 3.14806 $w=1.3e-08 $l=1.35e-08 $layer=M1 $thickness=3.6e-08 $X=0.162
+ $Y=0.036 $X2=0.1755 $Y2=0.036
r17 37 40 3.14806 $w=1.3e-08 $l=1.35e-08 $layer=M1 $thickness=3.6e-08 $X=0.189
+ $Y=0.036 $X2=0.1755 $Y2=0.036
r18 36 37 2.56509 $w=1.3e-08 $l=1.1e-08 $layer=M1 $thickness=3.6e-08 $X=0.2
+ $Y=0.036 $X2=0.189 $Y2=0.036
r19 35 36 4.19742 $w=1.3e-08 $l=1.8e-08 $layer=M1 $thickness=3.6e-08 $X=0.218
+ $Y=0.036 $X2=0.2 $Y2=0.036
r20 34 35 9.91056 $w=1.3e-08 $l=4.25e-08 $layer=M1 $thickness=3.6e-08 $X=0.2605
+ $Y=0.036 $X2=0.218 $Y2=0.036
r21 15 34 12.5922 $w=1.3e-08 $l=5.4e-08 $layer=M1 $thickness=3.6e-08 $X=0.3145
+ $Y=0.036 $X2=0.2605 $Y2=0.036
r22 14 33 3.36447 $w=1.71023e-08 $l=2.15e-08 $layer=M1 $thickness=3.6e-08
+ $X=0.351 $Y=0.198 $X2=0.351 $Y2=0.1765
r23 14 16 6.86231 $w=1.42329e-08 $l=3.65e-08 $layer=M1 $thickness=3.6e-08
+ $X=0.351 $Y=0.198 $X2=0.3145 $Y2=0.198
r24 12 32 2.5483 $w=1.79e-08 $l=1.8e-08 $layer=M1 $thickness=3.6e-08 $X=0.351
+ $Y=0.036 $X2=0.351 $Y2=0.054
r25 12 15 6.86231 $w=1.42329e-08 $l=3.65e-08 $layer=M1 $thickness=3.6e-08
+ $X=0.351 $Y=0.036 $X2=0.3145 $Y2=0.036
r26 18 33 5.24677 $w=1.3e-08 $l=2.25e-08 $layer=M1 $thickness=3.6e-08 $X=0.351
+ $Y=0.154 $X2=0.351 $Y2=0.1765
r27 31 32 4.19742 $w=1.3e-08 $l=1.8e-08 $layer=M1 $thickness=3.6e-08 $X=0.351
+ $Y=0.072 $X2=0.351 $Y2=0.054
r28 17 31 7.34548 $w=1.3e-08 $l=3.15e-08 $layer=M1 $thickness=3.6e-08 $X=0.351
+ $Y=0.1035 $X2=0.351 $Y2=0.072
r29 13 19 5.11582 $w=1.46667e-08 $l=2.7e-08 $layer=M1 $thickness=3.6e-08
+ $X=0.351 $Y=0.135 $X2=0.378 $Y2=0.135
r30 13 17 6.16517 $w=1.44286e-08 $l=3.15e-08 $layer=M1 $thickness=3.6e-08
+ $X=0.351 $Y=0.135 $X2=0.351 $Y2=0.1035
r31 13 18 3.2503 $w=1.53684e-08 $l=1.9e-08 $layer=M1 $thickness=3.6e-08
+ $X=0.351 $Y=0.135 $X2=0.351 $Y2=0.154
r32 19 28 6.29612 $w=1.3e-08 $l=2.7e-08 $layer=M1 $thickness=3.6e-08 $X=0.378
+ $Y=0.135 $X2=0.405 $Y2=0.135
r33 1 23 10.4265 $w=1.765e-08 $layer=LIG $thickness=5.2e-08 $X=0.405 $Y=0.135
+ $X2=0.405 $Y2=0.135
r34 1 28 19.3796 $a=3.24e-16 $layer=V0LIG $X=0.405 $Y=0.135 $X2=0.405 $Y2=0.135
r35 26 25 14.6259 $w=2.1e-08 $l=4.3e-08 $layer=Gate_1 $thickness=5.6e-08
+ $X=0.405 $Y=0.2025 $X2=0.405 $Y2=0.1595
r36 24 25 2.7211 $w=2.1e-08 $l=8e-09 $layer=Gate_1 $thickness=5.6e-08 $X=0.405
+ $Y=0.1515 $X2=0.405 $Y2=0.1595
r37 23 24 5.79936 $w=2.03333e-08 $l=1.65e-08 $layer=Gate_1 $thickness=5.6e-08
+ $X=0.405 $Y=0.135 $X2=0.405 $Y2=0.1515
r38 22 23 5.79936 $w=2.03333e-08 $l=1.65e-08 $layer=Gate_1 $thickness=5.6e-08
+ $X=0.405 $Y=0.1185 $X2=0.405 $Y2=0.135
r39 21 22 2.7211 $w=2.1e-08 $l=8e-09 $layer=Gate_1 $thickness=5.6e-08 $X=0.405
+ $Y=0.1105 $X2=0.405 $Y2=0.1185
r40 20 21 14.6259 $w=2.1e-08 $l=4.3e-08 $layer=Gate_1 $thickness=5.6e-08
+ $X=0.405 $Y=0.0675 $X2=0.405 $Y2=0.1105
r41 20 9 14.6259 $w=2.1e-08 $l=4.3e-08 $layer=Gate_1 $thickness=5.6e-08
+ $X=0.405 $Y=0.0675 $X2=0.405 $Y2=0.0245
.ends

.subckt PM_AO22x1_ASAP7_75t_R%B2 vss 11 5 9 1 4 3
c1 1 vss 0.00463461f $X=0.189 $Y=0.135
c2 3 vss 0.0500889f $X=0.189 $Y=0.0245
c3 4 vss 0.00351568f $X=0.189 $Y=0.0977
r1 12 13 3.32295 $w=1.3e-08 $l=1.43e-08 $layer=M1 $thickness=3.6e-08 $X=0.189
+ $Y=0.1207 $X2=0.189 $Y2=0.135
r2 11 12 1.34084 $w=1.3e-08 $l=5.7e-09 $layer=M1 $thickness=3.6e-08 $X=0.188
+ $Y=0.115 $X2=0.189 $Y2=0.1207
r3 11 4 4.02252 $w=1.3e-08 $l=1.73e-08 $layer=M1 $thickness=3.6e-08 $X=0.188
+ $Y=0.115 $X2=0.189 $Y2=0.0977
r4 1 7 10.4265 $w=1.765e-08 $layer=LIG $thickness=5.2e-08 $X=0.189 $Y=0.135
+ $X2=0.189 $Y2=0.135
r5 1 13 19.3796 $a=3.24e-16 $layer=V0LIG $X=0.189 $Y=0.135 $X2=0.189 $Y2=0.135
r6 9 8 16.4967 $w=2.1e-08 $l=4.85e-08 $layer=Gate_1 $thickness=5.6e-08 $X=0.189
+ $Y=0.216 $X2=0.189 $Y2=0.1675
r7 7 8 11.2416 $w=2.06615e-08 $l=3.25e-08 $layer=Gate_1 $thickness=5.6e-08
+ $X=0.189 $Y=0.135 $X2=0.189 $Y2=0.1675
r8 6 7 11.2416 $w=2.06615e-08 $l=3.25e-08 $layer=Gate_1 $thickness=5.6e-08
+ $X=0.189 $Y=0.1025 $X2=0.189 $Y2=0.135
r9 5 6 16.4967 $w=2.1e-08 $l=4.85e-08 $layer=Gate_1 $thickness=5.6e-08 $X=0.189
+ $Y=0.054 $X2=0.189 $Y2=0.1025
r10 5 3 10.0341 $w=2.1e-08 $l=2.95e-08 $layer=Gate_1 $thickness=5.6e-08
+ $X=0.189 $Y=0.054 $X2=0.189 $Y2=0.0245
.ends

.subckt PM_AO22x1_ASAP7_75t_R%B1 vss 5 6 12 3 4
c1 1 vss 0.00325027f $X=0.243 $Y=0.135
c2 3 vss 0.0850581f $X=0.243 $Y=0.0245
c3 4 vss 0.00354253f $X=0.2605 $Y=0.0752
c4 5 vss 0.00426086f $X=0.243 $Y=0.081
r1 4 17 0.126622 $w=4.8e-08 $l=5.5e-09 $layer=M1 $thickness=3.6e-08 $X=0.2605
+ $Y=0.0752 $X2=0.2605 $Y2=0.0807
r2 14 15 7.28718 $w=1.3e-08 $l=3.13e-08 $layer=M1 $thickness=3.6e-08 $X=0.243
+ $Y=0.1037 $X2=0.243 $Y2=0.135
r3 5 14 5.24677 $w=1.3e-08 $l=2.25e-08 $layer=M1 $thickness=3.6e-08 $X=0.243
+ $Y=0.081 $X2=0.243 $Y2=0.1037
r4 5 17 0.064053 $w=3.05e-08 $l=1.75071e-08 $layer=M1 $thickness=3.6e-08
+ $X=0.243 $Y=0.081 $X2=0.2605 $Y2=0.0807
r5 1 9 10.4265 $w=1.765e-08 $layer=LIG $thickness=5.2e-08 $X=0.243 $Y=0.135
+ $X2=0.243 $Y2=0.135
r6 1 15 19.3796 $a=3.24e-16 $layer=V0LIG $X=0.243 $Y=0.135 $X2=0.243 $Y2=0.135
r7 12 11 14.6259 $w=2.1e-08 $l=4.3e-08 $layer=Gate_1 $thickness=5.6e-08
+ $X=0.243 $Y=0.216 $X2=0.243 $Y2=0.173
r8 10 11 7.31297 $w=2.1e-08 $l=2.15e-08 $layer=Gate_1 $thickness=5.6e-08
+ $X=0.243 $Y=0.1515 $X2=0.243 $Y2=0.173
r9 9 10 5.79936 $w=2.03333e-08 $l=1.65e-08 $layer=Gate_1 $thickness=5.6e-08
+ $X=0.243 $Y=0.135 $X2=0.243 $Y2=0.1515
r10 8 9 5.79936 $w=2.03333e-08 $l=1.65e-08 $layer=Gate_1 $thickness=5.6e-08
+ $X=0.243 $Y=0.1185 $X2=0.243 $Y2=0.135
r11 7 8 7.31297 $w=2.1e-08 $l=2.15e-08 $layer=Gate_1 $thickness=5.6e-08
+ $X=0.243 $Y=0.097 $X2=0.243 $Y2=0.1185
r12 6 7 14.6259 $w=2.1e-08 $l=4.3e-08 $layer=Gate_1 $thickness=5.6e-08 $X=0.243
+ $Y=0.054 $X2=0.243 $Y2=0.097
r13 6 3 10.0341 $w=2.1e-08 $l=2.95e-08 $layer=Gate_1 $thickness=5.6e-08
+ $X=0.243 $Y=0.054 $X2=0.243 $Y2=0.0245
.ends

* End of included file AO22x1_ASAP7_75t_R.pex.sp.pex

*
.subckt AO22x1_ASAP7_75t_CUSTOM_4_25_0_7 VSS VDD A1 A2 B2 B1 Y
*
* VSS VSS
* VDD VDD
* A1 A1
* A2 A2
* B2 B2
* B1 B1
* Y Y
*
*

M0 noxref_10 N_M0_g VSS VSS nmos_rvt L=2e-08 W=5.4e-08 nfin=2 $X=0.071 $Y=0.027
M1 N_M1_d N_M1_g noxref_10 VSS nmos_rvt L=2e-08 W=5.4e-08 nfin=2 $X=0.125
+ $Y=0.027
M2 noxref_11 N_M2_g N_M2_s VSS nmos_rvt L=2e-08 W=5.4e-08 nfin=2 $X=0.179
+ $Y=0.027
M3 VSS N_M3_g noxref_11 VSS nmos_rvt L=2e-08 W=5.4e-08 nfin=2 $X=0.233 $Y=0.027
M4 N_M4_d N_M4_g VSS VSS nmos_rvt L=2e-08 W=8.1e-08 nfin=3 $X=0.395 $Y=0.027
M5 VDD N_M5_g noxref_8 VDD pmos_rvt L=2e-08 W=5.4e-08 nfin=2 $X=0.071 $Y=0.189
M6 noxref_8 N_M6_g VDD VDD pmos_rvt L=2e-08 W=5.4e-08 nfin=2 $X=0.125 $Y=0.189
M7 N_M7_d N_M7_g noxref_8 VDD pmos_rvt L=2e-08 W=5.4e-08 nfin=2 $X=0.179
+ $Y=0.189
M8 noxref_8 N_M8_g N_M8_s VDD pmos_rvt L=2e-08 W=5.4e-08 nfin=2 $X=0.233
+ $Y=0.189
M9 N_M9_d N_M9_g VDD VDD pmos_rvt L=2e-08 W=8.1e-08 nfin=3 $X=0.395 $Y=0.162

* .include "AO22x1_ASAP7_75t_R.pex.sp.pxi"

* Start of included file AO22x1_ASAP7_75t_R.pex.sp.pxi
x_PM_AO22x1_ASAP7_75t_R%A1 vss A1 N_M0_g N_M5_g N_A1_3 PM_AO22x1_ASAP7_75t_R%A1
x_PM_AO22x1_ASAP7_75t_R%A2 vss A2 N_M1_g N_M6_g N_A2_4 N_A2_1 N_A2_6 N_A2_3
+ PM_AO22x1_ASAP7_75t_R%A2
cc_1 N_A2_4 N_A1_3 0.000650897f $X=0.135 $Y=0.072
cc_2 N_A2_1 N_A1_3 0.00165802f $X=0.135 $Y=0.135
cc_3 N_A2_6 N_A1_3 0.0024868f $X=0.135 $Y=0.135
cc_4 N_A2_3 N_A1_3 0.0108587f $X=0.135 $Y=0.0245
x_PM_AO22x1_ASAP7_75t_R%Y vss Y N_M4_d N_M9_d N_Y_8 N_Y_11 N_Y_7
+ PM_AO22x1_ASAP7_75t_R%Y
cc_5 N_Y_8 N_7_17 0.000500624f $X=0.4175 $Y=0.2025
cc_6 N_Y_8 N_7_12 0.000579456f $X=0.4175 $Y=0.2025
cc_7 N_Y_8 N_7_14 0.000579491f $X=0.4175 $Y=0.2025
cc_8 N_Y_8 N_7_1 0.00261678f $X=0.4175 $Y=0.2025
cc_9 N_Y_11 N_7_19 0.00340811f $X=0.459 $Y=0.0855
cc_10 N_Y_7 N_7_9 0.0148654f $X=0.4175 $Y=0.0675
cc_11 N_Y_8 N_7_9 0.0571473f $X=0.4175 $Y=0.2025
x_PM_AO22x1_ASAP7_75t_R%7 vss N_M4_g N_M9_g N_M1_d N_M2_s N_M7_d N_M8_s N_7_3
+ N_7_15 N_7_10 N_7_4 N_7_16 N_7_11 N_7_17 N_7_12 N_7_14 N_7_1 N_7_19 N_7_9
+ PM_AO22x1_ASAP7_75t_R%7
cc_12 N_7_3 N_A2_3 0.00155412f $X=0.162 $Y=0.054
cc_13 N_7_15 N_A2_4 0.00382673f $X=0.3145 $Y=0.036
cc_14 N_7_10 N_A2_3 0.0267097f $X=0.1475 $Y=0.054
cc_15 N_7_4 N_B2_3 0.000445337f $X=0.216 $Y=0.216
cc_16 N_7_16 N_B2_4 0.000570346f $X=0.3145 $Y=0.198
cc_17 N_7_11 N_B2_1 0.000576187f $X=0.2015 $Y=0.216
cc_18 N_7_3 N_B2_3 0.000814454f $X=0.162 $Y=0.054
cc_19 N_7_15 N_B2_4 0.00111864f $X=0.3145 $Y=0.036
cc_20 N_7_3 N_B2_4 0.0023375f $X=0.162 $Y=0.054
cc_21 N_7_10 N_B2_3 0.0107978f $X=0.1475 $Y=0.054
cc_22 N_7_11 N_B2_3 0.0404865f $X=0.2015 $Y=0.216
cc_23 N_7_4 N_B1_3 0.000434905f $X=0.216 $Y=0.216
cc_24 N_7_17 N_B1_3 0.000447794f $X=0.351 $Y=0.1035
cc_25 N_7_16 N_B1_3 0.000575152f $X=0.3145 $Y=0.198
cc_26 N_7_16 B1 0.00344657f $X=0.3145 $Y=0.198
cc_27 N_7_15 N_B1_4 0.00604524f $X=0.3145 $Y=0.036
cc_28 N_7_11 N_B1_3 0.0269653f $X=0.2015 $Y=0.216
x_PM_AO22x1_ASAP7_75t_R%B2 vss B2 N_M2_g N_M7_g N_B2_1 N_B2_4 N_B2_3
+ PM_AO22x1_ASAP7_75t_R%B2
cc_29 N_B2_1 N_A2_1 0.00148097f $X=0.189 $Y=0.135
cc_30 N_B2_4 N_A2_6 0.00352204f $X=0.189 $Y=0.0977
cc_31 N_B2_3 N_A2_3 0.00854423f $X=0.189 $Y=0.0245
x_PM_AO22x1_ASAP7_75t_R%B1 vss B1 N_M3_g N_M8_g N_B1_3 N_B1_4
+ PM_AO22x1_ASAP7_75t_R%B1
cc_32 N_B1_3 N_B2_1 0.00157857f $X=0.243 $Y=0.0245
cc_33 B1 N_B2_4 0.00320466f $X=0.243 $Y=0.081
cc_34 N_B1_3 N_B2_3 0.00958738f $X=0.243 $Y=0.0245

* End of included file AO22x1_ASAP7_75t_R.pex.sp.pxi
.ends

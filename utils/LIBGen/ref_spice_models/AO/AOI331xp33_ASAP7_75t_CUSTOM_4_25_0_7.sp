.subckt PM_AOI331xp33_ASAP7_75t_R%A3 vss 13 5 11 4
c1 1 vss 0.00715998f $X=0.081 $Y=0.135
c2 3 vss 0.141681f $X=0.081 $Y=0.0245
c3 4 vss 0.0151937f $X=0.081 $Y=0.0742
r1 14 15 3.32295 $w=1.3e-08 $l=1.43e-08 $layer=M1 $thickness=3.6e-08 $X=0.081
+ $Y=0.1207 $X2=0.081 $Y2=0.135
r2 13 14 1.34084 $w=1.3e-08 $l=5.7e-09 $layer=M1 $thickness=3.6e-08 $X=0.081
+ $Y=0.115 $X2=0.081 $Y2=0.1207
r3 13 4 9.50248 $w=1.3e-08 $l=4.08e-08 $layer=M1 $thickness=3.6e-08 $X=0.081
+ $Y=0.115 $X2=0.081 $Y2=0.0742
r4 1 8 10.4265 $w=1.765e-08 $layer=LIG $thickness=5.2e-08 $X=0.081 $Y=0.135
+ $X2=0.081 $Y2=0.135
r5 1 15 19.3796 $a=3.24e-16 $layer=V0LIG $X=0.081 $Y=0.135 $X2=0.081 $Y2=0.135
r6 11 10 14.6259 $w=2.1e-08 $l=4.3e-08 $layer=Gate_1 $thickness=5.6e-08
+ $X=0.081 $Y=0.2025 $X2=0.081 $Y2=0.1595
r7 9 10 2.7211 $w=2.1e-08 $l=8e-09 $layer=Gate_1 $thickness=5.6e-08 $X=0.081
+ $Y=0.1515 $X2=0.081 $Y2=0.1595
r8 8 9 5.79936 $w=2.03333e-08 $l=1.65e-08 $layer=Gate_1 $thickness=5.6e-08
+ $X=0.081 $Y=0.135 $X2=0.081 $Y2=0.1515
r9 7 8 5.79936 $w=2.03333e-08 $l=1.65e-08 $layer=Gate_1 $thickness=5.6e-08
+ $X=0.081 $Y=0.1185 $X2=0.081 $Y2=0.135
r10 6 7 2.7211 $w=2.1e-08 $l=8e-09 $layer=Gate_1 $thickness=5.6e-08 $X=0.081
+ $Y=0.1105 $X2=0.081 $Y2=0.1185
r11 5 6 14.6259 $w=2.1e-08 $l=4.3e-08 $layer=Gate_1 $thickness=5.6e-08 $X=0.081
+ $Y=0.0675 $X2=0.081 $Y2=0.1105
r12 5 3 14.6259 $w=2.1e-08 $l=4.3e-08 $layer=Gate_1 $thickness=5.6e-08 $X=0.081
+ $Y=0.0675 $X2=0.081 $Y2=0.0245
.ends

.subckt PM_AOI331xp33_ASAP7_75t_R%A2 vss 11 5 9 3 4
c1 1 vss 0.00483454f $X=0.135 $Y=0.135
c2 3 vss 0.121615f $X=0.135 $Y=0.0245
c3 4 vss 0.0114315f $X=0.135 $Y=0.0922
r1 12 13 3.32295 $w=1.3e-08 $l=1.43e-08 $layer=M1 $thickness=3.6e-08 $X=0.135
+ $Y=0.1207 $X2=0.135 $Y2=0.135
r2 11 12 1.34084 $w=1.3e-08 $l=5.7e-09 $layer=M1 $thickness=3.6e-08 $X=0.135
+ $Y=0.115 $X2=0.135 $Y2=0.1207
r3 11 4 5.30507 $w=1.3e-08 $l=2.28e-08 $layer=M1 $thickness=3.6e-08 $X=0.135
+ $Y=0.115 $X2=0.135 $Y2=0.0922
r4 1 7 10.4265 $w=1.765e-08 $layer=LIG $thickness=5.2e-08 $X=0.135 $Y=0.135
+ $X2=0.135 $Y2=0.135
r5 1 13 19.3796 $a=3.24e-16 $layer=V0LIG $X=0.135 $Y=0.135 $X2=0.135 $Y2=0.135
r6 9 8 16.4967 $w=2.1e-08 $l=4.85e-08 $layer=Gate_1 $thickness=5.6e-08 $X=0.135
+ $Y=0.2025 $X2=0.135 $Y2=0.154
r7 7 8 6.6497 $w=2.04211e-08 $l=1.9e-08 $layer=Gate_1 $thickness=5.6e-08
+ $X=0.135 $Y=0.135 $X2=0.135 $Y2=0.154
r8 6 7 6.6497 $w=2.04211e-08 $l=1.9e-08 $layer=Gate_1 $thickness=5.6e-08
+ $X=0.135 $Y=0.116 $X2=0.135 $Y2=0.135
r9 5 6 16.4967 $w=2.1e-08 $l=4.85e-08 $layer=Gate_1 $thickness=5.6e-08 $X=0.135
+ $Y=0.0675 $X2=0.135 $Y2=0.116
r10 5 3 14.6259 $w=2.1e-08 $l=4.3e-08 $layer=Gate_1 $thickness=5.6e-08 $X=0.135
+ $Y=0.0675 $X2=0.135 $Y2=0.0245
.ends

.subckt PM_AOI331xp33_ASAP7_75t_R%B2 vss 11 5 9 4 3
c1 1 vss 0.00486166f $X=0.297 $Y=0.135
c2 3 vss 0.121113f $X=0.297 $Y=0.0245
c3 4 vss 0.00519113f $X=0.297 $Y=0.0922
r1 12 13 3.32295 $w=1.3e-08 $l=1.43e-08 $layer=M1 $thickness=3.6e-08 $X=0.297
+ $Y=0.1207 $X2=0.297 $Y2=0.135
r2 11 12 1.34084 $w=1.3e-08 $l=5.7e-09 $layer=M1 $thickness=3.6e-08 $X=0.296
+ $Y=0.115 $X2=0.297 $Y2=0.1207
r3 11 4 5.30507 $w=1.3e-08 $l=2.28e-08 $layer=M1 $thickness=3.6e-08 $X=0.296
+ $Y=0.115 $X2=0.297 $Y2=0.0922
r4 1 7 10.4265 $w=1.765e-08 $layer=LIG $thickness=5.2e-08 $X=0.297 $Y=0.135
+ $X2=0.297 $Y2=0.135
r5 1 13 19.3796 $a=3.24e-16 $layer=V0LIG $X=0.297 $Y=0.135 $X2=0.297 $Y2=0.135
r6 9 8 16.4967 $w=2.1e-08 $l=4.85e-08 $layer=Gate_1 $thickness=5.6e-08 $X=0.297
+ $Y=0.2025 $X2=0.297 $Y2=0.154
r7 7 8 6.6497 $w=2.04211e-08 $l=1.9e-08 $layer=Gate_1 $thickness=5.6e-08
+ $X=0.297 $Y=0.135 $X2=0.297 $Y2=0.154
r8 6 7 6.6497 $w=2.04211e-08 $l=1.9e-08 $layer=Gate_1 $thickness=5.6e-08
+ $X=0.297 $Y=0.116 $X2=0.297 $Y2=0.135
r9 5 6 16.4967 $w=2.1e-08 $l=4.85e-08 $layer=Gate_1 $thickness=5.6e-08 $X=0.297
+ $Y=0.0675 $X2=0.297 $Y2=0.116
r10 5 3 14.6259 $w=2.1e-08 $l=4.3e-08 $layer=Gate_1 $thickness=5.6e-08 $X=0.297
+ $Y=0.0675 $X2=0.297 $Y2=0.0245
.ends

.subckt PM_AOI331xp33_ASAP7_75t_R%B3 vss 11 5 9 4 3
c1 1 vss 0.00608978f $X=0.351 $Y=0.135
c2 3 vss 0.14004f $X=0.351 $Y=0.0245
c3 4 vss 0.00533962f $X=0.351 $Y=0.0922
r1 12 13 3.32295 $w=1.3e-08 $l=1.43e-08 $layer=M1 $thickness=3.6e-08 $X=0.351
+ $Y=0.1207 $X2=0.351 $Y2=0.135
r2 11 12 1.34084 $w=1.3e-08 $l=5.7e-09 $layer=M1 $thickness=3.6e-08 $X=0.349
+ $Y=0.115 $X2=0.351 $Y2=0.1207
r3 11 4 5.30507 $w=1.3e-08 $l=2.28e-08 $layer=M1 $thickness=3.6e-08 $X=0.349
+ $Y=0.115 $X2=0.351 $Y2=0.0922
r4 1 7 10.4265 $w=1.765e-08 $layer=LIG $thickness=5.2e-08 $X=0.351 $Y=0.135
+ $X2=0.351 $Y2=0.135
r5 1 13 19.3796 $a=3.24e-16 $layer=V0LIG $X=0.351 $Y=0.135 $X2=0.351 $Y2=0.135
r6 9 8 16.4967 $w=2.1e-08 $l=4.85e-08 $layer=Gate_1 $thickness=5.6e-08 $X=0.351
+ $Y=0.2025 $X2=0.351 $Y2=0.154
r7 7 8 6.6497 $w=2.04211e-08 $l=1.9e-08 $layer=Gate_1 $thickness=5.6e-08
+ $X=0.351 $Y=0.135 $X2=0.351 $Y2=0.154
r8 6 7 6.6497 $w=2.04211e-08 $l=1.9e-08 $layer=Gate_1 $thickness=5.6e-08
+ $X=0.351 $Y=0.116 $X2=0.351 $Y2=0.135
r9 5 6 16.4967 $w=2.1e-08 $l=4.85e-08 $layer=Gate_1 $thickness=5.6e-08 $X=0.351
+ $Y=0.0675 $X2=0.351 $Y2=0.116
r10 5 3 14.6259 $w=2.1e-08 $l=4.3e-08 $layer=Gate_1 $thickness=5.6e-08 $X=0.351
+ $Y=0.0675 $X2=0.351 $Y2=0.0245
.ends

.subckt PM_AOI331xp33_ASAP7_75t_R%C1 vss 13 5 11 4 3 1
c1 1 vss 0.00403073f $X=0.405 $Y=0.135
c2 3 vss 0.0891177f $X=0.405 $Y=0.0245
c3 4 vss 0.00655604f $X=0.405 $Y=0.0922
r1 14 15 3.32295 $w=1.3e-08 $l=1.43e-08 $layer=M1 $thickness=3.6e-08 $X=0.405
+ $Y=0.1207 $X2=0.405 $Y2=0.135
r2 13 14 1.34084 $w=1.3e-08 $l=5.7e-09 $layer=M1 $thickness=3.6e-08 $X=0.403
+ $Y=0.115 $X2=0.405 $Y2=0.1207
r3 13 4 5.30507 $w=1.3e-08 $l=2.28e-08 $layer=M1 $thickness=3.6e-08 $X=0.403
+ $Y=0.115 $X2=0.405 $Y2=0.0922
r4 1 8 10.4265 $w=1.765e-08 $layer=LIG $thickness=5.2e-08 $X=0.405 $Y=0.135
+ $X2=0.405 $Y2=0.135
r5 1 15 19.3796 $a=3.24e-16 $layer=V0LIG $X=0.405 $Y=0.135 $X2=0.405 $Y2=0.135
r6 11 10 14.6259 $w=2.1e-08 $l=4.3e-08 $layer=Gate_1 $thickness=5.6e-08
+ $X=0.405 $Y=0.2025 $X2=0.405 $Y2=0.1595
r7 9 10 2.7211 $w=2.1e-08 $l=8e-09 $layer=Gate_1 $thickness=5.6e-08 $X=0.405
+ $Y=0.1515 $X2=0.405 $Y2=0.1595
r8 8 9 5.79936 $w=2.03333e-08 $l=1.65e-08 $layer=Gate_1 $thickness=5.6e-08
+ $X=0.405 $Y=0.135 $X2=0.405 $Y2=0.1515
r9 7 8 5.79936 $w=2.03333e-08 $l=1.65e-08 $layer=Gate_1 $thickness=5.6e-08
+ $X=0.405 $Y=0.1185 $X2=0.405 $Y2=0.135
r10 6 7 2.7211 $w=2.1e-08 $l=8e-09 $layer=Gate_1 $thickness=5.6e-08 $X=0.405
+ $Y=0.1105 $X2=0.405 $Y2=0.1185
r11 5 6 14.6259 $w=2.1e-08 $l=4.3e-08 $layer=Gate_1 $thickness=5.6e-08 $X=0.405
+ $Y=0.0675 $X2=0.405 $Y2=0.1105
r12 5 3 14.6259 $w=2.1e-08 $l=4.3e-08 $layer=Gate_1 $thickness=5.6e-08 $X=0.405
+ $Y=0.0675 $X2=0.405 $Y2=0.0245
.ends

.subckt PM_AOI331xp33_ASAP7_75t_R%Y vss 37 19 20 43 48 1 10 15 3 2 11 12 16
c1 1 vss 0.00628023f $X=0.216 $Y=0.0675
c2 2 vss 0.00811314f $X=0.432 $Y=0.0675
c3 3 vss 0.00913289f $X=0.432 $Y=0.2025
c4 10 vss 0.00265451f $X=0.2015 $Y=0.0675
c5 11 vss 0.0378846f $X=0.4175 $Y=0.0675
c6 12 vss 0.0378627f $X=0.4175 $Y=0.2025
c7 13 vss 0.00670426f $X=0.459 $Y=0.234
c8 14 vss 0.00266142f $X=0.459 $Y=0.036
c9 15 vss 0.0220034f $X=0.204 $Y=0.036
c10 16 vss 0.00494934f $X=0.459 $Y=0.0575
r1 12 3 0.154321 $w=8.1e-08 $l=1.25e-08 $layer=P_src_drn $thickness=1e-09
+ $X=0.4175 $Y=0.2025 $X2=0.432 $Y2=0.2025
r2 48 12 0.0308642 $w=8.1e-08 $l=2.5e-09 $layer=P_src_drn $thickness=1e-09
+ $X=0.4146 $Y=0.2025 $X2=0.4175 $Y2=0.2025
r3 3 45 19.3796 $a=3.24e-16 $layer=V0LISD $X=0.432 $Y=0.2025 $X2=0.432 $Y2=0.234
r4 45 46 3.14806 $w=1.3e-08 $l=1.35e-08 $layer=M1 $thickness=3.6e-08 $X=0.432
+ $Y=0.234 $X2=0.4455 $Y2=0.234
r5 13 41 3.01711 $w=1.55e-08 $l=1.8e-08 $layer=M1 $thickness=3.6e-08 $X=0.459
+ $Y=0.234 $X2=0.459 $Y2=0.216
r6 13 46 1.96775 $w=1.63333e-08 $l=1.35e-08 $layer=M1 $thickness=3.6e-08
+ $X=0.459 $Y=0.234 $X2=0.4455 $Y2=0.234
r7 11 2 0.154321 $w=8.1e-08 $l=1.25e-08 $layer=N_src_drn $thickness=1e-09
+ $X=0.4175 $Y=0.0675 $X2=0.432 $Y2=0.0675
r8 43 11 0.0308642 $w=8.1e-08 $l=2.5e-09 $layer=N_src_drn $thickness=1e-09
+ $X=0.4146 $Y=0.0675 $X2=0.4175 $Y2=0.0675
r9 40 41 4.19742 $w=1.3e-08 $l=1.8e-08 $layer=M1 $thickness=3.6e-08 $X=0.459
+ $Y=0.198 $X2=0.459 $Y2=0.216
r10 39 40 5.01358 $w=1.3e-08 $l=2.15e-08 $layer=M1 $thickness=3.6e-08 $X=0.459
+ $Y=0.1765 $X2=0.459 $Y2=0.198
r11 38 39 7.17059 $w=1.3e-08 $l=3.08e-08 $layer=M1 $thickness=3.6e-08 $X=0.459
+ $Y=0.1457 $X2=0.459 $Y2=0.1765
r12 37 38 4.37231 $w=1.3e-08 $l=1.87e-08 $layer=M1 $thickness=3.6e-08 $X=0.458
+ $Y=0.127 $X2=0.459 $Y2=0.1457
r13 37 36 6.70421 $w=1.3e-08 $l=2.88e-08 $layer=M1 $thickness=3.6e-08 $X=0.458
+ $Y=0.127 $X2=0.459 $Y2=0.0982
r14 16 36 9.50248 $w=1.3e-08 $l=4.07e-08 $layer=M1 $thickness=3.6e-08 $X=0.459
+ $Y=0.0575 $X2=0.459 $Y2=0.0982
r15 2 34 19.3796 $a=3.24e-16 $layer=V0LISD $X=0.432 $Y=0.0675 $X2=0.432
+ $Y2=0.036
r16 14 35 1.49895 $w=1.63333e-08 $l=1.35e-08 $layer=M1 $thickness=3.6e-08
+ $X=0.459 $Y=0.036 $X2=0.4455 $Y2=0.036
r17 14 16 3.36447 $w=1.71023e-08 $l=2.15e-08 $layer=M1 $thickness=3.6e-08
+ $X=0.459 $Y=0.036 $X2=0.459 $Y2=0.0575
r18 34 35 3.14806 $w=1.3e-08 $l=1.35e-08 $layer=M1 $thickness=3.6e-08 $X=0.432
+ $Y=0.036 $X2=0.4455 $Y2=0.036
r19 33 34 2.79828 $w=1.3e-08 $l=1.2e-08 $layer=M1 $thickness=3.6e-08 $X=0.42
+ $Y=0.036 $X2=0.432 $Y2=0.036
r20 32 33 1.04935 $w=1.3e-08 $l=4.5e-09 $layer=M1 $thickness=3.6e-08 $X=0.4155
+ $Y=0.036 $X2=0.42 $Y2=0.036
r21 31 32 2.44849 $w=1.3e-08 $l=1.05e-08 $layer=M1 $thickness=3.6e-08 $X=0.405
+ $Y=0.036 $X2=0.4155 $Y2=0.036
r22 30 31 2.44849 $w=1.3e-08 $l=1.05e-08 $layer=M1 $thickness=3.6e-08 $X=0.3945
+ $Y=0.036 $X2=0.405 $Y2=0.036
r23 29 30 4.19742 $w=1.3e-08 $l=1.8e-08 $layer=M1 $thickness=3.6e-08 $X=0.3765
+ $Y=0.036 $X2=0.3945 $Y2=0.036
r24 28 29 5.94634 $w=1.3e-08 $l=2.55e-08 $layer=M1 $thickness=3.6e-08 $X=0.351
+ $Y=0.036 $X2=0.3765 $Y2=0.036
r25 27 28 6.29612 $w=1.3e-08 $l=2.7e-08 $layer=M1 $thickness=3.6e-08 $X=0.324
+ $Y=0.036 $X2=0.351 $Y2=0.036
r26 26 27 6.29612 $w=1.3e-08 $l=2.7e-08 $layer=M1 $thickness=3.6e-08 $X=0.297
+ $Y=0.036 $X2=0.324 $Y2=0.036
r27 25 26 6.06293 $w=1.3e-08 $l=2.6e-08 $layer=M1 $thickness=3.6e-08 $X=0.271
+ $Y=0.036 $X2=0.297 $Y2=0.036
r28 24 25 4.19742 $w=1.3e-08 $l=1.8e-08 $layer=M1 $thickness=3.6e-08 $X=0.253
+ $Y=0.036 $X2=0.271 $Y2=0.036
r29 23 24 2.3319 $w=1.3e-08 $l=1e-08 $layer=M1 $thickness=3.6e-08 $X=0.243
+ $Y=0.036 $X2=0.253 $Y2=0.036
r30 22 23 3.14806 $w=1.3e-08 $l=1.35e-08 $layer=M1 $thickness=3.6e-08 $X=0.2295
+ $Y=0.036 $X2=0.243 $Y2=0.036
r31 21 22 3.14806 $w=1.3e-08 $l=1.35e-08 $layer=M1 $thickness=3.6e-08 $X=0.216
+ $Y=0.036 $X2=0.2295 $Y2=0.036
r32 15 21 2.79828 $w=1.3e-08 $l=1.2e-08 $layer=M1 $thickness=3.6e-08 $X=0.204
+ $Y=0.036 $X2=0.216 $Y2=0.036
r33 1 21 19.3796 $a=3.24e-16 $layer=V0LISD $X=0.216 $Y=0.0675 $X2=0.216
+ $Y2=0.036
r34 20 18 0.0308642 $w=8.1e-08 $l=2.5e-09 $layer=N_src_drn $thickness=1e-09
+ $X=0.2333 $Y=0.0675 $X2=0.2305 $Y2=0.0675
r35 1 18 0.179012 $w=8.1e-08 $l=1.45e-08 $layer=N_src_drn $thickness=1e-09
+ $X=0.216 $Y=0.0675 $X2=0.2305 $Y2=0.0675
r36 10 1 0.179012 $w=8.1e-08 $l=1.45e-08 $layer=N_src_drn $thickness=1e-09
+ $X=0.2015 $Y=0.0675 $X2=0.216 $Y2=0.0675
r37 19 10 0.0308642 $w=8.1e-08 $l=2.5e-09 $layer=N_src_drn $thickness=1e-09
+ $X=0.1986 $Y=0.0675 $X2=0.2015 $Y2=0.0675
.ends

.subckt PM_AOI331xp33_ASAP7_75t_R%A1 vss 11 5 9 3 4
c1 1 vss 0.00718133f $X=0.189 $Y=0.135
c2 3 vss 0.101783f $X=0.189 $Y=0.0245
c3 4 vss 0.00856475f $X=0.189 $Y=0.0922
r1 12 13 3.32295 $w=1.3e-08 $l=1.43e-08 $layer=M1 $thickness=3.6e-08 $X=0.189
+ $Y=0.1207 $X2=0.189 $Y2=0.135
r2 11 12 1.34084 $w=1.3e-08 $l=5.7e-09 $layer=M1 $thickness=3.6e-08 $X=0.189
+ $Y=0.115 $X2=0.189 $Y2=0.1207
r3 11 4 5.30507 $w=1.3e-08 $l=2.28e-08 $layer=M1 $thickness=3.6e-08 $X=0.189
+ $Y=0.115 $X2=0.189 $Y2=0.0922
r4 1 7 10.4265 $w=1.765e-08 $layer=LIG $thickness=5.2e-08 $X=0.189 $Y=0.135
+ $X2=0.189 $Y2=0.135
r5 1 13 19.3796 $a=3.24e-16 $layer=V0LIG $X=0.189 $Y=0.135 $X2=0.189 $Y2=0.135
r6 9 8 16.4967 $w=2.1e-08 $l=4.85e-08 $layer=Gate_1 $thickness=5.6e-08 $X=0.189
+ $Y=0.2025 $X2=0.189 $Y2=0.154
r7 7 8 6.6497 $w=2.04211e-08 $l=1.9e-08 $layer=Gate_1 $thickness=5.6e-08
+ $X=0.189 $Y=0.135 $X2=0.189 $Y2=0.154
r8 6 7 6.6497 $w=2.04211e-08 $l=1.9e-08 $layer=Gate_1 $thickness=5.6e-08
+ $X=0.189 $Y=0.116 $X2=0.189 $Y2=0.135
r9 5 6 16.4967 $w=2.1e-08 $l=4.85e-08 $layer=Gate_1 $thickness=5.6e-08 $X=0.189
+ $Y=0.0675 $X2=0.189 $Y2=0.116
r10 5 3 14.6259 $w=2.1e-08 $l=4.3e-08 $layer=Gate_1 $thickness=5.6e-08 $X=0.189
+ $Y=0.0675 $X2=0.189 $Y2=0.0245
.ends

.subckt PM_AOI331xp33_ASAP7_75t_R%B1 vss 11 5 9 3 4
c1 1 vss 0.00700438f $X=0.243 $Y=0.135
c2 3 vss 0.101636f $X=0.243 $Y=0.0245
c3 4 vss 0.00496108f $X=0.243 $Y=0.0927
r1 12 13 3.20636 $w=1.3e-08 $l=1.38e-08 $layer=M1 $thickness=3.6e-08 $X=0.243
+ $Y=0.1212 $X2=0.243 $Y2=0.135
r2 11 12 1.22425 $w=1.3e-08 $l=5.2e-09 $layer=M1 $thickness=3.6e-08 $X=0.243
+ $Y=0.116 $X2=0.243 $Y2=0.1212
r3 11 4 5.42166 $w=1.3e-08 $l=2.33e-08 $layer=M1 $thickness=3.6e-08 $X=0.243
+ $Y=0.116 $X2=0.243 $Y2=0.0927
r4 1 7 10.4265 $w=1.765e-08 $layer=LIG $thickness=5.2e-08 $X=0.243 $Y=0.135
+ $X2=0.243 $Y2=0.135
r5 1 13 19.3796 $a=3.24e-16 $layer=V0LIG $X=0.243 $Y=0.135 $X2=0.243 $Y2=0.135
r6 9 8 16.4967 $w=2.1e-08 $l=4.85e-08 $layer=Gate_1 $thickness=5.6e-08 $X=0.243
+ $Y=0.2025 $X2=0.243 $Y2=0.154
r7 7 8 6.6497 $w=2.04211e-08 $l=1.9e-08 $layer=Gate_1 $thickness=5.6e-08
+ $X=0.243 $Y=0.135 $X2=0.243 $Y2=0.154
r8 6 7 6.6497 $w=2.04211e-08 $l=1.9e-08 $layer=Gate_1 $thickness=5.6e-08
+ $X=0.243 $Y=0.116 $X2=0.243 $Y2=0.135
r9 5 6 16.4967 $w=2.1e-08 $l=4.85e-08 $layer=Gate_1 $thickness=5.6e-08 $X=0.243
+ $Y=0.0675 $X2=0.243 $Y2=0.116
r10 5 3 14.6259 $w=2.1e-08 $l=4.3e-08 $layer=Gate_1 $thickness=5.6e-08 $X=0.243
+ $Y=0.0675 $X2=0.243 $Y2=0.0245
.ends

* End of included file AOI331xp33_ASAP7_75t_R.pex.sp.pex

*
.subckt AOI331xp33_ASAP7_75t_CUSTOM_4_25_0_7 VSS VDD A3 A2 A1 B1 B2 B3 C1 Y
*
* VSS VSS
* VDD VDD
* A3 A3
* A2 A2
* A1 A1
* B1 B1
* B2 B2
* B3 B3
* C1 C1
* Y Y
*
*

M0 noxref_13 N_M0_g VSS VSS nmos_rvt L=2e-08 W=8.1e-08 nfin=3 $X=0.071 $Y=0.027
M1 noxref_14 N_M1_g noxref_13 VSS nmos_rvt L=2e-08 W=8.1e-08 nfin=3 $X=0.125
+ $Y=0.027
M2 N_M2_d N_M2_g noxref_14 VSS nmos_rvt L=2e-08 W=8.1e-08 nfin=3 $X=0.179
+ $Y=0.027
M3 noxref_15 N_M3_g N_M3_s VSS nmos_rvt L=2e-08 W=8.1e-08 nfin=3 $X=0.233
+ $Y=0.027
M4 noxref_16 N_M4_g noxref_15 VSS nmos_rvt L=2e-08 W=8.1e-08 nfin=3 $X=0.287
+ $Y=0.027
M5 VSS N_M5_g noxref_16 VSS nmos_rvt L=2e-08 W=8.1e-08 nfin=3 $X=0.341 $Y=0.027
M6 N_M6_d N_M6_g VSS VSS nmos_rvt L=2e-08 W=8.1e-08 nfin=3 $X=0.395 $Y=0.027
M7 noxref_10 N_M7_g VDD VDD pmos_rvt L=2e-08 W=8.1e-08 nfin=3 $X=0.071 $Y=0.162
M8 VDD N_M8_g noxref_10 VDD pmos_rvt L=2e-08 W=8.1e-08 nfin=3 $X=0.125 $Y=0.162
M9 noxref_10 N_M9_g VDD VDD pmos_rvt L=2e-08 W=8.1e-08 nfin=3 $X=0.179 $Y=0.162
M10 noxref_11 N_M10_g noxref_10 VDD pmos_rvt L=2e-08 W=8.1e-08 nfin=3 $X=0.233
+ $Y=0.162
M11 noxref_10 N_M11_g noxref_11 VDD pmos_rvt L=2e-08 W=8.1e-08 nfin=3 $X=0.287
+ $Y=0.162
M12 noxref_11 N_M12_g noxref_10 VDD pmos_rvt L=2e-08 W=8.1e-08 nfin=3 $X=0.341
+ $Y=0.162
M13 N_M13_d N_M13_g noxref_11 VDD pmos_rvt L=2e-08 W=8.1e-08 nfin=3 $X=0.395
+ $Y=0.162

* .include "AOI331xp33_ASAP7_75t_R.pex.sp.pxi"

* Start of included file AOI331xp33_ASAP7_75t_R.pex.sp.pxi
x_PM_AOI331xp33_ASAP7_75t_R%A3 vss A3 N_M0_g N_M7_g N_A3_4
+ PM_AOI331xp33_ASAP7_75t_R%A3
x_PM_AOI331xp33_ASAP7_75t_R%A2 vss A2 N_M1_g N_M8_g N_A2_3 N_A2_4
+ PM_AOI331xp33_ASAP7_75t_R%A2
cc_1 N_A2_3 N_A3_4 0.00518111f $X=0.135 $Y=0.0245
cc_2 N_A2_4 N_A3_4 0.00833133f $X=0.135 $Y=0.0922
x_PM_AOI331xp33_ASAP7_75t_R%B2 vss B2 N_M4_g N_M11_g N_B2_4 N_B2_3
+ PM_AOI331xp33_ASAP7_75t_R%B2
cc_3 N_B2_4 N_B1_4 0.00339009f $X=0.297 $Y=0.0922
cc_4 N_B2_3 N_B1_3 0.00704712f $X=0.297 $Y=0.0245
x_PM_AOI331xp33_ASAP7_75t_R%B3 vss B3 N_M5_g N_M12_g N_B3_4 N_B3_3
+ PM_AOI331xp33_ASAP7_75t_R%B3
cc_5 N_B3_4 N_B2_4 0.00335824f $X=0.351 $Y=0.0922
cc_6 N_B3_3 N_B2_3 0.00698098f $X=0.351 $Y=0.0245
x_PM_AOI331xp33_ASAP7_75t_R%C1 vss C1 N_M6_g N_M13_g N_C1_4 N_C1_3 N_C1_1
+ PM_AOI331xp33_ASAP7_75t_R%C1
cc_7 N_C1_4 N_B3_4 0.00317006f $X=0.405 $Y=0.0922
cc_8 N_C1_3 N_B3_3 0.00501802f $X=0.405 $Y=0.0245
x_PM_AOI331xp33_ASAP7_75t_R%Y vss Y N_M2_d N_M3_s N_M6_d N_M13_d N_Y_1 N_Y_10
+ N_Y_15 N_Y_3 N_Y_2 N_Y_11 N_Y_12 N_Y_16 PM_AOI331xp33_ASAP7_75t_R%Y
cc_9 N_Y_1 N_A1_4 0.00120939f $X=0.216 $Y=0.0675
cc_10 N_Y_1 N_A1_3 0.00150191f $X=0.216 $Y=0.0675
cc_11 N_Y_10 N_A1_3 0.0365333f $X=0.2015 $Y=0.0675
cc_12 N_Y_15 N_B1_3 0.00114635f $X=0.204 $Y=0.036
cc_13 N_Y_1 N_B1_3 0.00143613f $X=0.216 $Y=0.0675
cc_14 N_Y_1 N_B1_4 0.00165474f $X=0.216 $Y=0.0675
cc_15 N_Y_10 N_B1_3 0.035936f $X=0.2015 $Y=0.0675
cc_16 N_Y_15 N_B2_4 0.00346233f $X=0.204 $Y=0.036
cc_17 N_Y_15 N_B3_4 0.00306463f $X=0.204 $Y=0.036
cc_18 N_Y_3 N_C1_3 0.00099526f $X=0.432 $Y=0.2025
cc_19 N_Y_15 N_C1_3 0.00101936f $X=0.204 $Y=0.036
cc_20 N_Y_2 N_C1_3 0.00120305f $X=0.432 $Y=0.0675
cc_21 N_Y_11 N_C1_1 0.00165682f $X=0.4175 $Y=0.0675
cc_22 N_Y_12 N_C1_3 0.0147911f $X=0.4175 $Y=0.2025
cc_23 N_Y_16 N_C1_4 0.00589085f $X=0.459 $Y=0.0575
cc_24 N_Y_11 N_C1_3 0.0548747f $X=0.4175 $Y=0.0675
x_PM_AOI331xp33_ASAP7_75t_R%A1 vss A1 N_M2_g N_M9_g N_A1_3 N_A1_4
+ PM_AOI331xp33_ASAP7_75t_R%A1
cc_25 N_A1_3 N_A2_3 0.0050521f $X=0.189 $Y=0.0245
cc_26 N_A1_4 N_A2_4 0.00703422f $X=0.189 $Y=0.0922
x_PM_AOI331xp33_ASAP7_75t_R%B1 vss B1 N_M3_g N_M10_g N_B1_3 N_B1_4
+ PM_AOI331xp33_ASAP7_75t_R%B1
cc_27 N_B1_3 N_A1_3 0.00317543f $X=0.243 $Y=0.0245
cc_28 N_B1_4 N_A1_4 0.00533408f $X=0.243 $Y=0.0927

* End of included file AOI331xp33_ASAP7_75t_R.pex.sp.pxi
.ends

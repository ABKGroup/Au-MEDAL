.subckt PM_AO331x1_ASAP7_75t_R%A1 vss 11 5 9 4 3
c1 1 vss 0.00427431f $X=0.243 $Y=0.135
c2 3 vss 0.102486f $X=0.243 $Y=0.0245
c3 4 vss 0.00974462f $X=0.243 $Y=0.0922
r1 12 13 3.32295 $w=1.3e-08 $l=1.43e-08 $layer=M1 $thickness=3.6e-08 $X=0.243
+ $Y=0.1207 $X2=0.243 $Y2=0.135
r2 11 12 1.34084 $w=1.3e-08 $l=5.7e-09 $layer=M1 $thickness=3.6e-08 $X=0.243
+ $Y=0.115 $X2=0.243 $Y2=0.1207
r3 11 4 5.30507 $w=1.3e-08 $l=2.28e-08 $layer=M1 $thickness=3.6e-08 $X=0.243
+ $Y=0.115 $X2=0.243 $Y2=0.0922
r4 1 7 10.4265 $w=1.765e-08 $layer=LIG $thickness=5.2e-08 $X=0.243 $Y=0.135
+ $X2=0.243 $Y2=0.135
r5 1 13 19.3796 $a=3.24e-16 $layer=V0LIG $X=0.243 $Y=0.135 $X2=0.243 $Y2=0.135
r6 9 8 16.4967 $w=2.1e-08 $l=4.85e-08 $layer=Gate_1 $thickness=5.6e-08 $X=0.243
+ $Y=0.2025 $X2=0.243 $Y2=0.154
r7 7 8 6.6497 $w=2.04211e-08 $l=1.9e-08 $layer=Gate_1 $thickness=5.6e-08
+ $X=0.243 $Y=0.135 $X2=0.243 $Y2=0.154
r8 6 7 6.6497 $w=2.04211e-08 $l=1.9e-08 $layer=Gate_1 $thickness=5.6e-08
+ $X=0.243 $Y=0.116 $X2=0.243 $Y2=0.135
r9 5 6 16.4967 $w=2.1e-08 $l=4.85e-08 $layer=Gate_1 $thickness=5.6e-08 $X=0.243
+ $Y=0.0675 $X2=0.243 $Y2=0.116
r10 5 3 14.6259 $w=2.1e-08 $l=4.3e-08 $layer=Gate_1 $thickness=5.6e-08 $X=0.243
+ $Y=0.0675 $X2=0.243 $Y2=0.0245
.ends

.subckt PM_AO331x1_ASAP7_75t_R%B1 vss 11 5 9 4 3
c1 1 vss 0.00698131f $X=0.297 $Y=0.135
c2 3 vss 0.10171f $X=0.297 $Y=0.0245
c3 4 vss 0.00469316f $X=0.297 $Y=0.0927
r1 12 13 3.20636 $w=1.3e-08 $l=1.38e-08 $layer=M1 $thickness=3.6e-08 $X=0.297
+ $Y=0.1212 $X2=0.297 $Y2=0.135
r2 11 12 1.22425 $w=1.3e-08 $l=5.2e-09 $layer=M1 $thickness=3.6e-08 $X=0.297
+ $Y=0.116 $X2=0.297 $Y2=0.1212
r3 11 4 5.42166 $w=1.3e-08 $l=2.33e-08 $layer=M1 $thickness=3.6e-08 $X=0.297
+ $Y=0.116 $X2=0.297 $Y2=0.0927
r4 1 7 10.4265 $w=1.765e-08 $layer=LIG $thickness=5.2e-08 $X=0.297 $Y=0.135
+ $X2=0.297 $Y2=0.135
r5 1 13 19.3796 $a=3.24e-16 $layer=V0LIG $X=0.297 $Y=0.135 $X2=0.297 $Y2=0.135
r6 9 8 16.4967 $w=2.1e-08 $l=4.85e-08 $layer=Gate_1 $thickness=5.6e-08 $X=0.297
+ $Y=0.2025 $X2=0.297 $Y2=0.154
r7 7 8 6.6497 $w=2.04211e-08 $l=1.9e-08 $layer=Gate_1 $thickness=5.6e-08
+ $X=0.297 $Y=0.135 $X2=0.297 $Y2=0.154
r8 6 7 6.6497 $w=2.04211e-08 $l=1.9e-08 $layer=Gate_1 $thickness=5.6e-08
+ $X=0.297 $Y=0.116 $X2=0.297 $Y2=0.135
r9 5 6 16.4967 $w=2.1e-08 $l=4.85e-08 $layer=Gate_1 $thickness=5.6e-08 $X=0.297
+ $Y=0.0675 $X2=0.297 $Y2=0.116
r10 5 3 14.6259 $w=2.1e-08 $l=4.3e-08 $layer=Gate_1 $thickness=5.6e-08 $X=0.297
+ $Y=0.0675 $X2=0.297 $Y2=0.0245
.ends

.subckt PM_AO331x1_ASAP7_75t_R%B2 vss 11 5 9 4 3
c1 1 vss 0.00485645f $X=0.351 $Y=0.135
c2 3 vss 0.121083f $X=0.351 $Y=0.0245
c3 4 vss 0.0051677f $X=0.351 $Y=0.0922
r1 12 13 3.32295 $w=1.3e-08 $l=1.43e-08 $layer=M1 $thickness=3.6e-08 $X=0.351
+ $Y=0.1207 $X2=0.351 $Y2=0.135
r2 11 12 1.34084 $w=1.3e-08 $l=5.7e-09 $layer=M1 $thickness=3.6e-08 $X=0.35
+ $Y=0.115 $X2=0.351 $Y2=0.1207
r3 11 4 5.30507 $w=1.3e-08 $l=2.28e-08 $layer=M1 $thickness=3.6e-08 $X=0.35
+ $Y=0.115 $X2=0.351 $Y2=0.0922
r4 1 7 10.4265 $w=1.765e-08 $layer=LIG $thickness=5.2e-08 $X=0.351 $Y=0.135
+ $X2=0.351 $Y2=0.135
r5 1 13 19.3796 $a=3.24e-16 $layer=V0LIG $X=0.351 $Y=0.135 $X2=0.351 $Y2=0.135
r6 9 8 16.4967 $w=2.1e-08 $l=4.85e-08 $layer=Gate_1 $thickness=5.6e-08 $X=0.351
+ $Y=0.2025 $X2=0.351 $Y2=0.154
r7 7 8 6.6497 $w=2.04211e-08 $l=1.9e-08 $layer=Gate_1 $thickness=5.6e-08
+ $X=0.351 $Y=0.135 $X2=0.351 $Y2=0.154
r8 6 7 6.6497 $w=2.04211e-08 $l=1.9e-08 $layer=Gate_1 $thickness=5.6e-08
+ $X=0.351 $Y=0.116 $X2=0.351 $Y2=0.135
r9 5 6 16.4967 $w=2.1e-08 $l=4.85e-08 $layer=Gate_1 $thickness=5.6e-08 $X=0.351
+ $Y=0.0675 $X2=0.351 $Y2=0.116
r10 5 3 14.6259 $w=2.1e-08 $l=4.3e-08 $layer=Gate_1 $thickness=5.6e-08 $X=0.351
+ $Y=0.0675 $X2=0.351 $Y2=0.0245
.ends

.subckt PM_AO331x1_ASAP7_75t_R%B3 vss 11 5 9 4 3
c1 1 vss 0.00578433f $X=0.405 $Y=0.135
c2 3 vss 0.140006f $X=0.405 $Y=0.0245
c3 4 vss 0.00562645f $X=0.405 $Y=0.0922
r1 12 13 3.32295 $w=1.3e-08 $l=1.43e-08 $layer=M1 $thickness=3.6e-08 $X=0.405
+ $Y=0.1207 $X2=0.405 $Y2=0.135
r2 11 12 1.34084 $w=1.3e-08 $l=5.7e-09 $layer=M1 $thickness=3.6e-08 $X=0.403
+ $Y=0.115 $X2=0.405 $Y2=0.1207
r3 11 4 5.30507 $w=1.3e-08 $l=2.28e-08 $layer=M1 $thickness=3.6e-08 $X=0.403
+ $Y=0.115 $X2=0.405 $Y2=0.0922
r4 1 7 10.4265 $w=1.765e-08 $layer=LIG $thickness=5.2e-08 $X=0.405 $Y=0.135
+ $X2=0.405 $Y2=0.135
r5 1 13 19.3796 $a=3.24e-16 $layer=V0LIG $X=0.405 $Y=0.135 $X2=0.405 $Y2=0.135
r6 9 8 16.4967 $w=2.1e-08 $l=4.85e-08 $layer=Gate_1 $thickness=5.6e-08 $X=0.405
+ $Y=0.2025 $X2=0.405 $Y2=0.154
r7 7 8 6.6497 $w=2.04211e-08 $l=1.9e-08 $layer=Gate_1 $thickness=5.6e-08
+ $X=0.405 $Y=0.135 $X2=0.405 $Y2=0.154
r8 6 7 6.6497 $w=2.04211e-08 $l=1.9e-08 $layer=Gate_1 $thickness=5.6e-08
+ $X=0.405 $Y=0.116 $X2=0.405 $Y2=0.135
r9 5 6 16.4967 $w=2.1e-08 $l=4.85e-08 $layer=Gate_1 $thickness=5.6e-08 $X=0.405
+ $Y=0.0675 $X2=0.405 $Y2=0.116
r10 5 3 14.6259 $w=2.1e-08 $l=4.3e-08 $layer=Gate_1 $thickness=5.6e-08 $X=0.405
+ $Y=0.0675 $X2=0.405 $Y2=0.0245
.ends

.subckt PM_AO331x1_ASAP7_75t_R%C vss 13 5 11 3 1 4
c1 1 vss 0.00402265f $X=0.459 $Y=0.135
c2 3 vss 0.0888706f $X=0.459 $Y=0.0245
c3 4 vss 0.0065195f $X=0.459 $Y=0.0922
r1 14 15 3.32295 $w=1.3e-08 $l=1.43e-08 $layer=M1 $thickness=3.6e-08 $X=0.459
+ $Y=0.1207 $X2=0.459 $Y2=0.135
r2 13 14 1.34084 $w=1.3e-08 $l=5.7e-09 $layer=M1 $thickness=3.6e-08 $X=0.457
+ $Y=0.115 $X2=0.459 $Y2=0.1207
r3 13 4 5.30507 $w=1.3e-08 $l=2.28e-08 $layer=M1 $thickness=3.6e-08 $X=0.457
+ $Y=0.115 $X2=0.459 $Y2=0.0922
r4 1 8 10.4265 $w=1.765e-08 $layer=LIG $thickness=5.2e-08 $X=0.459 $Y=0.135
+ $X2=0.459 $Y2=0.135
r5 1 15 19.3796 $a=3.24e-16 $layer=V0LIG $X=0.459 $Y=0.135 $X2=0.459 $Y2=0.135
r6 11 10 14.6259 $w=2.1e-08 $l=4.3e-08 $layer=Gate_1 $thickness=5.6e-08
+ $X=0.459 $Y=0.2025 $X2=0.459 $Y2=0.1595
r7 9 10 2.7211 $w=2.1e-08 $l=8e-09 $layer=Gate_1 $thickness=5.6e-08 $X=0.459
+ $Y=0.1515 $X2=0.459 $Y2=0.1595
r8 8 9 5.79936 $w=2.03333e-08 $l=1.65e-08 $layer=Gate_1 $thickness=5.6e-08
+ $X=0.459 $Y=0.135 $X2=0.459 $Y2=0.1515
r9 7 8 5.79936 $w=2.03333e-08 $l=1.65e-08 $layer=Gate_1 $thickness=5.6e-08
+ $X=0.459 $Y=0.1185 $X2=0.459 $Y2=0.135
r10 6 7 2.7211 $w=2.1e-08 $l=8e-09 $layer=Gate_1 $thickness=5.6e-08 $X=0.459
+ $Y=0.1105 $X2=0.459 $Y2=0.1185
r11 5 6 14.6259 $w=2.1e-08 $l=4.3e-08 $layer=Gate_1 $thickness=5.6e-08 $X=0.459
+ $Y=0.0675 $X2=0.459 $Y2=0.1105
r12 5 3 14.6259 $w=2.1e-08 $l=4.3e-08 $layer=Gate_1 $thickness=5.6e-08 $X=0.459
+ $Y=0.0675 $X2=0.459 $Y2=0.0245
.ends

.subckt PM_AO331x1_ASAP7_75t_R%Y vss 20 14 28 7 12 11 8
c1 7 vss 0.0469856f $X=0.056 $Y=0.0675
c2 8 vss 0.0479977f $X=0.056 $Y=0.2025
c3 9 vss 0.00280801f $X=0.027 $Y=0.036
c4 10 vss 0.00650335f $X=0.027 $Y=0.234
c5 11 vss 0.00577871f $X=0.027 $Y=0.054
c6 12 vss 0.00433353f $X=0.0405 $Y=0.036
r1 28 27 0.0308642 $w=8.1e-08 $l=2.5e-09 $layer=P_src_drn $thickness=1e-09
+ $X=0.0713 $Y=0.2025 $X2=0.0685 $Y2=0.2025
r2 8 27 0.154321 $w=8.1e-08 $l=1.25e-08 $layer=P_src_drn $thickness=1e-09
+ $X=0.056 $Y=0.2025 $X2=0.0685 $Y2=0.2025
r3 8 25 19.3796 $a=3.24e-16 $layer=V0LISD $X=0.056 $Y=0.2025 $X2=0.054 $Y2=0.234
r4 24 25 3.14806 $w=1.3e-08 $l=1.35e-08 $layer=M1 $thickness=3.6e-08 $X=0.0405
+ $Y=0.234 $X2=0.054 $Y2=0.234
r5 10 23 3.83327 $w=1.5093e-08 $l=2.15e-08 $layer=M1 $thickness=3.6e-08
+ $X=0.027 $Y=0.234 $X2=0.027 $Y2=0.2125
r6 10 24 1.96775 $w=1.63333e-08 $l=1.35e-08 $layer=M1 $thickness=3.6e-08
+ $X=0.027 $Y=0.234 $X2=0.0405 $Y2=0.234
r7 22 23 8.51143 $w=1.3e-08 $l=3.65e-08 $layer=M1 $thickness=3.6e-08 $X=0.027
+ $Y=0.176 $X2=0.027 $Y2=0.2125
r8 21 22 6.06293 $w=1.3e-08 $l=2.6e-08 $layer=M1 $thickness=3.6e-08 $X=0.027
+ $Y=0.15 $X2=0.027 $Y2=0.176
r9 20 21 0.582974 $w=1.3e-08 $l=2.5e-09 $layer=M1 $thickness=3.6e-08 $X=0.03
+ $Y=0.1475 $X2=0.027 $Y2=0.15
r10 20 19 9.91056 $w=1.3e-08 $l=4.25e-08 $layer=M1 $thickness=3.6e-08 $X=0.03
+ $Y=0.1475 $X2=0.027 $Y2=0.105
r11 11 19 11.8927 $w=1.3e-08 $l=5.1e-08 $layer=M1 $thickness=3.6e-08 $X=0.027
+ $Y=0.054 $X2=0.027 $Y2=0.105
r12 9 12 1.49895 $w=1.63333e-08 $l=1.35e-08 $layer=M1 $thickness=3.6e-08
+ $X=0.027 $Y=0.036 $X2=0.0405 $Y2=0.036
r13 9 11 2.5483 $w=1.79e-08 $l=1.8e-08 $layer=M1 $thickness=3.6e-08 $X=0.027
+ $Y=0.036 $X2=0.027 $Y2=0.054
r14 12 15 3.14806 $w=1.3e-08 $l=1.35e-08 $layer=M1 $thickness=3.6e-08 $X=0.0405
+ $Y=0.036 $X2=0.054 $Y2=0.036
r15 7 15 19.3796 $a=3.24e-16 $layer=V0LISD $X=0.056 $Y=0.0675 $X2=0.054
+ $Y2=0.036
r16 14 13 0.0308642 $w=8.1e-08 $l=2.5e-09 $layer=N_src_drn $thickness=1e-09
+ $X=0.0713 $Y=0.0675 $X2=0.0685 $Y2=0.0675
r17 7 13 0.154321 $w=8.1e-08 $l=1.25e-08 $layer=N_src_drn $thickness=1e-09
+ $X=0.056 $Y=0.0675 $X2=0.0685 $Y2=0.0675
.ends

.subckt PM_AO331x1_ASAP7_75t_R%3 vss 26 32 62 63 69 74 18 1 21 12 3 24 13 15 5
+ 4 14 25 16 17 22
c1 1 vss 0.00380499f $X=0.081 $Y=0.135
c2 3 vss 0.00506896f $X=0.27 $Y=0.0675
c3 4 vss 0.00836025f $X=0.486 $Y=0.0675
c4 5 vss 0.00939202f $X=0.486 $Y=0.2025
c5 12 vss 0.0818764f $X=0.081 $Y=0.0245
c6 13 vss 0.00409169f $X=0.2555 $Y=0.0675
c7 14 vss 0.0393074f $X=0.4715 $Y=0.0675
c8 15 vss 0.0392173f $X=0.4715 $Y=0.2025
c9 16 vss 0.000847823f $X=0.081 $Y=0.072
c10 17 vss 0.00286645f $X=0.135 $Y=0.036
c11 18 vss 0.000664222f $X=0.135 $Y=0.0665
c12 19 vss 0.00732482f $X=0.513 $Y=0.234
c13 20 vss 0.00297564f $X=0.513 $Y=0.036
c14 21 vss 0.00177234f $X=0.081 $Y=0.116
c15 22 vss 0.00152325f $X=0.108 $Y=0.072
c16 23 vss 0.000610003f $X=0.135 $Y=0.054
c17 24 vss 0.0319645f $X=0.145 $Y=0.036
c18 25 vss 0.00750537f $X=0.513 $Y=0.0575
r1 15 5 0.154321 $w=8.1e-08 $l=1.25e-08 $layer=P_src_drn $thickness=1e-09
+ $X=0.4715 $Y=0.2025 $X2=0.486 $Y2=0.2025
r2 74 15 0.0308642 $w=8.1e-08 $l=2.5e-09 $layer=P_src_drn $thickness=1e-09
+ $X=0.4686 $Y=0.2025 $X2=0.4715 $Y2=0.2025
r3 5 71 19.3796 $a=3.24e-16 $layer=V0LISD $X=0.486 $Y=0.2025 $X2=0.486 $Y2=0.234
r4 71 72 3.14806 $w=1.3e-08 $l=1.35e-08 $layer=M1 $thickness=3.6e-08 $X=0.486
+ $Y=0.234 $X2=0.4995 $Y2=0.234
r5 19 67 3.01711 $w=1.55e-08 $l=1.8e-08 $layer=M1 $thickness=3.6e-08 $X=0.513
+ $Y=0.234 $X2=0.513 $Y2=0.216
r6 19 72 1.96775 $w=1.63333e-08 $l=1.35e-08 $layer=M1 $thickness=3.6e-08
+ $X=0.513 $Y=0.234 $X2=0.4995 $Y2=0.234
r7 14 4 0.154321 $w=8.1e-08 $l=1.25e-08 $layer=N_src_drn $thickness=1e-09
+ $X=0.4715 $Y=0.0675 $X2=0.486 $Y2=0.0675
r8 69 14 0.0308642 $w=8.1e-08 $l=2.5e-09 $layer=N_src_drn $thickness=1e-09
+ $X=0.4686 $Y=0.0675 $X2=0.4715 $Y2=0.0675
r9 66 67 4.19742 $w=1.3e-08 $l=1.8e-08 $layer=M1 $thickness=3.6e-08 $X=0.513
+ $Y=0.198 $X2=0.513 $Y2=0.216
r10 65 66 5.01358 $w=1.3e-08 $l=2.15e-08 $layer=M1 $thickness=3.6e-08 $X=0.513
+ $Y=0.1765 $X2=0.513 $Y2=0.198
r11 64 65 13.8748 $w=1.3e-08 $l=5.95e-08 $layer=M1 $thickness=3.6e-08 $X=0.513
+ $Y=0.117 $X2=0.513 $Y2=0.1765
r12 25 64 13.8748 $w=1.3e-08 $l=5.95e-08 $layer=M1 $thickness=3.6e-08 $X=0.513
+ $Y=0.0575 $X2=0.513 $Y2=0.117
r13 63 61 0.0308642 $w=8.1e-08 $l=2.5e-09 $layer=N_src_drn $thickness=1e-09
+ $X=0.2873 $Y=0.0675 $X2=0.2845 $Y2=0.0675
r14 3 61 0.179012 $w=8.1e-08 $l=1.45e-08 $layer=N_src_drn $thickness=1e-09
+ $X=0.27 $Y=0.0675 $X2=0.2845 $Y2=0.0675
r15 13 3 0.179012 $w=8.1e-08 $l=1.45e-08 $layer=N_src_drn $thickness=1e-09
+ $X=0.2555 $Y=0.0675 $X2=0.27 $Y2=0.0675
r16 62 13 0.0308642 $w=8.1e-08 $l=2.5e-09 $layer=N_src_drn $thickness=1e-09
+ $X=0.2526 $Y=0.0675 $X2=0.2555 $Y2=0.0675
r17 4 58 19.3796 $a=3.24e-16 $layer=V0LISD $X=0.486 $Y=0.0675 $X2=0.486
+ $Y2=0.036
r18 20 59 1.49895 $w=1.63333e-08 $l=1.35e-08 $layer=M1 $thickness=3.6e-08
+ $X=0.513 $Y=0.036 $X2=0.4995 $Y2=0.036
r19 20 25 3.36447 $w=1.71023e-08 $l=2.15e-08 $layer=M1 $thickness=3.6e-08
+ $X=0.513 $Y=0.036 $X2=0.513 $Y2=0.0575
r20 3 45 19.3796 $a=3.24e-16 $layer=V0LISD $X=0.27 $Y=0.0675 $X2=0.27 $Y2=0.036
r21 58 59 3.14806 $w=1.3e-08 $l=1.35e-08 $layer=M1 $thickness=3.6e-08 $X=0.486
+ $Y=0.036 $X2=0.4995 $Y2=0.036
r22 57 58 2.79828 $w=1.3e-08 $l=1.2e-08 $layer=M1 $thickness=3.6e-08 $X=0.474
+ $Y=0.036 $X2=0.486 $Y2=0.036
r23 56 57 1.04935 $w=1.3e-08 $l=4.5e-09 $layer=M1 $thickness=3.6e-08 $X=0.4695
+ $Y=0.036 $X2=0.474 $Y2=0.036
r24 55 56 2.44849 $w=1.3e-08 $l=1.05e-08 $layer=M1 $thickness=3.6e-08 $X=0.459
+ $Y=0.036 $X2=0.4695 $Y2=0.036
r25 54 55 2.44849 $w=1.3e-08 $l=1.05e-08 $layer=M1 $thickness=3.6e-08 $X=0.4485
+ $Y=0.036 $X2=0.459 $Y2=0.036
r26 53 54 4.19742 $w=1.3e-08 $l=1.8e-08 $layer=M1 $thickness=3.6e-08 $X=0.4305
+ $Y=0.036 $X2=0.4485 $Y2=0.036
r27 52 53 5.94634 $w=1.3e-08 $l=2.55e-08 $layer=M1 $thickness=3.6e-08 $X=0.405
+ $Y=0.036 $X2=0.4305 $Y2=0.036
r28 51 52 6.29612 $w=1.3e-08 $l=2.7e-08 $layer=M1 $thickness=3.6e-08 $X=0.378
+ $Y=0.036 $X2=0.405 $Y2=0.036
r29 50 51 6.29612 $w=1.3e-08 $l=2.7e-08 $layer=M1 $thickness=3.6e-08 $X=0.351
+ $Y=0.036 $X2=0.378 $Y2=0.036
r30 49 50 6.06293 $w=1.3e-08 $l=2.6e-08 $layer=M1 $thickness=3.6e-08 $X=0.325
+ $Y=0.036 $X2=0.351 $Y2=0.036
r31 48 49 4.19742 $w=1.3e-08 $l=1.8e-08 $layer=M1 $thickness=3.6e-08 $X=0.307
+ $Y=0.036 $X2=0.325 $Y2=0.036
r32 47 48 2.3319 $w=1.3e-08 $l=1e-08 $layer=M1 $thickness=3.6e-08 $X=0.297
+ $Y=0.036 $X2=0.307 $Y2=0.036
r33 46 47 3.14806 $w=1.3e-08 $l=1.35e-08 $layer=M1 $thickness=3.6e-08 $X=0.2835
+ $Y=0.036 $X2=0.297 $Y2=0.036
r34 45 46 3.14806 $w=1.3e-08 $l=1.35e-08 $layer=M1 $thickness=3.6e-08 $X=0.27
+ $Y=0.036 $X2=0.2835 $Y2=0.036
r35 44 45 3.14806 $w=1.3e-08 $l=1.35e-08 $layer=M1 $thickness=3.6e-08 $X=0.2565
+ $Y=0.036 $X2=0.27 $Y2=0.036
r36 43 44 3.14806 $w=1.3e-08 $l=1.35e-08 $layer=M1 $thickness=3.6e-08 $X=0.243
+ $Y=0.036 $X2=0.2565 $Y2=0.036
r37 42 43 6.29612 $w=1.3e-08 $l=2.7e-08 $layer=M1 $thickness=3.6e-08 $X=0.216
+ $Y=0.036 $X2=0.243 $Y2=0.036
r38 41 42 6.29612 $w=1.3e-08 $l=2.7e-08 $layer=M1 $thickness=3.6e-08 $X=0.189
+ $Y=0.036 $X2=0.216 $Y2=0.036
r39 40 41 6.06293 $w=1.3e-08 $l=2.6e-08 $layer=M1 $thickness=3.6e-08 $X=0.163
+ $Y=0.036 $X2=0.189 $Y2=0.036
r40 24 40 4.19742 $w=1.3e-08 $l=1.8e-08 $layer=M1 $thickness=3.6e-08 $X=0.145
+ $Y=0.036 $X2=0.163 $Y2=0.036
r41 17 23 2.5483 $w=1.79e-08 $l=1.8e-08 $layer=M1 $thickness=3.6e-08 $X=0.135
+ $Y=0.036 $X2=0.135 $Y2=0.054
r42 17 24 0.682785 $w=1.75e-08 $l=1e-08 $layer=M1 $thickness=3.6e-08 $X=0.135
+ $Y=0.036 $X2=0.145 $Y2=0.036
r43 18 22 4.55457 $w=1.3814e-08 $l=2.75545e-08 $layer=M1 $thickness=3.6e-08
+ $X=0.135 $Y=0.0665 $X2=0.108 $Y2=0.072
r44 18 23 2.45586 $w=1.44e-08 $l=1.25e-08 $layer=M1 $thickness=3.6e-08 $X=0.135
+ $Y=0.0665 $X2=0.135 $Y2=0.054
r45 16 38 3.36447 $w=1.71023e-08 $l=2.15e-08 $layer=M1 $thickness=3.6e-08
+ $X=0.081 $Y=0.072 $X2=0.081 $Y2=0.0935
r46 16 22 4.64701 $w=1.46667e-08 $l=2.7e-08 $layer=M1 $thickness=3.6e-08
+ $X=0.081 $Y=0.072 $X2=0.108 $Y2=0.072
r47 21 36 4.43061 $w=1.3e-08 $l=1.9e-08 $layer=M1 $thickness=3.6e-08 $X=0.081
+ $Y=0.116 $X2=0.081 $Y2=0.135
r48 21 38 5.24677 $w=1.3e-08 $l=2.25e-08 $layer=M1 $thickness=3.6e-08 $X=0.081
+ $Y=0.116 $X2=0.081 $Y2=0.0935
r49 1 29 6.54019 $w=2.09524e-08 $layer=Gate_1 $thickness=5.21905e-08 $X=0.081
+ $Y=0.135 $X2=0.081 $Y2=0.135
r50 1 36 19.3796 $a=3.24e-16 $layer=V0LIG $X=0.081 $Y=0.135 $X2=0.081 $Y2=0.135
r51 32 31 14.6259 $w=2.1e-08 $l=4.3e-08 $layer=Gate_1 $thickness=5.6e-08
+ $X=0.081 $Y=0.2025 $X2=0.081 $Y2=0.1595
r52 30 31 2.7211 $w=2.1e-08 $l=8e-09 $layer=Gate_1 $thickness=5.6e-08 $X=0.081
+ $Y=0.1515 $X2=0.081 $Y2=0.1595
r53 29 30 5.79936 $w=2.03333e-08 $l=1.65e-08 $layer=Gate_1 $thickness=5.6e-08
+ $X=0.081 $Y=0.135 $X2=0.081 $Y2=0.1515
r54 28 29 5.79936 $w=2.03333e-08 $l=1.65e-08 $layer=Gate_1 $thickness=5.6e-08
+ $X=0.081 $Y=0.1185 $X2=0.081 $Y2=0.135
r55 27 28 2.7211 $w=2.1e-08 $l=8e-09 $layer=Gate_1 $thickness=5.6e-08 $X=0.081
+ $Y=0.1105 $X2=0.081 $Y2=0.1185
r56 26 27 14.6259 $w=2.1e-08 $l=4.3e-08 $layer=Gate_1 $thickness=5.6e-08
+ $X=0.081 $Y=0.0675 $X2=0.081 $Y2=0.1105
r57 26 12 14.6259 $w=2.1e-08 $l=4.3e-08 $layer=Gate_1 $thickness=5.6e-08
+ $X=0.081 $Y=0.0675 $X2=0.081 $Y2=0.0245
.ends

.subckt PM_AO331x1_ASAP7_75t_R%A3 vss 11 5 9 3 4
c1 1 vss 0.00666685f $X=0.135 $Y=0.135
c2 3 vss 0.139619f $X=0.135 $Y=0.0245
c3 4 vss 0.0065256f $X=0.135 $Y=0.1102
r1 12 13 3.32295 $w=1.3e-08 $l=1.43e-08 $layer=M1 $thickness=3.6e-08 $X=0.135
+ $Y=0.1207 $X2=0.135 $Y2=0.135
r2 11 12 1.34084 $w=1.3e-08 $l=5.7e-09 $layer=M1 $thickness=3.6e-08 $X=0.135
+ $Y=0.115 $X2=0.135 $Y2=0.1207
r3 11 4 1.10765 $w=1.3e-08 $l=4.8e-09 $layer=M1 $thickness=3.6e-08 $X=0.135
+ $Y=0.115 $X2=0.135 $Y2=0.1102
r4 1 7 10.4265 $w=1.765e-08 $layer=LIG $thickness=5.2e-08 $X=0.135 $Y=0.135
+ $X2=0.135 $Y2=0.135
r5 1 13 19.3796 $a=3.24e-16 $layer=V0LIG $X=0.135 $Y=0.135 $X2=0.135 $Y2=0.135
r6 9 8 16.4967 $w=2.1e-08 $l=4.85e-08 $layer=Gate_1 $thickness=5.6e-08 $X=0.135
+ $Y=0.2025 $X2=0.135 $Y2=0.154
r7 7 8 6.6497 $w=2.04211e-08 $l=1.9e-08 $layer=Gate_1 $thickness=5.6e-08
+ $X=0.135 $Y=0.135 $X2=0.135 $Y2=0.154
r8 6 7 6.6497 $w=2.04211e-08 $l=1.9e-08 $layer=Gate_1 $thickness=5.6e-08
+ $X=0.135 $Y=0.116 $X2=0.135 $Y2=0.135
r9 5 6 16.4967 $w=2.1e-08 $l=4.85e-08 $layer=Gate_1 $thickness=5.6e-08 $X=0.135
+ $Y=0.0675 $X2=0.135 $Y2=0.116
r10 5 3 14.6259 $w=2.1e-08 $l=4.3e-08 $layer=Gate_1 $thickness=5.6e-08 $X=0.135
+ $Y=0.0675 $X2=0.135 $Y2=0.0245
.ends

.subckt PM_AO331x1_ASAP7_75t_R%A2 vss 13 5 9 4 3
c1 1 vss 0.00462687f $X=0.189 $Y=0.135
c2 3 vss 0.121208f $X=0.189 $Y=0.0245
c3 4 vss 0.00697838f $X=0.189 $Y=0.0935
r1 14 15 3.32295 $w=1.3e-08 $l=1.43e-08 $layer=M1 $thickness=3.6e-08 $X=0.189
+ $Y=0.1207 $X2=0.189 $Y2=0.135
r2 13 14 1.34084 $w=1.3e-08 $l=5.7e-09 $layer=M1 $thickness=3.6e-08 $X=0.189
+ $Y=0.115 $X2=0.189 $Y2=0.1207
r3 13 12 1.10765 $w=1.3e-08 $l=4.8e-09 $layer=M1 $thickness=3.6e-08 $X=0.189
+ $Y=0.115 $X2=0.189 $Y2=0.1102
r4 4 12 3.90593 $w=1.3e-08 $l=1.67e-08 $layer=M1 $thickness=3.6e-08 $X=0.189
+ $Y=0.0935 $X2=0.189 $Y2=0.1102
r5 1 7 10.4265 $w=1.765e-08 $layer=LIG $thickness=5.2e-08 $X=0.189 $Y=0.135
+ $X2=0.189 $Y2=0.135
r6 1 15 19.3796 $a=3.24e-16 $layer=V0LIG $X=0.189 $Y=0.135 $X2=0.189 $Y2=0.135
r7 9 8 16.4967 $w=2.1e-08 $l=4.85e-08 $layer=Gate_1 $thickness=5.6e-08 $X=0.189
+ $Y=0.2025 $X2=0.189 $Y2=0.154
r8 7 8 6.6497 $w=2.04211e-08 $l=1.9e-08 $layer=Gate_1 $thickness=5.6e-08
+ $X=0.189 $Y=0.135 $X2=0.189 $Y2=0.154
r9 6 7 6.6497 $w=2.04211e-08 $l=1.9e-08 $layer=Gate_1 $thickness=5.6e-08
+ $X=0.189 $Y=0.116 $X2=0.189 $Y2=0.135
r10 5 6 16.4967 $w=2.1e-08 $l=4.85e-08 $layer=Gate_1 $thickness=5.6e-08
+ $X=0.189 $Y=0.0675 $X2=0.189 $Y2=0.116
r11 5 3 14.6259 $w=2.1e-08 $l=4.3e-08 $layer=Gate_1 $thickness=5.6e-08 $X=0.189
+ $Y=0.0675 $X2=0.189 $Y2=0.0245
.ends

* End of included file AO331x1_ASAP7_75t_R.pex.sp.pex

*
.subckt AO331x1_ASAP7_75t_CUSTOM_4_25_0_7 VSS VDD A3 A2 A1 B1 B2 B3 C Y
*
* VSS VSS
* VDD VDD
* A3 A3
* A2 A2
* A1 A1
* B1 B1
* B2 B2
* B3 B3
* C C
* Y Y
*
*

M0 VSS N_M0_g N_M0_s VSS nmos_rvt L=2e-08 W=8.1e-08 nfin=3 $X=0.071 $Y=0.027
M1 noxref_14 N_M1_g VSS VSS nmos_rvt L=2e-08 W=8.1e-08 nfin=3 $X=0.125 $Y=0.027
M2 noxref_15 N_M2_g noxref_14 VSS nmos_rvt L=2e-08 W=8.1e-08 nfin=3 $X=0.179
+ $Y=0.027
M3 N_M3_d N_M3_g noxref_15 VSS nmos_rvt L=2e-08 W=8.1e-08 nfin=3 $X=0.233
+ $Y=0.027
M4 noxref_16 N_M4_g N_M4_s VSS nmos_rvt L=2e-08 W=8.1e-08 nfin=3 $X=0.287
+ $Y=0.027
M5 noxref_17 N_M5_g noxref_16 VSS nmos_rvt L=2e-08 W=8.1e-08 nfin=3 $X=0.341
+ $Y=0.027
M6 VSS N_M6_g noxref_17 VSS nmos_rvt L=2e-08 W=8.1e-08 nfin=3 $X=0.395 $Y=0.027
M7 N_M7_d N_M7_g VSS VSS nmos_rvt L=2e-08 W=8.1e-08 nfin=3 $X=0.449 $Y=0.027
M8 VDD N_M8_g N_M8_s VDD pmos_rvt L=2e-08 W=8.1e-08 nfin=3 $X=0.071 $Y=0.162
M9 noxref_12 N_M9_g VDD VDD pmos_rvt L=2e-08 W=8.1e-08 nfin=3 $X=0.125 $Y=0.162
M10 VDD N_M10_g noxref_12 VDD pmos_rvt L=2e-08 W=8.1e-08 nfin=3 $X=0.179
+ $Y=0.162
M11 noxref_12 N_M11_g VDD VDD pmos_rvt L=2e-08 W=8.1e-08 nfin=3 $X=0.233
+ $Y=0.162
M12 noxref_13 N_M12_g noxref_12 VDD pmos_rvt L=2e-08 W=8.1e-08 nfin=3 $X=0.287
+ $Y=0.162
M13 noxref_12 N_M13_g noxref_13 VDD pmos_rvt L=2e-08 W=8.1e-08 nfin=3 $X=0.341
+ $Y=0.162
M14 noxref_13 N_M14_g noxref_12 VDD pmos_rvt L=2e-08 W=8.1e-08 nfin=3 $X=0.395
+ $Y=0.162
M15 N_M15_d N_M15_g noxref_13 VDD pmos_rvt L=2e-08 W=8.1e-08 nfin=3 $X=0.449
+ $Y=0.162

* .include "AO331x1_ASAP7_75t_R.pex.sp.pxi"

* Start of included file AO331x1_ASAP7_75t_R.pex.sp.pxi
x_PM_AO331x1_ASAP7_75t_R%A1 vss A1 N_M3_g N_M11_g N_A1_4 N_A1_3
+ PM_AO331x1_ASAP7_75t_R%A1
cc_1 N_A1_4 N_3_24 0.0012387f $X=0.243 $Y=0.0922
cc_2 N_A1_3 N_3_3 0.00143902f $X=0.243 $Y=0.0245
cc_3 N_A1_4 N_3_3 0.00186199f $X=0.243 $Y=0.0922
cc_4 N_A1_3 N_3_13 0.036297f $X=0.243 $Y=0.0245
cc_5 N_A1_4 N_A2_4 0.00464689f $X=0.243 $Y=0.0922
cc_6 N_A1_3 N_A2_3 0.00708647f $X=0.243 $Y=0.0245
x_PM_AO331x1_ASAP7_75t_R%B1 vss B1 N_M4_g N_M12_g N_B1_4 N_B1_3
+ PM_AO331x1_ASAP7_75t_R%B1
cc_7 N_B1_4 N_3_24 0.00124711f $X=0.297 $Y=0.0927
cc_8 N_B1_3 N_3_3 0.00148935f $X=0.297 $Y=0.0245
cc_9 N_B1_4 N_3_3 0.00172334f $X=0.297 $Y=0.0927
cc_10 N_B1_3 N_3_13 0.0360165f $X=0.297 $Y=0.0245
cc_11 N_B1_3 N_A1_3 0.00315942f $X=0.297 $Y=0.0245
cc_12 N_B1_4 N_A1_4 0.00528938f $X=0.297 $Y=0.0927
x_PM_AO331x1_ASAP7_75t_R%B2 vss B2 N_M5_g N_M13_g N_B2_4 N_B2_3
+ PM_AO331x1_ASAP7_75t_R%B2
cc_13 N_B2_4 N_3_24 0.00354183f $X=0.351 $Y=0.0922
cc_14 N_B2_4 N_B1_4 0.00337179f $X=0.351 $Y=0.0922
cc_15 N_B2_3 N_B1_3 0.00697514f $X=0.351 $Y=0.0245
x_PM_AO331x1_ASAP7_75t_R%B3 vss B3 N_M6_g N_M14_g N_B3_4 N_B3_3
+ PM_AO331x1_ASAP7_75t_R%B3
cc_16 N_B3_4 N_3_24 0.00310341f $X=0.405 $Y=0.0922
cc_17 N_B3_4 N_B2_4 0.00331594f $X=0.405 $Y=0.0922
cc_18 N_B3_3 N_B2_3 0.0070283f $X=0.405 $Y=0.0245
x_PM_AO331x1_ASAP7_75t_R%C vss C N_M7_g N_M15_g N_C_3 N_C_1 N_C_4
+ PM_AO331x1_ASAP7_75t_R%C
cc_19 N_C_3 N_3_15 0.0152531f $X=0.459 $Y=0.0245
cc_20 N_C_3 N_3_5 0.00176727f $X=0.459 $Y=0.0245
cc_21 N_C_3 N_3_24 0.00102254f $X=0.459 $Y=0.0245
cc_22 N_C_3 N_3_4 0.00120607f $X=0.459 $Y=0.0245
cc_23 N_C_1 N_3_14 0.00166094f $X=0.459 $Y=0.135
cc_24 N_C_4 N_3_25 0.00596247f $X=0.459 $Y=0.0922
cc_25 N_C_3 N_3_14 0.0538203f $X=0.459 $Y=0.0245
cc_26 N_C_4 N_B3_4 0.00321884f $X=0.459 $Y=0.0922
cc_27 N_C_3 N_B3_3 0.00523978f $X=0.459 $Y=0.0245
x_PM_AO331x1_ASAP7_75t_R%Y vss Y N_M0_s N_M8_s N_Y_7 N_Y_12 N_Y_11 N_Y_8
+ PM_AO331x1_ASAP7_75t_R%Y
cc_28 N_Y_7 N_3_16 0.000250152f $X=0.056 $Y=0.0675
cc_29 N_Y_7 N_3_17 0.000362474f $X=0.056 $Y=0.0675
cc_30 N_Y_7 N_3_22 0.000433621f $X=0.056 $Y=0.0675
cc_31 N_Y_7 N_3_1 0.00250221f $X=0.056 $Y=0.0675
cc_32 N_Y_12 N_3_16 0.00250886f $X=0.0405 $Y=0.036
cc_33 N_Y_11 N_3_21 0.00435744f $X=0.027 $Y=0.054
cc_34 N_Y_8 N_3_12 0.0148569f $X=0.056 $Y=0.2025
cc_35 N_Y_7 N_3_12 0.0568259f $X=0.056 $Y=0.0675
x_PM_AO331x1_ASAP7_75t_R%3 vss N_M0_g N_M8_g N_M3_d N_M4_s N_M7_d N_M15_d
+ N_3_18 N_3_1 N_3_21 N_3_12 N_3_3 N_3_24 N_3_13 N_3_15 N_3_5 N_3_4 N_3_14
+ N_3_25 N_3_16 N_3_17 N_3_22 PM_AO331x1_ASAP7_75t_R%3
x_PM_AO331x1_ASAP7_75t_R%A3 vss A3 N_M1_g N_M9_g N_A3_3 N_A3_4
+ PM_AO331x1_ASAP7_75t_R%A3
cc_36 N_A3_3 N_3_18 0.00055054f $X=0.135 $Y=0.0245
cc_37 N_A3_3 N_3_1 0.00200458f $X=0.135 $Y=0.0245
cc_38 N_A3_4 N_3_21 0.00326706f $X=0.135 $Y=0.1102
cc_39 N_A3_3 N_3_12 0.00392649f $X=0.135 $Y=0.0245
x_PM_AO331x1_ASAP7_75t_R%A2 vss A2 N_M2_g N_M10_g N_A2_4 N_A2_3
+ PM_AO331x1_ASAP7_75t_R%A2
cc_40 N_A2_4 N_3_3 0.00036428f $X=0.189 $Y=0.0935
cc_41 N_A2_4 N_3_24 0.00131933f $X=0.189 $Y=0.0935
cc_42 N_A2_4 N_3_18 0.0030436f $X=0.189 $Y=0.0935
cc_43 N_A2_4 N_A3_4 0.00364963f $X=0.189 $Y=0.0935
cc_44 N_A2_3 N_A3_3 0.00694222f $X=0.189 $Y=0.0245

* End of included file AO331x1_ASAP7_75t_R.pex.sp.pxi
.ends

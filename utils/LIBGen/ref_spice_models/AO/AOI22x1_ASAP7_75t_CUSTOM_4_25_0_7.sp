.subckt PM_AOI22x1_ASAP7_75t_R%B1 vss 30 8 12 25 28 3 1 5 4
c1 1 vss 0.014951f $X=0.1795 $Y=0.135
c2 3 vss 0.138146f $X=0.135 $Y=0.135
c3 4 vss 0.139409f $X=0.189 $Y=0.0245
c4 5 vss 0.00193795f $X=0.1812 $Y=0.108
c5 6 vss 0.00709116f $X=0.189 $Y=0.198
c6 7 vss 0.00351737f $X=0.189 $Y=0.1215
r1 6 23 3.01711 $w=1.55e-08 $l=1.8e-08 $layer=M1 $thickness=3.6e-08 $X=0.189
+ $Y=0.198 $X2=0.189 $Y2=0.18
r2 30 31 0.790844 $w=1.8e-08 $l=7.7e-09 $layer=M1 $thickness=3.6e-08 $X=0.183
+ $Y=0.108 $X2=0.1907 $Y2=0.108
r3 30 5 0.178578 $w=1.8e-08 $l=1.8e-09 $layer=M1 $thickness=3.6e-08 $X=0.183
+ $Y=0.108 $X2=0.1812 $Y2=0.108
r4 28 27 16.4967 $w=2.1e-08 $l=4.85e-08 $layer=Gate_1 $thickness=5.6e-08
+ $X=0.135 $Y=0.2025 $X2=0.135 $Y2=0.154
r5 25 26 16.4967 $w=2.1e-08 $l=4.85e-08 $layer=Gate_1 $thickness=5.6e-08
+ $X=0.135 $Y=0.0675 $X2=0.135 $Y2=0.116
r6 3 17 6.54019 $w=2.09524e-08 $layer=Gate_1 $thickness=5.21905e-08 $X=0.135
+ $Y=0.135 $X2=0.135 $Y2=0.135
r7 3 26 6.6497 $w=2.04211e-08 $l=1.9e-08 $layer=Gate_1 $thickness=5.6e-08
+ $X=0.135 $Y=0.135 $X2=0.135 $Y2=0.116
r8 3 27 6.6497 $w=2.04211e-08 $l=1.9e-08 $layer=Gate_1 $thickness=5.6e-08
+ $X=0.135 $Y=0.135 $X2=0.135 $Y2=0.154
r9 22 23 4.08082 $w=1.3e-08 $l=1.75e-08 $layer=M1 $thickness=3.6e-08 $X=0.189
+ $Y=0.1625 $X2=0.189 $Y2=0.18
r10 21 22 3.14806 $w=1.3e-08 $l=1.35e-08 $layer=M1 $thickness=3.6e-08 $X=0.189
+ $Y=0.149 $X2=0.189 $Y2=0.1625
r11 20 21 3.26466 $w=1.3e-08 $l=1.4e-08 $layer=M1 $thickness=3.6e-08 $X=0.189
+ $Y=0.135 $X2=0.189 $Y2=0.149
r12 7 20 3.14806 $w=1.3e-08 $l=1.35e-08 $layer=M1 $thickness=3.6e-08 $X=0.189
+ $Y=0.1215 $X2=0.189 $Y2=0.135
r13 7 31 1.78918 $w=1.60851e-08 $l=1.36066e-08 $layer=M1 $thickness=3.6e-08
+ $X=0.189 $Y=0.1215 $X2=0.1907 $Y2=0.108
r14 16 17 12.6539 $w=1.77815e-08 $l=2.7e-08 $layer=LIG $thickness=4.8e-08
+ $X=0.162 $Y=0.135 $X2=0.135 $Y2=0.135
r15 14 15 2.48102 $w=2.2e-08 $l=9.5e-09 $layer=LIG $thickness=4.8e-08 $X=0.189
+ $Y=0.135 $X2=0.1985 $Y2=0.135
r16 14 20 19.3796 $a=3.24e-16 $layer=V0LIG $X=0.189 $Y=0.135 $X2=0.189 $Y2=0.135
r17 1 14 2.48102 $w=2.2e-08 $l=9.5e-09 $layer=LIG $thickness=4.8e-08 $X=0.1795
+ $Y=0.135 $X2=0.189 $Y2=0.135
r18 1 16 10.1729 $w=1.54914e-08 $l=1.75e-08 $layer=LIG $thickness=4.8e-08
+ $X=0.1795 $Y=0.135 $X2=0.162 $Y2=0.135
r19 12 11 16.4967 $w=2.1e-08 $l=4.85e-08 $layer=Gate_1 $thickness=5.6e-08
+ $X=0.189 $Y=0.2025 $X2=0.189 $Y2=0.154
r20 10 11 6.6497 $w=2.04211e-08 $l=1.9e-08 $layer=Gate_1 $thickness=5.6e-08
+ $X=0.189 $Y=0.135 $X2=0.189 $Y2=0.154
r21 10 15 4.05918 $w=2.0087e-08 $l=9.5e-09 $layer=Gate_1 $thickness=5.56522e-08
+ $X=0.189 $Y=0.135 $X2=0.1985 $Y2=0.135
r22 10 14 6.27904 $w=2.09e-08 $layer=Gate_1 $thickness=5.24e-08 $X=0.189
+ $Y=0.135 $X2=0.189 $Y2=0.135
r23 9 10 6.6497 $w=2.04211e-08 $l=1.9e-08 $layer=Gate_1 $thickness=5.6e-08
+ $X=0.189 $Y=0.116 $X2=0.189 $Y2=0.135
r24 8 9 16.4967 $w=2.1e-08 $l=4.85e-08 $layer=Gate_1 $thickness=5.6e-08
+ $X=0.189 $Y=0.0675 $X2=0.189 $Y2=0.116
r25 8 4 14.6259 $w=2.1e-08 $l=4.3e-08 $layer=Gate_1 $thickness=5.6e-08 $X=0.189
+ $Y=0.0675 $X2=0.189 $Y2=0.0245
.ends

.subckt PM_AOI22x1_ASAP7_75t_R%A1 vss 28 8 12 22 25 4 5 1 3 6
c1 1 vss 0.0136766f $X=0.3415 $Y=0.135
c2 3 vss 0.102107f $X=0.351 $Y=0.0245
c3 4 vss 0.101181f $X=0.405 $Y=0.135
c4 5 vss 0.00284793f $X=0.351 $Y=0.108
c5 6 vss 0.00306767f $X=0.3502 $Y=0.162
c6 7 vss 0.00212483f $X=0.351 $Y=0.1345
r1 28 29 0.0765333 $w=1.8e-08 $l=7e-10 $layer=M1 $thickness=3.6e-08 $X=0.359
+ $Y=0.162 $X2=0.3597 $Y2=0.162
r2 28 6 0.892889 $w=1.8e-08 $l=8.8e-09 $layer=M1 $thickness=3.6e-08 $X=0.359
+ $Y=0.162 $X2=0.3502 $Y2=0.162
r3 6 20 0.958461 $w=1.77143e-08 $l=9.53363e-09 $layer=M1 $thickness=3.6e-08
+ $X=0.3502 $Y=0.162 $X2=0.351 $Y2=0.1525
r4 5 7 4.99922 $w=1.46981e-08 $l=2.65e-08 $layer=M1 $thickness=3.6e-08 $X=0.351
+ $Y=0.108 $X2=0.351 $Y2=0.1345
r5 25 24 16.4967 $w=2.1e-08 $l=4.85e-08 $layer=Gate_1 $thickness=5.6e-08
+ $X=0.405 $Y=0.2025 $X2=0.405 $Y2=0.154
r6 22 23 16.4967 $w=2.1e-08 $l=4.85e-08 $layer=Gate_1 $thickness=5.6e-08
+ $X=0.405 $Y=0.0675 $X2=0.405 $Y2=0.116
r7 4 18 6.54019 $w=2.09524e-08 $layer=Gate_1 $thickness=5.21905e-08 $X=0.405
+ $Y=0.135 $X2=0.405 $Y2=0.135
r8 4 23 6.6497 $w=2.04211e-08 $l=1.9e-08 $layer=Gate_1 $thickness=5.6e-08
+ $X=0.405 $Y=0.135 $X2=0.405 $Y2=0.116
r9 4 24 6.6497 $w=2.04211e-08 $l=1.9e-08 $layer=Gate_1 $thickness=5.6e-08
+ $X=0.405 $Y=0.135 $X2=0.405 $Y2=0.154
r10 20 29 0.142106 $w=1.46667e-08 $l=1.28818e-08 $layer=M1 $thickness=3.6e-08
+ $X=0.351 $Y=0.1525 $X2=0.3597 $Y2=0.162
r11 7 14 19.3796 $a=3.24e-16 $layer=V0LIG $X=0.351 $Y=0.1345 $X2=0.351 $Y2=0.135
r12 7 20 4.19742 $w=1.3e-08 $l=1.8e-08 $layer=M1 $thickness=3.6e-08 $X=0.351
+ $Y=0.1345 $X2=0.351 $Y2=0.1525
r13 17 18 12.6539 $w=1.77815e-08 $l=2.7e-08 $layer=LIG $thickness=4.8e-08
+ $X=0.378 $Y=0.135 $X2=0.405 $Y2=0.135
r14 15 17 10.1729 $w=1.54914e-08 $l=1.75e-08 $layer=LIG $thickness=4.8e-08
+ $X=0.3605 $Y=0.135 $X2=0.378 $Y2=0.135
r15 14 15 2.48102 $w=2.2e-08 $l=9.5e-09 $layer=LIG $thickness=4.8e-08 $X=0.351
+ $Y=0.135 $X2=0.3605 $Y2=0.135
r16 1 14 2.48102 $w=2.2e-08 $l=9.5e-09 $layer=LIG $thickness=4.8e-08 $X=0.3415
+ $Y=0.135 $X2=0.351 $Y2=0.135
r17 12 11 16.4967 $w=2.1e-08 $l=4.85e-08 $layer=Gate_1 $thickness=5.6e-08
+ $X=0.351 $Y=0.2025 $X2=0.351 $Y2=0.154
r18 10 11 6.6497 $w=2.04211e-08 $l=1.9e-08 $layer=Gate_1 $thickness=5.6e-08
+ $X=0.351 $Y=0.135 $X2=0.351 $Y2=0.154
r19 10 15 4.05918 $w=2.0087e-08 $l=9.5e-09 $layer=Gate_1 $thickness=5.56522e-08
+ $X=0.351 $Y=0.135 $X2=0.3605 $Y2=0.135
r20 10 14 6.27904 $w=2.09e-08 $layer=Gate_1 $thickness=5.24e-08 $X=0.351
+ $Y=0.135 $X2=0.351 $Y2=0.135
r21 9 10 6.6497 $w=2.04211e-08 $l=1.9e-08 $layer=Gate_1 $thickness=5.6e-08
+ $X=0.351 $Y=0.116 $X2=0.351 $Y2=0.135
r22 8 9 16.4967 $w=2.1e-08 $l=4.85e-08 $layer=Gate_1 $thickness=5.6e-08
+ $X=0.351 $Y=0.0675 $X2=0.351 $Y2=0.116
r23 8 3 14.6259 $w=2.1e-08 $l=4.3e-08 $layer=Gate_1 $thickness=5.6e-08 $X=0.351
+ $Y=0.0675 $X2=0.351 $Y2=0.0245
.ends

.subckt PM_AOI22x1_ASAP7_75t_R%Y vss 44 27 41 42 49 61 62 65 66 2 17 16 1 23 20
+ 19 5 3 4 18 25 24
c1 1 vss 0.00727301f $X=0.054 $Y=0.0675
c2 2 vss 0.00534123f $X=0.27 $Y=0.0675
c3 3 vss 0.00965008f $X=0.324 $Y=0.2025
c4 4 vss 0.009199f $X=0.432 $Y=0.2025
c5 5 vss 0.00646582f $X=0.486 $Y=0.0675
c6 16 vss 0.0365252f $X=0.056 $Y=0.0675
c7 17 vss 0.00251775f $X=0.2555 $Y=0.0675
c8 18 vss 0.0371697f $X=0.4715 $Y=0.0675
c9 19 vss 0.00455913f $X=0.3095 $Y=0.2025
c10 20 vss 0.00454099f $X=0.4175 $Y=0.2025
c11 21 vss 0.00262301f $X=0.513 $Y=0.036
c12 22 vss 0.00233443f $X=0.513 $Y=0.198
c13 23 vss 0.0385392f $X=0.039 $Y=0.036
c14 24 vss 0.0162849f $X=0.502 $Y=0.198
c15 25 vss 0.00452067f $X=0.513 $Y=0.054
r1 66 64 0.0308642 $w=8.1e-08 $l=2.5e-09 $layer=P_src_drn $thickness=1e-09
+ $X=0.3413 $Y=0.2025 $X2=0.3385 $Y2=0.2025
r2 3 64 0.179012 $w=8.1e-08 $l=1.45e-08 $layer=P_src_drn $thickness=1e-09
+ $X=0.324 $Y=0.2025 $X2=0.3385 $Y2=0.2025
r3 19 3 0.179012 $w=8.1e-08 $l=1.45e-08 $layer=P_src_drn $thickness=1e-09
+ $X=0.3095 $Y=0.2025 $X2=0.324 $Y2=0.2025
r4 65 19 0.0308642 $w=8.1e-08 $l=2.5e-09 $layer=P_src_drn $thickness=1e-09
+ $X=0.3066 $Y=0.2025 $X2=0.3095 $Y2=0.2025
r5 62 60 0.0308642 $w=8.1e-08 $l=2.5e-09 $layer=P_src_drn $thickness=1e-09
+ $X=0.4493 $Y=0.2025 $X2=0.4465 $Y2=0.2025
r6 4 60 0.179012 $w=8.1e-08 $l=1.45e-08 $layer=P_src_drn $thickness=1e-09
+ $X=0.432 $Y=0.2025 $X2=0.4465 $Y2=0.2025
r7 20 4 0.179012 $w=8.1e-08 $l=1.45e-08 $layer=P_src_drn $thickness=1e-09
+ $X=0.4175 $Y=0.2025 $X2=0.432 $Y2=0.2025
r8 61 20 0.0308642 $w=8.1e-08 $l=2.5e-09 $layer=P_src_drn $thickness=1e-09
+ $X=0.4146 $Y=0.2025 $X2=0.4175 $Y2=0.2025
r9 3 57 19.3796 $a=3.24e-16 $layer=V0LISD $X=0.324 $Y=0.2025 $X2=0.324 $Y2=0.198
r10 4 51 19.3796 $a=3.24e-16 $layer=V0LISD $X=0.432 $Y=0.2025 $X2=0.436
+ $Y2=0.198
r11 57 58 3.14806 $w=1.3e-08 $l=1.35e-08 $layer=M1 $thickness=3.6e-08 $X=0.324
+ $Y=0.198 $X2=0.3375 $Y2=0.198
r12 55 58 5.36336 $w=1.3e-08 $l=2.3e-08 $layer=M1 $thickness=3.6e-08 $X=0.3605
+ $Y=0.198 $X2=0.3375 $Y2=0.198
r13 53 54 6.06293 $w=1.3e-08 $l=2.6e-08 $layer=M1 $thickness=3.6e-08 $X=0.401
+ $Y=0.198 $X2=0.427 $Y2=0.198
r14 53 55 9.44418 $w=1.3e-08 $l=4.05e-08 $layer=M1 $thickness=3.6e-08 $X=0.401
+ $Y=0.198 $X2=0.3605 $Y2=0.198
r15 51 52 4.31401 $w=1.3e-08 $l=1.85e-08 $layer=M1 $thickness=3.6e-08 $X=0.436
+ $Y=0.198 $X2=0.4545 $Y2=0.198
r16 51 54 2.09871 $w=1.3e-08 $l=9e-09 $layer=M1 $thickness=3.6e-08 $X=0.436
+ $Y=0.198 $X2=0.427 $Y2=0.198
r17 50 52 6.8791 $w=1.3e-08 $l=2.95e-08 $layer=M1 $thickness=3.6e-08 $X=0.484
+ $Y=0.198 $X2=0.4545 $Y2=0.198
r18 24 50 4.19742 $w=1.3e-08 $l=1.8e-08 $layer=M1 $thickness=3.6e-08 $X=0.502
+ $Y=0.198 $X2=0.484 $Y2=0.198
r19 22 47 2.5483 $w=1.79e-08 $l=1.8e-08 $layer=M1 $thickness=3.6e-08 $X=0.513
+ $Y=0.198 $X2=0.513 $Y2=0.18
r20 22 24 0.915974 $w=1.70909e-08 $l=1.1e-08 $layer=M1 $thickness=3.6e-08
+ $X=0.513 $Y=0.198 $X2=0.502 $Y2=0.198
r21 18 5 0.154321 $w=8.1e-08 $l=1.25e-08 $layer=N_src_drn $thickness=1e-09
+ $X=0.4715 $Y=0.0675 $X2=0.486 $Y2=0.0675
r22 49 18 0.0308642 $w=8.1e-08 $l=2.5e-09 $layer=N_src_drn $thickness=1e-09
+ $X=0.4686 $Y=0.0675 $X2=0.4715 $Y2=0.0675
r23 46 47 4.19742 $w=1.3e-08 $l=1.8e-08 $layer=M1 $thickness=3.6e-08 $X=0.513
+ $Y=0.162 $X2=0.513 $Y2=0.18
r24 45 46 6.58761 $w=1.3e-08 $l=2.83e-08 $layer=M1 $thickness=3.6e-08 $X=0.513
+ $Y=0.1337 $X2=0.513 $Y2=0.162
r25 44 45 4.6055 $w=1.3e-08 $l=1.97e-08 $layer=M1 $thickness=3.6e-08 $X=0.513
+ $Y=0.114 $X2=0.513 $Y2=0.1337
r26 44 43 6.00464 $w=1.3e-08 $l=2.58e-08 $layer=M1 $thickness=3.6e-08 $X=0.513
+ $Y=0.114 $X2=0.513 $Y2=0.0882
r27 25 43 7.98675 $w=1.3e-08 $l=3.42e-08 $layer=M1 $thickness=3.6e-08 $X=0.513
+ $Y=0.054 $X2=0.513 $Y2=0.0882
r28 42 40 0.0308642 $w=8.1e-08 $l=2.5e-09 $layer=N_src_drn $thickness=1e-09
+ $X=0.2873 $Y=0.0675 $X2=0.2845 $Y2=0.0675
r29 2 40 0.179012 $w=8.1e-08 $l=1.45e-08 $layer=N_src_drn $thickness=1e-09
+ $X=0.27 $Y=0.0675 $X2=0.2845 $Y2=0.0675
r30 17 2 0.179012 $w=8.1e-08 $l=1.45e-08 $layer=N_src_drn $thickness=1e-09
+ $X=0.2555 $Y=0.0675 $X2=0.27 $Y2=0.0675
r31 41 17 0.0308642 $w=8.1e-08 $l=2.5e-09 $layer=N_src_drn $thickness=1e-09
+ $X=0.2526 $Y=0.0675 $X2=0.2555 $Y2=0.0675
r32 5 37 19.3796 $a=3.24e-16 $layer=V0LISD $X=0.486 $Y=0.0675 $X2=0.486
+ $Y2=0.036
r33 21 38 1.49895 $w=1.63333e-08 $l=1.35e-08 $layer=M1 $thickness=3.6e-08
+ $X=0.513 $Y=0.036 $X2=0.4995 $Y2=0.036
r34 21 25 2.5483 $w=1.79e-08 $l=1.8e-08 $layer=M1 $thickness=3.6e-08 $X=0.513
+ $Y=0.036 $X2=0.513 $Y2=0.054
r35 2 33 19.3796 $a=3.24e-16 $layer=V0LISD $X=0.27 $Y=0.0675 $X2=0.27 $Y2=0.036
r36 37 38 3.14806 $w=1.3e-08 $l=1.35e-08 $layer=M1 $thickness=3.6e-08 $X=0.486
+ $Y=0.036 $X2=0.4995 $Y2=0.036
r37 36 37 3.14806 $w=1.3e-08 $l=1.35e-08 $layer=M1 $thickness=3.6e-08 $X=0.4725
+ $Y=0.036 $X2=0.486 $Y2=0.036
r38 35 36 22.0364 $w=1.3e-08 $l=9.45e-08 $layer=M1 $thickness=3.6e-08 $X=0.378
+ $Y=0.036 $X2=0.4725 $Y2=0.036
r39 34 35 22.0364 $w=1.3e-08 $l=9.45e-08 $layer=M1 $thickness=3.6e-08 $X=0.2835
+ $Y=0.036 $X2=0.378 $Y2=0.036
r40 33 34 3.14806 $w=1.3e-08 $l=1.35e-08 $layer=M1 $thickness=3.6e-08 $X=0.27
+ $Y=0.036 $X2=0.2835 $Y2=0.036
r41 32 33 3.14806 $w=1.3e-08 $l=1.35e-08 $layer=M1 $thickness=3.6e-08 $X=0.2565
+ $Y=0.036 $X2=0.27 $Y2=0.036
r42 31 32 22.0364 $w=1.3e-08 $l=9.45e-08 $layer=M1 $thickness=3.6e-08 $X=0.162
+ $Y=0.036 $X2=0.2565 $Y2=0.036
r43 30 31 22.0364 $w=1.3e-08 $l=9.45e-08 $layer=M1 $thickness=3.6e-08 $X=0.0675
+ $Y=0.036 $X2=0.162 $Y2=0.036
r44 29 30 3.14806 $w=1.3e-08 $l=1.35e-08 $layer=M1 $thickness=3.6e-08 $X=0.054
+ $Y=0.036 $X2=0.0675 $Y2=0.036
r45 28 29 2.68168 $w=1.3e-08 $l=1.15e-08 $layer=M1 $thickness=3.6e-08 $X=0.0425
+ $Y=0.036 $X2=0.054 $Y2=0.036
r46 23 28 0.816164 $w=1.3e-08 $l=3.5e-09 $layer=M1 $thickness=3.6e-08 $X=0.039
+ $Y=0.036 $X2=0.0425 $Y2=0.036
r47 1 29 19.3796 $a=3.24e-16 $layer=V0LISD $X=0.054 $Y=0.0675 $X2=0.054
+ $Y2=0.036
r48 27 26 0.0308642 $w=8.1e-08 $l=2.5e-09 $layer=N_src_drn $thickness=1e-09
+ $X=0.0713 $Y=0.0675 $X2=0.0685 $Y2=0.0675
r49 16 26 0.154321 $w=8.1e-08 $l=1.25e-08 $layer=N_src_drn $thickness=1e-09
+ $X=0.056 $Y=0.0675 $X2=0.0685 $Y2=0.0675
r50 1 16 1e-05 $l=2e-09 $X=0.054 $Y=0.0675 $X2=0.056 $Y2=0.0675
.ends

.subckt PM_AOI22x1_ASAP7_75t_R%A2 vss 25 13 17 37 40 1 10 5 11 6 2 9 12 8 7
c1 1 vss 0.00575578f $X=0.297 $Y=0.135
c2 2 vss 0.00633025f $X=0.459 $Y=0.135
c3 5 vss 0.0642837f $X=0.297 $Y=0.0245
c4 6 vss 0.0672959f $X=0.459 $Y=0.135
c5 7 vss 0.00225258f $X=0.297 $Y=0.072
c6 8 vss 0.00281585f $X=0.459 $Y=0.162
c7 9 vss 0.00224893f $X=0.459 $Y=0.072
c8 10 vss 0.00342298f $X=0.297 $Y=0.1215
c9 11 vss 0.0051849f $X=0.3075 $Y=0.072
c10 12 vss 0.00251608f $X=0.459 $Y=0.09
r1 40 39 16.4967 $w=2.1e-08 $l=4.85e-08 $layer=Gate_1 $thickness=5.6e-08
+ $X=0.459 $Y=0.2025 $X2=0.459 $Y2=0.154
r2 37 38 16.4967 $w=2.1e-08 $l=4.85e-08 $layer=Gate_1 $thickness=5.6e-08
+ $X=0.459 $Y=0.0675 $X2=0.459 $Y2=0.116
r3 6 38 6.6497 $w=2.04211e-08 $l=1.9e-08 $layer=Gate_1 $thickness=5.6e-08
+ $X=0.459 $Y=0.135 $X2=0.459 $Y2=0.116
r4 6 39 6.6497 $w=2.04211e-08 $l=1.9e-08 $layer=Gate_1 $thickness=5.6e-08
+ $X=0.459 $Y=0.135 $X2=0.459 $Y2=0.154
r5 2 33 19.3796 $a=3.24e-16 $layer=V0LIG $X=0.459 $Y=0.135 $X2=0.459 $Y2=0.135
r6 2 6 10.4265 $w=1.765e-08 $layer=LIG $thickness=5.2e-08 $X=0.459 $Y=0.135
+ $X2=0.459 $Y2=0.135
r7 8 34 1.96775 $w=1.63333e-08 $l=1.35e-08 $layer=M1 $thickness=3.6e-08
+ $X=0.459 $Y=0.162 $X2=0.459 $Y2=0.1485
r8 33 34 3.14806 $w=1.3e-08 $l=1.35e-08 $layer=M1 $thickness=3.6e-08 $X=0.459
+ $Y=0.135 $X2=0.459 $Y2=0.1485
r9 32 33 3.14806 $w=1.3e-08 $l=1.35e-08 $layer=M1 $thickness=3.6e-08 $X=0.459
+ $Y=0.1215 $X2=0.459 $Y2=0.135
r10 31 32 3.14806 $w=1.3e-08 $l=1.35e-08 $layer=M1 $thickness=3.6e-08 $X=0.459
+ $Y=0.108 $X2=0.459 $Y2=0.1215
r11 12 31 4.19742 $w=1.3e-08 $l=1.8e-08 $layer=M1 $thickness=3.6e-08 $X=0.459
+ $Y=0.09 $X2=0.459 $Y2=0.108
r12 9 30 2.6649 $w=1.54324e-08 $l=1.85e-08 $layer=M1 $thickness=3.6e-08
+ $X=0.459 $Y=0.072 $X2=0.4405 $Y2=0.072
r13 9 12 2.5483 $w=1.79e-08 $l=1.8e-08 $layer=M1 $thickness=3.6e-08 $X=0.459
+ $Y=0.072 $X2=0.459 $Y2=0.09
r14 29 30 8.27824 $w=1.3e-08 $l=3.55e-08 $layer=M1 $thickness=3.6e-08 $X=0.405
+ $Y=0.072 $X2=0.4405 $Y2=0.072
r15 28 29 10.3769 $w=1.3e-08 $l=4.45e-08 $layer=M1 $thickness=3.6e-08 $X=0.3605
+ $Y=0.072 $X2=0.405 $Y2=0.072
r16 27 28 8.16164 $w=1.3e-08 $l=3.5e-08 $layer=M1 $thickness=3.6e-08 $X=0.3255
+ $Y=0.072 $X2=0.3605 $Y2=0.072
r17 11 27 4.19742 $w=1.3e-08 $l=1.8e-08 $layer=M1 $thickness=3.6e-08 $X=0.3075
+ $Y=0.072 $X2=0.3255 $Y2=0.072
r18 7 24 1.09087 $w=2.05064e-08 $l=1.17e-08 $layer=M1 $thickness=3.6e-08
+ $X=0.297 $Y=0.072 $X2=0.297 $Y2=0.0837
r19 7 11 0.79938 $w=1.72857e-08 $l=1.05e-08 $layer=M1 $thickness=3.6e-08
+ $X=0.297 $Y=0.072 $X2=0.3075 $Y2=0.072
r20 25 26 1.45744 $w=1.3e-08 $l=6.2e-09 $layer=M1 $thickness=3.6e-08 $X=0.296
+ $Y=0.087 $X2=0.297 $Y2=0.0932
r21 25 24 0.757867 $w=1.3e-08 $l=3.3e-09 $layer=M1 $thickness=3.6e-08 $X=0.296
+ $Y=0.087 $X2=0.297 $Y2=0.0837
r22 23 26 3.43955 $w=1.3e-08 $l=1.48e-08 $layer=M1 $thickness=3.6e-08 $X=0.297
+ $Y=0.108 $X2=0.297 $Y2=0.0932
r23 10 21 3.14806 $w=1.3e-08 $l=1.35e-08 $layer=M1 $thickness=3.6e-08 $X=0.297
+ $Y=0.1215 $X2=0.297 $Y2=0.135
r24 10 23 3.14806 $w=1.3e-08 $l=1.35e-08 $layer=M1 $thickness=3.6e-08 $X=0.297
+ $Y=0.1215 $X2=0.297 $Y2=0.108
r25 1 15 6.54019 $w=2.09524e-08 $layer=Gate_1 $thickness=5.21905e-08 $X=0.297
+ $Y=0.135 $X2=0.297 $Y2=0.135
r26 1 21 19.3796 $a=3.24e-16 $layer=V0LIG $X=0.297 $Y=0.135 $X2=0.297 $Y2=0.135
r27 17 16 16.4967 $w=2.1e-08 $l=4.85e-08 $layer=Gate_1 $thickness=5.6e-08
+ $X=0.297 $Y=0.2025 $X2=0.297 $Y2=0.154
r28 15 16 6.6497 $w=2.04211e-08 $l=1.9e-08 $layer=Gate_1 $thickness=5.6e-08
+ $X=0.297 $Y=0.135 $X2=0.297 $Y2=0.154
r29 14 15 6.6497 $w=2.04211e-08 $l=1.9e-08 $layer=Gate_1 $thickness=5.6e-08
+ $X=0.297 $Y=0.116 $X2=0.297 $Y2=0.135
r30 13 14 16.4967 $w=2.1e-08 $l=4.85e-08 $layer=Gate_1 $thickness=5.6e-08
+ $X=0.297 $Y=0.0675 $X2=0.297 $Y2=0.116
r31 13 5 14.6259 $w=2.1e-08 $l=4.3e-08 $layer=Gate_1 $thickness=5.6e-08
+ $X=0.297 $Y=0.0675 $X2=0.297 $Y2=0.0245
.ends

.subckt PM_AOI22x1_ASAP7_75t_R%B2 vss 25 13 19 40 43 8 2 12 1 11 6 5 10 7 9
c1 1 vss 0.00504541f $X=0.081 $Y=0.135
c2 2 vss 0.00425499f $X=0.243 $Y=0.135
c3 5 vss 0.107228f $X=0.081 $Y=0.0245
c4 6 vss 0.101097f $X=0.243 $Y=0.135
c5 7 vss 0.00106208f $X=0.081 $Y=0.072
c6 8 vss 0.00738334f $X=0.081 $Y=0.198
c7 9 vss 0.000566644f $X=0.243 $Y=0.072
c8 10 vss 0.00755336f $X=0.081 $Y=0.108
c9 11 vss 0.00536295f $X=0.0995 $Y=0.072
c10 12 vss 0.00320093f $X=0.243 $Y=0.09
r1 43 42 16.4967 $w=2.1e-08 $l=4.85e-08 $layer=Gate_1 $thickness=5.6e-08
+ $X=0.243 $Y=0.2025 $X2=0.243 $Y2=0.154
r2 40 41 16.4967 $w=2.1e-08 $l=4.85e-08 $layer=Gate_1 $thickness=5.6e-08
+ $X=0.243 $Y=0.0675 $X2=0.243 $Y2=0.116
r3 6 41 6.6497 $w=2.04211e-08 $l=1.9e-08 $layer=Gate_1 $thickness=5.6e-08
+ $X=0.243 $Y=0.135 $X2=0.243 $Y2=0.116
r4 6 42 6.6497 $w=2.04211e-08 $l=1.9e-08 $layer=Gate_1 $thickness=5.6e-08
+ $X=0.243 $Y=0.135 $X2=0.243 $Y2=0.154
r5 2 35 19.3796 $a=3.24e-16 $layer=V0LIG $X=0.243 $Y=0.135 $X2=0.243 $Y2=0.135
r6 2 6 10.4265 $w=1.765e-08 $layer=LIG $thickness=5.2e-08 $X=0.243 $Y=0.135
+ $X2=0.243 $Y2=0.135
r7 34 35 3.14806 $w=1.3e-08 $l=1.35e-08 $layer=M1 $thickness=3.6e-08 $X=0.243
+ $Y=0.1215 $X2=0.243 $Y2=0.135
r8 33 34 3.14806 $w=1.3e-08 $l=1.35e-08 $layer=M1 $thickness=3.6e-08 $X=0.243
+ $Y=0.108 $X2=0.243 $Y2=0.1215
r9 12 33 4.19742 $w=1.3e-08 $l=1.8e-08 $layer=M1 $thickness=3.6e-08 $X=0.243
+ $Y=0.09 $X2=0.243 $Y2=0.108
r10 9 32 4.64701 $w=1.46667e-08 $l=2.7e-08 $layer=M1 $thickness=3.6e-08
+ $X=0.243 $Y=0.072 $X2=0.216 $Y2=0.072
r11 9 12 2.5483 $w=1.79e-08 $l=1.8e-08 $layer=M1 $thickness=3.6e-08 $X=0.243
+ $Y=0.072 $X2=0.243 $Y2=0.09
r12 31 32 8.51143 $w=1.3e-08 $l=3.65e-08 $layer=M1 $thickness=3.6e-08 $X=0.1795
+ $Y=0.072 $X2=0.216 $Y2=0.072
r13 30 31 10.3769 $w=1.3e-08 $l=4.45e-08 $layer=M1 $thickness=3.6e-08 $X=0.135
+ $Y=0.072 $X2=0.1795 $Y2=0.072
r14 11 30 8.27824 $w=1.3e-08 $l=3.55e-08 $layer=M1 $thickness=3.6e-08 $X=0.0995
+ $Y=0.072 $X2=0.135 $Y2=0.072
r15 8 28 6.16517 $w=1.44286e-08 $l=3.15e-08 $layer=M1 $thickness=3.6e-08
+ $X=0.081 $Y=0.198 $X2=0.081 $Y2=0.1665
r16 7 23 2.5483 $w=1.79e-08 $l=1.8e-08 $layer=M1 $thickness=3.6e-08 $X=0.081
+ $Y=0.072 $X2=0.081 $Y2=0.09
r17 7 11 2.6649 $w=1.54324e-08 $l=1.85e-08 $layer=M1 $thickness=3.6e-08
+ $X=0.081 $Y=0.072 $X2=0.0995 $Y2=0.072
r18 27 28 7.34548 $w=1.3e-08 $l=3.15e-08 $layer=M1 $thickness=3.6e-08 $X=0.081
+ $Y=0.135 $X2=0.081 $Y2=0.1665
r19 26 27 2.97317 $w=1.3e-08 $l=1.28e-08 $layer=M1 $thickness=3.6e-08 $X=0.081
+ $Y=0.1222 $X2=0.081 $Y2=0.135
r20 25 26 0.991057 $w=1.3e-08 $l=4.2e-09 $layer=M1 $thickness=3.6e-08 $X=0.081
+ $Y=0.118 $X2=0.081 $Y2=0.1222
r21 25 24 0.174892 $w=1.3e-08 $l=8e-10 $layer=M1 $thickness=3.6e-08 $X=0.081
+ $Y=0.118 $X2=0.081 $Y2=0.1172
r22 10 23 4.19742 $w=1.3e-08 $l=1.8e-08 $layer=M1 $thickness=3.6e-08 $X=0.081
+ $Y=0.108 $X2=0.081 $Y2=0.09
r23 10 24 2.15701 $w=1.3e-08 $l=9.2e-09 $layer=M1 $thickness=3.6e-08 $X=0.081
+ $Y=0.108 $X2=0.081 $Y2=0.1172
r24 1 16 6.54019 $w=2.09524e-08 $layer=Gate_1 $thickness=5.21905e-08 $X=0.081
+ $Y=0.135 $X2=0.081 $Y2=0.135
r25 1 27 19.3796 $a=3.24e-16 $layer=V0LIG $X=0.081 $Y=0.135 $X2=0.081 $Y2=0.135
r26 19 18 14.6259 $w=2.1e-08 $l=4.3e-08 $layer=Gate_1 $thickness=5.6e-08
+ $X=0.081 $Y=0.2025 $X2=0.081 $Y2=0.1595
r27 17 18 2.7211 $w=2.1e-08 $l=8e-09 $layer=Gate_1 $thickness=5.6e-08 $X=0.081
+ $Y=0.1515 $X2=0.081 $Y2=0.1595
r28 16 17 5.79936 $w=2.03333e-08 $l=1.65e-08 $layer=Gate_1 $thickness=5.6e-08
+ $X=0.081 $Y=0.135 $X2=0.081 $Y2=0.1515
r29 15 16 5.79936 $w=2.03333e-08 $l=1.65e-08 $layer=Gate_1 $thickness=5.6e-08
+ $X=0.081 $Y=0.1185 $X2=0.081 $Y2=0.135
r30 14 15 2.7211 $w=2.1e-08 $l=8e-09 $layer=Gate_1 $thickness=5.6e-08 $X=0.081
+ $Y=0.1105 $X2=0.081 $Y2=0.1185
r31 13 14 14.6259 $w=2.1e-08 $l=4.3e-08 $layer=Gate_1 $thickness=5.6e-08
+ $X=0.081 $Y=0.0675 $X2=0.081 $Y2=0.1105
r32 13 5 14.6259 $w=2.1e-08 $l=4.3e-08 $layer=Gate_1 $thickness=5.6e-08
+ $X=0.081 $Y=0.0675 $X2=0.081 $Y2=0.0245
.ends

* End of included file AOI22x1_ASAP7_75t_R.pex.sp.pex

*
.subckt AOI22x1_ASAP7_75t_CUSTOM_4_25_0_7 VSS VDD B2 B1 A2 A1 Y
*
* VSS VSS
* VDD VDD
* B2 B2
* B1 B1
* A2 A2
* A1 A1
* Y Y
*
*

M0 N_M0_d N_M0_g noxref_9 VSS nmos_rvt L=2e-08 W=8.1e-08 nfin=3 $X=0.071
+ $Y=0.027
M1 noxref_9 N_M1_g VSS VSS nmos_rvt L=2e-08 W=8.1e-08 nfin=3 $X=0.125 $Y=0.027
M2 noxref_10 N_M2_g VSS VSS nmos_rvt L=2e-08 W=8.1e-08 nfin=3 $X=0.179 $Y=0.027
M3 N_M3_d N_M3_g noxref_10 VSS nmos_rvt L=2e-08 W=8.1e-08 nfin=3 $X=0.233
+ $Y=0.027
M4 N_M4_d N_M4_g noxref_11 VSS nmos_rvt L=2e-08 W=8.1e-08 nfin=3 $X=0.287
+ $Y=0.027
M5 noxref_11 N_M5_g VSS VSS nmos_rvt L=2e-08 W=8.1e-08 nfin=3 $X=0.341 $Y=0.027
M6 noxref_12 N_M6_g VSS VSS nmos_rvt L=2e-08 W=8.1e-08 nfin=3 $X=0.395 $Y=0.027
M7 N_M7_d N_M7_g noxref_12 VSS nmos_rvt L=2e-08 W=8.1e-08 nfin=3 $X=0.449
+ $Y=0.027
M8 VDD N_M8_g noxref_7 VDD pmos_rvt L=2e-08 W=8.1e-08 nfin=3 $X=0.071 $Y=0.162
M9 noxref_7 N_M9_g VDD VDD pmos_rvt L=2e-08 W=8.1e-08 nfin=3 $X=0.125 $Y=0.162
M10 noxref_7 N_M10_g VDD VDD pmos_rvt L=2e-08 W=8.1e-08 nfin=3 $X=0.179 $Y=0.162
M11 VDD N_M11_g noxref_7 VDD pmos_rvt L=2e-08 W=8.1e-08 nfin=3 $X=0.233 $Y=0.162
M12 N_M12_d N_M12_g noxref_7 VDD pmos_rvt L=2e-08 W=8.1e-08 nfin=3 $X=0.287
+ $Y=0.162
M13 noxref_7 N_M13_g N_M13_s VDD pmos_rvt L=2e-08 W=8.1e-08 nfin=3 $X=0.341
+ $Y=0.162
M14 noxref_7 N_M14_g N_M14_s VDD pmos_rvt L=2e-08 W=8.1e-08 nfin=3 $X=0.395
+ $Y=0.162
M15 N_M15_d N_M15_g noxref_7 VDD pmos_rvt L=2e-08 W=8.1e-08 nfin=3 $X=0.449
+ $Y=0.162

* .include "AOI22x1_ASAP7_75t_R.pex.sp.pxi"

* Start of included file AOI22x1_ASAP7_75t_R.pex.sp.pxi
x_PM_AOI22x1_ASAP7_75t_R%B1 vss B1 N_M2_g N_M10_g N_M1_g N_M9_g N_B1_3 N_B1_1
+ N_B1_5 N_B1_4 PM_AOI22x1_ASAP7_75t_R%B1
cc_1 N_B1_3 N_B2_8 0.000794822f $X=0.135 $Y=0.135
cc_2 N_B1_3 N_B2_2 0.000933297f $X=0.135 $Y=0.135
cc_3 N_B1_3 N_B2_12 0.00265849f $X=0.135 $Y=0.135
cc_4 N_B1_1 N_B2_1 0.00291366f $X=0.1795 $Y=0.135
cc_5 N_B1_5 N_B2_11 0.00511511f $X=0.1812 $Y=0.108
cc_6 N_B1_4 N_B2_6 0.00513526f $X=0.189 $Y=0.0245
cc_7 N_B1_3 N_B2_5 0.00692158f $X=0.135 $Y=0.135
x_PM_AOI22x1_ASAP7_75t_R%A1 vss A1 N_M5_g N_M13_g N_M6_g N_M14_g N_A1_4 N_A1_5
+ N_A1_1 N_A1_3 N_A1_6 PM_AOI22x1_ASAP7_75t_R%A1
cc_8 N_A1_4 N_A2_10 0.00148726f $X=0.405 $Y=0.135
cc_9 N_A1_4 N_A2_1 0.000873399f $X=0.405 $Y=0.135
cc_10 N_A1_5 N_A2_10 0.00106599f $X=0.351 $Y=0.108
cc_11 N_A1_1 N_A2_1 0.00296256f $X=0.3415 $Y=0.135
cc_12 N_A1_5 N_A2_11 0.00487253f $X=0.351 $Y=0.108
cc_13 N_A1_3 N_A2_5 0.00512379f $X=0.351 $Y=0.0245
cc_14 N_A1_4 N_A2_6 0.00692057f $X=0.405 $Y=0.135
x_PM_AOI22x1_ASAP7_75t_R%Y vss Y N_M0_d N_M3_d N_M4_d N_M7_d N_M14_s N_M15_d
+ N_M12_d N_M13_s N_Y_2 N_Y_17 N_Y_16 N_Y_1 N_Y_23 N_Y_20 N_Y_19 N_Y_5 N_Y_3
+ N_Y_4 N_Y_18 N_Y_25 N_Y_24 PM_AOI22x1_ASAP7_75t_R%Y
cc_15 N_Y_2 N_B2_12 0.000759046f $X=0.27 $Y=0.0675
cc_16 N_Y_17 N_B2_2 0.000759798f $X=0.2555 $Y=0.0675
cc_17 N_Y_16 N_B2_1 0.000870347f $X=0.056 $Y=0.0675
cc_18 N_Y_1 N_B2_10 0.000888457f $X=0.054 $Y=0.0675
cc_19 N_Y_23 N_B2_7 0.00138459f $X=0.039 $Y=0.036
cc_20 N_Y_2 N_B2_6 0.00153379f $X=0.27 $Y=0.0675
cc_21 N_Y_1 N_B2_5 0.00187308f $X=0.054 $Y=0.0675
cc_22 N_Y_23 N_B2_11 0.00502498f $X=0.039 $Y=0.036
cc_23 N_Y_23 N_B2_9 0.00807691f $X=0.039 $Y=0.036
cc_24 N_Y_16 N_B2_5 0.0339469f $X=0.056 $Y=0.0675
cc_25 N_Y_17 N_B2_6 0.035812f $X=0.2555 $Y=0.0675
cc_26 N_Y_20 N_A2_6 0.0522954f $X=0.4175 $Y=0.2025
cc_27 N_Y_19 N_A2_5 0.0149333f $X=0.3095 $Y=0.2025
cc_28 N_Y_2 N_A2_1 0.000505827f $X=0.27 $Y=0.0675
cc_29 N_Y_5 N_A2_2 0.000749062f $X=0.486 $Y=0.0675
cc_30 N_Y_3 N_A2_5 0.000804191f $X=0.324 $Y=0.2025
cc_31 N_Y_2 N_A2_10 0.000958043f $X=0.27 $Y=0.0675
cc_32 N_Y_4 N_A2_6 0.000987543f $X=0.432 $Y=0.2025
cc_33 N_Y_19 N_A2_1 0.00144961f $X=0.3095 $Y=0.2025
cc_34 N_Y_2 N_A2_5 0.00154169f $X=0.27 $Y=0.0675
cc_35 N_Y_5 N_A2_6 0.00160964f $X=0.486 $Y=0.0675
cc_36 N_Y_23 N_A2_9 0.00164584f $X=0.039 $Y=0.036
cc_37 N_Y_18 N_A2_2 0.00167898f $X=0.4715 $Y=0.0675
cc_38 N_Y_25 N_A2_12 0.00409437f $X=0.513 $Y=0.054
cc_39 N_Y_24 N_A2_8 0.0050908f $X=0.502 $Y=0.198
cc_40 N_Y_23 N_A2_11 0.00517669f $X=0.039 $Y=0.036
cc_41 N_Y_18 N_A2_6 0.0149338f $X=0.4715 $Y=0.0675
cc_42 N_Y_23 N_A2_7 0.00780547f $X=0.039 $Y=0.036
cc_43 N_Y_17 N_A2_5 0.0543093f $X=0.2555 $Y=0.0675
cc_44 N_Y_23 N_A1_3 0.000577746f $X=0.039 $Y=0.036
cc_45 N_Y_4 N_A1_3 0.000713973f $X=0.432 $Y=0.2025
cc_46 N_Y_3 N_A1_3 0.00081494f $X=0.324 $Y=0.2025
cc_47 N_Y_20 N_A1_1 0.00162575f $X=0.4175 $Y=0.2025
cc_48 N_Y_24 N_A1_6 0.00447853f $X=0.502 $Y=0.198
cc_49 N_Y_20 N_A1_4 0.0331409f $X=0.4175 $Y=0.2025
cc_50 N_Y_19 N_A1_3 0.0358873f $X=0.3095 $Y=0.2025
x_PM_AOI22x1_ASAP7_75t_R%A2 vss A2 N_M4_g N_M12_g N_M7_g N_M15_g N_A2_1 N_A2_10
+ N_A2_5 N_A2_11 N_A2_6 N_A2_2 N_A2_9 N_A2_12 N_A2_8 N_A2_7
+ PM_AOI22x1_ASAP7_75t_R%A2
cc_51 N_A2_1 N_B2_2 0.00112546f $X=0.297 $Y=0.135
cc_52 N_A2_10 N_B2_12 0.00264606f $X=0.297 $Y=0.1215
cc_53 N_A2_5 N_B2_6 0.00503952f $X=0.297 $Y=0.0245
x_PM_AOI22x1_ASAP7_75t_R%B2 vss B2 N_M0_g N_M8_g N_M3_g N_M11_g N_B2_8 N_B2_2
+ N_B2_12 N_B2_1 N_B2_11 N_B2_6 N_B2_5 N_B2_10 N_B2_7 N_B2_9
+ PM_AOI22x1_ASAP7_75t_R%B2

* End of included file AOI22x1_ASAP7_75t_R.pex.sp.pxi
.ends

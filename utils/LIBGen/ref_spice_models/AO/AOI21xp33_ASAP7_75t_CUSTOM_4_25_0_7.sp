.subckt PM_AOI21xp33_ASAP7_75t_R%A2 vss 23 10 16 3
c1 1 vss 0.00412864f $X=0.081 $Y=0.135
c2 3 vss 0.112498f $X=0.081 $Y=0.0245
c3 4 vss 0.00734803f $X=0.027 $Y=0.036
c4 5 vss 0.000975074f $X=0.027 $Y=0.13
c5 6 vss 0.00598006f $X=0.027 $Y=0.198
c6 7 vss 0.00573661f $X=0.027 $Y=0.103
c7 8 vss 0.00303129f $X=0.027 $Y=0.166
c8 9 vss 0.00236996f $X=0.0635 $Y=0.134
r1 6 8 6.28176 $w=1.44063e-08 $l=3.2e-08 $layer=M1 $thickness=3.6e-08 $X=0.027
+ $Y=0.198 $X2=0.027 $Y2=0.166
r2 4 26 3.01711 $w=1.55e-08 $l=1.8e-08 $layer=M1 $thickness=3.6e-08 $X=0.027
+ $Y=0.036 $X2=0.027 $Y2=0.054
r3 8 24 5.72052 $w=1.36604e-08 $l=2.65e-08 $layer=M1 $thickness=3.6e-08
+ $X=0.027 $Y=0.166 $X2=0.027 $Y2=0.1395
r4 25 26 4.19742 $w=1.3e-08 $l=1.8e-08 $layer=M1 $thickness=3.6e-08 $X=0.027
+ $Y=0.072 $X2=0.027 $Y2=0.054
r5 7 25 7.22888 $w=1.3e-08 $l=3.1e-08 $layer=M1 $thickness=3.6e-08 $X=0.027
+ $Y=0.103 $X2=0.027 $Y2=0.072
r6 23 24 0.408178 $w=1.8e-08 $l=4e-09 $layer=M1 $thickness=3.6e-08 $X=0.0215
+ $Y=0.1355 $X2=0.027 $Y2=0.1395
r7 23 5 0.561244 $w=1.8e-08 $l=5.5e-09 $layer=M1 $thickness=3.6e-08 $X=0.0215
+ $Y=0.1355 $X2=0.027 $Y2=0.13
r8 5 7 5.6404 $w=1.39259e-08 $l=2.7e-08 $layer=M1 $thickness=3.6e-08 $X=0.027
+ $Y=0.13 $X2=0.027 $Y2=0.103
r9 23 22 2.26632 $w=7.16216e-09 $l=1.85607e-08 $layer=M1 $thickness=3.6e-08
+ $X=0.0215 $Y=0.1355 $X2=0.0455 $Y2=0.134
r10 9 20 4.08082 $w=1.3e-08 $l=1.75e-08 $layer=M1 $thickness=3.6e-08 $X=0.0635
+ $Y=0.134 $X2=0.081 $Y2=0.134
r11 9 22 4.19742 $w=1.3e-08 $l=1.8e-08 $layer=M1 $thickness=3.6e-08 $X=0.0635
+ $Y=0.134 $X2=0.0455 $Y2=0.134
r12 1 13 6.54019 $w=2.09524e-08 $layer=Gate_1 $thickness=5.21905e-08 $X=0.081
+ $Y=0.135 $X2=0.081 $Y2=0.135
r13 1 20 19.3796 $a=3.24e-16 $layer=V0LIG $X=0.081 $Y=0.135 $X2=0.081 $Y2=0.134
r14 16 15 14.6259 $w=2.1e-08 $l=4.3e-08 $layer=Gate_1 $thickness=5.6e-08
+ $X=0.081 $Y=0.216 $X2=0.081 $Y2=0.173
r15 14 15 7.31297 $w=2.1e-08 $l=2.15e-08 $layer=Gate_1 $thickness=5.6e-08
+ $X=0.081 $Y=0.1515 $X2=0.081 $Y2=0.173
r16 13 14 5.79936 $w=2.03333e-08 $l=1.65e-08 $layer=Gate_1 $thickness=5.6e-08
+ $X=0.081 $Y=0.135 $X2=0.081 $Y2=0.1515
r17 12 13 5.79936 $w=2.03333e-08 $l=1.65e-08 $layer=Gate_1 $thickness=5.6e-08
+ $X=0.081 $Y=0.1185 $X2=0.081 $Y2=0.135
r18 11 12 7.31297 $w=2.1e-08 $l=2.15e-08 $layer=Gate_1 $thickness=5.6e-08
+ $X=0.081 $Y=0.097 $X2=0.081 $Y2=0.1185
r19 10 11 14.6259 $w=2.1e-08 $l=4.3e-08 $layer=Gate_1 $thickness=5.6e-08
+ $X=0.081 $Y=0.054 $X2=0.081 $Y2=0.097
r20 10 3 10.0341 $w=2.1e-08 $l=2.95e-08 $layer=Gate_1 $thickness=5.6e-08
+ $X=0.081 $Y=0.054 $X2=0.081 $Y2=0.0245
.ends

.subckt PM_AOI21xp33_ASAP7_75t_R%B vss 15 5 11 3 4 1
c1 1 vss 0.00615145f $X=0.189 $Y=0.135
c2 3 vss 0.0703554f $X=0.189 $Y=0.0245
c3 4 vss 0.00544495f $X=0.189 $Y=0.103
r1 15 4 7.22888 $w=1.3e-08 $l=3.1e-08 $layer=M1 $thickness=3.6e-08 $X=0.1865
+ $Y=0.1355 $X2=0.189 $Y2=0.103
r2 1 8 6.54019 $w=2.09524e-08 $layer=Gate_1 $thickness=5.21905e-08 $X=0.189
+ $Y=0.135 $X2=0.189 $Y2=0.135
r3 15 1 19.3796 $a=3.24e-16 $layer=V0LIG $X=0.1865 $Y=0.1355 $X2=0.189 $Y2=0.135
r4 11 10 14.6259 $w=2.1e-08 $l=4.3e-08 $layer=Gate_1 $thickness=5.6e-08
+ $X=0.189 $Y=0.216 $X2=0.189 $Y2=0.173
r5 9 10 7.31297 $w=2.1e-08 $l=2.15e-08 $layer=Gate_1 $thickness=5.6e-08
+ $X=0.189 $Y=0.1515 $X2=0.189 $Y2=0.173
r6 8 9 5.79936 $w=2.03333e-08 $l=1.65e-08 $layer=Gate_1 $thickness=5.6e-08
+ $X=0.189 $Y=0.135 $X2=0.189 $Y2=0.1515
r7 7 8 5.79936 $w=2.03333e-08 $l=1.65e-08 $layer=Gate_1 $thickness=5.6e-08
+ $X=0.189 $Y=0.1185 $X2=0.189 $Y2=0.135
r8 6 7 7.31297 $w=2.1e-08 $l=2.15e-08 $layer=Gate_1 $thickness=5.6e-08 $X=0.189
+ $Y=0.097 $X2=0.189 $Y2=0.1185
r9 5 6 14.6259 $w=2.1e-08 $l=4.3e-08 $layer=Gate_1 $thickness=5.6e-08 $X=0.189
+ $Y=0.054 $X2=0.189 $Y2=0.097
r10 5 3 10.0341 $w=2.1e-08 $l=2.95e-08 $layer=Gate_1 $thickness=5.6e-08
+ $X=0.189 $Y=0.054 $X2=0.189 $Y2=0.0245
.ends

.subckt PM_AOI21xp33_ASAP7_75t_R%A1 vss 6 7 11 4 1 3
c1 1 vss 0.00201089f $X=0.135 $Y=0.135
c2 3 vss 0.0774101f $X=0.135 $Y=0.0245
c3 4 vss 0.00205166f $X=0.135 $Y=0.072
c4 5 vss 0.00643902f $X=0.135 $Y=0.198
c5 6 vss 0.00431584f $X=0.1355 $Y=0.1355
r1 5 16 6.28176 $w=1.44063e-08 $l=3.2e-08 $layer=M1 $thickness=3.6e-08 $X=0.135
+ $Y=0.198 $X2=0.135 $Y2=0.166
r2 4 15 6.04857 $w=1.44516e-08 $l=3.1e-08 $layer=M1 $thickness=3.6e-08 $X=0.135
+ $Y=0.072 $X2=0.135 $Y2=0.103
r3 6 15 7.22888 $w=1.3e-08 $l=3.1e-08 $layer=M1 $thickness=3.6e-08 $X=0.1355
+ $Y=0.1355 $X2=0.135 $Y2=0.103
r4 6 16 7.46207 $w=1.3e-08 $l=3.2e-08 $layer=M1 $thickness=3.6e-08 $X=0.1355
+ $Y=0.1355 $X2=0.135 $Y2=0.166
r5 1 9 6.54019 $w=2.09524e-08 $layer=Gate_1 $thickness=5.21905e-08 $X=0.135
+ $Y=0.135 $X2=0.135 $Y2=0.135
r6 6 1 19.3796 $a=3.24e-16 $layer=V0LIG $X=0.1355 $Y=0.1355 $X2=0.135 $Y2=0.135
r7 11 10 16.4967 $w=2.1e-08 $l=4.85e-08 $layer=Gate_1 $thickness=5.6e-08
+ $X=0.135 $Y=0.216 $X2=0.135 $Y2=0.1675
r8 9 10 11.2416 $w=2.06615e-08 $l=3.25e-08 $layer=Gate_1 $thickness=5.6e-08
+ $X=0.135 $Y=0.135 $X2=0.135 $Y2=0.1675
r9 8 9 11.2416 $w=2.06615e-08 $l=3.25e-08 $layer=Gate_1 $thickness=5.6e-08
+ $X=0.135 $Y=0.1025 $X2=0.135 $Y2=0.135
r10 7 8 16.4967 $w=2.1e-08 $l=4.85e-08 $layer=Gate_1 $thickness=5.6e-08
+ $X=0.135 $Y=0.054 $X2=0.135 $Y2=0.1025
r11 7 3 10.0341 $w=2.1e-08 $l=2.95e-08 $layer=Gate_1 $thickness=5.6e-08
+ $X=0.135 $Y=0.054 $X2=0.135 $Y2=0.0245
.ends

.subckt PM_AOI21xp33_ASAP7_75t_R%Y vss 25 15 16 33 11 7 8 12
c1 1 vss 0.00650994f $X=0.162 $Y=0.054
c2 2 vss 0.00798345f $X=0.216 $Y=0.216
c3 7 vss 0.00321536f $X=0.1475 $Y=0.054
c4 8 vss 0.0281912f $X=0.2015 $Y=0.216
c5 9 vss 0.00621888f $X=0.243 $Y=0.234
c6 10 vss 0.00301186f $X=0.243 $Y=0.036
c7 11 vss 0.0128599f $X=0.1485 $Y=0.036
c8 12 vss 0.00619775f $X=0.243 $Y=0.054
r1 8 2 0.231482 $w=5.4e-08 $l=1.25e-08 $layer=P_src_drn $thickness=1e-09
+ $X=0.2015 $Y=0.216 $X2=0.216 $Y2=0.216
r2 33 8 0.0462963 $w=5.4e-08 $l=2.5e-09 $layer=P_src_drn $thickness=1e-09
+ $X=0.1986 $Y=0.216 $X2=0.2015 $Y2=0.216
r3 2 30 19.3796 $a=3.24e-16 $layer=V0LISD $X=0.216 $Y=0.216 $X2=0.216 $Y2=0.234
r4 30 31 3.14806 $w=1.3e-08 $l=1.35e-08 $layer=M1 $thickness=3.6e-08 $X=0.216
+ $Y=0.234 $X2=0.2295 $Y2=0.234
r5 9 28 3.01711 $w=1.55e-08 $l=1.8e-08 $layer=M1 $thickness=3.6e-08 $X=0.243
+ $Y=0.234 $X2=0.243 $Y2=0.216
r6 9 31 1.96775 $w=1.63333e-08 $l=1.35e-08 $layer=M1 $thickness=3.6e-08
+ $X=0.243 $Y=0.234 $X2=0.2295 $Y2=0.234
r7 27 28 2.91487 $w=1.3e-08 $l=1.25e-08 $layer=M1 $thickness=3.6e-08 $X=0.243
+ $Y=0.2035 $X2=0.243 $Y2=0.216
r8 26 27 11.1348 $w=1.3e-08 $l=4.78e-08 $layer=M1 $thickness=3.6e-08 $X=0.243
+ $Y=0.1557 $X2=0.243 $Y2=0.2035
r9 25 26 10.4352 $w=1.3e-08 $l=4.47e-08 $layer=M1 $thickness=3.6e-08 $X=0.245
+ $Y=0.111 $X2=0.243 $Y2=0.1557
r10 25 24 4.83869 $w=1.3e-08 $l=2.08e-08 $layer=M1 $thickness=3.6e-08 $X=0.245
+ $Y=0.111 $X2=0.243 $Y2=0.0902
r11 23 24 5.53826 $w=1.3e-08 $l=2.37e-08 $layer=M1 $thickness=3.6e-08 $X=0.243
+ $Y=0.0665 $X2=0.243 $Y2=0.0902
r12 12 23 2.91487 $w=1.3e-08 $l=1.25e-08 $layer=M1 $thickness=3.6e-08 $X=0.243
+ $Y=0.054 $X2=0.243 $Y2=0.0665
r13 10 22 4.18063 $w=1.48e-08 $l=2.5e-08 $layer=M1 $thickness=3.6e-08 $X=0.243
+ $Y=0.036 $X2=0.218 $Y2=0.036
r14 10 12 2.5483 $w=1.79e-08 $l=1.8e-08 $layer=M1 $thickness=3.6e-08 $X=0.243
+ $Y=0.036 $X2=0.243 $Y2=0.054
r15 21 22 4.19742 $w=1.3e-08 $l=1.8e-08 $layer=M1 $thickness=3.6e-08 $X=0.2
+ $Y=0.036 $X2=0.218 $Y2=0.036
r16 20 21 2.56509 $w=1.3e-08 $l=1.1e-08 $layer=M1 $thickness=3.6e-08 $X=0.189
+ $Y=0.036 $X2=0.2 $Y2=0.036
r17 19 20 3.14806 $w=1.3e-08 $l=1.35e-08 $layer=M1 $thickness=3.6e-08 $X=0.1755
+ $Y=0.036 $X2=0.189 $Y2=0.036
r18 17 19 3.14806 $w=1.3e-08 $l=1.35e-08 $layer=M1 $thickness=3.6e-08 $X=0.162
+ $Y=0.036 $X2=0.1755 $Y2=0.036
r19 11 17 3.14806 $w=1.3e-08 $l=1.35e-08 $layer=M1 $thickness=3.6e-08 $X=0.1485
+ $Y=0.036 $X2=0.162 $Y2=0.036
r20 1 17 19.3796 $a=3.24e-16 $layer=V0LISD $X=0.162 $Y=0.054 $X2=0.162 $Y2=0.036
r21 16 14 0.0462963 $w=5.4e-08 $l=2.5e-09 $layer=N_src_drn $thickness=1e-09
+ $X=0.1793 $Y=0.054 $X2=0.1765 $Y2=0.054
r22 1 14 0.268519 $w=5.4e-08 $l=1.45e-08 $layer=N_src_drn $thickness=1e-09
+ $X=0.162 $Y=0.054 $X2=0.1765 $Y2=0.054
r23 7 1 0.268519 $w=5.4e-08 $l=1.45e-08 $layer=N_src_drn $thickness=1e-09
+ $X=0.1475 $Y=0.054 $X2=0.162 $Y2=0.054
r24 15 7 0.0462963 $w=5.4e-08 $l=2.5e-09 $layer=N_src_drn $thickness=1e-09
+ $X=0.1446 $Y=0.054 $X2=0.1475 $Y2=0.054
.ends

* End of included file AOI21xp33_ASAP7_75t_R.pex.sp.pex

*
.subckt AOI21xp33_ASAP7_75t_CUSTOM_4_25_0_7 VSS VDD A2 A1 B Y
*
* VSS VSS
* VDD VDD
* A2 A2
* A1 A1
* B B
* Y Y
*
*

M0 noxref_8 N_M0_g VSS VSS nmos_rvt L=2e-08 W=5.4e-08 nfin=2 $X=0.071 $Y=0.027
M1 N_M1_d N_M1_g noxref_8 VSS nmos_rvt L=2e-08 W=5.4e-08 nfin=2 $X=0.125
+ $Y=0.027
M2 VSS N_M2_g N_M2_s VSS nmos_rvt L=2e-08 W=5.4e-08 nfin=2 $X=0.179 $Y=0.027
M3 VDD N_M3_g noxref_6 VDD pmos_rvt L=2e-08 W=5.4e-08 nfin=2 $X=0.071 $Y=0.189
M4 noxref_6 N_M4_g VDD VDD pmos_rvt L=2e-08 W=5.4e-08 nfin=2 $X=0.125 $Y=0.189
M5 N_M5_d N_M5_g noxref_6 VDD pmos_rvt L=2e-08 W=5.4e-08 nfin=2 $X=0.179
+ $Y=0.189

* .include "AOI21xp33_ASAP7_75t_R.pex.sp.pxi"

* Start of included file AOI21xp33_ASAP7_75t_R.pex.sp.pxi
x_PM_AOI21xp33_ASAP7_75t_R%A2 vss A2 N_M0_g N_M3_g N_A2_3
+ PM_AOI21xp33_ASAP7_75t_R%A2
x_PM_AOI21xp33_ASAP7_75t_R%B vss B N_M2_g N_M5_g N_B_3 N_B_4 N_B_1
+ PM_AOI21xp33_ASAP7_75t_R%B
cc_1 N_B_3 N_A1_1 0.00157503f $X=0.189 $Y=0.0245
cc_2 N_B_4 A1 0.00437783f $X=0.189 $Y=0.103
cc_3 N_B_3 N_A1_3 0.00875672f $X=0.189 $Y=0.0245
x_PM_AOI21xp33_ASAP7_75t_R%A1 vss A1 N_M1_g N_M4_g N_A1_4 N_A1_1 N_A1_3
+ PM_AOI21xp33_ASAP7_75t_R%A1
cc_4 N_A1_4 N_A2_3 0.000647404f $X=0.135 $Y=0.072
cc_5 N_A1_1 N_A2_3 0.00171585f $X=0.135 $Y=0.135
cc_6 A1 N_A2_3 0.00254603f $X=0.1355 $Y=0.1355
cc_7 N_A1_3 N_A2_3 0.0108773f $X=0.135 $Y=0.0245
x_PM_AOI21xp33_ASAP7_75t_R%Y vss Y N_M1_d N_M2_s N_M5_d N_Y_11 N_Y_7 N_Y_8
+ N_Y_12 PM_AOI21xp33_ASAP7_75t_R%Y
cc_8 N_Y_11 N_A1_4 0.00387209f $X=0.1485 $Y=0.036
cc_9 N_Y_7 N_A1_3 0.0283005f $X=0.1475 $Y=0.054
cc_10 N_Y_8 N_B_1 0.000827012f $X=0.2015 $Y=0.216
cc_11 N_Y_11 N_B_4 0.000988152f $X=0.1485 $Y=0.036
cc_12 N_Y_8 N_B_3 0.0107108f $X=0.2015 $Y=0.216
cc_13 N_Y_12 N_B_4 0.00762319f $X=0.243 $Y=0.054
cc_14 N_Y_7 N_B_3 0.0419273f $X=0.1475 $Y=0.054

* End of included file AOI21xp33_ASAP7_75t_R.pex.sp.pxi
.ends

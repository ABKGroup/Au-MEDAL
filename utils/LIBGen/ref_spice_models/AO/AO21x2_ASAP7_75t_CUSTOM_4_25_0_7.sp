.subckt PM_AO21x2_ASAP7_75t_R%A1 vss 17 9 15 8 3
c1 1 vss 0.00489996f $X=0.081 $Y=0.135
c2 3 vss 0.105083f $X=0.081 $Y=0.0245
c3 4 vss 0.00127732f $X=0.027 $Y=0.135
c4 5 vss 0.00648048f $X=0.027 $Y=0.198
c5 6 vss 0.0106961f $X=0.027 $Y=0.098
c6 7 vss 0.00364946f $X=0.027 $Y=0.154
c7 8 vss 0.00280879f $X=0.0635 $Y=0.135
r1 5 23 3.83327 $w=1.5093e-08 $l=2.15e-08 $layer=M1 $thickness=3.6e-08 $X=0.027
+ $Y=0.198 $X2=0.027 $Y2=0.1765
r2 7 23 5.24677 $w=1.3e-08 $l=2.25e-08 $layer=M1 $thickness=3.6e-08 $X=0.027
+ $Y=0.154 $X2=0.027 $Y2=0.1765
r3 4 19 3.1337 $w=1.54324e-08 $l=1.85e-08 $layer=M1 $thickness=3.6e-08 $X=0.027
+ $Y=0.135 $X2=0.0455 $Y2=0.135
r4 4 6 7.44771 $w=1.42162e-08 $l=3.7e-08 $layer=M1 $thickness=3.6e-08 $X=0.027
+ $Y=0.135 $X2=0.027 $Y2=0.098
r5 4 7 3.2503 $w=1.53684e-08 $l=1.9e-08 $layer=M1 $thickness=3.6e-08 $X=0.027
+ $Y=0.135 $X2=0.027 $Y2=0.154
r6 17 8 4.08082 $w=1.3e-08 $l=1.75e-08 $layer=M1 $thickness=3.6e-08 $X=0.0795
+ $Y=0.1355 $X2=0.0635 $Y2=0.135
r7 8 19 4.19742 $w=1.3e-08 $l=1.8e-08 $layer=M1 $thickness=3.6e-08 $X=0.0635
+ $Y=0.135 $X2=0.0455 $Y2=0.135
r8 1 12 10.4265 $w=1.765e-08 $layer=LIG $thickness=5.2e-08 $X=0.081 $Y=0.135
+ $X2=0.081 $Y2=0.135
r9 17 1 19.3796 $a=3.24e-16 $layer=V0LIG $X=0.0795 $Y=0.1355 $X2=0.081 $Y2=0.135
r10 15 14 14.6259 $w=2.1e-08 $l=4.3e-08 $layer=Gate_1 $thickness=5.6e-08
+ $X=0.081 $Y=0.2025 $X2=0.081 $Y2=0.1595
r11 13 14 2.7211 $w=2.1e-08 $l=8e-09 $layer=Gate_1 $thickness=5.6e-08 $X=0.081
+ $Y=0.1515 $X2=0.081 $Y2=0.1595
r12 12 13 5.79936 $w=2.03333e-08 $l=1.65e-08 $layer=Gate_1 $thickness=5.6e-08
+ $X=0.081 $Y=0.135 $X2=0.081 $Y2=0.1515
r13 11 12 5.79936 $w=2.03333e-08 $l=1.65e-08 $layer=Gate_1 $thickness=5.6e-08
+ $X=0.081 $Y=0.1185 $X2=0.081 $Y2=0.135
r14 10 11 2.7211 $w=2.1e-08 $l=8e-09 $layer=Gate_1 $thickness=5.6e-08 $X=0.081
+ $Y=0.1105 $X2=0.081 $Y2=0.1185
r15 9 10 14.6259 $w=2.1e-08 $l=4.3e-08 $layer=Gate_1 $thickness=5.6e-08
+ $X=0.081 $Y=0.0675 $X2=0.081 $Y2=0.1105
r16 9 3 14.6259 $w=2.1e-08 $l=4.3e-08 $layer=Gate_1 $thickness=5.6e-08 $X=0.081
+ $Y=0.0675 $X2=0.081 $Y2=0.0245
.ends

.subckt PM_AO21x2_ASAP7_75t_R%A2 vss 4 5 9 3 1
c1 1 vss 0.0067059f $X=0.135 $Y=0.135
c2 3 vss 0.0648298f $X=0.135 $Y=0.0245
c3 4 vss 0.00502963f $X=0.1315 $Y=0.1355
r1 1 7 10.4265 $w=1.765e-08 $layer=LIG $thickness=5.2e-08 $X=0.135 $Y=0.135
+ $X2=0.135 $Y2=0.135
r2 4 1 19.3796 $a=3.24e-16 $layer=V0LIG $X=0.1315 $Y=0.1355 $X2=0.135 $Y2=0.135
r3 9 8 16.4967 $w=2.1e-08 $l=4.85e-08 $layer=Gate_1 $thickness=5.6e-08 $X=0.135
+ $Y=0.2025 $X2=0.135 $Y2=0.154
r4 7 8 6.6497 $w=2.04211e-08 $l=1.9e-08 $layer=Gate_1 $thickness=5.6e-08
+ $X=0.135 $Y=0.135 $X2=0.135 $Y2=0.154
r5 6 7 6.6497 $w=2.04211e-08 $l=1.9e-08 $layer=Gate_1 $thickness=5.6e-08
+ $X=0.135 $Y=0.116 $X2=0.135 $Y2=0.135
r6 5 6 16.4967 $w=2.1e-08 $l=4.85e-08 $layer=Gate_1 $thickness=5.6e-08 $X=0.135
+ $Y=0.0675 $X2=0.135 $Y2=0.116
r7 5 3 14.6259 $w=2.1e-08 $l=4.3e-08 $layer=Gate_1 $thickness=5.6e-08 $X=0.135
+ $Y=0.0675 $X2=0.135 $Y2=0.0245
.ends

.subckt PM_AO21x2_ASAP7_75t_R%6 vss 18 22 37 41 60 61 64 65 3 15 12 16 4 11 1 9
+ 17 13 10 14
c1 1 vss 0.00708398f $X=0.2335 $Y=0.135
c2 3 vss 0.0100071f $X=0.108 $Y=0.2025
c3 4 vss 0.007827f $X=0.162 $Y=0.0675
c4 9 vss 0.0809786f $X=0.243 $Y=0.0245
c5 10 vss 0.0854938f $X=0.297 $Y=0.135
c6 11 vss 0.00680907f $X=0.1475 $Y=0.0675
c7 12 vss 0.00751225f $X=0.0935 $Y=0.2025
c8 13 vss 0.00279697f $X=0.243 $Y=0.0415
c9 14 vss 0.000821798f $X=0.243 $Y=0.198
c10 15 vss 0.0124553f $X=0.232 $Y=0.198
c11 16 vss 0.00933237f $X=0.216 $Y=0.036
c12 17 vss 0.00450838f $X=0.243 $Y=0.1065
r1 65 63 0.0308642 $w=8.1e-08 $l=2.5e-09 $layer=P_src_drn $thickness=1e-09
+ $X=0.1253 $Y=0.2025 $X2=0.1225 $Y2=0.2025
r2 3 63 0.179012 $w=8.1e-08 $l=1.45e-08 $layer=P_src_drn $thickness=1e-09
+ $X=0.108 $Y=0.2025 $X2=0.1225 $Y2=0.2025
r3 12 3 0.179012 $w=8.1e-08 $l=1.45e-08 $layer=P_src_drn $thickness=1e-09
+ $X=0.0935 $Y=0.2025 $X2=0.108 $Y2=0.2025
r4 64 12 0.0308642 $w=8.1e-08 $l=2.5e-09 $layer=P_src_drn $thickness=1e-09
+ $X=0.0906 $Y=0.2025 $X2=0.0935 $Y2=0.2025
r5 61 59 0.0308642 $w=8.1e-08 $l=2.5e-09 $layer=N_src_drn $thickness=1e-09
+ $X=0.1793 $Y=0.0675 $X2=0.1765 $Y2=0.0675
r6 4 59 0.179012 $w=8.1e-08 $l=1.45e-08 $layer=N_src_drn $thickness=1e-09
+ $X=0.162 $Y=0.0675 $X2=0.1765 $Y2=0.0675
r7 11 4 0.179012 $w=8.1e-08 $l=1.45e-08 $layer=N_src_drn $thickness=1e-09
+ $X=0.1475 $Y=0.0675 $X2=0.162 $Y2=0.0675
r8 60 11 0.0308642 $w=8.1e-08 $l=2.5e-09 $layer=N_src_drn $thickness=1e-09
+ $X=0.1446 $Y=0.0675 $X2=0.1475 $Y2=0.0675
r9 3 55 19.3796 $a=3.24e-16 $layer=V0LISD $X=0.108 $Y=0.2025 $X2=0.108 $Y2=0.198
r10 4 46 19.3796 $a=3.24e-16 $layer=V0LISD $X=0.162 $Y=0.0675 $X2=0.162
+ $Y2=0.036
r11 55 56 3.14806 $w=1.3e-08 $l=1.35e-08 $layer=M1 $thickness=3.6e-08 $X=0.108
+ $Y=0.198 $X2=0.1215 $Y2=0.198
r12 53 56 3.14806 $w=1.3e-08 $l=1.35e-08 $layer=M1 $thickness=3.6e-08 $X=0.135
+ $Y=0.198 $X2=0.1215 $Y2=0.198
r13 52 53 2.56509 $w=1.3e-08 $l=1.1e-08 $layer=M1 $thickness=3.6e-08 $X=0.146
+ $Y=0.198 $X2=0.135 $Y2=0.198
r14 51 52 3.73104 $w=1.3e-08 $l=1.6e-08 $layer=M1 $thickness=3.6e-08 $X=0.162
+ $Y=0.198 $X2=0.146 $Y2=0.198
r15 50 51 3.73104 $w=1.3e-08 $l=1.6e-08 $layer=M1 $thickness=3.6e-08 $X=0.178
+ $Y=0.198 $X2=0.162 $Y2=0.198
r16 49 50 2.56509 $w=1.3e-08 $l=1.1e-08 $layer=M1 $thickness=3.6e-08 $X=0.189
+ $Y=0.198 $X2=0.178 $Y2=0.198
r17 48 49 5.82974 $w=1.3e-08 $l=2.5e-08 $layer=M1 $thickness=3.6e-08 $X=0.214
+ $Y=0.198 $X2=0.189 $Y2=0.198
r18 15 48 4.19742 $w=1.3e-08 $l=1.8e-08 $layer=M1 $thickness=3.6e-08 $X=0.232
+ $Y=0.198 $X2=0.214 $Y2=0.198
r19 46 47 3.14806 $w=1.3e-08 $l=1.35e-08 $layer=M1 $thickness=3.6e-08 $X=0.162
+ $Y=0.036 $X2=0.1755 $Y2=0.036
r20 44 47 3.14806 $w=1.3e-08 $l=1.35e-08 $layer=M1 $thickness=3.6e-08 $X=0.189
+ $Y=0.036 $X2=0.1755 $Y2=0.036
r21 16 44 6.29612 $w=1.3e-08 $l=2.7e-08 $layer=M1 $thickness=3.6e-08 $X=0.216
+ $Y=0.036 $X2=0.189 $Y2=0.036
r22 14 34 3.36447 $w=1.71023e-08 $l=2.15e-08 $layer=M1 $thickness=3.6e-08
+ $X=0.243 $Y=0.198 $X2=0.243 $Y2=0.1765
r23 14 15 0.915974 $w=1.70909e-08 $l=1.1e-08 $layer=M1 $thickness=3.6e-08
+ $X=0.243 $Y=0.198 $X2=0.232 $Y2=0.198
r24 13 33 3.27203 $w=1.40938e-08 $l=1.6e-08 $layer=M1 $thickness=3.6e-08
+ $X=0.243 $Y=0.0415 $X2=0.243 $Y2=0.0575
r25 13 16 4.55457 $w=1.3814e-08 $l=2.75545e-08 $layer=M1 $thickness=3.6e-08
+ $X=0.243 $Y=0.0415 $X2=0.216 $Y2=0.036
r26 41 40 14.6259 $w=2.1e-08 $l=4.3e-08 $layer=Gate_1 $thickness=5.6e-08
+ $X=0.297 $Y=0.2025 $X2=0.297 $Y2=0.1595
r27 39 40 2.7211 $w=2.1e-08 $l=8e-09 $layer=Gate_1 $thickness=5.6e-08 $X=0.297
+ $Y=0.1515 $X2=0.297 $Y2=0.1595
r28 37 38 14.6259 $w=2.1e-08 $l=4.3e-08 $layer=Gate_1 $thickness=5.6e-08
+ $X=0.297 $Y=0.0675 $X2=0.297 $Y2=0.1105
r29 35 38 2.7211 $w=2.1e-08 $l=8e-09 $layer=Gate_1 $thickness=5.6e-08 $X=0.297
+ $Y=0.1185 $X2=0.297 $Y2=0.1105
r30 10 28 6.54019 $w=2.09524e-08 $layer=Gate_1 $thickness=5.21905e-08 $X=0.297
+ $Y=0.135 $X2=0.297 $Y2=0.135
r31 10 35 5.79936 $w=2.03333e-08 $l=1.65e-08 $layer=Gate_1 $thickness=5.6e-08
+ $X=0.297 $Y=0.135 $X2=0.297 $Y2=0.1185
r32 10 39 5.79936 $w=2.03333e-08 $l=1.65e-08 $layer=Gate_1 $thickness=5.6e-08
+ $X=0.297 $Y=0.135 $X2=0.297 $Y2=0.1515
r33 32 33 4.89699 $w=1.3e-08 $l=2.1e-08 $layer=M1 $thickness=3.6e-08 $X=0.243
+ $Y=0.0785 $X2=0.243 $Y2=0.0575
r34 31 34 5.24677 $w=1.3e-08 $l=2.25e-08 $layer=M1 $thickness=3.6e-08 $X=0.243
+ $Y=0.154 $X2=0.243 $Y2=0.1765
r35 30 31 4.43061 $w=1.3e-08 $l=1.9e-08 $layer=M1 $thickness=3.6e-08 $X=0.243
+ $Y=0.135 $X2=0.243 $Y2=0.154
r36 17 30 6.64591 $w=1.3e-08 $l=2.85e-08 $layer=M1 $thickness=3.6e-08 $X=0.243
+ $Y=0.1065 $X2=0.243 $Y2=0.135
r37 17 32 6.52931 $w=1.3e-08 $l=2.8e-08 $layer=M1 $thickness=3.6e-08 $X=0.243
+ $Y=0.1065 $X2=0.243 $Y2=0.0785
r38 27 28 12.6539 $w=1.77815e-08 $l=2.7e-08 $layer=LIG $thickness=4.8e-08
+ $X=0.27 $Y=0.135 $X2=0.297 $Y2=0.135
r39 25 27 10.1729 $w=1.54914e-08 $l=1.75e-08 $layer=LIG $thickness=4.8e-08
+ $X=0.2525 $Y=0.135 $X2=0.27 $Y2=0.135
r40 24 25 2.48102 $w=2.2e-08 $l=9.5e-09 $layer=LIG $thickness=4.8e-08 $X=0.243
+ $Y=0.135 $X2=0.2525 $Y2=0.135
r41 24 30 19.3796 $a=3.24e-16 $layer=V0LIG $X=0.243 $Y=0.135 $X2=0.243 $Y2=0.135
r42 1 24 2.48102 $w=2.2e-08 $l=9.5e-09 $layer=LIG $thickness=4.8e-08 $X=0.2335
+ $Y=0.135 $X2=0.243 $Y2=0.135
r43 22 21 16.4967 $w=2.1e-08 $l=4.85e-08 $layer=Gate_1 $thickness=5.6e-08
+ $X=0.243 $Y=0.2025 $X2=0.243 $Y2=0.154
r44 20 21 6.6497 $w=2.04211e-08 $l=1.9e-08 $layer=Gate_1 $thickness=5.6e-08
+ $X=0.243 $Y=0.135 $X2=0.243 $Y2=0.154
r45 20 25 4.05918 $w=2.0087e-08 $l=9.5e-09 $layer=Gate_1 $thickness=5.56522e-08
+ $X=0.243 $Y=0.135 $X2=0.2525 $Y2=0.135
r46 20 24 6.27904 $w=2.09e-08 $layer=Gate_1 $thickness=5.24e-08 $X=0.243
+ $Y=0.135 $X2=0.243 $Y2=0.135
r47 19 20 6.6497 $w=2.04211e-08 $l=1.9e-08 $layer=Gate_1 $thickness=5.6e-08
+ $X=0.243 $Y=0.116 $X2=0.243 $Y2=0.135
r48 18 19 16.4967 $w=2.1e-08 $l=4.85e-08 $layer=Gate_1 $thickness=5.6e-08
+ $X=0.243 $Y=0.0675 $X2=0.243 $Y2=0.116
r49 18 9 14.6259 $w=2.1e-08 $l=4.3e-08 $layer=Gate_1 $thickness=5.6e-08
+ $X=0.243 $Y=0.0675 $X2=0.243 $Y2=0.0245
.ends

.subckt PM_AO21x2_ASAP7_75t_R%B vss 11 5 9 3 4 1
c1 1 vss 0.00772757f $X=0.189 $Y=0.135
c2 3 vss 0.11942f $X=0.189 $Y=0.0245
c3 4 vss 0.0042306f $X=0.189 $Y=0.098
r1 11 4 8.62802 $w=1.3e-08 $l=3.7e-08 $layer=M1 $thickness=3.6e-08 $X=0.1865
+ $Y=0.1355 $X2=0.189 $Y2=0.098
r2 1 7 10.4265 $w=1.765e-08 $layer=LIG $thickness=5.2e-08 $X=0.189 $Y=0.135
+ $X2=0.189 $Y2=0.135
r3 11 1 19.3796 $a=3.24e-16 $layer=V0LIG $X=0.1865 $Y=0.1355 $X2=0.189 $Y2=0.135
r4 9 8 16.4967 $w=2.1e-08 $l=4.85e-08 $layer=Gate_1 $thickness=5.6e-08 $X=0.189
+ $Y=0.2025 $X2=0.189 $Y2=0.154
r5 7 8 6.6497 $w=2.04211e-08 $l=1.9e-08 $layer=Gate_1 $thickness=5.6e-08
+ $X=0.189 $Y=0.135 $X2=0.189 $Y2=0.154
r6 6 7 6.6497 $w=2.04211e-08 $l=1.9e-08 $layer=Gate_1 $thickness=5.6e-08
+ $X=0.189 $Y=0.116 $X2=0.189 $Y2=0.135
r7 5 6 16.4967 $w=2.1e-08 $l=4.85e-08 $layer=Gate_1 $thickness=5.6e-08 $X=0.189
+ $Y=0.0675 $X2=0.189 $Y2=0.116
r8 5 3 14.6259 $w=2.1e-08 $l=4.3e-08 $layer=Gate_1 $thickness=5.6e-08 $X=0.189
+ $Y=0.0675 $X2=0.189 $Y2=0.0245
.ends

.subckt PM_AO21x2_ASAP7_75t_R%Y vss 22 17 18 32 33 7 1 12 9 8
c1 1 vss 0.0118386f $X=0.276 $Y=0.0675
c2 2 vss 0.00838706f $X=0.27 $Y=0.2025
c3 7 vss 0.0035943f $X=0.2555 $Y=0.0675
c4 8 vss 0.00433287f $X=0.2555 $Y=0.2025
c5 9 vss 0.00252227f $X=0.285 $Y=0.0415
c6 10 vss 0.00179781f $X=0.324 $Y=0.078
c7 11 vss 0.00316599f $X=0.324 $Y=0.234
c8 12 vss 0.00796588f $X=0.3045 $Y=0.234
c9 13 vss 0.000772028f $X=0.3045 $Y=0.078
c10 14 vss 0.00644518f $X=0.324 $Y=0.1005
r1 33 31 0.0308642 $w=8.1e-08 $l=2.5e-09 $layer=P_src_drn $thickness=1e-09
+ $X=0.2873 $Y=0.2025 $X2=0.2845 $Y2=0.2025
r2 2 31 0.179012 $w=8.1e-08 $l=1.45e-08 $layer=P_src_drn $thickness=1e-09
+ $X=0.27 $Y=0.2025 $X2=0.2845 $Y2=0.2025
r3 8 2 0.179012 $w=8.1e-08 $l=1.45e-08 $layer=P_src_drn $thickness=1e-09
+ $X=0.2555 $Y=0.2025 $X2=0.27 $Y2=0.2025
r4 32 8 0.0308642 $w=8.1e-08 $l=2.5e-09 $layer=P_src_drn $thickness=1e-09
+ $X=0.2526 $Y=0.2025 $X2=0.2555 $Y2=0.2025
r5 2 28 19.3796 $a=3.24e-16 $layer=V0LISD $X=0.27 $Y=0.2025 $X2=0.2685 $Y2=0.234
r6 25 26 2.09871 $w=1.3e-08 $l=9e-09 $layer=M1 $thickness=3.6e-08 $X=0.2775
+ $Y=0.234 $X2=0.2865 $Y2=0.234
r7 25 28 2.09871 $w=1.3e-08 $l=9e-09 $layer=M1 $thickness=3.6e-08 $X=0.2775
+ $Y=0.234 $X2=0.2685 $Y2=0.234
r8 12 26 4.19742 $w=1.3e-08 $l=1.8e-08 $layer=M1 $thickness=3.6e-08 $X=0.3045
+ $Y=0.234 $X2=0.2865 $Y2=0.234
r9 11 24 2.5483 $w=1.79e-08 $l=1.8e-08 $layer=M1 $thickness=3.6e-08 $X=0.324
+ $Y=0.234 $X2=0.324 $Y2=0.216
r10 11 12 2.89809 $w=1.53077e-08 $l=1.95e-08 $layer=M1 $thickness=3.6e-08
+ $X=0.324 $Y=0.234 $X2=0.3045 $Y2=0.234
r11 23 24 12.8254 $w=1.3e-08 $l=5.5e-08 $layer=M1 $thickness=3.6e-08 $X=0.324
+ $Y=0.161 $X2=0.324 $Y2=0.216
r12 22 23 10.8433 $w=1.3e-08 $l=4.65e-08 $layer=M1 $thickness=3.6e-08 $X=0.3225
+ $Y=0.1145 $X2=0.324 $Y2=0.161
r13 22 14 3.26466 $w=1.3e-08 $l=1.4e-08 $layer=M1 $thickness=3.6e-08 $X=0.3225
+ $Y=0.1145 $X2=0.324 $Y2=0.1005
r14 10 13 2.89809 $w=1.53077e-08 $l=1.95e-08 $layer=M1 $thickness=3.6e-08
+ $X=0.324 $Y=0.078 $X2=0.3045 $Y2=0.078
r15 10 14 3.59766 $w=1.692e-08 $l=2.25e-08 $layer=M1 $thickness=3.6e-08
+ $X=0.324 $Y=0.078 $X2=0.324 $Y2=0.1005
r16 13 21 3.36689 $w=1.53077e-08 $l=1.95e-08 $layer=M1 $thickness=3.6e-08
+ $X=0.3045 $Y=0.078 $X2=0.285 $Y2=0.078
r17 20 21 1.61797 $w=1.675e-08 $l=1.2e-08 $layer=M1 $thickness=3.6e-08 $X=0.285
+ $Y=0.066 $X2=0.285 $Y2=0.078
r18 19 20 2.79828 $w=1.3e-08 $l=1.2e-08 $layer=M1 $thickness=3.6e-08 $X=0.285
+ $Y=0.054 $X2=0.285 $Y2=0.066
r19 9 19 2.91487 $w=1.3e-08 $l=1.25e-08 $layer=M1 $thickness=3.6e-08 $X=0.285
+ $Y=0.0415 $X2=0.285 $Y2=0.054
r20 1 19 19.3796 $a=3.24e-16 $layer=V0LISD $X=0.276 $Y=0.0675 $X2=0.285
+ $Y2=0.054
r21 18 16 0.0308642 $w=8.1e-08 $l=2.5e-09 $layer=N_src_drn $thickness=1e-09
+ $X=0.2873 $Y=0.0675 $X2=0.2845 $Y2=0.0675
r22 1 16 0.179012 $w=8.1e-08 $l=1.45e-08 $layer=N_src_drn $thickness=1e-09
+ $X=0.276 $Y=0.0675 $X2=0.2845 $Y2=0.0675
r23 7 1 0.179012 $w=8.1e-08 $l=1.45e-08 $layer=N_src_drn $thickness=1e-09
+ $X=0.2555 $Y=0.0675 $X2=0.276 $Y2=0.0675
r24 17 7 0.0308642 $w=8.1e-08 $l=2.5e-09 $layer=N_src_drn $thickness=1e-09
+ $X=0.2526 $Y=0.0675 $X2=0.2555 $Y2=0.0675
.ends

* End of included file AO21x2_ASAP7_75t_R.pex.sp.pex

*
.subckt AO21x2_ASAP7_75t_CUSTOM_4_25_0_7 VSS VDD A1 A2 B Y
*
* VSS VSS
* VDD VDD
* A1 A1
* A2 A2
* B B
* Y Y
*
*

M0 noxref_9 N_M0_g VSS VSS nmos_rvt L=2e-08 W=8.1e-08 nfin=3 $X=0.071 $Y=0.027
M1 N_M1_d N_M1_g noxref_9 VSS nmos_rvt L=2e-08 W=8.1e-08 nfin=3 $X=0.125
+ $Y=0.027
M2 VSS N_M2_g N_M2_s VSS nmos_rvt L=2e-08 W=8.1e-08 nfin=3 $X=0.179 $Y=0.027
M3 N_M3_d N_M3_g VSS VSS nmos_rvt L=2e-08 W=8.1e-08 nfin=3 $X=0.233 $Y=0.027
M4 N_M4_d N_M4_g VSS VSS nmos_rvt L=2e-08 W=8.1e-08 nfin=3 $X=0.287 $Y=0.027
M5 N_M5_d N_M5_g noxref_7 VDD pmos_rvt L=2e-08 W=8.1e-08 nfin=3 $X=0.071
+ $Y=0.162
M6 noxref_7 N_M6_g N_M6_s VDD pmos_rvt L=2e-08 W=8.1e-08 nfin=3 $X=0.125
+ $Y=0.162
M7 VDD N_M7_g noxref_7 VDD pmos_rvt L=2e-08 W=8.1e-08 nfin=3 $X=0.179 $Y=0.162
M8 N_M8_d N_M8_g VDD VDD pmos_rvt L=2e-08 W=8.1e-08 nfin=3 $X=0.233 $Y=0.162
M9 N_M9_d N_M9_g VDD VDD pmos_rvt L=2e-08 W=8.1e-08 nfin=3 $X=0.287 $Y=0.162

* .include "AO21x2_ASAP7_75t_R.pex.sp.pxi"

* Start of included file AO21x2_ASAP7_75t_R.pex.sp.pxi
x_PM_AO21x2_ASAP7_75t_R%A1 vss A1 N_M0_g N_M5_g N_A1_8 N_A1_3
+ PM_AO21x2_ASAP7_75t_R%A1
x_PM_AO21x2_ASAP7_75t_R%A2 vss A2 N_M1_g N_M6_g N_A2_3 N_A2_1
+ PM_AO21x2_ASAP7_75t_R%A2
cc_1 A2 N_A1_8 0.00232432f $X=0.1315 $Y=0.1355
cc_2 N_A2_3 N_A1_3 0.00740402f $X=0.135 $Y=0.0245
x_PM_AO21x2_ASAP7_75t_R%6 vss N_M3_g N_M8_g N_M4_g N_M9_g N_M1_d N_M2_s N_M5_d
+ N_M6_s N_6_3 N_6_15 N_6_12 N_6_16 N_6_4 N_6_11 N_6_1 N_6_9 N_6_17 N_6_13
+ N_6_10 N_6_14 PM_AO21x2_ASAP7_75t_R%6
cc_3 N_6_3 N_A1_3 0.00161556f $X=0.108 $Y=0.2025
cc_4 N_6_15 N_A1_8 0.00125874f $X=0.232 $Y=0.198
cc_5 N_6_12 N_A1_3 0.0366074f $X=0.0935 $Y=0.2025
cc_6 N_6_16 N_A2_3 0.000533927f $X=0.216 $Y=0.036
cc_7 N_6_4 N_A2_3 0.00195602f $X=0.162 $Y=0.0675
cc_8 N_6_3 N_A2_3 0.000801782f $X=0.108 $Y=0.2025
cc_9 N_6_15 A2 0.00113795f $X=0.232 $Y=0.198
cc_10 N_6_12 N_A2_1 0.0014542f $X=0.0935 $Y=0.2025
cc_11 N_6_4 A2 0.00238572f $X=0.162 $Y=0.0675
cc_12 N_6_11 N_A2_3 0.0148298f $X=0.1475 $Y=0.0675
cc_13 N_6_12 N_A2_3 0.0548592f $X=0.0935 $Y=0.2025
cc_14 N_6_1 N_B_3 0.000758455f $X=0.2335 $Y=0.135
cc_15 N_6_4 N_B_3 0.00184633f $X=0.162 $Y=0.0675
cc_16 N_6_16 N_B_3 0.000935384f $X=0.216 $Y=0.036
cc_17 N_6_15 N_B_4 0.00111455f $X=0.232 $Y=0.198
cc_18 N_6_11 N_B_1 0.00124854f $X=0.1475 $Y=0.0675
cc_19 N_6_9 N_B_3 0.00165654f $X=0.243 $Y=0.0245
cc_20 N_6_17 N_B_4 0.00609813f $X=0.243 $Y=0.1065
cc_21 N_6_11 N_B_3 0.0363691f $X=0.1475 $Y=0.0675
x_PM_AO21x2_ASAP7_75t_R%B vss B N_M2_g N_M7_g N_B_3 N_B_4 N_B_1
+ PM_AO21x2_ASAP7_75t_R%B
cc_22 N_B_3 N_A2_3 0.00317094f $X=0.189 $Y=0.0245
cc_23 N_B_4 A2 0.00495291f $X=0.189 $Y=0.098
x_PM_AO21x2_ASAP7_75t_R%Y vss Y N_M3_d N_M4_d N_M8_d N_M9_d N_Y_7 N_Y_1 N_Y_12
+ N_Y_9 N_Y_8 PM_AO21x2_ASAP7_75t_R%Y
cc_24 N_Y_7 N_6_1 0.00689182f $X=0.2555 $Y=0.0675
cc_25 N_Y_7 N_6_13 0.000618332f $X=0.2555 $Y=0.0675
cc_26 N_Y_7 N_6_15 0.000788537f $X=0.2555 $Y=0.0675
cc_27 N_Y_7 N_6_9 0.00165572f $X=0.2555 $Y=0.0675
cc_28 N_Y_1 N_6_10 0.00287623f $X=0.276 $Y=0.0675
cc_29 N_Y_12 N_6_14 0.00302651f $X=0.3045 $Y=0.234
cc_30 N_Y_9 N_6_17 0.00507923f $X=0.285 $Y=0.0415
cc_31 N_Y_8 N_6_10 0.0103356f $X=0.2555 $Y=0.2025
cc_32 N_Y_8 N_6_9 0.0545747f $X=0.2555 $Y=0.2025
cc_33 N_Y_7 N_6_10 0.0686551f $X=0.2555 $Y=0.0675

* End of included file AO21x2_ASAP7_75t_R.pex.sp.pxi
.ends

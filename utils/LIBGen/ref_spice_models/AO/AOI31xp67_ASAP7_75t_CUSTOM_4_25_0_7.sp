.subckt PM_AOI31xp67_ASAP7_75t_R%A3 vss 25 11 17 30 33 4 10
c1 1 vss 0.017037f $X=0.0715 $Y=0.135
c2 3 vss 0.159489f $X=0.081 $Y=0.0245
c3 4 vss 0.19145f $X=0.135 $Y=0.135
c4 5 vss 0.00781955f $X=0.027 $Y=0.036
c5 6 vss 0.00108312f $X=0.027 $Y=0.135
c6 7 vss 0.00667385f $X=0.027 $Y=0.198
c7 8 vss 0.0062109f $X=0.027 $Y=0.1035
c8 9 vss 0.00318379f $X=0.027 $Y=0.1665
c9 10 vss 0.00250532f $X=0.0655 $Y=0.135
r1 7 9 6.16517 $w=1.44286e-08 $l=3.15e-08 $layer=M1 $thickness=3.6e-08 $X=0.027
+ $Y=0.198 $X2=0.027 $Y2=0.1665
r2 5 36 3.01711 $w=1.55e-08 $l=1.8e-08 $layer=M1 $thickness=3.6e-08 $X=0.027
+ $Y=0.036 $X2=0.027 $Y2=0.054
r3 35 36 4.19742 $w=1.3e-08 $l=1.8e-08 $layer=M1 $thickness=3.6e-08 $X=0.027
+ $Y=0.072 $X2=0.027 $Y2=0.054
r4 8 35 7.34548 $w=1.3e-08 $l=3.15e-08 $layer=M1 $thickness=3.6e-08 $X=0.027
+ $Y=0.1035 $X2=0.027 $Y2=0.072
r5 6 27 3.60008 $w=1.51951e-08 $l=2.05e-08 $layer=M1 $thickness=3.6e-08
+ $X=0.027 $Y=0.135 $X2=0.0475 $Y2=0.135
r6 6 8 6.16517 $w=1.44286e-08 $l=3.15e-08 $layer=M1 $thickness=3.6e-08 $X=0.027
+ $Y=0.135 $X2=0.027 $Y2=0.1035
r7 6 9 6.16517 $w=1.44286e-08 $l=3.15e-08 $layer=M1 $thickness=3.6e-08 $X=0.027
+ $Y=0.135 $X2=0.027 $Y2=0.1665
r8 33 32 16.4967 $w=2.1e-08 $l=4.85e-08 $layer=Gate_1 $thickness=5.6e-08
+ $X=0.135 $Y=0.2025 $X2=0.135 $Y2=0.154
r9 30 31 16.4967 $w=2.1e-08 $l=4.85e-08 $layer=Gate_1 $thickness=5.6e-08
+ $X=0.135 $Y=0.0675 $X2=0.135 $Y2=0.116
r10 4 23 6.54019 $w=2.09524e-08 $layer=Gate_1 $thickness=5.21905e-08 $X=0.135
+ $Y=0.135 $X2=0.135 $Y2=0.135
r11 4 31 6.6497 $w=2.04211e-08 $l=1.9e-08 $layer=Gate_1 $thickness=5.6e-08
+ $X=0.135 $Y=0.135 $X2=0.135 $Y2=0.116
r12 4 32 6.6497 $w=2.04211e-08 $l=1.9e-08 $layer=Gate_1 $thickness=5.6e-08
+ $X=0.135 $Y=0.135 $X2=0.135 $Y2=0.154
r13 25 10 3.61444 $w=1.3e-08 $l=1.55e-08 $layer=M1 $thickness=3.6e-08 $X=0.08
+ $Y=0.136 $X2=0.0655 $Y2=0.135
r14 10 27 4.19742 $w=1.3e-08 $l=1.8e-08 $layer=M1 $thickness=3.6e-08 $X=0.0655
+ $Y=0.135 $X2=0.0475 $Y2=0.135
r15 22 23 12.6539 $w=1.77815e-08 $l=2.7e-08 $layer=LIG $thickness=4.8e-08
+ $X=0.108 $Y=0.135 $X2=0.135 $Y2=0.135
r16 20 22 10.1729 $w=1.54914e-08 $l=1.75e-08 $layer=LIG $thickness=4.8e-08
+ $X=0.0905 $Y=0.135 $X2=0.108 $Y2=0.135
r17 19 20 2.48102 $w=2.2e-08 $l=9.5e-09 $layer=LIG $thickness=4.8e-08 $X=0.081
+ $Y=0.135 $X2=0.0905 $Y2=0.135
r18 25 19 19.3796 $a=3.24e-16 $layer=V0LIG $X=0.08 $Y=0.136 $X2=0.081 $Y2=0.135
r19 1 19 2.48102 $w=2.2e-08 $l=9.5e-09 $layer=LIG $thickness=4.8e-08 $X=0.0715
+ $Y=0.135 $X2=0.081 $Y2=0.135
r20 17 16 14.6259 $w=2.1e-08 $l=4.3e-08 $layer=Gate_1 $thickness=5.6e-08
+ $X=0.081 $Y=0.2025 $X2=0.081 $Y2=0.1595
r21 15 16 2.7211 $w=2.1e-08 $l=8e-09 $layer=Gate_1 $thickness=5.6e-08 $X=0.081
+ $Y=0.1515 $X2=0.081 $Y2=0.1595
r22 14 15 5.79936 $w=2.03333e-08 $l=1.65e-08 $layer=Gate_1 $thickness=5.6e-08
+ $X=0.081 $Y=0.135 $X2=0.081 $Y2=0.1515
r23 14 20 4.05918 $w=2.0087e-08 $l=9.5e-09 $layer=Gate_1 $thickness=5.56522e-08
+ $X=0.081 $Y=0.135 $X2=0.0905 $Y2=0.135
r24 14 19 6.27904 $w=2.09e-08 $layer=Gate_1 $thickness=5.24e-08 $X=0.081
+ $Y=0.135 $X2=0.081 $Y2=0.135
r25 13 14 5.79936 $w=2.03333e-08 $l=1.65e-08 $layer=Gate_1 $thickness=5.6e-08
+ $X=0.081 $Y=0.1185 $X2=0.081 $Y2=0.135
r26 12 13 2.7211 $w=2.1e-08 $l=8e-09 $layer=Gate_1 $thickness=5.6e-08 $X=0.081
+ $Y=0.1105 $X2=0.081 $Y2=0.1185
r27 11 12 14.6259 $w=2.1e-08 $l=4.3e-08 $layer=Gate_1 $thickness=5.6e-08
+ $X=0.081 $Y=0.0675 $X2=0.081 $Y2=0.1105
r28 11 3 14.6259 $w=2.1e-08 $l=4.3e-08 $layer=Gate_1 $thickness=5.6e-08
+ $X=0.081 $Y=0.0675 $X2=0.081 $Y2=0.0245
.ends

.subckt PM_AOI31xp67_ASAP7_75t_R%A2 vss 23 9 15 28 31 4 8 6
c1 1 vss 0.0189005f $X=0.3955 $Y=0.134
c2 3 vss 0.159583f $X=0.405 $Y=0.0245
c3 4 vss 0.156303f $X=0.459 $Y=0.134
c4 5 vss 0.00644182f $X=0.297 $Y=0.072
c5 6 vss 0.00217001f $X=0.297 $Y=0.135
c6 7 vss 0.00236494f $X=0.297 $Y=0.1125
c7 8 vss 0.00852499f $X=0.38 $Y=0.135
r1 5 34 3.01711 $w=1.55e-08 $l=1.8e-08 $layer=M1 $thickness=3.6e-08 $X=0.297
+ $Y=0.072 $X2=0.297 $Y2=0.09
r2 7 34 5.24677 $w=1.3e-08 $l=2.25e-08 $layer=M1 $thickness=3.6e-08 $X=0.297
+ $Y=0.1125 $X2=0.297 $Y2=0.09
r3 6 26 3.1337 $w=1.54324e-08 $l=1.85e-08 $layer=M1 $thickness=3.6e-08 $X=0.297
+ $Y=0.135 $X2=0.3155 $Y2=0.135
r4 6 7 4.06646 $w=1.5e-08 $l=2.25e-08 $layer=M1 $thickness=3.6e-08 $X=0.297
+ $Y=0.135 $X2=0.297 $Y2=0.1125
r5 31 30 16.6668 $w=2.1e-08 $l=4.9e-08 $layer=Gate_1 $thickness=5.6e-08
+ $X=0.459 $Y=0.2025 $X2=0.459 $Y2=0.1535
r6 28 29 16.3266 $w=2.1e-08 $l=4.8e-08 $layer=Gate_1 $thickness=5.6e-08
+ $X=0.459 $Y=0.0675 $X2=0.459 $Y2=0.1155
r7 4 21 6.54019 $w=2.09524e-08 $layer=Gate_1 $thickness=5.21905e-08 $X=0.459
+ $Y=0.134 $X2=0.459 $Y2=0.134
r8 4 29 6.47963 $w=2.04054e-08 $l=1.85e-08 $layer=Gate_1 $thickness=5.6e-08
+ $X=0.459 $Y=0.134 $X2=0.459 $Y2=0.1155
r9 4 30 6.81977 $w=2.04359e-08 $l=1.95e-08 $layer=Gate_1 $thickness=5.6e-08
+ $X=0.459 $Y=0.134 $X2=0.459 $Y2=0.1535
r10 25 26 6.7625 $w=1.3e-08 $l=2.9e-08 $layer=M1 $thickness=3.6e-08 $X=0.3445
+ $Y=0.135 $X2=0.3155 $Y2=0.135
r11 23 8 5.82974 $w=1.3e-08 $l=2.5e-08 $layer=M1 $thickness=3.6e-08 $X=0.403
+ $Y=0.137 $X2=0.38 $Y2=0.135
r12 8 25 8.27824 $w=1.3e-08 $l=3.55e-08 $layer=M1 $thickness=3.6e-08 $X=0.38
+ $Y=0.135 $X2=0.3445 $Y2=0.135
r13 20 21 12.6539 $w=1.77815e-08 $l=2.7e-08 $layer=LIG $thickness=4.8e-08
+ $X=0.432 $Y=0.134 $X2=0.459 $Y2=0.134
r14 18 20 10.1729 $w=1.54914e-08 $l=1.75e-08 $layer=LIG $thickness=4.8e-08
+ $X=0.4145 $Y=0.134 $X2=0.432 $Y2=0.134
r15 17 18 2.48102 $w=2.2e-08 $l=9.5e-09 $layer=LIG $thickness=4.8e-08 $X=0.405
+ $Y=0.134 $X2=0.4145 $Y2=0.134
r16 23 17 19.3796 $a=3.24e-16 $layer=V0LIG $X=0.403 $Y=0.137 $X2=0.405 $Y2=0.134
r17 1 17 2.48102 $w=2.2e-08 $l=9.5e-09 $layer=LIG $thickness=4.8e-08 $X=0.3955
+ $Y=0.134 $X2=0.405 $Y2=0.134
r18 15 14 14.6259 $w=2.1e-08 $l=4.3e-08 $layer=Gate_1 $thickness=5.6e-08
+ $X=0.405 $Y=0.2025 $X2=0.405 $Y2=0.1595
r19 13 14 2.89117 $w=2.1e-08 $l=8.5e-09 $layer=Gate_1 $thickness=5.6e-08
+ $X=0.405 $Y=0.151 $X2=0.405 $Y2=0.1595
r20 12 13 5.96942 $w=2.03529e-08 $l=1.7e-08 $layer=Gate_1 $thickness=5.6e-08
+ $X=0.405 $Y=0.134 $X2=0.405 $Y2=0.151
r21 12 18 4.05918 $w=2.0087e-08 $l=9.5e-09 $layer=Gate_1 $thickness=5.56522e-08
+ $X=0.405 $Y=0.134 $X2=0.4145 $Y2=0.134
r22 12 17 6.27904 $w=2.09e-08 $layer=Gate_1 $thickness=5.24e-08 $X=0.405
+ $Y=0.134 $X2=0.405 $Y2=0.134
r23 11 12 5.62929 $w=2.03125e-08 $l=1.6e-08 $layer=Gate_1 $thickness=5.6e-08
+ $X=0.405 $Y=0.118 $X2=0.405 $Y2=0.134
r24 10 11 2.55104 $w=2.1e-08 $l=7.5e-09 $layer=Gate_1 $thickness=5.6e-08
+ $X=0.405 $Y=0.1105 $X2=0.405 $Y2=0.118
r25 9 10 14.6259 $w=2.1e-08 $l=4.3e-08 $layer=Gate_1 $thickness=5.6e-08
+ $X=0.405 $Y=0.0675 $X2=0.405 $Y2=0.1105
r26 9 3 14.6259 $w=2.1e-08 $l=4.3e-08 $layer=Gate_1 $thickness=5.6e-08 $X=0.405
+ $Y=0.0675 $X2=0.405 $Y2=0.0245
.ends

.subckt PM_AOI31xp67_ASAP7_75t_R%Y vss 31 26 48 49 63 64 17 16 2 13 1 20 15 21
+ 24 22 3 4 14 18
c1 1 vss 0.00735155f $X=0.216 $Y=0.054
c2 2 vss 0.00949794f $X=0.216 $Y=0.2025
c3 3 vss 0.0112244f $X=0.54 $Y=0.0675
c4 4 vss 0.0345841f $X=0.648 $Y=0.1935
c5 13 vss 0.00297199f $X=0.2015 $Y=0.054
c6 14 vss 0.00432517f $X=0.5255 $Y=0.0675
c7 15 vss 0.00434776f $X=0.2015 $Y=0.2025
c8 16 vss 0.00567617f $X=0.2025 $Y=0.072
c9 17 vss 0.00536675f $X=0.243 $Y=0.198
c10 18 vss 0.00123112f $X=0.594 $Y=0.1945
c11 19 vss 0.0034401f $X=0.594 $Y=0.234
c12 20 vss 0.00245976f $X=0.243 $Y=0.1035
c13 21 vss 0.0338515f $X=0.27 $Y=0.198
c14 22 vss 0.0169524f $X=0.6235 $Y=0.036
c15 23 vss 0.00108485f $X=0.594 $Y=0.216
c16 24 vss 0.00573184f $X=0.621 $Y=0.234
r1 64 62 0.0308642 $w=8.1e-08 $l=2.5e-09 $layer=N_src_drn $thickness=1e-09
+ $X=0.5573 $Y=0.0675 $X2=0.5545 $Y2=0.0675
r2 3 62 0.179012 $w=8.1e-08 $l=1.45e-08 $layer=N_src_drn $thickness=1e-09
+ $X=0.54 $Y=0.0675 $X2=0.5545 $Y2=0.0675
r3 14 3 0.179012 $w=8.1e-08 $l=1.45e-08 $layer=N_src_drn $thickness=1e-09
+ $X=0.5255 $Y=0.0675 $X2=0.54 $Y2=0.0675
r4 63 14 0.0308642 $w=8.1e-08 $l=2.5e-09 $layer=N_src_drn $thickness=1e-09
+ $X=0.5226 $Y=0.0675 $X2=0.5255 $Y2=0.0675
r5 3 59 19.3796 $a=3.24e-16 $layer=V0LISD $X=0.54 $Y=0.0675 $X2=0.54 $Y2=0.036
r6 59 60 8.97781 $w=1.3e-08 $l=3.85e-08 $layer=M1 $thickness=3.6e-08 $X=0.54
+ $Y=0.036 $X2=0.5785 $Y2=0.036
r7 22 56 5.71315 $w=1.3e-08 $l=2.45e-08 $layer=M1 $thickness=3.6e-08 $X=0.6235
+ $Y=0.036 $X2=0.648 $Y2=0.036
r8 22 60 10.4935 $w=1.3e-08 $l=4.5e-08 $layer=M1 $thickness=3.6e-08 $X=0.6235
+ $Y=0.036 $X2=0.5785 $Y2=0.036
r9 54 55 23.8708 $w=2.02e-08 $l=4.05e-08 $layer=LISD $thickness=2.7e-08
+ $X=0.648 $Y=0.036 $X2=0.648 $Y2=0.0765
r10 54 56 19.3796 $a=3.24e-16 $layer=V0LISD $X=0.648 $Y=0.036 $X2=0.648
+ $Y2=0.036
r11 53 55 34.4801 $w=2.02e-08 $l=5.85e-08 $layer=LISD $thickness=2.7e-08
+ $X=0.648 $Y=0.135 $X2=0.648 $Y2=0.0765
r12 4 52 23.8708 $w=2.02e-08 $l=4.05e-08 $layer=LISD $thickness=2.7e-08
+ $X=0.648 $Y=0.1935 $X2=0.648 $Y2=0.234
r13 4 53 34.4801 $w=2.02e-08 $l=5.85e-08 $layer=LISD $thickness=2.7e-08
+ $X=0.648 $Y=0.1935 $X2=0.648 $Y2=0.135
r14 50 52 19.3796 $a=3.24e-16 $layer=V0LISD $X=0.648 $Y=0.234 $X2=0.648
+ $Y2=0.234
r15 24 50 6.29612 $w=1.3e-08 $l=2.7e-08 $layer=M1 $thickness=3.6e-08 $X=0.621
+ $Y=0.234 $X2=0.648 $Y2=0.234
r16 19 23 2.5483 $w=1.79e-08 $l=1.8e-08 $layer=M1 $thickness=3.6e-08 $X=0.594
+ $Y=0.234 $X2=0.594 $Y2=0.216
r17 19 24 4.64701 $w=1.46667e-08 $l=2.7e-08 $layer=M1 $thickness=3.6e-08
+ $X=0.594 $Y=0.234 $X2=0.621 $Y2=0.234
r18 23 45 2.45586 $w=1.44e-08 $l=1.25e-08 $layer=M1 $thickness=3.6e-08 $X=0.594
+ $Y=0.216 $X2=0.594 $Y2=0.2035
r19 48 47 0.0308642 $w=8.1e-08 $l=2.5e-09 $layer=P_src_drn $thickness=1e-09
+ $X=0.2333 $Y=0.2025 $X2=0.2305 $Y2=0.2025
r20 2 47 0.179012 $w=8.1e-08 $l=1.45e-08 $layer=P_src_drn $thickness=1e-09
+ $X=0.216 $Y=0.2025 $X2=0.2305 $Y2=0.2025
r21 15 2 0.179012 $w=8.1e-08 $l=1.45e-08 $layer=P_src_drn $thickness=1e-09
+ $X=0.2015 $Y=0.2025 $X2=0.216 $Y2=0.2025
r22 49 15 0.0308642 $w=8.1e-08 $l=2.5e-09 $layer=P_src_drn $thickness=1e-09
+ $X=0.1986 $Y=0.2025 $X2=0.2015 $Y2=0.2025
r23 18 45 0.9184 $w=1.8e-08 $l=9e-09 $layer=M1 $thickness=3.6e-08 $X=0.594
+ $Y=0.1945 $X2=0.594 $Y2=0.2035
r24 2 37 19.3796 $a=3.24e-16 $layer=V0LISD $X=0.216 $Y=0.2025 $X2=0.216
+ $Y2=0.198
r25 44 45 3.9716 $w=1.39211e-08 $l=2.51098e-08 $layer=M1 $thickness=3.6e-08
+ $X=0.5695 $Y=0.198 $X2=0.594 $Y2=0.2035
r26 43 44 3.73104 $w=1.3e-08 $l=1.6e-08 $layer=M1 $thickness=3.6e-08 $X=0.5535
+ $Y=0.198 $X2=0.5695 $Y2=0.198
r27 42 43 15.7403 $w=1.3e-08 $l=6.75e-08 $layer=M1 $thickness=3.6e-08 $X=0.486
+ $Y=0.198 $X2=0.5535 $Y2=0.198
r28 41 42 28.7989 $w=1.3e-08 $l=1.235e-07 $layer=M1 $thickness=3.6e-08
+ $X=0.3625 $Y=0.198 $X2=0.486 $Y2=0.198
r29 40 41 15.2739 $w=1.3e-08 $l=6.55e-08 $layer=M1 $thickness=3.6e-08 $X=0.297
+ $Y=0.198 $X2=0.3625 $Y2=0.198
r30 21 40 6.29612 $w=1.3e-08 $l=2.7e-08 $layer=M1 $thickness=3.6e-08 $X=0.27
+ $Y=0.198 $X2=0.297 $Y2=0.198
r31 37 38 3.14806 $w=1.3e-08 $l=1.35e-08 $layer=M1 $thickness=3.6e-08 $X=0.216
+ $Y=0.198 $X2=0.2295 $Y2=0.198
r32 17 35 3.83327 $w=1.5093e-08 $l=2.15e-08 $layer=M1 $thickness=3.6e-08
+ $X=0.243 $Y=0.198 $X2=0.243 $Y2=0.1765
r33 17 38 1.96775 $w=1.63333e-08 $l=1.35e-08 $layer=M1 $thickness=3.6e-08
+ $X=0.243 $Y=0.198 $X2=0.2295 $Y2=0.198
r34 17 21 5.11582 $w=1.46667e-08 $l=2.7e-08 $layer=M1 $thickness=3.6e-08
+ $X=0.243 $Y=0.198 $X2=0.27 $Y2=0.198
r35 34 35 5.24677 $w=1.3e-08 $l=2.25e-08 $layer=M1 $thickness=3.6e-08 $X=0.243
+ $Y=0.154 $X2=0.243 $Y2=0.1765
r36 33 34 4.43061 $w=1.3e-08 $l=1.9e-08 $layer=M1 $thickness=3.6e-08 $X=0.243
+ $Y=0.135 $X2=0.243 $Y2=0.154
r37 20 30 5.93557 $w=1.41538e-08 $l=3.15839e-08 $layer=M1 $thickness=3.6e-08
+ $X=0.243 $Y=0.1035 $X2=0.2407 $Y2=0.072
r38 20 33 7.34548 $w=1.3e-08 $l=3.15e-08 $layer=M1 $thickness=3.6e-08 $X=0.243
+ $Y=0.1035 $X2=0.243 $Y2=0.135
r39 31 30 0.739822 $w=1.8e-08 $l=7.3e-09 $layer=M1 $thickness=3.6e-08 $X=0.248
+ $Y=0.077 $X2=0.2407 $Y2=0.072
r40 29 30 1.73815 $w=1.6e-08 $l=1.12e-08 $layer=M1 $thickness=3.6e-08 $X=0.2295
+ $Y=0.072 $X2=0.2407 $Y2=0.072
r41 28 29 3.14806 $w=1.3e-08 $l=1.35e-08 $layer=M1 $thickness=3.6e-08 $X=0.216
+ $Y=0.072 $X2=0.2295 $Y2=0.072
r42 27 28 2.56509 $w=1.3e-08 $l=1.1e-08 $layer=M1 $thickness=3.6e-08 $X=0.205
+ $Y=0.072 $X2=0.216 $Y2=0.072
r43 16 27 0.582974 $w=1.3e-08 $l=2.5e-09 $layer=M1 $thickness=3.6e-08 $X=0.2025
+ $Y=0.072 $X2=0.205 $Y2=0.072
r44 1 28 19.3796 $a=3.24e-16 $layer=V0LISD $X=0.216 $Y=0.054 $X2=0.216 $Y2=0.072
r45 13 1 0.231482 $w=5.4e-08 $l=1.25e-08 $layer=N_src_drn $thickness=1e-09
+ $X=0.2015 $Y=0.054 $X2=0.216 $Y2=0.054
r46 26 13 0.0462963 $w=5.4e-08 $l=2.5e-09 $layer=N_src_drn $thickness=1e-09
+ $X=0.1986 $Y=0.054 $X2=0.2015 $Y2=0.054
.ends

.subckt PM_AOI31xp67_ASAP7_75t_R%A1 vss 27 9 13 22 25 3 4 1 7 8 6
c1 1 vss 0.0142676f $X=0.513 $Y=0.135
c2 3 vss 0.118218f $X=0.513 $Y=0.0245
c3 4 vss 0.121769f $X=0.567 $Y=0.135
c4 5 vss 0.0014473f $X=0.675 $Y=0.135
c5 6 vss 0.00869558f $X=0.5555 $Y=0.135
c6 7 vss 0.00664365f $X=0.675 $Y=0.1125
c7 8 vss 0.00644268f $X=0.675 $Y=0.1665
r1 5 31 1.26818 $w=1.72857e-08 $l=1.05e-08 $layer=M1 $thickness=3.6e-08
+ $X=0.675 $Y=0.135 $X2=0.6645 $Y2=0.135
r2 5 7 4.06646 $w=1.5e-08 $l=2.25e-08 $layer=M1 $thickness=3.6e-08 $X=0.675
+ $Y=0.135 $X2=0.675 $Y2=0.1125
r3 5 8 6.16517 $w=1.44286e-08 $l=3.15e-08 $layer=M1 $thickness=3.6e-08 $X=0.675
+ $Y=0.135 $X2=0.675 $Y2=0.1665
r4 30 31 6.7625 $w=1.3e-08 $l=2.9e-08 $layer=M1 $thickness=3.6e-08 $X=0.6355
+ $Y=0.135 $X2=0.6645 $Y2=0.135
r5 29 30 6.99569 $w=1.3e-08 $l=3e-08 $layer=M1 $thickness=3.6e-08 $X=0.6055
+ $Y=0.135 $X2=0.6355 $Y2=0.135
r6 28 29 3.73104 $w=1.3e-08 $l=1.6e-08 $layer=M1 $thickness=3.6e-08 $X=0.5895
+ $Y=0.135 $X2=0.6055 $Y2=0.135
r7 27 28 5.24677 $w=1.3e-08 $l=2.25e-08 $layer=M1 $thickness=3.6e-08 $X=0.569
+ $Y=0.137 $X2=0.5895 $Y2=0.135
r8 27 6 2.68168 $w=1.3e-08 $l=1.15e-08 $layer=M1 $thickness=3.6e-08 $X=0.569
+ $Y=0.137 $X2=0.5555 $Y2=0.135
r9 25 24 16.4967 $w=2.1e-08 $l=4.85e-08 $layer=Gate_1 $thickness=5.6e-08
+ $X=0.567 $Y=0.2025 $X2=0.567 $Y2=0.154
r10 22 23 16.4967 $w=2.1e-08 $l=4.85e-08 $layer=Gate_1 $thickness=5.6e-08
+ $X=0.567 $Y=0.0675 $X2=0.567 $Y2=0.116
r11 4 18 6.27904 $w=2.09e-08 $layer=Gate_1 $thickness=5.24e-08 $X=0.567
+ $Y=0.135 $X2=0.567 $Y2=0.135
r12 4 23 6.6497 $w=2.04211e-08 $l=1.9e-08 $layer=Gate_1 $thickness=5.6e-08
+ $X=0.567 $Y=0.135 $X2=0.567 $Y2=0.116
r13 4 24 6.6497 $w=2.04211e-08 $l=1.9e-08 $layer=Gate_1 $thickness=5.6e-08
+ $X=0.567 $Y=0.135 $X2=0.567 $Y2=0.154
r14 27 18 19.3796 $a=3.24e-16 $layer=V0LIG $X=0.569 $Y=0.137 $X2=0.567 $Y2=0.135
r15 17 18 2.48102 $w=2.2e-08 $l=9.5e-09 $layer=LIG $thickness=4.8e-08 $X=0.5575
+ $Y=0.135 $X2=0.567 $Y2=0.135
r16 16 17 10.1729 $w=1.54914e-08 $l=1.75e-08 $layer=LIG $thickness=4.8e-08
+ $X=0.54 $Y=0.135 $X2=0.5575 $Y2=0.135
r17 1 11 6.54019 $w=2.09524e-08 $layer=Gate_1 $thickness=5.21905e-08 $X=0.513
+ $Y=0.135 $X2=0.513 $Y2=0.135
r18 1 16 12.6539 $w=1.77815e-08 $l=2.7e-08 $layer=LIG $thickness=4.8e-08
+ $X=0.513 $Y=0.135 $X2=0.54 $Y2=0.135
r19 13 12 16.4967 $w=2.1e-08 $l=4.85e-08 $layer=Gate_1 $thickness=5.6e-08
+ $X=0.513 $Y=0.2025 $X2=0.513 $Y2=0.154
r20 11 12 6.6497 $w=2.04211e-08 $l=1.9e-08 $layer=Gate_1 $thickness=5.6e-08
+ $X=0.513 $Y=0.135 $X2=0.513 $Y2=0.154
r21 10 11 6.6497 $w=2.04211e-08 $l=1.9e-08 $layer=Gate_1 $thickness=5.6e-08
+ $X=0.513 $Y=0.116 $X2=0.513 $Y2=0.135
r22 9 10 16.4967 $w=2.1e-08 $l=4.85e-08 $layer=Gate_1 $thickness=5.6e-08
+ $X=0.513 $Y=0.0675 $X2=0.513 $Y2=0.116
r23 9 3 14.6259 $w=2.1e-08 $l=4.3e-08 $layer=Gate_1 $thickness=5.6e-08 $X=0.513
+ $Y=0.0675 $X2=0.513 $Y2=0.0245
.ends

.subckt PM_AOI31xp67_ASAP7_75t_R%B vss 29 15 24 27 8 7 3 4 10 1
c1 1 vss 0.0108353f $X=0.243 $Y=0.135
c2 3 vss 0.0845929f $X=0.189 $Y=0.135
c3 4 vss 0.0561697f $X=0.243 $Y=0.0675
c4 5 vss 0.00820551f $X=0.135 $Y=0.072
c5 6 vss 0.00830143f $X=0.135 $Y=0.198
c6 7 vss 0.00227558f $X=0.135 $Y=0.135
c7 8 vss 0.00424345f $X=0.135 $Y=0.1035
c8 9 vss 0.00427969f $X=0.135 $Y=0.1665
c9 10 vss 0.00386537f $X=0.162 $Y=0.135
r1 6 9 6.16517 $w=1.44286e-08 $l=3.15e-08 $layer=M1 $thickness=3.6e-08 $X=0.135
+ $Y=0.198 $X2=0.135 $Y2=0.1665
r2 5 8 6.16517 $w=1.44286e-08 $l=3.15e-08 $layer=M1 $thickness=3.6e-08 $X=0.135
+ $Y=0.072 $X2=0.135 $Y2=0.1035
r3 7 10 5.11582 $w=1.46667e-08 $l=2.7e-08 $layer=M1 $thickness=3.6e-08 $X=0.135
+ $Y=0.135 $X2=0.162 $Y2=0.135
r4 7 8 6.16517 $w=1.44286e-08 $l=3.15e-08 $layer=M1 $thickness=3.6e-08 $X=0.135
+ $Y=0.135 $X2=0.135 $Y2=0.1035
r5 7 9 6.16517 $w=1.44286e-08 $l=3.15e-08 $layer=M1 $thickness=3.6e-08 $X=0.135
+ $Y=0.135 $X2=0.135 $Y2=0.1665
r6 29 10 6.29612 $w=1.3e-08 $l=2.7e-08 $layer=M1 $thickness=3.6e-08 $X=0.189
+ $Y=0.134 $X2=0.162 $Y2=0.135
r7 27 26 16.4967 $w=2.1e-08 $l=4.85e-08 $layer=Gate_1 $thickness=5.6e-08
+ $X=0.189 $Y=0.2025 $X2=0.189 $Y2=0.154
r8 24 25 16.4967 $w=2.1e-08 $l=4.85e-08 $layer=Gate_1 $thickness=5.6e-08
+ $X=0.189 $Y=0.054 $X2=0.189 $Y2=0.1025
r9 3 19 6.27904 $w=2.09e-08 $layer=Gate_1 $thickness=5.24e-08 $X=0.189 $Y=0.135
+ $X2=0.189 $Y2=0.135
r10 3 25 11.2416 $w=2.06615e-08 $l=3.25e-08 $layer=Gate_1 $thickness=5.6e-08
+ $X=0.189 $Y=0.135 $X2=0.189 $Y2=0.1025
r11 3 26 6.6497 $w=2.04211e-08 $l=1.9e-08 $layer=Gate_1 $thickness=5.6e-08
+ $X=0.189 $Y=0.135 $X2=0.189 $Y2=0.154
r12 19 20 2.48102 $w=2.2e-08 $l=9.5e-09 $layer=LIG $thickness=4.8e-08 $X=0.189
+ $Y=0.135 $X2=0.1985 $Y2=0.135
r13 29 19 19.3796 $a=3.24e-16 $layer=V0LIG $X=0.189 $Y=0.134 $X2=0.189 $Y2=0.135
r14 17 20 10.1729 $w=1.54914e-08 $l=1.75e-08 $layer=LIG $thickness=4.8e-08
+ $X=0.216 $Y=0.135 $X2=0.1985 $Y2=0.135
r15 1 12 6.54019 $w=2.09524e-08 $layer=Gate_1 $thickness=5.21905e-08 $X=0.243
+ $Y=0.135 $X2=0.243 $Y2=0.135
r16 1 17 12.6539 $w=1.77815e-08 $l=2.7e-08 $layer=LIG $thickness=4.8e-08
+ $X=0.243 $Y=0.135 $X2=0.216 $Y2=0.135
r17 15 14 14.6259 $w=2.1e-08 $l=4.3e-08 $layer=Gate_1 $thickness=5.6e-08
+ $X=0.243 $Y=0.2025 $X2=0.243 $Y2=0.1595
r18 13 14 2.7211 $w=2.1e-08 $l=8e-09 $layer=Gate_1 $thickness=5.6e-08 $X=0.243
+ $Y=0.1515 $X2=0.243 $Y2=0.1595
r19 12 13 5.79936 $w=2.03333e-08 $l=1.65e-08 $layer=Gate_1 $thickness=5.6e-08
+ $X=0.243 $Y=0.135 $X2=0.243 $Y2=0.1515
r20 11 12 5.79936 $w=2.03333e-08 $l=1.65e-08 $layer=Gate_1 $thickness=5.6e-08
+ $X=0.243 $Y=0.1185 $X2=0.243 $Y2=0.135
r21 4 11 17.347 $w=2.1e-08 $l=5.1e-08 $layer=Gate_1 $thickness=5.6e-08 $X=0.243
+ $Y=0.0675 $X2=0.243 $Y2=0.1185
.ends

* End of included file AOI31xp67_ASAP7_75t_R.pex.sp.pex

*
.subckt AOI31xp67_ASAP7_75t_CUSTOM_4_25_0_7 VSS VDD A3 B A2 A1 Y
*
* VSS VSS
* VDD VDD
* A3 A3
* B B
* A2 A2
* A1 A1
* Y Y
*
*

M0 noxref_8 N_M0_g VSS VSS nmos_rvt L=2e-08 W=8.1e-08 nfin=3 $X=0.071 $Y=0.027
M1 noxref_8 N_M1_g VSS VSS nmos_rvt L=2e-08 W=8.1e-08 nfin=3 $X=0.125 $Y=0.027
M2 N_M2_d N_M2_g VSS VSS nmos_rvt L=2e-08 W=5.4e-08 nfin=2 $X=0.179 $Y=0.027
M3 noxref_8 N_M3_g noxref_9 VSS nmos_rvt L=2e-08 W=8.1e-08 nfin=3 $X=0.395
+ $Y=0.027
M4 noxref_8 N_M4_g noxref_9 VSS nmos_rvt L=2e-08 W=8.1e-08 nfin=3 $X=0.449
+ $Y=0.027
M5 N_M5_d N_M5_g noxref_9 VSS nmos_rvt L=2e-08 W=8.1e-08 nfin=3 $X=0.503
+ $Y=0.027
M6 N_M6_d N_M6_g noxref_9 VSS nmos_rvt L=2e-08 W=8.1e-08 nfin=3 $X=0.557
+ $Y=0.027
M7 VDD N_M7_g noxref_7 VDD pmos_rvt L=2e-08 W=8.1e-08 nfin=3 $X=0.071 $Y=0.162
M8 VDD N_M8_g noxref_7 VDD pmos_rvt L=2e-08 W=8.1e-08 nfin=3 $X=0.125 $Y=0.162
M9 N_M9_d N_M9_g noxref_7 VDD pmos_rvt L=2e-08 W=8.1e-08 nfin=3 $X=0.179
+ $Y=0.162
M10 N_M10_d N_M10_g noxref_7 VDD pmos_rvt L=2e-08 W=8.1e-08 nfin=3 $X=0.233
+ $Y=0.162
M11 noxref_7 N_M11_g VDD VDD pmos_rvt L=2e-08 W=8.1e-08 nfin=3 $X=0.395 $Y=0.162
M12 noxref_7 N_M12_g VDD VDD pmos_rvt L=2e-08 W=8.1e-08 nfin=3 $X=0.449 $Y=0.162
M13 noxref_7 N_M13_g VDD VDD pmos_rvt L=2e-08 W=8.1e-08 nfin=3 $X=0.503 $Y=0.162
M14 noxref_7 N_M14_g VDD VDD pmos_rvt L=2e-08 W=8.1e-08 nfin=3 $X=0.557 $Y=0.162

* .include "AOI31xp67_ASAP7_75t_R.pex.sp.pxi"

* Start of included file AOI31xp67_ASAP7_75t_R.pex.sp.pxi
x_PM_AOI31xp67_ASAP7_75t_R%A3 vss A3 N_M0_g N_M7_g N_M1_g N_M8_g N_A3_4 N_A3_10
+ PM_AOI31xp67_ASAP7_75t_R%A3
x_PM_AOI31xp67_ASAP7_75t_R%A2 vss A2 N_M3_g N_M11_g N_M4_g N_M12_g N_A2_4
+ N_A2_8 N_A2_6 PM_AOI31xp67_ASAP7_75t_R%A2
x_PM_AOI31xp67_ASAP7_75t_R%Y vss Y N_M2_d N_M10_d N_M9_d N_M5_d N_M6_d N_Y_17
+ N_Y_16 N_Y_2 N_Y_13 N_Y_1 N_Y_20 N_Y_15 N_Y_21 N_Y_24 N_Y_22 N_Y_3 N_Y_4
+ N_Y_14 N_Y_18 PM_AOI31xp67_ASAP7_75t_R%Y
cc_1 N_Y_17 N_B_3 0.000540737f $X=0.243 $Y=0.198
cc_2 N_Y_16 N_B_3 0.000633368f $X=0.2025 $Y=0.072
cc_3 N_Y_2 N_B_3 0.00228758f $X=0.216 $Y=0.2025
cc_4 N_Y_13 N_B_3 0.00858351f $X=0.2015 $Y=0.054
cc_5 N_Y_1 N_B_4 0.000920515f $X=0.216 $Y=0.054
cc_6 N_Y_20 N_B_10 0.00316641f $X=0.243 $Y=0.1035
cc_7 N_Y_15 N_B_1 0.00352632f $X=0.2015 $Y=0.2025
cc_8 N_Y_13 N_B_4 0.014532f $X=0.2015 $Y=0.054
cc_9 N_Y_15 N_B_4 0.0510995f $X=0.2015 $Y=0.2025
cc_10 N_Y_15 N_B_3 0.0453711f $X=0.2015 $Y=0.2025
cc_11 N_Y_20 N_A2_8 0.000957012f $X=0.243 $Y=0.1035
cc_12 N_Y_21 N_A2_6 0.00143123f $X=0.27 $Y=0.198
cc_13 N_Y_20 N_A2_6 0.00204337f $X=0.243 $Y=0.1035
cc_14 N_Y_21 N_A2_8 0.00640319f $X=0.27 $Y=0.198
cc_15 N_Y_24 N_A1_4 0.000746652f $X=0.621 $Y=0.234
cc_16 N_Y_22 N_A1_4 0.000803825f $X=0.6235 $Y=0.036
cc_17 N_Y_21 N_A1_1 0.00113972f $X=0.27 $Y=0.198
cc_18 N_Y_3 N_A1_3 0.00153506f $X=0.54 $Y=0.0675
cc_19 N_Y_4 N_A1_7 0.00161595f $X=0.648 $Y=0.1935
cc_20 N_Y_4 N_A1_8 0.00179576f $X=0.648 $Y=0.1935
cc_21 N_Y_14 N_A1_1 0.00261883f $X=0.5255 $Y=0.0675
cc_22 N_Y_18 N_A1_6 0.00294884f $X=0.594 $Y=0.1945
cc_23 N_Y_4 N_A1_6 0.00312151f $X=0.648 $Y=0.1935
cc_24 N_Y_14 N_A1_3 0.0369609f $X=0.5255 $Y=0.0675
cc_25 N_Y_14 N_A1_4 0.0312697f $X=0.5255 $Y=0.0675
x_PM_AOI31xp67_ASAP7_75t_R%A1 vss A1 N_M5_g N_M13_g N_M6_g N_M14_g N_A1_3
+ N_A1_4 N_A1_1 N_A1_7 N_A1_8 N_A1_6 PM_AOI31xp67_ASAP7_75t_R%A1
cc_26 N_A1_3 N_A2_4 0.00466796f $X=0.513 $Y=0.0245
x_PM_AOI31xp67_ASAP7_75t_R%B vss B N_M10_g N_M2_g N_M9_g N_B_8 N_B_7 N_B_3
+ N_B_4 N_B_10 N_B_1 PM_AOI31xp67_ASAP7_75t_R%B
cc_27 N_B_8 N_A3_4 0.000709191f $X=0.135 $Y=0.1035
cc_28 N_B_7 N_A3_4 0.00151667f $X=0.135 $Y=0.135
cc_29 N_B_7 N_A3_10 0.00181315f $X=0.135 $Y=0.135
cc_30 N_B_3 N_A3_4 0.00717941f $X=0.189 $Y=0.135

* End of included file AOI31xp67_ASAP7_75t_R.pex.sp.pxi
.ends

.subckt PM_AO21x1_ASAP7_75t_R%A1 vss 17 9 15 8 3
c1 1 vss 0.00491909f $X=0.081 $Y=0.135
c2 3 vss 0.105066f $X=0.081 $Y=0.0245
c3 4 vss 0.0012752f $X=0.027 $Y=0.135
c4 5 vss 0.00647551f $X=0.027 $Y=0.198
c5 6 vss 0.0106903f $X=0.027 $Y=0.098
c6 7 vss 0.00367652f $X=0.027 $Y=0.154
c7 8 vss 0.0028125f $X=0.0635 $Y=0.135
r1 5 23 3.83327 $w=1.5093e-08 $l=2.15e-08 $layer=M1 $thickness=3.6e-08 $X=0.027
+ $Y=0.198 $X2=0.027 $Y2=0.1765
r2 7 23 5.24677 $w=1.3e-08 $l=2.25e-08 $layer=M1 $thickness=3.6e-08 $X=0.027
+ $Y=0.154 $X2=0.027 $Y2=0.1765
r3 4 19 3.1337 $w=1.54324e-08 $l=1.85e-08 $layer=M1 $thickness=3.6e-08 $X=0.027
+ $Y=0.135 $X2=0.0455 $Y2=0.135
r4 4 6 7.44771 $w=1.42162e-08 $l=3.7e-08 $layer=M1 $thickness=3.6e-08 $X=0.027
+ $Y=0.135 $X2=0.027 $Y2=0.098
r5 4 7 3.2503 $w=1.53684e-08 $l=1.9e-08 $layer=M1 $thickness=3.6e-08 $X=0.027
+ $Y=0.135 $X2=0.027 $Y2=0.154
r6 17 8 4.08082 $w=1.3e-08 $l=1.75e-08 $layer=M1 $thickness=3.6e-08 $X=0.0795
+ $Y=0.1355 $X2=0.0635 $Y2=0.135
r7 8 19 4.19742 $w=1.3e-08 $l=1.8e-08 $layer=M1 $thickness=3.6e-08 $X=0.0635
+ $Y=0.135 $X2=0.0455 $Y2=0.135
r8 1 12 10.4265 $w=1.765e-08 $layer=LIG $thickness=5.2e-08 $X=0.081 $Y=0.135
+ $X2=0.081 $Y2=0.135
r9 17 1 19.3796 $a=3.24e-16 $layer=V0LIG $X=0.0795 $Y=0.1355 $X2=0.081 $Y2=0.135
r10 15 14 14.6259 $w=2.1e-08 $l=4.3e-08 $layer=Gate_1 $thickness=5.6e-08
+ $X=0.081 $Y=0.2025 $X2=0.081 $Y2=0.1595
r11 13 14 2.7211 $w=2.1e-08 $l=8e-09 $layer=Gate_1 $thickness=5.6e-08 $X=0.081
+ $Y=0.1515 $X2=0.081 $Y2=0.1595
r12 12 13 5.79936 $w=2.03333e-08 $l=1.65e-08 $layer=Gate_1 $thickness=5.6e-08
+ $X=0.081 $Y=0.135 $X2=0.081 $Y2=0.1515
r13 11 12 5.79936 $w=2.03333e-08 $l=1.65e-08 $layer=Gate_1 $thickness=5.6e-08
+ $X=0.081 $Y=0.1185 $X2=0.081 $Y2=0.135
r14 10 11 2.7211 $w=2.1e-08 $l=8e-09 $layer=Gate_1 $thickness=5.6e-08 $X=0.081
+ $Y=0.1105 $X2=0.081 $Y2=0.1185
r15 9 10 14.6259 $w=2.1e-08 $l=4.3e-08 $layer=Gate_1 $thickness=5.6e-08
+ $X=0.081 $Y=0.0675 $X2=0.081 $Y2=0.1105
r16 9 3 14.6259 $w=2.1e-08 $l=4.3e-08 $layer=Gate_1 $thickness=5.6e-08 $X=0.081
+ $Y=0.0675 $X2=0.081 $Y2=0.0245
.ends

.subckt PM_AO21x1_ASAP7_75t_R%A2 vss 4 5 9 3 1
c1 1 vss 0.00669938f $X=0.135 $Y=0.135
c2 3 vss 0.0648512f $X=0.135 $Y=0.0245
c3 4 vss 0.00504795f $X=0.1315 $Y=0.1355
r1 1 7 10.4265 $w=1.765e-08 $layer=LIG $thickness=5.2e-08 $X=0.135 $Y=0.135
+ $X2=0.135 $Y2=0.135
r2 4 1 19.3796 $a=3.24e-16 $layer=V0LIG $X=0.1315 $Y=0.1355 $X2=0.135 $Y2=0.135
r3 9 8 16.4967 $w=2.1e-08 $l=4.85e-08 $layer=Gate_1 $thickness=5.6e-08 $X=0.135
+ $Y=0.2025 $X2=0.135 $Y2=0.154
r4 7 8 6.6497 $w=2.04211e-08 $l=1.9e-08 $layer=Gate_1 $thickness=5.6e-08
+ $X=0.135 $Y=0.135 $X2=0.135 $Y2=0.154
r5 6 7 6.6497 $w=2.04211e-08 $l=1.9e-08 $layer=Gate_1 $thickness=5.6e-08
+ $X=0.135 $Y=0.116 $X2=0.135 $Y2=0.135
r6 5 6 16.4967 $w=2.1e-08 $l=4.85e-08 $layer=Gate_1 $thickness=5.6e-08 $X=0.135
+ $Y=0.0675 $X2=0.135 $Y2=0.116
r7 5 3 14.6259 $w=2.1e-08 $l=4.3e-08 $layer=Gate_1 $thickness=5.6e-08 $X=0.135
+ $Y=0.0675 $X2=0.135 $Y2=0.0245
.ends

.subckt PM_AO21x1_ASAP7_75t_R%6 vss 17 23 46 47 50 51 3 14 11 4 10 15 9 16 12 1
+ 13
c1 1 vss 0.00342735f $X=0.243 $Y=0.135
c2 3 vss 0.0097952f $X=0.108 $Y=0.2025
c3 4 vss 0.0076954f $X=0.162 $Y=0.0675
c4 9 vss 0.0808649f $X=0.243 $Y=0.0245
c5 10 vss 0.0040317f $X=0.1475 $Y=0.0675
c6 11 vss 0.00510301f $X=0.0935 $Y=0.2025
c7 12 vss 0.00278361f $X=0.243 $Y=0.0415
c8 13 vss 0.000740617f $X=0.243 $Y=0.198
c9 14 vss 0.0110612f $X=0.232 $Y=0.198
c10 15 vss 0.00845075f $X=0.216 $Y=0.036
c11 16 vss 0.00282971f $X=0.243 $Y=0.098
r1 51 49 0.0308642 $w=8.1e-08 $l=2.5e-09 $layer=P_src_drn $thickness=1e-09
+ $X=0.1253 $Y=0.2025 $X2=0.1225 $Y2=0.2025
r2 3 49 0.179012 $w=8.1e-08 $l=1.45e-08 $layer=P_src_drn $thickness=1e-09
+ $X=0.108 $Y=0.2025 $X2=0.1225 $Y2=0.2025
r3 11 3 0.179012 $w=8.1e-08 $l=1.45e-08 $layer=P_src_drn $thickness=1e-09
+ $X=0.0935 $Y=0.2025 $X2=0.108 $Y2=0.2025
r4 50 11 0.0308642 $w=8.1e-08 $l=2.5e-09 $layer=P_src_drn $thickness=1e-09
+ $X=0.0906 $Y=0.2025 $X2=0.0935 $Y2=0.2025
r5 47 45 0.0308642 $w=8.1e-08 $l=2.5e-09 $layer=N_src_drn $thickness=1e-09
+ $X=0.1793 $Y=0.0675 $X2=0.1765 $Y2=0.0675
r6 4 45 0.179012 $w=8.1e-08 $l=1.45e-08 $layer=N_src_drn $thickness=1e-09
+ $X=0.162 $Y=0.0675 $X2=0.1765 $Y2=0.0675
r7 10 4 0.179012 $w=8.1e-08 $l=1.45e-08 $layer=N_src_drn $thickness=1e-09
+ $X=0.1475 $Y=0.0675 $X2=0.162 $Y2=0.0675
r8 46 10 0.0308642 $w=8.1e-08 $l=2.5e-09 $layer=N_src_drn $thickness=1e-09
+ $X=0.1446 $Y=0.0675 $X2=0.1475 $Y2=0.0675
r9 3 41 19.3796 $a=3.24e-16 $layer=V0LISD $X=0.108 $Y=0.2025 $X2=0.108 $Y2=0.198
r10 4 32 19.3796 $a=3.24e-16 $layer=V0LISD $X=0.162 $Y=0.0675 $X2=0.162
+ $Y2=0.036
r11 41 42 3.14806 $w=1.3e-08 $l=1.35e-08 $layer=M1 $thickness=3.6e-08 $X=0.108
+ $Y=0.198 $X2=0.1215 $Y2=0.198
r12 39 42 3.14806 $w=1.3e-08 $l=1.35e-08 $layer=M1 $thickness=3.6e-08 $X=0.135
+ $Y=0.198 $X2=0.1215 $Y2=0.198
r13 38 39 2.56509 $w=1.3e-08 $l=1.1e-08 $layer=M1 $thickness=3.6e-08 $X=0.146
+ $Y=0.198 $X2=0.135 $Y2=0.198
r14 37 38 3.73104 $w=1.3e-08 $l=1.6e-08 $layer=M1 $thickness=3.6e-08 $X=0.162
+ $Y=0.198 $X2=0.146 $Y2=0.198
r15 36 37 3.73104 $w=1.3e-08 $l=1.6e-08 $layer=M1 $thickness=3.6e-08 $X=0.178
+ $Y=0.198 $X2=0.162 $Y2=0.198
r16 35 36 2.56509 $w=1.3e-08 $l=1.1e-08 $layer=M1 $thickness=3.6e-08 $X=0.189
+ $Y=0.198 $X2=0.178 $Y2=0.198
r17 34 35 5.82974 $w=1.3e-08 $l=2.5e-08 $layer=M1 $thickness=3.6e-08 $X=0.214
+ $Y=0.198 $X2=0.189 $Y2=0.198
r18 14 34 4.19742 $w=1.3e-08 $l=1.8e-08 $layer=M1 $thickness=3.6e-08 $X=0.232
+ $Y=0.198 $X2=0.214 $Y2=0.198
r19 32 33 3.14806 $w=1.3e-08 $l=1.35e-08 $layer=M1 $thickness=3.6e-08 $X=0.162
+ $Y=0.036 $X2=0.1755 $Y2=0.036
r20 30 33 3.14806 $w=1.3e-08 $l=1.35e-08 $layer=M1 $thickness=3.6e-08 $X=0.189
+ $Y=0.036 $X2=0.1755 $Y2=0.036
r21 15 30 6.29612 $w=1.3e-08 $l=2.7e-08 $layer=M1 $thickness=3.6e-08 $X=0.216
+ $Y=0.036 $X2=0.189 $Y2=0.036
r22 13 28 3.36447 $w=1.71023e-08 $l=2.15e-08 $layer=M1 $thickness=3.6e-08
+ $X=0.243 $Y=0.198 $X2=0.243 $Y2=0.1765
r23 13 14 0.915974 $w=1.70909e-08 $l=1.1e-08 $layer=M1 $thickness=3.6e-08
+ $X=0.243 $Y=0.198 $X2=0.232 $Y2=0.198
r24 12 27 3.27203 $w=1.40938e-08 $l=1.6e-08 $layer=M1 $thickness=3.6e-08
+ $X=0.243 $Y=0.0415 $X2=0.243 $Y2=0.0575
r25 12 15 4.55457 $w=1.3814e-08 $l=2.75545e-08 $layer=M1 $thickness=3.6e-08
+ $X=0.243 $Y=0.0415 $X2=0.216 $Y2=0.036
r26 26 28 5.24677 $w=1.3e-08 $l=2.25e-08 $layer=M1 $thickness=3.6e-08 $X=0.243
+ $Y=0.154 $X2=0.243 $Y2=0.1765
r27 25 26 4.4306 $w=1.3e-08 $l=1.9e-08 $layer=M1 $thickness=3.6e-08 $X=0.243
+ $Y=0.135 $X2=0.243 $Y2=0.154
r28 16 25 8.62802 $w=1.3e-08 $l=3.7e-08 $layer=M1 $thickness=3.6e-08 $X=0.243
+ $Y=0.098 $X2=0.243 $Y2=0.135
r29 16 27 9.44418 $w=1.3e-08 $l=4.05e-08 $layer=M1 $thickness=3.6e-08 $X=0.243
+ $Y=0.098 $X2=0.243 $Y2=0.0575
r30 1 20 10.4265 $w=1.765e-08 $layer=LIG $thickness=5.2e-08 $X=0.243 $Y=0.135
+ $X2=0.243 $Y2=0.135
r31 1 25 19.3796 $a=3.24e-16 $layer=V0LIG $X=0.243 $Y=0.135 $X2=0.243 $Y2=0.135
r32 23 22 14.6259 $w=2.1e-08 $l=4.3e-08 $layer=Gate_1 $thickness=5.6e-08
+ $X=0.243 $Y=0.2025 $X2=0.243 $Y2=0.1595
r33 21 22 2.7211 $w=2.1e-08 $l=8e-09 $layer=Gate_1 $thickness=5.6e-08 $X=0.243
+ $Y=0.1515 $X2=0.243 $Y2=0.1595
r34 20 21 5.79936 $w=2.03333e-08 $l=1.65e-08 $layer=Gate_1 $thickness=5.6e-08
+ $X=0.243 $Y=0.135 $X2=0.243 $Y2=0.1515
r35 19 20 5.79936 $w=2.03333e-08 $l=1.65e-08 $layer=Gate_1 $thickness=5.6e-08
+ $X=0.243 $Y=0.1185 $X2=0.243 $Y2=0.135
r36 18 19 2.7211 $w=2.1e-08 $l=8e-09 $layer=Gate_1 $thickness=5.6e-08 $X=0.243
+ $Y=0.1105 $X2=0.243 $Y2=0.1185
r37 17 18 14.6259 $w=2.1e-08 $l=4.3e-08 $layer=Gate_1 $thickness=5.6e-08
+ $X=0.243 $Y=0.0675 $X2=0.243 $Y2=0.1105
r38 17 9 14.6259 $w=2.1e-08 $l=4.3e-08 $layer=Gate_1 $thickness=5.6e-08
+ $X=0.243 $Y=0.0675 $X2=0.243 $Y2=0.0245
.ends

.subckt PM_AO21x1_ASAP7_75t_R%B vss 11 5 9 3 4 1
c1 1 vss 0.00780272f $X=0.189 $Y=0.135
c2 3 vss 0.119737f $X=0.189 $Y=0.0245
c3 4 vss 0.00411488f $X=0.189 $Y=0.098
r1 11 4 8.62802 $w=1.3e-08 $l=3.7e-08 $layer=M1 $thickness=3.6e-08 $X=0.1865
+ $Y=0.1355 $X2=0.189 $Y2=0.098
r2 1 7 10.4265 $w=1.765e-08 $layer=LIG $thickness=5.2e-08 $X=0.189 $Y=0.135
+ $X2=0.189 $Y2=0.135
r3 11 1 19.3796 $a=3.24e-16 $layer=V0LIG $X=0.1865 $Y=0.1355 $X2=0.189 $Y2=0.135
r4 9 8 16.4967 $w=2.1e-08 $l=4.85e-08 $layer=Gate_1 $thickness=5.6e-08 $X=0.189
+ $Y=0.2025 $X2=0.189 $Y2=0.154
r5 7 8 6.6497 $w=2.04211e-08 $l=1.9e-08 $layer=Gate_1 $thickness=5.6e-08
+ $X=0.189 $Y=0.135 $X2=0.189 $Y2=0.154
r6 6 7 6.6497 $w=2.04211e-08 $l=1.9e-08 $layer=Gate_1 $thickness=5.6e-08
+ $X=0.189 $Y=0.116 $X2=0.189 $Y2=0.135
r7 5 6 16.4967 $w=2.1e-08 $l=4.85e-08 $layer=Gate_1 $thickness=5.6e-08 $X=0.189
+ $Y=0.0675 $X2=0.189 $Y2=0.116
r8 5 3 14.6259 $w=2.1e-08 $l=4.3e-08 $layer=Gate_1 $thickness=5.6e-08 $X=0.189
+ $Y=0.0675 $X2=0.189 $Y2=0.0245
.ends

.subckt PM_AO21x1_ASAP7_75t_R%Y vss 16 13 22 7 10 8 11
c1 1 vss 0.0112363f $X=0.2765 $Y=0.0675
c2 2 vss 0.0103116f $X=0.2765 $Y=0.2025
c3 7 vss 0.0373978f $X=0.2555 $Y=0.0675
c4 8 vss 0.0373948f $X=0.2555 $Y=0.2025
c5 9 vss 0.00284206f $X=0.286 $Y=0.234
c6 10 vss 0.00543884f $X=0.2645 $Y=0.234
c7 11 vss 0.00596451f $X=0.286 $Y=0.0415
r1 8 2 0.154321 $w=8.1e-08 $l=1.25e-08 $layer=P_src_drn $thickness=1e-09
+ $X=0.2555 $Y=0.2025 $X2=0.2765 $Y2=0.2025
r2 22 8 0.0308642 $w=8.1e-08 $l=2.5e-09 $layer=P_src_drn $thickness=1e-09
+ $X=0.2526 $Y=0.2025 $X2=0.2555 $Y2=0.2025
r3 9 20 2.08192 $w=1.85125e-08 $l=1.6e-08 $layer=M1 $thickness=3.6e-08 $X=0.286
+ $Y=0.234 $X2=0.286 $Y2=0.218
r4 9 10 3.36447 $w=1.5093e-08 $l=2.15e-08 $layer=M1 $thickness=3.6e-08 $X=0.286
+ $Y=0.234 $X2=0.2645 $Y2=0.234
r5 2 18 19.3796 $a=3.24e-16 $layer=V0LISD $X=0.2765 $Y=0.2025 $X2=0.286 $Y2=0.2
r6 19 20 2.09871 $w=1.3e-08 $l=9e-09 $layer=M1 $thickness=3.6e-08 $X=0.286
+ $Y=0.209 $X2=0.286 $Y2=0.218
r7 18 19 2.09871 $w=1.3e-08 $l=9e-09 $layer=M1 $thickness=3.6e-08 $X=0.286
+ $Y=0.2 $X2=0.286 $Y2=0.209
r8 17 18 10.7267 $w=1.3e-08 $l=4.6e-08 $layer=M1 $thickness=3.6e-08 $X=0.286
+ $Y=0.154 $X2=0.286 $Y2=0.2
r9 16 17 9.211 $w=1.3e-08 $l=3.95e-08 $layer=M1 $thickness=3.6e-08 $X=0.2835
+ $Y=0.1145 $X2=0.286 $Y2=0.154
r10 16 15 6.06293 $w=1.3e-08 $l=2.6e-08 $layer=M1 $thickness=3.6e-08 $X=0.2835
+ $Y=0.1145 $X2=0.286 $Y2=0.0885
r11 14 15 8.04505 $w=1.3e-08 $l=3.45e-08 $layer=M1 $thickness=3.6e-08 $X=0.286
+ $Y=0.054 $X2=0.286 $Y2=0.0885
r12 11 14 2.91487 $w=1.3e-08 $l=1.25e-08 $layer=M1 $thickness=3.6e-08 $X=0.286
+ $Y=0.0415 $X2=0.286 $Y2=0.054
r13 1 14 19.3796 $a=3.24e-16 $layer=V0LISD $X=0.2765 $Y=0.0675 $X2=0.286
+ $Y2=0.054
r14 7 1 0.154321 $w=8.1e-08 $l=1.25e-08 $layer=N_src_drn $thickness=1e-09
+ $X=0.2555 $Y=0.0675 $X2=0.2765 $Y2=0.0675
r15 13 7 0.0308642 $w=8.1e-08 $l=2.5e-09 $layer=N_src_drn $thickness=1e-09
+ $X=0.2526 $Y=0.0675 $X2=0.2555 $Y2=0.0675
.ends

* End of included file AO21x1_ASAP7_75t_R.pex.sp.pex

*
.subckt AO21x1_ASAP7_75t_CUSTOM_4_25_0_7 VSS VDD A1 A2 B Y
*
* VSS VSS
* VDD VDD
* A1 A1
* A2 A2
* B B
* Y Y
*
*

M0 noxref_9 N_M0_g VSS VSS nmos_rvt L=2e-08 W=8.1e-08 nfin=3 $X=0.071 $Y=0.027
M1 N_M1_d N_M1_g noxref_9 VSS nmos_rvt L=2e-08 W=8.1e-08 nfin=3 $X=0.125
+ $Y=0.027
M2 VSS N_M2_g N_M2_s VSS nmos_rvt L=2e-08 W=8.1e-08 nfin=3 $X=0.179 $Y=0.027
M3 N_M3_d N_M3_g VSS VSS nmos_rvt L=2e-08 W=8.1e-08 nfin=3 $X=0.233 $Y=0.027
M4 N_M4_d N_M4_g noxref_7 VDD pmos_rvt L=2e-08 W=8.1e-08 nfin=3 $X=0.071
+ $Y=0.162
M5 noxref_7 N_M5_g N_M5_s VDD pmos_rvt L=2e-08 W=8.1e-08 nfin=3 $X=0.125
+ $Y=0.162
M6 VDD N_M6_g noxref_7 VDD pmos_rvt L=2e-08 W=8.1e-08 nfin=3 $X=0.179 $Y=0.162
M7 N_M7_d N_M7_g VDD VDD pmos_rvt L=2e-08 W=8.1e-08 nfin=3 $X=0.233 $Y=0.162

* .include "AO21x1_ASAP7_75t_R.pex.sp.pxi"

* Start of included file AO21x1_ASAP7_75t_R.pex.sp.pxi
x_PM_AO21x1_ASAP7_75t_R%A1 vss A1 N_M0_g N_M4_g N_A1_8 N_A1_3
+ PM_AO21x1_ASAP7_75t_R%A1
x_PM_AO21x1_ASAP7_75t_R%A2 vss A2 N_M1_g N_M5_g N_A2_3 N_A2_1
+ PM_AO21x1_ASAP7_75t_R%A2
cc_1 A2 N_A1_8 0.00228738f $X=0.1315 $Y=0.1355
cc_2 N_A2_3 N_A1_3 0.00741218f $X=0.135 $Y=0.0245
x_PM_AO21x1_ASAP7_75t_R%6 vss N_M3_g N_M7_g N_M1_d N_M2_s N_M4_d N_M5_s N_6_3
+ N_6_14 N_6_11 N_6_4 N_6_10 N_6_15 N_6_9 N_6_16 N_6_12 N_6_1 N_6_13
+ PM_AO21x1_ASAP7_75t_R%6
cc_3 N_6_3 N_A1_3 0.000828233f $X=0.108 $Y=0.2025
cc_4 N_6_14 N_A1_8 0.00128947f $X=0.232 $Y=0.198
cc_5 N_6_11 N_A1_3 0.0373852f $X=0.0935 $Y=0.2025
cc_6 N_6_3 N_A2_3 0.00138331f $X=0.108 $Y=0.2025
cc_7 N_6_14 A2 0.00112616f $X=0.232 $Y=0.198
cc_8 N_6_4 N_A2_3 0.00137638f $X=0.162 $Y=0.0675
cc_9 N_6_11 N_A2_1 0.00145834f $X=0.0935 $Y=0.2025
cc_10 N_6_4 A2 0.00242462f $X=0.162 $Y=0.0675
cc_11 N_6_10 N_A2_3 0.0149229f $X=0.1475 $Y=0.0675
cc_12 N_6_11 N_A2_3 0.0553699f $X=0.0935 $Y=0.2025
cc_13 N_6_4 N_B_3 0.00180399f $X=0.162 $Y=0.0675
cc_14 N_6_15 N_B_3 0.000938042f $X=0.216 $Y=0.036
cc_15 N_6_14 N_B_4 0.00112095f $X=0.232 $Y=0.198
cc_16 N_6_10 N_B_1 0.00124828f $X=0.1475 $Y=0.0675
cc_17 N_6_9 N_B_3 0.00165304f $X=0.243 $Y=0.0245
cc_18 N_6_16 N_B_4 0.0060315f $X=0.243 $Y=0.098
cc_19 N_6_10 N_B_3 0.0369481f $X=0.1475 $Y=0.0675
x_PM_AO21x1_ASAP7_75t_R%B vss B N_M2_g N_M6_g N_B_3 N_B_4 N_B_1
+ PM_AO21x1_ASAP7_75t_R%B
cc_20 N_B_3 N_A2_3 0.0031636f $X=0.189 $Y=0.0245
cc_21 N_B_4 A2 0.00497128f $X=0.189 $Y=0.098
x_PM_AO21x1_ASAP7_75t_R%Y vss Y N_M3_d N_M7_d N_Y_7 N_Y_10 N_Y_8 N_Y_11
+ PM_AO21x1_ASAP7_75t_R%Y
cc_22 N_Y_7 N_6_12 0.000603859f $X=0.2555 $Y=0.0675
cc_23 N_Y_7 N_6_1 0.00249116f $X=0.2555 $Y=0.0675
cc_24 N_Y_7 N_6_14 0.000836902f $X=0.2555 $Y=0.0675
cc_25 N_Y_10 N_6_13 0.00279288f $X=0.2645 $Y=0.234
cc_26 N_Y_8 N_6_9 0.0148543f $X=0.2555 $Y=0.2025
cc_27 N_Y_11 N_6_16 0.00897648f $X=0.286 $Y=0.0415
cc_28 N_Y_7 N_6_9 0.0577593f $X=0.2555 $Y=0.0675

* End of included file AO21x1_ASAP7_75t_R.pex.sp.pxi
.ends

.subckt PM_AOI21x1_ASAP7_75t_R%A2 vss 5 7 11 21 24 4 6 1 3
c1 1 vss 0.0132363f $X=0.189 $Y=0.135
c2 3 vss 0.137123f $X=0.189 $Y=0.0245
c3 4 vss 0.137108f $X=0.243 $Y=0.135
c4 5 vss 0.0038462f $X=0.2085 $Y=0.1355
c5 6 vss 0.000708628f $X=0.229 $Y=0.134
r1 5 6 0.763861 $w=3.26364e-08 $l=2.05e-08 $layer=M1 $thickness=3.6e-08
+ $X=0.2085 $Y=0.1355 $X2=0.229 $Y2=0.134
r2 6 26 2.56509 $w=1.3e-08 $l=1.1e-08 $layer=M1 $thickness=3.6e-08 $X=0.229
+ $Y=0.134 $X2=0.24 $Y2=0.134
r3 24 23 16.4967 $w=2.1e-08 $l=4.85e-08 $layer=Gate_1 $thickness=5.6e-08
+ $X=0.243 $Y=0.2025 $X2=0.243 $Y2=0.154
r4 21 22 16.4967 $w=2.1e-08 $l=4.85e-08 $layer=Gate_1 $thickness=5.6e-08
+ $X=0.243 $Y=0.0675 $X2=0.243 $Y2=0.116
r5 4 18 3.9286 $w=2e-08 $layer=Gate_1 $thickness=5.6e-08 $X=0.243 $Y=0.135
+ $X2=0.243 $Y2=0.135
r6 4 22 6.6497 $w=2.04211e-08 $l=1.9e-08 $layer=Gate_1 $thickness=5.6e-08
+ $X=0.243 $Y=0.135 $X2=0.243 $Y2=0.116
r7 4 23 6.6497 $w=2.04211e-08 $l=1.9e-08 $layer=Gate_1 $thickness=5.6e-08
+ $X=0.243 $Y=0.135 $X2=0.243 $Y2=0.154
r8 16 18 2.08928 $w=2.2e-08 $l=2e-09 $layer=LIG $thickness=4.8e-08 $X=0.241
+ $Y=0.135 $X2=0.243 $Y2=0.135
r9 16 26 19.3796 $a=3.24e-16 $layer=V0LIG $X=0.241 $Y=0.135 $X2=0.24 $Y2=0.134
r10 15 16 2.68 $w=2.12556e-08 $l=9e-09 $layer=LIG $thickness=4.8e-08 $X=0.232
+ $Y=0.135 $X2=0.241 $Y2=0.135
r11 14 15 10.0423 $w=1.53e-08 $l=1.7e-08 $layer=LIG $thickness=4.8e-08 $X=0.215
+ $Y=0.135 $X2=0.232 $Y2=0.135
r12 1 9 6.54019 $w=2.09524e-08 $layer=Gate_1 $thickness=5.21905e-08 $X=0.189
+ $Y=0.135 $X2=0.189 $Y2=0.135
r13 1 14 12.0632 $w=1.78769e-08 $l=2.6e-08 $layer=LIG $thickness=4.8e-08
+ $X=0.189 $Y=0.135 $X2=0.215 $Y2=0.135
r14 11 10 16.4967 $w=2.1e-08 $l=4.85e-08 $layer=Gate_1 $thickness=5.6e-08
+ $X=0.189 $Y=0.2025 $X2=0.189 $Y2=0.154
r15 9 10 6.6497 $w=2.04211e-08 $l=1.9e-08 $layer=Gate_1 $thickness=5.6e-08
+ $X=0.189 $Y=0.135 $X2=0.189 $Y2=0.154
r16 8 9 6.6497 $w=2.04211e-08 $l=1.9e-08 $layer=Gate_1 $thickness=5.6e-08
+ $X=0.189 $Y=0.116 $X2=0.189 $Y2=0.135
r17 7 8 16.4967 $w=2.1e-08 $l=4.85e-08 $layer=Gate_1 $thickness=5.6e-08
+ $X=0.189 $Y=0.0675 $X2=0.189 $Y2=0.116
r18 7 3 14.6259 $w=2.1e-08 $l=4.3e-08 $layer=Gate_1 $thickness=5.6e-08 $X=0.189
+ $Y=0.0675 $X2=0.189 $Y2=0.0245
.ends

.subckt PM_AOI21x1_ASAP7_75t_R%A1 vss 29 12 16 34 37 1 2 11 6 5 9 10 7 8
c1 1 vss 0.010686f $X=0.135 $Y=0.135
c2 2 vss 0.0106491f $X=0.297 $Y=0.135
c3 5 vss 0.0767894f $X=0.135 $Y=0.135
c4 6 vss 0.077237f $X=0.297 $Y=0.0245
c5 7 vss 0.00367763f $X=0.135 $Y=0.0665
c6 8 vss 0.00373918f $X=0.297 $Y=0.072
c7 9 vss 0.00465917f $X=0.135 $Y=0.09
c8 10 vss 0.0067245f $X=0.272 $Y=0.072
c9 11 vss 0.0048137f $X=0.297 $Y=0.134
r1 37 36 16.4967 $w=2.1e-08 $l=4.85e-08 $layer=Gate_1 $thickness=5.6e-08
+ $X=0.135 $Y=0.2025 $X2=0.135 $Y2=0.154
r2 34 35 16.4967 $w=2.1e-08 $l=4.85e-08 $layer=Gate_1 $thickness=5.6e-08
+ $X=0.135 $Y=0.0675 $X2=0.135 $Y2=0.116
r3 5 35 6.6497 $w=2.04211e-08 $l=1.9e-08 $layer=Gate_1 $thickness=5.6e-08
+ $X=0.135 $Y=0.135 $X2=0.135 $Y2=0.116
r4 5 36 6.6497 $w=2.04211e-08 $l=1.9e-08 $layer=Gate_1 $thickness=5.6e-08
+ $X=0.135 $Y=0.135 $X2=0.135 $Y2=0.154
r5 29 1 19.3796 $a=3.24e-16 $layer=V0LIG $X=0.1345 $Y=0.1355 $X2=0.135 $Y2=0.135
r6 1 5 6.54019 $w=2.09524e-08 $layer=Gate_1 $thickness=5.21905e-08 $X=0.135
+ $Y=0.135 $X2=0.135 $Y2=0.135
r7 29 28 5.13017 $w=1.3e-08 $l=2.2e-08 $layer=M1 $thickness=3.6e-08 $X=0.1345
+ $Y=0.1355 $X2=0.135 $Y2=0.112
r8 9 27 2.65995 $w=1.48966e-08 $l=1.45e-08 $layer=M1 $thickness=3.6e-08
+ $X=0.135 $Y=0.09 $X2=0.135 $Y2=0.0755
r9 9 28 5.13017 $w=1.3e-08 $l=2.2e-08 $layer=M1 $thickness=3.6e-08 $X=0.135
+ $Y=0.09 $X2=0.135 $Y2=0.112
r10 7 26 5.72052 $w=1.36604e-08 $l=3.24692e-08 $layer=M1 $thickness=3.6e-08
+ $X=0.135 $Y=0.0665 $X2=0.167 $Y2=0.072
r11 7 27 0.9184 $w=1.8e-08 $l=9e-09 $layer=M1 $thickness=3.6e-08 $X=0.135
+ $Y=0.0665 $X2=0.135 $Y2=0.0755
r12 25 26 9.67737 $w=1.3e-08 $l=4.15e-08 $layer=M1 $thickness=3.6e-08 $X=0.2085
+ $Y=0.072 $X2=0.167 $Y2=0.072
r13 24 25 7.69526 $w=1.3e-08 $l=3.3e-08 $layer=M1 $thickness=3.6e-08 $X=0.2415
+ $Y=0.072 $X2=0.2085 $Y2=0.072
r14 10 24 7.11229 $w=1.3e-08 $l=3.05e-08 $layer=M1 $thickness=3.6e-08 $X=0.272
+ $Y=0.072 $X2=0.2415 $Y2=0.072
r15 8 22 2.5483 $w=1.79e-08 $l=1.8e-08 $layer=M1 $thickness=3.6e-08 $X=0.297
+ $Y=0.072 $X2=0.297 $Y2=0.09
r16 8 10 4.18063 $w=1.48e-08 $l=2.5e-08 $layer=M1 $thickness=3.6e-08 $X=0.297
+ $Y=0.072 $X2=0.272 $Y2=0.072
r17 21 22 4.08082 $w=1.3e-08 $l=1.75e-08 $layer=M1 $thickness=3.6e-08 $X=0.297
+ $Y=0.1075 $X2=0.297 $Y2=0.09
r18 20 21 3.03147 $w=1.3e-08 $l=1.3e-08 $layer=M1 $thickness=3.6e-08 $X=0.297
+ $Y=0.1205 $X2=0.297 $Y2=0.1075
r19 11 20 3.14806 $w=1.3e-08 $l=1.35e-08 $layer=M1 $thickness=3.6e-08 $X=0.297
+ $Y=0.134 $X2=0.297 $Y2=0.1205
r20 2 14 6.54019 $w=2.09524e-08 $layer=Gate_1 $thickness=5.21905e-08 $X=0.297
+ $Y=0.135 $X2=0.297 $Y2=0.135
r21 2 11 19.3796 $a=3.24e-16 $layer=V0LIG $X=0.297 $Y=0.135 $X2=0.297 $Y2=0.134
r22 16 15 16.4967 $w=2.1e-08 $l=4.85e-08 $layer=Gate_1 $thickness=5.6e-08
+ $X=0.297 $Y=0.2025 $X2=0.297 $Y2=0.154
r23 14 15 6.6497 $w=2.04211e-08 $l=1.9e-08 $layer=Gate_1 $thickness=5.6e-08
+ $X=0.297 $Y=0.135 $X2=0.297 $Y2=0.154
r24 13 14 6.6497 $w=2.04211e-08 $l=1.9e-08 $layer=Gate_1 $thickness=5.6e-08
+ $X=0.297 $Y=0.116 $X2=0.297 $Y2=0.135
r25 12 13 16.4967 $w=2.1e-08 $l=4.85e-08 $layer=Gate_1 $thickness=5.6e-08
+ $X=0.297 $Y=0.0675 $X2=0.297 $Y2=0.116
r26 12 6 14.6259 $w=2.1e-08 $l=4.3e-08 $layer=Gate_1 $thickness=5.6e-08
+ $X=0.297 $Y=0.0675 $X2=0.297 $Y2=0.0245
.ends

.subckt PM_AOI21x1_ASAP7_75t_R%Y vss 52 29 32 56 59 71 73 19 3 2 26 1 4 22 23
+ 20 16 18 27 25 13 14
c1 1 vss 0.00870641f $X=0.054 $Y=0.2025
c2 2 vss 0.00669f $X=0.108 $Y=0.054
c3 3 vss 0.00689697f $X=0.324 $Y=0.054
c4 4 vss 0.00870641f $X=0.378 $Y=0.2025
c5 13 vss 0.00291181f $X=0.0935 $Y=0.0725
c6 14 vss 0.00269512f $X=0.3095 $Y=0.0725
c7 15 vss 0.000139663f $X=0.0935 $Y=0.0455
c8 16 vss 0.000298962f $X=0.11 $Y=0.0945
c9 17 vss 0.000139663f $X=0.3095 $Y=0.0455
c10 18 vss 0.000298962f $X=0.3095 $Y=0.0945
c11 19 vss 0.0366961f $X=0.056 $Y=0.2025
c12 20 vss 0.0366961f $X=0.3635 $Y=0.2025
c13 21 vss 0.00291052f $X=0.027 $Y=0.036
c14 22 vss 0.00532306f $X=0.027 $Y=0.234
c15 23 vss 0.00528353f $X=0.405 $Y=0.234
c16 24 vss 0.00282551f $X=0.405 $Y=0.036
c17 25 vss 0.0055865f $X=0.027 $Y=0.054
c18 26 vss 0.0303738f $X=0.0945 $Y=0.036
c19 27 vss 0.0055955f $X=0.405 $Y=0.054
r1 20 4 0.154321 $w=8.1e-08 $l=1.25e-08 $layer=P_src_drn $thickness=1e-09
+ $X=0.3635 $Y=0.2025 $X2=0.378 $Y2=0.2025
r2 73 20 0.0308642 $w=8.1e-08 $l=2.5e-09 $layer=P_src_drn $thickness=1e-09
+ $X=0.3606 $Y=0.2025 $X2=0.3635 $Y2=0.2025
r3 71 70 0.0308642 $w=8.1e-08 $l=2.5e-09 $layer=P_src_drn $thickness=1e-09
+ $X=0.0713 $Y=0.2025 $X2=0.0685 $Y2=0.2025
r4 19 70 0.154321 $w=8.1e-08 $l=1.25e-08 $layer=P_src_drn $thickness=1e-09
+ $X=0.056 $Y=0.2025 $X2=0.0685 $Y2=0.2025
r5 4 68 19.3796 $a=3.24e-16 $layer=V0LISD $X=0.378 $Y=0.2025 $X2=0.378 $Y2=0.234
r6 1 67 19.3796 $a=3.24e-16 $layer=V0LISD $X=0.054 $Y=0.2025 $X2=0.054 $Y2=0.234
r7 68 69 3.14806 $w=1.3e-08 $l=1.35e-08 $layer=M1 $thickness=3.6e-08 $X=0.378
+ $Y=0.234 $X2=0.3915 $Y2=0.234
r8 23 65 3.01711 $w=1.55e-08 $l=1.8e-08 $layer=M1 $thickness=3.6e-08 $X=0.405
+ $Y=0.234 $X2=0.405 $Y2=0.216
r9 23 69 1.96775 $w=1.63333e-08 $l=1.35e-08 $layer=M1 $thickness=3.6e-08
+ $X=0.405 $Y=0.234 $X2=0.3915 $Y2=0.234
r10 66 67 3.14806 $w=1.3e-08 $l=1.35e-08 $layer=M1 $thickness=3.6e-08 $X=0.0405
+ $Y=0.234 $X2=0.054 $Y2=0.234
r11 22 54 3.01711 $w=1.55e-08 $l=1.8e-08 $layer=M1 $thickness=3.6e-08 $X=0.027
+ $Y=0.234 $X2=0.027 $Y2=0.216
r12 22 66 1.96775 $w=1.63333e-08 $l=1.35e-08 $layer=M1 $thickness=3.6e-08
+ $X=0.027 $Y=0.234 $X2=0.0405 $Y2=0.234
r13 64 65 12.7088 $w=1.3e-08 $l=5.45e-08 $layer=M1 $thickness=3.6e-08 $X=0.405
+ $Y=0.1615 $X2=0.405 $Y2=0.216
r14 63 64 16.7897 $w=1.3e-08 $l=7.2e-08 $layer=M1 $thickness=3.6e-08 $X=0.405
+ $Y=0.0895 $X2=0.405 $Y2=0.1615
r15 27 63 8.27824 $w=1.3e-08 $l=3.55e-08 $layer=M1 $thickness=3.6e-08 $X=0.405
+ $Y=0.054 $X2=0.405 $Y2=0.0895
r16 18 3 0.462963 $w=2.7e-08 $l=1.25e-08 $layer=N_src_drn $thickness=1e-09
+ $X=0.3095 $Y=0.0945 $X2=0.324 $Y2=0.054
r17 17 3 0.391892 $w=3.7e-08 $l=1.45e-08 $layer=N_src_drn $thickness=1e-09
+ $X=0.3095 $Y=0.0455 $X2=0.324 $Y2=0.054
r18 59 58 0.147059 $w=1.7e-08 $l=2.5e-09 $layer=N_src_drn $thickness=1e-09
+ $X=0.3413 $Y=0.054 $X2=0.3385 $Y2=0.0725
r19 57 58 0.264706 $w=1.7e-08 $l=4.5e-09 $layer=N_src_drn $thickness=1e-09
+ $X=0.334 $Y=0.0725 $X2=0.3385 $Y2=0.0725
r20 3 57 0.705882 $w=1.7e-08 $l=1.2e-08 $layer=N_src_drn $thickness=1e-09
+ $X=0.324 $Y=0.054 $X2=0.334 $Y2=0.0725
r21 14 3 0.735294 $w=1.7e-08 $l=1.25e-08 $layer=N_src_drn $thickness=1e-09
+ $X=0.3095 $Y=0.0725 $X2=0.324 $Y2=0.054
r22 56 14 0.147059 $w=1.7e-08 $l=2.5e-09 $layer=N_src_drn $thickness=1e-09
+ $X=0.3066 $Y=0.0675 $X2=0.3095 $Y2=0.0725
r23 53 54 13.2335 $w=1.3e-08 $l=5.68e-08 $layer=M1 $thickness=3.6e-08 $X=0.027
+ $Y=0.1592 $X2=0.027 $Y2=0.216
r24 52 53 11.2514 $w=1.3e-08 $l=4.82e-08 $layer=M1 $thickness=3.6e-08 $X=0.025
+ $Y=0.111 $X2=0.027 $Y2=0.1592
r25 52 51 4.83869 $w=1.3e-08 $l=2.08e-08 $layer=M1 $thickness=3.6e-08 $X=0.025
+ $Y=0.111 $X2=0.027 $Y2=0.0902
r26 50 51 5.53826 $w=1.3e-08 $l=2.37e-08 $layer=M1 $thickness=3.6e-08 $X=0.027
+ $Y=0.0665 $X2=0.027 $Y2=0.0902
r27 25 50 2.91487 $w=1.3e-08 $l=1.25e-08 $layer=M1 $thickness=3.6e-08 $X=0.027
+ $Y=0.054 $X2=0.027 $Y2=0.0665
r28 24 48 3.59766 $w=1.5e-08 $l=2.25e-08 $layer=M1 $thickness=3.6e-08 $X=0.405
+ $Y=0.036 $X2=0.3825 $Y2=0.036
r29 24 27 2.5483 $w=1.79e-08 $l=1.8e-08 $layer=M1 $thickness=3.6e-08 $X=0.405
+ $Y=0.036 $X2=0.405 $Y2=0.054
r30 3 44 19.3796 $a=3.24e-16 $layer=V0LISD $X=0.324 $Y=0.054 $X2=0.324 $Y2=0.036
r31 21 41 3.59766 $w=1.5e-08 $l=2.25e-08 $layer=M1 $thickness=3.6e-08 $X=0.027
+ $Y=0.036 $X2=0.0495 $Y2=0.036
r32 21 25 2.5483 $w=1.79e-08 $l=1.8e-08 $layer=M1 $thickness=3.6e-08 $X=0.027
+ $Y=0.036 $X2=0.027 $Y2=0.054
r33 47 48 4.19742 $w=1.3e-08 $l=1.8e-08 $layer=M1 $thickness=3.6e-08 $X=0.3645
+ $Y=0.036 $X2=0.3825 $Y2=0.036
r34 46 47 3.14806 $w=1.3e-08 $l=1.35e-08 $layer=M1 $thickness=3.6e-08 $X=0.351
+ $Y=0.036 $X2=0.3645 $Y2=0.036
r35 45 46 3.14806 $w=1.3e-08 $l=1.35e-08 $layer=M1 $thickness=3.6e-08 $X=0.3375
+ $Y=0.036 $X2=0.351 $Y2=0.036
r36 44 45 3.14806 $w=1.3e-08 $l=1.35e-08 $layer=M1 $thickness=3.6e-08 $X=0.324
+ $Y=0.036 $X2=0.3375 $Y2=0.036
r37 43 44 3.14806 $w=1.3e-08 $l=1.35e-08 $layer=M1 $thickness=3.6e-08 $X=0.3105
+ $Y=0.036 $X2=0.324 $Y2=0.036
r38 42 43 22.0364 $w=1.3e-08 $l=9.45e-08 $layer=M1 $thickness=3.6e-08 $X=0.216
+ $Y=0.036 $X2=0.3105 $Y2=0.036
r39 40 41 4.19742 $w=1.3e-08 $l=1.8e-08 $layer=M1 $thickness=3.6e-08 $X=0.0675
+ $Y=0.036 $X2=0.0495 $Y2=0.036
r40 39 40 3.14806 $w=1.3e-08 $l=1.35e-08 $layer=M1 $thickness=3.6e-08 $X=0.081
+ $Y=0.036 $X2=0.0675 $Y2=0.036
r41 38 42 22.0364 $w=1.3e-08 $l=9.45e-08 $layer=M1 $thickness=3.6e-08 $X=0.1215
+ $Y=0.036 $X2=0.216 $Y2=0.036
r42 37 38 3.14806 $w=1.3e-08 $l=1.35e-08 $layer=M1 $thickness=3.6e-08 $X=0.108
+ $Y=0.036 $X2=0.1215 $Y2=0.036
r43 26 37 3.14806 $w=1.3e-08 $l=1.35e-08 $layer=M1 $thickness=3.6e-08 $X=0.0945
+ $Y=0.036 $X2=0.108 $Y2=0.036
r44 26 39 3.14806 $w=1.3e-08 $l=1.35e-08 $layer=M1 $thickness=3.6e-08 $X=0.0945
+ $Y=0.036 $X2=0.081 $Y2=0.036
r45 2 37 19.3796 $a=3.24e-16 $layer=V0LISD $X=0.108 $Y=0.054 $X2=0.108 $Y2=0.036
r46 16 2 0.958606 $w=2.2e-08 $l=2.2e-08 $layer=N_src_drn $thickness=1e-09
+ $X=0.11 $Y=0.0945 $X2=0.108 $Y2=0.054
r47 15 2 0.391892 $w=3.7e-08 $l=1.45e-08 $layer=N_src_drn $thickness=1e-09
+ $X=0.0935 $Y=0.0455 $X2=0.108 $Y2=0.054
r48 32 31 0.147059 $w=1.7e-08 $l=2.5e-09 $layer=N_src_drn $thickness=1e-09
+ $X=0.1253 $Y=0.0675 $X2=0.1225 $Y2=0.0725
r49 2 31 0.735294 $w=1.7e-08 $l=1.25e-08 $layer=N_src_drn $thickness=1e-09
+ $X=0.108 $Y=0.054 $X2=0.1225 $Y2=0.0725
r50 28 2 0.705882 $w=1.7e-08 $l=1.2e-08 $layer=N_src_drn $thickness=1e-09
+ $X=0.098 $Y=0.0725 $X2=0.108 $Y2=0.054
r51 13 28 0.264706 $w=1.7e-08 $l=4.5e-09 $layer=N_src_drn $thickness=1e-09
+ $X=0.0935 $Y=0.0725 $X2=0.098 $Y2=0.0725
r52 29 13 0.147059 $w=1.7e-08 $l=2.5e-09 $layer=N_src_drn $thickness=1e-09
+ $X=0.0906 $Y=0.054 $X2=0.0935 $Y2=0.0725
r53 13 15 0.214626 $w=2.7e-08 $l=2.7e-08 $layer=N_src_drn $thickness=1e-09
+ $X=0.0935 $Y=0.0725 $X2=0.0935 $Y2=0.0455
r54 1 19 1e-05 $l=2e-09 $X=0.054 $Y=0.2025 $X2=0.056 $Y2=0.2025
r55 2 16 1e-05 $l=4.05494e-08 $X=0.108 $Y=0.054 $X2=0.11 $Y2=0.0945
.ends

.subckt PM_AOI21x1_ASAP7_75t_R%B vss 22 12 18 43 47 1 2 10 6 5 11 9 7 8
c1 1 vss 0.00358574f $X=0.081 $Y=0.135
c2 2 vss 0.00358574f $X=0.351 $Y=0.135
c3 5 vss 0.0842662f $X=0.081 $Y=0.0245
c4 6 vss 0.0842106f $X=0.351 $Y=0.135
c5 7 vss 0.00154225f $X=0.081 $Y=0.198
c6 8 vss 0.00154225f $X=0.351 $Y=0.198
c7 9 vss 0.00694101f $X=0.081 $Y=0.0975
c8 10 vss 0.0288502f $X=0.0945 $Y=0.198
c9 11 vss 0.00452304f $X=0.351 $Y=0.18
r1 47 46 14.6259 $w=2.1e-08 $l=4.3e-08 $layer=Gate_1 $thickness=5.6e-08
+ $X=0.351 $Y=0.2025 $X2=0.351 $Y2=0.1595
r2 45 46 2.7211 $w=2.1e-08 $l=8e-09 $layer=Gate_1 $thickness=5.6e-08 $X=0.351
+ $Y=0.1515 $X2=0.351 $Y2=0.1595
r3 43 44 14.6259 $w=2.1e-08 $l=4.3e-08 $layer=Gate_1 $thickness=5.6e-08
+ $X=0.351 $Y=0.054 $X2=0.351 $Y2=0.097
r4 41 44 7.31297 $w=2.1e-08 $l=2.15e-08 $layer=Gate_1 $thickness=5.6e-08
+ $X=0.351 $Y=0.1185 $X2=0.351 $Y2=0.097
r5 6 41 5.79936 $w=2.03333e-08 $l=1.65e-08 $layer=Gate_1 $thickness=5.6e-08
+ $X=0.351 $Y=0.135 $X2=0.351 $Y2=0.1185
r6 6 45 5.79936 $w=2.03333e-08 $l=1.65e-08 $layer=Gate_1 $thickness=5.6e-08
+ $X=0.351 $Y=0.135 $X2=0.351 $Y2=0.1515
r7 2 37 19.3796 $a=3.24e-16 $layer=V0LIG $X=0.351 $Y=0.135 $X2=0.351 $Y2=0.134
r8 2 6 6.54019 $w=2.09524e-08 $layer=Gate_1 $thickness=5.21905e-08 $X=0.351
+ $Y=0.135 $X2=0.351 $Y2=0.135
r9 37 38 4.5472 $w=1.3e-08 $l=1.95e-08 $layer=M1 $thickness=3.6e-08 $X=0.351
+ $Y=0.134 $X2=0.351 $Y2=0.1535
r10 35 38 3.26466 $w=1.3e-08 $l=1.4e-08 $layer=M1 $thickness=3.6e-08 $X=0.351
+ $Y=0.1675 $X2=0.351 $Y2=0.1535
r11 11 35 2.91487 $w=1.3e-08 $l=1.25e-08 $layer=M1 $thickness=3.6e-08 $X=0.351
+ $Y=0.18 $X2=0.351 $Y2=0.1675
r12 8 34 1.49895 $w=1.63333e-08 $l=1.35e-08 $layer=M1 $thickness=3.6e-08
+ $X=0.351 $Y=0.198 $X2=0.3375 $Y2=0.198
r13 8 11 2.5483 $w=1.79e-08 $l=1.8e-08 $layer=M1 $thickness=3.6e-08 $X=0.351
+ $Y=0.198 $X2=0.351 $Y2=0.18
r14 33 34 4.19742 $w=1.3e-08 $l=1.8e-08 $layer=M1 $thickness=3.6e-08 $X=0.3195
+ $Y=0.198 $X2=0.3375 $Y2=0.198
r15 32 33 5.24677 $w=1.3e-08 $l=2.25e-08 $layer=M1 $thickness=3.6e-08 $X=0.297
+ $Y=0.198 $X2=0.3195 $Y2=0.198
r16 31 32 5.82974 $w=1.3e-08 $l=2.5e-08 $layer=M1 $thickness=3.6e-08 $X=0.272
+ $Y=0.198 $X2=0.297 $Y2=0.198
r17 30 31 7.11229 $w=1.3e-08 $l=3.05e-08 $layer=M1 $thickness=3.6e-08 $X=0.2415
+ $Y=0.198 $X2=0.272 $Y2=0.198
r18 29 30 7.69526 $w=1.3e-08 $l=3.3e-08 $layer=M1 $thickness=3.6e-08 $X=0.2085
+ $Y=0.198 $X2=0.2415 $Y2=0.198
r19 28 29 9.67737 $w=1.3e-08 $l=4.15e-08 $layer=M1 $thickness=3.6e-08 $X=0.167
+ $Y=0.198 $X2=0.2085 $Y2=0.198
r20 27 28 7.46207 $w=1.3e-08 $l=3.2e-08 $layer=M1 $thickness=3.6e-08 $X=0.135
+ $Y=0.198 $X2=0.167 $Y2=0.198
r21 26 27 5.24677 $w=1.3e-08 $l=2.25e-08 $layer=M1 $thickness=3.6e-08 $X=0.1125
+ $Y=0.198 $X2=0.135 $Y2=0.198
r22 10 26 4.19742 $w=1.3e-08 $l=1.8e-08 $layer=M1 $thickness=3.6e-08 $X=0.0945
+ $Y=0.198 $X2=0.1125 $Y2=0.198
r23 7 25 2.5483 $w=1.79e-08 $l=1.8e-08 $layer=M1 $thickness=3.6e-08 $X=0.081
+ $Y=0.198 $X2=0.081 $Y2=0.18
r24 7 10 1.49895 $w=1.63333e-08 $l=1.35e-08 $layer=M1 $thickness=3.6e-08
+ $X=0.081 $Y=0.198 $X2=0.0945 $Y2=0.198
r25 24 25 2.91487 $w=1.3e-08 $l=1.25e-08 $layer=M1 $thickness=3.6e-08 $X=0.081
+ $Y=0.1675 $X2=0.081 $Y2=0.18
r26 23 24 3.26466 $w=1.3e-08 $l=1.4e-08 $layer=M1 $thickness=3.6e-08 $X=0.081
+ $Y=0.1535 $X2=0.081 $Y2=0.1675
r27 22 23 4.5472 $w=1.3e-08 $l=1.95e-08 $layer=M1 $thickness=3.6e-08 $X=0.0835
+ $Y=0.1355 $X2=0.081 $Y2=0.1535
r28 22 9 8.51143 $w=1.3e-08 $l=3.65e-08 $layer=M1 $thickness=3.6e-08 $X=0.0835
+ $Y=0.1355 $X2=0.081 $Y2=0.0975
r29 1 15 6.54019 $w=2.09524e-08 $layer=Gate_1 $thickness=5.21905e-08 $X=0.081
+ $Y=0.135 $X2=0.081 $Y2=0.135
r30 22 1 19.3796 $a=3.24e-16 $layer=V0LIG $X=0.0835 $Y=0.1355 $X2=0.081
+ $Y2=0.135
r31 18 17 14.6259 $w=2.1e-08 $l=4.3e-08 $layer=Gate_1 $thickness=5.6e-08
+ $X=0.081 $Y=0.2025 $X2=0.081 $Y2=0.1595
r32 16 17 2.7211 $w=2.1e-08 $l=8e-09 $layer=Gate_1 $thickness=5.6e-08 $X=0.081
+ $Y=0.1515 $X2=0.081 $Y2=0.1595
r33 15 16 5.79936 $w=2.03333e-08 $l=1.65e-08 $layer=Gate_1 $thickness=5.6e-08
+ $X=0.081 $Y=0.135 $X2=0.081 $Y2=0.1515
r34 14 15 5.79936 $w=2.03333e-08 $l=1.65e-08 $layer=Gate_1 $thickness=5.6e-08
+ $X=0.081 $Y=0.1185 $X2=0.081 $Y2=0.135
r35 13 14 7.31297 $w=2.1e-08 $l=2.15e-08 $layer=Gate_1 $thickness=5.6e-08
+ $X=0.081 $Y=0.097 $X2=0.081 $Y2=0.1185
r36 12 13 14.6259 $w=2.1e-08 $l=4.3e-08 $layer=Gate_1 $thickness=5.6e-08
+ $X=0.081 $Y=0.054 $X2=0.081 $Y2=0.097
r37 12 5 10.0341 $w=2.1e-08 $l=2.95e-08 $layer=Gate_1 $thickness=5.6e-08
+ $X=0.081 $Y=0.054 $X2=0.081 $Y2=0.0245
.ends

* End of included file AOI21x1_ASAP7_75t_R.pex.sp.pex

*
.subckt AOI21x1_ASAP7_75t_CUSTOM_4_25_0_7 VSS VDD B A1 A2 Y
*
* VSS VSS
* VDD VDD
* B B
* A1 A1
* A2 A2
* Y Y
*
*

M0 N_M0_d N_M0_g VSS VSS nmos_rvt L=2e-08 W=5.4e-08 nfin=2 $X=0.071 $Y=0.027
M1 N_M1_d N_M1_g noxref_8 VSS nmos_rvt L=2e-08 W=8.1e-08 nfin=3 $X=0.125
+ $Y=0.027
M2 noxref_8 N_M2_g VSS VSS nmos_rvt L=2e-08 W=8.1e-08 nfin=3 $X=0.179 $Y=0.027
M3 noxref_9 N_M3_g VSS VSS nmos_rvt L=2e-08 W=8.1e-08 nfin=3 $X=0.233 $Y=0.027
M4 N_M4_d N_M4_g noxref_9 VSS nmos_rvt L=2e-08 W=8.1e-08 nfin=3 $X=0.287
+ $Y=0.027
M5 N_M5_d N_M5_g VSS VSS nmos_rvt L=2e-08 W=5.4e-08 nfin=2 $X=0.341 $Y=0.027
M6 noxref_6 N_M6_g N_M6_s VDD pmos_rvt L=2e-08 W=8.1e-08 nfin=3 $X=0.071
+ $Y=0.162
M7 VDD N_M7_g noxref_6 VDD pmos_rvt L=2e-08 W=8.1e-08 nfin=3 $X=0.125 $Y=0.162
M8 noxref_6 N_M8_g VDD VDD pmos_rvt L=2e-08 W=8.1e-08 nfin=3 $X=0.179 $Y=0.162
M9 noxref_6 N_M9_g VDD VDD pmos_rvt L=2e-08 W=8.1e-08 nfin=3 $X=0.233 $Y=0.162
M10 VDD N_M10_g noxref_6 VDD pmos_rvt L=2e-08 W=8.1e-08 nfin=3 $X=0.287 $Y=0.162
M11 noxref_6 N_M11_g N_M11_s VDD pmos_rvt L=2e-08 W=8.1e-08 nfin=3 $X=0.341
+ $Y=0.162

* .include "AOI21x1_ASAP7_75t_R.pex.sp.pxi"

* Start of included file AOI21x1_ASAP7_75t_R.pex.sp.pxi
x_PM_AOI21x1_ASAP7_75t_R%A2 vss A2 N_M2_g N_M8_g N_M3_g N_M9_g N_A2_4 N_A2_6
+ N_A2_1 N_A2_3 PM_AOI21x1_ASAP7_75t_R%A2
cc_1 A2 N_B_10 0.00544192f $X=0.2085 $Y=0.1355
cc_2 N_A2_4 N_A1_9 0.00146296f $X=0.243 $Y=0.135
cc_3 N_A2_6 N_A1_11 0.00183541f $X=0.229 $Y=0.134
cc_4 N_A2_1 N_A1_1 0.00260747f $X=0.189 $Y=0.135
cc_5 A2 N_A1_10 0.00531237f $X=0.2085 $Y=0.1355
cc_6 N_A2_3 N_A1_5 0.00951466f $X=0.189 $Y=0.0245
cc_7 N_A2_4 N_A1_6 0.0115009f $X=0.243 $Y=0.135
x_PM_AOI21x1_ASAP7_75t_R%A1 vss A1 N_M4_g N_M10_g N_M1_g N_M7_g N_A1_1 N_A1_2
+ N_A1_11 N_A1_6 N_A1_5 N_A1_9 N_A1_10 N_A1_7 N_A1_8 PM_AOI21x1_ASAP7_75t_R%A1
cc_8 N_A1_1 N_B_1 0.00187969f $X=0.135 $Y=0.135
cc_9 N_A1_2 N_B_2 0.00106776f $X=0.297 $Y=0.135
cc_10 N_A1_11 N_B_10 0.00238928f $X=0.297 $Y=0.134
cc_11 N_A1_6 N_B_6 0.00314915f $X=0.297 $Y=0.0245
cc_12 N_A1_5 N_B_5 0.00316179f $X=0.135 $Y=0.135
cc_13 N_A1_11 N_B_11 0.00333726f $X=0.297 $Y=0.134
cc_14 N_A1_9 N_B_9 0.00587261f $X=0.135 $Y=0.09
x_PM_AOI21x1_ASAP7_75t_R%Y vss Y N_M0_d N_M1_d N_M4_d N_M5_d N_M6_s N_M11_s
+ N_Y_19 N_Y_3 N_Y_2 N_Y_26 N_Y_1 N_Y_4 N_Y_22 N_Y_23 N_Y_20 N_Y_16 N_Y_18
+ N_Y_27 N_Y_25 N_Y_13 N_Y_14 PM_AOI21x1_ASAP7_75t_R%Y
cc_15 N_Y_19 N_B_6 0.000409981f $X=0.056 $Y=0.2025
cc_16 N_Y_3 N_B_10 0.000650878f $X=0.324 $Y=0.054
cc_17 N_Y_3 N_B_6 0.000842759f $X=0.324 $Y=0.054
cc_18 N_Y_2 N_B_1 0.000861781f $X=0.108 $Y=0.054
cc_19 N_Y_3 N_B_2 0.000861781f $X=0.324 $Y=0.054
cc_20 N_Y_2 N_B_5 0.00110423f $X=0.108 $Y=0.054
cc_21 N_Y_26 N_B_9 0.00126062f $X=0.0945 $Y=0.036
cc_22 N_Y_1 N_B_5 0.00131019f $X=0.054 $Y=0.2025
cc_23 N_Y_4 N_B_6 0.00131019f $X=0.378 $Y=0.2025
cc_24 N_Y_22 N_B_7 0.00156647f $X=0.027 $Y=0.234
cc_25 N_Y_23 N_B_8 0.00156647f $X=0.405 $Y=0.234
cc_26 N_Y_19 N_B_1 0.00173421f $X=0.056 $Y=0.2025
cc_27 N_Y_20 N_B_2 0.00173421f $X=0.3635 $Y=0.2025
cc_28 N_Y_16 N_B_5 0.00493403f $X=0.11 $Y=0.0945
cc_29 N_Y_18 N_B_6 0.00493403f $X=0.3095 $Y=0.0945
cc_30 N_Y_27 N_B_11 0.00499499f $X=0.405 $Y=0.054
cc_31 N_Y_25 N_B_9 0.00681043f $X=0.027 $Y=0.054
cc_32 N_Y_20 N_B_6 0.0529693f $X=0.3635 $Y=0.2025
cc_33 N_Y_13 N_B_5 0.00982507f $X=0.0935 $Y=0.0725
cc_34 N_Y_14 N_B_6 0.00982507f $X=0.3095 $Y=0.0725
cc_35 N_Y_19 N_B_5 0.0550713f $X=0.056 $Y=0.2025
cc_36 N_Y_18 N_A1_9 0.000665161f $X=0.3095 $Y=0.0945
cc_37 N_Y_13 N_A1_1 0.000792066f $X=0.0935 $Y=0.0725
cc_38 N_Y_14 N_A1_2 0.000792066f $X=0.3095 $Y=0.0725
cc_39 N_Y_3 N_A1_11 0.00080542f $X=0.324 $Y=0.054
cc_40 N_Y_26 N_A1_7 0.00133612f $X=0.0945 $Y=0.036
cc_41 N_Y_26 N_A1_8 0.0013838f $X=0.0945 $Y=0.036
cc_42 N_Y_2 N_A1_5 0.00146906f $X=0.108 $Y=0.054
cc_43 N_Y_3 N_A1_6 0.00151209f $X=0.324 $Y=0.054
cc_44 N_Y_13 N_A1_5 0.00954666f $X=0.0935 $Y=0.0725
cc_45 N_Y_14 N_A1_6 0.00954666f $X=0.3095 $Y=0.0725
cc_46 N_Y_26 N_A1_10 0.0117878f $X=0.0945 $Y=0.036
cc_47 N_Y_16 N_A1_5 0.0284547f $X=0.11 $Y=0.0945
cc_48 N_Y_18 N_A1_6 0.0307436f $X=0.3095 $Y=0.0945
x_PM_AOI21x1_ASAP7_75t_R%B vss B N_M0_g N_M6_g N_M5_g N_M11_g N_B_1 N_B_2
+ N_B_10 N_B_6 N_B_5 N_B_11 N_B_9 N_B_7 N_B_8 PM_AOI21x1_ASAP7_75t_R%B

* End of included file AOI21x1_ASAP7_75t_R.pex.sp.pxi
.ends

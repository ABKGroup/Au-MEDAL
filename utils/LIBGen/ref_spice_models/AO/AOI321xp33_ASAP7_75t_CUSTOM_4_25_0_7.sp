.subckt PM_AOI321xp33_ASAP7_75t_R%A2 vss 4 5 9 3
c1 1 vss 0.00460229f $X=0.135 $Y=0.135
c2 3 vss 0.118991f $X=0.135 $Y=0.0245
c3 4 vss 0.00925599f $X=0.134 $Y=0.136
r1 1 7 10.4265 $w=1.765e-08 $layer=LIG $thickness=5.2e-08 $X=0.135 $Y=0.135
+ $X2=0.135 $Y2=0.135
r2 4 1 19.3796 $a=3.24e-16 $layer=V0LIG $X=0.134 $Y=0.136 $X2=0.135 $Y2=0.135
r3 9 8 16.4967 $w=2.1e-08 $l=4.85e-08 $layer=Gate_1 $thickness=5.6e-08 $X=0.135
+ $Y=0.2025 $X2=0.135 $Y2=0.154
r4 7 8 6.6497 $w=2.04211e-08 $l=1.9e-08 $layer=Gate_1 $thickness=5.6e-08
+ $X=0.135 $Y=0.135 $X2=0.135 $Y2=0.154
r5 6 7 6.6497 $w=2.04211e-08 $l=1.9e-08 $layer=Gate_1 $thickness=5.6e-08
+ $X=0.135 $Y=0.116 $X2=0.135 $Y2=0.135
r6 5 6 16.4967 $w=2.1e-08 $l=4.85e-08 $layer=Gate_1 $thickness=5.6e-08 $X=0.135
+ $Y=0.0675 $X2=0.135 $Y2=0.116
r7 5 3 14.6259 $w=2.1e-08 $l=4.3e-08 $layer=Gate_1 $thickness=5.6e-08 $X=0.135
+ $Y=0.0675 $X2=0.135 $Y2=0.0245
.ends

.subckt PM_AOI321xp33_ASAP7_75t_R%A1 vss 11 5 9 4 3
c1 1 vss 0.00668855f $X=0.189 $Y=0.135
c2 3 vss 0.0855877f $X=0.189 $Y=0.0245
c3 4 vss 0.0186598f $X=0.189 $Y=0.098
r1 11 4 8.62802 $w=1.3e-08 $l=3.7e-08 $layer=M1 $thickness=3.6e-08 $X=0.196
+ $Y=0.136 $X2=0.189 $Y2=0.098
r2 1 7 10.4265 $w=1.765e-08 $layer=LIG $thickness=5.2e-08 $X=0.189 $Y=0.135
+ $X2=0.189 $Y2=0.135
r3 11 1 19.3796 $a=3.24e-16 $layer=V0LIG $X=0.196 $Y=0.136 $X2=0.189 $Y2=0.135
r4 9 8 16.4967 $w=2.1e-08 $l=4.85e-08 $layer=Gate_1 $thickness=5.6e-08 $X=0.189
+ $Y=0.2025 $X2=0.189 $Y2=0.154
r5 7 8 6.6497 $w=2.04211e-08 $l=1.9e-08 $layer=Gate_1 $thickness=5.6e-08
+ $X=0.189 $Y=0.135 $X2=0.189 $Y2=0.154
r6 6 7 6.6497 $w=2.04211e-08 $l=1.9e-08 $layer=Gate_1 $thickness=5.6e-08
+ $X=0.189 $Y=0.116 $X2=0.189 $Y2=0.135
r7 5 6 16.4967 $w=2.1e-08 $l=4.85e-08 $layer=Gate_1 $thickness=5.6e-08 $X=0.189
+ $Y=0.0675 $X2=0.189 $Y2=0.116
r8 5 3 14.6259 $w=2.1e-08 $l=4.3e-08 $layer=Gate_1 $thickness=5.6e-08 $X=0.189
+ $Y=0.0675 $X2=0.189 $Y2=0.0245
.ends

.subckt PM_AOI321xp33_ASAP7_75t_R%C vss 11 5 9 3 4
c1 1 vss 0.0121961f $X=0.243 $Y=0.135
c2 3 vss 0.116497f $X=0.243 $Y=0.0245
c3 4 vss 0.00775212f $X=0.243 $Y=0.098
r1 11 4 8.62802 $w=1.3e-08 $l=3.7e-08 $layer=M1 $thickness=3.6e-08 $X=0.243
+ $Y=0.134 $X2=0.243 $Y2=0.098
r2 1 7 10.4265 $w=1.765e-08 $layer=LIG $thickness=5.2e-08 $X=0.243 $Y=0.135
+ $X2=0.243 $Y2=0.135
r3 11 1 19.3796 $a=3.24e-16 $layer=V0LIG $X=0.243 $Y=0.134 $X2=0.243 $Y2=0.135
r4 9 8 16.4967 $w=2.1e-08 $l=4.85e-08 $layer=Gate_1 $thickness=5.6e-08 $X=0.243
+ $Y=0.2025 $X2=0.243 $Y2=0.154
r5 7 8 6.6497 $w=2.04211e-08 $l=1.9e-08 $layer=Gate_1 $thickness=5.6e-08
+ $X=0.243 $Y=0.135 $X2=0.243 $Y2=0.154
r6 6 7 11.2416 $w=2.06615e-08 $l=3.25e-08 $layer=Gate_1 $thickness=5.6e-08
+ $X=0.243 $Y=0.1025 $X2=0.243 $Y2=0.135
r7 5 6 16.4967 $w=2.1e-08 $l=4.85e-08 $layer=Gate_1 $thickness=5.6e-08 $X=0.243
+ $Y=0.054 $X2=0.243 $Y2=0.1025
r8 5 3 10.0341 $w=2.1e-08 $l=2.95e-08 $layer=Gate_1 $thickness=5.6e-08 $X=0.243
+ $Y=0.054 $X2=0.243 $Y2=0.0245
.ends

.subckt PM_AOI321xp33_ASAP7_75t_R%B2 vss 13 5 11 4 3 1
c1 1 vss 0.00367992f $X=0.351 $Y=0.135
c2 3 vss 0.0731824f $X=0.351 $Y=0.0245
c3 4 vss 0.00816738f $X=0.351 $Y=0.098
r1 13 4 8.62802 $w=1.3e-08 $l=3.7e-08 $layer=M1 $thickness=3.6e-08 $X=0.348
+ $Y=0.134 $X2=0.351 $Y2=0.098
r2 1 8 10.4265 $w=1.765e-08 $layer=LIG $thickness=5.2e-08 $X=0.351 $Y=0.135
+ $X2=0.351 $Y2=0.135
r3 13 1 19.3796 $a=3.24e-16 $layer=V0LIG $X=0.348 $Y=0.134 $X2=0.351 $Y2=0.135
r4 11 10 14.6259 $w=2.1e-08 $l=4.3e-08 $layer=Gate_1 $thickness=5.6e-08
+ $X=0.351 $Y=0.2025 $X2=0.351 $Y2=0.1595
r5 9 10 2.7211 $w=2.1e-08 $l=8e-09 $layer=Gate_1 $thickness=5.6e-08 $X=0.351
+ $Y=0.1515 $X2=0.351 $Y2=0.1595
r6 8 9 5.79936 $w=2.03333e-08 $l=1.65e-08 $layer=Gate_1 $thickness=5.6e-08
+ $X=0.351 $Y=0.135 $X2=0.351 $Y2=0.1515
r7 7 8 5.79936 $w=2.03333e-08 $l=1.65e-08 $layer=Gate_1 $thickness=5.6e-08
+ $X=0.351 $Y=0.1185 $X2=0.351 $Y2=0.135
r8 6 7 7.31297 $w=2.1e-08 $l=2.15e-08 $layer=Gate_1 $thickness=5.6e-08 $X=0.351
+ $Y=0.097 $X2=0.351 $Y2=0.1185
r9 5 6 14.6259 $w=2.1e-08 $l=4.3e-08 $layer=Gate_1 $thickness=5.6e-08 $X=0.351
+ $Y=0.054 $X2=0.351 $Y2=0.097
r10 5 3 10.0341 $w=2.1e-08 $l=2.95e-08 $layer=Gate_1 $thickness=5.6e-08
+ $X=0.351 $Y=0.054 $X2=0.351 $Y2=0.0245
.ends

.subckt PM_AOI321xp33_ASAP7_75t_R%Y vss 33 21 24 47 54 55 1 10 12 2 14 17 3 18
+ 13 19
c1 1 vss 0.00662623f $X=0.216 $Y=0.054
c2 2 vss 0.00905715f $X=0.324 $Y=0.2025
c3 3 vss 0.00558096f $X=0.378 $Y=0.054
c4 10 vss 0.00265974f $X=0.2015 $Y=0.0725
c5 11 vss 0.000109629f $X=0.2015 $Y=0.0455
c6 12 vss 0.000257356f $X=0.2015 $Y=0.0945
c7 13 vss 0.0250391f $X=0.3635 $Y=0.054
c8 14 vss 0.00421012f $X=0.3095 $Y=0.2025
c9 15 vss 0.00246496f $X=0.405 $Y=0.036
c10 16 vss 0.00221628f $X=0.405 $Y=0.198
c11 17 vss 0.0165231f $X=0.2025 $Y=0.036
c12 18 vss 0.00718546f $X=0.378 $Y=0.198
c13 19 vss 0.00428164f $X=0.405 $Y=0.0575
r1 55 53 0.0308642 $w=8.1e-08 $l=2.5e-09 $layer=P_src_drn $thickness=1e-09
+ $X=0.3413 $Y=0.2025 $X2=0.3385 $Y2=0.2025
r2 2 53 0.179012 $w=8.1e-08 $l=1.45e-08 $layer=P_src_drn $thickness=1e-09
+ $X=0.324 $Y=0.2025 $X2=0.3385 $Y2=0.2025
r3 14 2 0.179012 $w=8.1e-08 $l=1.45e-08 $layer=P_src_drn $thickness=1e-09
+ $X=0.3095 $Y=0.2025 $X2=0.324 $Y2=0.2025
r4 54 14 0.0308642 $w=8.1e-08 $l=2.5e-09 $layer=P_src_drn $thickness=1e-09
+ $X=0.3066 $Y=0.2025 $X2=0.3095 $Y2=0.2025
r5 2 50 19.3796 $a=3.24e-16 $layer=V0LISD $X=0.324 $Y=0.2025 $X2=0.324 $Y2=0.198
r6 50 51 3.14806 $w=1.3e-08 $l=1.35e-08 $layer=M1 $thickness=3.6e-08 $X=0.324
+ $Y=0.198 $X2=0.3375 $Y2=0.198
r7 48 51 3.14806 $w=1.3e-08 $l=1.35e-08 $layer=M1 $thickness=3.6e-08 $X=0.351
+ $Y=0.198 $X2=0.3375 $Y2=0.198
r8 18 48 6.29612 $w=1.3e-08 $l=2.7e-08 $layer=M1 $thickness=3.6e-08 $X=0.378
+ $Y=0.198 $X2=0.351 $Y2=0.198
r9 16 45 3.36447 $w=1.71023e-08 $l=2.15e-08 $layer=M1 $thickness=3.6e-08
+ $X=0.405 $Y=0.198 $X2=0.405 $Y2=0.1765
r10 16 18 4.64701 $w=1.46667e-08 $l=2.7e-08 $layer=M1 $thickness=3.6e-08
+ $X=0.405 $Y=0.198 $X2=0.378 $Y2=0.198
r11 13 3 0.231482 $w=5.4e-08 $l=1.25e-08 $layer=N_src_drn $thickness=1e-09
+ $X=0.3635 $Y=0.054 $X2=0.378 $Y2=0.054
r12 47 13 0.0462963 $w=5.4e-08 $l=2.5e-09 $layer=N_src_drn $thickness=1e-09
+ $X=0.3606 $Y=0.054 $X2=0.3635 $Y2=0.054
r13 44 45 13.8748 $w=1.3e-08 $l=5.95e-08 $layer=M1 $thickness=3.6e-08 $X=0.405
+ $Y=0.117 $X2=0.405 $Y2=0.1765
r14 19 44 13.8748 $w=1.3e-08 $l=5.95e-08 $layer=M1 $thickness=3.6e-08 $X=0.405
+ $Y=0.0575 $X2=0.405 $Y2=0.117
r15 3 42 19.3796 $a=3.24e-16 $layer=V0LISD $X=0.378 $Y=0.054 $X2=0.378 $Y2=0.036
r16 15 43 1.49895 $w=1.63333e-08 $l=1.35e-08 $layer=M1 $thickness=3.6e-08
+ $X=0.405 $Y=0.036 $X2=0.3915 $Y2=0.036
r17 15 19 3.36447 $w=1.71023e-08 $l=2.15e-08 $layer=M1 $thickness=3.6e-08
+ $X=0.405 $Y=0.036 $X2=0.405 $Y2=0.0575
r18 42 43 3.14806 $w=1.3e-08 $l=1.35e-08 $layer=M1 $thickness=3.6e-08 $X=0.378
+ $Y=0.036 $X2=0.3915 $Y2=0.036
r19 41 42 3.14806 $w=1.3e-08 $l=1.35e-08 $layer=M1 $thickness=3.6e-08 $X=0.3645
+ $Y=0.036 $X2=0.378 $Y2=0.036
r20 40 41 3.14806 $w=1.3e-08 $l=1.35e-08 $layer=M1 $thickness=3.6e-08 $X=0.351
+ $Y=0.036 $X2=0.3645 $Y2=0.036
r21 39 40 5.82974 $w=1.3e-08 $l=2.5e-08 $layer=M1 $thickness=3.6e-08 $X=0.326
+ $Y=0.036 $X2=0.351 $Y2=0.036
r22 38 39 4.19742 $w=1.3e-08 $l=1.8e-08 $layer=M1 $thickness=3.6e-08 $X=0.308
+ $Y=0.036 $X2=0.326 $Y2=0.036
r23 37 38 2.56509 $w=1.3e-08 $l=1.1e-08 $layer=M1 $thickness=3.6e-08 $X=0.297
+ $Y=0.036 $X2=0.308 $Y2=0.036
r24 36 37 5.82974 $w=1.3e-08 $l=2.5e-08 $layer=M1 $thickness=3.6e-08 $X=0.272
+ $Y=0.036 $X2=0.297 $Y2=0.036
r25 35 36 4.19742 $w=1.3e-08 $l=1.8e-08 $layer=M1 $thickness=3.6e-08 $X=0.254
+ $Y=0.036 $X2=0.272 $Y2=0.036
r26 34 35 0.874462 $w=1.3e-08 $l=3.8e-09 $layer=M1 $thickness=3.6e-08 $X=0.2502
+ $Y=0.036 $X2=0.254 $Y2=0.036
r27 33 34 0.524677 $w=1.3e-08 $l=2.2e-09 $layer=M1 $thickness=3.6e-08 $X=0.248
+ $Y=0.035 $X2=0.2502 $Y2=0.036
r28 33 32 1.69063 $w=1.3e-08 $l=7.3e-09 $layer=M1 $thickness=3.6e-08 $X=0.248
+ $Y=0.035 $X2=0.2407 $Y2=0.036
r29 31 32 2.04041 $w=1.3e-08 $l=8.7e-09 $layer=M1 $thickness=3.6e-08 $X=0.232
+ $Y=0.036 $X2=0.2407 $Y2=0.036
r30 30 31 1.04935 $w=1.3e-08 $l=4.5e-09 $layer=M1 $thickness=3.6e-08 $X=0.2275
+ $Y=0.036 $X2=0.232 $Y2=0.036
r31 29 30 2.68168 $w=1.3e-08 $l=1.15e-08 $layer=M1 $thickness=3.6e-08 $X=0.216
+ $Y=0.036 $X2=0.2275 $Y2=0.036
r32 17 29 3.14806 $w=1.3e-08 $l=1.35e-08 $layer=M1 $thickness=3.6e-08 $X=0.2025
+ $Y=0.036 $X2=0.216 $Y2=0.036
r33 1 29 19.3796 $a=3.24e-16 $layer=V0LISD $X=0.216 $Y=0.054 $X2=0.216 $Y2=0.036
r34 12 1 0.462963 $w=2.7e-08 $l=1.25e-08 $layer=N_src_drn $thickness=1e-09
+ $X=0.2015 $Y=0.0945 $X2=0.216 $Y2=0.054
r35 11 1 0.245304 $w=3.7e-08 $l=1.45e-08 $layer=N_src_drn $thickness=1e-09
+ $X=0.2015 $Y=0.0455 $X2=0.216 $Y2=0.054
r36 24 23 0.147059 $w=1.7e-08 $l=2.5e-09 $layer=N_src_drn $thickness=1e-09
+ $X=0.2333 $Y=0.054 $X2=0.2305 $Y2=0.0725
r37 22 23 0.264706 $w=1.7e-08 $l=4.5e-09 $layer=N_src_drn $thickness=1e-09
+ $X=0.226 $Y=0.0725 $X2=0.2305 $Y2=0.0725
r38 1 22 0.705882 $w=1.7e-08 $l=1.2e-08 $layer=N_src_drn $thickness=1e-09
+ $X=0.216 $Y=0.054 $X2=0.226 $Y2=0.0725
r39 10 1 0.735294 $w=1.7e-08 $l=1.25e-08 $layer=N_src_drn $thickness=1e-09
+ $X=0.2015 $Y=0.0725 $X2=0.216 $Y2=0.054
r40 21 10 0.147059 $w=1.7e-08 $l=2.5e-09 $layer=N_src_drn $thickness=1e-09
+ $X=0.1986 $Y=0.0675 $X2=0.2015 $Y2=0.0725
.ends

.subckt PM_AOI321xp33_ASAP7_75t_R%A3 vss 16 8 14 3
c1 1 vss 0.00710629f $X=0.081 $Y=0.135
c2 3 vss 0.142412f $X=0.081 $Y=0.0245
c3 4 vss 0.00110562f $X=0.027 $Y=0.135
c4 5 vss 0.00978575f $X=0.027 $Y=0.08
c5 6 vss 0.0104629f $X=0.027 $Y=0.154
c6 7 vss 0.00356301f $X=0.054 $Y=0.135
r1 4 7 5.11582 $w=1.46667e-08 $l=2.7e-08 $layer=M1 $thickness=3.6e-08 $X=0.027
+ $Y=0.135 $X2=0.054 $Y2=0.135
r2 4 5 11.6451 $w=1.38182e-08 $l=5.5e-08 $layer=M1 $thickness=3.6e-08 $X=0.027
+ $Y=0.135 $X2=0.027 $Y2=0.08
r3 4 6 3.2503 $w=1.53684e-08 $l=1.9e-08 $layer=M1 $thickness=3.6e-08 $X=0.027
+ $Y=0.135 $X2=0.027 $Y2=0.154
r4 16 7 6.29612 $w=1.3e-08 $l=2.7e-08 $layer=M1 $thickness=3.6e-08 $X=0.08
+ $Y=0.136 $X2=0.054 $Y2=0.135
r5 1 11 10.4265 $w=1.765e-08 $layer=LIG $thickness=5.2e-08 $X=0.081 $Y=0.135
+ $X2=0.081 $Y2=0.135
r6 16 1 19.3796 $a=3.24e-16 $layer=V0LIG $X=0.08 $Y=0.136 $X2=0.081 $Y2=0.135
r7 14 13 14.6259 $w=2.1e-08 $l=4.3e-08 $layer=Gate_1 $thickness=5.6e-08
+ $X=0.081 $Y=0.2025 $X2=0.081 $Y2=0.1595
r8 12 13 2.7211 $w=2.1e-08 $l=8e-09 $layer=Gate_1 $thickness=5.6e-08 $X=0.081
+ $Y=0.1515 $X2=0.081 $Y2=0.1595
r9 11 12 5.79936 $w=2.03333e-08 $l=1.65e-08 $layer=Gate_1 $thickness=5.6e-08
+ $X=0.081 $Y=0.135 $X2=0.081 $Y2=0.1515
r10 10 11 5.79936 $w=2.03333e-08 $l=1.65e-08 $layer=Gate_1 $thickness=5.6e-08
+ $X=0.081 $Y=0.1185 $X2=0.081 $Y2=0.135
r11 9 10 2.7211 $w=2.1e-08 $l=8e-09 $layer=Gate_1 $thickness=5.6e-08 $X=0.081
+ $Y=0.1105 $X2=0.081 $Y2=0.1185
r12 8 9 14.6259 $w=2.1e-08 $l=4.3e-08 $layer=Gate_1 $thickness=5.6e-08 $X=0.081
+ $Y=0.0675 $X2=0.081 $Y2=0.1105
r13 8 3 14.6259 $w=2.1e-08 $l=4.3e-08 $layer=Gate_1 $thickness=5.6e-08 $X=0.081
+ $Y=0.0675 $X2=0.081 $Y2=0.0245
.ends

.subckt PM_AOI321xp33_ASAP7_75t_R%B1 vss 11 5 9 4 3 1
c1 1 vss 0.00783018f $X=0.297 $Y=0.135
c2 3 vss 0.0912007f $X=0.297 $Y=0.0245
c3 4 vss 0.00518071f $X=0.297 $Y=0.098
r1 11 4 8.62802 $w=1.3e-08 $l=3.7e-08 $layer=M1 $thickness=3.6e-08 $X=0.296
+ $Y=0.134 $X2=0.297 $Y2=0.098
r2 1 7 10.4265 $w=1.765e-08 $layer=LIG $thickness=5.2e-08 $X=0.297 $Y=0.135
+ $X2=0.297 $Y2=0.135
r3 11 1 19.3796 $a=3.24e-16 $layer=V0LIG $X=0.296 $Y=0.134 $X2=0.297 $Y2=0.135
r4 9 8 16.4967 $w=2.1e-08 $l=4.85e-08 $layer=Gate_1 $thickness=5.6e-08 $X=0.297
+ $Y=0.2025 $X2=0.297 $Y2=0.154
r5 7 8 6.6497 $w=2.04211e-08 $l=1.9e-08 $layer=Gate_1 $thickness=5.6e-08
+ $X=0.297 $Y=0.135 $X2=0.297 $Y2=0.154
r6 6 7 11.2416 $w=2.06615e-08 $l=3.25e-08 $layer=Gate_1 $thickness=5.6e-08
+ $X=0.297 $Y=0.1025 $X2=0.297 $Y2=0.135
r7 5 6 16.4967 $w=2.1e-08 $l=4.85e-08 $layer=Gate_1 $thickness=5.6e-08 $X=0.297
+ $Y=0.054 $X2=0.297 $Y2=0.1025
r8 5 3 10.0341 $w=2.1e-08 $l=2.95e-08 $layer=Gate_1 $thickness=5.6e-08 $X=0.297
+ $Y=0.054 $X2=0.297 $Y2=0.0245
.ends

* End of included file AOI321xp33_ASAP7_75t_R.pex.sp.pex

*
.subckt AOI321xp33_ASAP7_75t_CUSTOM_4_25_0_7 VSS VDD A3 A2 A1 C B1 B2 Y
*
* VSS VSS
* VDD VDD
* A3 A3
* A2 A2
* A1 A1
* C C
* B1 B1
* B2 B2
* Y Y
*
*

M0 noxref_12 N_M0_g VSS VSS nmos_rvt L=2e-08 W=8.1e-08 nfin=3 $X=0.071 $Y=0.027
M1 noxref_13 N_M1_g noxref_12 VSS nmos_rvt L=2e-08 W=8.1e-08 nfin=3 $X=0.125
+ $Y=0.027
M2 N_M2_d N_M2_g noxref_13 VSS nmos_rvt L=2e-08 W=8.1e-08 nfin=3 $X=0.179
+ $Y=0.027
M3 VSS N_M3_g N_M3_s VSS nmos_rvt L=2e-08 W=5.4e-08 nfin=2 $X=0.233 $Y=0.027
M4 noxref_14 N_M4_g VSS VSS nmos_rvt L=2e-08 W=5.4e-08 nfin=2 $X=0.287 $Y=0.027
M5 N_M5_d N_M5_g noxref_14 VSS nmos_rvt L=2e-08 W=5.4e-08 nfin=2 $X=0.341
+ $Y=0.027
M6 noxref_9 N_M6_g VDD VDD pmos_rvt L=2e-08 W=8.1e-08 nfin=3 $X=0.071 $Y=0.162
M7 VDD N_M7_g noxref_9 VDD pmos_rvt L=2e-08 W=8.1e-08 nfin=3 $X=0.125 $Y=0.162
M8 noxref_9 N_M8_g VDD VDD pmos_rvt L=2e-08 W=8.1e-08 nfin=3 $X=0.179 $Y=0.162
M9 noxref_10 N_M9_g noxref_9 VDD pmos_rvt L=2e-08 W=8.1e-08 nfin=3 $X=0.233
+ $Y=0.162
M10 N_M10_d N_M10_g noxref_10 VDD pmos_rvt L=2e-08 W=8.1e-08 nfin=3 $X=0.287
+ $Y=0.162
M11 noxref_10 N_M11_g N_M11_s VDD pmos_rvt L=2e-08 W=8.1e-08 nfin=3 $X=0.341
+ $Y=0.162

* .include "AOI321xp33_ASAP7_75t_R.pex.sp.pxi"

* Start of included file AOI321xp33_ASAP7_75t_R.pex.sp.pxi
x_PM_AOI321xp33_ASAP7_75t_R%A2 vss A2 N_M1_g N_M7_g N_A2_3
+ PM_AOI321xp33_ASAP7_75t_R%A2
cc_1 A2 N_A3_3 0.00253597f $X=0.134 $Y=0.136
cc_2 N_A2_3 N_A3_3 0.00769778f $X=0.135 $Y=0.0245
x_PM_AOI321xp33_ASAP7_75t_R%A1 vss A1 N_M2_g N_M8_g N_A1_4 N_A1_3
+ PM_AOI321xp33_ASAP7_75t_R%A1
cc_3 N_A1_4 A2 0.00377979f $X=0.189 $Y=0.098
cc_4 N_A1_3 N_A2_3 0.0112033f $X=0.189 $Y=0.0245
x_PM_AOI321xp33_ASAP7_75t_R%C vss C N_M3_g N_M9_g N_C_3 N_C_4
+ PM_AOI321xp33_ASAP7_75t_R%C
cc_5 N_C_3 N_A1_3 0.00302079f $X=0.243 $Y=0.0245
cc_6 N_C_4 N_A1_4 0.00492902f $X=0.243 $Y=0.098
x_PM_AOI321xp33_ASAP7_75t_R%B2 vss B2 N_M5_g N_M11_g N_B2_4 N_B2_3 N_B2_1
+ PM_AOI321xp33_ASAP7_75t_R%B2
cc_7 N_B2_4 N_B1_4 0.00336899f $X=0.351 $Y=0.098
cc_8 N_B2_3 N_B1_3 0.00858714f $X=0.351 $Y=0.0245
x_PM_AOI321xp33_ASAP7_75t_R%Y vss Y N_M2_d N_M3_s N_M5_d N_M10_d N_M11_s N_Y_1
+ N_Y_10 N_Y_12 N_Y_2 N_Y_14 N_Y_17 N_Y_3 N_Y_18 N_Y_13 N_Y_19
+ PM_AOI321xp33_ASAP7_75t_R%Y
cc_9 N_Y_1 N_A1_4 0.00111223f $X=0.216 $Y=0.054
cc_10 N_Y_1 N_A1_3 0.00132424f $X=0.216 $Y=0.054
cc_11 N_Y_10 N_A1_3 0.00892908f $X=0.2015 $Y=0.0725
cc_12 N_Y_12 N_A1_3 0.0368108f $X=0.2015 $Y=0.0945
cc_13 N_Y_1 N_C_3 0.00115187f $X=0.216 $Y=0.054
cc_14 N_Y_1 N_C_4 0.00159449f $X=0.216 $Y=0.054
cc_15 N_Y_12 N_C_3 0.00461173f $X=0.2015 $Y=0.0945
cc_16 N_Y_10 N_C_3 0.0353522f $X=0.2015 $Y=0.0725
cc_17 N_Y_2 N_B1_3 0.000735581f $X=0.324 $Y=0.2025
cc_18 N_Y_14 N_B1_1 0.000800622f $X=0.3095 $Y=0.2025
cc_19 N_Y_17 N_B1_4 0.00111714f $X=0.2025 $Y=0.036
cc_20 N_Y_2 N_B1_4 0.00200578f $X=0.324 $Y=0.2025
cc_21 N_Y_14 N_B1_3 0.0337978f $X=0.3095 $Y=0.2025
cc_22 N_Y_2 N_B2_3 0.000732149f $X=0.324 $Y=0.2025
cc_23 N_Y_3 N_B2_3 0.000832014f $X=0.378 $Y=0.054
cc_24 N_Y_18 N_B2_4 0.000880143f $X=0.378 $Y=0.198
cc_25 N_Y_17 N_B2_4 0.000973079f $X=0.2025 $Y=0.036
cc_26 N_Y_14 N_B2_1 0.00115301f $X=0.3095 $Y=0.2025
cc_27 N_Y_13 N_B2_3 0.00986668f $X=0.3635 $Y=0.054
cc_28 N_Y_19 N_B2_4 0.00600268f $X=0.405 $Y=0.0575
cc_29 N_Y_14 N_B2_3 0.0467753f $X=0.3095 $Y=0.2025
x_PM_AOI321xp33_ASAP7_75t_R%A3 vss A3 N_M0_g N_M6_g N_A3_3
+ PM_AOI321xp33_ASAP7_75t_R%A3
x_PM_AOI321xp33_ASAP7_75t_R%B1 vss B1 N_M4_g N_M10_g N_B1_4 N_B1_3 N_B1_1
+ PM_AOI321xp33_ASAP7_75t_R%B1
cc_30 N_B1_4 N_C_4 0.00335544f $X=0.297 $Y=0.098
cc_31 N_B1_3 N_C_3 0.00711162f $X=0.297 $Y=0.0245

* End of included file AOI321xp33_ASAP7_75t_R.pex.sp.pxi
.ends

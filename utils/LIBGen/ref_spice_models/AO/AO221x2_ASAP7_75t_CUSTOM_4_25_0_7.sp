.subckt PM_AO221x2_ASAP7_75t_R%C vss 11 5 9 4 3
c1 1 vss 0.0068547f $X=0.189 $Y=0.135
c2 3 vss 0.112783f $X=0.189 $Y=0.0245
c3 4 vss 0.00478097f $X=0.189 $Y=0.0962
r1 12 13 2.39019 $w=1.3e-08 $l=1.03e-08 $layer=M1 $thickness=3.6e-08 $X=0.189
+ $Y=0.1247 $X2=0.189 $Y2=0.135
r2 11 12 0.408082 $w=1.3e-08 $l=1.7e-09 $layer=M1 $thickness=3.6e-08 $X=0.188
+ $Y=0.123 $X2=0.189 $Y2=0.1247
r3 11 4 6.23783 $w=1.3e-08 $l=2.68e-08 $layer=M1 $thickness=3.6e-08 $X=0.188
+ $Y=0.123 $X2=0.189 $Y2=0.0962
r4 1 7 10.4265 $w=1.765e-08 $layer=LIG $thickness=5.2e-08 $X=0.189 $Y=0.135
+ $X2=0.189 $Y2=0.135
r5 1 13 19.3796 $a=3.24e-16 $layer=V0LIG $X=0.189 $Y=0.135 $X2=0.189 $Y2=0.135
r6 9 8 16.4967 $w=2.1e-08 $l=4.85e-08 $layer=Gate_1 $thickness=5.6e-08 $X=0.189
+ $Y=0.2025 $X2=0.189 $Y2=0.154
r7 7 8 6.6497 $w=2.04211e-08 $l=1.9e-08 $layer=Gate_1 $thickness=5.6e-08
+ $X=0.189 $Y=0.135 $X2=0.189 $Y2=0.154
r8 6 7 11.2416 $w=2.06615e-08 $l=3.25e-08 $layer=Gate_1 $thickness=5.6e-08
+ $X=0.189 $Y=0.1025 $X2=0.189 $Y2=0.135
r9 5 6 16.4967 $w=2.1e-08 $l=4.85e-08 $layer=Gate_1 $thickness=5.6e-08 $X=0.189
+ $Y=0.054 $X2=0.189 $Y2=0.1025
r10 5 3 10.0341 $w=2.1e-08 $l=2.95e-08 $layer=Gate_1 $thickness=5.6e-08
+ $X=0.189 $Y=0.054 $X2=0.189 $Y2=0.0245
.ends

.subckt PM_AO221x2_ASAP7_75t_R%A1 vss 13 5 9 4 3
c1 1 vss 0.00662156f $X=0.243 $Y=0.135
c2 3 vss 0.100924f $X=0.243 $Y=0.0245
c3 4 vss 0.00520076f $X=0.243 $Y=0.098
r1 13 12 0.874462 $w=1.3e-08 $l=3.8e-09 $layer=M1 $thickness=3.6e-08 $X=0.244
+ $Y=0.151 $X2=0.243 $Y2=0.1472
r2 11 12 2.85657 $w=1.3e-08 $l=1.22e-08 $layer=M1 $thickness=3.6e-08 $X=0.243
+ $Y=0.135 $X2=0.243 $Y2=0.1472
r3 4 11 8.62802 $w=1.3e-08 $l=3.7e-08 $layer=M1 $thickness=3.6e-08 $X=0.243
+ $Y=0.098 $X2=0.243 $Y2=0.135
r4 1 7 10.4265 $w=1.765e-08 $layer=LIG $thickness=5.2e-08 $X=0.243 $Y=0.135
+ $X2=0.243 $Y2=0.135
r5 1 11 19.3796 $a=3.24e-16 $layer=V0LIG $X=0.243 $Y=0.135 $X2=0.243 $Y2=0.135
r6 9 8 16.4967 $w=2.1e-08 $l=4.85e-08 $layer=Gate_1 $thickness=5.6e-08 $X=0.243
+ $Y=0.2025 $X2=0.243 $Y2=0.154
r7 7 8 6.6497 $w=2.04211e-08 $l=1.9e-08 $layer=Gate_1 $thickness=5.6e-08
+ $X=0.243 $Y=0.135 $X2=0.243 $Y2=0.154
r8 6 7 11.2416 $w=2.06615e-08 $l=3.25e-08 $layer=Gate_1 $thickness=5.6e-08
+ $X=0.243 $Y=0.1025 $X2=0.243 $Y2=0.135
r9 5 6 16.4967 $w=2.1e-08 $l=4.85e-08 $layer=Gate_1 $thickness=5.6e-08 $X=0.243
+ $Y=0.054 $X2=0.243 $Y2=0.1025
r10 5 3 10.0341 $w=2.1e-08 $l=2.95e-08 $layer=Gate_1 $thickness=5.6e-08
+ $X=0.243 $Y=0.054 $X2=0.243 $Y2=0.0245
.ends

.subckt PM_AO221x2_ASAP7_75t_R%A2 vss 13 5 11 4 3
c1 1 vss 0.00613797f $X=0.297 $Y=0.135
c2 3 vss 0.133788f $X=0.297 $Y=0.0245
c3 4 vss 0.00652768f $X=0.297 $Y=0.0962
r1 14 15 2.39019 $w=1.3e-08 $l=1.03e-08 $layer=M1 $thickness=3.6e-08 $X=0.297
+ $Y=0.1247 $X2=0.297 $Y2=0.135
r2 13 14 0.408082 $w=1.3e-08 $l=1.7e-09 $layer=M1 $thickness=3.6e-08 $X=0.295
+ $Y=0.123 $X2=0.297 $Y2=0.1247
r3 13 4 6.23783 $w=1.3e-08 $l=2.68e-08 $layer=M1 $thickness=3.6e-08 $X=0.295
+ $Y=0.123 $X2=0.297 $Y2=0.0962
r4 1 8 10.4265 $w=1.765e-08 $layer=LIG $thickness=5.2e-08 $X=0.297 $Y=0.135
+ $X2=0.297 $Y2=0.135
r5 1 15 19.3796 $a=3.24e-16 $layer=V0LIG $X=0.297 $Y=0.135 $X2=0.297 $Y2=0.135
r6 11 10 14.6259 $w=2.1e-08 $l=4.3e-08 $layer=Gate_1 $thickness=5.6e-08
+ $X=0.297 $Y=0.2025 $X2=0.297 $Y2=0.1595
r7 9 10 2.7211 $w=2.1e-08 $l=8e-09 $layer=Gate_1 $thickness=5.6e-08 $X=0.297
+ $Y=0.1515 $X2=0.297 $Y2=0.1595
r8 8 9 5.79936 $w=2.03333e-08 $l=1.65e-08 $layer=Gate_1 $thickness=5.6e-08
+ $X=0.297 $Y=0.135 $X2=0.297 $Y2=0.1515
r9 7 8 5.79936 $w=2.03333e-08 $l=1.65e-08 $layer=Gate_1 $thickness=5.6e-08
+ $X=0.297 $Y=0.1185 $X2=0.297 $Y2=0.135
r10 6 7 7.31297 $w=2.1e-08 $l=2.15e-08 $layer=Gate_1 $thickness=5.6e-08
+ $X=0.297 $Y=0.097 $X2=0.297 $Y2=0.1185
r11 5 6 14.6259 $w=2.1e-08 $l=4.3e-08 $layer=Gate_1 $thickness=5.6e-08 $X=0.297
+ $Y=0.054 $X2=0.297 $Y2=0.097
r12 5 3 10.0341 $w=2.1e-08 $l=2.95e-08 $layer=Gate_1 $thickness=5.6e-08
+ $X=0.297 $Y=0.054 $X2=0.297 $Y2=0.0245
.ends

.subckt PM_AO221x2_ASAP7_75t_R%Y vss 23 16 17 33 34 8 2 7
c1 1 vss 0.0093666f $X=0.486 $Y=0.0675
c2 2 vss 0.0093666f $X=0.486 $Y=0.2025
c3 7 vss 0.00438186f $X=0.4715 $Y=0.0675
c4 8 vss 0.00439007f $X=0.4715 $Y=0.2025
c5 9 vss 0.00318181f $X=0.54 $Y=0.036
c6 10 vss 0.00319534f $X=0.54 $Y=0.234
c7 11 vss 0.00717809f $X=0.4665 $Y=0.036
c8 12 vss 0.00615816f $X=0.4755 $Y=0.234
c9 13 vss 0.00889201f $X=0.54 $Y=0.0855
r1 34 32 0.0308642 $w=8.1e-08 $l=2.5e-09 $layer=P_src_drn $thickness=1e-09
+ $X=0.5033 $Y=0.2025 $X2=0.5005 $Y2=0.2025
r2 2 32 0.179012 $w=8.1e-08 $l=1.45e-08 $layer=P_src_drn $thickness=1e-09
+ $X=0.486 $Y=0.2025 $X2=0.5005 $Y2=0.2025
r3 8 2 0.179012 $w=8.1e-08 $l=1.45e-08 $layer=P_src_drn $thickness=1e-09
+ $X=0.4715 $Y=0.2025 $X2=0.486 $Y2=0.2025
r4 33 8 0.0308642 $w=8.1e-08 $l=2.5e-09 $layer=P_src_drn $thickness=1e-09
+ $X=0.4686 $Y=0.2025 $X2=0.4715 $Y2=0.2025
r5 2 28 19.3796 $a=3.24e-16 $layer=V0LISD $X=0.486 $Y=0.2025 $X2=0.486 $Y2=0.234
r6 28 29 6.29612 $w=1.3e-08 $l=2.7e-08 $layer=M1 $thickness=3.6e-08 $X=0.486
+ $Y=0.234 $X2=0.513 $Y2=0.234
r7 12 28 2.44849 $w=1.3e-08 $l=1.05e-08 $layer=M1 $thickness=3.6e-08 $X=0.4755
+ $Y=0.234 $X2=0.486 $Y2=0.234
r8 10 27 2.5483 $w=1.79e-08 $l=1.8e-08 $layer=M1 $thickness=3.6e-08 $X=0.54
+ $Y=0.234 $X2=0.54 $Y2=0.216
r9 10 29 4.64701 $w=1.46667e-08 $l=2.7e-08 $layer=M1 $thickness=3.6e-08 $X=0.54
+ $Y=0.234 $X2=0.513 $Y2=0.234
r10 26 27 4.19742 $w=1.3e-08 $l=1.8e-08 $layer=M1 $thickness=3.6e-08 $X=0.54
+ $Y=0.198 $X2=0.54 $Y2=0.216
r11 25 26 5.01358 $w=1.3e-08 $l=2.15e-08 $layer=M1 $thickness=3.6e-08 $X=0.54
+ $Y=0.1765 $X2=0.54 $Y2=0.198
r12 24 25 4.78039 $w=1.3e-08 $l=2.05e-08 $layer=M1 $thickness=3.6e-08 $X=0.54
+ $Y=0.156 $X2=0.54 $Y2=0.1765
r13 23 24 1.98211 $w=1.3e-08 $l=8.5e-09 $layer=M1 $thickness=3.6e-08 $X=0.537
+ $Y=0.1475 $X2=0.54 $Y2=0.156
r14 23 22 0.46638 $w=1.3e-08 $l=2e-09 $layer=M1 $thickness=3.6e-08 $X=0.537
+ $Y=0.1475 $X2=0.54 $Y2=0.1455
r15 21 22 2.44849 $w=1.3e-08 $l=1.05e-08 $layer=M1 $thickness=3.6e-08 $X=0.54
+ $Y=0.135 $X2=0.54 $Y2=0.1455
r16 13 21 11.5429 $w=1.3e-08 $l=4.95e-08 $layer=M1 $thickness=3.6e-08 $X=0.54
+ $Y=0.0855 $X2=0.54 $Y2=0.135
r17 9 20 4.64701 $w=1.46667e-08 $l=2.7e-08 $layer=M1 $thickness=3.6e-08 $X=0.54
+ $Y=0.036 $X2=0.513 $Y2=0.036
r18 9 13 9.89378 $w=1.47818e-08 $l=4.95e-08 $layer=M1 $thickness=3.6e-08
+ $X=0.54 $Y=0.036 $X2=0.54 $Y2=0.0855
r19 19 20 6.29612 $w=1.3e-08 $l=2.7e-08 $layer=M1 $thickness=3.6e-08 $X=0.486
+ $Y=0.036 $X2=0.513 $Y2=0.036
r20 18 19 2.44849 $w=1.3e-08 $l=1.05e-08 $layer=M1 $thickness=3.6e-08 $X=0.4755
+ $Y=0.036 $X2=0.486 $Y2=0.036
r21 11 18 2.09871 $w=1.3e-08 $l=9e-09 $layer=M1 $thickness=3.6e-08 $X=0.4665
+ $Y=0.036 $X2=0.4755 $Y2=0.036
r22 1 19 19.3796 $a=3.24e-16 $layer=V0LISD $X=0.486 $Y=0.0675 $X2=0.486
+ $Y2=0.036
r23 17 15 0.0308642 $w=8.1e-08 $l=2.5e-09 $layer=N_src_drn $thickness=1e-09
+ $X=0.5033 $Y=0.0675 $X2=0.5005 $Y2=0.0675
r24 1 15 0.179012 $w=8.1e-08 $l=1.45e-08 $layer=N_src_drn $thickness=1e-09
+ $X=0.486 $Y=0.0675 $X2=0.5005 $Y2=0.0675
r25 7 1 0.179012 $w=8.1e-08 $l=1.45e-08 $layer=N_src_drn $thickness=1e-09
+ $X=0.4715 $Y=0.0675 $X2=0.486 $Y2=0.0675
r26 16 7 0.0308642 $w=8.1e-08 $l=2.5e-09 $layer=N_src_drn $thickness=1e-09
+ $X=0.4686 $Y=0.0675 $X2=0.4715 $Y2=0.0675
.ends

.subckt PM_AO221x2_ASAP7_75t_R%8 vss 26 32 46 50 72 73 77 85 86 14 4 3 23 22 16
+ 21 5 15 24 25 1 12 19 13
c1 1 vss 0.00878191f $X=0.4495 $Y=0.135
c2 3 vss 0.006482f $X=0.054 $Y=0.054
c3 4 vss 0.00994207f $X=0.108 $Y=0.2025
c4 5 vss 0.00617496f $X=0.216 $Y=0.054
c5 12 vss 0.0841827f $X=0.459 $Y=0.0245
c6 13 vss 0.0839894f $X=0.513 $Y=0.135
c7 14 vss 0.0297232f $X=0.056 $Y=0.054
c8 15 vss 0.00484672f $X=0.2015 $Y=0.054
c9 16 vss 0.00663765f $X=0.0935 $Y=0.2025
c10 17 vss 0.00323645f $X=0.027 $Y=0.036
c11 18 vss 0.00304098f $X=0.027 $Y=0.198
c12 19 vss 0.00317916f $X=0.405 $Y=0.036
c13 20 vss 0.00185585f $X=0.405 $Y=0.135
c14 21 vss 0.00823604f $X=0.027 $Y=0.0575
c15 22 vss 0.0353483f $X=0.3675 $Y=0.036
c16 23 vss 0.00952047f $X=0.0375 $Y=0.198
c17 24 vss 0.00497709f $X=0.405 $Y=0.098
c18 25 vss 0.00308227f $X=0.432 $Y=0.135
r1 86 84 0.0308642 $w=8.1e-08 $l=2.5e-09 $layer=P_src_drn $thickness=1e-09
+ $X=0.1253 $Y=0.2025 $X2=0.1225 $Y2=0.2025
r2 4 84 0.179012 $w=8.1e-08 $l=1.45e-08 $layer=P_src_drn $thickness=1e-09
+ $X=0.108 $Y=0.2025 $X2=0.1225 $Y2=0.2025
r3 16 4 0.179012 $w=8.1e-08 $l=1.45e-08 $layer=P_src_drn $thickness=1e-09
+ $X=0.0935 $Y=0.2025 $X2=0.108 $Y2=0.2025
r4 85 16 0.0308642 $w=8.1e-08 $l=2.5e-09 $layer=P_src_drn $thickness=1e-09
+ $X=0.0906 $Y=0.2025 $X2=0.0935 $Y2=0.2025
r5 4 81 19.3796 $a=3.24e-16 $layer=V0LISD $X=0.108 $Y=0.2025 $X2=0.108 $Y2=0.198
r6 80 81 3.14806 $w=1.3e-08 $l=1.35e-08 $layer=M1 $thickness=3.6e-08 $X=0.0945
+ $Y=0.198 $X2=0.108 $Y2=0.198
r7 79 80 3.14806 $w=1.3e-08 $l=1.35e-08 $layer=M1 $thickness=3.6e-08 $X=0.081
+ $Y=0.198 $X2=0.0945 $Y2=0.198
r8 78 79 5.94634 $w=1.3e-08 $l=2.55e-08 $layer=M1 $thickness=3.6e-08 $X=0.0555
+ $Y=0.198 $X2=0.081 $Y2=0.198
r9 23 78 4.19742 $w=1.3e-08 $l=1.8e-08 $layer=M1 $thickness=3.6e-08 $X=0.0375
+ $Y=0.198 $X2=0.0555 $Y2=0.198
r10 18 75 3.36447 $w=1.71023e-08 $l=2.15e-08 $layer=M1 $thickness=3.6e-08
+ $X=0.027 $Y=0.198 $X2=0.027 $Y2=0.1765
r11 18 23 0.79938 $w=1.72857e-08 $l=1.05e-08 $layer=M1 $thickness=3.6e-08
+ $X=0.027 $Y=0.198 $X2=0.0375 $Y2=0.198
r12 77 76 0.0462963 $w=5.4e-08 $l=2.5e-09 $layer=N_src_drn $thickness=1e-09
+ $X=0.0713 $Y=0.054 $X2=0.0685 $Y2=0.054
r13 14 76 0.231482 $w=5.4e-08 $l=1.25e-08 $layer=N_src_drn $thickness=1e-09
+ $X=0.056 $Y=0.054 $X2=0.0685 $Y2=0.054
r14 74 75 13.8748 $w=1.3e-08 $l=5.95e-08 $layer=M1 $thickness=3.6e-08 $X=0.027
+ $Y=0.117 $X2=0.027 $Y2=0.1765
r15 21 74 13.8748 $w=1.3e-08 $l=5.95e-08 $layer=M1 $thickness=3.6e-08 $X=0.027
+ $Y=0.0575 $X2=0.027 $Y2=0.117
r16 73 71 0.0462963 $w=5.4e-08 $l=2.5e-09 $layer=N_src_drn $thickness=1e-09
+ $X=0.2333 $Y=0.054 $X2=0.2305 $Y2=0.054
r17 5 71 0.268519 $w=5.4e-08 $l=1.45e-08 $layer=N_src_drn $thickness=1e-09
+ $X=0.216 $Y=0.054 $X2=0.2305 $Y2=0.054
r18 15 5 0.268519 $w=5.4e-08 $l=1.45e-08 $layer=N_src_drn $thickness=1e-09
+ $X=0.2015 $Y=0.054 $X2=0.216 $Y2=0.054
r19 72 15 0.0462963 $w=5.4e-08 $l=2.5e-09 $layer=N_src_drn $thickness=1e-09
+ $X=0.1986 $Y=0.054 $X2=0.2015 $Y2=0.054
r20 3 68 19.3796 $a=3.24e-16 $layer=V0LISD $X=0.054 $Y=0.054 $X2=0.054 $Y2=0.036
r21 17 67 1.49895 $w=1.63333e-08 $l=1.35e-08 $layer=M1 $thickness=3.6e-08
+ $X=0.027 $Y=0.036 $X2=0.0405 $Y2=0.036
r22 17 21 3.36447 $w=1.71023e-08 $l=2.15e-08 $layer=M1 $thickness=3.6e-08
+ $X=0.027 $Y=0.036 $X2=0.027 $Y2=0.0575
r23 5 58 19.3796 $a=3.24e-16 $layer=V0LISD $X=0.216 $Y=0.054 $X2=0.216 $Y2=0.036
r24 68 69 3.14806 $w=1.3e-08 $l=1.35e-08 $layer=M1 $thickness=3.6e-08 $X=0.054
+ $Y=0.036 $X2=0.0675 $Y2=0.036
r25 67 68 3.14806 $w=1.3e-08 $l=1.35e-08 $layer=M1 $thickness=3.6e-08 $X=0.0405
+ $Y=0.036 $X2=0.054 $Y2=0.036
r26 66 69 3.14806 $w=1.3e-08 $l=1.35e-08 $layer=M1 $thickness=3.6e-08 $X=0.081
+ $Y=0.036 $X2=0.0675 $Y2=0.036
r27 65 66 6.29612 $w=1.3e-08 $l=2.7e-08 $layer=M1 $thickness=3.6e-08 $X=0.108
+ $Y=0.036 $X2=0.081 $Y2=0.036
r28 64 65 6.29612 $w=1.3e-08 $l=2.7e-08 $layer=M1 $thickness=3.6e-08 $X=0.135
+ $Y=0.036 $X2=0.108 $Y2=0.036
r29 63 64 5.82974 $w=1.3e-08 $l=2.5e-08 $layer=M1 $thickness=3.6e-08 $X=0.16
+ $Y=0.036 $X2=0.135 $Y2=0.036
r30 62 63 4.19742 $w=1.3e-08 $l=1.8e-08 $layer=M1 $thickness=3.6e-08 $X=0.178
+ $Y=0.036 $X2=0.16 $Y2=0.036
r31 61 62 2.56509 $w=1.3e-08 $l=1.1e-08 $layer=M1 $thickness=3.6e-08 $X=0.189
+ $Y=0.036 $X2=0.178 $Y2=0.036
r32 60 61 2.3319 $w=1.3e-08 $l=1e-08 $layer=M1 $thickness=3.6e-08 $X=0.199
+ $Y=0.036 $X2=0.189 $Y2=0.036
r33 58 59 3.14806 $w=1.3e-08 $l=1.35e-08 $layer=M1 $thickness=3.6e-08 $X=0.216
+ $Y=0.036 $X2=0.2295 $Y2=0.036
r34 57 58 2.91487 $w=1.3e-08 $l=1.25e-08 $layer=M1 $thickness=3.6e-08 $X=0.2035
+ $Y=0.036 $X2=0.216 $Y2=0.036
r35 57 60 1.04935 $w=1.3e-08 $l=4.5e-09 $layer=M1 $thickness=3.6e-08 $X=0.2035
+ $Y=0.036 $X2=0.199 $Y2=0.036
r36 56 59 3.14806 $w=1.3e-08 $l=1.35e-08 $layer=M1 $thickness=3.6e-08 $X=0.243
+ $Y=0.036 $X2=0.2295 $Y2=0.036
r37 55 56 6.29612 $w=1.3e-08 $l=2.7e-08 $layer=M1 $thickness=3.6e-08 $X=0.27
+ $Y=0.036 $X2=0.243 $Y2=0.036
r38 54 55 6.29612 $w=1.3e-08 $l=2.7e-08 $layer=M1 $thickness=3.6e-08 $X=0.297
+ $Y=0.036 $X2=0.27 $Y2=0.036
r39 53 54 5.94634 $w=1.3e-08 $l=2.55e-08 $layer=M1 $thickness=3.6e-08 $X=0.3225
+ $Y=0.036 $X2=0.297 $Y2=0.036
r40 22 53 10.4935 $w=1.3e-08 $l=4.5e-08 $layer=M1 $thickness=3.6e-08 $X=0.3675
+ $Y=0.036 $X2=0.3225 $Y2=0.036
r41 19 52 3.36447 $w=1.71023e-08 $l=2.15e-08 $layer=M1 $thickness=3.6e-08
+ $X=0.405 $Y=0.036 $X2=0.405 $Y2=0.0575
r42 19 22 7.0955 $w=1.42e-08 $l=3.75e-08 $layer=M1 $thickness=3.6e-08 $X=0.405
+ $Y=0.036 $X2=0.3675 $Y2=0.036
r43 24 52 9.44419 $w=1.3e-08 $l=4.05e-08 $layer=M1 $thickness=3.6e-08 $X=0.405
+ $Y=0.098 $X2=0.405 $Y2=0.0575
r44 20 25 4.64701 $w=1.46667e-08 $l=2.7e-08 $layer=M1 $thickness=3.6e-08
+ $X=0.405 $Y=0.135 $X2=0.432 $Y2=0.135
r45 20 24 6.97891 $w=1.53838e-08 $l=3.7e-08 $layer=M1 $thickness=3.6e-08
+ $X=0.405 $Y=0.135 $X2=0.405 $Y2=0.098
r46 50 49 14.6259 $w=2.1e-08 $l=4.3e-08 $layer=Gate_1 $thickness=5.6e-08
+ $X=0.513 $Y=0.2025 $X2=0.513 $Y2=0.1595
r47 48 49 2.7211 $w=2.1e-08 $l=8e-09 $layer=Gate_1 $thickness=5.6e-08 $X=0.513
+ $Y=0.1515 $X2=0.513 $Y2=0.1595
r48 46 47 14.6259 $w=2.1e-08 $l=4.3e-08 $layer=Gate_1 $thickness=5.6e-08
+ $X=0.513 $Y=0.0675 $X2=0.513 $Y2=0.1105
r49 44 47 2.7211 $w=2.1e-08 $l=8e-09 $layer=Gate_1 $thickness=5.6e-08 $X=0.513
+ $Y=0.1185 $X2=0.513 $Y2=0.1105
r50 13 38 6.54019 $w=2.09524e-08 $layer=Gate_1 $thickness=5.21905e-08 $X=0.513
+ $Y=0.135 $X2=0.513 $Y2=0.135
r51 13 44 5.79936 $w=2.03333e-08 $l=1.65e-08 $layer=Gate_1 $thickness=5.6e-08
+ $X=0.513 $Y=0.135 $X2=0.513 $Y2=0.1185
r52 13 48 5.79936 $w=2.03333e-08 $l=1.65e-08 $layer=Gate_1 $thickness=5.6e-08
+ $X=0.513 $Y=0.135 $X2=0.513 $Y2=0.1515
r53 25 40 5.24677 $w=1.3e-08 $l=2.25e-08 $layer=M1 $thickness=3.6e-08 $X=0.432
+ $Y=0.135 $X2=0.4545 $Y2=0.135
r54 37 38 12.6539 $w=1.77815e-08 $l=2.7e-08 $layer=LIG $thickness=4.8e-08
+ $X=0.486 $Y=0.135 $X2=0.513 $Y2=0.135
r55 35 37 10.1729 $w=1.54914e-08 $l=1.75e-08 $layer=LIG $thickness=4.8e-08
+ $X=0.4685 $Y=0.135 $X2=0.486 $Y2=0.135
r56 34 35 2.48102 $w=2.2e-08 $l=9.5e-09 $layer=LIG $thickness=4.8e-08 $X=0.459
+ $Y=0.135 $X2=0.4685 $Y2=0.135
r57 34 40 19.3796 $a=3.24e-16 $layer=V0LIG $X=0.459 $Y=0.135 $X2=0.4545
+ $Y2=0.135
r58 1 34 2.48102 $w=2.2e-08 $l=9.5e-09 $layer=LIG $thickness=4.8e-08 $X=0.4495
+ $Y=0.135 $X2=0.459 $Y2=0.135
r59 32 31 14.6259 $w=2.1e-08 $l=4.3e-08 $layer=Gate_1 $thickness=5.6e-08
+ $X=0.459 $Y=0.2025 $X2=0.459 $Y2=0.1595
r60 30 31 2.7211 $w=2.1e-08 $l=8e-09 $layer=Gate_1 $thickness=5.6e-08 $X=0.459
+ $Y=0.1515 $X2=0.459 $Y2=0.1595
r61 29 30 5.79936 $w=2.03333e-08 $l=1.65e-08 $layer=Gate_1 $thickness=5.6e-08
+ $X=0.459 $Y=0.135 $X2=0.459 $Y2=0.1515
r62 29 35 4.05918 $w=2.0087e-08 $l=9.5e-09 $layer=Gate_1 $thickness=5.56522e-08
+ $X=0.459 $Y=0.135 $X2=0.4685 $Y2=0.135
r63 29 34 6.27904 $w=2.09e-08 $layer=Gate_1 $thickness=5.24e-08 $X=0.459
+ $Y=0.135 $X2=0.459 $Y2=0.135
r64 28 29 5.79936 $w=2.03333e-08 $l=1.65e-08 $layer=Gate_1 $thickness=5.6e-08
+ $X=0.459 $Y=0.1185 $X2=0.459 $Y2=0.135
r65 27 28 2.7211 $w=2.1e-08 $l=8e-09 $layer=Gate_1 $thickness=5.6e-08 $X=0.459
+ $Y=0.1105 $X2=0.459 $Y2=0.1185
r66 26 27 14.6259 $w=2.1e-08 $l=4.3e-08 $layer=Gate_1 $thickness=5.6e-08
+ $X=0.459 $Y=0.0675 $X2=0.459 $Y2=0.1105
r67 26 12 14.6259 $w=2.1e-08 $l=4.3e-08 $layer=Gate_1 $thickness=5.6e-08
+ $X=0.459 $Y=0.0675 $X2=0.459 $Y2=0.0245
r68 3 14 1e-05 $l=2e-09 $X=0.054 $Y=0.054 $X2=0.056 $Y2=0.054
.ends

.subckt PM_AO221x2_ASAP7_75t_R%B2 vss 11 5 9 4 3 1
c1 1 vss 0.00594906f $X=0.135 $Y=0.135
c2 3 vss 0.090251f $X=0.135 $Y=0.0245
c3 4 vss 0.00414026f $X=0.135 $Y=0.0892
r1 12 13 4.02252 $w=1.3e-08 $l=1.73e-08 $layer=M1 $thickness=3.6e-08 $X=0.135
+ $Y=0.1177 $X2=0.135 $Y2=0.135
r2 11 12 2.04041 $w=1.3e-08 $l=8.7e-09 $layer=M1 $thickness=3.6e-08 $X=0.133
+ $Y=0.109 $X2=0.135 $Y2=0.1177
r3 11 4 4.6055 $w=1.3e-08 $l=1.98e-08 $layer=M1 $thickness=3.6e-08 $X=0.133
+ $Y=0.109 $X2=0.135 $Y2=0.0892
r4 1 7 10.4265 $w=1.765e-08 $layer=LIG $thickness=5.2e-08 $X=0.135 $Y=0.135
+ $X2=0.135 $Y2=0.135
r5 1 13 19.3796 $a=3.24e-16 $layer=V0LIG $X=0.135 $Y=0.135 $X2=0.135 $Y2=0.135
r6 9 8 16.4967 $w=2.1e-08 $l=4.85e-08 $layer=Gate_1 $thickness=5.6e-08 $X=0.135
+ $Y=0.2025 $X2=0.135 $Y2=0.154
r7 7 8 6.6497 $w=2.04211e-08 $l=1.9e-08 $layer=Gate_1 $thickness=5.6e-08
+ $X=0.135 $Y=0.135 $X2=0.135 $Y2=0.154
r8 6 7 11.2416 $w=2.06615e-08 $l=3.25e-08 $layer=Gate_1 $thickness=5.6e-08
+ $X=0.135 $Y=0.1025 $X2=0.135 $Y2=0.135
r9 5 6 16.4967 $w=2.1e-08 $l=4.85e-08 $layer=Gate_1 $thickness=5.6e-08 $X=0.135
+ $Y=0.054 $X2=0.135 $Y2=0.1025
r10 5 3 10.0341 $w=2.1e-08 $l=2.95e-08 $layer=Gate_1 $thickness=5.6e-08
+ $X=0.135 $Y=0.054 $X2=0.135 $Y2=0.0245
.ends

.subckt PM_AO221x2_ASAP7_75t_R%B1 vss 15 5 11 4 3 1
c1 1 vss 0.00333577f $X=0.081 $Y=0.135
c2 3 vss 0.0691937f $X=0.081 $Y=0.0245
c3 4 vss 0.00576217f $X=0.081 $Y=0.098
r1 15 14 0.524677 $w=1.3e-08 $l=2.3e-09 $layer=M1 $thickness=3.6e-08 $X=0.076
+ $Y=0.148 $X2=0.081 $Y2=0.1457
r2 13 14 2.50679 $w=1.3e-08 $l=1.07e-08 $layer=M1 $thickness=3.6e-08 $X=0.081
+ $Y=0.135 $X2=0.081 $Y2=0.1457
r3 4 13 8.62802 $w=1.3e-08 $l=3.7e-08 $layer=M1 $thickness=3.6e-08 $X=0.081
+ $Y=0.098 $X2=0.081 $Y2=0.135
r4 1 8 10.4265 $w=1.765e-08 $layer=LIG $thickness=5.2e-08 $X=0.081 $Y=0.135
+ $X2=0.081 $Y2=0.135
r5 1 13 19.3796 $a=3.24e-16 $layer=V0LIG $X=0.081 $Y=0.135 $X2=0.081 $Y2=0.135
r6 11 10 14.6259 $w=2.1e-08 $l=4.3e-08 $layer=Gate_1 $thickness=5.6e-08
+ $X=0.081 $Y=0.2025 $X2=0.081 $Y2=0.1595
r7 9 10 2.7211 $w=2.1e-08 $l=8e-09 $layer=Gate_1 $thickness=5.6e-08 $X=0.081
+ $Y=0.1515 $X2=0.081 $Y2=0.1595
r8 8 9 5.79936 $w=2.03333e-08 $l=1.65e-08 $layer=Gate_1 $thickness=5.6e-08
+ $X=0.081 $Y=0.135 $X2=0.081 $Y2=0.1515
r9 7 8 5.79936 $w=2.03333e-08 $l=1.65e-08 $layer=Gate_1 $thickness=5.6e-08
+ $X=0.081 $Y=0.1185 $X2=0.081 $Y2=0.135
r10 6 7 7.31297 $w=2.1e-08 $l=2.15e-08 $layer=Gate_1 $thickness=5.6e-08
+ $X=0.081 $Y=0.097 $X2=0.081 $Y2=0.1185
r11 5 6 14.6259 $w=2.1e-08 $l=4.3e-08 $layer=Gate_1 $thickness=5.6e-08 $X=0.081
+ $Y=0.054 $X2=0.081 $Y2=0.097
r12 5 3 10.0341 $w=2.1e-08 $l=2.95e-08 $layer=Gate_1 $thickness=5.6e-08
+ $X=0.081 $Y=0.054 $X2=0.081 $Y2=0.0245
.ends

* End of included file AO221x2_ASAP7_75t_R.pex.sp.pex

*
.subckt AO221x2_ASAP7_75t_CUSTOM_4_25_0_7 VSS VDD B1 B2 C A1 A2 Y
*
* VSS VSS
* VDD VDD
* B1 B1
* B2 B2
* C C
* A1 A1
* A2 A2
* Y Y
*
*

M0 noxref_12 N_M0_g N_M0_s VSS nmos_rvt L=2e-08 W=5.4e-08 nfin=2 $X=0.071
+ $Y=0.027
M1 VSS N_M1_g noxref_12 VSS nmos_rvt L=2e-08 W=5.4e-08 nfin=2 $X=0.125 $Y=0.027
M2 N_M2_d N_M2_g VSS VSS nmos_rvt L=2e-08 W=5.4e-08 nfin=2 $X=0.179 $Y=0.027
M3 noxref_13 N_M3_g N_M3_s VSS nmos_rvt L=2e-08 W=5.4e-08 nfin=2 $X=0.233
+ $Y=0.027
M4 VSS N_M4_g noxref_13 VSS nmos_rvt L=2e-08 W=5.4e-08 nfin=2 $X=0.287 $Y=0.027
M5 N_M5_d N_M5_g VSS VSS nmos_rvt L=2e-08 W=8.1e-08 nfin=3 $X=0.449 $Y=0.027
M6 N_M6_d N_M6_g VSS VSS nmos_rvt L=2e-08 W=8.1e-08 nfin=3 $X=0.503 $Y=0.027
M7 N_M7_d N_M7_g noxref_9 VDD pmos_rvt L=2e-08 W=8.1e-08 nfin=3 $X=0.071
+ $Y=0.162
M8 noxref_9 N_M8_g N_M8_s VDD pmos_rvt L=2e-08 W=8.1e-08 nfin=3 $X=0.125
+ $Y=0.162
M9 noxref_10 N_M9_g noxref_9 VDD pmos_rvt L=2e-08 W=8.1e-08 nfin=3 $X=0.179
+ $Y=0.162
M10 VDD N_M10_g noxref_10 VDD pmos_rvt L=2e-08 W=8.1e-08 nfin=3 $X=0.233
+ $Y=0.162
M11 noxref_10 N_M11_g VDD VDD pmos_rvt L=2e-08 W=8.1e-08 nfin=3 $X=0.287
+ $Y=0.162
M12 N_M12_d N_M12_g VDD VDD pmos_rvt L=2e-08 W=8.1e-08 nfin=3 $X=0.449 $Y=0.162
M13 N_M13_d N_M13_g VDD VDD pmos_rvt L=2e-08 W=8.1e-08 nfin=3 $X=0.503 $Y=0.162

* .include "AO221x2_ASAP7_75t_R.pex.sp.pxi"

* Start of included file AO221x2_ASAP7_75t_R.pex.sp.pxi
x_PM_AO221x2_ASAP7_75t_R%C vss C N_M2_g N_M9_g N_C_4 N_C_3
+ PM_AO221x2_ASAP7_75t_R%C
cc_1 N_C_4 N_B2_4 0.00337279f $X=0.189 $Y=0.0962
cc_2 N_C_3 N_B2_3 0.00715272f $X=0.189 $Y=0.0245
x_PM_AO221x2_ASAP7_75t_R%A1 vss A1 N_M3_g N_M10_g N_A1_4 N_A1_3
+ PM_AO221x2_ASAP7_75t_R%A1
cc_3 N_A1_4 N_C_4 0.00330417f $X=0.243 $Y=0.098
cc_4 N_A1_3 N_C_3 0.00713846f $X=0.243 $Y=0.0245
x_PM_AO221x2_ASAP7_75t_R%A2 vss A2 N_M4_g N_M11_g N_A2_4 N_A2_3
+ PM_AO221x2_ASAP7_75t_R%A2
cc_5 N_A2_4 N_A1_4 0.00332922f $X=0.297 $Y=0.0962
cc_6 N_A2_3 N_A1_3 0.00863057f $X=0.297 $Y=0.0245
x_PM_AO221x2_ASAP7_75t_R%Y vss Y N_M5_d N_M6_d N_M12_d N_M13_d N_Y_8 N_Y_2
+ N_Y_7 PM_AO221x2_ASAP7_75t_R%Y
cc_7 N_Y_8 N_8_25 0.00148264f $X=0.4715 $Y=0.2025
cc_8 N_Y_8 N_8_24 0.000544781f $X=0.4715 $Y=0.2025
cc_9 N_Y_8 N_8_1 0.00720501f $X=0.4715 $Y=0.2025
cc_10 N_Y_8 N_8_12 0.0199376f $X=0.4715 $Y=0.2025
cc_11 N_Y_8 N_8_19 0.000856272f $X=0.4715 $Y=0.2025
cc_12 N_Y_2 N_8_13 0.00168332f $X=0.486 $Y=0.2025
cc_13 N_Y_7 N_8_13 0.0102264f $X=0.4715 $Y=0.0675
cc_14 N_Y_7 N_8_12 0.0546279f $X=0.4715 $Y=0.0675
cc_15 N_Y_8 N_8_13 0.04899f $X=0.4715 $Y=0.2025
x_PM_AO221x2_ASAP7_75t_R%8 vss N_M5_g N_M12_g N_M6_g N_M13_g N_M2_d N_M3_s
+ N_M0_s N_M7_d N_M8_s N_8_14 N_8_4 N_8_3 N_8_23 N_8_22 N_8_16 N_8_21 N_8_5
+ N_8_15 N_8_24 N_8_25 N_8_1 N_8_12 N_8_19 N_8_13 PM_AO221x2_ASAP7_75t_R%8
cc_16 N_8_14 N_B1_3 0.011264f $X=0.056 $Y=0.054
cc_17 N_8_4 N_B1_3 0.00159013f $X=0.108 $Y=0.2025
cc_18 N_8_3 N_B1_3 0.000914512f $X=0.054 $Y=0.054
cc_19 N_8_23 N_B1_4 0.00097929f $X=0.0375 $Y=0.198
cc_20 N_8_22 N_B1_4 0.00111222f $X=0.3675 $Y=0.036
cc_21 N_8_16 N_B1_1 0.00126646f $X=0.0935 $Y=0.2025
cc_22 N_8_21 N_B1_4 0.00652273f $X=0.027 $Y=0.0575
cc_23 N_8_16 N_B1_3 0.0502562f $X=0.0935 $Y=0.2025
cc_24 N_8_4 N_B2_3 0.00122513f $X=0.108 $Y=0.2025
cc_25 N_8_23 N_B2_3 0.000587036f $X=0.0375 $Y=0.198
cc_26 N_8_16 N_B2_1 0.000856813f $X=0.0935 $Y=0.2025
cc_27 N_8_22 N_B2_4 0.00128986f $X=0.3675 $Y=0.036
cc_28 N_8_4 N_B2_4 0.00224981f $X=0.108 $Y=0.2025
cc_29 N_8_16 N_B2_3 0.0360761f $X=0.0935 $Y=0.2025
cc_30 N_8_5 N_C_3 0.000626125f $X=0.216 $Y=0.054
cc_31 N_8_22 N_C_3 0.0011426f $X=0.3675 $Y=0.036
cc_32 N_8_5 N_C_4 0.00172177f $X=0.216 $Y=0.054
cc_33 N_8_15 N_C_3 0.0260389f $X=0.2015 $Y=0.054
cc_34 N_8_5 N_A1_3 0.000873047f $X=0.216 $Y=0.054
cc_35 N_8_22 N_A1_4 0.00123246f $X=0.3675 $Y=0.036
cc_36 N_8_5 N_A1_4 0.0017304f $X=0.216 $Y=0.054
cc_37 N_8_15 N_A1_3 0.0266103f $X=0.2015 $Y=0.054
cc_38 N_8_5 N_A2_4 0.00025375f $X=0.216 $Y=0.054
cc_39 N_8_24 N_A2_4 0.000271902f $X=0.405 $Y=0.098
cc_40 N_8_22 N_A2_4 0.00417409f $X=0.3675 $Y=0.036
x_PM_AO221x2_ASAP7_75t_R%B2 vss B2 N_M1_g N_M8_g N_B2_4 N_B2_3 N_B2_1
+ PM_AO221x2_ASAP7_75t_R%B2
cc_41 N_B2_4 N_B1_4 0.00330967f $X=0.135 $Y=0.0892
cc_42 N_B2_3 N_B1_3 0.0085892f $X=0.135 $Y=0.0245
x_PM_AO221x2_ASAP7_75t_R%B1 vss B1 N_M0_g N_M7_g N_B1_4 N_B1_3 N_B1_1
+ PM_AO221x2_ASAP7_75t_R%B1

* End of included file AO221x2_ASAP7_75t_R.pex.sp.pxi
.ends

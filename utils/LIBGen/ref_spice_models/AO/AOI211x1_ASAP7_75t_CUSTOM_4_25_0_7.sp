.subckt PM_AOI211x1_ASAP7_75t_R%B vss 27 8 12 24 4 5
c1 1 vss 0.0155329f $X=0.459 $Y=0.135
c2 3 vss 0.135398f $X=0.405 $Y=0.135
c3 4 vss 0.120992f $X=0.459 $Y=0.0245
c4 5 vss 0.00296838f $X=0.405 $Y=0.072
c5 6 vss 0.00758411f $X=0.405 $Y=0.162
c6 7 vss 0.00430059f $X=0.405 $Y=0.135
r1 6 29 1.96775 $w=1.63333e-08 $l=1.35e-08 $layer=M1 $thickness=3.6e-08
+ $X=0.405 $Y=0.162 $X2=0.405 $Y2=0.1485
r2 5 26 4.59114 $w=1.48182e-08 $l=2.47e-08 $layer=M1 $thickness=3.6e-08
+ $X=0.405 $Y=0.072 $X2=0.405 $Y2=0.0967
r3 27 28 1.57403 $w=1.3e-08 $l=6.7e-09 $layer=M1 $thickness=3.6e-08 $X=0.405
+ $Y=0.113 $X2=0.405 $Y2=0.1197
r4 27 26 3.78933 $w=1.3e-08 $l=1.63e-08 $layer=M1 $thickness=3.6e-08 $X=0.405
+ $Y=0.113 $X2=0.405 $Y2=0.0967
r5 7 16 19.3796 $a=3.24e-16 $layer=V0LIG $X=0.405 $Y=0.135 $X2=0.405 $Y2=0.135
r6 7 28 3.55614 $w=1.3e-08 $l=1.53e-08 $layer=M1 $thickness=3.6e-08 $X=0.405
+ $Y=0.135 $X2=0.405 $Y2=0.1197
r7 7 29 3.14806 $w=1.3e-08 $l=1.35e-08 $layer=M1 $thickness=3.6e-08 $X=0.405
+ $Y=0.135 $X2=0.405 $Y2=0.1485
r8 24 23 14.6259 $w=2.1e-08 $l=4.3e-08 $layer=Gate_1 $thickness=5.6e-08
+ $X=0.405 $Y=0.2025 $X2=0.405 $Y2=0.1595
r9 22 23 2.7211 $w=2.1e-08 $l=8e-09 $layer=Gate_1 $thickness=5.6e-08 $X=0.405
+ $Y=0.1515 $X2=0.405 $Y2=0.1595
r10 3 16 6.27904 $w=2.09e-08 $layer=Gate_1 $thickness=5.24e-08 $X=0.405
+ $Y=0.135 $X2=0.405 $Y2=0.135
r11 3 22 5.79936 $w=2.03333e-08 $l=1.65e-08 $layer=Gate_1 $thickness=5.6e-08
+ $X=0.405 $Y=0.135 $X2=0.405 $Y2=0.1515
r12 16 17 2.48102 $w=2.2e-08 $l=9.5e-09 $layer=LIG $thickness=4.8e-08 $X=0.405
+ $Y=0.135 $X2=0.4145 $Y2=0.135
r13 14 17 10.1729 $w=1.54914e-08 $l=1.75e-08 $layer=LIG $thickness=4.8e-08
+ $X=0.432 $Y=0.135 $X2=0.4145 $Y2=0.135
r14 1 10 6.54019 $w=2.09524e-08 $layer=Gate_1 $thickness=5.21905e-08 $X=0.459
+ $Y=0.135 $X2=0.459 $Y2=0.135
r15 1 14 12.6539 $w=1.77815e-08 $l=2.7e-08 $layer=LIG $thickness=4.8e-08
+ $X=0.459 $Y=0.135 $X2=0.432 $Y2=0.135
r16 12 11 16.4967 $w=2.1e-08 $l=4.85e-08 $layer=Gate_1 $thickness=5.6e-08
+ $X=0.459 $Y=0.2025 $X2=0.459 $Y2=0.154
r17 10 11 6.6497 $w=2.04211e-08 $l=1.9e-08 $layer=Gate_1 $thickness=5.6e-08
+ $X=0.459 $Y=0.135 $X2=0.459 $Y2=0.154
r18 9 10 6.6497 $w=2.04211e-08 $l=1.9e-08 $layer=Gate_1 $thickness=5.6e-08
+ $X=0.459 $Y=0.116 $X2=0.459 $Y2=0.135
r19 8 9 16.4967 $w=2.1e-08 $l=4.85e-08 $layer=Gate_1 $thickness=5.6e-08
+ $X=0.459 $Y=0.0675 $X2=0.459 $Y2=0.116
r20 8 4 14.6259 $w=2.1e-08 $l=4.3e-08 $layer=Gate_1 $thickness=5.6e-08 $X=0.459
+ $Y=0.0675 $X2=0.459 $Y2=0.0245
.ends

.subckt PM_AOI211x1_ASAP7_75t_R%C vss 32 9 13 28 3 6 1 4 7 5
c1 1 vss 0.014088f $X=0.513 $Y=0.135
c2 3 vss 0.0843234f $X=0.513 $Y=0.0245
c3 4 vss 0.0961938f $X=0.567 $Y=0.135
c4 5 vss 0.00385216f $X=0.513 $Y=0.072
c5 6 vss 0.00383061f $X=0.513 $Y=0.135
c6 7 vss 0.00282759f $X=0.5265 $Y=0.135
c7 8 vss 0.00326698f $X=0.513 $Y=0.1012
r1 5 8 5.64049 $w=1.45385e-08 $l=2.92e-08 $layer=M1 $thickness=3.6e-08 $X=0.513
+ $Y=0.072 $X2=0.513 $Y2=0.1012
r2 32 33 0.524677 $w=1.3e-08 $l=2.2e-09 $layer=M1 $thickness=3.6e-08 $X=0.516
+ $Y=0.122 $X2=0.513 $Y2=0.1242
r3 32 8 4.83869 $w=1.3e-08 $l=2.08e-08 $layer=M1 $thickness=3.6e-08 $X=0.516
+ $Y=0.122 $X2=0.513 $Y2=0.1012
r4 6 7 1.96775 $w=1.63333e-08 $l=1.35e-08 $layer=M1 $thickness=3.6e-08 $X=0.513
+ $Y=0.135 $X2=0.5265 $Y2=0.135
r5 6 33 1.32648 $w=1.7186e-08 $l=1.08e-08 $layer=M1 $thickness=3.6e-08 $X=0.513
+ $Y=0.135 $X2=0.513 $Y2=0.1242
r6 28 27 14.6259 $w=2.1e-08 $l=4.3e-08 $layer=Gate_1 $thickness=5.6e-08
+ $X=0.567 $Y=0.2025 $X2=0.567 $Y2=0.1595
r7 26 27 2.7211 $w=2.1e-08 $l=8e-09 $layer=Gate_1 $thickness=5.6e-08 $X=0.567
+ $Y=0.1515 $X2=0.567 $Y2=0.1595
r8 4 19 6.54019 $w=2.09524e-08 $layer=Gate_1 $thickness=5.21905e-08 $X=0.567
+ $Y=0.135 $X2=0.567 $Y2=0.135
r9 4 26 5.79936 $w=2.03333e-08 $l=1.65e-08 $layer=Gate_1 $thickness=5.6e-08
+ $X=0.567 $Y=0.135 $X2=0.567 $Y2=0.1515
r10 7 21 3.14806 $w=1.3e-08 $l=1.35e-08 $layer=M1 $thickness=3.6e-08 $X=0.5265
+ $Y=0.135 $X2=0.54 $Y2=0.135
r11 18 19 4.97449 $w=2.00857e-08 $l=1.4e-08 $layer=LIG $thickness=4.8e-08
+ $X=0.553 $Y=0.135 $X2=0.567 $Y2=0.135
r12 17 18 7.6794 $w=1.53e-08 $l=1.3e-08 $layer=LIG $thickness=4.8e-08 $X=0.54
+ $Y=0.135 $X2=0.553 $Y2=0.135
r13 17 21 19.3796 $a=3.24e-16 $layer=V0LIG $X=0.54 $Y=0.135 $X2=0.54 $Y2=0.135
r14 16 17 7.6794 $w=1.53e-08 $l=1.3e-08 $layer=LIG $thickness=4.8e-08 $X=0.527
+ $Y=0.135 $X2=0.54 $Y2=0.135
r15 1 11 6.54019 $w=2.09524e-08 $layer=Gate_1 $thickness=5.21905e-08 $X=0.513
+ $Y=0.135 $X2=0.513 $Y2=0.135
r16 1 16 4.97449 $w=2.00857e-08 $l=1.4e-08 $layer=LIG $thickness=4.8e-08
+ $X=0.513 $Y=0.135 $X2=0.527 $Y2=0.135
r17 13 12 16.4967 $w=2.1e-08 $l=4.85e-08 $layer=Gate_1 $thickness=5.6e-08
+ $X=0.513 $Y=0.2025 $X2=0.513 $Y2=0.154
r18 11 12 6.6497 $w=2.04211e-08 $l=1.9e-08 $layer=Gate_1 $thickness=5.6e-08
+ $X=0.513 $Y=0.135 $X2=0.513 $Y2=0.154
r19 10 11 6.6497 $w=2.04211e-08 $l=1.9e-08 $layer=Gate_1 $thickness=5.6e-08
+ $X=0.513 $Y=0.116 $X2=0.513 $Y2=0.135
r20 9 10 16.4967 $w=2.1e-08 $l=4.85e-08 $layer=Gate_1 $thickness=5.6e-08
+ $X=0.513 $Y=0.0675 $X2=0.513 $Y2=0.116
r21 9 3 14.6259 $w=2.1e-08 $l=4.3e-08 $layer=Gate_1 $thickness=5.6e-08 $X=0.513
+ $Y=0.0675 $X2=0.513 $Y2=0.0245
.ends

.subckt PM_AOI211x1_ASAP7_75t_R%Y vss 40 19 37 38 54 55 15 10 1 2 11 16 17 3 12
c1 1 vss 0.00578789f $X=0.108 $Y=0.0675
c2 2 vss 0.00862432f $X=0.486 $Y=0.0675
c3 3 vss 0.00942123f $X=0.54 $Y=0.2025
c4 10 vss 0.0024599f $X=0.11 $Y=0.0675
c5 11 vss 0.00435229f $X=0.4715 $Y=0.0675
c6 12 vss 0.00432278f $X=0.5255 $Y=0.2025
c7 13 vss 0.00287481f $X=0.621 $Y=0.036
c8 14 vss 0.00231638f $X=0.621 $Y=0.198
c9 15 vss 0.0481112f $X=0.095 $Y=0.036
c10 16 vss 0.00920095f $X=0.61 $Y=0.198
c11 17 vss 0.0057702f $X=0.621 $Y=0.054
r1 55 53 0.0308642 $w=8.1e-08 $l=2.5e-09 $layer=P_src_drn $thickness=1e-09
+ $X=0.5573 $Y=0.2025 $X2=0.5545 $Y2=0.2025
r2 3 53 0.179012 $w=8.1e-08 $l=1.45e-08 $layer=P_src_drn $thickness=1e-09
+ $X=0.54 $Y=0.2025 $X2=0.5545 $Y2=0.2025
r3 12 3 0.179012 $w=8.1e-08 $l=1.45e-08 $layer=P_src_drn $thickness=1e-09
+ $X=0.5255 $Y=0.2025 $X2=0.54 $Y2=0.2025
r4 54 12 0.0308642 $w=8.1e-08 $l=2.5e-09 $layer=P_src_drn $thickness=1e-09
+ $X=0.5226 $Y=0.2025 $X2=0.5255 $Y2=0.2025
r5 3 49 19.3796 $a=3.24e-16 $layer=V0LISD $X=0.54 $Y=0.2025 $X2=0.54 $Y2=0.198
r6 49 50 2.68168 $w=1.3e-08 $l=1.15e-08 $layer=M1 $thickness=3.6e-08 $X=0.54
+ $Y=0.198 $X2=0.5515 $Y2=0.198
r7 47 50 6.8791 $w=1.3e-08 $l=2.95e-08 $layer=M1 $thickness=3.6e-08 $X=0.581
+ $Y=0.198 $X2=0.5515 $Y2=0.198
r8 16 47 6.7625 $w=1.3e-08 $l=2.9e-08 $layer=M1 $thickness=3.6e-08 $X=0.61
+ $Y=0.198 $X2=0.581 $Y2=0.198
r9 14 46 2.5483 $w=1.79e-08 $l=1.8e-08 $layer=M1 $thickness=3.6e-08 $X=0.621
+ $Y=0.198 $X2=0.621 $Y2=0.18
r10 14 16 0.915974 $w=1.70909e-08 $l=1.1e-08 $layer=M1 $thickness=3.6e-08
+ $X=0.621 $Y=0.198 $X2=0.61 $Y2=0.198
r11 45 46 2.91487 $w=1.3e-08 $l=1.25e-08 $layer=M1 $thickness=3.6e-08 $X=0.621
+ $Y=0.1675 $X2=0.621 $Y2=0.18
r12 44 45 3.14806 $w=1.3e-08 $l=1.35e-08 $layer=M1 $thickness=3.6e-08 $X=0.621
+ $Y=0.154 $X2=0.621 $Y2=0.1675
r13 43 44 4.43061 $w=1.3e-08 $l=1.9e-08 $layer=M1 $thickness=3.6e-08 $X=0.621
+ $Y=0.135 $X2=0.621 $Y2=0.154
r14 42 43 7.34548 $w=1.3e-08 $l=3.15e-08 $layer=M1 $thickness=3.6e-08 $X=0.621
+ $Y=0.1035 $X2=0.621 $Y2=0.135
r15 41 42 6.70421 $w=1.3e-08 $l=2.88e-08 $layer=M1 $thickness=3.6e-08 $X=0.621
+ $Y=0.0747 $X2=0.621 $Y2=0.1035
r16 40 41 1.57403 $w=1.3e-08 $l=6.7e-09 $layer=M1 $thickness=3.6e-08 $X=0.624
+ $Y=0.068 $X2=0.621 $Y2=0.0747
r17 40 39 0.641272 $w=1.3e-08 $l=2.8e-09 $layer=M1 $thickness=3.6e-08 $X=0.624
+ $Y=0.068 $X2=0.621 $Y2=0.0652
r18 17 39 2.62338 $w=1.3e-08 $l=1.12e-08 $layer=M1 $thickness=3.6e-08 $X=0.621
+ $Y=0.054 $X2=0.621 $Y2=0.0652
r19 38 36 0.0308642 $w=8.1e-08 $l=2.5e-09 $layer=N_src_drn $thickness=1e-09
+ $X=0.5033 $Y=0.0675 $X2=0.5005 $Y2=0.0675
r20 2 36 0.179012 $w=8.1e-08 $l=1.45e-08 $layer=N_src_drn $thickness=1e-09
+ $X=0.486 $Y=0.0675 $X2=0.5005 $Y2=0.0675
r21 11 2 0.179012 $w=8.1e-08 $l=1.45e-08 $layer=N_src_drn $thickness=1e-09
+ $X=0.4715 $Y=0.0675 $X2=0.486 $Y2=0.0675
r22 37 11 0.0308642 $w=8.1e-08 $l=2.5e-09 $layer=N_src_drn $thickness=1e-09
+ $X=0.4686 $Y=0.0675 $X2=0.4715 $Y2=0.0675
r23 13 34 7.2121 $w=1.41842e-08 $l=3.8e-08 $layer=M1 $thickness=3.6e-08
+ $X=0.621 $Y=0.036 $X2=0.583 $Y2=0.036
r24 13 17 2.5483 $w=1.79e-08 $l=1.8e-08 $layer=M1 $thickness=3.6e-08 $X=0.621
+ $Y=0.036 $X2=0.621 $Y2=0.054
r25 2 30 19.3796 $a=3.24e-16 $layer=V0LISD $X=0.486 $Y=0.0675 $X2=0.486
+ $Y2=0.036
r26 33 34 7.22888 $w=1.3e-08 $l=3.1e-08 $layer=M1 $thickness=3.6e-08 $X=0.552
+ $Y=0.036 $X2=0.583 $Y2=0.036
r27 32 33 5.82974 $w=1.3e-08 $l=2.5e-08 $layer=M1 $thickness=3.6e-08 $X=0.527
+ $Y=0.036 $X2=0.552 $Y2=0.036
r28 31 32 6.41272 $w=1.3e-08 $l=2.75e-08 $layer=M1 $thickness=3.6e-08 $X=0.4995
+ $Y=0.036 $X2=0.527 $Y2=0.036
r29 30 31 3.14806 $w=1.3e-08 $l=1.35e-08 $layer=M1 $thickness=3.6e-08 $X=0.486
+ $Y=0.036 $X2=0.4995 $Y2=0.036
r30 29 30 5.36336 $w=1.3e-08 $l=2.3e-08 $layer=M1 $thickness=3.6e-08 $X=0.463
+ $Y=0.036 $X2=0.486 $Y2=0.036
r31 28 29 4.08082 $w=1.3e-08 $l=1.75e-08 $layer=M1 $thickness=3.6e-08 $X=0.4455
+ $Y=0.036 $X2=0.463 $Y2=0.036
r32 27 28 6.17953 $w=1.3e-08 $l=2.65e-08 $layer=M1 $thickness=3.6e-08 $X=0.419
+ $Y=0.036 $X2=0.4455 $Y2=0.036
r33 26 27 17.9556 $w=1.3e-08 $l=7.7e-08 $layer=M1 $thickness=3.6e-08 $X=0.342
+ $Y=0.036 $X2=0.419 $Y2=0.036
r34 25 26 19.4713 $w=1.3e-08 $l=8.35e-08 $layer=M1 $thickness=3.6e-08 $X=0.2585
+ $Y=0.036 $X2=0.342 $Y2=0.036
r35 24 25 7.92845 $w=1.3e-08 $l=3.4e-08 $layer=M1 $thickness=3.6e-08 $X=0.2245
+ $Y=0.036 $X2=0.2585 $Y2=0.036
r36 23 24 5.71315 $w=1.3e-08 $l=2.45e-08 $layer=M1 $thickness=3.6e-08 $X=0.2
+ $Y=0.036 $X2=0.2245 $Y2=0.036
r37 22 23 11.3097 $w=1.3e-08 $l=4.85e-08 $layer=M1 $thickness=3.6e-08 $X=0.1515
+ $Y=0.036 $X2=0.2 $Y2=0.036
r38 21 22 7.34548 $w=1.3e-08 $l=3.15e-08 $layer=M1 $thickness=3.6e-08 $X=0.12
+ $Y=0.036 $X2=0.1515 $Y2=0.036
r39 20 21 2.79828 $w=1.3e-08 $l=1.2e-08 $layer=M1 $thickness=3.6e-08 $X=0.108
+ $Y=0.036 $X2=0.12 $Y2=0.036
r40 15 20 3.03147 $w=1.3e-08 $l=1.3e-08 $layer=M1 $thickness=3.6e-08 $X=0.095
+ $Y=0.036 $X2=0.108 $Y2=0.036
r41 1 20 19.3796 $a=3.24e-16 $layer=V0LISD $X=0.108 $Y=0.0675 $X2=0.108
+ $Y2=0.036
r42 19 18 0.0308642 $w=8.1e-08 $l=2.5e-09 $layer=N_src_drn $thickness=1e-09
+ $X=0.1253 $Y=0.0675 $X2=0.1225 $Y2=0.0675
r43 10 18 0.154321 $w=8.1e-08 $l=1.25e-08 $layer=N_src_drn $thickness=1e-09
+ $X=0.11 $Y=0.0675 $X2=0.1225 $Y2=0.0675
r44 1 10 1e-05 $l=2e-09 $X=0.108 $Y=0.0675 $X2=0.11 $Y2=0.0675
.ends

.subckt PM_AOI211x1_ASAP7_75t_R%A1 vss 31 10 14 29 1 3 5
c1 1 vss 0.0156276f $X=0.189 $Y=0.135
c2 3 vss 0.142311f $X=0.189 $Y=0.0245
c3 4 vss 0.132286f $X=0.243 $Y=0.135
c4 5 vss 0.00224748f $X=0.189 $Y=0.072
c5 6 vss 0.00209606f $X=0.202 $Y=0.135
c6 7 vss 0.00770652f $X=0.189 $Y=0.198
c7 8 vss 0.00178252f $X=0.189 $Y=0.0997
c8 9 vss 0.0027579f $X=0.189 $Y=0.1485
r1 7 34 3.01711 $w=1.55e-08 $l=1.8e-08 $layer=M1 $thickness=3.6e-08 $X=0.189
+ $Y=0.198 $X2=0.189 $Y2=0.18
r2 5 8 5.29071 $w=1.46216e-08 $l=2.77e-08 $layer=M1 $thickness=3.6e-08 $X=0.189
+ $Y=0.072 $X2=0.189 $Y2=0.0997
r3 33 34 4.19742 $w=1.3e-08 $l=1.8e-08 $layer=M1 $thickness=3.6e-08 $X=0.189
+ $Y=0.162 $X2=0.189 $Y2=0.18
r4 9 21 1.96775 $w=1.63333e-08 $l=1.35e-08 $layer=M1 $thickness=3.6e-08
+ $X=0.189 $Y=0.1485 $X2=0.189 $Y2=0.135
r5 9 33 3.14806 $w=1.3e-08 $l=1.35e-08 $layer=M1 $thickness=3.6e-08 $X=0.189
+ $Y=0.1485 $X2=0.189 $Y2=0.162
r6 31 32 0.874462 $w=1.3e-08 $l=3.7e-09 $layer=M1 $thickness=3.6e-08 $X=0.192
+ $Y=0.119 $X2=0.189 $Y2=0.1227
r7 31 8 4.4889 $w=1.3e-08 $l=1.93e-08 $layer=M1 $thickness=3.6e-08 $X=0.192
+ $Y=0.119 $X2=0.189 $Y2=0.0997
r8 29 28 14.6259 $w=2.1e-08 $l=4.3e-08 $layer=Gate_1 $thickness=5.6e-08
+ $X=0.243 $Y=0.2025 $X2=0.243 $Y2=0.1595
r9 27 28 2.7211 $w=2.1e-08 $l=8e-09 $layer=Gate_1 $thickness=5.6e-08 $X=0.243
+ $Y=0.1515 $X2=0.243 $Y2=0.1595
r10 4 18 6.54019 $w=2.09524e-08 $layer=Gate_1 $thickness=5.21905e-08 $X=0.243
+ $Y=0.135 $X2=0.243 $Y2=0.135
r11 4 27 5.79936 $w=2.03333e-08 $l=1.65e-08 $layer=Gate_1 $thickness=5.6e-08
+ $X=0.243 $Y=0.135 $X2=0.243 $Y2=0.1515
r12 21 32 1.67627 $w=1.66735e-08 $l=1.23e-08 $layer=M1 $thickness=3.6e-08
+ $X=0.189 $Y=0.135 $X2=0.189 $Y2=0.1227
r13 6 20 2.56509 $w=1.3e-08 $l=1.1e-08 $layer=M1 $thickness=3.6e-08 $X=0.202
+ $Y=0.135 $X2=0.213 $Y2=0.135
r14 6 21 1.85116 $w=1.64615e-08 $l=1.3e-08 $layer=M1 $thickness=3.6e-08
+ $X=0.202 $Y=0.135 $X2=0.189 $Y2=0.135
r15 17 18 12.6539 $w=1.77815e-08 $l=2.7e-08 $layer=LIG $thickness=4.8e-08
+ $X=0.216 $Y=0.135 $X2=0.243 $Y2=0.135
r16 17 20 19.3796 $a=3.24e-16 $layer=V0LIG $X=0.216 $Y=0.135 $X2=0.213 $Y2=0.135
r17 1 12 6.54019 $w=2.09524e-08 $layer=Gate_1 $thickness=5.21905e-08 $X=0.189
+ $Y=0.135 $X2=0.189 $Y2=0.135
r18 1 17 12.6539 $w=1.77815e-08 $l=2.7e-08 $layer=LIG $thickness=4.8e-08
+ $X=0.189 $Y=0.135 $X2=0.216 $Y2=0.135
r19 14 13 16.4967 $w=2.1e-08 $l=4.85e-08 $layer=Gate_1 $thickness=5.6e-08
+ $X=0.189 $Y=0.2025 $X2=0.189 $Y2=0.154
r20 12 13 6.6497 $w=2.04211e-08 $l=1.9e-08 $layer=Gate_1 $thickness=5.6e-08
+ $X=0.189 $Y=0.135 $X2=0.189 $Y2=0.154
r21 11 12 6.6497 $w=2.04211e-08 $l=1.9e-08 $layer=Gate_1 $thickness=5.6e-08
+ $X=0.189 $Y=0.116 $X2=0.189 $Y2=0.135
r22 10 11 16.4967 $w=2.1e-08 $l=4.85e-08 $layer=Gate_1 $thickness=5.6e-08
+ $X=0.189 $Y=0.0675 $X2=0.189 $Y2=0.116
r23 10 3 14.6259 $w=2.1e-08 $l=4.3e-08 $layer=Gate_1 $thickness=5.6e-08
+ $X=0.189 $Y=0.0675 $X2=0.189 $Y2=0.0245
.ends

.subckt PM_AOI211x1_ASAP7_75t_R%A2 vss 33 9 13 28 1 4 3
c1 1 vss 0.0102586f $X=0.135 $Y=0.135
c2 3 vss 0.0938629f $X=0.081 $Y=0.135
c3 4 vss 0.103095f $X=0.135 $Y=0.0245
c4 5 vss 0.00141306f $X=0.027 $Y=0.135
c5 6 vss 0.0107604f $X=0.027 $Y=0.1035
c6 7 vss 0.0125792f $X=0.027 $Y=0.1482
c7 8 vss 0.00490644f $X=0.0955 $Y=0.135
r1 33 7 1.10765 $w=1.3e-08 $l=4.8e-09 $layer=M1 $thickness=3.6e-08 $X=0.028
+ $Y=0.153 $X2=0.027 $Y2=0.1482
r2 5 23 7.33112 $w=1.42329e-08 $l=3.65e-08 $layer=M1 $thickness=3.6e-08
+ $X=0.027 $Y=0.135 $X2=0.0635 $Y2=0.135
r3 5 6 6.16517 $w=1.44286e-08 $l=3.15e-08 $layer=M1 $thickness=3.6e-08 $X=0.027
+ $Y=0.135 $X2=0.027 $Y2=0.1035
r4 5 7 1.90946 $w=1.63962e-08 $l=1.32e-08 $layer=M1 $thickness=3.6e-08 $X=0.027
+ $Y=0.135 $X2=0.027 $Y2=0.1482
r5 28 27 14.6259 $w=2.1e-08 $l=4.3e-08 $layer=Gate_1 $thickness=5.6e-08
+ $X=0.081 $Y=0.2025 $X2=0.081 $Y2=0.1595
r6 26 27 2.7211 $w=2.1e-08 $l=8e-09 $layer=Gate_1 $thickness=5.6e-08 $X=0.081
+ $Y=0.1515 $X2=0.081 $Y2=0.1595
r7 3 18 6.54019 $w=2.09524e-08 $layer=Gate_1 $thickness=5.21905e-08 $X=0.081
+ $Y=0.135 $X2=0.081 $Y2=0.135
r8 3 26 5.79936 $w=2.03333e-08 $l=1.65e-08 $layer=Gate_1 $thickness=5.6e-08
+ $X=0.081 $Y=0.135 $X2=0.081 $Y2=0.1515
r9 8 21 3.14806 $w=1.3e-08 $l=1.35e-08 $layer=M1 $thickness=3.6e-08 $X=0.0955
+ $Y=0.135 $X2=0.109 $Y2=0.135
r10 8 23 7.46207 $w=1.3e-08 $l=3.2e-08 $layer=M1 $thickness=3.6e-08 $X=0.0955
+ $Y=0.135 $X2=0.0635 $Y2=0.135
r11 16 17 7.38404 $w=1.53e-08 $l=1.25e-08 $layer=LIG $thickness=4.8e-08
+ $X=0.109 $Y=0.135 $X2=0.1215 $Y2=0.135
r12 16 21 19.3796 $a=3.24e-16 $layer=V0LIG $X=0.109 $Y=0.135 $X2=0.109 $Y2=0.135
r13 15 16 7.97476 $w=1.53e-08 $l=1.35e-08 $layer=LIG $thickness=4.8e-08
+ $X=0.0955 $Y=0.135 $X2=0.109 $Y2=0.135
r14 15 18 5.26985 $w=1.99207e-08 $l=1.45e-08 $layer=LIG $thickness=4.8e-08
+ $X=0.0955 $Y=0.135 $X2=0.081 $Y2=0.135
r15 1 11 6.54019 $w=2.09524e-08 $layer=Gate_1 $thickness=5.21905e-08 $X=0.135
+ $Y=0.135 $X2=0.135 $Y2=0.135
r16 1 17 4.67913 $w=2.0263e-08 $l=1.35e-08 $layer=LIG $thickness=4.8e-08
+ $X=0.135 $Y=0.135 $X2=0.1215 $Y2=0.135
r17 13 12 16.4967 $w=2.1e-08 $l=4.85e-08 $layer=Gate_1 $thickness=5.6e-08
+ $X=0.135 $Y=0.2025 $X2=0.135 $Y2=0.154
r18 11 12 6.6497 $w=2.04211e-08 $l=1.9e-08 $layer=Gate_1 $thickness=5.6e-08
+ $X=0.135 $Y=0.135 $X2=0.135 $Y2=0.154
r19 10 11 6.6497 $w=2.04211e-08 $l=1.9e-08 $layer=Gate_1 $thickness=5.6e-08
+ $X=0.135 $Y=0.116 $X2=0.135 $Y2=0.135
r20 9 10 16.4967 $w=2.1e-08 $l=4.85e-08 $layer=Gate_1 $thickness=5.6e-08
+ $X=0.135 $Y=0.0675 $X2=0.135 $Y2=0.116
r21 9 4 14.6259 $w=2.1e-08 $l=4.3e-08 $layer=Gate_1 $thickness=5.6e-08 $X=0.135
+ $Y=0.0675 $X2=0.135 $Y2=0.0245
.ends

* End of included file AOI211x1_ASAP7_75t_R.pex.sp.pex

*
.subckt AOI211x1_ASAP7_75t_CUSTOM_4_25_0_7 VSS VDD A2 A1 B C Y
*
* VSS VSS
* VDD VDD
* A2 A2
* A1 A1
* B B
* C C
* Y Y
*
*

M0 noxref_10 N_M0_g N_M0_s VSS nmos_rvt L=2e-08 W=8.1e-08 nfin=3 $X=0.125
+ $Y=0.027
M1 VSS N_M1_g noxref_10 VSS nmos_rvt L=2e-08 W=8.1e-08 nfin=3 $X=0.179 $Y=0.027
M2 N_M2_d N_M2_g VSS VSS nmos_rvt L=2e-08 W=8.1e-08 nfin=3 $X=0.449 $Y=0.027
M3 VSS N_M3_g N_M3_s VSS nmos_rvt L=2e-08 W=8.1e-08 nfin=3 $X=0.503 $Y=0.027
M4 noxref_7 N_M4_g VDD VDD pmos_rvt L=2e-08 W=8.1e-08 nfin=3 $X=0.071 $Y=0.162
M5 noxref_7 N_M5_g VDD VDD pmos_rvt L=2e-08 W=8.1e-08 nfin=3 $X=0.125 $Y=0.162
M6 noxref_7 N_M6_g VDD VDD pmos_rvt L=2e-08 W=8.1e-08 nfin=3 $X=0.179 $Y=0.162
M7 noxref_7 N_M7_g VDD VDD pmos_rvt L=2e-08 W=8.1e-08 nfin=3 $X=0.233 $Y=0.162
M8 noxref_7 N_M8_g noxref_8 VDD pmos_rvt L=2e-08 W=8.1e-08 nfin=3 $X=0.395
+ $Y=0.162
M9 noxref_7 N_M9_g noxref_8 VDD pmos_rvt L=2e-08 W=8.1e-08 nfin=3 $X=0.449
+ $Y=0.162
M10 N_M10_d N_M10_g noxref_8 VDD pmos_rvt L=2e-08 W=8.1e-08 nfin=3 $X=0.503
+ $Y=0.162
M11 N_M11_d N_M11_g noxref_8 VDD pmos_rvt L=2e-08 W=8.1e-08 nfin=3 $X=0.557
+ $Y=0.162

* .include "AOI211x1_ASAP7_75t_R.pex.sp.pxi"

* Start of included file AOI211x1_ASAP7_75t_R.pex.sp.pxi
x_PM_AOI211x1_ASAP7_75t_R%B vss B N_M2_g N_M9_g N_M8_g N_B_4 N_B_5
+ PM_AOI211x1_ASAP7_75t_R%B
x_PM_AOI211x1_ASAP7_75t_R%C vss C N_M3_g N_M10_g N_M11_g N_C_3 N_C_6 N_C_1
+ N_C_4 N_C_7 N_C_5 PM_AOI211x1_ASAP7_75t_R%C
cc_1 N_C_3 N_B_4 0.00695256f $X=0.513 $Y=0.0245
x_PM_AOI211x1_ASAP7_75t_R%Y vss Y N_M0_s N_M2_d N_M3_s N_M10_d N_M11_d N_Y_15
+ N_Y_10 N_Y_1 N_Y_2 N_Y_11 N_Y_16 N_Y_17 N_Y_3 N_Y_12 PM_AOI211x1_ASAP7_75t_R%Y
cc_2 N_Y_15 N_A2_4 0.00100899f $X=0.095 $Y=0.036
cc_3 N_Y_10 N_A2_1 0.00254908f $X=0.11 $Y=0.0675
cc_4 N_Y_1 N_A2_3 0.00275042f $X=0.108 $Y=0.0675
cc_5 N_Y_10 N_A2_3 0.0190258f $X=0.11 $Y=0.0675
cc_6 N_Y_10 N_A2_4 0.0540768f $X=0.11 $Y=0.0675
cc_7 N_Y_15 N_A1_5 0.00729021f $X=0.095 $Y=0.036
cc_8 N_Y_2 N_B_4 0.00091281f $X=0.486 $Y=0.0675
cc_9 N_Y_15 N_B_5 0.00568678f $X=0.095 $Y=0.036
cc_10 N_Y_11 N_B_4 0.0357808f $X=0.4715 $Y=0.0675
cc_11 N_Y_2 N_C_3 0.00202751f $X=0.486 $Y=0.0675
cc_12 N_Y_16 N_C_6 0.000956018f $X=0.61 $Y=0.198
cc_13 N_Y_17 N_C_1 0.00127788f $X=0.621 $Y=0.054
cc_14 N_Y_3 N_C_4 0.00171087f $X=0.54 $Y=0.2025
cc_15 N_Y_16 N_C_7 0.00188838f $X=0.61 $Y=0.198
cc_16 N_Y_12 N_C_1 0.00359488f $X=0.5255 $Y=0.2025
cc_17 N_Y_11 N_C_3 0.0144098f $X=0.4715 $Y=0.0675
cc_18 N_Y_15 N_C_5 0.00567858f $X=0.095 $Y=0.036
cc_19 N_Y_12 N_C_4 0.0477699f $X=0.5255 $Y=0.2025
cc_20 N_Y_12 N_C_3 0.0406019f $X=0.5255 $Y=0.2025
x_PM_AOI211x1_ASAP7_75t_R%A1 vss A1 N_M1_g N_M6_g N_M7_g N_A1_1 N_A1_3 N_A1_5
+ PM_AOI211x1_ASAP7_75t_R%A1
cc_21 N_A1_1 N_A2_1 0.00199546f $X=0.189 $Y=0.135
cc_22 N_A1_3 N_A2_4 0.00763688f $X=0.189 $Y=0.0245
x_PM_AOI211x1_ASAP7_75t_R%A2 vss A2 N_M0_g N_M5_g N_M4_g N_A2_1 N_A2_4 N_A2_3
+ PM_AOI211x1_ASAP7_75t_R%A2

* End of included file AOI211x1_ASAP7_75t_R.pex.sp.pxi
.ends

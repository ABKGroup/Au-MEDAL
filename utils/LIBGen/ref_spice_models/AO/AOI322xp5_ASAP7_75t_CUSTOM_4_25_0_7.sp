.subckt PM_AOI322xp5_ASAP7_75t_R%B2 vss 13 5 11 3
c1 1 vss 0.0065655f $X=0.081 $Y=0.135
c2 3 vss 0.134191f $X=0.081 $Y=0.0245
c3 4 vss 0.0132214f $X=0.081 $Y=0.098
r1 13 4 8.62802 $w=1.3e-08 $l=3.7e-08 $layer=M1 $thickness=3.6e-08 $X=0.075
+ $Y=0.134 $X2=0.081 $Y2=0.098
r2 1 8 10.4265 $w=1.765e-08 $layer=LIG $thickness=5.2e-08 $X=0.081 $Y=0.135
+ $X2=0.081 $Y2=0.135
r3 13 1 19.3796 $a=3.24e-16 $layer=V0LIG $X=0.075 $Y=0.134 $X2=0.081 $Y2=0.135
r4 11 10 14.6259 $w=2.1e-08 $l=4.3e-08 $layer=Gate_1 $thickness=5.6e-08
+ $X=0.081 $Y=0.2025 $X2=0.081 $Y2=0.1595
r5 9 10 2.7211 $w=2.1e-08 $l=8e-09 $layer=Gate_1 $thickness=5.6e-08 $X=0.081
+ $Y=0.1515 $X2=0.081 $Y2=0.1595
r6 8 9 5.79936 $w=2.03333e-08 $l=1.65e-08 $layer=Gate_1 $thickness=5.6e-08
+ $X=0.081 $Y=0.135 $X2=0.081 $Y2=0.1515
r7 7 8 5.79936 $w=2.03333e-08 $l=1.65e-08 $layer=Gate_1 $thickness=5.6e-08
+ $X=0.081 $Y=0.1185 $X2=0.081 $Y2=0.135
r8 6 7 7.31297 $w=2.1e-08 $l=2.15e-08 $layer=Gate_1 $thickness=5.6e-08 $X=0.081
+ $Y=0.097 $X2=0.081 $Y2=0.1185
r9 5 6 14.6259 $w=2.1e-08 $l=4.3e-08 $layer=Gate_1 $thickness=5.6e-08 $X=0.081
+ $Y=0.054 $X2=0.081 $Y2=0.097
r10 5 3 10.0341 $w=2.1e-08 $l=2.95e-08 $layer=Gate_1 $thickness=5.6e-08
+ $X=0.081 $Y=0.054 $X2=0.081 $Y2=0.0245
.ends

.subckt PM_AOI322xp5_ASAP7_75t_R%B1 vss 11 5 9 4 3
c1 1 vss 0.0120522f $X=0.135 $Y=0.135
c2 3 vss 0.103179f $X=0.135 $Y=0.0245
c3 4 vss 0.00838796f $X=0.135 $Y=0.098
r1 11 4 8.62802 $w=1.3e-08 $l=3.7e-08 $layer=M1 $thickness=3.6e-08 $X=0.131
+ $Y=0.134 $X2=0.135 $Y2=0.098
r2 1 7 10.4265 $w=1.765e-08 $layer=LIG $thickness=5.2e-08 $X=0.135 $Y=0.135
+ $X2=0.135 $Y2=0.135
r3 11 1 19.3796 $a=3.24e-16 $layer=V0LIG $X=0.131 $Y=0.134 $X2=0.135 $Y2=0.135
r4 9 8 16.4967 $w=2.1e-08 $l=4.85e-08 $layer=Gate_1 $thickness=5.6e-08 $X=0.135
+ $Y=0.2025 $X2=0.135 $Y2=0.154
r5 7 8 6.6497 $w=2.04211e-08 $l=1.9e-08 $layer=Gate_1 $thickness=5.6e-08
+ $X=0.135 $Y=0.135 $X2=0.135 $Y2=0.154
r6 6 7 11.2416 $w=2.06615e-08 $l=3.25e-08 $layer=Gate_1 $thickness=5.6e-08
+ $X=0.135 $Y=0.1025 $X2=0.135 $Y2=0.135
r7 5 6 16.4967 $w=2.1e-08 $l=4.85e-08 $layer=Gate_1 $thickness=5.6e-08 $X=0.135
+ $Y=0.054 $X2=0.135 $Y2=0.1025
r8 5 3 10.0341 $w=2.1e-08 $l=2.95e-08 $layer=Gate_1 $thickness=5.6e-08 $X=0.135
+ $Y=0.054 $X2=0.135 $Y2=0.0245
.ends

.subckt PM_AOI322xp5_ASAP7_75t_R%A3 vss 11 5 9 4 3
c1 1 vss 0.00625712f $X=0.297 $Y=0.135
c2 3 vss 0.143171f $X=0.297 $Y=0.0245
c3 4 vss 0.00774487f $X=0.297 $Y=0.098
r1 11 4 8.62802 $w=1.3e-08 $l=3.7e-08 $layer=M1 $thickness=3.6e-08 $X=0.296
+ $Y=0.136 $X2=0.297 $Y2=0.098
r2 1 7 10.4265 $w=1.765e-08 $layer=LIG $thickness=5.2e-08 $X=0.297 $Y=0.135
+ $X2=0.297 $Y2=0.135
r3 11 1 19.3796 $a=3.24e-16 $layer=V0LIG $X=0.296 $Y=0.136 $X2=0.297 $Y2=0.135
r4 9 8 16.4967 $w=2.1e-08 $l=4.85e-08 $layer=Gate_1 $thickness=5.6e-08 $X=0.297
+ $Y=0.2025 $X2=0.297 $Y2=0.154
r5 7 8 6.6497 $w=2.04211e-08 $l=1.9e-08 $layer=Gate_1 $thickness=5.6e-08
+ $X=0.297 $Y=0.135 $X2=0.297 $Y2=0.154
r6 6 7 6.6497 $w=2.04211e-08 $l=1.9e-08 $layer=Gate_1 $thickness=5.6e-08
+ $X=0.297 $Y=0.116 $X2=0.297 $Y2=0.135
r7 5 6 16.4967 $w=2.1e-08 $l=4.85e-08 $layer=Gate_1 $thickness=5.6e-08 $X=0.297
+ $Y=0.0675 $X2=0.297 $Y2=0.116
r8 5 3 14.6259 $w=2.1e-08 $l=4.3e-08 $layer=Gate_1 $thickness=5.6e-08 $X=0.297
+ $Y=0.0675 $X2=0.297 $Y2=0.0245
.ends

.subckt PM_AOI322xp5_ASAP7_75t_R%C2 vss 11 5 9 3 4
c1 1 vss 0.00862706f $X=0.351 $Y=0.135
c2 3 vss 0.114005f $X=0.351 $Y=0.0245
c3 4 vss 0.00553607f $X=0.351 $Y=0.098
r1 11 4 8.62802 $w=1.3e-08 $l=3.7e-08 $layer=M1 $thickness=3.6e-08 $X=0.348
+ $Y=0.134 $X2=0.351 $Y2=0.098
r2 1 7 10.4265 $w=1.765e-08 $layer=LIG $thickness=5.2e-08 $X=0.351 $Y=0.135
+ $X2=0.351 $Y2=0.135
r3 11 1 19.3796 $a=3.24e-16 $layer=V0LIG $X=0.348 $Y=0.134 $X2=0.351 $Y2=0.135
r4 9 8 16.4967 $w=2.1e-08 $l=4.85e-08 $layer=Gate_1 $thickness=5.6e-08 $X=0.351
+ $Y=0.2025 $X2=0.351 $Y2=0.154
r5 7 8 6.6497 $w=2.04211e-08 $l=1.9e-08 $layer=Gate_1 $thickness=5.6e-08
+ $X=0.351 $Y=0.135 $X2=0.351 $Y2=0.154
r6 6 7 11.2416 $w=2.06615e-08 $l=3.25e-08 $layer=Gate_1 $thickness=5.6e-08
+ $X=0.351 $Y=0.1025 $X2=0.351 $Y2=0.135
r7 5 6 16.4967 $w=2.1e-08 $l=4.85e-08 $layer=Gate_1 $thickness=5.6e-08 $X=0.351
+ $Y=0.054 $X2=0.351 $Y2=0.1025
r8 5 3 10.0341 $w=2.1e-08 $l=2.95e-08 $layer=Gate_1 $thickness=5.6e-08 $X=0.351
+ $Y=0.054 $X2=0.351 $Y2=0.0245
.ends

.subckt PM_AOI322xp5_ASAP7_75t_R%C1 vss 13 5 11 4 3 1
c1 1 vss 0.0107488f $X=0.405 $Y=0.135
c2 3 vss 0.0687979f $X=0.405 $Y=0.0245
c3 4 vss 0.00550848f $X=0.405 $Y=0.098
r1 13 4 8.62802 $w=1.3e-08 $l=3.7e-08 $layer=M1 $thickness=3.6e-08 $X=0.405
+ $Y=0.134 $X2=0.405 $Y2=0.098
r2 1 8 10.4265 $w=1.765e-08 $layer=LIG $thickness=5.2e-08 $X=0.405 $Y=0.135
+ $X2=0.405 $Y2=0.135
r3 13 1 19.3796 $a=3.24e-16 $layer=V0LIG $X=0.405 $Y=0.134 $X2=0.405 $Y2=0.135
r4 11 10 14.6259 $w=2.1e-08 $l=4.3e-08 $layer=Gate_1 $thickness=5.6e-08
+ $X=0.405 $Y=0.2025 $X2=0.405 $Y2=0.1595
r5 9 10 2.7211 $w=2.1e-08 $l=8e-09 $layer=Gate_1 $thickness=5.6e-08 $X=0.405
+ $Y=0.1515 $X2=0.405 $Y2=0.1595
r6 8 9 5.79936 $w=2.03333e-08 $l=1.65e-08 $layer=Gate_1 $thickness=5.6e-08
+ $X=0.405 $Y=0.135 $X2=0.405 $Y2=0.1515
r7 7 8 5.79936 $w=2.03333e-08 $l=1.65e-08 $layer=Gate_1 $thickness=5.6e-08
+ $X=0.405 $Y=0.1185 $X2=0.405 $Y2=0.135
r8 6 7 7.31297 $w=2.1e-08 $l=2.15e-08 $layer=Gate_1 $thickness=5.6e-08 $X=0.405
+ $Y=0.097 $X2=0.405 $Y2=0.1185
r9 5 6 14.6259 $w=2.1e-08 $l=4.3e-08 $layer=Gate_1 $thickness=5.6e-08 $X=0.405
+ $Y=0.054 $X2=0.405 $Y2=0.097
r10 5 3 10.0341 $w=2.1e-08 $l=2.95e-08 $layer=Gate_1 $thickness=5.6e-08
+ $X=0.405 $Y=0.054 $X2=0.405 $Y2=0.0245
.ends

.subckt PM_AOI322xp5_ASAP7_75t_R%Y vss 34 21 24 51 58 59 1 12 10 17 18 2 14 3
+ 13 19
c1 1 vss 0.00546275f $X=0.162 $Y=0.054
c2 2 vss 0.00905222f $X=0.378 $Y=0.2025
c3 3 vss 0.00563175f $X=0.432 $Y=0.054
c4 10 vss 0.0019623f $X=0.1475 $Y=0.0725
c5 11 vss 0.000118009f $X=0.1475 $Y=0.0455
c6 12 vss 0.000260714f $X=0.164 $Y=0.0945
c7 13 vss 0.0251678f $X=0.4175 $Y=0.054
c8 14 vss 0.00423642f $X=0.3635 $Y=0.2025
c9 15 vss 0.00246449f $X=0.459 $Y=0.036
c10 16 vss 0.00221171f $X=0.459 $Y=0.198
c11 17 vss 0.0254107f $X=0.15 $Y=0.036
c12 18 vss 0.00749927f $X=0.432 $Y=0.198
c13 19 vss 0.0043507f $X=0.459 $Y=0.0575
r1 59 57 0.0308642 $w=8.1e-08 $l=2.5e-09 $layer=P_src_drn $thickness=1e-09
+ $X=0.3953 $Y=0.2025 $X2=0.3925 $Y2=0.2025
r2 2 57 0.179012 $w=8.1e-08 $l=1.45e-08 $layer=P_src_drn $thickness=1e-09
+ $X=0.378 $Y=0.2025 $X2=0.3925 $Y2=0.2025
r3 14 2 0.179012 $w=8.1e-08 $l=1.45e-08 $layer=P_src_drn $thickness=1e-09
+ $X=0.3635 $Y=0.2025 $X2=0.378 $Y2=0.2025
r4 58 14 0.0308642 $w=8.1e-08 $l=2.5e-09 $layer=P_src_drn $thickness=1e-09
+ $X=0.3606 $Y=0.2025 $X2=0.3635 $Y2=0.2025
r5 2 54 19.3796 $a=3.24e-16 $layer=V0LISD $X=0.378 $Y=0.2025 $X2=0.378 $Y2=0.198
r6 54 55 3.14806 $w=1.3e-08 $l=1.35e-08 $layer=M1 $thickness=3.6e-08 $X=0.378
+ $Y=0.198 $X2=0.3915 $Y2=0.198
r7 52 55 3.14806 $w=1.3e-08 $l=1.35e-08 $layer=M1 $thickness=3.6e-08 $X=0.405
+ $Y=0.198 $X2=0.3915 $Y2=0.198
r8 18 52 6.29612 $w=1.3e-08 $l=2.7e-08 $layer=M1 $thickness=3.6e-08 $X=0.432
+ $Y=0.198 $X2=0.405 $Y2=0.198
r9 16 49 3.24787 $w=1.72e-08 $l=2.1e-08 $layer=M1 $thickness=3.6e-08 $X=0.459
+ $Y=0.198 $X2=0.459 $Y2=0.177
r10 16 18 4.64701 $w=1.46667e-08 $l=2.7e-08 $layer=M1 $thickness=3.6e-08
+ $X=0.459 $Y=0.198 $X2=0.432 $Y2=0.198
r11 13 3 0.231482 $w=5.4e-08 $l=1.25e-08 $layer=N_src_drn $thickness=1e-09
+ $X=0.4175 $Y=0.054 $X2=0.432 $Y2=0.054
r12 51 13 0.0462963 $w=5.4e-08 $l=2.5e-09 $layer=N_src_drn $thickness=1e-09
+ $X=0.4146 $Y=0.054 $X2=0.4175 $Y2=0.054
r13 48 49 2.91487 $w=1.3e-08 $l=1.25e-08 $layer=M1 $thickness=3.6e-08 $X=0.459
+ $Y=0.1645 $X2=0.459 $Y2=0.177
r14 47 48 11.0765 $w=1.3e-08 $l=4.75e-08 $layer=M1 $thickness=3.6e-08 $X=0.459
+ $Y=0.117 $X2=0.459 $Y2=0.1645
r15 19 47 13.8748 $w=1.3e-08 $l=5.95e-08 $layer=M1 $thickness=3.6e-08 $X=0.459
+ $Y=0.0575 $X2=0.459 $Y2=0.117
r16 3 45 19.3796 $a=3.24e-16 $layer=V0LISD $X=0.432 $Y=0.054 $X2=0.432 $Y2=0.036
r17 15 46 1.49895 $w=1.63333e-08 $l=1.35e-08 $layer=M1 $thickness=3.6e-08
+ $X=0.459 $Y=0.036 $X2=0.4455 $Y2=0.036
r18 15 19 3.36447 $w=1.71023e-08 $l=2.15e-08 $layer=M1 $thickness=3.6e-08
+ $X=0.459 $Y=0.036 $X2=0.459 $Y2=0.0575
r19 45 46 3.14806 $w=1.3e-08 $l=1.35e-08 $layer=M1 $thickness=3.6e-08 $X=0.432
+ $Y=0.036 $X2=0.4455 $Y2=0.036
r20 44 45 3.14806 $w=1.3e-08 $l=1.35e-08 $layer=M1 $thickness=3.6e-08 $X=0.4185
+ $Y=0.036 $X2=0.432 $Y2=0.036
r21 43 44 3.14806 $w=1.3e-08 $l=1.35e-08 $layer=M1 $thickness=3.6e-08 $X=0.405
+ $Y=0.036 $X2=0.4185 $Y2=0.036
r22 42 43 5.82974 $w=1.3e-08 $l=2.5e-08 $layer=M1 $thickness=3.6e-08 $X=0.38
+ $Y=0.036 $X2=0.405 $Y2=0.036
r23 41 42 4.19742 $w=1.3e-08 $l=1.8e-08 $layer=M1 $thickness=3.6e-08 $X=0.362
+ $Y=0.036 $X2=0.38 $Y2=0.036
r24 40 41 2.56509 $w=1.3e-08 $l=1.1e-08 $layer=M1 $thickness=3.6e-08 $X=0.351
+ $Y=0.036 $X2=0.362 $Y2=0.036
r25 39 40 6.29612 $w=1.3e-08 $l=2.7e-08 $layer=M1 $thickness=3.6e-08 $X=0.324
+ $Y=0.036 $X2=0.351 $Y2=0.036
r26 38 39 6.29612 $w=1.3e-08 $l=2.7e-08 $layer=M1 $thickness=3.6e-08 $X=0.297
+ $Y=0.036 $X2=0.324 $Y2=0.036
r27 37 38 2.56509 $w=1.3e-08 $l=1.1e-08 $layer=M1 $thickness=3.6e-08 $X=0.286
+ $Y=0.036 $X2=0.297 $Y2=0.036
r28 36 37 4.19742 $w=1.3e-08 $l=1.8e-08 $layer=M1 $thickness=3.6e-08 $X=0.268
+ $Y=0.036 $X2=0.286 $Y2=0.036
r29 35 36 4.13912 $w=1.3e-08 $l=1.78e-08 $layer=M1 $thickness=3.6e-08 $X=0.2502
+ $Y=0.036 $X2=0.268 $Y2=0.036
r30 34 35 0.524677 $w=1.3e-08 $l=2.2e-09 $layer=M1 $thickness=3.6e-08 $X=0.248
+ $Y=0.035 $X2=0.2502 $Y2=0.036
r31 34 33 1.69063 $w=1.3e-08 $l=7.3e-09 $layer=M1 $thickness=3.6e-08 $X=0.248
+ $Y=0.035 $X2=0.2407 $Y2=0.036
r32 32 33 5.77145 $w=1.3e-08 $l=2.47e-08 $layer=M1 $thickness=3.6e-08 $X=0.216
+ $Y=0.036 $X2=0.2407 $Y2=0.036
r33 31 32 6.29612 $w=1.3e-08 $l=2.7e-08 $layer=M1 $thickness=3.6e-08 $X=0.189
+ $Y=0.036 $X2=0.216 $Y2=0.036
r34 30 31 3.14806 $w=1.3e-08 $l=1.35e-08 $layer=M1 $thickness=3.6e-08 $X=0.1755
+ $Y=0.036 $X2=0.189 $Y2=0.036
r35 29 30 3.14806 $w=1.3e-08 $l=1.35e-08 $layer=M1 $thickness=3.6e-08 $X=0.162
+ $Y=0.036 $X2=0.1755 $Y2=0.036
r36 17 29 2.79828 $w=1.3e-08 $l=1.2e-08 $layer=M1 $thickness=3.6e-08 $X=0.15
+ $Y=0.036 $X2=0.162 $Y2=0.036
r37 1 29 19.3796 $a=3.24e-16 $layer=V0LISD $X=0.162 $Y=0.054 $X2=0.162 $Y2=0.036
r38 12 1 0.958606 $w=2.2e-08 $l=2.2e-08 $layer=N_src_drn $thickness=1e-09
+ $X=0.164 $Y=0.0945 $X2=0.162 $Y2=0.054
r39 11 1 0.391892 $w=3.7e-08 $l=1.45e-08 $layer=N_src_drn $thickness=1e-09
+ $X=0.1475 $Y=0.0455 $X2=0.162 $Y2=0.054
r40 24 23 0.147059 $w=1.7e-08 $l=2.5e-09 $layer=N_src_drn $thickness=1e-09
+ $X=0.1793 $Y=0.0675 $X2=0.1765 $Y2=0.0725
r41 1 23 0.735294 $w=1.7e-08 $l=1.25e-08 $layer=N_src_drn $thickness=1e-09
+ $X=0.162 $Y=0.054 $X2=0.1765 $Y2=0.0725
r42 20 1 0.705882 $w=1.7e-08 $l=1.2e-08 $layer=N_src_drn $thickness=1e-09
+ $X=0.152 $Y=0.0725 $X2=0.162 $Y2=0.054
r43 10 20 0.264706 $w=1.7e-08 $l=4.5e-09 $layer=N_src_drn $thickness=1e-09
+ $X=0.1475 $Y=0.0725 $X2=0.152 $Y2=0.0725
r44 21 10 0.147059 $w=1.7e-08 $l=2.5e-09 $layer=N_src_drn $thickness=1e-09
+ $X=0.1446 $Y=0.054 $X2=0.1475 $Y2=0.0725
r45 10 11 0.214626 $w=2.7e-08 $l=2.7e-08 $layer=N_src_drn $thickness=1e-09
+ $X=0.1475 $Y=0.0725 $X2=0.1475 $Y2=0.0455
r46 1 12 1e-05 $l=4.05494e-08 $X=0.162 $Y=0.054 $X2=0.164 $Y2=0.0945
.ends

.subckt PM_AOI322xp5_ASAP7_75t_R%A1 vss 11 5 9 3 4
c1 1 vss 0.0191234f $X=0.189 $Y=0.135
c2 3 vss 0.0799492f $X=0.189 $Y=0.0245
c3 4 vss 0.0118773f $X=0.189 $Y=0.098
r1 11 4 8.62802 $w=1.3e-08 $l=3.7e-08 $layer=M1 $thickness=3.6e-08 $X=0.187
+ $Y=0.136 $X2=0.189 $Y2=0.098
r2 1 7 10.4265 $w=1.765e-08 $layer=LIG $thickness=5.2e-08 $X=0.189 $Y=0.135
+ $X2=0.189 $Y2=0.135
r3 11 1 19.3796 $a=3.24e-16 $layer=V0LIG $X=0.187 $Y=0.136 $X2=0.189 $Y2=0.135
r4 9 8 16.4967 $w=2.1e-08 $l=4.85e-08 $layer=Gate_1 $thickness=5.6e-08 $X=0.189
+ $Y=0.2025 $X2=0.189 $Y2=0.154
r5 7 8 6.6497 $w=2.04211e-08 $l=1.9e-08 $layer=Gate_1 $thickness=5.6e-08
+ $X=0.189 $Y=0.135 $X2=0.189 $Y2=0.154
r6 6 7 6.6497 $w=2.04211e-08 $l=1.9e-08 $layer=Gate_1 $thickness=5.6e-08
+ $X=0.189 $Y=0.116 $X2=0.189 $Y2=0.135
r7 5 6 16.4967 $w=2.1e-08 $l=4.85e-08 $layer=Gate_1 $thickness=5.6e-08 $X=0.189
+ $Y=0.0675 $X2=0.189 $Y2=0.116
r8 5 3 14.6259 $w=2.1e-08 $l=4.3e-08 $layer=Gate_1 $thickness=5.6e-08 $X=0.189
+ $Y=0.0675 $X2=0.189 $Y2=0.0245
.ends

.subckt PM_AOI322xp5_ASAP7_75t_R%A2 vss 11 5 9 4 3
c1 1 vss 0.00451819f $X=0.243 $Y=0.135
c2 3 vss 0.115205f $X=0.243 $Y=0.0245
c3 4 vss 0.00423014f $X=0.243 $Y=0.098
r1 11 4 8.62802 $w=1.3e-08 $l=3.7e-08 $layer=M1 $thickness=3.6e-08 $X=0.247
+ $Y=0.136 $X2=0.243 $Y2=0.098
r2 1 7 10.4265 $w=1.765e-08 $layer=LIG $thickness=5.2e-08 $X=0.243 $Y=0.135
+ $X2=0.243 $Y2=0.135
r3 11 1 19.3796 $a=3.24e-16 $layer=V0LIG $X=0.247 $Y=0.136 $X2=0.243 $Y2=0.135
r4 9 8 16.4967 $w=2.1e-08 $l=4.85e-08 $layer=Gate_1 $thickness=5.6e-08 $X=0.243
+ $Y=0.2025 $X2=0.243 $Y2=0.154
r5 7 8 6.6497 $w=2.04211e-08 $l=1.9e-08 $layer=Gate_1 $thickness=5.6e-08
+ $X=0.243 $Y=0.135 $X2=0.243 $Y2=0.154
r6 6 7 6.6497 $w=2.04211e-08 $l=1.9e-08 $layer=Gate_1 $thickness=5.6e-08
+ $X=0.243 $Y=0.116 $X2=0.243 $Y2=0.135
r7 5 6 16.4967 $w=2.1e-08 $l=4.85e-08 $layer=Gate_1 $thickness=5.6e-08 $X=0.243
+ $Y=0.0675 $X2=0.243 $Y2=0.116
r8 5 3 14.6259 $w=2.1e-08 $l=4.3e-08 $layer=Gate_1 $thickness=5.6e-08 $X=0.243
+ $Y=0.0675 $X2=0.243 $Y2=0.0245
.ends

* End of included file AOI322xp5_ASAP7_75t_R.pex.sp.pex

*
.subckt AOI322xp5_ASAP7_75t_CUSTOM_4_25_0_7 VSS VDD B2 B1 A1 A2 A3 C2 C1 Y
*
* VSS VSS
* VDD VDD
* B2 B2
* B1 B1
* A1 A1
* A2 A2
* A3 A3
* C2 C2
* C1 C1
* Y Y
*
*

M0 noxref_13 N_M0_g VSS VSS nmos_rvt L=2e-08 W=5.4e-08 nfin=2 $X=0.071 $Y=0.027
M1 N_M1_d N_M1_g noxref_13 VSS nmos_rvt L=2e-08 W=5.4e-08 nfin=2 $X=0.125
+ $Y=0.027
M2 noxref_14 N_M2_g N_M2_s VSS nmos_rvt L=2e-08 W=8.1e-08 nfin=3 $X=0.179
+ $Y=0.027
M3 noxref_15 N_M3_g noxref_14 VSS nmos_rvt L=2e-08 W=8.1e-08 nfin=3 $X=0.233
+ $Y=0.027
M4 VSS N_M4_g noxref_15 VSS nmos_rvt L=2e-08 W=8.1e-08 nfin=3 $X=0.287 $Y=0.027
M5 noxref_16 N_M5_g VSS VSS nmos_rvt L=2e-08 W=5.4e-08 nfin=2 $X=0.341 $Y=0.027
M6 N_M6_d N_M6_g noxref_16 VSS nmos_rvt L=2e-08 W=5.4e-08 nfin=2 $X=0.395
+ $Y=0.027
M7 VDD N_M7_g noxref_10 VDD pmos_rvt L=2e-08 W=8.1e-08 nfin=3 $X=0.071 $Y=0.162
M8 noxref_10 N_M8_g VDD VDD pmos_rvt L=2e-08 W=8.1e-08 nfin=3 $X=0.125 $Y=0.162
M9 noxref_11 N_M9_g noxref_10 VDD pmos_rvt L=2e-08 W=8.1e-08 nfin=3 $X=0.179
+ $Y=0.162
M10 noxref_10 N_M10_g noxref_11 VDD pmos_rvt L=2e-08 W=8.1e-08 nfin=3 $X=0.233
+ $Y=0.162
M11 noxref_11 N_M11_g noxref_10 VDD pmos_rvt L=2e-08 W=8.1e-08 nfin=3 $X=0.287
+ $Y=0.162
M12 N_M12_d N_M12_g noxref_11 VDD pmos_rvt L=2e-08 W=8.1e-08 nfin=3 $X=0.341
+ $Y=0.162
M13 noxref_11 N_M13_g N_M13_s VDD pmos_rvt L=2e-08 W=8.1e-08 nfin=3 $X=0.395
+ $Y=0.162

* .include "AOI322xp5_ASAP7_75t_R.pex.sp.pxi"

* Start of included file AOI322xp5_ASAP7_75t_R.pex.sp.pxi
x_PM_AOI322xp5_ASAP7_75t_R%B2 vss B2 N_M0_g N_M7_g N_B2_3
+ PM_AOI322xp5_ASAP7_75t_R%B2
x_PM_AOI322xp5_ASAP7_75t_R%B1 vss B1 N_M1_g N_M8_g N_B1_4 N_B1_3
+ PM_AOI322xp5_ASAP7_75t_R%B1
cc_1 N_B1_4 N_B2_3 0.00386443f $X=0.135 $Y=0.098
cc_2 N_B1_3 N_B2_3 0.00865858f $X=0.135 $Y=0.0245
x_PM_AOI322xp5_ASAP7_75t_R%A3 vss A3 N_M4_g N_M11_g N_A3_4 N_A3_3
+ PM_AOI322xp5_ASAP7_75t_R%A3
cc_3 N_A3_4 N_A2_4 0.00322785f $X=0.297 $Y=0.098
cc_4 N_A3_3 N_A2_3 0.0107732f $X=0.297 $Y=0.0245
x_PM_AOI322xp5_ASAP7_75t_R%C2 vss C2 N_M5_g N_M12_g N_C2_3 N_C2_4
+ PM_AOI322xp5_ASAP7_75t_R%C2
cc_5 N_C2_3 N_A3_3 0.00303304f $X=0.351 $Y=0.0245
cc_6 N_C2_4 N_A3_4 0.00509844f $X=0.351 $Y=0.098
x_PM_AOI322xp5_ASAP7_75t_R%C1 vss C1 N_M6_g N_M13_g N_C1_4 N_C1_3 N_C1_1
+ PM_AOI322xp5_ASAP7_75t_R%C1
cc_7 N_C1_4 N_C2_4 0.00334394f $X=0.405 $Y=0.098
cc_8 N_C1_3 N_C2_3 0.00848996f $X=0.405 $Y=0.0245
x_PM_AOI322xp5_ASAP7_75t_R%Y vss Y N_M1_d N_M2_s N_M6_d N_M12_d N_M13_s N_Y_1
+ N_Y_12 N_Y_10 N_Y_17 N_Y_18 N_Y_2 N_Y_14 N_Y_3 N_Y_13 N_Y_19
+ PM_AOI322xp5_ASAP7_75t_R%Y
cc_9 N_Y_1 N_B1_4 0.00109822f $X=0.162 $Y=0.054
cc_10 N_Y_1 N_B1_3 0.00128161f $X=0.162 $Y=0.054
cc_11 N_Y_12 N_B1_3 0.00463126f $X=0.164 $Y=0.0945
cc_12 N_Y_10 N_B1_3 0.0355566f $X=0.1475 $Y=0.0725
cc_13 N_Y_17 N_A1_3 0.00106491f $X=0.15 $Y=0.036
cc_14 N_Y_1 N_A1_3 0.00122683f $X=0.162 $Y=0.054
cc_15 N_Y_1 N_A1_4 0.00159083f $X=0.162 $Y=0.054
cc_16 N_Y_10 N_A1_3 0.00894856f $X=0.1475 $Y=0.0725
cc_17 N_Y_12 N_A1_3 0.0364149f $X=0.164 $Y=0.0945
cc_18 N_Y_17 N_A2_4 0.00320162f $X=0.15 $Y=0.036
cc_19 N_Y_17 N_A3_4 0.00278461f $X=0.15 $Y=0.036
cc_20 N_Y_18 N_C2_3 0.000473209f $X=0.432 $Y=0.198
cc_21 N_Y_2 N_C2_3 0.000735652f $X=0.378 $Y=0.2025
cc_22 N_Y_17 N_C2_4 0.00116402f $X=0.15 $Y=0.036
cc_23 N_Y_2 N_C2_4 0.00197729f $X=0.378 $Y=0.2025
cc_24 N_Y_14 N_C2_3 0.0338944f $X=0.3635 $Y=0.2025
cc_25 N_Y_2 N_C1_3 0.00144598f $X=0.378 $Y=0.2025
cc_26 N_Y_3 N_C1_3 0.000834552f $X=0.432 $Y=0.054
cc_27 N_Y_18 N_C1_4 0.000877162f $X=0.432 $Y=0.198
cc_28 N_Y_17 N_C1_4 0.00102541f $X=0.15 $Y=0.036
cc_29 N_Y_14 N_C1_1 0.00115538f $X=0.3635 $Y=0.2025
cc_30 N_Y_13 N_C1_3 0.00992187f $X=0.4175 $Y=0.054
cc_31 N_Y_19 N_C1_4 0.00599715f $X=0.459 $Y=0.0575
cc_32 N_Y_14 N_C1_3 0.0462255f $X=0.3635 $Y=0.2025
x_PM_AOI322xp5_ASAP7_75t_R%A1 vss A1 N_M2_g N_M9_g N_A1_3 N_A1_4
+ PM_AOI322xp5_ASAP7_75t_R%A1
cc_33 N_A1_3 N_B1_3 0.00302274f $X=0.189 $Y=0.0245
cc_34 N_A1_4 N_B1_4 0.00498773f $X=0.189 $Y=0.098
x_PM_AOI322xp5_ASAP7_75t_R%A2 vss A2 N_M3_g N_M10_g N_A2_4 N_A2_3
+ PM_AOI322xp5_ASAP7_75t_R%A2
cc_35 N_A2_4 N_A1_4 0.00318262f $X=0.243 $Y=0.098
cc_36 N_A2_3 N_A1_3 0.0109099f $X=0.243 $Y=0.0245

* End of included file AOI322xp5_ASAP7_75t_R.pex.sp.pxi
.ends

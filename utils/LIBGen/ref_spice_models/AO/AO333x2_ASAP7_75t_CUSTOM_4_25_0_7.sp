.subckt PM_AO333x2_ASAP7_75t_R%A3 vss 11 5 9 4 3
c1 1 vss 0.00572017f $X=0.189 $Y=0.135
c2 3 vss 0.139812f $X=0.189 $Y=0.0245
c3 4 vss 0.00769929f $X=0.189 $Y=0.081
r1 12 13 5.94634 $w=1.3e-08 $l=2.55e-08 $layer=M1 $thickness=3.6e-08 $X=0.189
+ $Y=0.1095 $X2=0.189 $Y2=0.135
r2 11 12 3.96423 $w=1.3e-08 $l=1.7e-08 $layer=M1 $thickness=3.6e-08 $X=0.1875
+ $Y=0.0925 $X2=0.189 $Y2=0.1095
r3 11 4 2.68168 $w=1.3e-08 $l=1.15e-08 $layer=M1 $thickness=3.6e-08 $X=0.1875
+ $Y=0.0925 $X2=0.189 $Y2=0.081
r4 1 7 10.4265 $w=1.765e-08 $layer=LIG $thickness=5.2e-08 $X=0.189 $Y=0.135
+ $X2=0.189 $Y2=0.135
r5 1 13 19.3796 $a=3.24e-16 $layer=V0LIG $X=0.189 $Y=0.135 $X2=0.189 $Y2=0.135
r6 9 8 16.4967 $w=2.1e-08 $l=4.85e-08 $layer=Gate_1 $thickness=5.6e-08 $X=0.189
+ $Y=0.2025 $X2=0.189 $Y2=0.154
r7 7 8 6.6497 $w=2.04211e-08 $l=1.9e-08 $layer=Gate_1 $thickness=5.6e-08
+ $X=0.189 $Y=0.135 $X2=0.189 $Y2=0.154
r8 6 7 6.6497 $w=2.04211e-08 $l=1.9e-08 $layer=Gate_1 $thickness=5.6e-08
+ $X=0.189 $Y=0.116 $X2=0.189 $Y2=0.135
r9 5 6 16.4967 $w=2.1e-08 $l=4.85e-08 $layer=Gate_1 $thickness=5.6e-08 $X=0.189
+ $Y=0.0675 $X2=0.189 $Y2=0.116
r10 5 3 14.6259 $w=2.1e-08 $l=4.3e-08 $layer=Gate_1 $thickness=5.6e-08 $X=0.189
+ $Y=0.0675 $X2=0.189 $Y2=0.0245
.ends

.subckt PM_AO333x2_ASAP7_75t_R%B3 vss 13 5 9 3 4
c1 1 vss 0.00720482f $X=0.351 $Y=0.135
c2 3 vss 0.101712f $X=0.351 $Y=0.0245
c3 4 vss 0.00465518f $X=0.351 $Y=0.098
r1 13 12 1.28254 $w=1.3e-08 $l=5.5e-09 $layer=M1 $thickness=3.6e-08 $X=0.3515
+ $Y=0.1545 $X2=0.351 $Y2=0.149
r2 11 12 3.26466 $w=1.3e-08 $l=1.4e-08 $layer=M1 $thickness=3.6e-08 $X=0.351
+ $Y=0.135 $X2=0.351 $Y2=0.149
r3 4 11 8.62802 $w=1.3e-08 $l=3.7e-08 $layer=M1 $thickness=3.6e-08 $X=0.351
+ $Y=0.098 $X2=0.351 $Y2=0.135
r4 1 7 10.4265 $w=1.765e-08 $layer=LIG $thickness=5.2e-08 $X=0.351 $Y=0.135
+ $X2=0.351 $Y2=0.135
r5 1 11 19.3796 $a=3.24e-16 $layer=V0LIG $X=0.351 $Y=0.135 $X2=0.351 $Y2=0.135
r6 9 8 16.4967 $w=2.1e-08 $l=4.85e-08 $layer=Gate_1 $thickness=5.6e-08 $X=0.351
+ $Y=0.2025 $X2=0.351 $Y2=0.154
r7 7 8 6.6497 $w=2.04211e-08 $l=1.9e-08 $layer=Gate_1 $thickness=5.6e-08
+ $X=0.351 $Y=0.135 $X2=0.351 $Y2=0.154
r8 6 7 6.6497 $w=2.04211e-08 $l=1.9e-08 $layer=Gate_1 $thickness=5.6e-08
+ $X=0.351 $Y=0.116 $X2=0.351 $Y2=0.135
r9 5 6 16.4967 $w=2.1e-08 $l=4.85e-08 $layer=Gate_1 $thickness=5.6e-08 $X=0.351
+ $Y=0.0675 $X2=0.351 $Y2=0.116
r10 5 3 14.6259 $w=2.1e-08 $l=4.3e-08 $layer=Gate_1 $thickness=5.6e-08 $X=0.351
+ $Y=0.0675 $X2=0.351 $Y2=0.0245
.ends

.subckt PM_AO333x2_ASAP7_75t_R%B2 vss 13 5 9 4 3
c1 1 vss 0.00479078f $X=0.405 $Y=0.135
c2 3 vss 0.120849f $X=0.405 $Y=0.0245
c3 4 vss 0.00524549f $X=0.405 $Y=0.077
r1 14 15 6.8791 $w=1.3e-08 $l=2.95e-08 $layer=M1 $thickness=3.6e-08 $X=0.405
+ $Y=0.1055 $X2=0.405 $Y2=0.135
r2 13 14 4.89699 $w=1.3e-08 $l=2.1e-08 $layer=M1 $thickness=3.6e-08 $X=0.4045
+ $Y=0.0845 $X2=0.405 $Y2=0.1055
r3 13 4 1.74892 $w=1.3e-08 $l=7.5e-09 $layer=M1 $thickness=3.6e-08 $X=0.4045
+ $Y=0.0845 $X2=0.405 $Y2=0.077
r4 1 7 6.54019 $w=2.09524e-08 $layer=Gate_1 $thickness=5.21905e-08 $X=0.405
+ $Y=0.135 $X2=0.405 $Y2=0.135
r5 1 15 19.3796 $a=3.24e-16 $layer=V0LIG $X=0.405 $Y=0.135 $X2=0.405 $Y2=0.135
r6 9 8 16.4967 $w=2.1e-08 $l=4.85e-08 $layer=Gate_1 $thickness=5.6e-08 $X=0.405
+ $Y=0.2025 $X2=0.405 $Y2=0.154
r7 7 8 6.6497 $w=2.04211e-08 $l=1.9e-08 $layer=Gate_1 $thickness=5.6e-08
+ $X=0.405 $Y=0.135 $X2=0.405 $Y2=0.154
r8 6 7 6.6497 $w=2.04211e-08 $l=1.9e-08 $layer=Gate_1 $thickness=5.6e-08
+ $X=0.405 $Y=0.116 $X2=0.405 $Y2=0.135
r9 5 6 16.4967 $w=2.1e-08 $l=4.85e-08 $layer=Gate_1 $thickness=5.6e-08 $X=0.405
+ $Y=0.0675 $X2=0.405 $Y2=0.116
r10 5 3 14.6259 $w=2.1e-08 $l=4.3e-08 $layer=Gate_1 $thickness=5.6e-08 $X=0.405
+ $Y=0.0675 $X2=0.405 $Y2=0.0245
.ends

.subckt PM_AO333x2_ASAP7_75t_R%B1 vss 15 5 9 4 3
c1 1 vss 0.00615012f $X=0.459 $Y=0.135
c2 3 vss 0.139898f $X=0.459 $Y=0.0245
c3 4 vss 0.00592643f $X=0.459 $Y=0.098
r1 15 14 1.39914 $w=1.3e-08 $l=6e-09 $layer=M1 $thickness=3.6e-08 $X=0.4625
+ $Y=0.1555 $X2=0.459 $Y2=0.1495
r2 13 14 3.38125 $w=1.3e-08 $l=1.45e-08 $layer=M1 $thickness=3.6e-08 $X=0.459
+ $Y=0.135 $X2=0.459 $Y2=0.1495
r3 4 13 8.62802 $w=1.3e-08 $l=3.7e-08 $layer=M1 $thickness=3.6e-08 $X=0.459
+ $Y=0.098 $X2=0.459 $Y2=0.135
r4 1 7 6.54019 $w=2.09524e-08 $layer=Gate_1 $thickness=5.21905e-08 $X=0.459
+ $Y=0.135 $X2=0.459 $Y2=0.135
r5 1 13 19.3796 $a=3.24e-16 $layer=V0LIG $X=0.459 $Y=0.135 $X2=0.459 $Y2=0.135
r6 9 8 16.4967 $w=2.1e-08 $l=4.85e-08 $layer=Gate_1 $thickness=5.6e-08 $X=0.459
+ $Y=0.2025 $X2=0.459 $Y2=0.154
r7 7 8 6.6497 $w=2.04211e-08 $l=1.9e-08 $layer=Gate_1 $thickness=5.6e-08
+ $X=0.459 $Y=0.135 $X2=0.459 $Y2=0.154
r8 6 7 6.6497 $w=2.04211e-08 $l=1.9e-08 $layer=Gate_1 $thickness=5.6e-08
+ $X=0.459 $Y=0.116 $X2=0.459 $Y2=0.135
r9 5 6 16.4967 $w=2.1e-08 $l=4.85e-08 $layer=Gate_1 $thickness=5.6e-08 $X=0.459
+ $Y=0.0675 $X2=0.459 $Y2=0.116
r10 5 3 14.6259 $w=2.1e-08 $l=4.3e-08 $layer=Gate_1 $thickness=5.6e-08 $X=0.459
+ $Y=0.0675 $X2=0.459 $Y2=0.0245
.ends

.subckt PM_AO333x2_ASAP7_75t_R%C3 vss 13 5 9 3 4
c1 1 vss 0.00464789f $X=0.513 $Y=0.135
c2 3 vss 0.103386f $X=0.513 $Y=0.0245
c3 4 vss 0.00783405f $X=0.513 $Y=0.0765
r1 14 15 6.99569 $w=1.3e-08 $l=3e-08 $layer=M1 $thickness=3.6e-08 $X=0.513
+ $Y=0.105 $X2=0.513 $Y2=0.135
r2 13 14 5.01358 $w=1.3e-08 $l=2.15e-08 $layer=M1 $thickness=3.6e-08 $X=0.5105
+ $Y=0.0835 $X2=0.513 $Y2=0.105
r3 13 4 1.63233 $w=1.3e-08 $l=7e-09 $layer=M1 $thickness=3.6e-08 $X=0.5105
+ $Y=0.0835 $X2=0.513 $Y2=0.0765
r4 1 7 6.54019 $w=2.09524e-08 $layer=Gate_1 $thickness=5.21905e-08 $X=0.513
+ $Y=0.135 $X2=0.513 $Y2=0.135
r5 1 15 19.3796 $a=3.24e-16 $layer=V0LIG $X=0.513 $Y=0.135 $X2=0.513 $Y2=0.135
r6 9 8 16.4967 $w=2.1e-08 $l=4.85e-08 $layer=Gate_1 $thickness=5.6e-08 $X=0.513
+ $Y=0.2025 $X2=0.513 $Y2=0.154
r7 7 8 6.6497 $w=2.04211e-08 $l=1.9e-08 $layer=Gate_1 $thickness=5.6e-08
+ $X=0.513 $Y=0.135 $X2=0.513 $Y2=0.154
r8 6 7 6.6497 $w=2.04211e-08 $l=1.9e-08 $layer=Gate_1 $thickness=5.6e-08
+ $X=0.513 $Y=0.116 $X2=0.513 $Y2=0.135
r9 5 6 16.4967 $w=2.1e-08 $l=4.85e-08 $layer=Gate_1 $thickness=5.6e-08 $X=0.513
+ $Y=0.0675 $X2=0.513 $Y2=0.116
r10 5 3 14.6259 $w=2.1e-08 $l=4.3e-08 $layer=Gate_1 $thickness=5.6e-08 $X=0.513
+ $Y=0.0675 $X2=0.513 $Y2=0.0245
.ends

.subckt PM_AO333x2_ASAP7_75t_R%C2 vss 15 5 9 3 4
c1 1 vss 0.00332229f $X=0.567 $Y=0.135
c2 3 vss 0.0833884f $X=0.567 $Y=0.0245
c3 4 vss 0.00728447f $X=0.567 $Y=0.098
r1 15 14 1.16595 $w=1.3e-08 $l=5e-09 $layer=M1 $thickness=3.6e-08 $X=0.5665
+ $Y=0.1535 $X2=0.567 $Y2=0.1485
r2 13 14 3.14806 $w=1.3e-08 $l=1.35e-08 $layer=M1 $thickness=3.6e-08 $X=0.567
+ $Y=0.135 $X2=0.567 $Y2=0.1485
r3 4 13 8.62802 $w=1.3e-08 $l=3.7e-08 $layer=M1 $thickness=3.6e-08 $X=0.567
+ $Y=0.098 $X2=0.567 $Y2=0.135
r4 1 7 6.54019 $w=2.09524e-08 $layer=Gate_1 $thickness=5.21905e-08 $X=0.567
+ $Y=0.135 $X2=0.567 $Y2=0.135
r5 1 13 19.3796 $a=3.24e-16 $layer=V0LIG $X=0.567 $Y=0.135 $X2=0.567 $Y2=0.135
r6 9 8 16.4967 $w=2.1e-08 $l=4.85e-08 $layer=Gate_1 $thickness=5.6e-08 $X=0.567
+ $Y=0.2025 $X2=0.567 $Y2=0.154
r7 7 8 6.6497 $w=2.04211e-08 $l=1.9e-08 $layer=Gate_1 $thickness=5.6e-08
+ $X=0.567 $Y=0.135 $X2=0.567 $Y2=0.154
r8 6 7 6.6497 $w=2.04211e-08 $l=1.9e-08 $layer=Gate_1 $thickness=5.6e-08
+ $X=0.567 $Y=0.116 $X2=0.567 $Y2=0.135
r9 5 6 16.4967 $w=2.1e-08 $l=4.85e-08 $layer=Gate_1 $thickness=5.6e-08 $X=0.567
+ $Y=0.0675 $X2=0.567 $Y2=0.116
r10 5 3 14.6259 $w=2.1e-08 $l=4.3e-08 $layer=Gate_1 $thickness=5.6e-08 $X=0.567
+ $Y=0.0675 $X2=0.567 $Y2=0.0245
.ends

.subckt PM_AO333x2_ASAP7_75t_R%C1 vss 15 5 11 3 1 4
c1 1 vss 0.00287129f $X=0.621 $Y=0.135
c2 3 vss 0.07088f $X=0.621 $Y=0.0245
c3 4 vss 0.00590386f $X=0.621 $Y=0.0755
r1 16 17 7.22888 $w=1.3e-08 $l=3.1e-08 $layer=M1 $thickness=3.6e-08 $X=0.621
+ $Y=0.104 $X2=0.621 $Y2=0.135
r2 15 16 5.24677 $w=1.3e-08 $l=2.25e-08 $layer=M1 $thickness=3.6e-08 $X=0.6255
+ $Y=0.0815 $X2=0.621 $Y2=0.104
r3 15 4 1.39914 $w=1.3e-08 $l=6e-09 $layer=M1 $thickness=3.6e-08 $X=0.6255
+ $Y=0.0815 $X2=0.621 $Y2=0.0755
r4 1 8 6.54019 $w=2.09524e-08 $layer=Gate_1 $thickness=5.21905e-08 $X=0.621
+ $Y=0.135 $X2=0.621 $Y2=0.135
r5 1 17 19.3796 $a=3.24e-16 $layer=V0LIG $X=0.621 $Y=0.135 $X2=0.621 $Y2=0.135
r6 11 10 14.6259 $w=2.1e-08 $l=4.3e-08 $layer=Gate_1 $thickness=5.6e-08
+ $X=0.621 $Y=0.2025 $X2=0.621 $Y2=0.1595
r7 9 10 2.7211 $w=2.1e-08 $l=8e-09 $layer=Gate_1 $thickness=5.6e-08 $X=0.621
+ $Y=0.1515 $X2=0.621 $Y2=0.1595
r8 8 9 5.79936 $w=2.03333e-08 $l=1.65e-08 $layer=Gate_1 $thickness=5.6e-08
+ $X=0.621 $Y=0.135 $X2=0.621 $Y2=0.1515
r9 7 8 5.79936 $w=2.03333e-08 $l=1.65e-08 $layer=Gate_1 $thickness=5.6e-08
+ $X=0.621 $Y=0.1185 $X2=0.621 $Y2=0.135
r10 6 7 2.7211 $w=2.1e-08 $l=8e-09 $layer=Gate_1 $thickness=5.6e-08 $X=0.621
+ $Y=0.1105 $X2=0.621 $Y2=0.1185
r11 5 6 14.6259 $w=2.1e-08 $l=4.3e-08 $layer=Gate_1 $thickness=5.6e-08 $X=0.621
+ $Y=0.0675 $X2=0.621 $Y2=0.1105
r12 5 3 14.6259 $w=2.1e-08 $l=4.3e-08 $layer=Gate_1 $thickness=5.6e-08 $X=0.621
+ $Y=0.0675 $X2=0.621 $Y2=0.0245
.ends

.subckt PM_AO333x2_ASAP7_75t_R%Y vss 24 18 19 33 34 7 2 1 11 8
c1 1 vss 0.0076898f $X=0.108 $Y=0.0675
c2 2 vss 0.00932209f $X=0.108 $Y=0.2025
c3 7 vss 0.00443412f $X=0.0935 $Y=0.0675
c4 8 vss 0.00433535f $X=0.0935 $Y=0.2025
c5 9 vss 0.00160567f $X=0.027 $Y=0.09
c6 10 vss 0.00292046f $X=0.027 $Y=0.234
c7 11 vss 0.00107679f $X=0.108 $Y=0.09
c8 12 vss 0.00552769f $X=0.027 $Y=0.1125
c9 13 vss 0.00256434f $X=0.083 $Y=0.09
c10 14 vss 0.00892574f $X=0.0515 $Y=0.234
c11 15 vss 0.00228721f $X=0.108 $Y=0.0505
r1 34 32 0.0308642 $w=8.1e-08 $l=2.5e-09 $layer=P_src_drn $thickness=1e-09
+ $X=0.1253 $Y=0.2025 $X2=0.1225 $Y2=0.2025
r2 2 32 0.179012 $w=8.1e-08 $l=1.45e-08 $layer=P_src_drn $thickness=1e-09
+ $X=0.108 $Y=0.2025 $X2=0.1225 $Y2=0.2025
r3 8 2 0.179012 $w=8.1e-08 $l=1.45e-08 $layer=P_src_drn $thickness=1e-09
+ $X=0.0935 $Y=0.2025 $X2=0.108 $Y2=0.2025
r4 33 8 0.0308642 $w=8.1e-08 $l=2.5e-09 $layer=P_src_drn $thickness=1e-09
+ $X=0.0906 $Y=0.2025 $X2=0.0935 $Y2=0.2025
r5 2 29 19.3796 $a=3.24e-16 $layer=V0LISD $X=0.108 $Y=0.2025 $X2=0.108 $Y2=0.234
r6 28 29 5.82974 $w=1.3e-08 $l=2.5e-08 $layer=M1 $thickness=3.6e-08 $X=0.083
+ $Y=0.234 $X2=0.108 $Y2=0.234
r7 14 28 7.34548 $w=1.3e-08 $l=3.15e-08 $layer=M1 $thickness=3.6e-08 $X=0.0515
+ $Y=0.234 $X2=0.083 $Y2=0.234
r8 10 27 3.36447 $w=1.71023e-08 $l=2.15e-08 $layer=M1 $thickness=3.6e-08
+ $X=0.027 $Y=0.234 $X2=0.027 $Y2=0.2125
r9 10 14 4.06404 $w=1.48367e-08 $l=2.45e-08 $layer=M1 $thickness=3.6e-08
+ $X=0.027 $Y=0.234 $X2=0.0515 $Y2=0.234
r10 26 27 9.44419 $w=1.3e-08 $l=4.05e-08 $layer=M1 $thickness=3.6e-08 $X=0.027
+ $Y=0.172 $X2=0.027 $Y2=0.2125
r11 25 26 6.99569 $w=1.3e-08 $l=3e-08 $layer=M1 $thickness=3.6e-08 $X=0.027
+ $Y=0.142 $X2=0.027 $Y2=0.172
r12 24 25 0.582974 $w=1.3e-08 $l=2.5e-09 $layer=M1 $thickness=3.6e-08 $X=0.0285
+ $Y=0.1395 $X2=0.027 $Y2=0.142
r13 24 23 1.63233 $w=1.3e-08 $l=7e-09 $layer=M1 $thickness=3.6e-08 $X=0.0285
+ $Y=0.1395 $X2=0.027 $Y2=0.1325
r14 12 23 4.6638 $w=1.3e-08 $l=2e-08 $layer=M1 $thickness=3.6e-08 $X=0.027
+ $Y=0.1125 $X2=0.027 $Y2=0.1325
r15 9 22 4.06404 $w=1.48367e-08 $l=2.45e-08 $layer=M1 $thickness=3.6e-08
+ $X=0.027 $Y=0.09 $X2=0.0515 $Y2=0.09
r16 9 12 3.59766 $w=1.692e-08 $l=2.25e-08 $layer=M1 $thickness=3.6e-08 $X=0.027
+ $Y=0.09 $X2=0.027 $Y2=0.1125
r17 13 22 7.34548 $w=1.3e-08 $l=3.15e-08 $layer=M1 $thickness=3.6e-08 $X=0.083
+ $Y=0.09 $X2=0.0515 $Y2=0.09
r18 11 21 1.26576 $w=2.0056e-08 $l=1.25e-08 $layer=M1 $thickness=3.6e-08
+ $X=0.108 $Y=0.09 $X2=0.108 $Y2=0.0775
r19 11 13 4.18063 $w=1.48e-08 $l=2.5e-08 $layer=M1 $thickness=3.6e-08 $X=0.108
+ $Y=0.09 $X2=0.083 $Y2=0.09
r20 20 21 2.91487 $w=1.3e-08 $l=1.25e-08 $layer=M1 $thickness=3.6e-08 $X=0.108
+ $Y=0.065 $X2=0.108 $Y2=0.0775
r21 15 20 3.38125 $w=1.3e-08 $l=1.45e-08 $layer=M1 $thickness=3.6e-08 $X=0.108
+ $Y=0.0505 $X2=0.108 $Y2=0.065
r22 1 20 19.3796 $a=3.24e-16 $layer=V0LISD $X=0.108 $Y=0.0675 $X2=0.108
+ $Y2=0.065
r23 19 17 0.0308642 $w=8.1e-08 $l=2.5e-09 $layer=N_src_drn $thickness=1e-09
+ $X=0.1253 $Y=0.0675 $X2=0.1225 $Y2=0.0675
r24 1 17 0.179012 $w=8.1e-08 $l=1.45e-08 $layer=N_src_drn $thickness=1e-09
+ $X=0.108 $Y=0.0675 $X2=0.1225 $Y2=0.0675
r25 7 1 0.179012 $w=8.1e-08 $l=1.45e-08 $layer=N_src_drn $thickness=1e-09
+ $X=0.0935 $Y=0.0675 $X2=0.108 $Y2=0.0675
r26 18 7 0.0308642 $w=8.1e-08 $l=2.5e-09 $layer=N_src_drn $thickness=1e-09
+ $X=0.0906 $Y=0.0675 $X2=0.0935 $Y2=0.0675
.ends

.subckt PM_AO333x2_ASAP7_75t_R%3 vss 31 37 53 56 86 87 93 100 103 104 1 26 28
+ 27 17 23 18 4 5 20 6 19 7 21 30 22 16
c1 1 vss 0.00792357f $X=0.0715 $Y=0.135
c2 4 vss 0.00506542f $X=0.324 $Y=0.0675
c3 5 vss 0.0120086f $X=0.54 $Y=0.2025
c4 6 vss 0.0066044f $X=0.648 $Y=0.0675
c5 7 vss 0.00952986f $X=0.648 $Y=0.2025
c6 16 vss 0.0832361f $X=0.081 $Y=0.0245
c7 17 vss 0.0808015f $X=0.135 $Y=0.135
c8 18 vss 0.004612f $X=0.3095 $Y=0.0675
c9 19 vss 0.0389536f $X=0.6335 $Y=0.0675
c10 20 vss 0.00620633f $X=0.5255 $Y=0.2025
c11 21 vss 0.0396954f $X=0.6335 $Y=0.2025
c12 22 vss 0.00303276f $X=0.153 $Y=0.036
c13 23 vss 0.000365066f $X=0.153 $Y=0.135
c14 24 vss 0.00309963f $X=0.675 $Y=0.036
c15 25 vss 0.00317256f $X=0.675 $Y=0.234
c16 26 vss 0.00176004f $X=0.0695 $Y=0.135
c17 27 vss 0.00263873f $X=0.153 $Y=0.1125
c18 28 vss 0.045851f $X=0.171 $Y=0.036
c19 29 vss 0.021061f $X=0.6345 $Y=0.234
c20 30 vss 0.00856254f $X=0.675 $Y=0.0575
r1 104 102 0.0308642 $w=8.1e-08 $l=2.5e-09 $layer=P_src_drn $thickness=1e-09
+ $X=0.5573 $Y=0.2025 $X2=0.5545 $Y2=0.2025
r2 5 102 0.179012 $w=8.1e-08 $l=1.45e-08 $layer=P_src_drn $thickness=1e-09
+ $X=0.54 $Y=0.2025 $X2=0.5545 $Y2=0.2025
r3 20 5 0.179012 $w=8.1e-08 $l=1.45e-08 $layer=P_src_drn $thickness=1e-09
+ $X=0.5255 $Y=0.2025 $X2=0.54 $Y2=0.2025
r4 103 20 0.0308642 $w=8.1e-08 $l=2.5e-09 $layer=P_src_drn $thickness=1e-09
+ $X=0.5226 $Y=0.2025 $X2=0.5255 $Y2=0.2025
r5 21 7 0.154321 $w=8.1e-08 $l=1.25e-08 $layer=P_src_drn $thickness=1e-09
+ $X=0.6335 $Y=0.2025 $X2=0.648 $Y2=0.2025
r6 100 21 0.0308642 $w=8.1e-08 $l=2.5e-09 $layer=P_src_drn $thickness=1e-09
+ $X=0.6306 $Y=0.2025 $X2=0.6335 $Y2=0.2025
r7 5 97 19.3796 $a=3.24e-16 $layer=V0LISD $X=0.54 $Y=0.2025 $X2=0.54 $Y2=0.234
r8 7 94 19.3796 $a=3.24e-16 $layer=V0LISD $X=0.648 $Y=0.2025 $X2=0.648 $Y2=0.234
r9 97 98 11.5429 $w=1.3e-08 $l=4.95e-08 $layer=M1 $thickness=3.6e-08 $X=0.54
+ $Y=0.234 $X2=0.5895 $Y2=0.234
r10 94 95 3.14806 $w=1.3e-08 $l=1.35e-08 $layer=M1 $thickness=3.6e-08 $X=0.648
+ $Y=0.234 $X2=0.6615 $Y2=0.234
r11 29 94 3.14806 $w=1.3e-08 $l=1.35e-08 $layer=M1 $thickness=3.6e-08 $X=0.6345
+ $Y=0.234 $X2=0.648 $Y2=0.234
r12 29 98 10.4935 $w=1.3e-08 $l=4.5e-08 $layer=M1 $thickness=3.6e-08 $X=0.6345
+ $Y=0.234 $X2=0.5895 $Y2=0.234
r13 25 91 2.5483 $w=1.79e-08 $l=1.8e-08 $layer=M1 $thickness=3.6e-08 $X=0.675
+ $Y=0.234 $X2=0.675 $Y2=0.216
r14 25 95 1.49895 $w=1.63333e-08 $l=1.35e-08 $layer=M1 $thickness=3.6e-08
+ $X=0.675 $Y=0.234 $X2=0.6615 $Y2=0.234
r15 19 6 0.154321 $w=8.1e-08 $l=1.25e-08 $layer=N_src_drn $thickness=1e-09
+ $X=0.6335 $Y=0.0675 $X2=0.648 $Y2=0.0675
r16 93 19 0.0308642 $w=8.1e-08 $l=2.5e-09 $layer=N_src_drn $thickness=1e-09
+ $X=0.6306 $Y=0.0675 $X2=0.6335 $Y2=0.0675
r17 90 91 4.19742 $w=1.3e-08 $l=1.8e-08 $layer=M1 $thickness=3.6e-08 $X=0.675
+ $Y=0.198 $X2=0.675 $Y2=0.216
r18 89 90 5.01358 $w=1.3e-08 $l=2.15e-08 $layer=M1 $thickness=3.6e-08 $X=0.675
+ $Y=0.1765 $X2=0.675 $Y2=0.198
r19 88 89 13.8748 $w=1.3e-08 $l=5.95e-08 $layer=M1 $thickness=3.6e-08 $X=0.675
+ $Y=0.117 $X2=0.675 $Y2=0.1765
r20 30 88 13.8748 $w=1.3e-08 $l=5.95e-08 $layer=M1 $thickness=3.6e-08 $X=0.675
+ $Y=0.0575 $X2=0.675 $Y2=0.117
r21 87 85 0.0308642 $w=8.1e-08 $l=2.5e-09 $layer=N_src_drn $thickness=1e-09
+ $X=0.3413 $Y=0.0675 $X2=0.3385 $Y2=0.0675
r22 4 85 0.179012 $w=8.1e-08 $l=1.45e-08 $layer=N_src_drn $thickness=1e-09
+ $X=0.324 $Y=0.0675 $X2=0.3385 $Y2=0.0675
r23 18 4 0.179012 $w=8.1e-08 $l=1.45e-08 $layer=N_src_drn $thickness=1e-09
+ $X=0.3095 $Y=0.0675 $X2=0.324 $Y2=0.0675
r24 86 18 0.0308642 $w=8.1e-08 $l=2.5e-09 $layer=N_src_drn $thickness=1e-09
+ $X=0.3066 $Y=0.0675 $X2=0.3095 $Y2=0.0675
r25 6 82 19.3796 $a=3.24e-16 $layer=V0LISD $X=0.648 $Y=0.0675 $X2=0.648
+ $Y2=0.036
r26 24 83 1.49895 $w=1.63333e-08 $l=1.35e-08 $layer=M1 $thickness=3.6e-08
+ $X=0.675 $Y=0.036 $X2=0.6615 $Y2=0.036
r27 24 30 3.36447 $w=1.71023e-08 $l=2.15e-08 $layer=M1 $thickness=3.6e-08
+ $X=0.675 $Y=0.036 $X2=0.675 $Y2=0.0575
r28 4 67 19.3796 $a=3.24e-16 $layer=V0LISD $X=0.324 $Y=0.0675 $X2=0.324
+ $Y2=0.036
r29 82 83 3.14806 $w=1.3e-08 $l=1.35e-08 $layer=M1 $thickness=3.6e-08 $X=0.648
+ $Y=0.036 $X2=0.6615 $Y2=0.036
r30 81 82 3.14806 $w=1.3e-08 $l=1.35e-08 $layer=M1 $thickness=3.6e-08 $X=0.6345
+ $Y=0.036 $X2=0.648 $Y2=0.036
r31 80 81 3.14806 $w=1.3e-08 $l=1.35e-08 $layer=M1 $thickness=3.6e-08 $X=0.621
+ $Y=0.036 $X2=0.6345 $Y2=0.036
r32 79 80 6.29612 $w=1.3e-08 $l=2.7e-08 $layer=M1 $thickness=3.6e-08 $X=0.594
+ $Y=0.036 $X2=0.621 $Y2=0.036
r33 78 79 6.29612 $w=1.3e-08 $l=2.7e-08 $layer=M1 $thickness=3.6e-08 $X=0.567
+ $Y=0.036 $X2=0.594 $Y2=0.036
r34 77 78 6.29612 $w=1.3e-08 $l=2.7e-08 $layer=M1 $thickness=3.6e-08 $X=0.54
+ $Y=0.036 $X2=0.567 $Y2=0.036
r35 76 77 6.29612 $w=1.3e-08 $l=2.7e-08 $layer=M1 $thickness=3.6e-08 $X=0.513
+ $Y=0.036 $X2=0.54 $Y2=0.036
r36 75 76 6.29612 $w=1.3e-08 $l=2.7e-08 $layer=M1 $thickness=3.6e-08 $X=0.486
+ $Y=0.036 $X2=0.513 $Y2=0.036
r37 74 75 6.29612 $w=1.3e-08 $l=2.7e-08 $layer=M1 $thickness=3.6e-08 $X=0.459
+ $Y=0.036 $X2=0.486 $Y2=0.036
r38 73 74 6.29612 $w=1.3e-08 $l=2.7e-08 $layer=M1 $thickness=3.6e-08 $X=0.432
+ $Y=0.036 $X2=0.459 $Y2=0.036
r39 72 73 6.29612 $w=1.3e-08 $l=2.7e-08 $layer=M1 $thickness=3.6e-08 $X=0.405
+ $Y=0.036 $X2=0.432 $Y2=0.036
r40 71 72 5.82974 $w=1.3e-08 $l=2.5e-08 $layer=M1 $thickness=3.6e-08 $X=0.38
+ $Y=0.036 $X2=0.405 $Y2=0.036
r41 70 71 4.19742 $w=1.3e-08 $l=1.8e-08 $layer=M1 $thickness=3.6e-08 $X=0.362
+ $Y=0.036 $X2=0.38 $Y2=0.036
r42 69 70 2.56509 $w=1.3e-08 $l=1.1e-08 $layer=M1 $thickness=3.6e-08 $X=0.351
+ $Y=0.036 $X2=0.362 $Y2=0.036
r43 68 69 3.14806 $w=1.3e-08 $l=1.35e-08 $layer=M1 $thickness=3.6e-08 $X=0.3375
+ $Y=0.036 $X2=0.351 $Y2=0.036
r44 67 68 3.14806 $w=1.3e-08 $l=1.35e-08 $layer=M1 $thickness=3.6e-08 $X=0.324
+ $Y=0.036 $X2=0.3375 $Y2=0.036
r45 66 67 3.14806 $w=1.3e-08 $l=1.35e-08 $layer=M1 $thickness=3.6e-08 $X=0.3105
+ $Y=0.036 $X2=0.324 $Y2=0.036
r46 65 66 3.14806 $w=1.3e-08 $l=1.35e-08 $layer=M1 $thickness=3.6e-08 $X=0.297
+ $Y=0.036 $X2=0.3105 $Y2=0.036
r47 64 65 6.29612 $w=1.3e-08 $l=2.7e-08 $layer=M1 $thickness=3.6e-08 $X=0.27
+ $Y=0.036 $X2=0.297 $Y2=0.036
r48 63 64 6.29612 $w=1.3e-08 $l=2.7e-08 $layer=M1 $thickness=3.6e-08 $X=0.243
+ $Y=0.036 $X2=0.27 $Y2=0.036
r49 62 63 5.82974 $w=1.3e-08 $l=2.5e-08 $layer=M1 $thickness=3.6e-08 $X=0.218
+ $Y=0.036 $X2=0.243 $Y2=0.036
r50 61 62 4.19742 $w=1.3e-08 $l=1.8e-08 $layer=M1 $thickness=3.6e-08 $X=0.2
+ $Y=0.036 $X2=0.218 $Y2=0.036
r51 60 61 2.56509 $w=1.3e-08 $l=1.1e-08 $layer=M1 $thickness=3.6e-08 $X=0.189
+ $Y=0.036 $X2=0.2 $Y2=0.036
r52 28 60 4.19742 $w=1.3e-08 $l=1.8e-08 $layer=M1 $thickness=3.6e-08 $X=0.171
+ $Y=0.036 $X2=0.189 $Y2=0.036
r53 22 59 3.36447 $w=1.71023e-08 $l=2.15e-08 $layer=M1 $thickness=3.6e-08
+ $X=0.153 $Y=0.036 $X2=0.153 $Y2=0.0575
r54 22 28 2.5483 $w=1.55e-08 $l=1.8e-08 $layer=M1 $thickness=3.6e-08 $X=0.153
+ $Y=0.036 $X2=0.171 $Y2=0.036
r55 58 59 6.29612 $w=1.3e-08 $l=2.7e-08 $layer=M1 $thickness=3.6e-08 $X=0.153
+ $Y=0.0845 $X2=0.153 $Y2=0.0575
r56 27 58 6.52931 $w=1.3e-08 $l=2.8e-08 $layer=M1 $thickness=3.6e-08 $X=0.153
+ $Y=0.1125 $X2=0.153 $Y2=0.0845
r57 23 51 2.5483 $w=1.55e-08 $l=1.8e-08 $layer=M1 $thickness=3.6e-08 $X=0.153
+ $Y=0.135 $X2=0.135 $Y2=0.135
r58 23 27 3.59766 $w=1.692e-08 $l=2.25e-08 $layer=M1 $thickness=3.6e-08
+ $X=0.153 $Y=0.135 $X2=0.153 $Y2=0.1125
r59 56 55 16.4967 $w=2.1e-08 $l=4.85e-08 $layer=Gate_1 $thickness=5.6e-08
+ $X=0.135 $Y=0.2025 $X2=0.135 $Y2=0.154
r60 53 54 16.4967 $w=2.1e-08 $l=4.85e-08 $layer=Gate_1 $thickness=5.6e-08
+ $X=0.135 $Y=0.0675 $X2=0.135 $Y2=0.116
r61 17 44 6.27904 $w=2.09e-08 $layer=Gate_1 $thickness=5.24e-08 $X=0.135
+ $Y=0.135 $X2=0.135 $Y2=0.135
r62 17 54 6.6497 $w=2.04211e-08 $l=1.9e-08 $layer=Gate_1 $thickness=5.6e-08
+ $X=0.135 $Y=0.135 $X2=0.135 $Y2=0.116
r63 17 55 6.6497 $w=2.04211e-08 $l=1.9e-08 $layer=Gate_1 $thickness=5.6e-08
+ $X=0.135 $Y=0.135 $X2=0.135 $Y2=0.154
r64 50 51 2.56509 $w=1.3e-08 $l=1.1e-08 $layer=M1 $thickness=3.6e-08 $X=0.124
+ $Y=0.135 $X2=0.135 $Y2=0.135
r65 49 50 1.04935 $w=1.3e-08 $l=4.5e-09 $layer=M1 $thickness=3.6e-08 $X=0.1195
+ $Y=0.135 $X2=0.124 $Y2=0.135
r66 48 49 3.73104 $w=1.3e-08 $l=1.6e-08 $layer=M1 $thickness=3.6e-08 $X=0.1035
+ $Y=0.135 $X2=0.1195 $Y2=0.135
r67 47 48 5.24677 $w=1.3e-08 $l=2.25e-08 $layer=M1 $thickness=3.6e-08 $X=0.081
+ $Y=0.135 $X2=0.1035 $Y2=0.135
r68 26 47 2.68168 $w=1.3e-08 $l=1.15e-08 $layer=M1 $thickness=3.6e-08 $X=0.0695
+ $Y=0.135 $X2=0.081 $Y2=0.135
r69 44 51 19.3796 $a=3.24e-16 $layer=V0LIG $X=0.135 $Y=0.135 $X2=0.135 $Y2=0.135
r70 43 44 2.48102 $w=2.2e-08 $l=9.5e-09 $layer=LIG $thickness=4.8e-08 $X=0.1255
+ $Y=0.135 $X2=0.135 $Y2=0.135
r71 42 43 10.1729 $w=1.54914e-08 $l=1.75e-08 $layer=LIG $thickness=4.8e-08
+ $X=0.108 $Y=0.135 $X2=0.1255 $Y2=0.135
r72 40 42 10.1729 $w=1.54914e-08 $l=1.75e-08 $layer=LIG $thickness=4.8e-08
+ $X=0.0905 $Y=0.135 $X2=0.108 $Y2=0.135
r73 39 40 2.48102 $w=2.2e-08 $l=9.5e-09 $layer=LIG $thickness=4.8e-08 $X=0.081
+ $Y=0.135 $X2=0.0905 $Y2=0.135
r74 39 47 19.3796 $a=3.24e-16 $layer=V0LIG $X=0.081 $Y=0.135 $X2=0.081 $Y2=0.135
r75 1 39 2.48102 $w=2.2e-08 $l=9.5e-09 $layer=LIG $thickness=4.8e-08 $X=0.0715
+ $Y=0.135 $X2=0.081 $Y2=0.135
r76 37 36 14.6259 $w=2.1e-08 $l=4.3e-08 $layer=Gate_1 $thickness=5.6e-08
+ $X=0.081 $Y=0.2025 $X2=0.081 $Y2=0.1595
r77 35 36 2.7211 $w=2.1e-08 $l=8e-09 $layer=Gate_1 $thickness=5.6e-08 $X=0.081
+ $Y=0.1515 $X2=0.081 $Y2=0.1595
r78 34 35 5.79936 $w=2.03333e-08 $l=1.65e-08 $layer=Gate_1 $thickness=5.6e-08
+ $X=0.081 $Y=0.135 $X2=0.081 $Y2=0.1515
r79 34 40 4.05918 $w=2.0087e-08 $l=9.5e-09 $layer=Gate_1 $thickness=5.56522e-08
+ $X=0.081 $Y=0.135 $X2=0.0905 $Y2=0.135
r80 34 39 6.27904 $w=2.09e-08 $layer=Gate_1 $thickness=5.24e-08 $X=0.081
+ $Y=0.135 $X2=0.081 $Y2=0.135
r81 33 34 5.79936 $w=2.03333e-08 $l=1.65e-08 $layer=Gate_1 $thickness=5.6e-08
+ $X=0.081 $Y=0.1185 $X2=0.081 $Y2=0.135
r82 32 33 2.7211 $w=2.1e-08 $l=8e-09 $layer=Gate_1 $thickness=5.6e-08 $X=0.081
+ $Y=0.1105 $X2=0.081 $Y2=0.1185
r83 31 32 14.6259 $w=2.1e-08 $l=4.3e-08 $layer=Gate_1 $thickness=5.6e-08
+ $X=0.081 $Y=0.0675 $X2=0.081 $Y2=0.1105
r84 31 16 14.6259 $w=2.1e-08 $l=4.3e-08 $layer=Gate_1 $thickness=5.6e-08
+ $X=0.081 $Y=0.0675 $X2=0.081 $Y2=0.0245
.ends

.subckt PM_AO333x2_ASAP7_75t_R%A1 vss 11 5 9 3 4
c1 1 vss 0.00457212f $X=0.297 $Y=0.135
c2 3 vss 0.102574f $X=0.297 $Y=0.0245
c3 4 vss 0.009706f $X=0.297 $Y=0.098
r1 11 4 8.62802 $w=1.3e-08 $l=3.7e-08 $layer=M1 $thickness=3.6e-08 $X=0.2975
+ $Y=0.1345 $X2=0.297 $Y2=0.098
r2 1 7 10.4265 $w=1.765e-08 $layer=LIG $thickness=5.2e-08 $X=0.297 $Y=0.135
+ $X2=0.297 $Y2=0.135
r3 11 1 19.3796 $a=3.24e-16 $layer=V0LIG $X=0.2975 $Y=0.1345 $X2=0.297 $Y2=0.135
r4 9 8 16.4967 $w=2.1e-08 $l=4.85e-08 $layer=Gate_1 $thickness=5.6e-08 $X=0.297
+ $Y=0.2025 $X2=0.297 $Y2=0.154
r5 7 8 6.6497 $w=2.04211e-08 $l=1.9e-08 $layer=Gate_1 $thickness=5.6e-08
+ $X=0.297 $Y=0.135 $X2=0.297 $Y2=0.154
r6 6 7 6.6497 $w=2.04211e-08 $l=1.9e-08 $layer=Gate_1 $thickness=5.6e-08
+ $X=0.297 $Y=0.116 $X2=0.297 $Y2=0.135
r7 5 6 16.4967 $w=2.1e-08 $l=4.85e-08 $layer=Gate_1 $thickness=5.6e-08 $X=0.297
+ $Y=0.0675 $X2=0.297 $Y2=0.116
r8 5 3 14.6259 $w=2.1e-08 $l=4.3e-08 $layer=Gate_1 $thickness=5.6e-08 $X=0.297
+ $Y=0.0675 $X2=0.297 $Y2=0.0245
.ends

.subckt PM_AO333x2_ASAP7_75t_R%A2 vss 13 5 9 4 3
c1 1 vss 0.00438957f $X=0.243 $Y=0.135
c2 3 vss 0.121303f $X=0.243 $Y=0.0245
c3 4 vss 0.00688272f $X=0.243 $Y=0.098
r1 13 12 5.01358 $w=1.3e-08 $l=2.15e-08 $layer=M1 $thickness=3.6e-08 $X=0.2415
+ $Y=0.1865 $X2=0.243 $Y2=0.165
r2 11 12 6.99569 $w=1.3e-08 $l=3e-08 $layer=M1 $thickness=3.6e-08 $X=0.243
+ $Y=0.135 $X2=0.243 $Y2=0.165
r3 4 11 8.62802 $w=1.3e-08 $l=3.7e-08 $layer=M1 $thickness=3.6e-08 $X=0.243
+ $Y=0.098 $X2=0.243 $Y2=0.135
r4 1 7 10.4265 $w=1.765e-08 $layer=LIG $thickness=5.2e-08 $X=0.243 $Y=0.135
+ $X2=0.243 $Y2=0.135
r5 1 11 19.3796 $a=3.24e-16 $layer=V0LIG $X=0.243 $Y=0.135 $X2=0.243 $Y2=0.135
r6 9 8 16.4967 $w=2.1e-08 $l=4.85e-08 $layer=Gate_1 $thickness=5.6e-08 $X=0.243
+ $Y=0.2025 $X2=0.243 $Y2=0.154
r7 7 8 6.6497 $w=2.04211e-08 $l=1.9e-08 $layer=Gate_1 $thickness=5.6e-08
+ $X=0.243 $Y=0.135 $X2=0.243 $Y2=0.154
r8 6 7 6.6497 $w=2.04211e-08 $l=1.9e-08 $layer=Gate_1 $thickness=5.6e-08
+ $X=0.243 $Y=0.116 $X2=0.243 $Y2=0.135
r9 5 6 16.4967 $w=2.1e-08 $l=4.85e-08 $layer=Gate_1 $thickness=5.6e-08 $X=0.243
+ $Y=0.0675 $X2=0.243 $Y2=0.116
r10 5 3 14.6259 $w=2.1e-08 $l=4.3e-08 $layer=Gate_1 $thickness=5.6e-08 $X=0.243
+ $Y=0.0675 $X2=0.243 $Y2=0.0245
.ends

* End of included file AO333x2_ASAP7_75t_R.pex.sp.pex

*
.subckt AO333x2_ASAP7_75t_CUSTOM_4_25_0_7 VSS VDD A3 A2 A1 B3 B2 B1 C3 C2 C1 Y
*
* VSS VSS
* VDD VDD
* A3 A3
* A2 A2
* A1 A1
* B3 B3
* B2 B2
* B1 B1
* C3 C3
* C2 C2
* C1 C1
* Y Y
*
*

M0 N_M0_d N_M0_g VSS VSS nmos_rvt L=2e-08 W=8.1e-08 nfin=3 $X=0.071 $Y=0.027
M1 N_M1_d N_M1_g VSS VSS nmos_rvt L=2e-08 W=8.1e-08 nfin=3 $X=0.125 $Y=0.027
M2 noxref_16 N_M2_g VSS VSS nmos_rvt L=2e-08 W=8.1e-08 nfin=3 $X=0.179 $Y=0.027
M3 noxref_17 N_M3_g noxref_16 VSS nmos_rvt L=2e-08 W=8.1e-08 nfin=3 $X=0.233
+ $Y=0.027
M4 N_M4_d N_M4_g noxref_17 VSS nmos_rvt L=2e-08 W=8.1e-08 nfin=3 $X=0.287
+ $Y=0.027
M5 noxref_18 N_M5_g N_M5_s VSS nmos_rvt L=2e-08 W=8.1e-08 nfin=3 $X=0.341
+ $Y=0.027
M6 noxref_19 N_M6_g noxref_18 VSS nmos_rvt L=2e-08 W=8.1e-08 nfin=3 $X=0.395
+ $Y=0.027
M7 VSS N_M7_g noxref_19 VSS nmos_rvt L=2e-08 W=8.1e-08 nfin=3 $X=0.449 $Y=0.027
M8 noxref_20 N_M8_g VSS VSS nmos_rvt L=2e-08 W=8.1e-08 nfin=3 $X=0.503 $Y=0.027
M9 noxref_21 N_M9_g noxref_20 VSS nmos_rvt L=2e-08 W=8.1e-08 nfin=3 $X=0.557
+ $Y=0.027
M10 N_M10_d N_M10_g noxref_21 VSS nmos_rvt L=2e-08 W=8.1e-08 nfin=3 $X=0.611
+ $Y=0.027
M11 N_M11_d N_M11_g VDD VDD pmos_rvt L=2e-08 W=8.1e-08 nfin=3 $X=0.071 $Y=0.162
M12 N_M12_d N_M12_g VDD VDD pmos_rvt L=2e-08 W=8.1e-08 nfin=3 $X=0.125 $Y=0.162
M13 noxref_14 N_M13_g VDD VDD pmos_rvt L=2e-08 W=8.1e-08 nfin=3 $X=0.179
+ $Y=0.162
M14 VDD N_M14_g noxref_14 VDD pmos_rvt L=2e-08 W=8.1e-08 nfin=3 $X=0.233
+ $Y=0.162
M15 noxref_14 N_M15_g VDD VDD pmos_rvt L=2e-08 W=8.1e-08 nfin=3 $X=0.287
+ $Y=0.162
M16 noxref_15 N_M16_g noxref_14 VDD pmos_rvt L=2e-08 W=8.1e-08 nfin=3 $X=0.341
+ $Y=0.162
M17 noxref_14 N_M17_g noxref_15 VDD pmos_rvt L=2e-08 W=8.1e-08 nfin=3 $X=0.395
+ $Y=0.162
M18 noxref_15 N_M18_g noxref_14 VDD pmos_rvt L=2e-08 W=8.1e-08 nfin=3 $X=0.449
+ $Y=0.162
M19 N_M19_d N_M19_g noxref_15 VDD pmos_rvt L=2e-08 W=8.1e-08 nfin=3 $X=0.503
+ $Y=0.162
M20 noxref_15 N_M20_g N_M20_s VDD pmos_rvt L=2e-08 W=8.1e-08 nfin=3 $X=0.557
+ $Y=0.162
M21 N_M21_d N_M21_g noxref_15 VDD pmos_rvt L=2e-08 W=8.1e-08 nfin=3 $X=0.611
+ $Y=0.162

* .include "AO333x2_ASAP7_75t_R.pex.sp.pxi"

* Start of included file AO333x2_ASAP7_75t_R.pex.sp.pxi
x_PM_AO333x2_ASAP7_75t_R%A3 vss A3 N_M2_g N_M13_g N_A3_4 N_A3_3
+ PM_AO333x2_ASAP7_75t_R%A3
cc_1 N_A3_4 N_3_1 0.00165996f $X=0.189 $Y=0.081
cc_2 N_A3_4 N_3_26 0.000287765f $X=0.189 $Y=0.081
cc_3 N_A3_4 N_3_28 0.00100389f $X=0.189 $Y=0.081
cc_4 N_A3_4 N_3_27 0.00219113f $X=0.189 $Y=0.081
cc_5 N_A3_3 N_3_17 0.00340161f $X=0.189 $Y=0.0245
cc_6 N_A3_4 N_3_23 0.00611378f $X=0.189 $Y=0.081
x_PM_AO333x2_ASAP7_75t_R%B3 vss B3 N_M5_g N_M16_g N_B3_3 N_B3_4
+ PM_AO333x2_ASAP7_75t_R%B3
cc_7 N_B3_3 N_3_4 0.00170299f $X=0.351 $Y=0.0245
cc_8 N_B3_4 N_3_28 0.00125464f $X=0.351 $Y=0.098
cc_9 N_B3_4 N_3_4 0.00170276f $X=0.351 $Y=0.098
cc_10 N_B3_3 N_3_18 0.03577f $X=0.351 $Y=0.0245
cc_11 N_B3_3 N_A1_3 0.00315946f $X=0.351 $Y=0.0245
cc_12 N_B3_4 N_A1_4 0.0053253f $X=0.351 $Y=0.098
x_PM_AO333x2_ASAP7_75t_R%B2 vss B2 N_M6_g N_M17_g N_B2_4 N_B2_3
+ PM_AO333x2_ASAP7_75t_R%B2
cc_13 N_B2_4 N_3_4 0.000366341f $X=0.405 $Y=0.077
cc_14 N_B2_4 N_3_28 0.00315117f $X=0.405 $Y=0.077
cc_15 N_B2_4 N_B3_4 0.00336051f $X=0.405 $Y=0.077
cc_16 N_B2_3 N_B3_3 0.007002f $X=0.405 $Y=0.0245
x_PM_AO333x2_ASAP7_75t_R%B1 vss B1 N_M7_g N_M18_g N_B1_4 N_B1_3
+ PM_AO333x2_ASAP7_75t_R%B1
cc_17 N_B1_4 N_3_28 0.00274747f $X=0.459 $Y=0.098
cc_18 N_B1_4 N_B2_4 0.00332096f $X=0.459 $Y=0.098
cc_19 N_B1_3 N_B2_3 0.00697565f $X=0.459 $Y=0.0245
x_PM_AO333x2_ASAP7_75t_R%C3 vss C3 N_M8_g N_M19_g N_C3_3 N_C3_4
+ PM_AO333x2_ASAP7_75t_R%C3
cc_20 N_C3_3 N_3_5 0.00105609f $X=0.513 $Y=0.0245
cc_21 N_C3_4 N_3_28 0.00133968f $X=0.513 $Y=0.0765
cc_22 N_C3_4 N_3_5 0.00155105f $X=0.513 $Y=0.0765
cc_23 N_C3_3 N_3_20 0.0351667f $X=0.513 $Y=0.0245
cc_24 N_C3_3 N_B1_3 0.003144f $X=0.513 $Y=0.0245
cc_25 N_C3_4 N_B1_4 0.00500378f $X=0.513 $Y=0.0765
x_PM_AO333x2_ASAP7_75t_R%C2 vss C2 N_M9_g N_M20_g N_C2_3 N_C2_4
+ PM_AO333x2_ASAP7_75t_R%C2
cc_26 N_C2_3 N_3_6 0.00023596f $X=0.567 $Y=0.0245
cc_27 N_C2_3 N_3_5 0.00120342f $X=0.567 $Y=0.0245
cc_28 N_C2_4 N_3_28 0.00146084f $X=0.567 $Y=0.098
cc_29 N_C2_4 N_3_5 0.00180536f $X=0.567 $Y=0.098
cc_30 N_C2_3 N_3_20 0.0355817f $X=0.567 $Y=0.0245
cc_31 N_C2_4 N_C3_4 0.00334765f $X=0.567 $Y=0.098
cc_32 N_C2_3 N_C3_3 0.00696199f $X=0.567 $Y=0.0245
x_PM_AO333x2_ASAP7_75t_R%C1 vss C1 N_M10_g N_M21_g N_C1_3 N_C1_1 N_C1_4
+ PM_AO333x2_ASAP7_75t_R%C1
cc_33 N_C1_3 N_3_19 0.0154492f $X=0.621 $Y=0.0245
cc_34 N_C1_3 N_3_6 0.00239445f $X=0.621 $Y=0.0245
cc_35 N_C1_3 N_3_7 0.000943875f $X=0.621 $Y=0.0245
cc_36 N_C1_3 N_3_28 0.00115512f $X=0.621 $Y=0.0245
cc_37 N_C1_1 N_3_21 0.00178502f $X=0.621 $Y=0.135
cc_38 N_C1_4 N_3_30 0.00582182f $X=0.621 $Y=0.0755
cc_39 N_C1_3 N_3_21 0.0542754f $X=0.621 $Y=0.0245
cc_40 N_C1_4 N_C2_4 0.00338109f $X=0.621 $Y=0.0755
cc_41 N_C1_3 N_C2_3 0.00712187f $X=0.621 $Y=0.0245
x_PM_AO333x2_ASAP7_75t_R%Y vss Y N_M0_d N_M1_d N_M11_d N_M12_d N_Y_7 N_Y_2
+ N_Y_1 N_Y_11 N_Y_8 PM_AO333x2_ASAP7_75t_R%Y
cc_42 N_Y_7 N_3_23 0.00021125f $X=0.0935 $Y=0.0675
cc_43 N_Y_7 N_3_26 0.002685f $X=0.0935 $Y=0.0675
cc_44 N_Y_7 N_3_22 0.000434252f $X=0.0935 $Y=0.0675
cc_45 N_Y_7 N_3_1 0.00601557f $X=0.0935 $Y=0.0675
cc_46 N_Y_7 N_3_27 0.00327148f $X=0.0935 $Y=0.0675
cc_47 N_Y_7 N_3_17 0.00167894f $X=0.0935 $Y=0.0675
cc_48 N_Y_2 N_3_16 0.00180606f $X=0.108 $Y=0.2025
cc_49 N_Y_1 N_3_16 0.0019027f $X=0.108 $Y=0.0675
cc_50 N_Y_11 N_3_26 0.00389804f $X=0.108 $Y=0.09
cc_51 N_Y_8 N_3_16 0.0183917f $X=0.0935 $Y=0.2025
cc_52 N_Y_8 N_3_17 0.0468909f $X=0.0935 $Y=0.2025
cc_53 N_Y_7 N_3_16 0.0659447f $X=0.0935 $Y=0.0675
x_PM_AO333x2_ASAP7_75t_R%3 vss N_M0_g N_M11_g N_M1_g N_M12_g N_M4_d N_M5_s
+ N_M10_d N_M21_d N_M19_d N_M20_s N_3_1 N_3_26 N_3_28 N_3_27 N_3_17 N_3_23
+ N_3_18 N_3_4 N_3_5 N_3_20 N_3_6 N_3_19 N_3_7 N_3_21 N_3_30 N_3_22 N_3_16
+ PM_AO333x2_ASAP7_75t_R%3
x_PM_AO333x2_ASAP7_75t_R%A1 vss A1 N_M4_g N_M15_g N_A1_3 N_A1_4
+ PM_AO333x2_ASAP7_75t_R%A1
cc_54 N_A1_3 N_3_4 0.00177621f $X=0.297 $Y=0.0245
cc_55 N_A1_4 N_3_28 0.00128322f $X=0.297 $Y=0.098
cc_56 N_A1_4 N_3_4 0.00183332f $X=0.297 $Y=0.098
cc_57 N_A1_3 N_3_18 0.0359039f $X=0.297 $Y=0.0245
cc_58 N_A1_4 N_A2_4 0.00460511f $X=0.297 $Y=0.098
cc_59 N_A1_3 N_A2_3 0.00695684f $X=0.297 $Y=0.0245
x_PM_AO333x2_ASAP7_75t_R%A2 vss A2 N_M3_g N_M14_g N_A2_4 N_A2_3
+ PM_AO333x2_ASAP7_75t_R%A2
cc_60 N_A2_4 N_3_18 0.000178084f $X=0.243 $Y=0.098
cc_61 N_A2_4 N_3_4 0.000286608f $X=0.243 $Y=0.098
cc_62 N_A2_4 N_3_28 0.00145661f $X=0.243 $Y=0.098
cc_63 N_A2_4 N_3_23 0.00192984f $X=0.243 $Y=0.098
cc_64 N_A2_4 N_A3_4 0.00459858f $X=0.243 $Y=0.098
cc_65 N_A2_3 N_A3_3 0.00704927f $X=0.243 $Y=0.0245

* End of included file AO333x2_ASAP7_75t_R.pex.sp.pxi
.ends
